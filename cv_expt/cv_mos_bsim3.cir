* MOSFET CV Analysis with BSIM3 Model
* This simulation performs a comprehensive bias sweep with multiple AC analyses
* to generate complete CV characteristics including frequency-dependent effects

.option temp=27 tnom=27
.option gmin=1e-15
.option reltol=1e-8
.option abstol=1e-12
.option chgtol=1e-15
.option method=gear

* BSIM3 NMOS Model with frequency-dependent behavior
.model NMOS_BSIM3 NMOS level=49
+ toxe=4e-9 toxp=4e-9 toxm=4e-9 toxref=4e-9
+ xl=3e-8 xw=0 dlc=3e-8
+ wint=0 lint=1e-8
+ version=3.3.0
+ tnom=27 tox=4e-9
+ vth0=0.5 k1=0.6 k2=1e-3 k3=0 k3b=0
+ nlx=1.74e-7 w0=1e-7
+ dvt0=1.3 dvt1=0.6 dvt2=-0.1
+ dvt0w=0 dvt1w=5.3e6 dvt2w=-0.032
+ u0=400 ua=2.25e-9 ub=5.8e-19 uc=2.9e-11
+ vsat=8.5e4 a0=1 ags=0
+ keta=-6e-3 nch=2.5e17 ngate=0
+ rdsw=550
+ prwg=0 prwb=-0.2
+ wr=1 wint=0 lint=0
+ xj=3e-7
+ js=1e-4 jsw=0 jsd=0.15
+ pclm=1.2 pdiblc1=0.15 pdiblc2=5e-3 pdiblcb=0
+ drout=0.56 pvag=0 delta=0.1 pscbe1=3.5e8 pscbe2=1e-7
+ fprout=0.2 pdits=0.012 pditsd=0.23 pditsl=2.3e6
+ rsh=3 nfactor=1
+ cj=9.5e-4 mj=0.4 pb=0.9
+ cjsw=2.5e-10 mjsw=0.2 pbsw=0.9
+ cjswg=5e-10 mjswg=0.35 pbswg=0.9
+ cgso=2.6e-10 cgdo=2.6e-10 cgbo=0
+ capmod=3
+ xpart=1 cf=0 ckappa=0.6
+ cgsl=1e-14 cgdl=1e-14 ckappa=0.6 clc=1e-7 cle=0.6
+ acde=0.4 moin=15 noff=2.5

* Enhanced test circuit for capacitance measurements
* Use small signal AC analysis to extract capacitance components
* Configure for operation in different regions (accumulation, depletion, inversion)

* Gate voltage source with AC component for small-signal analysis
VG gate 0 DC 0 AC 1
* Drain bias at VDD (typical operation voltage)
VD drain 0 DC 1.0
* Source and bulk connections tied to ground
VS source 0 DC 0
VB bulk 0 DC 0

* MOSFET device under test with BSIM3 model
M1 drain gate source bulk NMOS_BSIM3 L=0.15u W=10u

.control
* Create output directories if they don't exist
shell mkdir -p results

* Output format configuration
set filetype=ascii
set wr_vecnames=yes
set wr_singlescale=yes
set numdgt=16

* Set up gate voltage sweep parameters
let vg_start = -0.8   ; Start accumulation region
let vg_stop = 1.2     ; End strong inversion
let vg_step = 0.05    ; Small step size for smooth curve
let num_points = floor((vg_stop - vg_start)/vg_step) + 1

* Create output file with header
echo "Vg Cgg_1kHz Cgg_10kHz Cgg_100kHz Cgg_1MHz Cgb_1MHz Cgs_1MHz Cgd_1MHz" > ./results/cv_bsim3_data.txt

* Initialize vectors for capacitance values
let cgg_1k_vec = vector(num_points)
let cgg_10k_vec = vector(num_points)
let cgg_100k_vec = vector(num_points)
let cgg_1m_vec = vector(num_points)
let cgb_1m_vec = vector(num_points)
let cgs_1m_vec = vector(num_points)
let cgd_1m_vec = vector(num_points)
let vg_vec = vector(num_points)
let idx = 0

* Initialize capacitance value variables
let cgg_val_1k = 0
let cgg_val_10k = 0
let cgg_val_100k = 0
let cgg_val_1m = 0
let cgb_val_1m = 0
let cgs_val_1m = 0
let cgd_val_1m = 0

* Perform gate voltage sweep with measurements at each bias point
let idx = 0
while idx < num_points
    let vg_bias = vg_start + idx * vg_step
    * Set gate bias
    alter VG = vg_bias

    * Store gate voltage value
    let vg_vec[idx] = vg_bias

    * Run AC analysis at 1kHz (low frequency response)
    ac lin 1 1k 1k
    let cgg_val_1k = -imag(i(VG))/(2*3.14159*1e3)
    let cgg_1k_vec[idx] = cgg_val_1k

    * Run AC analysis at 10kHz
    ac lin 1 10k 10k
    let cgg_val_10k = -imag(i(VG))/(2*3.14159*1e4)
    let cgg_10k_vec[idx] = cgg_val_10k

    * Run AC analysis at 100kHz
    ac lin 1 100k 100k
    let cgg_val_100k = -imag(i(VG))/(2*3.14159*1e5)
    let cgg_100k_vec[idx] = cgg_val_100k

    * Run AC analysis at 1MHz (standard frequency for CV measurements)
    ac lin 1 1meg 1meg
    let cgg_val_1m = -imag(i(VG))/(2*3.14159*1e6)
    let cgg_1m_vec[idx] = cgg_val_1m

    * Calculate individual capacitance components at 1MHz
    let cgb_val_1m = -imag(i(VB))/(2*3.14159*1e6)
    let cgb_1m_vec[idx] = cgb_val_1m

    let cgs_val_1m = -imag(i(VS))/(2*3.14159*1e6)
    let cgs_1m_vec[idx] = cgs_val_1m

    let cgd_val_1m = -imag(i(VD))/(2*3.14159*1e6)
    let cgd_1m_vec[idx] = cgd_val_1m

    * Print results to file
    echo "$&vg_bias $&cgg_val_1k $&cgg_val_10k $&cgg_val_100k $&cgg_val_1m $&cgb_val_1m $&cgs_val_1m $&cgd_val_1m" >> ./results/cv_bsim3_data.txt

    * Increment index
    let idx = idx + 1
end

echo "CV simulation completed."
quit
.endc

.end
