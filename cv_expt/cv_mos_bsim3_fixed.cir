* MOSFET CV Analysis with BSIM3 Model - Fixed version
* This simulation performs a comprehensive bias sweep with multiple AC analyses
* to generate complete CV characteristics including frequency-dependent effects

.option temp=27 tnom=27
.option gmin=1e-15
.option reltol=1e-6
.option abstol=1e-12
.option chgtol=1e-15
.option method=gear

* BSIM3 NMOS Model with frequency-dependent behavior
.model NMOS_BSIM3 NMOS level=49
+ toxe=4e-9 toxp=4e-9 toxm=4e-9 toxref=4e-9
+ xl=3e-8 xw=0 dlc=3e-8
+ wint=0 lint=1e-8
+ version=3.3.0
+ tnom=27 tox=4e-9
+ vth0=0.5 k1=0.6 k2=1e-3 k3=0 k3b=0
+ nlx=1.74e-7 w0=1e-7
+ dvt0=1.3 dvt1=0.6 dvt2=-0.1
+ dvt0w=0 dvt1w=5.3e6 dvt2w=-0.032
+ u0=400 ua=2.25e-9 ub=5.8e-19 uc=2.9e-11
+ vsat=8.5e4 a0=1 ags=0
+ keta=-6e-3 nch=2.5e17 ngate=0
+ rdsw=550
+ prwg=0 prwb=-0.2
+ wr=1 wint=0 lint=0
+ xj=3e-7
+ js=1e-4 jsw=0 jsd=0.15
+ pclm=1.2 pdiblc1=0.15 pdiblc2=5e-3 pdiblcb=0
+ drout=0.56 pvag=0 delta=0.1 pscbe1=3.5e8 pscbe2=1e-7
+ fprout=0.2 pdits=0.012 pditsd=0.23 pditsl=2.3e6
+ rsh=3 nfactor=1
+ cj=9.5e-4 mj=0.4 pb=0.9
+ cjsw=2.5e-10 mjsw=0.2 pbsw=0.9
+ cjswg=5e-10 mjswg=0.35 pbswg=0.9
+ cgso=2.6e-10 cgdo=2.6e-10 cgbo=0
+ capmod=3
+ xpart=1 cf=0 ckappa=0.6
+ cgsl=1e-14 cgdl=1e-14 ckappa=0.6 clc=1e-7 cle=0.6
+ acde=0.4 moin=15 noff=2.5

* Enhanced test circuit for capacitance measurements
* Use small signal AC analysis to extract capacitance components
* Configure for operation in different regions (accumulation, depletion, inversion)

* Gate voltage source with AC component for small-signal analysis
VG gate 0 DC 0 AC 1
* Drain bias at VDD (typical operation voltage)
VD drain 0 DC 1.0
* Source and bulk connections tied to ground
VS source 0 DC 0
VB bulk 0 DC 0

* MOSFET device under test with BSIM3 model
M1 drain gate source bulk NMOS_BSIM3 L=0.15u W=10u

.control
* Create output directories if they don't exist
shell mkdir -p results

* Output format configuration
set filetype=ascii
set wr_vecnames=yes
set wr_singlescale=yes
set numdgt=8

* Create log file
echo "** MOSFET CV Characteristic Simulation with BSIM3 - Fixed **" > ./results/cv_bsim3_fixed_sim.log

* Set up gate voltage sweep parameters
let vg_start = -0.8   ; Start accumulation region
let vg_stop = 1.2     ; End strong inversion
let vg_step = 0.05    ; Small step size for smooth curve
let num_points = floor((vg_stop - vg_start)/vg_step) + 1
echo "Gate voltage sweep from $&vg_start V to $&vg_stop V, $&num_points points" >> ./results/cv_bsim3_fixed_sim.log

* Create output file with header
echo "Vg Cgg_1kHz Cgg_10kHz Cgg_100kHz Cgg_1MHz Cgb_1MHz Cgs_1MHz Cgd_1MHz" > ./results/cv_bsim3_fixed_data.txt

* Initialize vectors for later plotting
let vg_vec = vector($&num_points)
let cgg_1k_vec = vector($&num_points)
let cgg_10k_vec = vector($&num_points)
let cgg_100k_vec = vector($&num_points)
let cgg_1m_vec = vector($&num_points)
let cgb_1m_vec = vector($&num_points)
let cgs_1m_vec = vector($&num_points)
let cgd_1m_vec = vector($&num_points)

* Loop through each gate voltage point
let idx = 0
let vg_val = $&vg_start
while vg_val <= $&vg_stop
    alter VG = $&vg_val

    * Store gate voltage
    let vg_vec[$&idx] = $&vg_val

    * Run AC analysis at 1kHz and measure capacitance
    ac lin 1 1k 1k
    meas ac cgg_1k imag(i(VG))/(2*pi*1k) at=1k
    let cgg_1k_vec[$&idx] = cgg_1k

    * Run AC analysis at 10kHz and measure capacitance
    ac lin 1 10k 10k
    meas ac cgg_10k imag(i(VG))/(2*pi*10k) at=10k
    let cgg_10k_vec[$&idx] = cgg_10k

    * Run AC analysis at 100kHz and measure capacitance
    ac lin 1 100k 100k
    meas ac cgg_100k imag(i(VG))/(2*pi*100k) at=100k
    let cgg_100k_vec[$&idx] = cgg_100k

    * Run AC analysis at 1MHz and measure capacitance and components
    ac lin 1 1meg 1meg
    meas ac cgg_1m imag(i(VG))/(2*pi*1meg) at=1meg
    meas ac cgb_1m imag(i(VB))/(2*pi*1meg) at=1meg
    meas ac cgs_1m imag(i(VS))/(2*pi*1meg) at=1meg
    meas ac cgd_1m imag(i(VD))/(2*pi*1meg) at=1meg

    let cgg_1m_vec[$&idx] = cgg_1m
    let cgb_1m_vec[$&idx] = cgb_1m
    let cgs_1m_vec[$&idx] = cgs_1m
    let cgd_1m_vec[$&idx] = cgd_1m

    * Write data to file for later processing
    echo "$&vg_val $&cgg_1k $&cgg_10k $&cgg_100k $&cgg_1m $&cgb_1m $&cgs_1m $&cgd_1m" >> ./results/cv_bsim3_fixed_data.txt

    * Log progress
    echo "VG = $&vg_val V: Cgg(1k) = $&cgg_1k F, Cgg(1M) = $&cgg_1m F" >> ./results/cv_bsim3_fixed_sim.log

    * Increment values for next iteration
    let idx = idx + 1
    let vg_val = vg_val + $&vg_step
end

* Plot capacitance vs gate voltage directly in SPICE (simple plot)
set xbrushwidth=2
plot abs(cgg_1k_vec) vs vg_vec title "Cgg @ 1kHz" \
     abs(cgg_10k_vec) vs vg_vec title "Cgg @ 10kHz" \
     abs(cgg_100k_vec) vs vg_vec title "Cgg @ 100kHz" \
     abs(cgg_1m_vec) vs vg_vec title "Cgg @ 1MHz"

hardcopy ./results/bsim3_capfreq_spice.ps abs(cgg_1k_vec) vs vg_vec abs(cgg_10k_vec) vs vg_vec abs(cgg_100k_vec) vs vg_vec abs(cgg_1m_vec) vs vg_vec

* Plot capacitance components at 1MHz
plot abs(cgg_1m_vec) vs vg_vec title "Total Cap" \
     abs(cgb_1m_vec) vs vg_vec title "Gate-Bulk Cap" \
     abs(cgs_1m_vec) vs vg_vec title "Gate-Source Cap" \
     abs(cgd_1m_vec) vs vg_vec title "Gate-Drain Cap"

hardcopy ./results/bsim3_cap_components.ps abs(cgg_1m_vec) vs vg_vec abs(cgb_1m_vec) vs vg_vec abs(cgs_1m_vec) vs vg_vec abs(cgd_1m_vec) vs vg_vec

echo "CV simulation completed successfully." >> ./results/cv_bsim3_fixed_sim.log
echo "CV simulation completed."

quit
.endc

.end
