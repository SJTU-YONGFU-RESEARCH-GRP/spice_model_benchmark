simulator lang = spectre insensitive = yes

* 6th May 2008:
* - MOS flicker noise checked: NMOS2v is worst, other 3 (NMOS1v, PMOS1v, PMOS2v) are at same level
* - mvtwl added
* - mbewl added and adjusted empirically to fit MC

* TODO:
* - align dcmatch fully with MC mismatch

library gpdk090

section stat_mis
parameters
+ pvt_mc=0
+ pu0_mc=0
+ pltw_mc=0

statistics {
 mismatch {
  vary pvt_mc  dist=gauss std=1/1
  vary pu0_mc  dist=gauss std=1/1
  vary pltw_mc dist=gauss std=1/1
  }
 }
endsection stat_mis

section TT_s1v
parameters
+           s1v_rs_ne =        0.000000e+000          s1v_vsat_ne =        1.120000e+005        s1v_pldd_surf =        6.000000e+019
+          s1v_uc1_ne =        3.700000e-010            s1v_u0_ne =        2.000000e-002           s1v_nch_ne =        5.200000e+017
+          s1v_rsc_ne =        4.082483e-014          s1v_cgbo_ne =        1.482000e-011           s1v_prt_ne =        1.000000e+001
+          s1v_rdc_ne =        4.082483e-014          s1v_vth0_ne =        1.692662e-001            s1v_k2_ne =        0.000000e+000
+         s1v_cgdo_ne =        2.667600e-010        s1v_ckappa_ne =        4.605336e+000          s1v_wint_ne =        6.000000e-009
+           s1v_k1_ne =        2.825346e-001          s1v_cgsl_ne =        1.111500e-010        s1v_nldd_surf =        3.000000e+019
+           s1v_js_ne =        3.366667e-006          s1v_hdif_ne =        1.400000e-007          s1v_rdsw_ne =        3.900000e-006
+          s1v_jsw_ne =        3.366667e-010           s1v_tox_ne =        2.330000e-009            s1v_cj_ne =        7.983537e-004
+         s1v_cjsw_ne =        4.790122e-011          s1v_ldif_ne =        1.000000e-008            s1v_xj_ne =        2.500000e-008
+           s1v_rd_ne =        0.000000e+000            s1v_pb_ne =        9.918524e-001            s1v_cf_ne =        4.594612e-011
+         s1v_lint_ne =        1.500000e-008         s1v_cjswg_ne =        1.995884e-011           s1v_rsh_ne =        1.000000e+001
+           s1v_u0_pe =        1.200000e-002           s1v_nch_pe =        4.000000e+017           s1v_rsc_pe =        2.886751e-014
+         s1v_cgbo_pe =        1.392363e-011           s1v_rdc_pe =        2.886751e-014          s1v_vth0_pe =       -1.359511e-001
+           s1v_k2_pe =        0.000000e+000          s1v_cgdo_pe =        2.506253e-010        s1v_ckappa_pe =        1.043477e+001
+         s1v_wint_pe =        5.000000e-009            s1v_k1_pe =        2.637520e-001          s1v_cgsl_pe =        1.044272e-010
+           s1v_js_pe =        3.350000e-006          s1v_hdif_pe =        1.400000e-007          s1v_rdsw_pe =        7.800000e-006
+          s1v_jsw_pe =        3.350000e-010           s1v_tox_pe =        2.480000e-009            s1v_cj_pe =        7.912252e-004
+         s1v_cjsw_pe =        4.747351e-011          s1v_ldif_pe =        1.000000e-008            s1v_xj_pe =        2.500000e-008
+           s1v_rd_pe =        0.000000e+000            s1v_pb_pe =        1.009805e+000            s1v_cf_pe =        4.527118e-011
+         s1v_lint_pe =        1.500000e-008         s1v_cjswg_pe =        1.978063e-011           s1v_rsh_pe =        2.000000e+001
+           s1v_rs_pe =        0.000000e+000          s1v_vsat_pe =        1.000000e+005
+         gleak_scale =          1.0
+     s1v_nat_vth0_ne =        0.192662e-001        s1v_nat_k1_ne =        2.825346e-002
include "gpdk090_mos.scs" section =stat_mis
include "gpdk090_mos.scs" section = s1v_mos
endsection TT_s1v

section FF_s1v
parameters
+           s1v_rs_ne =        0.000000e+000          s1v_vsat_ne =        1.120000e+005        s1v_pldd_surf =        6.000000e+019
+          s1v_uc1_ne =        3.700000e-010            s1v_u0_ne =        2.600000e-002           s1v_nch_ne =        4.680000e+017
+          s1v_rsc_ne =        4.082483e-014          s1v_cgbo_ne =        1.482000e-011           s1v_prt_ne =        1.000000e+001
+          s1v_rdc_ne =        4.082483e-014          s1v_vth0_ne =        1.518852e-001            s1v_k2_ne =        0.000000e+000
+         s1v_cgdo_ne =        2.667600e-010        s1v_ckappa_ne =        4.605336e+000          s1v_wint_ne =        5.400000e-009
+           s1v_k1_ne =        2.825346e-001          s1v_cgsl_ne =        1.111500e-010        s1v_nldd_surf =        3.000000e+019
+           s1v_js_ne =        3.366667e-006          s1v_hdif_ne =        1.400000e-007          s1v_rdsw_ne =        3.900000e-006
+          s1v_jsw_ne =        3.366667e-010           s1v_tox_ne =        2.097000e-009            s1v_cj_ne =        7.983537e-004
+         s1v_cjsw_ne =        4.790122e-011          s1v_ldif_ne =        1.000000e-008            s1v_xj_ne =        2.500000e-008
+           s1v_rd_ne =        0.000000e+000            s1v_pb_ne =        9.918524e-001            s1v_cf_ne =        4.594612e-011
+         s1v_lint_ne =        1.650000e-008         s1v_cjswg_ne =        1.995884e-011           s1v_rsh_ne =        1.000000e+001
+           s1v_u0_pe =        1.560000e-002           s1v_nch_pe =        3.600000e+017           s1v_rsc_pe =        2.886751e-014
+         s1v_cgbo_pe =        1.392363e-011           s1v_rdc_pe =        2.886751e-014          s1v_vth0_pe =       -1.228104e-001
+           s1v_k2_pe =        0.000000e+000          s1v_cgdo_pe =        2.506253e-010        s1v_ckappa_pe =        1.043477e+001
+         s1v_wint_pe =        4.500000e-009            s1v_k1_pe =        2.637520e-001          s1v_cgsl_pe =        1.044272e-010
+           s1v_js_pe =        3.350000e-006          s1v_hdif_pe =        1.400000e-007          s1v_rdsw_pe =        7.800000e-006
+          s1v_jsw_pe =        3.350000e-010           s1v_tox_pe =        2.232000e-009            s1v_cj_pe =        7.912252e-004
+         s1v_cjsw_pe =        4.747351e-011          s1v_ldif_pe =        1.000000e-008            s1v_xj_pe =        2.500000e-008
+           s1v_rd_pe =        0.000000e+000            s1v_pb_pe =        1.009805e+000            s1v_cf_pe =        4.527118e-011
+         s1v_lint_pe =        1.650000e-008         s1v_cjswg_pe =        1.978063e-011           s1v_rsh_pe =        2.000000e+001
+           s1v_rs_pe =        0.000000e+000          s1v_vsat_pe =        1.000000e+005
+         gleak_scale =          2.0
+     s1v_nat_vth0_ne =        0.018852e-001        s1v_nat_k1_ne =        2.825346e-002
include "gpdk090_mos.scs" section =stat_mis
include "gpdk090_mos.scs" section = s1v_mos
endsection FF_s1v

section SS_s1v
parameters
+           s1v_rs_ne =        0.000000e+000          s1v_vsat_ne =        1.120000e+005        s1v_pldd_surf =        6.000000e+019
+          s1v_uc1_ne =        3.700000e-010            s1v_u0_ne =        1.400000e-002           s1v_nch_ne =        5.720000e+017
+          s1v_rsc_ne =        4.082483e-014          s1v_cgbo_ne =        1.482000e-011           s1v_prt_ne =        1.000000e+001
+          s1v_rdc_ne =        4.082483e-014          s1v_vth0_ne =        1.866039e-001            s1v_k2_ne =        0.000000e+000
+         s1v_cgdo_ne =        2.667600e-010        s1v_ckappa_ne =        4.605336e+000          s1v_wint_ne =        6.600000e-009
+           s1v_k1_ne =        2.825346e-001          s1v_cgsl_ne =        1.111500e-010        s1v_nldd_surf =        3.000000e+019
+           s1v_js_ne =        3.366667e-006          s1v_hdif_ne =        1.400000e-007          s1v_rdsw_ne =        3.900000e-006
+          s1v_jsw_ne =        3.366667e-010           s1v_tox_ne =        2.563000e-009            s1v_cj_ne =        7.983537e-004
+         s1v_cjsw_ne =        4.790122e-011          s1v_ldif_ne =        1.000000e-008            s1v_xj_ne =        2.500000e-008
+           s1v_rd_ne =        0.000000e+000            s1v_pb_ne =        9.918524e-001            s1v_cf_ne =        4.594612e-011
+         s1v_lint_ne =        1.350000e-008         s1v_cjswg_ne =        1.995884e-011           s1v_rsh_ne =        1.000000e+001
+           s1v_u0_pe =        8.400000e-003           s1v_nch_pe =        4.400000e+017           s1v_rsc_pe =        2.886751e-014
+         s1v_cgbo_pe =        1.392363e-011           s1v_rdc_pe =        2.886751e-014          s1v_vth0_pe =       -1.491351e-001
+           s1v_k2_pe =        0.000000e+000          s1v_cgdo_pe =        2.506253e-010        s1v_ckappa_pe =        1.043477e+001
+         s1v_wint_pe =        5.500000e-009            s1v_k1_pe =        2.637520e-001          s1v_cgsl_pe =        1.044272e-010
+           s1v_js_pe =        3.350000e-006          s1v_hdif_pe =        1.400000e-007          s1v_rdsw_pe =        7.800000e-006
+          s1v_jsw_pe =        3.350000e-010           s1v_tox_pe =        2.728000e-009            s1v_cj_pe =        7.912252e-004
+         s1v_cjsw_pe =        4.747351e-011          s1v_ldif_pe =        1.000000e-008            s1v_xj_pe =        2.500000e-008
+           s1v_rd_pe =        0.000000e+000            s1v_pb_pe =        1.009805e+000            s1v_cf_pe =        4.527118e-011
+         s1v_lint_pe =        1.350000e-008         s1v_cjswg_pe =        1.978063e-011           s1v_rsh_pe =        2.000000e+001
+           s1v_rs_pe =        0.000000e+000          s1v_vsat_pe =        1.000000e+005
+         gleak_scale =          0.5
+     s1v_nat_vth0_ne =        0.366039e-001        s1v_nat_k1_ne =        2.825346e-002
include "gpdk090_mos.scs" section =stat_mis
include "gpdk090_mos.scs" section = s1v_mos
endsection SS_s1v

section FS_s1v
parameters
+           s1v_rs_ne =        0.000000e+000          s1v_vsat_ne =        1.120000e+005        s1v_pldd_surf =        6.000000e+019
+          s1v_uc1_ne =        3.700000e-010            s1v_u0_ne =        2.600000e-002           s1v_nch_ne =        4.680000e+017
+          s1v_rsc_ne =        4.082483e-014          s1v_cgbo_ne =        1.482000e-011           s1v_prt_ne =        1.000000e+001
+          s1v_rdc_ne =        4.082483e-014          s1v_vth0_ne =        1.518852e-001            s1v_k2_ne =        0.000000e+000
+         s1v_cgdo_ne =        2.667600e-010        s1v_ckappa_ne =        4.605336e+000          s1v_wint_ne =        5.400000e-009
+           s1v_k1_ne =        2.825346e-001          s1v_cgsl_ne =        1.111500e-010        s1v_nldd_surf =        3.000000e+019
+           s1v_js_ne =        3.366667e-006          s1v_hdif_ne =        1.400000e-007          s1v_rdsw_ne =        3.900000e-006
+          s1v_jsw_ne =        3.366667e-010           s1v_tox_ne =        2.097000e-009            s1v_cj_ne =        7.983537e-004
+         s1v_cjsw_ne =        4.790122e-011          s1v_ldif_ne =        1.000000e-008            s1v_xj_ne =        2.500000e-008
+           s1v_rd_ne =        0.000000e+000            s1v_pb_ne =        9.918524e-001            s1v_cf_ne =        4.594612e-011
+         s1v_lint_ne =        1.650000e-008         s1v_cjswg_ne =        1.995884e-011           s1v_rsh_ne =        1.000000e+001
+           s1v_u0_pe =        8.400000e-003           s1v_nch_pe =        4.400000e+017           s1v_rsc_pe =        2.886751e-014
+         s1v_cgbo_pe =        1.392363e-011           s1v_rdc_pe =        2.886751e-014          s1v_vth0_pe =       -1.491351e-001
+           s1v_k2_pe =        0.000000e+000          s1v_cgdo_pe =        2.506253e-010        s1v_ckappa_pe =        1.043477e+001
+         s1v_wint_pe =        5.500000e-009            s1v_k1_pe =        2.637520e-001          s1v_cgsl_pe =        1.044272e-010
+           s1v_js_pe =        3.350000e-006          s1v_hdif_pe =        1.400000e-007          s1v_rdsw_pe =        7.800000e-006
+          s1v_jsw_pe =        3.350000e-010           s1v_tox_pe =        2.728000e-009            s1v_cj_pe =        7.912252e-004
+         s1v_cjsw_pe =        4.747351e-011          s1v_ldif_pe =        1.000000e-008            s1v_xj_pe =        2.500000e-008
+           s1v_rd_pe =        0.000000e+000            s1v_pb_pe =        1.009805e+000            s1v_cf_pe =        4.527118e-011
+         s1v_lint_pe =        1.350000e-008         s1v_cjswg_pe =        1.978063e-011           s1v_rsh_pe =        2.000000e+001
+           s1v_rs_pe =        0.000000e+000          s1v_vsat_pe =        1.000000e+005
+         gleak_scale =          1.0
+     s1v_nat_vth0_ne =        0.018852e-001        s1v_nat_k1_ne =        2.825346e-002
include "gpdk090_mos.scs" section =stat_mis
include "gpdk090_mos.scs" section = s1v_mos
endsection FS_s1v

section SF_s1v
parameters
+           s1v_rs_ne =        0.000000e+000          s1v_vsat_ne =        1.120000e+005        s1v_pldd_surf =        6.000000e+019
+          s1v_uc1_ne =        3.700000e-010            s1v_u0_ne =        1.400000e-002           s1v_nch_ne =        5.720000e+017
+          s1v_rsc_ne =        4.082483e-014          s1v_cgbo_ne =        1.482000e-011           s1v_prt_ne =        1.000000e+001
+          s1v_rdc_ne =        4.082483e-014          s1v_vth0_ne =        1.866039e-001            s1v_k2_ne =        0.000000e+000
+         s1v_cgdo_ne =        2.667600e-010        s1v_ckappa_ne =        4.605336e+000          s1v_wint_ne =        6.600000e-009
+           s1v_k1_ne =        2.825346e-001          s1v_cgsl_ne =        1.111500e-010        s1v_nldd_surf =        3.000000e+019
+           s1v_js_ne =        3.366667e-006          s1v_hdif_ne =        1.400000e-007          s1v_rdsw_ne =        3.900000e-006
+          s1v_jsw_ne =        3.366667e-010           s1v_tox_ne =        2.563000e-009            s1v_cj_ne =        7.983537e-004
+         s1v_cjsw_ne =        4.790122e-011          s1v_ldif_ne =        1.000000e-008            s1v_xj_ne =        2.500000e-008
+           s1v_rd_ne =        0.000000e+000            s1v_pb_ne =        9.918524e-001            s1v_cf_ne =        4.594612e-011
+         s1v_lint_ne =        1.350000e-008         s1v_cjswg_ne =        1.995884e-011           s1v_rsh_ne =        1.000000e+001
+           s1v_u0_pe =        1.560000e-002           s1v_nch_pe =        3.600000e+017           s1v_rsc_pe =        2.886751e-014
+         s1v_cgbo_pe =        1.392363e-011           s1v_rdc_pe =        2.886751e-014          s1v_vth0_pe =       -1.228104e-001
+           s1v_k2_pe =        0.000000e+000          s1v_cgdo_pe =        2.506253e-010        s1v_ckappa_pe =        1.043477e+001
+         s1v_wint_pe =        4.500000e-009            s1v_k1_pe =        2.637520e-001          s1v_cgsl_pe =        1.044272e-010
+           s1v_js_pe =        3.350000e-006          s1v_hdif_pe =        1.400000e-007          s1v_rdsw_pe =        7.800000e-006
+          s1v_jsw_pe =        3.350000e-010           s1v_tox_pe =        2.232000e-009            s1v_cj_pe =        7.912252e-004
+         s1v_cjsw_pe =        4.747351e-011          s1v_ldif_pe =        1.000000e-008            s1v_xj_pe =        2.500000e-008
+           s1v_rd_pe =        0.000000e+000            s1v_pb_pe =        1.009805e+000            s1v_cf_pe =        4.527118e-011
+         s1v_lint_pe =        1.650000e-008         s1v_cjswg_pe =        1.978063e-011           s1v_rsh_pe =        2.000000e+001
+           s1v_rs_pe =        0.000000e+000          s1v_vsat_pe =        1.000000e+005
+         gleak_scale =          1.0
+     s1v_nat_vth0_ne =        0.366039e-001        s1v_nat_k1_ne =        2.825346e-002
include "gpdk090_mos.scs" section =stat_mis
include "gpdk090_mos.scs" section = s1v_mos
endsection SF_s1v

section TT_lp
parameters
+            lp_rs_ne =        0.000000e+000           lp_vsat_ne =        1.120000e+005         lp_pldd_surf =        6.000000e+019
+           lp_uc1_ne =       -6.420000e-011             lp_u0_ne =        2.000000e-002            lp_nch_ne =        8.500000e+017
+           lp_rsc_ne =        4.082483e-014           lp_cgbo_ne =        1.482000e-011            lp_prt_ne =        0.000000e+000
+           lp_rdc_ne =        4.082483e-014           lp_vth0_ne =        2.742286e-001             lp_k2_ne =        0.000000e+000
+          lp_cgdo_ne =        2.667600e-010         lp_ckappa_ne =        4.605336e+000           lp_wint_ne =        6.000000e-009
+            lp_k1_ne =        3.612264e-001           lp_cgsl_ne =        1.111500e-010         lp_nldd_surf =        3.000000e+019
+            lp_js_ne =        3.366667e-006           lp_hdif_ne =        1.400000e-007           lp_rdsw_ne =        3.900000e-006
+           lp_jsw_ne =        3.366667e-010            lp_tox_ne =        2.330000e-009             lp_cj_ne =        7.983537e-004
+          lp_cjsw_ne =        4.790122e-011           lp_ldif_ne =        1.000000e-008             lp_xj_ne =        2.500000e-008
+            lp_rd_ne =        0.000000e+000             lp_pb_ne =        9.918524e-001             lp_cf_ne =        4.594612e-011
+          lp_lint_ne =        1.500000e-008          lp_cjswg_ne =        1.995884e-011            lp_rsh_ne =        1.000000e+001
+            lp_u0_pe =        1.200000e-002            lp_nch_pe =        6.700000e+017            lp_rsc_pe =        2.886751e-014
+          lp_cgbo_pe =        1.392363e-011            lp_rdc_pe =        2.886751e-014           lp_vth0_pe =       -2.405796e-001
+            lp_k2_pe =        0.000000e+000           lp_cgdo_pe =        2.506253e-010         lp_ckappa_pe =        1.043477e+001
+          lp_wint_pe =        5.000000e-009             lp_k1_pe =        3.413526e-001           lp_cgsl_pe =        1.044272e-010
+            lp_js_pe =        3.350000e-006           lp_hdif_pe =        1.400000e-007           lp_rdsw_pe =        7.800000e-006
+           lp_jsw_pe =        3.350000e-010            lp_tox_pe =        2.480000e-009             lp_cj_pe =        7.912252e-004
+          lp_cjsw_pe =        4.747351e-011           lp_ldif_pe =        1.000000e-008             lp_xj_pe =        2.500000e-008
+            lp_rd_pe =        0.000000e+000             lp_pb_pe =        1.009805e+000             lp_cf_pe =        4.527118e-011
+          lp_lint_pe =        1.500000e-008          lp_cjswg_pe =        1.978063e-011            lp_rsh_pe =        2.000000e+001
+            lp_rs_pe =        0.000000e+000           lp_vsat_pe =        1.000000e+005
+      lp_gleak_scale =          1.0
include "gpdk090_mos.scs" section = lp_mos
endsection TT_lp

section FF_lp
parameters
+            lp_rs_ne =        0.000000e+000           lp_vsat_ne =        1.120000e+005         lp_pldd_surf =        6.000000e+019
+           lp_uc1_ne =       -6.420000e-011             lp_u0_ne =        2.600000e-002            lp_nch_ne =        7.650000e+017
+           lp_rsc_ne =        4.082483e-014           lp_cgbo_ne =        1.482000e-011            lp_prt_ne =        0.000000e+000
+           lp_rdc_ne =        4.082483e-014           lp_vth0_ne =        2.463513e-001             lp_k2_ne =        0.000000e+000
+          lp_cgdo_ne =        2.667600e-010         lp_ckappa_ne =        4.605336e+000           lp_wint_ne =        5.400000e-009
+            lp_k1_ne =        3.612264e-001           lp_cgsl_ne =        1.111500e-010         lp_nldd_surf =        3.000000e+019
+            lp_js_ne =        3.366667e-006           lp_hdif_ne =        1.400000e-007           lp_rdsw_ne =        3.900000e-006
+           lp_jsw_ne =        3.366667e-010            lp_tox_ne =        2.097000e-009             lp_cj_ne =        7.983537e-004
+          lp_cjsw_ne =        4.790122e-011           lp_ldif_ne =        1.000000e-008             lp_xj_ne =        2.500000e-008
+            lp_rd_ne =        0.000000e+000             lp_pb_ne =        9.918524e-001             lp_cf_ne =        4.594612e-011
+          lp_lint_ne =        1.650000e-008          lp_cjswg_ne =        1.995884e-011            lp_rsh_ne =        1.000000e+001
+            lp_u0_pe =        1.560000e-002            lp_nch_pe =        6.030000e+017            lp_rsc_pe =        2.886751e-014
+          lp_cgbo_pe =        1.392363e-011            lp_rdc_pe =        2.886751e-014           lp_vth0_pe =       -2.169761e-001
+            lp_k2_pe =        0.000000e+000           lp_cgdo_pe =        2.506253e-010         lp_ckappa_pe =        1.043477e+001
+          lp_wint_pe =        4.500000e-009             lp_k1_pe =        3.413526e-001           lp_cgsl_pe =        1.044272e-010
+            lp_js_pe =        3.350000e-006           lp_hdif_pe =        1.400000e-007           lp_rdsw_pe =        7.800000e-006
+           lp_jsw_pe =        3.350000e-010            lp_tox_pe =        2.232000e-009             lp_cj_pe =        7.912252e-004
+          lp_cjsw_pe =        4.747351e-011           lp_ldif_pe =        1.000000e-008             lp_xj_pe =        2.500000e-008
+            lp_rd_pe =        0.000000e+000             lp_pb_pe =        1.009805e+000             lp_cf_pe =        4.527118e-011
+          lp_lint_pe =        1.650000e-008          lp_cjswg_pe =        1.978063e-011            lp_rsh_pe =        2.000000e+001
+            lp_rs_pe =        0.000000e+000           lp_vsat_pe =        1.000000e+005
+      lp_gleak_scale =          2.0
include "gpdk090_mos.scs" section = lp_mos
endsection FF_lp

section SS_lp
parameters
+            lp_rs_ne =        0.000000e+000           lp_vsat_ne =        1.120000e+005         lp_pldd_surf =        6.000000e+019
+           lp_uc1_ne =       -6.420000e-011             lp_u0_ne =        1.400000e-002            lp_nch_ne =        9.350000e+017
+           lp_rsc_ne =        4.082483e-014           lp_cgbo_ne =        1.482000e-011            lp_prt_ne =        0.000000e+000
+           lp_rdc_ne =        4.082483e-014           lp_vth0_ne =        3.020626e-001             lp_k2_ne =        0.000000e+000
+          lp_cgdo_ne =        2.667600e-010         lp_ckappa_ne =        4.605336e+000           lp_wint_ne =        6.600000e-009
+            lp_k1_ne =        3.612264e-001           lp_cgsl_ne =        1.111500e-010         lp_nldd_surf =        3.000000e+019
+            lp_js_ne =        3.366667e-006           lp_hdif_ne =        1.400000e-007           lp_rdsw_ne =        3.900000e-006
+           lp_jsw_ne =        3.366667e-010            lp_tox_ne =        2.563000e-009             lp_cj_ne =        7.983537e-004
+          lp_cjsw_ne =        4.790122e-011           lp_ldif_ne =        1.000000e-008             lp_xj_ne =        2.500000e-008
+            lp_rd_ne =        0.000000e+000             lp_pb_ne =        9.918524e-001             lp_cf_ne =        4.594612e-011
+          lp_lint_ne =        1.350000e-008          lp_cjswg_ne =        1.995884e-011            lp_rsh_ne =        1.000000e+001
+            lp_u0_pe =        8.400000e-003            lp_nch_pe =        7.370000e+017            lp_rsc_pe =        2.886751e-014
+          lp_cgbo_pe =        1.392363e-011            lp_rdc_pe =        2.886751e-014           lp_vth0_pe =       -2.642265e-001
+            lp_k2_pe =        0.000000e+000           lp_cgdo_pe =        2.506253e-010         lp_ckappa_pe =        1.043477e+001
+          lp_wint_pe =        5.500000e-009             lp_k1_pe =        3.413526e-001           lp_cgsl_pe =        1.044272e-010
+            lp_js_pe =        3.350000e-006           lp_hdif_pe =        1.400000e-007           lp_rdsw_pe =        7.800000e-006
+           lp_jsw_pe =        3.350000e-010            lp_tox_pe =        2.728000e-009             lp_cj_pe =        7.912252e-004
+          lp_cjsw_pe =        4.747351e-011           lp_ldif_pe =        1.000000e-008             lp_xj_pe =        2.500000e-008
+            lp_rd_pe =        0.000000e+000             lp_pb_pe =        1.009805e+000             lp_cf_pe =        4.527118e-011
+          lp_lint_pe =        1.350000e-008          lp_cjswg_pe =        1.978063e-011            lp_rsh_pe =        2.000000e+001
+            lp_rs_pe =        0.000000e+000           lp_vsat_pe =        1.000000e+005
+      lp_gleak_scale =          0.5
include "gpdk090_mos.scs" section = lp_mos
endsection SS_lp

section FS_lp
parameters
+            lp_rs_ne =        0.000000e+000           lp_vsat_ne =        1.120000e+005         lp_pldd_surf =        6.000000e+019
+           lp_uc1_ne =       -6.420000e-011             lp_u0_ne =        2.600000e-002            lp_nch_ne =        7.650000e+017
+           lp_rsc_ne =        4.082483e-014           lp_cgbo_ne =        1.482000e-011            lp_prt_ne =        0.000000e+000
+           lp_rdc_ne =        4.082483e-014           lp_vth0_ne =        2.463513e-001             lp_k2_ne =        0.000000e+000
+          lp_cgdo_ne =        2.667600e-010         lp_ckappa_ne =        4.605336e+000           lp_wint_ne =        5.400000e-009
+            lp_k1_ne =        3.612264e-001           lp_cgsl_ne =        1.111500e-010         lp_nldd_surf =        3.000000e+019
+            lp_js_ne =        3.366667e-006           lp_hdif_ne =        1.400000e-007           lp_rdsw_ne =        3.900000e-006
+           lp_jsw_ne =        3.366667e-010            lp_tox_ne =        2.097000e-009             lp_cj_ne =        7.983537e-004
+          lp_cjsw_ne =        4.790122e-011           lp_ldif_ne =        1.000000e-008             lp_xj_ne =        2.500000e-008
+            lp_rd_ne =        0.000000e+000             lp_pb_ne =        9.918524e-001             lp_cf_ne =        4.594612e-011
+          lp_lint_ne =        1.650000e-008          lp_cjswg_ne =        1.995884e-011            lp_rsh_ne =        1.000000e+001
+            lp_u0_pe =        8.400000e-003            lp_nch_pe =        7.370000e+017            lp_rsc_pe =        2.886751e-014
+          lp_cgbo_pe =        1.392363e-011            lp_rdc_pe =        2.886751e-014           lp_vth0_pe =       -2.642265e-001
+            lp_k2_pe =        0.000000e+000           lp_cgdo_pe =        2.506253e-010         lp_ckappa_pe =        1.043477e+001
+          lp_wint_pe =        5.500000e-009             lp_k1_pe =        3.413526e-001           lp_cgsl_pe =        1.044272e-010
+            lp_js_pe =        3.350000e-006           lp_hdif_pe =        1.400000e-007           lp_rdsw_pe =        7.800000e-006
+           lp_jsw_pe =        3.350000e-010            lp_tox_pe =        2.728000e-009             lp_cj_pe =        7.912252e-004
+          lp_cjsw_pe =        4.747351e-011           lp_ldif_pe =        1.000000e-008             lp_xj_pe =        2.500000e-008
+            lp_rd_pe =        0.000000e+000             lp_pb_pe =        1.009805e+000             lp_cf_pe =        4.527118e-011
+          lp_lint_pe =        1.350000e-008          lp_cjswg_pe =        1.978063e-011            lp_rsh_pe =        2.000000e+001
+            lp_rs_pe =        0.000000e+000           lp_vsat_pe =        1.000000e+005
+      lp_gleak_scale =          1.0
include "gpdk090_mos.scs" section = lp_mos
endsection FS_lp

section SF_lp
parameters
+            lp_rs_ne =        0.000000e+000           lp_vsat_ne =        1.120000e+005         lp_pldd_surf =        6.000000e+019
+           lp_uc1_ne =       -6.420000e-011             lp_u0_ne =        1.400000e-002            lp_nch_ne =        9.350000e+017
+           lp_rsc_ne =        4.082483e-014           lp_cgbo_ne =        1.482000e-011            lp_prt_ne =        0.000000e+000
+           lp_rdc_ne =        4.082483e-014           lp_vth0_ne =        3.020626e-001             lp_k2_ne =        0.000000e+000
+          lp_cgdo_ne =        2.667600e-010         lp_ckappa_ne =        4.605336e+000           lp_wint_ne =        6.600000e-009
+            lp_k1_ne =        3.612264e-001           lp_cgsl_ne =        1.111500e-010         lp_nldd_surf =        3.000000e+019
+            lp_js_ne =        3.366667e-006           lp_hdif_ne =        1.400000e-007           lp_rdsw_ne =        3.900000e-006
+           lp_jsw_ne =        3.366667e-010            lp_tox_ne =        2.563000e-009             lp_cj_ne =        7.983537e-004
+          lp_cjsw_ne =        4.790122e-011           lp_ldif_ne =        1.000000e-008             lp_xj_ne =        2.500000e-008
+            lp_rd_ne =        0.000000e+000             lp_pb_ne =        9.918524e-001             lp_cf_ne =        4.594612e-011
+          lp_lint_ne =        1.350000e-008          lp_cjswg_ne =        1.995884e-011            lp_rsh_ne =        1.000000e+001
+            lp_u0_pe =        1.560000e-002            lp_nch_pe =        6.030000e+017            lp_rsc_pe =        2.886751e-014
+          lp_cgbo_pe =        1.392363e-011            lp_rdc_pe =        2.886751e-014           lp_vth0_pe =       -2.169761e-001
+            lp_k2_pe =        0.000000e+000           lp_cgdo_pe =        2.506253e-010         lp_ckappa_pe =        1.043477e+001
+          lp_wint_pe =        4.500000e-009             lp_k1_pe =        3.413526e-001           lp_cgsl_pe =        1.044272e-010
+            lp_js_pe =        3.350000e-006           lp_hdif_pe =        1.400000e-007           lp_rdsw_pe =        7.800000e-006
+           lp_jsw_pe =        3.350000e-010            lp_tox_pe =        2.232000e-009             lp_cj_pe =        7.912252e-004
+          lp_cjsw_pe =        4.747351e-011           lp_ldif_pe =        1.000000e-008             lp_xj_pe =        2.500000e-008
+            lp_rd_pe =        0.000000e+000             lp_pb_pe =        1.009805e+000             lp_cf_pe =        4.527118e-011
+          lp_lint_pe =        1.650000e-008          lp_cjswg_pe =        1.978063e-011            lp_rsh_pe =        2.000000e+001
+            lp_rs_pe =        0.000000e+000           lp_vsat_pe =        1.000000e+005
+      lp_gleak_scale =          1.0
include "gpdk090_mos.scs" section = lp_mos
endsection SF_lp

section TT_hv
parameters
+            hv_rs_ne =        0.000000e+000           hv_vsat_ne =        1.120000e+005         hv_pldd_surf =        6.000000e+019
* +           hv_uc1_ne =       -6.420000e-011             hv_u0_ne =        2.000000e-002            hv_nch_ne =        4.000000e+017
+           hv_uc1_ne =       -6.420000e-011             hv_u0_ne =        3.300000e-002            hv_nch_ne =        4.000000e+017
+           hv_rsc_ne =        4.082483e-014           hv_cgbo_ne =        6.166179e-012            hv_prt_ne =        0.000000e+000
+           hv_rdc_ne =        4.082483e-014           hv_vth0_ne =        4.485433e-001             hv_k2_ne =        0.000000e+000
+          hv_cgdo_ne =        1.109912e-010         hv_ckappa_ne =        2.660269e+001           hv_wint_ne =        6.000000e-009
+            hv_k1_ne =        5.955691e-001           hv_cgsl_ne =        4.624634e-011         hv_nldd_surf =        3.000000e+019
+            hv_js_ne =        3.366667e-006           hv_hdif_ne =        1.400000e-007           hv_rdsw_ne =        3.900000e-006
+           hv_jsw_ne =        3.366667e-010            hv_tox_ne =        5.600000e-009             hv_cj_ne =        7.983537e-004
+          hv_cjsw_ne =        4.790122e-011           hv_ldif_ne =        1.000000e-008             hv_xj_ne =        2.500000e-008
+            hv_rd_ne =        0.000000e+000             hv_pb_ne =        9.918524e-001             hv_cf_ne =        3.654122e-011
+          hv_lint_ne =        1.500000e-008          hv_cjswg_ne =        1.995884e-011            hv_rsh_ne =        1.000000e+001
* +            hv_u0_pe =        1.200000e-002            hv_nch_pe =        3.300000e+017            hv_rsc_pe =        2.886751e-014
+            hv_u0_pe =        2.200000e-002            hv_nch_pe =        3.300000e+017            hv_rsc_pe =        2.886751e-014
+          hv_cgbo_pe =        5.953552e-012            hv_rdc_pe =        2.886751e-014           hv_vth0_pe =       -4.023550e-001
+            hv_k2_pe =        0.000000e+000           hv_cgdo_pe =        1.071639e-010         hv_ckappa_pe =        5.707362e+001
+          hv_wint_pe =        5.000000e-009             hv_k1_pe =        5.602722e-001           hv_cgsl_pe =        4.465164e-011
+            hv_js_pe =        3.350000e-006           hv_hdif_pe =        1.400000e-007           hv_rdsw_pe =        7.800000e-006
+           hv_jsw_pe =        3.350000e-010            hv_tox_pe =        5.800000e-009             hv_cj_pe =        7.912252e-004
+          hv_cjsw_pe =        4.747351e-011           hv_ldif_pe =        1.000000e-008             hv_xj_pe =        2.500000e-008
+            hv_rd_pe =        0.000000e+000             hv_pb_pe =        1.009805e+000             hv_cf_pe =        3.616963e-011
+          hv_lint_pe =        1.500000e-008          hv_cjswg_pe =        1.978063e-011            hv_rsh_pe =        2.000000e+001
+            hv_rs_pe =        0.000000e+000           hv_vsat_pe =        1.000000e+005
+      hv_nat_vth0_ne =        0.485433e-001         hv_nat_k1_ne =        5.955691e-002
include "gpdk090_mos.scs" section = hv_mos
endsection TT_hv

section FF_hv
parameters
+            hv_rs_ne =        0.000000e+000           hv_vsat_ne =        1.120000e+005         hv_pldd_surf =        6.000000e+019
* +           hv_uc1_ne =       -6.420000e-011             hv_u0_ne =        2.600000e-002            hv_nch_ne =        3.600000e+017
+           hv_uc1_ne =       -6.420000e-011             hv_u0_ne =        3.900000e-002            hv_nch_ne =        3.600000e+017
+           hv_rsc_ne =        4.082483e-014           hv_cgbo_ne =        6.166179e-012            hv_prt_ne =        0.000000e+000
+           hv_rdc_ne =        4.082483e-014           hv_vth0_ne =        4.032345e-001             hv_k2_ne =        0.000000e+000
+          hv_cgdo_ne =        1.109912e-010         hv_ckappa_ne =        2.660269e+001           hv_wint_ne =        5.400000e-009
+            hv_k1_ne =        5.955691e-001           hv_cgsl_ne =        4.624634e-011         hv_nldd_surf =        3.000000e+019
+            hv_js_ne =        3.366667e-006           hv_hdif_ne =        1.400000e-007           hv_rdsw_ne =        3.900000e-006
+           hv_jsw_ne =        3.366667e-010            hv_tox_ne =        5.040000e-009             hv_cj_ne =        7.983537e-004
+          hv_cjsw_ne =        4.790122e-011           hv_ldif_ne =        1.000000e-008             hv_xj_ne =        2.500000e-008
+            hv_rd_ne =        0.000000e+000             hv_pb_ne =        9.918524e-001             hv_cf_ne =        3.654122e-011
+          hv_lint_ne =        1.650000e-008          hv_cjswg_ne =        1.995884e-011            hv_rsh_ne =        1.000000e+001
* +            hv_u0_pe =        1.560000e-002            hv_nch_pe =        2.970000e+017            hv_rsc_pe =        2.886751e-014
+            hv_u0_pe =        2.600000e-002            hv_nch_pe =        2.970000e+017            hv_rsc_pe =        2.886751e-014
+          hv_cgbo_pe =        5.953552e-012            hv_rdc_pe =        2.886751e-014           hv_vth0_pe =       -3.625740e-001
+            hv_k2_pe =        0.000000e+000           hv_cgdo_pe =        1.071639e-010         hv_ckappa_pe =        5.707362e+001
+          hv_wint_pe =        4.500000e-009             hv_k1_pe =        5.602722e-001           hv_cgsl_pe =        4.465164e-011
+            hv_js_pe =        3.350000e-006           hv_hdif_pe =        1.400000e-007           hv_rdsw_pe =        7.800000e-006
+           hv_jsw_pe =        3.350000e-010            hv_tox_pe =        5.220000e-009             hv_cj_pe =        7.912252e-004
+          hv_cjsw_pe =        4.747351e-011           hv_ldif_pe =        1.000000e-008             hv_xj_pe =        2.500000e-008
+            hv_rd_pe =        0.000000e+000             hv_pb_pe =        1.009805e+000             hv_cf_pe =        3.616963e-011
+          hv_lint_pe =        1.650000e-008          hv_cjswg_pe =        1.978063e-011            hv_rsh_pe =        2.000000e+001
+            hv_rs_pe =        0.000000e+000           hv_vsat_pe =        1.000000e+005
+      hv_nat_vth0_ne =        0.032345e-001         hv_nat_k1_ne =        5.955691e-002
include "gpdk090_mos.scs" section = hv_mos
endsection FF_hv

section SS_hv
parameters
+            hv_rs_ne =        0.000000e+000           hv_vsat_ne =        1.120000e+005         hv_pldd_surf =        6.000000e+019
* +           hv_uc1_ne =       -6.420000e-011             hv_u0_ne =        1.400000e-002            hv_nch_ne =        4.400000e+017
+           hv_uc1_ne =       -6.420000e-011             hv_u0_ne =        2.400000e-002            hv_nch_ne =        4.400000e+017
+           hv_rsc_ne =        4.082483e-014           hv_cgbo_ne =        6.166179e-012            hv_prt_ne =        0.000000e+000
+           hv_rdc_ne =        4.082483e-014           hv_vth0_ne =        4.938087e-001             hv_k2_ne =        0.000000e+000
+          hv_cgdo_ne =        1.109912e-010         hv_ckappa_ne =        2.660269e+001           hv_wint_ne =        6.600000e-009
+            hv_k1_ne =        5.955691e-001           hv_cgsl_ne =        4.624634e-011         hv_nldd_surf =        3.000000e+019
+            hv_js_ne =        3.366667e-006           hv_hdif_ne =        1.400000e-007           hv_rdsw_ne =        3.900000e-006
+           hv_jsw_ne =        3.366667e-010            hv_tox_ne =        6.160000e-009             hv_cj_ne =        7.983537e-004
+          hv_cjsw_ne =        4.790122e-011           hv_ldif_ne =        1.000000e-008             hv_xj_ne =        2.500000e-008
+            hv_rd_ne =        0.000000e+000             hv_pb_ne =        9.918524e-001             hv_cf_ne =        3.654122e-011
+          hv_lint_ne =        1.350000e-008          hv_cjswg_ne =        1.995884e-011            hv_rsh_ne =        1.000000e+001
* +            hv_u0_pe =        8.400000e-003            hv_nch_pe =        3.630000e+017            hv_rsc_pe =        2.886751e-014
+            hv_u0_pe =        9.500000e-003            hv_nch_pe =        3.630000e+017            hv_rsc_pe =        2.886751e-014
+          hv_cgbo_pe =        5.953552e-012            hv_rdc_pe =        2.886751e-014           hv_vth0_pe =       -4.421794e-001
+            hv_k2_pe =        0.000000e+000           hv_cgdo_pe =        1.071639e-010         hv_ckappa_pe =        5.707362e+001
+          hv_wint_pe =        5.500000e-009             hv_k1_pe =        5.602722e-001           hv_cgsl_pe =        4.465164e-011
+            hv_js_pe =        3.350000e-006           hv_hdif_pe =        1.400000e-007           hv_rdsw_pe =        7.800000e-006
+           hv_jsw_pe =        3.350000e-010            hv_tox_pe =        6.380000e-009             hv_cj_pe =        7.912252e-004
+          hv_cjsw_pe =        4.747351e-011           hv_ldif_pe =        1.000000e-008             hv_xj_pe =        2.500000e-008
+            hv_rd_pe =        0.000000e+000             hv_pb_pe =        1.009805e+000             hv_cf_pe =        3.616963e-011
+          hv_lint_pe =        1.350000e-008          hv_cjswg_pe =        1.978063e-011            hv_rsh_pe =        2.000000e+001
+            hv_rs_pe =        0.000000e+000           hv_vsat_pe =        1.000000e+005
+      hv_nat_vth0_ne =        0.938087e-001         hv_nat_k1_ne =        5.955691e-002
include "gpdk090_mos.scs" section = hv_mos
endsection SS_hv

section FS_hv
parameters
+            hv_rs_ne =        0.000000e+000           hv_vsat_ne =        1.120000e+005         hv_pldd_surf =        6.000000e+019
* +           hv_uc1_ne =       -6.420000e-011             hv_u0_ne =        2.600000e-002            hv_nch_ne =        3.600000e+017
+           hv_uc1_ne =       -6.420000e-011             hv_u0_ne =        3.900000e-002            hv_nch_ne =        3.600000e+017
+           hv_rsc_ne =        4.082483e-014           hv_cgbo_ne =        6.166179e-012            hv_prt_ne =        0.000000e+000
+           hv_rdc_ne =        4.082483e-014           hv_vth0_ne =        4.032345e-001             hv_k2_ne =        0.000000e+000
+          hv_cgdo_ne =        1.109912e-010         hv_ckappa_ne =        2.660269e+001           hv_wint_ne =        5.400000e-009
+            hv_k1_ne =        5.955691e-001           hv_cgsl_ne =        4.624634e-011         hv_nldd_surf =        3.000000e+019
+            hv_js_ne =        3.366667e-006           hv_hdif_ne =        1.400000e-007           hv_rdsw_ne =        3.900000e-006
+           hv_jsw_ne =        3.366667e-010            hv_tox_ne =        5.040000e-009             hv_cj_ne =        7.983537e-004
+          hv_cjsw_ne =        4.790122e-011           hv_ldif_ne =        1.000000e-008             hv_xj_ne =        2.500000e-008
+            hv_rd_ne =        0.000000e+000             hv_pb_ne =        9.918524e-001             hv_cf_ne =        3.654122e-011
+          hv_lint_ne =        1.650000e-008          hv_cjswg_ne =        1.995884e-011            hv_rsh_ne =        1.000000e+001
* +            hv_u0_pe =        8.400000e-003            hv_nch_pe =        3.630000e+017            hv_rsc_pe =        2.886751e-014
+            hv_u0_pe =        9.500000e-003            hv_nch_pe =        3.630000e+017            hv_rsc_pe =        2.886751e-014
+          hv_cgbo_pe =        5.953552e-012            hv_rdc_pe =        2.886751e-014           hv_vth0_pe =       -4.421794e-001
+            hv_k2_pe =        0.000000e+000           hv_cgdo_pe =        1.071639e-010         hv_ckappa_pe =        5.707362e+001
+          hv_wint_pe =        5.500000e-009             hv_k1_pe =        5.602722e-001           hv_cgsl_pe =        4.465164e-011
+            hv_js_pe =        3.350000e-006           hv_hdif_pe =        1.400000e-007           hv_rdsw_pe =        7.800000e-006
+           hv_jsw_pe =        3.350000e-010            hv_tox_pe =        6.380000e-009             hv_cj_pe =        7.912252e-004
+          hv_cjsw_pe =        4.747351e-011           hv_ldif_pe =        1.000000e-008             hv_xj_pe =        2.500000e-008
+            hv_rd_pe =        0.000000e+000             hv_pb_pe =        1.009805e+000             hv_cf_pe =        3.616963e-011
+          hv_lint_pe =        1.350000e-008          hv_cjswg_pe =        1.978063e-011            hv_rsh_pe =        2.000000e+001
+            hv_rs_pe =        0.000000e+000           hv_vsat_pe =        1.000000e+005
+      hv_nat_vth0_ne =        0.032345e-001         hv_nat_k1_ne =        5.955691e-002
include "gpdk090_mos.scs" section = hv_mos
endsection FS_hv

section SF_hv
parameters
+            hv_rs_ne =        0.000000e+000           hv_vsat_ne =        1.120000e+005         hv_pldd_surf =        6.000000e+019
* +           hv_uc1_ne =       -6.420000e-011             hv_u0_ne =        1.400000e-002            hv_nch_ne =        4.400000e+017
+           hv_uc1_ne =       -6.420000e-011             hv_u0_ne =        2.400000e-002            hv_nch_ne =        4.400000e+017
+           hv_rsc_ne =        4.082483e-014           hv_cgbo_ne =        6.166179e-012            hv_prt_ne =        0.000000e+000
+           hv_rdc_ne =        4.082483e-014           hv_vth0_ne =        4.938087e-001             hv_k2_ne =        0.000000e+000
+          hv_cgdo_ne =        1.109912e-010         hv_ckappa_ne =        2.660269e+001           hv_wint_ne =        6.600000e-009
+            hv_k1_ne =        5.955691e-001           hv_cgsl_ne =        4.624634e-011         hv_nldd_surf =        3.000000e+019
+            hv_js_ne =        3.366667e-006           hv_hdif_ne =        1.400000e-007           hv_rdsw_ne =        3.900000e-006
+           hv_jsw_ne =        3.366667e-010            hv_tox_ne =        6.160000e-009             hv_cj_ne =        7.983537e-004
+          hv_cjsw_ne =        4.790122e-011           hv_ldif_ne =        1.000000e-008             hv_xj_ne =        2.500000e-008
+            hv_rd_ne =        0.000000e+000             hv_pb_ne =        9.918524e-001             hv_cf_ne =        3.654122e-011
+          hv_lint_ne =        1.350000e-008          hv_cjswg_ne =        1.995884e-011            hv_rsh_ne =        1.000000e+001
* +            hv_u0_pe =        1.560000e-002            hv_nch_pe =        2.970000e+017            hv_rsc_pe =        2.886751e-014
+            hv_u0_pe =        2.500000e-002            hv_nch_pe =        2.970000e+017            hv_rsc_pe =        2.886751e-014
+          hv_cgbo_pe =        5.953552e-012            hv_rdc_pe =        2.886751e-014           hv_vth0_pe =       -3.625740e-001
+            hv_k2_pe =        0.000000e+000           hv_cgdo_pe =        1.071639e-010         hv_ckappa_pe =        5.707362e+001
+          hv_wint_pe =        4.500000e-009             hv_k1_pe =        5.602722e-001           hv_cgsl_pe =        4.465164e-011
+            hv_js_pe =        3.350000e-006           hv_hdif_pe =        1.400000e-007           hv_rdsw_pe =        7.800000e-006
+           hv_jsw_pe =        3.350000e-010            hv_tox_pe =        5.220000e-009             hv_cj_pe =        7.912252e-004
+          hv_cjsw_pe =        4.747351e-011           hv_ldif_pe =        1.000000e-008             hv_xj_pe =        2.500000e-008
+            hv_rd_pe =        0.000000e+000             hv_pb_pe =        1.009805e+000             hv_cf_pe =        3.616963e-011
+          hv_lint_pe =        1.650000e-008          hv_cjswg_pe =        1.978063e-011            hv_rsh_pe =        2.000000e+001
+            hv_rs_pe =        0.000000e+000           hv_vsat_pe =        1.000000e+005
+      hv_nat_vth0_ne =        0.938087e-001         hv_nat_k1_ne =        5.955691e-002
include "gpdk090_mos.scs" section = hv_mos
endsection SF_hv

section s1v_mos

*inline subckt gpdk090_nmoscap1v (D G S B)
*parameters l=0.1u w=10u simM=1 nrd=s1v_hdif_ne/w nrs=s1v_hdif_ne/w  as=1p ad=1p ps=1u pd=1u
*gpdk090_nmoscap1v (D G S B) gpdk090_nmos1v  w=w l=l nrd=nrd nrs=nrs
*ends gpdk090_nmoscap1v

inline subckt gpdk090_nmos1v (D G S B)
parameters l=0.1u w=10u simM=1 nrd=s1v_hdif_ne/w nrs=s1v_hdif_ne/w  as=1p ad=1p ps=1u pd=1u
+ garea=w*l  maforward=2.5e3*garea*gleak_scale   mareverse=.03*maforward
//mismatch
+ varvt =  .004   // 1 sigma Vt mismatch variation in unit of v-um
+ geo_fac =  0.7071 / sqrt(l*w*simM*1e12)
+ mm_delvt = varvt * geo_fac * pvt_mc
+ mm_mu0 = 1-(.005 * geo_fac * pu0_mc )
+ mm_dl= 2e-03  * geo_fac * l * pltw_mc
+ mm_dw = - 24e-03 * geo_fac * w *  pltw_mc
+ mm_dtox = 2e-03 * geo_fac * s1v_tox_ne *  pltw_mc

gpdk090_nmos1v (D G S B)  gpdk090_nmos1v_x  w=w l=l as=as ad=ad ps=ps pd=pd nrd=nrd nrs=nrs
+ aforward=maforward areverse=mareverse

model gpdk090_nmos1v_x bsim3v3 type = n
+ mvtwl = varvt*1u  mbewl = 0.025*1u
+                lmin =                   0.0                lmax =                  1.0                 wmin =                  0.0
+                wmax =                  1.0                 tnom =                 25.0              version =                  3.2
+                 tox =           s1v_tox_ne + mm_dtox       toxm =           s1v_tox_ne  + mm_dtox        xj =            s1v_xj_ne
+                 nch =           s1v_nch_ne                  lln =            1.0000000                  lwn =            1.0000000
+                 wln =            1.0000000                  wwn =           -1.0000000                 lint =          s1v_lint_ne
+                  ll =                 0.00                   lw =                 0.00                  lwl =                 0.00
+                wint =          s1v_wint_ne                   wl =                 0.00                   ww =                 0.00
+                 wwl =                 0.00               mobmod =                    1              binunit =                    2
+                  xl =                mm_dl                   xw =                mm_dw                  dwg =                 0.00
+                 dwb =                 0.00                  acm =                   12                 ldif =          s1v_ldif_ne
+                hdif =          s1v_hdif_ne                  rsh =           s1v_rsh_ne                   rd =            s1v_rd_ne
+                  rs =            s1v_rs_ne                  rsc =           s1v_rsc_ne                  rdc =           s1v_rdc_ne
+                vth0 =          s1v_vth0_ne + mm_delvt       k1 =            s1v_k1_ne                   k2 =            s1v_k2_ne
+                  k3 =           -2.3000000                 dvt0 =              3.86366                 dvt1 =                  1.2
+                dvt2 =        5.0299990E-02                dvt0w =                 0.00                dvt1w =                 0.00
+               dvt2w =                 0.00                  nlx =        1.2517999E-07                   w0 =       -7.1353000E-09
+                 k3b =            0.5576769                ngate =               4.0E20                 vsat =          s1v_vsat_ne
+                  ua =       -6.1879500E-10                   ub =        1.8806652E-18                   uc =        1.3823546E-10
+                rdsw =          s1v_rdsw_ne                 prwb =                 0.00                 prwg =                 0.00
+                  wr =            1.0000000                   u0 =            s1v_u0_ne *mm_mu0           a0 =            2.3750000
+                keta =       -3.1429991E-02                   a1 =                 0.00                   a2 =            0.9900000
+                 ags =            0.8900000                   b0 =                 0.00                   b1 =                 0.00
+                voff =       -9.6776000E-02              nfactor =            1.0200000                  cit =       -8.6656060E-04
+                cdsc =        4.4460000E-02                cdscb =        1.0565110E-02                cdscd =                 0.00
+                eta0 =        7.6580000E-02                 etab =       -3.4998000E-02                 dsub =            0.2200000
+                pclm =            1.5488822              pdiblc1 =                 0.00              pdiblc2 =        2.4648249E-02
+             pdiblcb =                 0.00                drout =                 0.00               pscbe1 =         9.2648200E08
+              pscbe2 =        1.0000000E-20                 pvag =                 0.00                delta =        7.5000000E-03
+              alpha0 =                 0.00               alpha1 =               0.0177                beta0 =               6.3203
+                 kt1 =                -0.13                  kt2 =               -0.042                   at =         9.0000000E04
+                 ute =           -1.7303560                  ua1 =        1.8035814E-09                  ub1 =       -2.1874742E-18
+                 uc1 =           s1v_uc1_ne                 kt1l =                 0.00                  prt =           s1v_prt_ne
+                  cj =            s1v_cj_ne                   mj =                0.222                   pb =            s1v_pb_ne
+                cjsw =          s1v_cjsw_ne                 mjsw =                 0.01                 pbsw =                  0.1
+               cjswg =         s1v_cjswg_ne                mjswg =               0.5028                pbswg =               0.6859
+                 tpb =             1.30E-03                tpbsw =               0.0000               tpbswg =             2.81E-03
+                 tcj =             7.61E-04                tcjsw =             1.04E-03               tcjswg =             1.63E-03
+                  js =            s1v_js_ne                  jsw =           s1v_jsw_ne                    n =                    1
+                 xti =                    3                 cgdo =          s1v_cgdo_ne                 cgso =          s1v_cgdo_ne
+                cgbo =          s1v_cgbo_ne               capmod =                    2               nqsmod =                    0
+                 elm =                    5                xpart =                    1                 cgsl =          s1v_cgsl_ne
+                cgdl =          s1v_cgsl_ne               ckappa =        s1v_ckappa_ne                   cf =            s1v_cf_ne
+                 clc =        1.0000000E-07                  cle =            0.6000000                  dlc =             1.89E-08
+                 dwc =             1.62E-08                  llc =             1.53E-16                  lwc =             -9.0E-16
+                 wlc =                    0                  wwc =              -0.0989                 lwlc =                    0
+                wwlc =                    0                 acde =                  0.5                 moin =                 10.5
+                noff =                 1.85               voffcv =               -0.048              lvoffcv =              2.0E-09
+             calcacm =                    1             sfvtflag =                    0                 tlev =                    1
+               tlevc =                    1                 ijth =                 1
+                noia =              1.0e+19                 noib =                 2e+4                 noic =              1.0e-13
+                  ef =                  1.0               noimod =                    2                   em =                 4e+7
+            bforward =                  3.3             breverse =                  3.3               cforward =                1.5
+            creverse =                  1.5                  tcc =                 2e-3
ends gpdk090_nmos1v

*inline subckt gpdk090_pmoscap1v (D G S B)
*parameters l=0.1u w=10u simM=1 nrd=s1v_hdif_ne/w nrs=s1v_hdif_ne/w  as=1p ad=1p ps=1u pd=1u
*gpdk090_pmoscap1v (p11 p2 p33 p4) gpdk090_pmos1v  w=w l=l nrd=nrd nrs=nrs
*ends gpdk090_pmoscap1v

inline subckt  gpdk090_pmos1v  (D G S B)
parameters l=0.1u w=10u simM=1 nrd=s1v_hdif_pe/w nrs=s1v_hdif_pe/w  as=1p ad=1p ps=1u pd=1u
+ garea=w*l  maforward=1.6e3*garea*gleak_scale   mareverse=.03*maforward
//mismatch
+ varvt =  .003   // 1 sigma Vt mismatch variation in unit of v-um
+ geo_fac =  0.7071 / sqrt(l*w*simM*1e12)
+ mm_delvt = varvt * geo_fac * pvt_mc
+ mm_mu0 = 1-(.005 * geo_fac * pu0_mc )
+ mm_dl= 2e-03  * geo_fac * l * pltw_mc
+ mm_dw = - 24e-03 * geo_fac * w *  pltw_mc
+ mm_dtox = 2e-03 * geo_fac * s1v_tox_pe *  pltw_mc

gpdk090_pmos1v (D G S B) gpdk090_pmos1v_x  w=w l=l as=as ad=ad ps=ps pd=pd nrd=nrd nrs=nrs
+ aforward=maforward areverse=mareverse

model gpdk090_pmos1v_x bsim3v3 type = p
+ mvtwl = varvt*1u  mbewl = 0.025*1u
+                lmin =                  0.0                 lmax =                  1.0                 wmin =                  0.0
+                wmax =                  1.0                 tnom =                 25.0              version =                  3.2
+                 tox =           s1v_tox_pe+ mm_dtox        toxm =           s1v_tox_pe+ mm_dtox          xj =            s1v_xj_pe
+                 nch =         1.7200001E17                  lln =            1.0000000                  lwn =            1.0000000
+                 wln =            1.0000000                  wwn =           -1.0000000                 lint =          s1v_lint_pe
+                  ll =                 0.00                   lw =                 0.00                  lwl =                 0.00
+                wint =          s1v_wint_pe                   wl =                 0.00                   ww =                 0.00
+                 wwl =                 0.00               mobmod =                    1              binunit =                    2
+                  xl =                mm_dl                   xw =                mm_dw                  dwg =                 0.00
+                 dwb =                 0.00                  acm =                   12                 ldif =          s1v_ldif_pe
+                hdif =          s1v_hdif_pe                  rsh =           s1v_rsh_pe                   rd =            s1v_rd_pe
+                  rs =            s1v_rs_pe                  rsc =           s1v_rsc_pe                  rdc =           s1v_rdc_pe
+                vth0 =          s1v_vth0_pe + mm_delvt       pvth0 =                  0                   k1 =            s1v_k1_pe
+                  k2 =            s1v_k2_pe                   k3 =           -0.5000000                 dvt0 =                  8.0
+                dvt1 =                 2.07                 dvt2 =            0.1000000                dvt0w =                 0.00
+               dvt1w =                 0.00                dvt2w =                 0.00                  nlx =        2.2400000E-07
+                  w0 =                 0.00                  k3b =        7.0000000E-02                ngate =         9.3200000E19
+                vsat =          s1v_vsat_pe                   ua =       -2.7643932E-10                   ub =        2.2546092E-18
+                  uc =        1.6265005E-10                 rdsw =          s1v_rdsw_pe                 prwb =                 0.00
+                prwg =                 0.00                   wr =            1.0000000                   u0 =            s1v_u0_pe*mm_mu0
+                  a0 =            2.9669099                 keta =       -8.2015020E-02                   a1 =                 0.00
+                  a2 =            1.0000000                  ags =            1.2279299                   b0 =                 0.00
+                  b1 =                 0.00                 voff =           -0.1170768              nfactor =            1.0000000
+                 cit =       -2.5695576E-03                 cdsc =                 0.00                cdscb =                 0.00
+               cdscd =                 0.00                 eta0 =        5.0000000E-02                leta0 =                    0
+                etab =                    0                 dsub =            0.3000000                 pclm =            1.0000000
+             pdiblc1 =        6.0000000E-03              pdiblc2 =        5.0000000E-03              pdiblcb =           -0.5267781
+               drout =                 0.00               pscbe1 =         5.1300000E08               pscbe2 =        4.8900000E-07
+                pvag =                 0.00                delta =        9.9999990E-03               alpha0 =                 0.00
+              alpha1 =                0.001                beta0 =                  7.6                  kt1 =                -0.11
+                 kt2 =        4.4329650E-02                   at =         1.0000000E04                  ute =           -1.4468272
+                 ua1 =        1.2158887E-09                  ub1 =       -4.0489830E-18                  uc1 =       -5.6549980E-10
+                kt1l =                 0.00                  prt =                    0                   cj =            s1v_cj_pe
+                  mj =                0.331                   pb =            s1v_pb_pe                 cjsw =          s1v_cjsw_pe
+                mjsw =                 0.01                 pbsw =                 0.10                cjswg =         s1v_cjswg_pe
+               mjswg =               0.7833                pbswg =               0.8137                  tpb =              0.00173
+               tpbsw =                  0.0               tpbswg =               0.0044                  tcj =             0.000949
+               tcjsw =            0.0000758               tcjswg =              0.00388                   js =            s1v_js_pe
+                 jsw =           s1v_jsw_pe                    n =                    1                  xti =                    3
+                cgdo =          s1v_cgdo_pe                 cgso =          s1v_cgdo_pe                 cgbo =          s1v_cgbo_pe
+              capmod =                    2               nqsmod =                    0                  elm =                    5
+               xpart =                    1                 cgsl =          s1v_cgsl_pe                 cgdl =          s1v_cgsl_pe
+              ckappa =        s1v_ckappa_pe                   cf =            s1v_cf_pe                  clc =        1.0000000E-07
+                 cle =            0.6000000                  dlc =            2.252E-08                  dwc =           1.2404E-08
+                 llc =             -1.2E-16                  lwc =             -6.2E-16                  wlc =                    0
+                 wwc =                -0.15                 lwlc =                    0                 wwlc =                    0
+                acde =                  0.5                 moin =                 15.6                 noff =                 2.16
+              voffcv =              -0.0385              lvoffcv =            -3.80E-09                lnoff =             7.50E-08
+             calcacm =                    1             sfvtflag =                    0                 tlev =                    1
+               tlevc =                    1                 ijth =                 1
+                noia =              1.0e+19                 noib =               2.0e+3                 noic =              1.0e-11
+                  ef =                  1.1               noimod =                    2                   em =               1.0e+8
+            bforward =                  3.0             breverse =                  3.0               cforward =                1.0
+            creverse =                  1.0                  tcc =                 2e-3
ends gpdk090_pmos1v

inline subckt gpdk090_nmos1v_nat (D G S B)
parameters l=0.1u w=10u simM=1 nrd=s1v_hdif_ne/w nrs=s1v_hdif_ne/w  as=1p ad=1p ps=1u pd=1u
+ garea=w*l  maforward=2.5e3*garea*gleak_scale   mareverse=.03*maforward
//mismatch
+ varvt =  .004   // 1 sigma Vt mismatch variation in unit of v-um
+ geo_fac =  0.7071 / sqrt(l*w*simM*1e12)
+ mm_delvt = varvt * geo_fac * pvt_mc
+ mm_mu0 = 1-(.005 * geo_fac * pu0_mc )
+ mm_dl= 2e-03  * geo_fac * l * pltw_mc
+ mm_dw = - 24e-03 * geo_fac * w *  pltw_mc
+ mm_dtox = 2e-03 * geo_fac * s1v_tox_ne *  pltw_mc

gpdk090_nmos1v_nat (D G S B)  gpdk090_nmos1v_nat_x  w=w l=l as=as ad=ad ps=ps pd=pd nrd=nrd nrs=nrs
+ aforward=maforward areverse=mareverse

model gpdk090_nmos1v_nat_x bsim3v3 type = n
+ mvtwl = varvt*1u  mbewl = 0.025*1u
+                lmin =                   0.0                lmax =                  1.0                 wmin =                  0.0
+                wmax =                  1.0                 tnom =                 25.0              version =                  3.2
+                 tox =           s1v_tox_ne + mm_dtox       toxm =           s1v_tox_ne + mm_dtox         xj =            s1v_xj_ne
+                 nch =           s1v_nch_ne                  lln =            1.0000000                  lwn =            1.0000000
+                 wln =            1.0000000                  wwn =           -1.0000000                 lint =          s1v_lint_ne
+                  ll =                 0.00                   lw =                 0.00                  lwl =                 0.00
+                wint =          s1v_wint_ne                   wl =                 0.00                   ww =                 0.00
+                 wwl =                 0.00               mobmod =                    1              binunit =                    2
+                  xl =                mm_dl                   xw =                mm_dw                  dwg =                 0.00
+                 dwb =                 0.00                  acm =                   12                 ldif =          s1v_ldif_ne
+                hdif =          s1v_hdif_ne                  rsh =           s1v_rsh_ne                   rd =            s1v_rd_ne
+                  rs =            s1v_rs_ne                  rsc =           s1v_rsc_ne                  rdc =           s1v_rdc_ne
+                vth0 =      s1v_nat_vth0_ne  + mm_delvt       k1 =        s1v_nat_k1_ne                   k2 =            s1v_k2_ne
+                  k3 =           -2.3000000                 dvt0 =              3.86366                 dvt1 =                  1.2
+                dvt2 =        5.0299990E-02                dvt0w =                 0.00                dvt1w =                 0.00
+               dvt2w =                 0.00                  nlx =        1.2517999E-07                   w0 =       -7.1353000E-09
+                 k3b =            0.5576769                ngate =               4.0E20                 vsat =          s1v_vsat_ne
+                  ua =       -6.1879500E-10                   ub =        1.8806652E-18                   uc =        1.3823546E-10
+                rdsw =          s1v_rdsw_ne                 prwb =                 0.00                 prwg =                 0.00
+                  wr =            1.0000000                   u0 =            s1v_u0_ne*mm_mu0            a0 =            2.3750000
+                keta =       -3.1429991E-02                   a1 =                 0.00                   a2 =            0.9900000
+                 ags =            0.8900000                   b0 =                 0.00                   b1 =                 0.00
+                voff =       -9.6776000E-02              nfactor =            1.0200000                  cit =       -8.6656060E-04
+                cdsc =        4.4460000E-02                cdscb =        1.0565110E-02                cdscd =                 0.00
+                eta0 =        7.6580000E-02                 etab =       -3.4998000E-02                 dsub =            0.2200000
+                pclm =            1.5488822              pdiblc1 =                 0.00              pdiblc2 =        2.4648249E-02
+             pdiblcb =                 0.00                drout =                 0.00               pscbe1 =         9.2648200E08
+              pscbe2 =        1.0000000E-20                 pvag =                 0.00                delta =        7.5000000E-03
+              alpha0 =                 0.00               alpha1 =               0.0177                beta0 =               6.3203
+                 kt1 =                -0.13                  kt2 =               -0.042                   at =         9.0000000E04
+                 ute =           -1.7303560                  ua1 =        1.8035814E-09                  ub1 =       -2.1874742E-18
+                 uc1 =           s1v_uc1_ne                 kt1l =                 0.00                  prt =           s1v_prt_ne
+                  cj =            s1v_cj_ne                   mj =                0.222                   pb =            s1v_pb_ne
+                cjsw =          s1v_cjsw_ne                 mjsw =                 0.01                 pbsw =                  0.1
+               cjswg =         s1v_cjswg_ne                mjswg =               0.5028                pbswg =               0.6859
+                 tpb =             1.30E-03                tpbsw =               0.0000               tpbswg =             2.81E-03
+                 tcj =             7.61E-04                tcjsw =             1.04E-03               tcjswg =             1.63E-03
+                  js =            s1v_js_ne                  jsw =           s1v_jsw_ne                    n =                    1
+                 xti =                    3                 cgdo =          s1v_cgdo_ne                 cgso =          s1v_cgdo_ne
+                cgbo =          s1v_cgbo_ne               capmod =                    2               nqsmod =                    0
+                 elm =                    5                xpart =                    1                 cgsl =          s1v_cgsl_ne
+                cgdl =          s1v_cgsl_ne               ckappa =        s1v_ckappa_ne                   cf =            s1v_cf_ne
+                 clc =        1.0000000E-07                  cle =            0.6000000                  dlc =             1.89E-08
+                 dwc =             1.62E-08                  llc =             1.53E-16                  lwc =             -9.0E-16
+                 wlc =                    0                  wwc =              -0.0989                 lwlc =                    0
+                wwlc =                    0                 acde =                  0.5                 moin =                 10.5
+                noff =                 1.85               voffcv =               -0.048              lvoffcv =              2.0E-09
+             calcacm =                    1             sfvtflag =                    0                 tlev =                    1
+               tlevc =                    1                 ijth =                 1
+                noia =              1.0e+19                 noib =                 2e+4                 noic =              1.0e-13
+                  ef =                  1.0               noimod =                    2                   em =                 4e+7
+            bforward =                  3.3             breverse =                  3.3               cforward =                1.5
+            creverse =                  1.5                  tcc =                 2e-3
ends gpdk090_nmos1v_nat

endsection s1v_mos

section lp_mos

*inline subckt gpdk090_nmoscap1v_hvt (D G S B)
*parameters l=0.1u w=10u simM=1 nrd=s1v_hdif_ne/w nrs=s1v_hdif_ne/w  as=1p ad=1p ps=1u pd=1u
*gpdk090_nmoscap1v_hvt (D G S B) gpdk090_nmos1v_hvt  w=w l=l nrd=nrd nrs=nrs
*ends gpdk090_nmoscap1v_hvt

inline subckt gpdk090_nmos1v_hvt (D G S B)
parameters l=0.1u w=10u simM=1 nrd=lp_hdif_ne/w nrs=lp_hdif_ne/w  as=1p ad=1p ps=1u pd=1u
+ garea=w*l  maforward=2.5e3*garea*lp_gleak_scale   mareverse=.03*maforward
//mismatch
+ varvt =  .004   // 1 sigma Vt mismatch variation in unit of v-um
+ geo_fac =  0.7071 / sqrt(l*w*simM*1e12)
+ mm_delvt = varvt * geo_fac * pvt_mc
+ mm_mu0 = 1-(.005 * geo_fac * pu0_mc )
+ mm_dl= 2e-03  * geo_fac * l * pltw_mc
+ mm_dw = - 24e-03 * geo_fac * w *  pltw_mc
+ mm_dtox = 2e-03 * geo_fac * lp_tox_ne *  pltw_mc

gpdk090_nmos1v_hvt (D G S B) gpdk090_nmos1v_hvt_x  w=w l=l as=as ad=ad ps=ps pd=pd nrd=nrd nrs=nrs
+ aforward=maforward areverse=mareverse

model gpdk090_nmos1v_hvt_x bsim3v3 type = n
+ mvtwl = varvt*1u  mbewl = 0.025*1u
+                lmin =                   0.0                lmax =                  1.0                 wmin =                  0.0
+                wmax =                  1.0                 tnom =                 25.0              version =                  3.2
+                 tox =            lp_tox_ne + mm_dtox       toxm =            lp_tox_ne + mm_dtox         xj =             lp_xj_ne
+                 nch =            lp_nch_ne                  lln =            1.0000000                  lwn =            1.0000000
+                 wln =            1.0000000                  wwn =           -1.0000000                 lint =           lp_lint_ne
+                  ll =                 0.00                   lw =                 0.00                  lwl =                 0.00
+                wint =           lp_wint_ne                   wl =                 0.00                   ww =                 0.00
+                 wwl =                 0.00               mobmod =                    1              binunit =                    2
+                  xl =                mm_dl                   xw =                mm_dw                  dwg =                 0.00
+                 dwb =                 0.00                  acm =                   12                 ldif =           lp_ldif_ne
+                hdif =           lp_hdif_ne                  rsh =            lp_rsh_ne                   rd =             lp_rd_ne
+                  rs =             lp_rs_ne                  rsc =            lp_rsc_ne                  rdc =            lp_rdc_ne
+                vth0 =           lp_vth0_ne + mm_delvt        k1 =             lp_k1_ne                   k2 =             lp_k2_ne
+                  k3 =           -2.3000000                 dvt0 =              3.86366                 dvt1 =                  1.2
+                dvt2 =        5.0299990E-02                dvt0w =                 0.00                dvt1w =                 0.00
+               dvt2w =                 0.00                  nlx =        1.2517999E-07                   w0 =       -7.1353000E-09
+                 k3b =            0.5576769                ngate =               4.0E20                 vsat =           lp_vsat_ne
+                  ua =       -6.1879500E-10                   ub =        1.8806652E-18                   uc =        1.3823546E-10
+                rdsw =           lp_rdsw_ne                 prwb =                 0.00                 prwg =                 0.00
+                  wr =            1.0000000                   u0 =             lp_u0_ne*mm_mu0            a0 =            2.3750000
+                keta =       -3.1429991E-02                   a1 =                 0.00                   a2 =            0.9900000
+                 ags =            0.8900000                   b0 =                 0.00                   b1 =                 0.00
+                voff =       -9.6776000E-02              nfactor =            1.0200000                  cit =       -8.6656060E-04
+                cdsc =        4.4460000E-02                cdscb =        1.0565110E-02                cdscd =                 0.00
+                eta0 =        7.6580000E-02                 etab =       -3.4998000E-02                 dsub =            0.2200000
+                pclm =            1.5488822              pdiblc1 =                 0.00              pdiblc2 =        2.4648249E-02
+             pdiblcb =                 0.00                drout =                 0.00               pscbe1 =         9.2648200E08
+              pscbe2 =        1.0000000E-20                 pvag =                 0.00                delta =        7.5000000E-03
+              alpha0 =                 0.00               alpha1 =               0.0177                beta0 =               6.3203
+                 kt1 =                -0.13                  kt2 =               -0.042                   at =         9.0000000E04
+                 ute =           -1.7303560                  ua1 =        1.8035814E-09                  ub1 =       -2.1874742E-18
+                 uc1 =            lp_uc1_ne                 kt1l =                 0.00                  prt =            lp_prt_ne
+                  cj =             lp_cj_ne                   mj =                0.222                   pb =             lp_pb_ne
+                cjsw =           lp_cjsw_ne                 mjsw =                 0.01                 pbsw =                  0.1
+               cjswg =          lp_cjswg_ne                mjswg =               0.5028                pbswg =               0.6859
+                 tpb =             1.30E-03                tpbsw =               0.0000               tpbswg =             2.81E-03
+                 tcj =             7.61E-04                tcjsw =             1.04E-03               tcjswg =             1.63E-03
+                  js =             lp_js_ne                  jsw =            lp_jsw_ne                    n =                    1
+                 xti =                    3                 cgdo =           lp_cgdo_ne                 cgso =           lp_cgdo_ne
+                cgbo =           lp_cgbo_ne               capmod =                    2               nqsmod =                    0
+                 elm =                    5                xpart =                    1                 cgsl =           lp_cgsl_ne
+                cgdl =           lp_cgsl_ne               ckappa =         lp_ckappa_ne                   cf =             lp_cf_ne
+                 clc =        1.0000000E-07                  cle =            0.6000000                  dlc =             1.89E-08
+                 dwc =             1.62E-08                  llc =             1.53E-16                  lwc =             -9.0E-16
+                 wlc =                    0                  wwc =              -0.0989                 lwlc =                    0
+                wwlc =                    0                 acde =                  0.5                 moin =                 10.5
+                noff =                 1.85               voffcv =               -0.048              lvoffcv =              2.0E-09
+             calcacm =                    1             sfvtflag =                    0                 tlev =                    1
+               tlevc =                    1                 ijth =                 1
+                noia =              5.0e+19                 noib =               8.0e+4                 noic =              4.0e-13
+                  ef =                1.146               noimod =                    2                   em =                 4e+7
+            bforward =                  4.0             breverse =                  4.0               cforward =                1.5
+            creverse =                  1.5                  tcc =                 2e-3
ends gpdk090_nmos1v_hvt

*inline subckt gpdk090_pmoscap1v_hvt (D G S B)
*parameters l=0.1u w=10u simM=1 nrd=s1v_hdif_ne/w nrs=s1v_hdif_ne/w  as=1p ad=1p ps=1u pd=1u
*gpdk090_pmoscap1v_hvt (p11 p2 p33 p4) gpdk090_pmos1v_hvt  w=w l=l nrd=nrd nrs=nrs
*ends gpdk090_pmoscap1v_hvt

inline subckt gpdk090_pmos1v_hvt (D G S B)
parameters l=0.1u w=10u simM=1 nrd=lp_hdif_pe/w nrs=lp_hdif_pe/w  as=1p ad=1p ps=1u pd=1u
+ garea=w*l  maforward=1.5e3*garea*lp_gleak_scale   mareverse=.03*maforward
//mismatch
+ varvt =  .003   // 1 sigma Vt mismatch variation in unit of v-um
+ geo_fac =  0.7071 / sqrt(l*w*simM*1e12)
+ mm_delvt = varvt * geo_fac * pvt_mc
+ mm_mu0 = 1-(.005 * geo_fac * pu0_mc )
+ mm_dl= 2e-03  * geo_fac * l * pltw_mc
+ mm_dw = - 24e-03 * geo_fac * w *  pltw_mc
+ mm_dtox = 2e-03 * geo_fac * lp_tox_pe *  pltw_mc

gpdk090_pmos1v_hvt (D G S B) gpdk090_pmos1v_hvt_x  w=w l=l as=as ad=ad ps=ps pd=pd nrd=nrd nrs=nrs
+ aforward=maforward areverse=mareverse

model gpdk090_pmos1v_hvt_x bsim3v3 type = p
+ mvtwl = varvt*1u  mbewl = 0.025*1u
+                lmin =                  0.0                 lmax =                  1.0                 wmin =                  0.0
+                wmax =                  1.0                 tnom =                 25.0              version =                  3.2
+                 tox =            lp_tox_pe + mm_dtox       toxm =            lp_tox_pe + mm_dtox         xj =             lp_xj_pe
+                 nch =         1.7200001E17                  lln =            1.0000000                  lwn =            1.0000000
+                 wln =            1.0000000                  wwn =           -1.0000000                 lint =           lp_lint_pe
+                  ll =                 0.00                   lw =                 0.00                  lwl =                 0.00
+                wint =           lp_wint_pe                   wl =                 0.00                   ww =                 0.00
+                 wwl =                 0.00               mobmod =                    1              binunit =                    2
+                  xl =                mm_dl                   xw =                mm_dw                  dwg =                 0.00
+                 dwb =                 0.00                  acm =                   12                 ldif =           lp_ldif_pe
+                hdif =           lp_hdif_pe                  rsh =            lp_rsh_pe                   rd =             lp_rd_pe
+                  rs =             lp_rs_pe                  rsc =            lp_rsc_pe                  rdc =            lp_rdc_pe
+                vth0 =           lp_vth0_pe + mm_delvt     pvth0 =                    0                   k1 =             lp_k1_pe
+                  k2 =             lp_k2_pe                   k3 =           -0.5000000                 dvt0 =                  8.0
+                dvt1 =                 2.07                 dvt2 =            0.1000000                dvt0w =                 0.00
+               dvt1w =                 0.00                dvt2w =                 0.00                  nlx =        2.2400000E-07
+                  w0 =                 0.00                  k3b =        7.0000000E-02                ngate =         9.3200000E19
+                vsat =           lp_vsat_pe                   ua =       -2.7643932E-10                   ub =        2.2546092E-18
+                  uc =        1.6265005E-10                 rdsw =           lp_rdsw_pe                 prwb =                 0.00
+                prwg =                 0.00                   wr =            1.0000000                   u0 =             lp_u0_pe*mm_mu0
+                  a0 =            2.9669099                 keta =       -8.2015020E-02                   a1 =                 0.00
+                  a2 =            1.0000000                  ags =            1.2279299                   b0 =                 0.00
+                  b1 =                 0.00                 voff =           -0.1170768              nfactor =            1.0000000
+                 cit =       -2.5695576E-03                 cdsc =                 0.00                cdscb =                 0.00
+               cdscd =                 0.00                 eta0 =        5.0000000E-02                leta0 =                    0
+                etab =                    0                 dsub =            0.3000000                 pclm =            1.0000000
+             pdiblc1 =        6.0000000E-03              pdiblc2 =        5.0000000E-03              pdiblcb =           -0.5267781
+               drout =                 0.00               pscbe1 =         5.1300000E08               pscbe2 =        4.8900000E-07
+                pvag =                 0.00                delta =        9.9999990E-03               alpha0 =                 0.00
+              alpha1 =                0.001                beta0 =                  7.6                  kt1 =                -0.11
+                 kt2 =        4.4329650E-02                   at =         1.0000000E04                  ute =           -1.4468272
+                 ua1 =        1.2158887E-09                  ub1 =       -4.0489830E-18                  uc1 =       -5.6549980E-10
+                kt1l =                 0.00                  prt =                    0                   cj =             lp_cj_pe
+                  mj =                0.331                   pb =             lp_pb_pe                 cjsw =           lp_cjsw_pe
+                mjsw =                 0.01                 pbsw =                 0.10                cjswg =          lp_cjswg_pe
+               mjswg =               0.7833                pbswg =               0.8137                  tpb =              0.00173
+               tpbsw =                  0.0               tpbswg =               0.0044                  tcj =             0.000949
+               tcjsw =            0.0000758               tcjswg =              0.00388                   js =             lp_js_pe
+                 jsw =            lp_jsw_pe                    n =                    1                  xti =                    3
+                cgdo =           lp_cgdo_pe                 cgso =           lp_cgdo_pe                 cgbo =           lp_cgbo_pe
+              capmod =                    2               nqsmod =                    0                  elm =                    5
+               xpart =                    1                 cgsl =           lp_cgsl_pe                 cgdl =           lp_cgsl_pe
+              ckappa =         lp_ckappa_pe                   cf =             lp_cf_pe                  clc =        1.0000000E-07
+                 cle =            0.6000000                  dlc =            2.252E-08                  dwc =           1.2404E-08
+                 llc =             -1.2E-16                  lwc =             -6.2E-16                  wlc =                    0
+                 wwc =                -0.15                 lwlc =                    0                 wwlc =                    0
+                acde =                  0.5                 moin =                 15.6                 noff =                 2.16
+              voffcv =              -0.0385              lvoffcv =            -3.80E-09                lnoff =             7.50E-08
+             calcacm =                    1             sfvtflag =                    0                 tlev =                    1
+               tlevc =                    1                 ijth =                 1
+                noia =              3.0e+19                 noib =               4.0e+3                 noic =              1.0e-11
+                  ef =                 1.06               noimod =                    2                   em =                 4e+7
+            bforward =                  3.8             breverse =                  3.8               cforward =                1.0
+            creverse =                  1.0                  tcc =                 2e-3
ends gpdk090_pmos1v_hvt

endsection lp_mos

section hv_mos

*inline subckt gpdk090_nmoscap2v (D G S B)
*parameters l=0.1u w=10u simM=1 nrd=s1v_hdif_ne/w nrs=s1v_hdif_ne/w  as=1p ad=1p ps=1u pd=1u
*gpdk090_nmoscap2v (D G S B) gpdk090_nmos2v  w=w l=l nrd=nrd nrs=nrs
*ends gpdk090_nmoscap2v

inline subckt gpdk090_nmos2v (D G S B)
parameters l=0.1u w=10u simM=1 nrd=s1v_hdif_ne/w nrs=s1v_hdif_ne/w  as=1p ad=1p ps=1u pd=1u
//mismatch
+ varvt =  .004   // 1 sigma Vt mismatch variation in unit of v-um
+ geo_fac =  0.7071 / sqrt(l*w*simM*1e12)
+ mm_delvt = varvt * geo_fac * pvt_mc
+ mm_mu0 = 1-(.005 * geo_fac * pu0_mc )
+ mm_dl= 2e-03  * geo_fac * l * pltw_mc
+ mm_dw = - 24e-03 * geo_fac * w *  pltw_mc
+ mm_dtox = 2e-03 * geo_fac * s1v_tox_ne *  pltw_mc

gpdk090_nmos2v (D G S B)  gpdk090_nmos2v_x  w=w l=l as=as ad=ad ps=ps pd=pd nrd=nrd nrs=nrs

model gpdk090_nmos2v_x bsim3v3 type = n
+ mvtwl = varvt*1u  mbewl = 0.025*1u
+                lmin =                   0.0                lmax =                  1.0                 wmin =                  0.0
+                wmax =                  1.0                 tnom =                 25.0              version =                  3.2
+                 tox =            hv_tox_ne + mm_dtox       toxm =            hv_tox_ne + mm_dtox         xj =             hv_xj_ne
+                 nch =            hv_nch_ne                  lln =            1.0000000                  lwn =            1.0000000
+                 wln =            1.0000000                  wwn =           -1.0000000                 lint =           hv_lint_ne
+                  ll =                 0.00                   lw =                 0.00                  lwl =                 0.00
+                wint =           hv_wint_ne                   wl =                 0.00                   ww =                 0.00
+                 wwl =                 0.00               mobmod =                    1              binunit =                    2
+                  xl =                mm_dl                   xw =                mm_dw                  dwg =                 0.00
+                 dwb =                 0.00                  acm =                   12                 ldif =           hv_ldif_ne
+                hdif =           hv_hdif_ne                  rsh =            hv_rsh_ne                   rd =             hv_rd_ne
+                  rs =             hv_rs_ne                  rsc =            hv_rsc_ne                  rdc =            hv_rdc_ne
+                vth0 =           hv_vth0_ne + mm_delvt        k1 =             hv_k1_ne                   k2 =             hv_k2_ne
+                  k3 =           -2.3000000                 dvt0 =              3.86366                 dvt1 =                  1.2
+                dvt2 =        5.0299990E-02                dvt0w =                 0.00                dvt1w =                 0.00
+               dvt2w =                 0.00                  nlx =        1.2517999E-07                   w0 =       -7.1353000E-09
+                 k3b =            0.5576769                ngate =               4.0E20                 vsat =           hv_vsat_ne
+                  ua =       -6.1879500E-10                   ub =        1.8806652E-18                   uc =        1.3823546E-10
+                rdsw =           hv_rdsw_ne                 prwb =                 0.00                 prwg =                 0.00
+                  wr =            1.0000000                   u0 =             hv_u0_ne*mm_mu0            a0 =            2.3750000
+                keta =       -3.1429991E-02                   a1 =                 0.00                   a2 =            0.9900000
+                 ags =            0.8900000                   b0 =                 0.00                   b1 =                 0.00
+                voff =       -9.6776000E-02              nfactor =            1.0200000                  cit =       -8.6656060E-04
+                cdsc =        4.4460000E-02                cdscb =        1.0565110E-02                cdscd =                 0.00
+                eta0 =        7.6580000E-02                 etab =       -3.4998000E-02                 dsub =            0.2200000
+                pclm =            1.5488822              pdiblc1 =                 0.00              pdiblc2 =        2.4648249E-02
+             pdiblcb =                 0.00                drout =                 0.00               pscbe1 =         9.2648200E08
+              pscbe2 =        1.0000000E-20                 pvag =                 0.00                delta =        7.5000000E-03
+              alpha0 =                 0.00               alpha1 =               0.0177                beta0 =               6.3203
+                 kt1 =                -0.13                  kt2 =               -0.042                   at =         9.0000000E04
+                 ute =           -1.7303560                  ua1 =        1.8035814E-09                  ub1 =       -2.1874742E-18
+                 uc1 =            hv_uc1_ne                 kt1l =                 0.00                  prt =            hv_prt_ne
+                  cj =             hv_cj_ne                   mj =                0.222                   pb =             hv_pb_ne
+                cjsw =           hv_cjsw_ne                 mjsw =                 0.01                 pbsw =                  0.1
+               cjswg =          hv_cjswg_ne                mjswg =               0.5028                pbswg =               0.6859
+                 tpb =             1.30E-03                tpbsw =               0.0000               tpbswg =             2.81E-03
+                 tcj =             7.61E-04                tcjsw =             1.04E-03               tcjswg =             1.63E-03
+                  js =             hv_js_ne                  jsw =            hv_jsw_ne                    n =                    1
+                 xti =                    3                 cgdo =           hv_cgdo_ne                 cgso =           hv_cgdo_ne
+                cgbo =           hv_cgbo_ne               capmod =                    2               nqsmod =                    0
+                 elm =                    5                xpart =                    1                 cgsl =           hv_cgsl_ne
+                cgdl =           hv_cgsl_ne               ckappa =         hv_ckappa_ne                   cf =             hv_cf_ne
+                 clc =        1.0000000E-07                  cle =            0.6000000                  dlc =             1.89E-08
+                 dwc =             1.62E-08                  llc =             1.53E-16                  lwc =             -9.0E-16
+                 wlc =                    0                  wwc =              -0.0989                 lwlc =                    0
+                wwlc =                    0                 acde =                  0.5                 moin =                 10.5
+                noff =                 1.85               voffcv =               -0.048              lvoffcv =              2.0E-09
+             calcacm =                    1             sfvtflag =                    0                 tlev =                    1
+               tlevc =                    1                 ijth =                 1
+                noia =               1.3e20                 noib =                 7e+4                 noic =              5.0e-13
+                  ef =                 0.95               noimod =                    2                   em =                 2e+7
ends gpdk090_nmos2v

*inline subckt gpdk090_pmoscap2v (D G S B)
*parameters l=0.1u w=10u simM=1 nrd=s1v_hdif_ne/w nrs=s1v_hdif_ne/w  as=1p ad=1p ps=1u pd=1u
*gpdk090_pmoscap2v (p11 p2 p33 p4) gpdk090_pmos2v  w=w l=l nrd=nrd nrs=nrs
*ends gpdk090_pmoscap2v

inline subckt gpdk090_pmos2v (D G S B)
parameters l=0.1u w=10u simM=1 nrd=s1v_hdif_ne/w nrs=s1v_hdif_ne/w  as=1p ad=1p ps=1u pd=1u
//mismatch
+ varvt =  .004   // 1 sigma Vt mismatch variation in unit of v-um
+ geo_fac =  0.7071 / sqrt(l*w*simM*1e12)
+ mm_delvt = varvt * geo_fac * pvt_mc
+ mm_mu0 = 1-(.005 * geo_fac * pu0_mc )
+ mm_dl= 2e-03  * geo_fac * l * pltw_mc
+ mm_dw = - 24e-03 * geo_fac * w *  pltw_mc
+ mm_dtox = 2e-03 * geo_fac * s1v_tox_ne *  pltw_mc

gpdk090_pmos2v (D G S B)  gpdk090_pmos2v_x  w=w l=l as=as ad=ad ps=ps pd=pd nrd=nrd nrs=nrs

model gpdk090_pmos2v_x  bsim3v3 type = p
+ mvtwl = varvt*1u  mbewl = 0.025*1u
+                lmin =                  0.0                 lmax =                  1.0                 wmin =                  0.0
+                wmax =                  1.0                 tnom =                 25.0              version =                  3.2
+                 tox =            hv_tox_pe + mm_dtox       toxm =            hv_tox_pe + mm_dtox         xj =             hv_xj_pe
+                 nch =         1.7200001E17                  lln =            1.0000000                  lwn =            1.0000000
+                 wln =            1.0000000                  wwn =           -1.0000000                 lint =           hv_lint_pe
+                  ll =                 0.00                   lw =                 0.00                  lwl =                 0.00
+                wint =           hv_wint_pe                   wl =                 0.00                   ww =                 0.00
+                 wwl =                 0.00               mobmod =                    1              binunit =                    2
+                  xl =                mm_dl                   xw =                mm_dw                  dwg =                 0.00
+                 dwb =                 0.00                  acm =                   12                 ldif =           hv_ldif_pe
+                hdif =           hv_hdif_pe                  rsh =            hv_rsh_pe                   rd =             hv_rd_pe
+                  rs =             hv_rs_pe                  rsc =            hv_rsc_pe                  rdc =            hv_rdc_pe
+                vth0 =           hv_vth0_pe + mm_delvt     pvth0 =                    0                   k1 =             hv_k1_pe
+                  k2 =             hv_k2_pe                   k3 =           -0.5000000                 dvt0 =                  8.0
+                dvt1 =                 2.07                 dvt2 =            0.1000000                dvt0w =                 0.00
+               dvt1w =                 0.00                dvt2w =                 0.00                  nlx =        2.2400000E-07
+                  w0 =                 0.00                  k3b =        7.0000000E-02                ngate =         9.3200000E19
+                vsat =           hv_vsat_pe                   ua =       -2.7643932E-10                   ub =        2.2546092E-18
+                  uc =        1.6265005E-10                 rdsw =           hv_rdsw_pe                 prwb =                 0.00
+                prwg =                 0.00                   wr =            1.0000000                   u0 =             hv_u0_pe*mm_mu0
+                  a0 =            2.9669099                 keta =       -8.2015020E-02                   a1 =                 0.00
+                  a2 =            1.0000000                  ags =            1.2279299                   b0 =                 0.00
+                  b1 =                 0.00                 voff =           -0.1170768              nfactor =            1.0000000
+                 cit =       -2.5695576E-03                 cdsc =                 0.00                cdscb =                 0.00
+               cdscd =                 0.00                 eta0 =        5.0000000E-02                leta0 =                    0
+                etab =                    0                 dsub =            0.3000000                 pclm =            1.0000000
+             pdiblc1 =        6.0000000E-03              pdiblc2 =        5.0000000E-03              pdiblcb =           -0.5267781
+               drout =                 0.00               pscbe1 =         5.1300000E08               pscbe2 =        4.8900000E-07
+                pvag =                 0.00                delta =        9.9999990E-03               alpha0 =                 0.00
+              alpha1 =                0.001                beta0 =                  7.6                  kt1 =                -0.11
+                 kt2 =        4.4329650E-02                   at =         1.0000000E04                  ute =           -1.4468272
+                 ua1 =        1.2158887E-09                  ub1 =       -4.0489830E-18                  uc1 =       -5.6549980E-10
+                kt1l =                 0.00                  prt =                    0                   cj =             hv_cj_pe
+                  mj =                0.331                   pb =             hv_pb_pe                 cjsw =           hv_cjsw_pe
+                mjsw =                 0.01                 pbsw =                 0.10                cjswg =          hv_cjswg_pe
+               mjswg =               0.7833                pbswg =               0.8137                  tpb =              0.00173
+               tpbsw =                  0.0               tpbswg =               0.0044                  tcj =             0.000949
+               tcjsw =            0.0000758               tcjswg =              0.00388                   js =             hv_js_pe
+                 jsw =            hv_jsw_pe                    n =                    1                  xti =                    3
+                cgdo =           hv_cgdo_pe                 cgso =           hv_cgdo_pe                 cgbo =           hv_cgbo_pe
+              capmod =                    2               nqsmod =                    0                  elm =                    5
+               xpart =                    1                 cgsl =           hv_cgsl_pe                 cgdl =           hv_cgsl_pe
+              ckappa =         hv_ckappa_pe                   cf =             hv_cf_pe                  clc =        1.0000000E-07
+                 cle =            0.6000000                  dlc =            2.252E-08                  dwc =           1.2404E-08
+                 llc =             -1.2E-16                  lwc =             -6.2E-16                  wlc =                    0
+                 wwc =                -0.15                 lwlc =                    0                 wwlc =                    0
+                acde =                  0.5                 moin =                 15.6                 noff =                 2.16
+              voffcv =              -0.0385              lvoffcv =            -3.80E-09                lnoff =             7.50E-08
+             calcacm =                    1             sfvtflag =                    0                 tlev =                    1
+               tlevc =                    1                 ijth =                 1
+                noia =              5.0e+19                 noib =               4.0e+3                 noic =                1e-11
+                  ef =                 1.16               noimod =                    2                   em =                 3e+7
ends gpdk090_pmos2v

inline subckt gpdk090_nmos2v_nat (D G S B)
parameters l=0.1u w=10u simM=1 nrd=s1v_hdif_ne/w nrs=s1v_hdif_ne/w  as=1p ad=1p ps=1u pd=1u
//mismatch
+ varvt =  .004   // 1 sigma Vt mismatch variation in unit of v-um
+ geo_fac =  0.7071 / sqrt(l*w*simM*1e12)
+ mm_delvt = varvt * geo_fac * pvt_mc
+ mm_mu0 = 1-(.005 * geo_fac * pu0_mc )
+ mm_dl= 2e-03  * geo_fac * l * pltw_mc
+ mm_dw = - 24e-03 * geo_fac * w *  pltw_mc
+ mm_dtox = 2e-03 * geo_fac * s1v_tox_ne *  pltw_mc

gpdk090_nmos2v_nat (D G S B)  gpdk090_nmos2v_nat_x  w=w l=l as=as ad=ad ps=ps pd=pd nrd=nrd nrs=nrs

model gpdk090_nmos2v_nat_x bsim3v3 type = n
+ mvtwl = varvt*1u  mbewl = 0.025*1u
+                lmin =                   0.0                lmax =                  1.0                 wmin =                  0.0
+                wmax =                  1.0                 tnom =                 25.0              version =                  3.2
+                 tox =            hv_tox_ne + mm_dtox       toxm =            hv_tox_ne + mm_dtox         xj =             hv_xj_ne
+                 nch =            hv_nch_ne                  lln =            1.0000000                  lwn =            1.0000000
+                 wln =            1.0000000                  wwn =           -1.0000000                 lint =           hv_lint_ne
+                  ll =                 0.00                   lw =                 0.00                  lwl =                 0.00
+                wint =           hv_wint_ne                   wl =                 0.00                   ww =                 0.00
+                 wwl =                 0.00               mobmod =                    1              binunit =                    2
+                  xl =                mm_dl                   xw =                mm_dw                  dwg =                 0.00
+                 dwb =                 0.00                  acm =                   12                 ldif =           hv_ldif_ne
+                hdif =           hv_hdif_ne                  rsh =            hv_rsh_ne                   rd =             hv_rd_ne
+                  rs =             hv_rs_ne                  rsc =            hv_rsc_ne                  rdc =            hv_rdc_ne
+                vth0 =       hv_nat_vth0_ne + mm_delvt        k1 =         hv_nat_k1_ne                   k2 =             hv_k2_ne
+                  k3 =           -2.3000000                 dvt0 =              3.86366                 dvt1 =                  1.2
+                dvt2 =        5.0299990E-02                dvt0w =                 0.00                dvt1w =                 0.00
+               dvt2w =                 0.00                  nlx =        1.2517999E-07                   w0 =       -7.1353000E-09
+                 k3b =            0.5576769                ngate =               4.0E20                 vsat =           hv_vsat_ne
+                  ua =       -6.1879500E-10                   ub =        1.8806652E-18                   uc =        1.3823546E-10
+                rdsw =           hv_rdsw_ne                 prwb =                 0.00                 prwg =                 0.00
+                  wr =            1.0000000                   u0 =             hv_u0_ne*mm_mu0            a0 =            2.3750000
+                keta =       -3.1429991E-02                   a1 =                 0.00                   a2 =            0.9900000
+                 ags =            0.8900000                   b0 =                 0.00                   b1 =                 0.00
+                voff =       -9.6776000E-02              nfactor =            1.0200000                  cit =       -8.6656060E-04
+                cdsc =        4.4460000E-02                cdscb =        1.0565110E-02                cdscd =                 0.00
+                eta0 =        7.6580000E-02                 etab =       -3.4998000E-02                 dsub =            0.2200000
+                pclm =            1.5488822              pdiblc1 =                 0.00              pdiblc2 =        2.4648249E-02
+             pdiblcb =                 0.00                drout =                 0.00               pscbe1 =         9.2648200E08
+              pscbe2 =        1.0000000E-20                 pvag =                 0.00                delta =        7.5000000E-03
+              alpha0 =                 0.00               alpha1 =               0.0177                beta0 =               6.3203
+                 kt1 =                -0.13                  kt2 =               -0.042                   at =         9.0000000E04
+                 ute =           -1.7303560                  ua1 =        1.8035814E-09                  ub1 =       -2.1874742E-18
+                 uc1 =            hv_uc1_ne                 kt1l =                 0.00                  prt =            hv_prt_ne
+                  cj =             hv_cj_ne                   mj =                0.222                   pb =             hv_pb_ne
+                cjsw =           hv_cjsw_ne                 mjsw =                 0.01                 pbsw =                  0.1
+               cjswg =          hv_cjswg_ne                mjswg =               0.5028                pbswg =               0.6859
+                 tpb =             1.30E-03                tpbsw =               0.0000               tpbswg =             2.81E-03
+                 tcj =             7.61E-04                tcjsw =             1.04E-03               tcjswg =             1.63E-03
+                  js =             hv_js_ne                  jsw =            hv_jsw_ne                    n =                    1
+                 xti =                    3                 cgdo =           hv_cgdo_ne                 cgso =           hv_cgdo_ne
+                cgbo =           hv_cgbo_ne               capmod =                    2               nqsmod =                    0
+                 elm =                    5                xpart =                    1                 cgsl =           hv_cgsl_ne
+                cgdl =           hv_cgsl_ne               ckappa =         hv_ckappa_ne                   cf =             hv_cf_ne
+                 clc =        1.0000000E-07                  cle =            0.6000000                  dlc =             1.89E-08
+                 dwc =             1.62E-08                  llc =             1.53E-16                  lwc =             -9.0E-16
+                 wlc =                    0                  wwc =              -0.0989                 lwlc =                    0
+                wwlc =                    0                 acde =                  0.5                 moin =                 10.5
+                noff =                 1.85               voffcv =               -0.048              lvoffcv =              2.0E-09
+             calcacm =                    1             sfvtflag =                    0                 tlev =                    1
+               tlevc =                    1                 ijth =                 1
+                noia =               1.3e20                 noib =                 7e+4                 noic =              5.0e-13
+                  ef =                 0.95               noimod =                    2                   em =                 2e+7
ends gpdk090_nmos2v_nat

endsection hv_mos

endlibrary
