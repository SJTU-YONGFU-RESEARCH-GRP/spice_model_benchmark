**************************************************************
*   Generic PDK Capacitor model                       02/02/06
*                                              PDK Tech Center
**************************************************************

simulator lang=spectre
library gpdk

section cap
  parameters cjmim=1e-3 cjmim_std=0.1e-3
  parameters cjswmim=1e-10 cjswmim_std=0.1e-10
  parameters mcjmim_std=0.01e-3
  parameters mcjswmim_std=0.01e-10

  statistics {
        process{
             vary cjmim  dist=gauss std=cjmim_std
             vary cjswmim dist=gauss std=cjswmim_std
           }
        mismatch {
             vary cjmim  dist=gauss std=mcjmim_std
             vary cjswmim dist=gauss std=mcjswmim_std
           }
  }

inline subckt mimcap(PLUS MINUS)
    parameters area=1 perim=1
    model mimcapmod capacitor cj=cjmim cjsw=cjswmim tc2=3e-10 tc1=9e-4
    mimcap (PLUS MINUS) mimcapmod area=area perim=perim
ends mimcap

endsection cap

endlibrary gpdk
