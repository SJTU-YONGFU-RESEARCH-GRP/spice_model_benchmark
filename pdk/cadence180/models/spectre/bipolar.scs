**************************************************************
*   Generic PDK Bipolar models                        05/17/01
*                                                  PDK Factory
**************************************************************

simulator lang=spectre
library gpdk

section bjt

model vpnp bjt type=pnp rbmod=spice minr=1e-60 bf=3.0 nf=1.0
+                      is=2.4e-18 ise=2.4e-18

model npn bjt type=npn is=3.26E-16 va=60 bf=100
+                      br=6 nc=2 ikr=100m rc=1 vje=0.7
+                      cjc=1e-12 fc=0.5 cje=0.7e-12
+                      tr=200e-12 tf=25e-12 itf=0.03 vtf=7 xtf=2

model pnp bjt type=pnp is=3.28e-16 va=30 bf=35
+                      br=6 nc=2 ikr=100m rc=1
+                      cjc=1e-12 fc=0.5 cje=0.7e-12
+                      tr=200e-12 tf=65e-12 itf=0.03 vtf=7 xtf=2

endsection bjt

endlibrary gpdk
