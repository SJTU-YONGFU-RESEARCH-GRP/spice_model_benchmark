// ****************************************************************************
// 		  Advance Node PDK / Generic Resistor models
//
//  Copyright (c) 2014
//  Cadence Design Systems, Inc.  All rights reserved.
//
// These models represent a pseudo-process and are intended to be use
// for demonstration purpose only.
// *****************************************************************************

simulator lang=spectre
library cds_ff_mpt
//  **********************************************************************
//  **********************************************************************
//        Model name      structure
//        -----------------------------------------
//        rnws	   N-well Resistor under STI
//        rnwo	   N-well Resistor under Oxide
//        rsnd	   N+ Diffused Resistor (salicide)
//        rspd	   P+ Diffused Resistor (salicide)
//        rsnp	   N+ Poly Resistor (salicide)
//        rspp	   P+ Poly Resistor (salicide)
//        rnsnd	   N+ Diffused Resistor (w/o salicide)
//        rnspd	   P+ Diffused Resistor (w/o salicide)
//        rnsnp	   N+ Poly Resistor (w/o salicide)
//        rnspp	   P+ Poly Resistor (w/o salicide)
//        resm1         Metal 1 Resistor
//        resm2         Metal 2 Resistor
//        resm3         Metal 3 Resistor
//        resm4         Metal 4 Resistor
//        resm5         Metal 5 Resistor
//        resm6         Metal 6 Resistor
//        resm7         Metal 7 Resistor
//        resm8         Metal 8 Resistor
//        resm9         Metal 9 Resistor
//        resm10        Metal10 Resistor
//        resm11	   Metal11 Resistor
//        rnws_m        NW diff(under STI)
//        rnwo_m        NW diff(under OD)
//        rsnd_m        N+diff w/i silicide
//        rspd_m        P+diff w/i silicide
//        rsnp_dis      N+Poly w/i silicide
//        rspp_dis      P+Poly w/i silicide
//        rnsnd_m       N+diff w/o silicide
//        rnspd_m       P+diff w/o silicide
//        rnsnp_dis     N+Poly w/o silicide
//        rnspp_dis     P+Poly w/o silicide
//        ---------------------------------------

section tt_res
parameters     r_rnws         =  1e3
parameters     r_rnwo	  =  450
parameters     r_rsnd	  =  18
parameters     r_dxw_rsnd    =  0
parameters     r_rspd	  =  15
parameters     r_dxw_rspd    =  0
parameters     r_rsnp	  =  15
parameters     r_dxw_rsnp    =  0
parameters     r_rspp	  =  15
parameters     r_dxw_rspp    =  0
parameters     r_rnsnd	  =  100
parameters     r_rend_rnsnd  =  8.46e-6
parameters     r_dxl_rnsnd   =  0
parameters     r_dxw_rnsnd   =  0
parameters     r_rnspd	  =  200
parameters     r_rend_rnspd  =  2.95e-5
parameters     r_dxl_rnspd   =  0
parameters     r_dxw_rnspd   =  0
parameters     r_rnsnp	  =  200
parameters     r_rend_rnsnp  =  1.44e-5
parameters     r_dxl_rnsnp   =  0
parameters     r_dxw_rnsnp   =  0
parameters     r_rnspp	  =  600
parameters     r_rend_rnspp  =  7.015e-6
parameters     r_dxl_rnspp   =  0
parameters     r_dxw_rnspp   =  0
parameters     r_resm1            =  0.0736
parameters     r_resm2            =  0.0604
parameters     r_resm3            =  0.0604
parameters     r_resm4            =  0.0604
parameters     r_resm5            =  0.0604
parameters     r_resm6            =  0.0604
parameters     r_resm7            =  0.0604
parameters     r_resm8            =  0.0214
parameters     r_resm9            =  0.0214
parameters     r_resm10           =  0.0214
parameters     r_resm11	          =  0.021
parameters    fac_mm_r_resm1             =  0
parameters    fac_mm_r_resm2             =  0
parameters    fac_mm_r_resm3             =  0
parameters    fac_mm_r_resm4             =  0
parameters    fac_mm_r_resm5             =  0
parameters    fac_mm_r_resm6             =  0
parameters    fac_mm_r_resm7             =  0
parameters    fac_mm_r_resm8             =  0
parameters    fac_mm_r_resm9             =  0
parameters    fac_mm_r_resm10            =  0
parameters    fac_mm_r_resm11  	         =  0
parameters    fac_mm_r_rsnp    	         =  0
parameters    fac_mm_dxw_rsnp       =  0
parameters    fac_mm_r_rnsnp   	         =  0
parameters    fac_mm_dxw_rnsnp      =  0
parameters    fac_mm_rend_rnsnp     =  0
parameters    fac_mm_r_rspp    	         =  0
parameters    fac_mm_dxw_rspp       =  0
parameters    fac_mm_r_rnspp   	         =  0
parameters    fac_mm_dxw_rnspp      =  0
parameters    fac_mm_rend_rnspp     =  0
parameters    fac_mm_r_rnsnd   	         =  0
parameters    fac_mm_dxw_rnsnd      =  0
parameters    fac_mm_rend_rnsnd     =  0
parameters    fac_mm_r_rnspd   	         =  0
parameters    fac_mm_dxw_rnspd      =  0
parameters    fac_mm_rend_rnspd     =  0
parameters    fac_mm_r_rsnd   	         =  0
parameters    fac_mm_dxw_rsnd      =  0
parameters    fac_mm_r_rspd   	         =  0
parameters    fac_mm_dxw_rspd      =  0
parameters    fac_mm_r_rnwo   	         =  0
parameters    fac_mm_r_rnws   	         =  0
include "cds_ff_mpt_resistor.scs" section=res
endsection tt_res

section ss_res
parameters     r_rnws                =  1e3  * 1.20
parameters     r_rnwo	         =  450 * 1.20
parameters     r_rsnd	         =  18 * 1.20
parameters     r_dxw_rsnd           =  0 + 0.015u
parameters     r_rspd	         =  15* 1.20
parameters     r_dxw_rspd           =  0+ 0.015u
parameters     r_rsnp	         =  15* 1.20
parameters     r_dxw_rsnp           =  0    + 0.009u
parameters     r_rspp	         =  15* 1.20
parameters     r_dxw_rspp           =         0   + 0.012u
parameters     r_rnsnd	         =  100* 1.15
parameters     r_rend_rnsnd         =  8.46e-6 * 1.90
parameters     r_dxl_rnsnd          =  0+ 0.0u
parameters     r_dxw_rnsnd          =  0  + 0.040u
parameters     r_rnspd	         =  200  * 1.25
parameters     r_rend_rnspd         =  2.95e-5    * 1.60
parameters     r_dxl_rnspd          =  0   + 0.0u
parameters     r_dxw_rnspd          =  0  + 0.022u
parameters     r_rnsnp	         =  200* 1.15
parameters     r_rend_rnsnp         =  1.44e-5   * 1.90
parameters     r_dxl_rnsnp          =  0  + 0.0u
parameters     r_dxw_rnsnp          =  0  + 0.032u
parameters     r_rnspp	         =  600 * 1.15
parameters     r_rend_rnspp         =  7.015e-6     * 1.60
parameters     r_dxl_rnspp          =  0  + 0.0u
parameters     r_dxw_rnspp          =  0 + 0.035u
parameters     r_resm1                   =  0.0736  * 1.20
parameters     r_resm2                   =  0.0604  * 1.20
parameters     r_resm3                   =  0.0604  * 1.20
parameters     r_resm4                   =  0.0604  * 1.20
parameters     r_resm5                   =  0.0604  * 1.20
parameters     r_resm6                   =  0.0604  * 1.20
parameters     r_resm7                   =  0.0604  * 1.20
parameters     r_resm8                   =  0.0214  * 1.20
parameters     r_resm9                   =  0.0214  * 1.20
parameters     r_resm10                  =  0.0214  * 1.20
parameters     r_resm11	                 =  0.021   * 1.20
parameters    fac_mm_r_resm1             =  0
parameters    fac_mm_r_resm2             =  0
parameters    fac_mm_r_resm3             =  0
parameters    fac_mm_r_resm4             =  0
parameters    fac_mm_r_resm5             =  0
parameters    fac_mm_r_resm6             =  0
parameters    fac_mm_r_resm7             =  0
parameters    fac_mm_r_resm8             =  0
parameters    fac_mm_r_resm9             =  0
parameters    fac_mm_r_resm10            =  0
parameters    fac_mm_r_resm11  	         =  0
parameters    fac_mm_r_rsnp    	         =  0
parameters    fac_mm_dxw_rsnp       =  0
parameters    fac_mm_r_rnsnp   	         =  0
parameters    fac_mm_dxw_rnsnp      =  0
parameters    fac_mm_rend_rnsnp     =  0
parameters    fac_mm_r_rspp    	         =  0
parameters    fac_mm_dxw_rspp       =  0
parameters    fac_mm_r_rnspp   	         =  0
parameters    fac_mm_dxw_rnspp      =  0
parameters    fac_mm_rend_rnspp     =  0
parameters    fac_mm_r_rnsnd   	         =  0
parameters    fac_mm_dxw_rnsnd      =  0
parameters    fac_mm_rend_rnsnd     =  0
parameters    fac_mm_r_rnspd   	         =  0
parameters    fac_mm_dxw_rnspd      =  0
parameters    fac_mm_rend_rnspd     =  0
parameters    fac_mm_r_rsnd   	         =  0
parameters    fac_mm_dxw_rsnd      =  0
parameters    fac_mm_r_rspd   	         =  0
parameters    fac_mm_dxw_rspd      =  0
parameters    fac_mm_r_rnwo   	         =  0
parameters    fac_mm_r_rnws   	         =  0
include "cds_ff_mpt_resistor.scs" section=res
endsection ss_res

section ff_res
parameters     r_rnws         =  1e3  * 0.8
parameters     r_rnwo	  =  450 * 0.8
parameters     r_rsnd	  =  18 * 0.8
parameters     r_dxw_rsnd    =  0 - 0.015u
parameters     r_rspd	  =  15* 0.8
parameters     r_dxw_rspd    =  0 - 0.015u
parameters     r_rsnp	  =  15* 0.8
parameters     r_dxw_rsnp    =  0 - 0.009u
parameters     r_rspp	  =  15*0.8
parameters     r_dxw_rspp    =  0  - 0.012u
parameters     r_rnsnd	  =  100* 0.85
parameters     r_rend_rnsnd  =  8.46e-6 * 0.1
parameters     r_dxl_rnsnd   =  0
parameters     r_dxw_rnsnd   =  0  - 0.040u
parameters     r_rnspd	  =  200  * 0.75
parameters     r_rend_rnspd  =  2.95e-5    * 0.4
parameters     r_dxl_rnspd   =  0   + 0.0u
parameters     r_dxw_rnspd   =  0  - 0.022u
parameters     r_rnsnp	  =  200* 0.85
parameters     r_rend_rnsnp  =  1.44e-5   *0.1
parameters     r_dxl_rnsnp   =  0  + 0.0u
parameters     r_dxw_rnsnp   =  0  - 0.032u
parameters     r_rnspp	  =  600 *0.85
parameters     r_rend_rnspp  =  7.015e-6     * 0.4
parameters     r_dxl_rnspp   =  0  + 0.0u
parameters     r_dxw_rnspp   =  0 - 0.035u
parameters     r_resm1            =  0.0736  * 0.8
parameters     r_resm2            =  0.0604  * 0.8
parameters     r_resm3            =  0.0604  * 0.8
parameters     r_resm4            =  0.0604  * 0.8
parameters     r_resm5            =  0.0604  * 0.8
parameters     r_resm6            =  0.0604  * 0.8
parameters     r_resm7            =  0.0604  * 0.8
parameters     r_resm8            =  0.0214  * 0.8
parameters     r_resm9            =  0.0214  * 0.8
parameters     r_resm10           =  0.0214  * 0.8
parameters     r_resm11	          =  0.021   * 0.8
parameters    fac_mm_r_resm1             =  0
parameters    fac_mm_r_resm2             =  0
parameters    fac_mm_r_resm3             =  0
parameters    fac_mm_r_resm4             =  0
parameters    fac_mm_r_resm5             =  0
parameters    fac_mm_r_resm6             =  0
parameters    fac_mm_r_resm7             =  0
parameters    fac_mm_r_resm8             =  0
parameters    fac_mm_r_resm9             =  0
parameters    fac_mm_r_resm10            =  0
parameters    fac_mm_r_resm11  	         =  0
parameters    fac_mm_r_rsnp    	         =  0
parameters    fac_mm_dxw_rsnp       =  0
parameters    fac_mm_r_rnsnp   	         =  0
parameters    fac_mm_dxw_rnsnp      =  0
parameters    fac_mm_rend_rnsnp     =  0
parameters    fac_mm_r_rspp    	         =  0
parameters    fac_mm_dxw_rspp       =  0
parameters    fac_mm_r_rnspp   	         =  0
parameters    fac_mm_dxw_rnspp      =  0
parameters    fac_mm_rend_rnspp     =  0
parameters    fac_mm_r_rnsnd   	         =  0
parameters    fac_mm_dxw_rnsnd      =  0
parameters    fac_mm_rend_rnsnd     =  0
parameters    fac_mm_r_rnspd   	         =  0
parameters    fac_mm_dxw_rnspd      =  0
parameters    fac_mm_rend_rnspd     =  0
parameters    fac_mm_r_rsnd   	         =  0
parameters    fac_mm_dxw_rsnd      =  0
parameters    fac_mm_r_rspd   	         =  0
parameters    fac_mm_dxw_rspd      =  0
parameters    fac_mm_r_rnwo   	         =  0
parameters    fac_mm_r_rnws   	         =  0
include "cds_ff_mpt_resistor.scs" section=res
endsection ff_res

section  res

//  *********************************   N-well Resistor under STI  *********************************
subckt cds_ff_mpt_rnws ( n1 n2 )
parameters l=1.0e-6 w=1.0e-6 factor=1.0 mf=1.0 mismod=0
+ geo_fac = 1/sqrt(mf*l*factor*w*factor*1e12)
+ drsh_mis = 0.02*geo_fac*fac_mm_r_rnws*mismod
+ dw = 2e-9                     pvc1 = 7.6e-7
+ pvc2 = -4.77e-4               ptc1 = 3.71e-3                ptc2 = 1e-7
+rsh = r_rnws*(1+drsh_mis)      pt = temp                 tfac = 1.0+ptc1*(pt-25.0)+ptc2*(pt-25.0)*(pt-25.0)
r1 ( n1 n2 ) bsource r=rsh/mf*l*factor/(w*factor-dw)*(1+pvc1*(abs(v(n2,n1))/factor)+pvc2*(v(n2,n1)/factor)*(v(n2,n1)/factor))*tfac
ends rnws

//  *********************************   N-well Resistor under Oxide  *********************************

subckt cds_ff_mpt_rnwo ( n1 n2 )
parameters l=1.0e-6 w=1.0e-6 factor=1.0 mf=1.0 mismod=0
+ geo_fac = 1/sqrt(mf*l*factor*w*factor*1e12)
+ drsh_mis = 0.02*geo_fac*fac_mm_r_rnwo*mismod
+ dw = 1.4e-9                   pvc1 = 0.0124
+ pvc2 = -2.98e-4               ptc1 = 2.83e-3                ptc2 = 1.04e-5
+rsh = r_rnwo*(1+drsh_mis)            pt = temp                 tfac = 1.0+ptc1*(pt-25.0)+ptc2*(pt-25.0)*(pt-25.0)
r1 ( n1 n2 ) bsource r=rsh/mf*l*factor/(w*factor-dw)*(1+pvc1*(abs(v(n2,n1))/factor)+pvc2*(v(n2,n1)/factor)*(v(n2,n1)/factor))*tfac
ends rnwo

//  *********************************   N+ Diffused Resistor (salicide)  *********************************

subckt cds_ff_mpt_rsnd ( n1 n2 )
parameters l=1.0e-6 w=1.0e-6 factor=1.0 mf=1.0 mismod=0
+ geo_fac = 1/sqrt(mf*l*factor*w*factor*1e12)
+ drsh_mis = 0.02*geo_fac*fac_mm_r_rsnd*mismod
+ dw_mis = 0.01*geo_fac*fac_mm_dxw_rsnd*mismod
+ pvc1 = 4.77e-7
+ pvc2 = 7.63e-13               ptc1 = 3.2e-3                 ptc2 = 4.06e-7
+rsh = r_rsnd*(1+drsh_mis)               dw = r_dxw_rsnd*(1+dw_mis)              pt = temp
+tfac = 1.0+ptc1*(pt-25.0)+ptc2*(pt-25.0)*(pt-25.0)
r1 ( n1 n2 ) bsource r=rsh/mf*l*factor/(w*factor-dw)*(1+pvc1*(abs(v(n2,n1))/l/factor)+pvc2*(v(n2,n1)/l/factor)*(v(n2,n1)/l/factor))*tfac
ends rsnd

//  *********************************   P+ Diffused Resistor (salicide)  *********************************

subckt cds_ff_mpt_rspd ( n1 n2 )
parameters l=1.0e-6 w=1.0e-6 factor=1.0 mf=1.0  mismod=0
+ geo_fac = 1/sqrt(mf*l*factor*w*factor*1e12)
+ drsh_mis = 0.02*geo_fac*fac_mm_r_rspd*mismod
+ dw_mis = 0.01*geo_fac*fac_mm_dxw_rspd*mismod
+ pvc1 = 6.04e-7
+ pvc2 = 7.82e-13               ptc1 = 3.55e-3                ptc2 = -3.88e-7
+rsh = r_rspd*(1+drsh_mis)               dw = r_dxw_rspd*(1+dw_mis)              pt = temp
+tfac = 1.0+ptc1*(pt-25.0)+ptc2*(pt-25.0)*(pt-25.0)
r1 ( n1 n2 ) bsource r=rsh/mf*l*factor/(w*factor-dw)*(1+pvc1*(abs(v(n2,n1))/l/factor)+pvc2*(v(n2,n1)/l/factor)*(v(n2,n1)/l/factor))*tfac
ends rspd

//  *********************************   N+ Poly Resistor (salicide) *********************************

subckt cds_ff_mpt_rsnp ( n1 n2 )
parameters l=1.0e-6 w=1.0e-6 factor=1.0 mf=1.0 mismod=0
+ geo_fac = 1/sqrt(mf*l*factor*w*factor*1e12)
+ drsh_mis = 0.02*geo_fac*fac_mm_r_rsnp*mismod
+ dw_mis = 0.01*geo_fac*fac_mm_dxw_rsnp*mismod
+ pvc1 = 1.51e-6
+ pvc2 = 1.13e-12               ptc1 = 3.32e-3                ptc2 = -1.71e-6
+rsh = r_rsnp*(1+drsh_mis)             dw = r_dxw_rsnp*(1+dw_mis)            pt = temp
+tfac = 1.0+ptc1*(pt-25.0)+ptc2*(pt-25.0)*(pt-25.0)
r1 ( n1 n2 ) bsource r=rsh/mf*l*factor/(w*factor-dw)*(1+pvc1*(abs(v(n2,n1))/l/factor)+pvc2*(v(n2,n1)/l/factor)*(v(n2,n1)/l/factor))*tfac
ends rsnp

//  *********************************   P+ Poly Resistor (salicide) *********************************

subckt cds_ff_mpt_rspp ( n1 n2 )
parameters  l=1.0e-6 w=1.0e-6 factor=1.0 mf=1.0  mismod=0
+ geo_fac = 1/sqrt(mf*l*factor*w*factor*1e12)
+ drsh_mis = 0.02*geo_fac*fac_mm_r_rspp *mismod
+ dw_mis = 0.01*geo_fac*fac_mm_dxw_rspp*mismod
+ pvc1 = 1.82e-6
+ pvc2 = 1.23e-12               ptc1 = 3.28e-3                ptc2 = -1.09e-6
+rsh = r_rspp*(1+drsh_mis)            dw = r_dxw_rspp*(1+dw_mis)            pt = temp
+tfac = 1.0+ptc1*(pt-25.0)+ptc2*(pt-25.0)*(pt-25.0)
r1 ( n1 n2 ) bsource r=rsh/mf*l*factor/(w*factor-dw)*(1+pvc1*(abs(v(n2,n1))/l/factor)+pvc2*(v(n2,n1)/l/factor)*(v(n2,n1)/l/factor))*tfac
ends rspp

//  *********************************  N+ Diffused Resistor (w/o salicide)  *********************************

subckt cds_ff_mpt_rnsnd ( n1 n2 )
parameters  l=1.0e-6 w=1.0e-6 factor=1.0 mf=1.0 mismod=0
+ geo_fac = 1/sqrt(mf*l*factor*w*factor*1e12)
+ drsh_mis = 0.02*geo_fac*fac_mm_r_rnsnd *mismod
+ dw_mis = 0.01*geo_fac*fac_mm_dxw_rnsnd*mismod
+ drend_mis = 0.01*geo_fac*fac_mm_rend_rnsnd*mismod
+pvcp1 = -0.296                pvcp2 = -8.04e-6
+pvcp3 = -2.449                ptcp1 = 2.565e-3              ptcp2 = 5.5e-7
+pvce1 = -0.0689               pvce2 = 1.12e3                pvce3 = -0.182
+ptce1 = 1.875e-3              ptce2 = 2.5e-6
+rsh = r_rnsnd*(1+drsh_mis)             rend0 = r_rend_rnsnd*(1+drend_mis)    dw = r_dxw_rnsnd*(1+dw_mis)
+dl = 0             pt = temp                  tface = 1.0+ptce1*(pt-25.0)+ptce2*(pt-25.0)*(pt-25.0)
+tfacp = 1.0+ptcp1*(pt-25.0)+ptcp2*(pt-25.0)*(pt-25.0)
rend1 ( n1 3 ) bsource r=rend0/mf/w/factor*tface*(1+pvce1*(tanh(pvce2*abs(v(n1,3))+pvce3)-tanh(pvce3)))
rp ( 3 4 ) bsource r=rsh/mf*(l*factor-dl)/(w*factor-dw)*tfacp*(1+pvcp1*(tanh(pvcp2*abs(v(3,4)/(l*factor-dl))+pvcp3)-tanh(pvcp3)))
rend2 ( 4 n2 ) bsource r=rend0/mf/w/factor*tface*(1+pvce1*(tanh(pvce2*abs(v(4,n2))+pvce3)-tanh(pvce3)))
ends rnsnd

//  *********************************  P+ Diffused Resistor (w/o salicide)  *********************************

subckt cds_ff_mpt_rnspd ( n1 n2 )
parameters  l=1.0e-6 w=1.0e-6 factor=1.0 mf=1.0 mismod=0
+ geo_fac = 1/sqrt(mf*l*factor*w*factor*1e12)
+ drsh_mis = 0.02*geo_fac*fac_mm_r_rnspd *mismod
+ dw_mis = 0.01*geo_fac*fac_mm_dxw_rnspd*mismod
+ drend_mis = 0.01*geo_fac*fac_mm_rend_rnspd*mismod
+ pvcp1 = -0.389                pvcp2 = -1.73e-6
+ pvcp3 = -2.098                ptcp1 = 1.51e-3               ptcp2 = 4.14e-6
+ pvce1 = 0.035                 pvce2 = 259                   pvce3 = -0.0992
+ ptce1 = -1e-3                 ptce2 = 2e-6
+rsh = r_rnspd*(1+drsh_mis)              rend0 = r_rend_rnspd*(1+drend_mis)         dw = r_dxw_rnspd*(1+dw_mis)
+dl = 0             pt = temp                 tface = 1.0+ptce1*(pt-25.0)+ptce2*(pt-25.0)*(pt-25.0)
+tfacp = 1.0+ptcp1*(pt-25.0)+ptcp2*(pt-25.0)*(pt-25.0)
rend1 ( n1 3 ) bsource r=rend0/mf/w/factor*tface*(1+pvce1*(tanh(pvce2*abs(v(n1,3))+pvce3)-tanh(pvce3)))
rp ( 3 4 ) bsource r=rsh/mf*(l*factor-dl)/(w*factor-dw)*tfacp*(1+pvcp1*(tanh(pvcp2*abs(v(3,4)/(l*factor-dl))+pvcp3)-tanh(pvcp3)))
rend2 ( 4 n2 ) bsource r=rend0/mf/w/factor*tface*(1+pvce1*(tanh(pvce2*abs(v(4,n2))+pvce3)-tanh(pvce3)))
ends rnspd

//  *********************************    N+ Poly Resistor (w/o salicide)  *********************************

subckt cds_ff_mpt_rnsnp ( n1 n2 )
parameters l=1.0e-6 w=1.0e-6 factor=1.0 mf=1.0 mismod=0
+ geo_fac = 1/sqrt(mf*l*factor*w*factor*1e12)
+ drsh_mis = 0.02*geo_fac*fac_mm_r_rnsnp*mismod
+ dw_mis = 0.01*geo_fac*fac_mm_dxw_rnsnp*mismod
+ drend_mis = 0.01*geo_fac*fac_mm_rend_rnsnp*mismod
+pvcp1 = -0.788                pvcp2 = -9.8e-5
+pvcp3 = -2.453                ptcp1 = 9.89e-4               ptcp2 = 2.5e-6
+pvce1 = -0.0227               pvce2 = -654                  pvce3 = 0.766
+ptce1 = 3e-3                  ptce2 = 8e-6
+rsh = r_rnsnp*(1+drsh_mis)            rend0 = r_rend_rnsnp*(1+drend_mis)       dw = r_dxw_rnsnp*(1+dw_mis)
+dl = 0           pt = temp                 tface = 1.0+ptce1*(pt-25.0)+ptce2*(pt-25.0)*(pt-25.0)
+tfacp = 1.0+ptcp1*(pt-25.0)+ptcp2*(pt-25.0)*(pt-25.0)
rend1 ( n1 3 ) bsource r=rend0/mf/w/factor*tface*(1+pvce1*(tanh(pvce2*abs(v(n1,3))+pvce3)-tanh(pvce3)))
rp ( 3 4 ) bsource r=rsh/mf*(l*factor-dl)/(w*factor-dw)*tfacp*(1+pvcp1*(tanh(pvcp2*abs(v(3,4)/(l*factor-dl))+pvcp3)-tanh(pvcp3)))
rend2 ( 4 n2 ) bsource r=rend0/mf/w/factor*tface*(1+pvce1*(tanh(pvce2*abs(v(4,n2))+pvce3)-tanh(pvce3)))
ends rnsnp

//  *********************************  P+ Poly Resistor (w/o salicide)  *********************************

subckt cds_ff_mpt_rnspp ( n1 n2 )
parameters l=1.0e-6 w=1.0e-6 factor=1.0 mf=1.0 mismod=0
+ geo_fac = 1/sqrt(mf*l*factor*w*factor*1e12)
+ drsh_mis = 0.02*geo_fac*fac_mm_r_rnspp*mismod
+ dw_mis = 0.01*geo_fac*fac_mm_dxw_rnspp*mismod
+ drend_mis = 0.01*geo_fac*fac_mm_rend_rnspp*mismod
+pvcp1 = 1.1e-3                pvcp2 = -2.69e-5
+pvcp3 = 2.957                 ptcp1 = -5e-4                 ptcp2 = 8.692e-15
+pvce1 = 0.0104                pvce2 = -7.216                pvce3 = 0.172
+ptce1 = -8e-7                 ptce2 = -5e-6
+rsh = r_rnspp*(1+drsh_mis)            rend0 = r_rend_rnspp*(1+drend_mis)       dw = r_dxw_rnspp*(1+dw_mis)
+dl = 0           pt = temp                 tface = 1.0+ptce1*(pt-25.0)+ptce2*(pt-25.0)*(pt-25.0)
+tfacp = 1.0+ptcp1*(pt-25.0)+ptcp2*(pt-25.0)*(pt-25.0)
rend1 ( n1 3 ) bsource r=rend0/mf/w/factor*tface*(1+pvce1*(tanh(pvce2*abs(v(n1,3))+pvce3)-tanh(pvce3)))
rp ( 3 4 ) bsource r=rsh/mf*(l*factor-dl)/(w*factor-dw)*tfacp*(1+pvcp1*(tanh(pvcp2*abs(v(3,4)/(l*factor-dl))+pvcp3)-tanh(pvcp3)))
rend2 ( 4 n2 ) bsource r=rend0/mf/w/factor*tface*(1+pvce1*(tanh(pvce2*abs(v(4,n2))+pvce3)-tanh(pvce3)))
ends rnspp

//  *********************************     Metal 1      ***********************************
subckt cds_ff_mpt_resm1 ( n1 n2 )
parameters l=1.0e-6 w=1.0e-6 factor=1.0 mf=1.0  mismod=0
+ geo_fac = 1/sqrt(mf*l*factor*w*factor*1e12)
+ drsh_mis = 0.02*geo_fac*fac_mm_r_resm1*mismod
+dw = 0                        pvc1 = 0
+pvc2 = 0                      ptc1 = 2.92e-3                ptc2 = -1.22e-7
+rsh = r_resm1*(1+drsh_mis)                 pt = temp                  tfac = 1.0+ptc1*(pt-25.0)+ptc2*(pt-25.0)*(pt-25.0)
r1 ( n1 n2 ) bsource r=rsh/mf*l*factor/(w*factor-dw)*(1+pvc1*(abs(v(n2,n1))/l/factor)+pvc2*(v(n2,n1)/l/factor)*(v(n2,n1)/l/factor))*tfac
ends resm1

//  *********************************     Metal 2      ***********************************
subckt cds_ff_mpt_resm2 ( n1 n2 )
parameters l=1.0e-6 w=1.0e-6 factor=1.0 mf=1.0 mismod=0
+ geo_fac = 1/sqrt(mf*l*factor*w*factor*1e12)
+ drsh_mis = 0.02*geo_fac*fac_mm_r_resm2*mismod
+dw = 0                        pvc1 = 0
+pvc2 = 0                      ptc1 = 3.077e-3               ptc2 = -1.14e-7
+rsh =  r_resm2*(1+drsh_mis)                   pt = temp                  tfac = 1.0+ptc1*(pt-25.0)+ptc2*(pt-25.0)*(pt-25.0)
r1 ( n1 n2 ) bsource r=rsh/mf*l*factor/(w*factor-dw)*(1+pvc1*(abs(v(n2,n1))/l/factor)+pvc2*(v(n2,n1)/l/factor)*(v(n2,n1)/l/factor))*tfac
ends resm2

//  *********************************     Metal 3      ***********************************
subckt cds_ff_mpt_resm3 ( n1 n2 )
parameters l=1.0e-6 w=1.0e-6 factor=1.0 mf=1.0  mismod=0
+ geo_fac = 1/sqrt(mf*l*factor*w*factor*1e12)
+ drsh_mis = 0.02*geo_fac*fac_mm_r_resm3*mismod
+dw = 0                        pvc1 = 0
+pvc2 = 0                      ptc1 = 3.077e-3               ptc2 = -1.14e-7
+rsh = r_resm3*(1+drsh_mis)                    pt = temp                  tfac = 1.0+ptc1*(pt-25.0)+ptc2*(pt-25.0)*(pt-25.0)
r1 ( n1 n2 ) bsource r=rsh/mf*l*factor/(w*factor-dw)*(1+pvc1*(abs(v(n2,n1))/l/factor)+pvc2*(v(n2,n1)/l/factor)*(v(n2,n1)/l/factor))*tfac
ends resm3

//  *********************************     Metal 4      ***********************************
subckt cds_ff_mpt_resm4 ( n1 n2 )
parameters l=1.0e-6 w=1.0e-6 factor=1.0 mf=1.0  mismod=0
+ geo_fac = 1/sqrt(mf*l*factor*w*factor*1e12)
+ drsh_mis = 0.02*geo_fac*fac_mm_r_resm4*mismod
+dw = 0                        pvc1 = 0
+pvc2 = 0                      ptc1 = 3.077e-3               ptc2 = -1.14e-7
+rsh = r_resm4*(1+drsh_mis)                    pt = temp                  tfac = 1.0+ptc1*(pt-25.0)+ptc2*(pt-25.0)*(pt-25.0)
r1 ( n1 n2 ) bsource r=rsh/mf*l*factor/(w*factor-dw)*(1+pvc1*(abs(v(n2,n1))/l/factor)+pvc2*(v(n2,n1)/l/factor)*(v(n2,n1)/l/factor))*tfac
ends resm4

//  *********************************     Metal 5      ***********************************
subckt cds_ff_mpt_resm5 ( n1 n2 )
parameters l=1.0e-6 w=1.0e-6 factor=1.0 mf=1.0 mismod=0
+ geo_fac = 1/sqrt(mf*l*factor*w*factor*1e12)
+ drsh_mis = 0.02*geo_fac*fac_mm_r_resm5*mismod
+dw = 0                        pvc1 = 0
+pvc2 = 0                      ptc1 = 3.077e-3               ptc2 = -1.14e-7
+rsh = r_resm5*(1+drsh_mis)                    pt = temp                  tfac = 1.0+ptc1*(pt-25.0)+ptc2*(pt-25.0)*(pt-25.0)
r1 ( n1 n2 ) bsource r=rsh/mf*l*factor/(w*factor-dw)*(1+pvc1*(abs(v(n2,n1))/l/factor)+pvc2*(v(n2,n1)/l/factor)*(v(n2,n1)/l/factor))*tfac
ends resm5

//  *********************************     Metal 6      ***********************************
subckt cds_ff_mpt_resm6 ( n1 n2 )
parameters l=1.0e-6 w=1.0e-6 factor=1.0 mf=1.0  mismod=0
+ geo_fac = 1/sqrt(mf*l*factor*w*factor*1e12)
+ drsh_mis = 0.02*geo_fac*fac_mm_r_resm6*mismod
+dw = 0                        pvc1 = 0
+pvc2 = 0                      ptc1 = 3.077e-3               ptc2 = -1.14e-7
+rsh = r_resm6*(1+drsh_mis)                    pt = temp                  tfac = 1.0+ptc1*(pt-25.0)+ptc2*(pt-25.0)*(pt-25.0)
r1 ( n1 n2 ) bsource r=rsh/mf*l*factor/(w*factor-dw)*(1+pvc1*(abs(v(n2,n1))/l/factor)+pvc2*(v(n2,n1)/l/factor)*(v(n2,n1)/l/factor))*tfac
ends resm6

//  *********************************     Metal 7      ***********************************
subckt cds_ff_mpt_resm7 ( n1 n2 )
parameters l=1.0e-6 w=1.0e-6 factor=1.0 mf=1.0 mismod=0
+ geo_fac = 1/sqrt(mf*l*factor*w*factor*1e12)
+ drsh_mis = 0.02*geo_fac*fac_mm_r_resm7*mismod
+dw = 0                        pvc1 = 0
+pvc2 = 0                      ptc1 = 3.077e-3               ptc2 = -1.14e-7
+rsh =r_resm7*(1+drsh_mis)                    pt = temp                  tfac = 1.0+ptc1*(pt-25.0)+ptc2*(pt-25.0)*(pt-25.0)
r1 ( n1 n2 ) bsource r=rsh/mf*l*factor/(w*factor-dw)*(1+pvc1*(abs(v(n2,n1))/l/factor)+pvc2*(v(n2,n1)/l/factor)*(v(n2,n1)/l/factor))*tfac
ends resm7

//  *********************************     Metal 8      ***********************************
subckt cds_ff_mpt_resm8 ( n1 n2 )
parameters l=1.0e-6 w=1.0e-6 factor=1.0 mf=1.0 mismod=0
+ geo_fac = 1/sqrt(mf*l*factor*w*factor*1e12)
+ drsh_mis = 0.02*geo_fac*fac_mm_r_resm8*mismod
+dw = 0                        pvc1 = 0
+pvc2 = 0                      ptc1 = 3.506e-3               ptc2 = -3.6e-7
+rsh =r_resm8*(1+drsh_mis)                  pt = temp                  tfac = 1.0+ptc1*(pt-25.0)+ptc2*(pt-25.0)*(pt-25.0)
r1 ( n1 n2 ) bsource r=rsh/mf*l*factor/(w*factor-dw)*(1+pvc1*(abs(v(n2,n1))/l/factor)+pvc2*(v(n2,n1)/l/factor)*(v(n2,n1)/l/factor))*tfac
ends resm8

//  *********************************     Metal 9      ***********************************
subckt cds_ff_mpt_resm9 ( n1 n2 )
parameters l=1.0e-6 w=1.0e-6 factor=1.0 mf=1.0  mismod=0
+ geo_fac = 1/sqrt(mf*l*factor*w*factor*1e12)
+ drsh_mis = 0.02*geo_fac*fac_mm_r_resm9*mismod
+dw = 0                        pvc1 = 0
+pvc2 = 0                      ptc1 = 3.506e-3               ptc2 = -3.6e-7
+rsh = r_resm9*(1+drsh_mis)                 pt = temp                  tfac = 1.0+ptc1*(pt-25.0)+ptc2*(pt-25.0)*(pt-25.0)
r1 ( n1 n2 ) bsource r=rsh/mf*l*factor/(w*factor-dw)*(1+pvc1*(abs(v(n2,n1))/l/factor)+pvc2*(v(n2,n1)/l/factor)*(v(n2,n1)/l/factor))*tfac
ends resm9

//  *********************************     Metal 10      ***********************************
subckt cds_ff_mpt_resm10 ( n1 n2 )
parameters l=1.0e-6 w=1.0e-6 factor=1.0 mf=1.0 mismod=0
+ geo_fac = 1/sqrt(mf*l*factor*w*factor*1e12)
+ drsh_mis = 0.02*geo_fac*fac_mm_r_resm10*mismod
+dw = 0                        pvc1 = 0
+pvc2 = 0                      ptc1 = 3.506e-3               ptc2 = -3.6e-7
+rsh = r_resm10*(1+drsh_mis)                pt = temp                  tfac = 1.0+ptc1*(pt-25.0)+ptc2*(pt-25.0)*(pt-25.0)
r1 ( n1 n2 ) bsource r=rsh/mf*l*factor/(w*factor-dw)*(1+pvc1*(abs(v(n2,n1))/l/factor)+pvc2*(v(n2,n1)/l/factor)*(v(n2,n1)/l/factor))*tfac
ends resm10

//  *********************************     Metal 11      ***********************************
subckt cds_ff_mpt_resm11 ( n1 n2 )
parameters  l=1.0e-6 w=1.0e-6 factor=1.0 mf=1.0  mismod=0
+ geo_fac = 1/sqrt(mf*l*factor*w*factor*1e12)
+ drsh_mis = 0.02*geo_fac*fac_mm_r_resm11*mismod
+dw = 0                        pvc1 = 0
+pvc2 = 0                      ptc1 = 3.89e-3                ptc2 = -1.5e-7
+rsh = r_resm11*(1+drsh_mis)                pt = temp                  tfac = 1.0+ptc1*(pt-25.0)+ptc2*(pt-25.0)*(pt-25.0)
r1 ( n1 n2 ) bsource r=rsh/mf*l*factor/(w*factor-dw)*(1+pvc1*(abs(v(n2,n1))/l/factor)+pvc2*(v(n2,n1)/l/factor)*(v(n2,n1)/l/factor))*tfac
ends resm11

endsection res

section tt_res3
parameters      r_rnws_m          =   1000
parameters      r_rnwo_m        =   450
parameters      r_rsnd_m         =   18
parameters      r_rspd_m         =   15
parameters      r_rsnp_dis       =   15
parameters      r_rspp_dis       =    15
parameters      r_rnsnd_m        =   100
parameters      r_rend_rnsnd_m   =   8.46u
parameters      r_dxl_rnsnd_m    =   0
parameters      r_dxw_rnsnd_m    =   0.0027u
parameters      r_rnspd_m        =   200
parameters      r_rend_rnspd_m   =   29.5u
parameters      r_dxl_rnspd_m    =   0
parameters      r_dxw_rnspd_m    =   0.03071u
parameters      r_rnsnp_dis      =    200
parameters      r_rend_rnsnp_dis =   14.4u
parameters      r_dxl_rnsnp_dis  =   0
parameters      r_dxw_rnsnp_dis  =   0.0936u
parameters      r_rnspp_dis      =   650
parameters      r_rend_rnspp_dis =   86.7u
parameters      r_dxl_rnspp_dis  =   0
parameters      r_dxw_rnspp_dis  =   0.0689u
include "cds_ff_mpt_resistor.scs" section=res_3t

endsection tt_res3

section ss_res3
parameters     r_rnws_m          =  1e3  * 1.20
parameters     r_rnwo_m        =  450 * 1.20
parameters     r_rsnd_m         =  18 * 1.20
parameters     r_rspd_m         =  15* 1.20
parameters     r_rsnp_dis       =  15* 1.20
parameters     r_rspp_dis       =  15* 1.20
parameters     r_rnsnd_m        =  100* 1.15
parameters     r_rend_rnsnd_m   =  8.46e-6 * 1.90
parameters     r_dxl_rnsnd_m    =  0+ 0.0u
parameters     r_dxw_rnsnd_m    =  0  + 0.040u
parameters     r_rnspd_m        =  200  * 1.25
parameters     r_rend_rnspd_m   =  2.95e-5    * 1.60
parameters     r_dxl_rnspd_m    =  0   + 0.0u
parameters     r_dxw_rnspd_m    =  0  + 0.022u
parameters     r_rnsnp_dis      =  200* 1.15
parameters     r_rend_rnsnp_dis =  1.44e-5   * 1.90
parameters     r_dxl_rnsnp_dis  =  0  + 0.0u
parameters     r_dxw_rnsnp_dis  =  0  + 0.032u
parameters     r_rnspp_dis      =  650 * 1.15
parameters     r_rend_rnspp_dis =  7.015e-6     * 1.60
parameters     r_dxl_rnspp_dis  =  0  + 0.0u
parameters     r_dxw_rnspp_dis  =  0 + 0.035u
include "cds_ff_mpt_resistor.scs" section=res_3t

endsection ss_res3

section ff_res3
parameters     r_rnws_m          =  1e3  * 0.8
parameters     r_rnwo_m        =  450 * 0.8
parameters     r_rsnd_m         =  18 * 0.8
parameters     r_rspd_m         =  15* 0.8
parameters     r_rsnp_dis       =  15* 0.8
parameters     r_rspp_dis       =  15*0.8
parameters     r_rnsnd_m        =  100* 0.85
parameters     r_rend_rnsnd_m   =  8.46e-6 * 0.1
parameters     r_dxl_rnsnd_m    =  0
parameters     r_dxw_rnsnd_m    =  0  - 0.040u
parameters     r_rnspd_m        =  200  * 0.75
parameters     r_rend_rnspd_m   =  2.95e-5    * 0.4
parameters     r_dxl_rnspd_m    =  0   + 0.0u
parameters     r_dxw_rnspd_m    =  0  - 0.022u
parameters     r_rnsnp_dis      =  200* 0.85
parameters     r_rend_rnsnp_dis =  1.44e-5   *0.1
parameters     r_dxl_rnsnp_dis  =  0  + 0.0u
parameters     r_dxw_rnsnp_dis  =  0  - 0.032u
parameters     r_rnspp_dis      =  650 *0.85
parameters     r_rend_rnspp_dis =  7.015e-6     * 0.4
parameters     r_dxl_rnspp_dis  =  0  + 0.0u
parameters     r_dxw_rnspp_dis  =  0 - 0.035u
include "cds_ff_mpt_resistor.scs" section=res_3t

endsection ff_res3

section res_3t

//*********************       rnws_m      NW diff(under STI)   *********************
subckt cds_ff_mpt_rnws_m (n2 n1 body)
parameters l=1e-6 w=1e-6 mf=1 factor=1 mismod=0
+ geo_fac = 1/sqrt(mf*l*factor*w*factor*1e12)
+ drsh_mis = 0.02*geo_fac*fac_r_rnws_m *mismod
+ rsh=r_rnws_m*(1+drsh_mis) dw=4.5n ptc1=1.90e-03 ptc2=1.062e-05 pvc1=1.27e-02 pvc2=-5.02e-04 pt=temp
+ tfac= 1.0+ptc1*(pt-25.0)+ptc2*(pt-25.0)*(pt-25.0)
r1 ( n2 nm ) bsource r=rsh/mf*l*factor/(4.0*(w*factor-dw))*(1+pvc1*abs(v(n2,n1))+pvc2*v(n2,n1)*v(n2,n1))*tfac
r2 ( nm nn ) bsource r=rsh/mf*l*factor/(4.0*(w*factor-dw))*(1+pvc1*abs(v(n2,n1))+pvc2*v(n2,n1)*v(n2,n1))*tfac
r3 ( nn nx ) bsource r=rsh/mf*l*factor/(4.0*(w*factor-dw))*(1+pvc1*abs(v(n2,n1))+pvc2*v(n2,n1)*v(n2,n1))*tfac
r4 ( nx n1 ) bsource r=rsh/mf*l*factor/(4.0*(w*factor-dw))*(1+pvc1*abs(v(n2,n1))+pvc2*v(n2,n1)*v(n2,n1))*tfac
d1 ( body n2 ) nwdio area=mf*((w*factor-dw)*l*factor/5.0)  pj= mf*((w*factor-dw)+2.0*l*factor/5.0)
d2 ( body nm ) nwdio area=mf*((w*factor-dw)*l*factor/5.0)  pj= mf*2.0*l*factor/5.0
d3 ( body nn ) nwdio area=mf*((w*factor-dw)*l*factor/5.0)  pj= mf*2.0*l*factor/5.0
d4 ( body nx ) nwdio area=mf*((w*factor-dw)*l*factor/5.0)  pj= mf*2.0*l*factor/5.0
d5 ( body n1 ) nwdio area=mf*((w*factor-dw)*l*factor/5.0)  pj= mf*((w*factor-dw)+2.0*l*factor/5.0)
ends rnws_m

//*********************   rnwo_m       NW diff(under OD)   *********************
subckt cds_ff_mpt_rnwo_m (n2 n1 body)
parameters l=1e-6 w=1e-6 mf=1 factor=1 mismod=0
+ geo_fac = 1/sqrt(mf*l*factor*w*factor*1e12)
+ drsh_mis = 0.02*geo_fac*fac_r_rnwo_m *mismod
+ rsh=r_rnwo_m*(1+drsh_mis) dw=3.19n ptc1=3.113e-03 ptc2=1.144e-05 pvc1=1.364e-02 pvc2=-3.278e-04 pt=temp
+ tfac=1.0+ptc1*(pt-25.0)+ptc2*(pt-25.0)*(pt-25.0)
r1 ( n2 nm ) bsource r=rsh/mf*l*factor/(4.0*(w*factor-dw))*(1+pvc1*abs(v(n2,n1))+pvc2*v(n2,n1)*v(n2,n1))*tfac
r2 ( nm nn ) bsource r=rsh/mf*l*factor/(4.0*(w*factor-dw))*(1+pvc1*abs(v(n2,n1))+pvc2*v(n2,n1)*v(n2,n1))*tfac
r3 ( nn nx ) bsource r=rsh/mf*l*factor/(4.0*(w*factor-dw))*(1+pvc1*abs(v(n2,n1))+pvc2*v(n2,n1)*v(n2,n1))*tfac
r4 ( nx n1 ) bsource r=rsh/mf*l*factor/(4.0*(w*factor-dw))*(1+pvc1*abs(v(n2,n1))+pvc2*v(n2,n1)*v(n2,n1))*tfac
d1 ( body n2 ) nwdio area=mf*((w*factor-dw)*l*factor/5.0)  pj= mf*((w*factor-dw)+2.0*l*factor/5.0)
d2 ( body nm ) nwdio area=mf*((w*factor-dw)*l*factor/5.0)  pj= mf*2.0*l*factor/5.0
d3 ( body nn ) nwdio area=mf*((w*factor-dw)*l*factor/5.0)  pj= mf*2.0*l*factor/5.0
d4 ( body nx ) nwdio area=mf*((w*factor-dw)*l*factor/5.0)  pj= mf*2.0*l*factor/5.0
d5 ( body n1 ) nwdio area=mf*((w*factor-dw)*l*factor/5.0)  pj= mf*((w*factor-dw)+2.0*l*factor/5.0)
ends rnwo_m

//*********************       rsnd_m       N+diff w/i silicide   *********************

subckt cds_ff_mpt_rsnd_m (n2 n1 body)
parameters l=1e-6 w=1e-6 mf=1 factor=1 mismod=0
+ geo_fac = 1/sqrt(mf*l*factor*w*factor*1e12)
+ drsh_mis = 0.02*geo_fac*fac_r_rsnd_m *mismod
+ rsh=r_rsnd_m*(1+drsh_mis)  dw=0.00352u pvc1 = 5.247e-07   pvc2 = 8.393e-13   ptc1 = 3.41e-03   ptc2 = 4.356e-07 pt=temp
+ tfac= 1.0+ptc1*(pt-25.0)+ptc2*(pt-25.0)*(pt-25)
r1 ( n2 nm ) bsource r=rsh/mf*l*factor/(4.0*(w*factor-dw))*(1+pvc1*abs((v(n2,n1)/l/factor))+pvc2*(v(n2,n1)/l/factor)*(v(n2,n1)/l/factor))*tfac
r2 ( nm nn ) bsource r=rsh/mf*l*factor/(4.0*(w*factor-dw))*(1+pvc1*abs((v(n2,n1)/l/factor))+pvc2*(v(n2,n1)/l/factor)*(v(n2,n1)/l/factor))*tfac
r3 ( nn nx ) bsource r=rsh/mf*l*factor/(4.0*(w*factor-dw))*(1+pvc1*abs((v(n2,n1)/l/factor))+pvc2*(v(n2,n1)/l/factor)*(v(n2,n1)/l/factor))*tfac
r4 ( nx n1 ) bsource r=rsh/mf*l*factor/(4.0*(w*factor-dw))*(1+pvc1*abs((v(n2,n1)/l/factor))+pvc2*(v(n2,n1)/l/factor)*(v(n2,n1)/l/factor))*tfac
d1 ( body n2 ) _ndio area=mf*((w*factor-dw)*l*factor/5.0) pj= mf*((w*factor-dw)+2.0*l*factor/5.0)
d2 ( body nm ) _ndio area=mf*((w*factor-dw)*l*factor/5.0)  pj= mf*2.0*l*factor/5.0
d3 ( body nn ) _ndio area=mf*((w*factor-dw)*l*factor/5.0)  pj= mf*2.0*l*factor/5.0
d4 ( body nx ) _ndio area=mf*((w*factor-dw)*l*factor/5.0)  pj= mf*2.0*l*factor/5.0
d5 ( body n1 ) _ndio area=mf*((w*factor-dw)*l*factor/5.0)  pj= mf*((w*factor-dw)+2.0*l*factor/5.0)
ends rsnd_m

//*********************       rspd_m       P+diff w/i silicide    *********************
subckt cds_ff_mpt_rspd_m (n2 n1 body)
parameters l=1e-6 w=1e-6 mf=1 factor=1 mismod=0
+ geo_fac = 1/sqrt(mf*l*factor*w*factor*1e12)
+ drsh_mis = 0.02*geo_fac*fac_r_rspd_m *mismod
+ rsh=r_rspd_m*(1+drsh_mis)  dw=0.00726u pvc1 = 6.644e-07   pvc2 = 8.602e-13   ptc1 = 3.575e-03   ptc2 = -4.598e-07 pt=temp
+ tfac= 1.0+ptc1*(pt-25.0)+ptc2*(pt-25.0)*(pt-25)
r1 ( n2 nm ) bsource r=rsh/mf*l*factor/(4.0*(w*factor-dw))*(1+pvc1*abs((v(n2,n1)/l/factor))+pvc2*(v(n2,n1)/l/factor)*(v(n2,n1)/l/factor))*tfac
r2 ( nm nn ) bsource r=rsh/mf*l*factor/(4.0*(w*factor-dw))*(1+pvc1*abs((v(n2,n1)/l/factor))+pvc2*(v(n2,n1)/l/factor)*(v(n2,n1)/l/factor))*tfac
r3 ( nn nx ) bsource r=rsh/mf*l*factor/(4.0*(w*factor-dw))*(1+pvc1*abs((v(n2,n1)/l/factor))+pvc2*(v(n2,n1)/l/factor)*(v(n2,n1)/l/factor))*tfac
r4 ( nx n1 ) bsource r=rsh/mf*l*factor/(4.0*(w*factor-dw))*(1+pvc1*abs((v(n2,n1)/l/factor))+pvc2*(v(n2,n1)/l/factor)*(v(n2,n1)/l/factor))*tfac
d1 ( n2 body ) _pdio area=mf*((w*factor-dw)*l*factor/5.0)  pj= mf*((w*factor-dw)+2.0*l*factor/5.0)
d2 ( nm body ) _pdio area=mf*((w*factor-dw)*l*factor/5.0)  pj= mf*2.0*l*factor/5.0
d3 ( nn body ) _pdio area=mf*((w*factor-dw)*l*factor/5.0)  pj= mf*2.0*l*factor/5.0
d4 ( nx body ) _pdio area=mf*((w*factor-dw)*l*factor/5.0)  pj= mf*2.0*l*factor/5.0
d5 ( n1 body ) _pdio area=mf*((w*factor-dw)*l*factor/5.0)  pj= mf*((w*factor-dw)+2.0*l*factor/5.0)
ends rspd_m

//*********************     rsnp_dis   N+Poly w/i silicide    *********************
subckt cds_ff_mpt_rsnp_dis (n2 n1 body)
parameters l=1e-6 w=1e-6 mf=1 factor=1 mismod=0
+ geo_fac = 1/sqrt(mf*l*factor*w*factor*1e12)
+ drsh_mis = 0.02*geo_fac*fac_r_rsnp_dis *mismod
+ rsh=r_rsnp_dis*(1+drsh_mis) dw=0.02044u pvc1 = 1.661e-06   pvc2 = 1.243e-12   ptc1 = 3.432e-03   ptc2 = -2.101e-06 pt=temp
+ tfac= 1.0+ptc1*(pt-25.0)+ptc2*(pt-25.0)*(pt-25)
+ ca=1.024e-16 cf=4.136e-17
r1 ( n2 nm ) bsource r=rsh/mf*l*factor/(4.0*(w*factor-dw))*(1+pvc1*abs((v(n2,n1)/l/factor))+pvc2*(v(n2,n1)/l/factor)*(v(n2,n1)/l/factor))*tfac
r2 ( nm nn ) bsource r=rsh/mf*l*factor/(4.0*(w*factor-dw))*(1+pvc1*abs((v(n2,n1)/l/factor))+pvc2*(v(n2,n1)/l/factor)*(v(n2,n1)/l/factor))*tfac
r3 ( nn nx ) bsource r=rsh/mf*l*factor/(4.0*(w*factor-dw))*(1+pvc1*abs((v(n2,n1)/l/factor))+pvc2*(v(n2,n1)/l/factor)*(v(n2,n1)/l/factor))*tfac
r4 ( nx n1 ) bsource r=rsh/mf*l*factor/(4.0*(w*factor-dw))*(1+pvc1*abs((v(n2,n1)/l/factor))+pvc2*(v(n2,n1)/l/factor)*(v(n2,n1)/l/factor))*tfac
c1 ( body n2 )  capacitor c=mf*(ca*((w*factor-0.02u)*l*factor/5.0)*1e12+2*cf*l*factor/5.0*1e6)
c2 ( body nm )  capacitor c=mf*(ca*((w*factor-0.02u)*l*factor/5.0)*1e12+2*cf*l*factor/5.0*1e6)
c3 ( body nn )  capacitor c=mf*(ca*((w*factor-0.02u)*l*factor/5.0)*1e12+2*cf*l*factor/5.0*1e6)
c4 ( body nx )  capacitor c=mf*(ca*((w*factor-0.02u)*l*factor/5.0)*1e12+2*cf*l*factor/5.0*1e6)
c5 ( body n1 )  capacitor c=mf*(ca*((w*factor-0.02u)*l*factor/5.0)*1e12+2*cf*l*factor/5.0*1e6)
ends rsnp_dis

//*********************      rspp_dis   P+Poly w/i silicide  *********************
subckt cds_ff_mpt_rspp_dis (n2 n1 body)
parameters l=1e-6 w=1e-6 mf=1 factor=1 mismod=0
+ geo_fac = 1/sqrt(mf*l*factor*w*factor*1e12)
+ drsh_mis = 0.02*geo_fac*fac_r_rspp_dis *mismod
+ rsh=r_rspp_dis*(1+drsh_mis) dw= 0.00583u  pvc1 = 2.002e-06   pvc2 = 1.353e-12   ptc1 = 3.388e-03   ptc2 = -1.529e-06 pt=temp
+ tfac= 1.0+ptc1*(pt-25.0)+ptc2*(pt-25.0)*(pt-25)
+ ca=1.024e-16 cf=4.136e-17
r1 ( n2 nm ) bsource r=rsh/mf*l*factor/(4.0*(w*factor-dw))*(1+pvc1*abs((v(n2,n1)/l/factor))+pvc2*(v(n2,n1)/l/factor)*(v(n2,n1)/l/factor))*tfac
r2 ( nm nn ) bsource r=rsh/mf*l*factor/(4.0*(w*factor-dw))*(1+pvc1*abs((v(n2,n1)/l/factor))+pvc2*(v(n2,n1)/l/factor)*(v(n2,n1)/l/factor))*tfac
r3 ( nn nx ) bsource r=rsh/mf*l*factor/(4.0*(w*factor-dw))*(1+pvc1*abs((v(n2,n1)/l/factor))+pvc2*(v(n2,n1)/l/factor)*(v(n2,n1)/l/factor))*tfac
r4 ( nx n1 ) bsource r=rsh/mf*l*factor/(4.0*(w*factor-dw))*(1+pvc1*abs((v(n2,n1)/l/factor))+pvc2*(v(n2,n1)/l/factor)*(v(n2,n1)/l/factor))*tfac
c1 ( body n2 )  capacitor c=mf*(ca*((w*factor-0.02u)*l*factor/5.0)*1e12+2*cf*l*factor/5.0*1e6)
c2 ( body nm )  capacitor c=mf*(ca*((w*factor-0.02u)*l*factor/5.0)*1e12+2*cf*l*factor/5.0*1e6)
c3 ( body nn )  capacitor c=mf*(ca*((w*factor-0.02u)*l*factor/5.0)*1e12+2*cf*l*factor/5.0*1e6)
c4 ( body nx )  capacitor c=mf*(ca*((w*factor-0.02u)*l*factor/5.0)*1e12+2*cf*l*factor/5.0*1e6)
c5 ( body n1 )  capacitor c=mf*(ca*((w*factor-0.02u)*l*factor/5.0)*1e12+2*cf*l*factor/5.0*1e6)
ends rspp_dis

//*********************       rnsnd_m      N+diff w/o silicide   *********************
subckt cds_ff_mpt_rnsnd_m (ns ne body)
parameters l=1e-6 w=1e-6 mf=1 factor=1 mismod=0
+ geo_fac = 1/sqrt(mf*l*factor*w*factor*1e12)
+ drsh_mis = 0.02*geo_fac*fac_r_rnsnd_m*mismod
+ dw_mis = 0.01*geo_fac*fac_r_dxw_rnsnd_m*mismod
+ drend_mis = 0.01*geo_fac*fac_r_rend_rnsnd_m*mismod
+ rsh=r_rnsnd_m*(1+drsh_mis)  rend0=r_rend_rnsnd_m*(1+drend_mis)
+ dl=0
+ dw=r_dxw_rnsnd_m*(1+dw_mis)
+ pt=temp
+ pvce1=-7.579e-002 pvce2=1.221e+003 pvce3=-1.997e-001 ptce1=1.375e-003 ptce2=2.75e-006
+ pvcp1=-3.255e-001 pvcp2=-8.84e-006 pvcp3=-2.549 ptcp1=1.662e-003 ptcp2=1.2e-006
+ tface= 1.0+ptce1*(pt-25.0)+ptce2*(pt-25.0)*(pt-25.0)
+ tfacp= 1.0+ptcp1*(pt-25.0)+ptcp2*(pt-25.0)*(pt-25.0)
rend1 ns n2  bsource r=rend0/mf/w/factor*tface*(1+pvce1*(tanh(pvce2*abs(v(ns,n2))+pvce3)-tanh(pvce3)))
r1 ( n2 nm ) bsource r=rsh/mf*(l*factor-dl)/(4.0*(w*factor-dw))*tfacp*(1+pvcp1*(tanh(pvcp2*abs(v(n2,n1)/(l*factor-dl))+pvcp3)-tanh(pvcp3)))
r2 ( nm nn ) bsource r=rsh/mf*(l*factor-dl)/(4.0*(w*factor-dw))*tfacp*(1+pvcp1*(tanh(pvcp2*abs(v(n2,n1)/(l*factor-dl))+pvcp3)-tanh(pvcp3)))
r3 ( nn nx ) bsource r=rsh/mf*(l*factor-dl)/(4.0*(w*factor-dw))*tfacp*(1+pvcp1*(tanh(pvcp2*abs(v(n2,n1)/(l*factor-dl))+pvcp3)-tanh(pvcp3)))
r4 ( nx n1 ) bsource r=rsh/mf*(l*factor-dl)/(4.0*(w*factor-dw))*tfacp*(1+pvcp1*(tanh(pvcp2*abs(v(n2,n1)/(l*factor-dl))+pvcp3)-tanh(pvcp3)))
rend2 ( n1 ne )  bsource r=rend0/mf/w/factor*tface*(1+pvce1*(tanh(pvce2*abs(v(n1,ne))+pvce3)-tanh(pvce3)))
d1 ( body n2 ) _ndio area=mf*((w*factor-dw)*(l*factor-dl)/5.0)  pj= mf*((w*factor-dw)+2.0*(l*factor-dl)/5.0)
d2 ( body nm ) _ndio area=mf*((w*factor-dw)*(l*factor-dl)/5.0)  pj= mf*(2.0*(l*factor-dl)/5.0)
d3 ( body nn ) _ndio area=mf*((w*factor-dw)*(l*factor-dl)/5.0)  pj= mf*(2.0*(l*factor-dl)/5.0)
d4 ( body nx ) _ndio area=mf*((w*factor-dw)*(l*factor-dl)/5.0)  pj= mf*(2.0*(l*factor-dl)/5.0)
d5 ( body n1 ) _ndio area=mf*((w*factor-dw)*(l*factor-dl)/5.0)  pj= mf*((w*factor-dw)+2.0*(l*factor-dl)/5.0)
ends rnsnd_m

//*********************       rnspd_m      P+diff w/o silicide    *********************
subckt cds_ff_mpt_rnspd_m (ns ne body)
parameters l=1e-6 w=1e-6 mf=1 factor=1  mismod=0
+ geo_fac = 1/sqrt(mf*l*factor*w*factor*1e12)
+ drsh_mis = 0.02*geo_fac*fac_r_rnspd_m*mismod
+ dw_mis = 0.01*geo_fac*fac_r_dxw_rnspd_m*mismod
+ drend_mis = 0.01*geo_fac*fac_r_rend_rnspd_m *mismod
+ rsh=r_rnspd_m*(1+drsh_mis)  rend0=r_rend_rnspd_m*(1+drend_mis)
+ dl=0
+ dw=r_dxw_rnspd_m*(1+dw_mis)
+ pt=temp
+ pvce1=3.85e-002 pvce2=2.85e+002 pvce3=-10.92e-002 ptce1=-1.1e-003 ptce2=2.2e-006
+ pvcp1=-4.389e-001 pvcp2=-1.95e-006 pvcp3=-2.3 ptcp1=1.21e-003 ptcp2=4.537e-006
+ tface= 1.0+ptce1*(pt-25.0)+ptce2*(pt-25.0)*(pt-25.0)
+ tfacp= 1.0+ptcp1*(pt-25.0)+ptcp2*(pt-25.0)*(pt-25.0)
rend1 ns n2  bsource r=rend0/mf/w/factor*tface*(1+pvce1*(tanh(pvce2*abs(v(ns,n2))+pvce3)-tanh(pvce3)))
r1 ( n2 nm ) bsource r=rsh/mf*(l*factor-dl)/(4.0*(w*factor-dw))*tfacp*(1+pvcp1*(tanh(pvcp2*abs(v(n2,n1)/(l*factor-dl))+pvcp3)-tanh(pvcp3)))
r2 ( nm nn ) bsource r=rsh/mf*(l*factor-dl)/(4.0*(w*factor-dw))*tfacp*(1+pvcp1*(tanh(pvcp2*abs(v(n2,n1)/(l*factor-dl))+pvcp3)-tanh(pvcp3)))
r3 ( nn nx ) bsource r=rsh/mf*(l*factor-dl)/(4.0*(w*factor-dw))*tfacp*(1+pvcp1*(tanh(pvcp2*abs(v(n2,n1)/(l*factor-dl))+pvcp3)-tanh(pvcp3)))
r4 ( nx n1 ) bsource r=rsh/mf*(l*factor-dl)/(4.0*(w*factor-dw))*tfacp*(1+pvcp1*(tanh(pvcp2*abs(v(n2,n1)/(l*factor-dl))+pvcp3)-tanh(pvcp3)))
rend2 ( n1 ne ) bsource r=rend0/mf/w/factor*tface*(1+pvce1*(tanh(pvce2*abs(v(n1,ne))+pvce3)-tanh(pvce3)))
d1 ( n2 body ) _pdio area=mf*((w*factor-dw)*(l*factor-dl)/5.0)  pj= mf*((w*factor-dw)+2.0*(l*factor-dl)/5.0)
d2 ( nm body ) _pdio area=mf*((w*factor-dw)*(l*factor-dl)/5.0)  pj= mf*(2.0*(l*factor-dl)/5.0)
d3 ( nn body ) _pdio area=mf*((w*factor-dw)*(l*factor-dl)/5.0)  pj= mf*(2.0*(l*factor-dl)/5.0)
d4 ( nx body ) _pdio area=mf*((w*factor-dw)*(l*factor-dl)/5.0)  pj= mf*(2.0*(l*factor-dl)/5.0)
d5 ( n1 body ) _pdio area=mf*((w*factor-dw)*(l*factor-dl)/5.0)  pj= mf*((w*factor-dw)+2.0*(l*factor-dl)/5.0)
ends rnspd_m

//*********************      rnsnp_dis  N+Poly w/o silicide   *********************
subckt cds_ff_mpt_rnsnp_dis (ns ne body)
parameters l=1e-6 w=1e-6 mf=1 factor=1 mismod=0
+ geo_fac = 1/sqrt(mf*l*factor*w*factor*1e12)
+ drsh_mis = 0.02*geo_fac*fac_r_rnsnp_dis*mismod
+ dw_mis = 0.01*geo_fac*fac_r_dxw_rnsnp_dis*mismod
+ drend_mis = 0.01*geo_fac*fac_r_rend_rnsnp_dis*mismod
+ rsh=r_rnsnp_dis*(1+drsh_mis)   rend0=r_rend_rnsnp_dis*(1+drend_mis)
+ dl=0
+ dw=r_dxw_rnsnp_dis*(1+dw_mis)
+ pt=temp
+ pvce1=-2.4e-002 pvce2=-7.138e+002 pvce3=8.259e-001 ptce1=3.3e-003 ptce2=8.8e-006
+ pvcp1=-8.582e-001 pvcp2=-10.703e-005 pvcp3=-2.693 ptcp1=1.95e-004 ptcp2=-6.042e-007
+ tface=1.0+ptce1*(pt-25.0)+ptce2*(pt-25.0)*(pt-25.0)
+ tfacp=1.0+ptcp1*(pt-25.0)+ptcp2*(pt-25.0)*(pt-25.0)
+ ca=1.024e-16 cf=4.477e-17
rend1 ns n2 bsource r=rend0/mf/w/factor*tface*(1+pvce1*(tanh(pvce2*abs(v(ns,n2))+pvce3)-tanh(pvce3)))
r1 ( n2 nm ) bsource r=rsh/mf*(l*factor-dl)/(4.0*(w*factor-dw))*tfacp*(1+pvcp1*(tanh(pvcp2*abs(v(n2,n1)/(l*factor-dl))+pvcp3)-tanh(pvcp3)))
r2 ( nm nn ) bsource r=rsh/mf*(l*factor-dl)/(4.0*(w*factor-dw))*tfacp*(1+pvcp1*(tanh(pvcp2*abs(v(n2,n1)/(l*factor-dl))+pvcp3)-tanh(pvcp3)))
r3 ( nn nx ) bsource r=rsh/mf*(l*factor-dl)/(4.0*(w*factor-dw))*tfacp*(1+pvcp1*(tanh(pvcp2*abs(v(n2,n1)/(l*factor-dl))+pvcp3)-tanh(pvcp3)))
r4 ( nx n1 ) bsource r=rsh/mf*(l*factor-dl)/(4.0*(w*factor-dw))*tfacp*(1+pvcp1*(tanh(pvcp2*abs(v(n2,n1)/(l*factor-dl))+pvcp3)-tanh(pvcp3)))
rend2 ( n1 ne ) bsource r=rend0/mf/w/factor*tface*(1+pvce1*(tanh(pvce2*abs(v(n1,ne))+pvce3)-tanh(pvce3)))
c1 ( body n2 ) capacitor c=mf*(ca*((w*factor-0.02u)*l*factor/5.0)*1e12+2*cf*l*factor/5.0*1e6)
c2 ( body nm ) capacitor c=mf*(ca*((w*factor-0.02u)*l*factor/5.0)*1e12+2*cf*l*factor/5.0*1e6)
c3 ( body nn ) capacitor c=mf*(ca*((w*factor-0.02u)*l*factor/5.0)*1e12+2*cf*l*factor/5.0*1e6)
c4 ( body nx ) capacitor c=mf*(ca*((w*factor-0.02u)*l*factor/5.0)*1e12+2*cf*l*factor/5.0*1e6)
c5 ( body n1 ) capacitor c=mf*(ca*((w*factor-0.02u)*l*factor/5.0)*1e12+2*cf*l*factor/5.0*1e6)
ends rnsnp_dis

//***********************************  rnspp_dis  P+Poly w/o silicide    ***********************************
subckt cds_ff_mpt_rnspp_dis (ns ne body)
parameters l=1e-6 w=1e-6 mf=1 factor=1 mismod=0
+ geo_fac =1/sqrt(mf*l*factor*w*factor*1e12)
+ drsh_mis = 0.02*geo_fac*fac_r_rnspp_dis *mismod
+ dw_mis = 0.01*geo_fac*fac_r_dxw_rnspp_dis*mismod
+ drend_mis = 0.01*geo_fac*fac_r_rend_rnspp_dis*mismod
+ rsh=r_rnspp_dis*(1+drsh_mis) rend0=r_rend_rnspp_dis*(1+drend_mis)
+ dl=0
+ dw=r_dxw_rnspp_dis*(1+dw_mis)
+ pt=temp
+ pvce1=1.140e-002 pvce2=-7.916 pvce3=1.92e-001 ptce1=-8.8e-004 ptce2=-5.5e-006
+ pvcp1=1.2e-003 pvcp2=-2.95e-005 pvcp3=3.37 ptcp1=-2.2e-004 ptcp2=1.106e-006
+ tface= 1.0+ptce1*(pt-25.0)+ptce2*(pt-25.0)*(pt-25.0)
+ tfacp= 1.0+ptcp1*(pt-25.0)+ptcp2*(pt-25.0)*(pt-25.0)
+ ca=1.024e-16 cf=4.477e-17
rend1 ns n2 bsource r=rend0/mf/w/factor*tface*(1+pvce1*(tanh(pvce2*abs(v(ns,n2))+pvce3)-tanh(pvce3)))
r1 ( n2 nm ) bsource r=rsh/mf*(l*factor-dl)/(4.0*(w*factor-dw))*tfacp*(1+pvcp1*(tanh(pvcp2*abs(v(n2,n1)/(l*factor-dl))+pvcp3)-tanh(pvcp3)))
r2 ( nm nn ) bsource r=rsh/mf*(l*factor-dl)/(4.0*(w*factor-dw))*tfacp*(1+pvcp1*(tanh(pvcp2*abs(v(n2,n1)/(l*factor-dl))+pvcp3)-tanh(pvcp3)))
r3 ( nn nx ) bsource r=rsh/mf*(l*factor-dl)/(4.0*(w*factor-dw))*tfacp*(1+pvcp1*(tanh(pvcp2*abs(v(n2,n1)/(l*factor-dl))+pvcp3)-tanh(pvcp3)))
r4 ( nx n1 ) bsource r=rsh/mf*(l*factor-dl)/(4.0*(w*factor-dw))*tfacp*(1+pvcp1*(tanh(pvcp2*abs(v(n2,n1)/(l*factor-dl))+pvcp3)-tanh(pvcp3)))
rend2 ( n1 ne ) bsource r=rend0/mf/w/factor*tface*(1+pvce1*(tanh(pvce2*abs(v(n1,ne))+pvce3)-tanh(pvce3)))
c1 ( body n2 ) capacitor c=mf*(ca*((w*factor-0.02u)*l*factor/5.0)*1e12+2*cf*l*factor/5.0*1e6)
c2 ( body nm ) capacitor c=mf*(ca*((w*factor-0.02u)*l*factor/5.0)*1e12+2*cf*l*factor/5.0*1e6)
c3 ( body nn ) capacitor c=mf*(ca*((w*factor-0.02u)*l*factor/5.0)*1e12+2*cf*l*factor/5.0*1e6)
c4 ( body nx ) capacitor c=mf*(ca*((w*factor-0.02u)*l*factor/5.0)*1e12+2*cf*l*factor/5.0*1e6)
c5 ( body n1 ) capacitor c=mf*(ca*((w*factor-0.02u)*l*factor/5.0)*1e12+2*cf*l*factor/5.0*1e6)
ends rnspp_dis

//  *************************************************************
//                       MODEL OF N+/PW DIODE                   *
//                                                              *
//  *************************************************************

model _ndio diode
+level = 1                     tlev = 1                      tlevc = 1
+imax = 1e40                   minr = 1e-10                  ibv = 0.03
+ik = 8.007637E10              is = 1.985439E-7	             n = 1.241062
+rs = 8.701365E-11	        bv = 9.2                      area = 3.6E-8
+cjo = 1.177208E-3	        vj = 0.5                      m = 0.249998
+fc = 0                        cjsw = 6.561678E-11	     vjsw = 0.73
+mjsw = 9.48645E-3             tnom = 25                     eg = 1.16
+xti = 3                       cta = 8E-4                    ctp = 3.6E-4
+trs = 2.4E-3                  isw = 7.240096E-13	    perim = 7.32E-4
+tbv1 = -1E-3                  pta = 1E-3                    ptp = 1.85E-3
+allow_scaling=1

//  *************************************************************
//                       MODEL OF P+/NW DIODE                   *
//                                                              *
//  *************************************************************

model _pdio diode
+level = 1                     tlev = 1                      tlevc = 1
+imax = 1e40                   minr = 1e-10                  ibv = 0.03
+ik = 1.225265E10              is = 1.657517E-7	             n = 1.223746
+rs = 1.1E-10	               bv = 9.2                      area = 3.6E-8
+cjo = 1.308015E-3	       vj = 0.8                      m = 0.349995
+fc = 0                        cjsw = 7.604536E-11	     vjsw = 0.44
+mjsw = 9.369543E-3            tnom = 25                     eg = 1.17
+xti = 3                       cta = 8E-4                    ctp = 2.4E-4
+trs = 2.4E-3                  isw = 6.075E-13	            perim = 7.32E-4
+tbv1 = -1E-3                  pta = 1.85E-3                 ptp = 1.8E-3
+allow_scaling=1

model nwdio diode
+level = 1                     imax = 1e40                   is = 9.065751E-7
+isw = 9.075E-13               n = 1.243746                  ik = 1.025265E10
+area = 3.6E-8                 perim = 7.32E-4               allow_scaling = 1
+cjo = 1.808015E-3             vj = 0.8                      m = 0.349997
+cjsw = 9.604536E-10           vjsw = 0.44                   mjsw = 9.369543E-3
+fc = 0                        bv = 9.2                      ibv = 0.03
+rs = 6.8E-10                  minr = 1E-10                  tlev = 1
+tlevc = 1                     eg = 1.17                     xti = 3
+tbv1 = -1E-3                  tnom = 25                     trs = 2.4E-3
+cta = 8E-4                    ctp = 2.4E-4                  pta = 1.85E-3
+ptp = 1.8E-3

endsection res_3t

section mc_res
parameters    par_r_rnws             =    var_r_rnws
parameters    par_r_rnwo           =    var_r_rnwo
parameters    par_r_rsnd            =    var_r_rsnd
parameters    par_dxw_rsnd          =    var_dxw_rsnd
parameters    par_r_rspd            =    var_r_rspd
parameters    par_dxw_rspd          =    var_dxw_rspd
parameters    par_r_rsnp            =    var_r_rsnp
parameters    par_dxw_rsnp          =    var_dxw_rsnp
parameters    par_r_rspp            =    var_r_rspp
parameters    par_dxw_rspp          =    var_dxw_rspp
parameters    par_r_rnsnd           =    var_r_rnsnd
parameters    par_rend_rnsnd        =    var_rend_rnsnd
parameters    par_dxw_rnsnd         =    var_dxw_rnsnd
parameters    par_r_rnspd           =    var_r_rnspd
parameters    par_rend_rnspd        =    var_rend_rnspd
parameters    par_dxw_rnspd         =    var_dxw_rnspd
parameters    par_r_rnsnp           =    var_r_rnsnp
parameters    par_rend_rnsnp        =    var_rend_rnsnp
parameters    par_dxw_rnsnp         =    var_dxw_rnsnp
parameters    par_r_rnspp           =    var_r_rnspp
parameters    par_rend_rnspp        =    var_rend_rnspp
parameters    par_dxw_rnspp         =    var_dxw_rnspp
parameters    par_r_resm1                =    var_r_resm1
parameters    par_r_resm2                =    var_r_resm2
parameters    par_r_resm3                =    var_r_resm3
parameters    par_r_resm4                =    var_r_resm4
parameters    par_r_resm5                =    var_r_resm5
parameters    par_r_resm6                =    var_r_resm6
parameters    par_r_resm7                =    var_r_resm7
parameters    par_r_resm8                =    var_r_resm8
parameters    par_r_resm9                =    var_r_resm9
parameters    par_r_resm10               =    var_r_resm10
parameters    par_r_resm11  	           =    var_r_resm11
parameters    par_mm_r_rnws          =    mm_r_rnws
parameters    par_mm_r_rnwo        =    mm_r_rnwo
parameters    par_mm_r_rsnd         =    mm_r_rsnd
parameters    par_mm_dxw_rsnd       =    mm_dxw_rsnd
parameters    par_mm_r_rspd         =    mm_r_rspd
parameters    par_mm_dxw_rspd       =    mm_dxw_rspd
parameters    par_mm_r_rsnp         =    mm_r_rsnp
parameters    par_mm_dxw_rsnp       =    mm_dxw_rsnp
parameters    par_mm_r_rspp         =    mm_r_rspp
parameters    par_mm_dxw_rspp       =    mm_dxw_rspp
parameters    par_mm_r_rnsnd        =    mm_r_rnsnd
parameters    par_mm_rend_rnsnd     =    mm_rend_rnsnd
parameters    par_mm_dxw_rnsnd      =    mm_dxw_rnsnd
parameters    par_mm_r_rnspd        =    mm_r_rnspd
parameters    par_mm_rend_rnspd     =    mm_rend_rnspd
parameters    par_mm_dxw_rnspd      =    mm_dxw_rnspd
parameters    par_mm_r_rnsnp        =    mm_r_rnsnp
parameters    par_mm_rend_rnsnp     =    mm_rend_rnsnp
parameters    par_mm_dxw_rnsnp      =    mm_dxw_rnsnp
parameters    par_mm_r_rnspp        =    mm_r_rnspp
parameters    par_mm_rend_rnspp     =    mm_rend_rnspp
parameters    par_mm_dxw_rnspp      =    mm_dxw_rnspp
parameters    par_mm_r_resm1             =    mm_r_resm1
parameters    par_mm_r_resm2             =    mm_r_resm2
parameters    par_mm_r_resm3             =    mm_r_resm3
parameters    par_mm_r_resm4             =    mm_r_resm4
parameters    par_mm_r_resm5             =    mm_r_resm5
parameters    par_mm_r_resm6             =    mm_r_resm6
parameters    par_mm_r_resm7             =    mm_r_resm7
parameters    par_mm_r_resm8             =    mm_r_resm8
parameters    par_mm_r_resm9             =    mm_r_resm9
parameters    par_mm_r_resm10            =    mm_r_resm10
parameters    par_mm_r_resm11  	         =    mm_r_resm11
parameters    r_rnws                 =  1e3    * (1 + 0.05 *    par_r_rnws          )
parameters    r_rnwo	         =  450    * (1 + 0.05 *    par_r_rnwo        )
parameters    r_rsnd	         =  18     * (1 + 0.05 *    par_r_rsnd         )
parameters    r_dxw_rsnd            = 0.0099u *                par_dxw_rsnd
parameters    r_rspd	         =  15   *   (1 + 0.05 *    par_r_rspd         )
parameters    r_dxw_rspd            =  0.0099u *               par_dxw_rspd
parameters    r_rsnp	         =  15    *  (1 + 0.05 *    par_r_rsnp         )
parameters    r_dxw_rsnp            =  0.0072u *               par_dxw_rsnp
parameters    r_rspp	         =  15    *  (1 + 0.05 *    par_r_rspp         )
parameters    r_dxw_rspp            =  0.0086u *               par_dxw_rspp
parameters    r_rnsnd	         =  100 *    (1 + 0.0375 *  par_r_rnsnd        )
parameters    r_rend_rnsnd          =  8.46e-6 *(1 + 0.45 *    par_rend_rnsnd     )
parameters    r_dxl_rnsnd           =  0+ 0.0u
parameters    r_dxw_rnsnd           =  0.023u *                par_dxw_rnsnd
parameters    r_rnspd	         =  200  *   (1 + 0.0625 *  par_r_rnspd        )
parameters    r_rend_rnspd          =  2.95e-5 *(1 + 0.29 *    par_rend_rnspd     )
parameters    r_dxl_rnspd           =  0 + 0.0u
parameters    r_dxw_rnspd           =  0.021u *                par_dxw_rnspd
parameters    r_rnsnp	         =  200 *    (1 + 0.0375 *  par_r_rnsnp        )
parameters    r_rend_rnsnp          =  1.44e-5* (1 + 0.38 *    par_rend_rnsnp     )
parameters    r_dxl_rnsnp           =  0  + 0.0u
parameters    r_dxw_rnsnp           =  0.018u *                par_dxw_rnsnp
parameters    r_rnspp	         =  600 *    (1 + 0.0375 *  par_r_rnspp        )
parameters    r_rend_rnspp          =  7.015e-6*(1 + 0.27   *  par_rend_rnspp     )
parameters    r_dxl_rnspp           =  0  + 0.0u
parameters    r_dxw_rnspp           =  0.020u *                par_dxw_rnspp
parameters    r_resm1                    =  0.0736 * (1 + 0.05 *    par_r_resm1             )
parameters    r_resm2                    =  0.0604  * (1 + 0.05 *   par_r_resm2             )
parameters    r_resm3                    =  0.0604  * (1 + 0.05 *   par_r_resm3             )
parameters    r_resm4                    =  0.0604  * (1 + 0.05 *   par_r_resm4             )
parameters    r_resm5                    =  0.0604  * (1 + 0.05 *   par_r_resm5             )
parameters    r_resm6                    =  0.0604 * (1 + 0.05 *    par_r_resm6             )
parameters    r_resm7                    =  0.0604 * (1 + 0.05 *    par_r_resm7             )
parameters    r_resm8                    =  0.0214 * (1 + 0.05 *    par_r_resm8             )
parameters    r_resm9                    =  0.0214  * (1 + 0.05 *   par_r_resm9             )
parameters    r_resm10                   =  0.0214  * (1 + 0.05 *   par_r_resm10            )
parameters    r_resm11	                 =  0.021  * (1 + 0.05 *    par_r_resm11            )
parameters    fac_mm_r_rnws          =  0.01*par_mm_r_rnws
parameters    fac_mm_r_rnwo        =  0.01*par_mm_r_rnwo
parameters    fac_mm_r_rsnd         =  0.01*par_mm_r_rsnd
parameters    fac_mm_dxw_rsnd       =  0.01*par_mm_dxw_rsnd
parameters    fac_mm_r_rspd         =  0.01*par_mm_r_rspd
parameters    fac_mm_dxw_rspd       =  0.01*par_mm_dxw_rspd
parameters    fac_mm_r_rsnp         =  0.01*par_mm_r_rsnp
parameters    fac_mm_dxw_rsnp       =  0.01*par_mm_dxw_rsnp
parameters    fac_mm_r_rspp         =  0.01*par_mm_r_rspp
parameters    fac_mm_dxw_rspp       =  0.01*par_mm_dxw_rspp
parameters    fac_mm_r_rnsnd        =  0.01*par_mm_r_rnsnd
parameters    fac_mm_rend_rnsnd     =  0.01*par_mm_rend_rnsnd
parameters    fac_mm_dxw_rnsnd      =  0.01*par_mm_dxw_rnsnd
parameters    fac_mm_r_rnspd        =  0.01*par_mm_r_rnspd
parameters    fac_mm_rend_rnspd     =  0.01*par_mm_rend_rnspd
parameters    fac_mm_dxw_rnspd      =  0.01*par_mm_dxw_rnspd
parameters    fac_mm_r_rnsnp        =  0.01*par_mm_r_rnsnp
parameters    fac_mm_rend_rnsnp     =  0.01*par_mm_rend_rnsnp
parameters    fac_mm_dxw_rnsnp      =  0.01*par_mm_dxw_rnsnp
parameters    fac_mm_r_rnspp        =  0.01*par_mm_r_rnspp
parameters    fac_mm_rend_rnspp     =  0.01*par_mm_rend_rnspp
parameters    fac_mm_dxw_rnspp      =  0.01*par_mm_dxw_rnspp
parameters    fac_mm_r_resm1             =  0.01*par_mm_r_resm1
parameters    fac_mm_r_resm2             =  0.01*par_mm_r_resm2
parameters    fac_mm_r_resm3             =  0.01*par_mm_r_resm3
parameters    fac_mm_r_resm4             =  0.01*par_mm_r_resm4
parameters    fac_mm_r_resm5             =  0.01*par_mm_r_resm5
parameters    fac_mm_r_resm6             =  0.01*par_mm_r_resm6
parameters    fac_mm_r_resm7             =  0.01*par_mm_r_resm7
parameters    fac_mm_r_resm8             =  0.01*par_mm_r_resm8
parameters    fac_mm_r_resm9             =  0.01*par_mm_r_resm9
parameters    fac_mm_r_resm10            =  0.01*par_mm_r_resm10
parameters    fac_mm_r_resm11  	         =  0.01*par_mm_r_resm11

include "cds_ff_mpt_resistor.scs" section=res
include "cds_ff_mpt_resistor.scs" section= stat_res
endsection mc_res

section mc_res_mis
parameters    par_mm_r_rnws          =    mm_r_rnws
parameters    par_mm_r_rnwo        =    mm_r_rnwo
parameters    par_mm_r_rsnd         =    mm_r_rsnd
parameters    par_mm_dxw_rsnd       =    mm_dxw_rsnd
parameters    par_mm_r_rspd         =    mm_r_rspd
parameters    par_mm_dxw_rspd       =    mm_dxw_rspd
parameters    par_mm_r_rsnp         =    mm_r_rsnp
parameters    par_mm_dxw_rsnp       =    mm_dxw_rsnp
parameters    par_mm_r_rspp         =    mm_r_rspp
parameters    par_mm_dxw_rspp       =    mm_dxw_rspp
parameters    par_mm_r_rnsnd        =    mm_r_rnsnd
parameters    par_mm_rend_rnsnd     =    mm_rend_rnsnd
parameters    par_mm_dxw_rnsnd      =    mm_dxw_rnsnd
parameters    par_mm_r_rnspd        =    mm_r_rnspd
parameters    par_mm_rend_rnspd     =    mm_rend_rnspd
parameters    par_mm_dxw_rnspd      =    mm_dxw_rnspd
parameters    par_mm_r_rnsnp        =    mm_r_rnsnp
parameters    par_mm_rend_rnsnp     =    mm_rend_rnsnp
parameters    par_mm_dxw_rnsnp      =    mm_dxw_rnsnp
parameters    par_mm_r_rnspp        =    mm_r_rnspp
parameters    par_mm_rend_rnspp     =    mm_rend_rnspp
parameters    par_mm_dxw_rnspp      =    mm_dxw_rnspp
parameters    par_mm_r_resm1             =    mm_r_resm1
parameters    par_mm_r_resm2             =    mm_r_resm2
parameters    par_mm_r_resm3             =    mm_r_resm3
parameters    par_mm_r_resm4             =    mm_r_resm4
parameters    par_mm_r_resm5             =    mm_r_resm5
parameters    par_mm_r_resm6             =    mm_r_resm6
parameters    par_mm_r_resm7             =    mm_r_resm7
parameters    par_mm_r_resm8             =    mm_r_resm8
parameters    par_mm_r_resm9             =    mm_r_resm9
parameters    par_mm_r_resm10            =    mm_r_resm10
parameters    par_mm_r_resm11  	         =    mm_r_resm11
parameters    fac_mm_r_rnws          =  0.01*par_mm_r_rnws
parameters    fac_mm_r_rnwo        =  0.01*par_mm_r_rnwo
parameters    fac_mm_r_rsnd         =  0.01*par_mm_r_rsnd
parameters    fac_mm_dxw_rsnd       =  0.01*par_mm_dxw_rsnd
parameters    fac_mm_r_rspd         =  0.01*par_mm_r_rspd
parameters    fac_mm_dxw_rspd       =  0.01*par_mm_dxw_rspd
parameters    fac_mm_r_rsnp         =  0.01*par_mm_r_rsnp
parameters    fac_mm_dxw_rsnp       =  0.01*par_mm_dxw_rsnp
parameters    fac_mm_r_rspp         =  0.01*par_mm_r_rspp
parameters    fac_mm_dxw_rspp       =  0.01*par_mm_dxw_rspp
parameters    fac_mm_r_rnsnd        =  0.01*par_mm_r_rnsnd
parameters    fac_mm_rend_rnsnd     =  0.01*par_mm_rend_rnsnd
parameters    fac_mm_dxw_rnsnd      =  0.01*par_mm_dxw_rnsnd
parameters    fac_mm_r_rnspd        =  0.01*par_mm_r_rnspd
parameters    fac_mm_rend_rnspd     =  0.01*par_mm_rend_rnspd
parameters    fac_mm_dxw_rnspd      =  0.01*par_mm_dxw_rnspd
parameters    fac_mm_r_rnsnp        =  0.01*par_mm_r_rnsnp
parameters    fac_mm_rend_rnsnp     =  0.01*par_mm_rend_rnsnp
parameters    fac_mm_dxw_rnsnp      =  0.01*par_mm_dxw_rnsnp
parameters    fac_mm_r_rnspp        =  0.01*par_mm_r_rnspp
parameters    fac_mm_rend_rnspp     =  0.01*par_mm_rend_rnspp
parameters    fac_mm_dxw_rnspp      =  0.01*par_mm_dxw_rnspp
parameters    fac_mm_r_resm1             =  0.01*par_mm_r_resm1
parameters    fac_mm_r_resm2             =  0.01*par_mm_r_resm2
parameters    fac_mm_r_resm3             =  0.01*par_mm_r_resm3
parameters    fac_mm_r_resm4             =  0.01*par_mm_r_resm4
parameters    fac_mm_r_resm5             =  0.01*par_mm_r_resm5
parameters    fac_mm_r_resm6             =  0.01*par_mm_r_resm6
parameters    fac_mm_r_resm7             =  0.01*par_mm_r_resm7
parameters    fac_mm_r_resm8             =  0.01*par_mm_r_resm8
parameters    fac_mm_r_resm9             =  0.01*par_mm_r_resm9
parameters    fac_mm_r_resm10            =  0.01*par_mm_r_resm10
parameters    fac_mm_r_resm11  	         =  0.01*par_mm_r_resm11

include "cds_ff_mpt_resistor.scs" section= stat_res
endsection mc_res_mis

section stat_res
parameters      random_r_rnws        = 0
parameters      random_r_rnwo      = 0
parameters      random_r_rsnd       = 0
parameters      random_dxw_rsnd     = 0
parameters      random_r_rspd       = 0
parameters      random_dxw_rspd     = 0
parameters      random_r_rsnp       = 0
parameters      random_dxw_rsnp     = 0
parameters      random_r_rspp       = 0
parameters      random_dxw_rspp     = 0
parameters      random_r_rnsnd      = 0
parameters      random_rend_rnsnd   = 0
parameters      random_dxw_rnsnd    = 0
parameters      random_r_rnspd      = 0
parameters      random_rend_rnspd   = 0
parameters      random_dxw_rnspd    = 0
parameters      random_r_rnsnp      = 0
parameters      random_rend_rnsnp   = 0
parameters      random_dxw_rnsnp    = 0
parameters      random_r_rnspp      = 0
parameters      random_rend_rnspp   = 0
parameters      random_dxw_rnspp    = 0
parameters      random_r_resm1           = 0
parameters      random_r_resm2           = 0
parameters      random_r_resm3           = 0
parameters      random_r_resm4           = 0
parameters      random_r_resm5           = 0
parameters      random_r_resm6           = 0
parameters      random_r_resm7           = 0
parameters      random_r_resm8           = 0
parameters      random_r_resm9           = 0
parameters      random_r_resm10          = 0
parameters      random_r_resm11          = 0
parameters      mis_r_rnws           = 0
parameters      mis_r_rnwo         = 0
parameters      mis_r_rsnd          = 0
parameters      mis_dxw_rsnd        = 0
parameters      mis_r_rspd          = 0
parameters      mis_dxw_rspd        = 0
parameters      mis_r_rsnp          = 0
parameters      mis_dxw_rsnp        = 0
parameters      mis_r_rspp          = 0
parameters      mis_dxw_rspp        = 0
parameters      mis_r_rnsnd         = 0
parameters      mis_rend_rnsnd      = 0
parameters      mis_dxw_rnsnd       = 0
parameters      mis_r_rnspd         = 0
parameters      mis_rend_rnspd      = 0
parameters      mis_dxw_rnspd       = 0
parameters      mis_r_rnsnp         = 0
parameters      mis_rend_rnsnp      = 0
parameters      mis_dxw_rnsnp       = 0
parameters      mis_r_rnspp         = 0
parameters      mis_rend_rnspp      = 0
parameters      mis_dxw_rnspp       = 0
parameters      mis_r_resm1              = 0
parameters      mis_r_resm2              = 0
parameters      mis_r_resm3              = 0
parameters      mis_r_resm4              = 0
parameters      mis_r_resm5              = 0
parameters      mis_r_resm6              = 0
parameters      mis_r_resm7              = 0
parameters      mis_r_resm8              = 0
parameters      mis_r_resm9              = 0
parameters      mis_r_resm10             = 0
parameters      mis_r_resm11             = 0
parameters     var_r_rnws            =     random_r_rnws
parameters     var_r_rnwo          =     random_r_rnwo
parameters     var_r_rsnd           =     random_r_rsnd
parameters     var_dxw_rsnd         =     random_dxw_rsnd
parameters     var_r_rspd           =     random_r_rspd
parameters     var_dxw_rspd         =     random_dxw_rspd
parameters     var_r_rsnp           =     random_r_rsnp
parameters     var_dxw_rsnp         =     random_dxw_rsnp
parameters     var_r_rspp           =     random_r_rspp
parameters     var_dxw_rspp         =     random_dxw_rspp
parameters     var_r_rnsnd          =     random_r_rnsnd
parameters     var_rend_rnsnd       =     random_rend_rnsnd
parameters     var_dxw_rnsnd        =     random_dxw_rnsnd
parameters     var_r_rnspd          =     random_r_rnspd
parameters     var_rend_rnspd       =     random_rend_rnspd
parameters     var_dxw_rnspd        =     random_dxw_rnspd
parameters     var_r_rnsnp          =     random_r_rnsnp
parameters     var_rend_rnsnp       =     random_rend_rnsnp
parameters     var_dxw_rnsnp        =     random_dxw_rnsnp
parameters     var_r_rnspp          =     random_r_rnspp
parameters     var_rend_rnspp       =     random_rend_rnspp
parameters     var_dxw_rnspp        =     random_dxw_rnspp
parameters     var_r_resm1               =     random_r_resm1
parameters     var_r_resm2               =     random_r_resm2
parameters     var_r_resm3               =     random_r_resm3
parameters     var_r_resm4               =     random_r_resm4
parameters     var_r_resm5               =     random_r_resm5
parameters     var_r_resm6               =     random_r_resm6
parameters     var_r_resm7               =     random_r_resm7
parameters     var_r_resm8               =     random_r_resm8
parameters     var_r_resm9               =     random_r_resm9
parameters     var_r_resm10              =     random_r_resm10
parameters     var_r_resm11  	           =     random_r_resm11
parameters     mm_r_rnws             =     mis_r_rnws
parameters     mm_r_rnwo           =     mis_r_rnwo
parameters     mm_r_rsnd            =     mis_r_rsnd
parameters     mm_dxw_rsnd          =     mis_dxw_rsnd
parameters     mm_r_rspd            =     mis_r_rspd
parameters     mm_dxw_rspd          =     mis_dxw_rspd
parameters     mm_r_rsnp            =     mis_r_rsnp
parameters     mm_dxw_rsnp          =     mis_dxw_rsnp
parameters     mm_r_rspp            =     mis_r_rspp
parameters     mm_dxw_rspp          =     mis_dxw_rspp
parameters     mm_r_rnsnd           =     mis_r_rnsnd
parameters     mm_rend_rnsnd        =     mis_rend_rnsnd
parameters     mm_dxw_rnsnd         =     mis_dxw_rnsnd
parameters     mm_r_rnspd           =     mis_r_rnspd
parameters     mm_rend_rnspd        =     mis_rend_rnspd
parameters     mm_dxw_rnspd         =     mis_dxw_rnspd
parameters     mm_r_rnsnp           =     mis_r_rnsnp
parameters     mm_rend_rnsnp        =     mis_rend_rnsnp
parameters     mm_dxw_rnsnp         =     mis_dxw_rnsnp
parameters     mm_r_rnspp           =     mis_r_rnspp
parameters     mm_rend_rnspp        =     mis_rend_rnspp
parameters     mm_dxw_rnspp         =     mis_dxw_rnspp
parameters     mm_r_resm1                =     mis_r_resm1
parameters     mm_r_resm2                =     mis_r_resm2
parameters     mm_r_resm3                =     mis_r_resm3
parameters     mm_r_resm4                =     mis_r_resm4
parameters     mm_r_resm5                =     mis_r_resm5
parameters     mm_r_resm6                =     mis_r_resm6
parameters     mm_r_resm7                =     mis_r_resm7
parameters     mm_r_resm8                =     mis_r_resm8
parameters     mm_r_resm9                =     mis_r_resm9
parameters     mm_r_resm10               =     mis_r_resm10
parameters     mm_r_resm11  	           =     mis_r_resm11

statistics {
   process {
            vary    random_r_rnws               dist=gauss std=1/1
            vary    random_r_rnwo             dist=gauss std=1/1
            vary    random_r_rsnd              dist=gauss std=1/1
            vary    random_dxw_rsnd            dist=gauss std=1/1
            vary    random_r_rspd              dist=gauss std=1/1
            vary    random_dxw_rspd            dist=gauss std=1/1
            vary    random_r_rsnp              dist=gauss std=1/1
            vary    random_dxw_rsnp            dist=gauss std=1/1
            vary    random_r_rspp              dist=gauss std=1/1
            vary    random_dxw_rspp            dist=gauss std=1/1
            vary    random_r_rnsnd             dist=gauss std=1/1
            vary    random_rend_rnsnd          dist=gauss std=1/1
            vary    random_dxw_rnsnd           dist=gauss std=1/1
            vary    random_r_rnspd             dist=gauss std=1/1
            vary    random_rend_rnspd          dist=gauss std=1/1
            vary    random_dxw_rnspd           dist=gauss std=1/1
            vary    random_r_rnsnp             dist=gauss std=1/1
            vary    random_rend_rnsnp          dist=gauss std=1/1
            vary    random_dxw_rnsnp           dist=gauss std=1/1
            vary    random_r_rnspp             dist=gauss std=1/1
            vary    random_rend_rnspp          dist=gauss std=1/1
            vary    random_dxw_rnspp           dist=gauss std=1/1
            vary    random_r_resm1                  dist=gauss std=1/1
            vary    random_r_resm2                  dist=gauss std=1/1
            vary    random_r_resm3                  dist=gauss std=1/1
            vary    random_r_resm4                  dist=gauss std=1/1
            vary    random_r_resm5                  dist=gauss std=1/1
            vary    random_r_resm6                  dist=gauss std=1/1
            vary    random_r_resm7                  dist=gauss std=1/1
            vary    random_r_resm8                  dist=gauss std=1/1
            vary    random_r_resm9                  dist=gauss std=1/1
            vary    random_r_resm10                 dist=gauss std=1/1
            vary    random_r_resm11                 dist=gauss std=1/1
        }
   mismatch {
            vary    mis_r_rnws               dist=gauss std=1/1
            vary    mis_r_rnwo             dist=gauss std=1/1
            vary    mis_r_rsnd              dist=gauss std=1/1
            vary    mis_dxw_rsnd            dist=gauss std=1/1
            vary    mis_r_rspd              dist=gauss std=1/1
            vary    mis_dxw_rspd            dist=gauss std=1/1
            vary    mis_r_rsnp              dist=gauss std=1/1
            vary    mis_dxw_rsnp            dist=gauss std=1/1
            vary    mis_r_rspp              dist=gauss std=1/1
            vary    mis_dxw_rspp            dist=gauss std=1/1
            vary    mis_r_rnsnd             dist=gauss std=1/1
            vary    mis_rend_rnsnd          dist=gauss std=1/1
            vary    mis_dxw_rnsnd           dist=gauss std=1/1
            vary    mis_r_rnspd             dist=gauss std=1/1
            vary    mis_rend_rnspd          dist=gauss std=1/1
            vary    mis_dxw_rnspd           dist=gauss std=1/1
            vary    mis_r_rnsnp             dist=gauss std=1/1
            vary    mis_rend_rnsnp          dist=gauss std=1/1
            vary    mis_dxw_rnsnp           dist=gauss std=1/1
            vary    mis_r_rnspp             dist=gauss std=1/1
            vary    mis_rend_rnspp          dist=gauss std=1/1
            vary    mis_dxw_rnspp           dist=gauss std=1/1
            vary    mis_r_resm1                  dist=gauss std=1/1
            vary    mis_r_resm2                  dist=gauss std=1/1
            vary    mis_r_resm3                  dist=gauss std=1/1
            vary    mis_r_resm4                  dist=gauss std=1/1
            vary    mis_r_resm5                  dist=gauss std=1/1
            vary    mis_r_resm6                  dist=gauss std=1/1
            vary    mis_r_resm7                  dist=gauss std=1/1
            vary    mis_r_resm8                  dist=gauss std=1/1
            vary    mis_r_resm9                  dist=gauss std=1/1
            vary    mis_r_resm10                 dist=gauss std=1/1
            vary    mis_r_resm11                 dist=gauss std=1/1
        }
    }
endsection stat_res

section mc_res3
parameters      par_r_rnws_m            =    var_r_rnws_m
parameters      par_r_rnwo_m          =    var_r_rnwo_m
parameters      par_r_rsnd_m           =    var_r_rsnd_m
parameters      par_r_rspd_m           =    var_r_rspd_m
parameters      par_r_rsnp_dis         =    var_r_rsnp_dis
parameters      par_r_rspp_dis         =    var_r_rspp_dis
parameters      par_r_rnsnd_m          =    var_r_rnsnd_m
parameters      par_rend_rnsnd_m       =    var_rend_rnsnd_m
parameters      par_dxw_rnsnd_m        =    var_dxw_rnsnd_m
parameters      par_r_rnspd_m          =    var_r_rnspd_m
parameters      par_rend_rnspd_m       =    var_rend_rnspd_m
parameters      par_dxw_rnspd_m        =    var_dxw_rnspd_m
parameters      par_r_rnsnp_dis        =    var_r_rnsnp_dis
parameters      par_rend_rnsnp_dis     =    var_rend_rnsnp_dis
parameters      par_dxw_rnsnp_dis      =    var_dxw_rnsnp_dis
parameters      par_r_rnspp_dis        =    var_r_rnspp_dis
parameters      par_rend_rnspp_dis     =    var_rend_rnspp_dis
parameters      par_dxw_rnspp_dis      =    var_dxw_rnspp_dis
parameters      par_mis_r_rnws_m            =    mm_r_rnws_m
parameters      par_mis_r_rnwo_m          =    mm_r_rnwo_m
parameters      par_mis_r_rsnd_m           =    mm_r_rsnd_m
parameters      par_mis_r_rspd_m           =    mm_r_rspd_m
parameters      par_mis_r_rsnp_dis         =    mm_r_rsnp_dis
parameters      par_mis_r_rspp_dis         =    mm_r_rspp_dis
parameters      par_mis_r_rnsnd_m          =    mm_r_rnsnd_m
parameters      par_mis_rend_rnsnd_m       =    mm_rend_rnsnd_m
parameters      par_mis_dxw_rnsnd_m        =    mm_dxw_rnsnd_m
parameters      par_mis_r_rnspd_m          =    mm_r_rnspd_m
parameters      par_mis_rend_rnspd_m       =    mm_rend_rnspd_m
parameters      par_mis_dxw_rnspd_m        =    mm_dxw_rnspd_m
parameters      par_mis_r_rnsnp_dis        =    mm_r_rnsnp_dis
parameters      par_mis_rend_rnsnp_dis     =    mm_rend_rnsnp_dis
parameters      par_mis_dxw_rnsnp_dis      =    mm_dxw_rnsnp_dis
parameters      par_mis_r_rnspp_dis        =    mm_r_rnspp_dis
parameters      par_mis_rend_rnspp_dis     =    mm_rend_rnspp_dis
parameters      par_mis_dxw_rnspp_dis      =    mm_dxw_rnspp_dis
parameters      r_rnws_m                =   1000    * (1 + 0.05   *  par_r_rnws_m        )
parameters      r_rnwo_m              =   450     * (1 + 0.05   *  par_r_rnwo_m      )
parameters      r_rsnd_m               =   18      * (1 + 0.05   *  par_r_rsnd_m       )
parameters      r_rspd_m               =   15      * (1 + 0.05   *  par_r_rspd_m       )
parameters      r_rsnp_dis             =   15      * (1 + 0.05   *  par_r_rsnp_dis     )
parameters      r_rspp_dis             =    15     * (1 + 0.05   *  par_r_rspp_dis     )
parameters      r_rnsnd_m              =   100     * (1 + 0.0375 *  par_r_rnsnd_m      )
parameters      r_rend_rnsnd_m           =   8.46u   * (1 +  0.45  *  par_rend_rnsnd_m   )
parameters      r_dxl_rnsnd_m            =   0
parameters      r_dxw_rnsnd_m            =   0.027u                *  par_dxw_rnsnd_m
parameters      r_rnspd_m              =   200     * (1 + 0.0625 *  par_r_rnspd_m      )
parameters      r_rend_rnspd_m           =   29.5u   * (1 + 0.29   *  par_rend_rnspd_m   )
parameters      r_dxl_rnspd_m            =   0  + 0.0u
parameters      r_dxw_rnspd_m            =   0.03071u              *  par_dxw_rnspd_m
parameters      r_rnsnp_dis            =    200    * (1 + 0.0375 *  par_r_rnsnp_dis    )
parameters      r_rend_rnsnp_dis         =   14.4u   * (1 + 0.38   *  par_rend_rnsnp_dis )
parameters      r_dxl_rnsnp_dis          =   0     + 0.0u
parameters      r_dxw_rnsnp_dis          =   0.0936u               *  par_dxw_rnsnp_dis
parameters      r_rnspp_dis            =   650     * (1 + 0.0375 *  par_r_rnspp_dis    )
parameters      r_rend_rnspp_dis         =   86.7u   * (1 + 0.27   *  par_rend_rnspp_dis )
parameters      r_dxl_rnspp_dis          =   0  + 0.0u
parameters      r_dxw_rnspp_dis          =   0.0689u
parameters      fac_r_rnws_m             =   0.01*par_mis_r_rnws_m
parameters      fac_r_rnwo_m           =   0.01*par_mis_r_rnwo_m
parameters      fac_r_rsnd_m            =   0.01*par_mis_r_rsnd_m
parameters      fac_r_rspd_m            =   0.01*par_mis_r_rspd_m
parameters      fac_r_rsnp_dis          =   0.01*par_mis_r_rsnp_dis
parameters      fac_r_rspp_dis          =   0.01*par_mis_r_rspp_dis
parameters      fac_r_rnsnd_m           =   0.01*par_mis_r_rnsnd_m
parameters      fac_r_rend_rnsnd_m      =   0.01*par_mis_rend_rnsnd_m
parameters      fac_r_dxw_rnsnd_m       =   0.01*par_mis_dxw_rnsnd_m
parameters      fac_r_rnspd_m           =   0.01*par_mis_r_rnspd_m
parameters      fac_r_rend_rnspd_m      =   0.01*par_mis_rend_rnspd_m
parameters      fac_r_dxw_rnspd_m       =   0.01*par_mis_dxw_rnspd_m
parameters      fac_r_rnsnp_dis         =   0.01*par_mis_r_rnsnp_dis
parameters      fac_r_rend_rnsnp_dis    =   0.01*par_mis_rend_rnsnp_dis
parameters      fac_r_dxw_rnsnp_dis     =   0.01*par_mis_dxw_rnsnp_dis
parameters      fac_r_rnspp_dis         =   0.01*par_mis_r_rnspp_dis
parameters      fac_r_rend_rnspp_dis    =   0.01*par_mis_rend_rnspp_dis
parameters      fac_r_dxw_rnspp_dis         =   0.01*par_mis_dxw_rnspp_dis

include "cds_ff_mpt_resistor.scs" section=res_3t
include "cds_ff_mpt_resistor.scs" section= stat_res3

endsection mc_res3

section mc_res3_mis
parameters      par_mis_r_rnws_m            =    mm_r_rnws_m
parameters      par_mis_r_rnwo_m          =    mm_r_rnwo_m
parameters      par_mis_r_rsnd_m           =    mm_r_rsnd_m
parameters      par_mis_r_rspd_m           =    mm_r_rspd_m
parameters      par_mis_r_rsnp_dis         =    mm_r_rsnp_dis
parameters      par_mis_r_rspp_dis         =    mm_r_rspp_dis
parameters      par_mis_r_rnsnd_m          =    mm_r_rnsnd_m
parameters      par_mis_rend_rnsnd_m       =    mm_rend_rnsnd_m
parameters      par_mis_dxw_rnsnd_m        =    mm_dxw_rnsnd_m
parameters      par_mis_r_rnspd_m          =    mm_r_rnspd_m
parameters      par_mis_rend_rnspd_m       =    mm_rend_rnspd_m
parameters      par_mis_dxw_rnspd_m        =    mm_dxw_rnspd_m
parameters      par_mis_r_rnsnp_dis        =    mm_r_rnsnp_dis
parameters      par_mis_rend_rnsnp_dis     =    mm_rend_rnsnp_dis
parameters      par_mis_dxw_rnsnp_dis      =    mm_dxw_rnsnp_dis
parameters      par_mis_r_rnspp_dis        =    mm_r_rnspp_dis
parameters      par_mis_rend_rnspp_dis     =    mm_rend_rnspp_dis
parameters      par_mis_dxw_rnspp_dis      =    mm_dxw_rnspp_dis
parameters      fac_r_rnws_m             =   0.01*par_mis_r_rnws_m
parameters      fac_r_rnwo_m           =   0.01*par_mis_r_rnwo_m
parameters      fac_r_rsnd_m            =   0.01*par_mis_r_rsnd_m
parameters      fac_r_rspd_m            =   0.01*par_mis_r_rspd_m
parameters      fac_r_rsnp_dis          =   0.01*par_mis_r_rsnp_dis
parameters      fac_r_rspp_dis          =   0.01*par_mis_r_rspp_dis
parameters      fac_r_rnsnd_m           =   0.01*par_mis_r_rnsnd_m
parameters      fac_r_rend_rnsnd_m      =   0.01*par_mis_rend_rnsnd_m
parameters      fac_r_dxw_rnsnd_m       =   0.01*par_mis_dxw_rnsnd_m
parameters      fac_r_rnspd_m           =   0.01*par_mis_r_rnspd_m
parameters      fac_r_rend_rnspd_m      =   0.01*par_mis_rend_rnspd_m
parameters      fac_r_dxw_rnspd_m       =   0.01*par_mis_dxw_rnspd_m
parameters      fac_r_rnsnp_dis         =   0.01*par_mis_r_rnsnp_dis
parameters      fac_r_rend_rnsnp_dis    =   0.01*par_mis_rend_rnsnp_dis
parameters      fac_r_dxw_rnsnp_dis     =   0.01*par_mis_dxw_rnsnp_dis
parameters      fac_r_rnspp_dis         =   0.01*par_mis_r_rnspp_dis
parameters      fac_r_rend_rnspp_dis    =   0.01*par_mis_rend_rnspp_dis
parameters      fac_r_dxw_rnspp_dis         =   0.01*par_mis_dxw_rnspp_dis

include "cds_ff_mpt_resistor.scs" section= stat_res3

endsection mc_res3_mis

section stat_res3
parameters                 radom_r_rnws_m               =     0
parameters                 random_r_rnwo_m            =     0
parameters                 random_r_rsnd_m             =     0
parameters                 random_r_rspd_m             =     0
parameters                 random_r_rsnp_dis           =     0
parameters                 random_r_rspp_dis           =     0
parameters                 random_r_rnsnd_m            =     0
parameters                 random_rend_rnsnd_m         =     0
parameters                 random_dxw_rnsnd_m          =     0
parameters                 random_r_rnspd_m            =     0
parameters                 random_rend_rnspd_m         =     0
parameters                 random_dxw_rnspd_m          =     0
parameters                 random_r_rnsnp_dis          =     0
parameters                 random_rend_rnsnp_dis       =     0
parameters                 random_dxw_rnsnp_dis        =     0
parameters                 random_r_rnspp_dis          =     0
parameters                 random_rend_rnspp_dis       =     0
parameters                 random_dxw_rnspp_dis        =     0
parameters                 mis_r_rnws_m                 =     0
parameters                 mis_r_rnwo_m               =     0
parameters                 mis_r_rsnd_m                =     0
parameters                 mis_r_rspd_m                =     0
parameters                 mis_r_rsnp_dis              =     0
parameters                 mis_r_rspp_dis              =     0
parameters                 mis_r_rnsnd_m               =     0
parameters                 mis_rend_rnsnd_m            =     0
parameters                 mis_dxw_rnsnd_m             =     0
parameters                 mis_r_rnspd_m               =     0
parameters                 mis_rend_rnspd_m            =     0
parameters                 mis_dxw_rnspd_m             =     0
parameters                 mis_r_rnsnp_dis             =     0
parameters                 mis_rend_rnsnp_dis          =     0
parameters                 mis_dxw_rnsnp_dis           =     0
parameters                 mis_r_rnspp_dis             =     0
parameters                 mis_rend_rnspp_dis          =     0
parameters                 mis_dxw_rnspp_dis           =     0
parameters                var_r_rnws_m          =     radom_r_rnws_m
parameters                var_r_rnwo_m        =     random_r_rnwo_m
parameters                var_r_rsnd_m         =     random_r_rsnd_m
parameters                var_r_rspd_m         =     random_r_rspd_m
parameters                var_r_rsnp_dis       =     random_r_rsnp_dis
parameters                var_r_rspp_dis       =     random_r_rspp_dis
parameters                var_r_rnsnd_m        =     random_r_rnsnd_m
parameters                var_rend_rnsnd_m     =     random_rend_rnsnd_m
parameters                var_dxw_rnsnd_m      =     random_dxw_rnsnd_m
parameters                var_r_rnspd_m        =     random_r_rnspd_m
parameters                var_rend_rnspd_m     =     random_rend_rnspd_m
parameters                var_dxw_rnspd_m      =     random_dxw_rnspd_m
parameters                var_r_rnsnp_dis      =     random_r_rnsnp_dis
parameters                var_rend_rnsnp_dis   =     random_rend_rnsnp_dis
parameters                var_dxw_rnsnp_dis    =     random_dxw_rnsnp_dis
parameters                var_r_rnspp_dis      =     random_r_rnspp_dis
parameters                var_rend_rnspp_dis   =     random_rend_rnspp_dis
parameters                var_dxw_rnspp_dis    =     random_dxw_rnspp_dis
parameters                mm_r_rnws_m           =     mis_r_rnws_m
parameters                mm_r_rnwo_m         =     mis_r_rnwo_m
parameters                mm_r_rsnd_m          =     mis_r_rsnd_m
parameters                mm_r_rspd_m          =     mis_r_rspd_m
parameters                mm_r_rsnp_dis        =     mis_r_rsnp_dis
parameters                mm_r_rspp_dis        =     mis_r_rspp_dis
parameters                mm_r_rnsnd_m         =     mis_r_rnsnd_m
parameters                mm_rend_rnsnd_m      =     mis_rend_rnsnd_m
parameters                mm_dxw_rnsnd_m       =     mis_dxw_rnsnd_m
parameters                mm_r_rnspd_m         =     mis_r_rnspd_m
parameters                mm_rend_rnspd_m      =     mis_rend_rnspd_m
parameters                mm_dxw_rnspd_m       =     mis_dxw_rnspd_m
parameters                mm_r_rnsnp_dis       =     mis_r_rnsnp_dis
parameters                mm_rend_rnsnp_dis    =     mis_rend_rnsnp_dis
parameters                mm_dxw_rnsnp_dis     =     mis_dxw_rnsnp_dis
parameters                mm_r_rnspp_dis       =     mis_r_rnspp_dis
parameters                mm_rend_rnspp_dis    =     mis_rend_rnspp_dis
parameters                mm_dxw_rnspp_dis     =     mis_dxw_rnspp_dis
statistics {
    process {
            vary      radom_r_rnws_m              dist=gauss std=1/1
            vary      random_r_rnwo_m           dist=gauss std=1/1
            vary      random_r_rsnd_m            dist=gauss std=1/1
            vary      random_r_rspd_m            dist=gauss std=1/1
            vary      random_r_rsnp_dis          dist=gauss std=1/1
            vary      random_r_rspp_dis          dist=gauss std=1/1
            vary      random_r_rnsnd_m           dist=gauss std=1/1
            vary      random_rend_rnsnd_m        dist=gauss std=1/1
            vary      random_dxw_rnsnd_m         dist=gauss std=1/1
            vary      random_r_rnspd_m           dist=gauss std=1/1
            vary      random_rend_rnspd_m        dist=gauss std=1/1
            vary      random_dxw_rnspd_m         dist=gauss std=1/1
            vary      random_r_rnsnp_dis         dist=gauss std=1/1
            vary      random_rend_rnsnp_dis      dist=gauss std=1/1
            vary      random_dxw_rnsnp_dis       dist=gauss std=1/1
            vary      random_r_rnspp_dis         dist=gauss std=1/1
            vary      random_rend_rnspp_dis      dist=gauss std=1/1
            vary      random_dxw_rnspp_dis       dist=gauss std=1/1
        }
    mismatch {
            vary      mis_r_rnws_m              dist=gauss std=1/1
            vary      mis_r_rnwo_m           dist=gauss std=1/1
            vary      mis_r_rsnd_m            dist=gauss std=1/1
            vary      mis_r_rspd_m            dist=gauss std=1/1
            vary      mis_r_rsnp_dis          dist=gauss std=1/1
            vary      mis_r_rspp_dis          dist=gauss std=1/1
            vary      mis_r_rnsnd_m           dist=gauss std=1/1
            vary      mis_rend_rnsnd_m        dist=gauss std=1/1
            vary      mis_dxw_rnsnd_m         dist=gauss std=1/1
            vary      mis_r_rnspd_m           dist=gauss std=1/1
            vary      mis_rend_rnspd_m        dist=gauss std=1/1
            vary      mis_dxw_rnspd_m         dist=gauss std=1/1
            vary      mis_r_rnsnp_dis         dist=gauss std=1/1
            vary      mis_rend_rnsnp_dis      dist=gauss std=1/1
            vary      mis_dxw_rnsnp_dis       dist=gauss std=1/1
            vary      mis_r_rnspp_dis         dist=gauss std=1/1
            vary      mis_rend_rnspp_dis      dist=gauss std=1/1
            vary      mis_dxw_rnspp_dis       dist=gauss std=1/1
        }

    }
endsection stat_res3

endlibrary cds_ff_mpt
