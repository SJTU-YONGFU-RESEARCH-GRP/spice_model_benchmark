// ****************************************************************************
// 		          Advance Node PDK / Generic models
//
//  Copyright (c) 2014
//  Cadence Design Systems, Inc.  All rights reserved.
//
// These models represent a pseudo-process and are intended to be use
// for demonstration purpose only.
//
// CDN20 Corner Definitions
// This is an example file showing how to define corners
// using model files for individual components as the
// building blocks.
// Author/contact - Jim McMahon (james@cadence.com)
// *****************************************************************************
//

simulator lang=spectre
library cds_ff_mpt

section tt
include "cds_ff_mpt_mosfet.scs" section=tt
include "cds_ff_mpt_mosfet.scs" section=tt_hvt
include "cds_ff_mpt_mosfet.scs" section=tt_lvt
include "cds_ff_mpt_mosfet.scs" section=tt_18
include "cds_ff_mpt_diode.scs" section=tt_dio
include "cds_ff_mpt_diode.scs" section=tt_dio_hvt
include "cds_ff_mpt_diode.scs" section=tt_dio_lvt
include "cds_ff_mpt_diode.scs" section=tt_dio_18
include "cds_ff_mpt_bipolar.scs" section=tt_bjt_npn
include "cds_ff_mpt_mimcap.scs" section=tt_mim
include "cds_ff_mpt_resistor.scs" section=tt_res
include "cds_ff_mpt_resistor.scs" section=tt_res3
endsection tt

section ff
include "cds_ff_mpt_mosfet.scs" section=ff
include "cds_ff_mpt_mosfet.scs" section=ff_hvt
include "cds_ff_mpt_mosfet.scs" section=ff_lvt
include "cds_ff_mpt_mosfet.scs" section=ff_18
include "cds_ff_mpt_diode.scs" section=ff_dio
include "cds_ff_mpt_diode.scs" section=ff_dio_hvt
include "cds_ff_mpt_diode.scs" section=ff_dio_lvt
include "cds_ff_mpt_diode.scs" section=ff_dio_18
include "cds_ff_mpt_bipolar.scs" section=ff_bjt_npn
include "cds_ff_mpt_mimcap.scs" section=ff_mim
include "cds_ff_mpt_resistor.scs" section=ff_res
include "cds_ff_mpt_resistor.scs" section=ff_res3
endsection ff

section ss
include "cds_ff_mpt_mosfet.scs" section=ss
include "cds_ff_mpt_mosfet.scs" section=ss_hvt
include "cds_ff_mpt_mosfet.scs" section=ss_lvt
include "cds_ff_mpt_mosfet.scs" section=ss_18
include "cds_ff_mpt_diode.scs" section=ss_dio
include "cds_ff_mpt_diode.scs" section=ss_dio_hvt
include "cds_ff_mpt_diode.scs" section=ss_dio_lvt
include "cds_ff_mpt_diode.scs" section=ss_dio_18
include "cds_ff_mpt_bipolar.scs" section=ss_bjt_npn
include "cds_ff_mpt_mimcap.scs" section=ss_mim
include "cds_ff_mpt_resistor.scs" section=ss_res
include "cds_ff_mpt_resistor.scs" section=ss_res3
endsection ss

section fs
include "cds_ff_mpt_mosfet.scs" section=fs
include "cds_ff_mpt_mosfet.scs" section=fs_hvt
include "cds_ff_mpt_mosfet.scs" section=fs_lvt
include "cds_ff_mpt_mosfet.scs" section=fs_18
include "cds_ff_mpt_diode.scs" section=ss_dio
include "cds_ff_mpt_diode.scs" section=ss_dio_hvt
include "cds_ff_mpt_diode.scs" section=ss_dio_lvt
include "cds_ff_mpt_diode.scs" section=ss_dio_18
include "cds_ff_mpt_bipolar.scs" section=ss_bjt_npn
include "cds_ff_mpt_mimcap.scs" section=ss_mim
include "cds_ff_mpt_resistor.scs" section=ss_res
include "cds_ff_mpt_resistor.scs" section=ss_res3
endsection fs

section sf
include "cds_ff_mpt_mosfet.scs" section=sf
include "cds_ff_mpt_mosfet.scs" section=sf_hvt
include "cds_ff_mpt_mosfet.scs" section=sf_lvt
include "cds_ff_mpt_mosfet.scs" section=sf_18
include "cds_ff_mpt_diode.scs" section=ss_dio
include "cds_ff_mpt_diode.scs" section=ss_dio_hvt
include "cds_ff_mpt_diode.scs" section=ss_dio_lvt
include "cds_ff_mpt_diode.scs" section=ss_dio_18
include "cds_ff_mpt_bipolar.scs" section=ss_bjt_npn
include "cds_ff_mpt_mimcap.scs" section=ss_mim
include "cds_ff_mpt_resistor.scs" section=ss_res
include "cds_ff_mpt_resistor.scs" section=ss_res3
endsection sf

section mc
include "cds_ff_mpt_mosfet.scs" section=stat
include "cds_ff_mpt_mosfet.scs" section=mc
include "cds_ff_mpt_mosfet.scs" section=mc_hvt
include "cds_ff_mpt_mosfet.scs" section=mc_lvt
include "cds_ff_mpt_mosfet.scs" section=mc_18
include "cds_ff_mpt_diode.scs" section=mc_dio
include "cds_ff_mpt_diode.scs" section=mc_dio_hvt
include "cds_ff_mpt_diode.scs" section=mc_dio_lvt
include "cds_ff_mpt_diode.scs" section=mc_dio_18
include "cds_ff_mpt_bipolar.scs" section=mc_bjt_npn
include "cds_ff_mpt_mimcap.scs" section=mc_mim
include "cds_ff_mpt_resistor.scs" section=mc_res
include "cds_ff_mpt_resistor.scs" section=mc_res3
endsection mc

endlibrary cds_ff_mpt
