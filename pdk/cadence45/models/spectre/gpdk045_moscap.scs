simulator lang=spectre
library  gpdk045
//  ******************************************************************************
//  ****************************************************************************
//                                                                             *
//        THIS MODEL LIB CONTAINS :                                            *
//                                                                             *
//        1.LIB TTCAP							       *
//              FFCAP							       *
//		SSCAP							       *
//		FSCAP							       *
//		SFCAP							       *
//		MCCAP                                               	       *
//    ( 1.1V Standard-Vt devices with different geometric,statistical, mimatch *
//	     and corner models. )					       *
//                                                                             *
//        5.LIB TTCAP_18                                                          *
//	        FFCAP_18                                                          *
//	        SSCAP_18                                                          *
//	        FSCAP_18                                                          *
//	        SFCAP_18                                                          *
//	        MCCAP_18                                                          *
//    ( 1.8V devices with different geometric, statistical, mismatch and       *
//	     corner models.  )    		               		       *

section  ttcap
parameters
+tox_n_cap = 2.41E-9                       dxl_n_cap = 0
+dxw_n_cap = 0                     dvth0_n_cap = 0                   dlvth0_n_cap = 0
+dwvth0_n_cap = 0                  dpvth0_n_cap = 0                  du0_n_cap = 0
+dlu0_n_cap = 0                    dwu0_n_cap = 0                    dpu0_n_cap = 0
+dvsat_n_cap = 0                   dcj_n_cap = 0                     dcjsw_n_cap = 0
+dcjswg_n_cap = 0                  dcgso_n_cap = 0                   dcgdo_n_cap = 0
+dcgsl_n_cap = 0                   dcgdl_n_cap = 0
+tox_p_cap = 2.4E-9                     dvth0_p_cap = 0                   dlvth0_p_cap = 0
+dwvth0_p_cap = 0                  dpvth0_p_cap = 0                  dxl_p_cap = 0
+dxw_p_cap = 0                     du0_p_cap = 0                     dlu0_p_cap = 0
+dwu0_p_cap = 0                    dpu0_p_cap = 0                    dvsat_p_cap = 0
+dcj_p_cap = 0                     dcjsw_p_cap = 0                   dcjswg_p_cap = 0
+dcgso_p_cap = 0                   dcgdo_p_cap = 0                   dcgsl_p_cap = 0
+dcgdl_p_cap = 0
include "gpdk045_moscap.scs"   section = moscap
include "gpdk045_moscap.scs"   section = s1v_mac
endsection  ttcap

section  ffcap
parameters
+tox_n_cap = 2.37E-9               dxl_n_cap = -4.4E-9
+dxw_n_cap = 9E-9                  dvth0_n_cap = -0.035              dlvth0_n_cap = -6.4E-10
+dwvth0_n_cap = -3.58E-9           dpvth0_n_cap = -1.18E-16          du0_n_cap = 6E-5
+dlu0_n_cap = -8.1E-11             dwu0_n_cap = -2.2E-11             dpu0_n_cap = -3.84E-18
+dvsat_n_cap = 0                   dcj_n_cap = -5.682E-5             dcjsw_n_cap = -3.2142E-12
+dcjswg_n_cap = -1.6896E-11        dcgso_n_cap = 4.98E-12            dcgdo_n_cap = 4.98E-12
+dcgsl_n_cap = 1.539E-12           dcgdl_n_cap = 1.539E-12
+tox_p_cap = 2.36E-9               dvth0_p_cap = 0.0292              dlvth0_p_cap = 9E-10
+dwvth0_p_cap = 2.6E-9             dpvth0_p_cap = 8.7E-17            dxl_p_cap = -4.4E-9
+dxw_p_cap = 9E-9                  du0_p_cap = 6.8E-4                dlu0_p_cap = -7.8E-11
+dwu0_p_cap = 2E-12                dpu0_p_cap = -1.34E-17            dvsat_p_cap = 0
+dcj_p_cap = -6.5868E-5            dcjsw_p_cap = -4.098E-12          dcjswg_p_cap = -1.6698E-11
+dcgso_p_cap = 2.79E-12            dcgdo_p_cap = 2.79E-12            dcgsl_p_cap = 4.86E-12
+dcgdl_p_cap = 4.86E-12
include "gpdk045_moscap.scs"   section = moscap
include "gpdk045_moscap.scs"   section = s1v_mac
endsection  ffcap

section  sscap
parameters
+tox_n_cap = 2.45E-9               dxl_n_cap = 4.4E-9
+dxw_n_cap = -9E-9                 dvth0_n_cap = 0.036               dlvth0_n_cap = 8.42E-10
+dwvth0_n_cap = 2.976E-9           dpvth0_n_cap = 1.18E-16           du0_n_cap = -2.07E-4
+dlu0_n_cap = 1.172E-10            dwu0_n_cap = -6.33E-11            dpu0_n_cap = 9.342E-18
+dvsat_n_cap = 0                   dcj_n_cap = 5.682E-5              dcjsw_n_cap = 3.2142E-12
+dcjswg_n_cap = 1.6896E-11         dcgso_n_cap = -4.98E-12           dcgdo_n_cap = -4.98E-12
+dcgsl_n_cap = -1.539E-12          dcgdl_n_cap = -1.539E-12
+tox_p_cap = 2.44E-9               dvth0_p_cap = -0.029              dlvth0_p_cap = -1.04E-9
+dwvth0_p_cap = -1.9E-9            dpvth0_p_cap = -9E-17             dxl_p_cap = 4.4E-9
+dxw_p_cap = -9E-9                 du0_p_cap = -9.6E-4               dlu0_p_cap = 1.18E-10
+dwu0_p_cap = -1.22E-10            dpu0_p_cap = 1.97E-17             dvsat_p_cap = 0
+dcj_p_cap = 6.5868E-5             dcjsw_p_cap = 4.098E-12           dcjswg_p_cap = 1.6698E-11
+dcgso_p_cap = -2.79E-12           dcgdo_p_cap = -2.79E-12           dcgsl_p_cap = -4.86E-12
+dcgdl_p_cap = -4.86E-12
include "gpdk045_moscap.scs"   section = moscap
include "gpdk045_moscap.scs"   section = s1v_mac
endsection  sscap

section  fscap
parameters
+tox_n_cap = 2.41E-9               dxl_n_cap = 0
+dxw_n_cap = 0                     dvth0_n_cap = -0.0175             dlvth0_n_cap = -4.13744E-10
+dwvth0_n_cap = -1.271456E-9       dpvth0_n_cap = -4.57276E-17       du0_n_cap = 7E-5
+dlu0_n_cap = -2.1E-11             dwu0_n_cap = 7.641E-11            dpu0_n_cap = -7.68E-19
+dvsat_n_cap = 0                   dcj_n_cap = -5.682E-5             dcjsw_n_cap = -3.2142E-12
+dcjswg_n_cap = -1.6896E-11        dcgso_n_cap = 0                   dcgdo_n_cap = 0
+dcgsl_n_cap = 0                   dcgdl_n_cap = 0
+tox_p_cap = 2.4E-9                dvth0_p_cap = -0.0145             dlvth0_p_cap = -3.8E-10
+dwvth0_p_cap = -9.5E-10           dpvth0_p_cap = -9E-18             dxl_p_cap = 0
+dxw_p_cap = 0                     du0_p_cap = -4.8E-4               dlu0_p_cap = 3.5E-11
+dwu0_p_cap = -1.27E-10            dpu0_p_cap = -8.2E-18             dvsat_p_cap = 0
+dcj_p_cap = 6.5868E-5             dcjsw_p_cap = 4.098E-12           dcjswg_p_cap = 1.6698E-11
+dcgso_p_cap = 0                   dcgdo_p_cap = 0                   dcgsl_p_cap = 0
+dcgdl_p_cap = 0
include "gpdk045_moscap.scs"   section = moscap
include "gpdk045_moscap.scs"   section = s1v_mac
endsection  fscap

section  sfcap
parameters
+tox_n_cap = 2.41E-9               dxl_n_cap = 0
+dxw_n_cap = 0                     dvth0_n_cap = 0.018               dlvth0_n_cap = 3.61E-10
+dwvth0_n_cap = 1.088E-9           dpvth0_n_cap = 5.1E-17            du0_n_cap = -1.0825E-4
+dlu0_n_cap = 1.86E-11             dwu0_n_cap = -1.023E-10           dpu0_n_cap = 1.67232E-18
+dvsat_n_cap = 0                   dcj_n_cap = 5.682E-5              dcjsw_n_cap = 3.2142E-12
+dcjswg_n_cap = 1.6896E-11         dcgso_n_cap = 0                   dcgdo_n_cap = 0
+dcgsl_n_cap = 0                   dcgdl_n_cap = 0
+tox_p_cap = 2.4E-9                dvth0_p_cap = 0.0136              dlvth0_p_cap = 4.6E-10
+dwvth0_p_cap = 1.2E-9             dpvth0_p_cap = 2.55E-17           dxl_p_cap = 0
+dxw_p_cap = 0                     du0_p_cap = 4.6E-4                dlu0_p_cap = -4E-11
+dwu0_p_cap = 8.948E-11            dpu0_p_cap = -1.4E-18             dvsat_p_cap = 0
+dcj_p_cap = -6.5868E-5            dcjsw_p_cap = -4.098E-12          dcjswg_p_cap = -1.6698E-11
+dcgso_p_cap = 0                   dcgdo_p_cap = 0                   dcgsl_p_cap = 0
+dcgdl_p_cap = 0
include "gpdk045_moscap.scs"   section = moscap
include "gpdk045_moscap.scs"   section = s1v_mac
endsection  sfcap

section mccap
parameters
+random1_cap = 0                   random2_cap = 0                   random3_cap = 0
+random4_cap = 0
statistics {
    process {
        vary random1_cap dist=gauss std=1/1
        vary random2_cap dist=gauss std=1/1
        vary random3_cap dist=gauss std=1/1
        vary random4_cap dist=gauss std=1/1
        }
    }
parameters
+a1_cap = random1_cap                  a2_cap = random2_cap
+a3_cap = random3_cap                  a4_cap = random4_cap

parameters
+tox_n_cap = 2.41e-9-3.4e-13*a1_cap-1.1903e-11*a2_cap-5.1e-13*a3_cap+5.7697e-12*a4_cap
+dxl_n_cap = 0-3.1e-11*a1_cap-1.4e-9*a2_cap-1.405e-10*a3_cap+3.7e-10*a4_cap
+dxw_n_cap = 0+1.8797e-10*a1_cap+2.7e-9*a2_cap-9.5e-10*a3_cap-2.3e-10*a4_cap
+dvth0_n_cap = 0-6.3e-3*a1_cap-4.9519e-3*a2_cap+6.3164e-3*a3_cap+3.8623e-3*a4_cap
+dlvth0_n_cap = 0-6.89e-11*a1_cap-1.83e-10*a2_cap+2.4158e-10*a3_cap-7.5252e-11*a4_cap
+dwvth0_n_cap = 0-2.9703e-10*a1_cap-5.39e-11*a2_cap+7.373e-10*a3_cap+3.3967e-10*a4_cap
+dpvth0_n_cap = 0-4.32e-17*a1_cap+4.786e-18*a2_cap+1.49e-17*a3_cap+2.8e-17*a4_cap
+du0_n_cap = 0+8e-5*a1_cap-4.848e-5*a2_cap-7.86e-5*a3_cap+2.8e-17*a4_cap
+dlu0_n_cap = 0-2.1e-12*a1_cap-2.7e-11*a2_cap+1.48e-11*a3_cap-1.1e-12*a4_cap
+dwu0_n_cap = 0-1.13e-11*a1_cap+1.4e-11*a2_cap-3.62e-11*a3_cap-3e-12*a4_cap
+dpu0_n_cap = 0+5e-19*a1_cap-2.4e-19*a2_cap+3.751e-18*a3_cap-3.4e-19*a4_cap
+dvsat_n_cap = 0+0*a1_cap+0*a2_cap+0*a3_cap+0*a4_cap
+dcgso_n_cap = -0.1245*(-3.4e-13*a1_cap-1.1903e-11*a2_cap-5.1e-13*a3_cap+5.7697e-12*a4_cap)
+dcgdo_n_cap = -0.1245*(-3.4e-13*a1_cap-1.1903e-11*a2_cap-5.1e-13*a3_cap+5.7697e-12*a4_cap)
+dcgsl_n_cap = -0.0385*(-3.4e-13*a1_cap-1.1903e-11*a2_cap-5.1e-13*a3_cap+5.7697e-12*a4_cap)
+dcgdl_n_cap = -0.0385*(-3.4e-13*a1_cap-1.1903e-11*a2_cap-5.1e-13*a3_cap+5.7697e-12*a4_cap)
+dcj_n_cap = 1.14e-5*a1_cap-5.2e-6*a2_cap-1.31e-5*a3_cap+1.34e-6*a4_cap
+dcjsw_n_cap = 5.66e-8*(1.14e-5*a1_cap-5.2e-6*a2_cap-1.31e-5*a3_cap+1.34e-6*a4_cap)
+dcjswg_n_cap = 2.975e-7*(1.14e-5*a1_cap-5.2e-6*a2_cap-1.31e-5*a3_cap+1.34e-6*a4_cap)
+tox_p_cap = 2.4e-9-3.4e-13*a1_cap-1.1903e-11*a2_cap-5.1e-13*a3_cap+5.7697e-12*a4_cap
+dxl_p_cap = 0-3.1e-11*a1_cap-1.4e-9*a2_cap-1.405e-10*a3_cap+3.7e-10*a4_cap
+dxw_p_cap = 0+1.8797e-10*a1_cap+2.7e-9*a2_cap-9.5e-10*a3_cap-2.3e-10*a4_cap
+dvth0_p_cap = 0-5.50872e-3*a1_cap-3.06696e-3*a2_cap+5.860787e-3*a3_cap+3.048809e-3*a4_cap
+dlvth0_p_cap = 0-2.9e-11*a1_cap-1.7e-10*a2_cap+2.158e-10*a3_cap-7.5252e-11*a4_cap
+dwvth0_p_cap = 0-2.003e-10*a1_cap-6.539e-10*a2_cap+2.073e-10*a3_cap+3.0967e-10*a4_cap
+dpvth0_p_cap = 0-4.8e-18*a1_cap+4.786e-18*a2_cap+2.9e-18*a3_cap+2.8e-17*a4_cap
+du0_p_cap = 0-1.61018e-4*a1_cap-4.05e-4*a2_cap-4.1196e-6*a3_cap+2.8e-17*a4_cap
+dlu0_p_cap = 0+2.5e-11*a1_cap+2.053e-11*a2_cap+8e-13*a3_cap+2e-12*a4_cap
+dwu0_p_cap = 0-7.13e-11*a1_cap-8.154e-11*a2_cap-2e-13*a3_cap+3.1e-11*a4_cap
+dpu0_p_cap = 0+9.98e-19*a1_cap-6.921e-18*a2_cap-2.1e-19*a3_cap-1.94e-18*a4_cap
+dvsat_p_cap = 0+0*a1_cap+0*a2_cap+0*a3_cap+0*a4_cap
+dcgso_p_cap = -0.06975*(-3.4e-13*a1_cap-1.1903e-11*a2_cap-5.1e-13*a3_cap+5.7697e-12*a4_cap)
+dcgdo_p_cap = -0.06975*(-3.4e-13*a1_cap-1.1903e-11*a2_cap-5.1e-13*a3_cap+5.7697e-12*a4_cap)
+dcgsl_p_cap = -0.1215*(-3.4e-13*a1_cap-1.1903e-11*a2_cap-5.1e-13*a3_cap+5.7697e-12*a4_cap)
+dcgdl_p_cap = -0.1215*(-3.4e-13*a1_cap-1.1903e-11*a2_cap-5.1e-13*a3_cap+5.7697e-12*a4_cap)
+dcj_p_cap = 1.443e-5*a1_cap-5.55e-6*a2_cap-1.42e-5*a3_cap+9.4e-7*a4_cap
+dcjsw_p_cap = 6.22e-8*(1.443e-5*a1_cap-5.55e-6*a2_cap-1.42e-5*a3_cap+9.4e-7*a4_cap)
+dcjswg_p_cap = 2.536e-7*(1.443e-5*a1_cap-5.55e-6*a2_cap-1.42e-5*a3_cap+9.4e-7*a4_cap)
include "gpdk045_moscap.scs"   section = moscap
include "gpdk045_moscap.scs"   section = s1v_mac
endsection mccap

section  ttcap_18
parameters
+tox_n_18_cap = 3.62E-9                                 dxl_n_18_cap = 0
+dxw_n_18_cap = 0                  dvth0_n_18_cap = 0                dlvth0_n_18_cap = 0
+dwvth0_n_18_cap = 0               dpvth0_n_18_cap = 0               du0_n_18_cap = 0
+dlu0_n_18_cap = 0                 dwu0_n_18_cap = 0                 dpu0_n_18_cap = 0
+dvsat_n_18_cap = 0                dcj_n_18_cap = 0                  dcjsw_n_18_cap = 0
+dcjswg_n_18_cap = 0               dcgso_n_18_cap = 0                dcgdo_n_18_cap = 0
+dcgsl_n_18_cap = 0                dcgdl_n_18_cap = 0
+tox_p_18_cap = 3.62E-9                  dxl_p_18_cap = 0                  dxw_p_18_cap = 0
+dvth0_p_18_cap = 0                dlvth0_p_18_cap = 0               dwvth0_p_18_cap = 0
+dpvth0_p_18_cap = 0               du0_p_18_cap = 0                  dlu0_p_18_cap = 0
+dwu0_p_18_cap = 0                 dpu0_p_18_cap = 0                 dvsat_p_18_cap = 0
+dcj_p_18_cap = 0                  dcjsw_p_18_cap = 0                dcjswg_p_18_cap = 0
+dcgso_p_18_cap = 0                dcgdo_p_18_cap = 0                dcgsl_p_18_cap = 0
+dcgdl_p_18_cap = 0
include "gpdk045_moscap.scs"   section = moscap18
include "gpdk045_moscap.scs"   section = s1p8v_mac
endsection  ttcap_18

section  ffcap_18
parameters
+tox_n_18_cap = 3.49E-9            dxl_n_18_cap = -9E-9
+dxw_n_18_cap = 9E-9               dvth0_n_18_cap = -0.0374          dlvth0_n_18_cap = -4E-9
+dwvth0_n_18_cap = -6.6E-9         dpvth0_n_18_cap = -2.5E-16        du0_n_18_cap = 1.26E-3
+dlu0_n_18_cap = -3.44E-10         dwu0_n_18_cap = 4.6E-11           dpu0_n_18_cap = 4E-18
+dvsat_n_18_cap = 0                dcj_n_18_cap = -5.55E-5           dcjsw_n_18_cap = -6.732E-12
+dcjswg_n_18_cap = -7.92E-12       dcgso_n_18_cap = 2.817E-12        dcgdo_n_18_cap = 2.817E-12
+dcgsl_n_18_cap = 2.43E-12         dcgdl_n_18_cap = 2.43E-12
+tox_p_18_cap = 3.49E-9            dxl_p_18_cap = -9E-9              dxw_p_18_cap = 9E-9
+dvth0_p_18_cap = 0.03594          dlvth0_p_18_cap = 4.12E-9         dwvth0_p_18_cap = 2.8E-9
+dpvth0_p_18_cap = 1.7232E-16      du0_p_18_cap = 1.44E-3            dlu0_p_18_cap = -2.28E-10
+dwu0_p_18_cap = 2.4E-11           dpu0_p_18_cap = 8E-18             dvsat_p_18_cap = 0
+dcj_p_18_cap = -6.402E-5          dcjsw_p_18_cap = -7.26E-12        dcjswg_p_18_cap = -1.518E-11
+dcgso_p_18_cap = 1.98E-12         dcgdo_p_18_cap = 1.98E-12         dcgsl_p_18_cap = 9E-12
+dcgdl_p_18_cap = 9E-12
include "gpdk045_moscap.scs"   section = moscap18
include "gpdk045_moscap.scs"   section = s1p8v_mac
endsection  ffcap_18

section  sscap_18
parameters
+tox_n_18_cap = 3.75E-9            dxl_n_18_cap = 9E-9
+dxw_n_18_cap = -9E-9              dvth0_n_18_cap = 0.0346           dlvth0_n_18_cap = 4.08E-9
+dwvth0_n_18_cap = 6.4E-9          dpvth0_n_18_cap = 2.214E-16       du0_n_18_cap = -1.802E-3
+dlu0_n_18_cap = 2.62E-10          dwu0_n_18_cap = -2.2E-10          dpu0_n_18_cap = -7.3E-18
+dvsat_n_18_cap = 0                dcj_n_18_cap = 5.55E-5            dcjsw_n_18_cap = 6.732E-12
+dcjswg_n_18_cap = 7.92E-12        dcgso_n_18_cap = -2.817E-12       dcgdo_n_18_cap = -2.817E-12
+dcgsl_n_18_cap = -2.43E-12        dcgdl_n_18_cap = -2.43E-12
+tox_p_18_cap = 3.75E-9            dxl_p_18_cap = 9E-9               dxw_p_18_cap = -9E-9
+dvth0_p_18_cap = -0.034           dlvth0_p_18_cap = -3.6E-9         dwvth0_p_18_cap = -2.4E-9
+dpvth0_p_18_cap = -3.56E-16       du0_p_18_cap = -1.8E-3            dlu0_p_18_cap = 1.13E-10
+dwu0_p_18_cap = -1.08E-10         dpu0_p_18_cap = 1E-17             dvsat_p_18_cap = 0
+dcj_p_18_cap = 6.402E-5           dcjsw_p_18_cap = 7.26E-12         dcjswg_p_18_cap = 1.518E-11
+dcgso_p_18_cap = -1.98E-12        dcgdo_p_18_cap = -1.98E-12        dcgsl_p_18_cap = -9E-12
+dcgdl_p_18_cap = -9E-12
include "gpdk045_moscap.scs"   section = moscap18
include "gpdk045_moscap.scs"   section = s1p8v_mac
endsection  sscap_18

section  fscap_18
parameters
+tox_n_18_cap = 3.62E-9            dxl_n_18_cap = 0
+dxw_n_18_cap = 0                  dvth0_n_18_cap = -0.0187          dlvth0_n_18_cap = -2E-9
+dwvth0_n_18_cap = -2.9E-9         dpvth0_n_18_cap = -3.5E-17        du0_n_18_cap = 8E-4
+dlu0_n_18_cap = 0                 dwu0_n_18_cap = 1.8E-10           dpu0_n_18_cap = 5.264E-17
+dvsat_n_18_cap = 0                dcj_n_18_cap = -5.55E-5           dcjsw_n_18_cap = -6.732E-12
+dcjswg_n_18_cap = -7.92E-12       dcgso_n_18_cap = 0                dcgdo_n_18_cap = 0
+dcgsl_n_18_cap = 0                dcgdl_n_18_cap = 0
+tox_p_18_cap = 3.62E-9            dxl_p_18_cap = 0                  dxw_p_18_cap = 0
+dvth0_p_18_cap = -0.017           dlvth0_p_18_cap = -1.2E-9         dwvth0_p_18_cap = -1.3E-9
+dpvth0_p_18_cap = -1.86E-16       du0_p_18_cap = -8.6E-4            dlu0_p_18_cap = -7.3E-11
+dwu0_p_18_cap = -1.28E-10         dpu0_p_18_cap = 3E-19             dvsat_p_18_cap = 0
+dcj_p_18_cap = 6.402E-5           dcjsw_p_18_cap = 7.26E-12         dcjswg_p_18_cap = 1.518E-11
+dcgso_p_18_cap = 0                dcgdo_p_18_cap = 0                dcgsl_p_18_cap = 0
+dcgdl_p_18_cap = 0
include "gpdk045_moscap.scs"   section = moscap18
include "gpdk045_moscap.scs"   section = s1p8v_mac
endsection  fscap_18

section  sfcap_18
parameters
+tox_n_18_cap = 3.62E-9            dxl_n_18_cap = 0
+dxw_n_18_cap = 0                  dvth0_n_18_cap = 0.0166           dlvth0_n_18_cap = 1.44E-9
+dwvth0_n_18_cap = 3.2E-9          dpvth0_n_18_cap = 1.507E-16       du0_n_18_cap = -9.72E-4
+dlu0_n_18_cap = -9E-11            dwu0_n_18_cap = -2.08E-10         dpu0_n_18_cap = -1.7E-17
+dvsat_n_18_cap = 0                dcj_n_18_cap = 5.55E-5            dcjsw_n_18_cap = 6.732E-12
+dcjswg_n_18_cap = 7.92E-12        dcgso_n_18_cap = 0                dcgdo_n_18_cap = 0
+dcgsl_n_18_cap = 0                dcgdl_n_18_cap = 0
+tox_p_18_cap = 3.62E-9            dxl_p_18_cap = 0                  dxw_p_18_cap = 0
+dvth0_p_18_cap = 0.01797          dlvth0_p_18_cap = 2.22E-9         dwvth0_p_18_cap = 1.3E-9
+dpvth0_p_18_cap = -4E-17          du0_p_18_cap = 7.4E-4             dlu0_p_18_cap = -2.9E-11
+dwu0_p_18_cap = 1.158E-10         dpu0_p_18_cap = 3.744E-17         dvsat_p_18_cap = 0
+dcj_p_18_cap = -6.402E-5          dcjsw_p_18_cap = -7.26E-12        dcjswg_p_18_cap = -1.518E-11
+dcgso_p_18_cap = 0                dcgdo_p_18_cap = 0                dcgsl_p_18_cap = 0
+dcgdl_p_18_cap = 0
include "gpdk045_moscap.scs"   section = moscap18
include "gpdk045_moscap.scs"   section = s1p8v_mac
endsection  sfcap_18

section mccap_18
parameters
+random13_cap = 0                   random14_cap = 0                   random15_cap = 0
+random16_cap = 0
statistics {
    process {

        vary random13_cap dist=gauss std=1/1
        vary random14_cap dist=gauss std=1/1
        vary random15_cap dist=gauss std=1/1
        vary random16_cap dist=gauss std=1/1
        }
    }
parameters
+a13_cap = random13_cap                  a14_cap = random14_cap
+a15_cap = random15_cap                  a16_cap = random16_cap
+tox_n_18_cap = 3.62e-9-4.216e-13*a13_cap-4.118364e-11*a14_cap-6.633e-13*a15_cap+1.186255e-11*a16_cap
+dxl_n_18_cap = 0-5.0716e-10*a13_cap-2.88e-9*a14_cap-3.3158e-10*a15_cap+5.5e-10*a16_cap
+dxw_n_18_cap = 0+2.81955e-10*a13_cap+2e-9*a14_cap-9.5e-10*a15_cap-2.0444e-9*a16_cap
+dvth0_n_18_cap = 0-6.3e-3*a13_cap-5.19e-3*a14_cap+7.3164e-3*a15_cap+3.8623e-3*a16_cap
+dlvth0_n_18_cap = 0-9.0589e-10*a13_cap-1.046e-9*a14_cap+2.4158e-10*a15_cap-7.5252e-11*a16_cap
+dwvth0_n_18_cap = 0-7.9703e-10*a13_cap-2.49e-10*a14_cap+1.57373e-9*a15_cap+1.33967e-9*a16_cap
+dpvth0_n_18_cap = 0-1.8e-18*a13_cap+1.04786e-16*a14_cap+2.49e-16*a15_cap+2.8e-17*a16_cap
+du0_n_18_cap = 0+6.12e-4*a13_cap+9.8e-5*a14_cap-1.26e-4*a15_cap+2.8e-17*a16_cap
+dlu0_n_18_cap = 0-9.834e-11*a13_cap+3e-13*a14_cap+8.8e-12*a15_cap+2e-11*a16_cap
+dwu0_n_18_cap = 0+6.73e-11*a13_cap+8e-12*a14_cap-3.62e-11*a15_cap-3e-12*a16_cap
+dpu0_n_18_cap = 0+5e-19*a13_cap-9.14e-18*a14_cap-2.93e-17*a15_cap-9.4e-19*a16_cap
+dvsat_n_18_cap = 0+0*a13_cap+0*a14_cap+0*a15_cap+0*a16_cap
+dcgso_n_18_cap = -0.02167*(-4.216e-13*a13_cap-4.118364e-11*a14_cap-6.633e-13*a15_cap+1.186255e-11*a16_cap)
+dcgdo_n_18_cap = -0.02167*(-4.216e-13*a13_cap-4.118364e-11*a14_cap-6.633e-13*a15_cap+1.186255e-11*a16_cap)
+dcgsl_n_18_cap = -0.01876*(-4.216e-13*a13_cap-4.118364e-11*a14_cap-6.633e-13*a15_cap+1.186255e-11*a16_cap)
+dcgdl_n_18_cap = -0.01876*(-4.216e-13*a13_cap-4.118364e-11*a14_cap-6.633e-13*a15_cap+1.186255e-11*a16_cap)
+dcj_n_18_cap = 1.1e-5*a13_cap-5.1e-6*a14_cap-1.293e-5*a15_cap+1.34e-6*a16_cap
+dcjsw_n_18_cap = 1.2126e-7*(1.1e-5*a13_cap-5.1e-6*a14_cap-1.293e-5*a15_cap+1.34e-6*a16_cap)
+dcjswg_n_18_cap = 1.426e-7*(1.1e-5*a13_cap-5.1e-6*a14_cap-1.293e-5*a15_cap+1.34e-6*a16_cap)
+tox_p_18_cap = 2.4e-9-6.528e-13*a13_cap-4.04702e-11*a14_cap-5.1e-13*a15_cap-1.038546e-11*a16_cap
+dxl_p_18_cap = 0-3.1e-11*a13_cap-2.928e-9*a14_cap-6.744e-11*a15_cap+3.774e-10*a16_cap
+dxw_p_18_cap = 0+1.8797e-10*a13_cap+2.5e-9*a14_cap-1.437e-9*a15_cap-2.3e-10*a16_cap
+dvth0_p_18_cap = 0+0.0114*a13_cap-4.9519e-3*a14_cap+5.64e-3*a15_cap+3.8623e-3*a16_cap
+dlvth0_p_18_cap = 0-1.0589e-10*a13_cap-1.35e-9*a14_cap+2.4158e-10*a15_cap-7.5252e-11*a16_cap
+dwvth0_p_18_cap = 0-1.703e-10*a13_cap+3.39e-11*a14_cap+1.63e-9*a15_cap+3.3967e-10*a16_cap
+dpvth0_p_18_cap = 0-1.58e-17*a13_cap+1.5986e-17*a14_cap+2.949e-16*a15_cap+2.8e-17*a16_cap
+du0_p_18_cap = 0+2.4e-4*a13_cap-3.3e-4*a14_cap+2.86e-5*a15_cap+2.8e-17*a16_cap
+dlu0_p_18_cap = 0+9.1e-12*a13_cap-2.7e-11*a14_cap+1.88e-11*a15_cap+4.8e-11*a16_cap
+dwu0_p_18_cap = 0+8.26e-11*a13_cap-7.02e-11*a14_cap+1.3e-10*a15_cap-3e-12*a16_cap
+dpu0_p_18_cap = 0+8.7e-18*a13_cap+8.4e-19*a14_cap-1.41e-18*a15_cap-4.94e-18*a16_cap
+dvsat_p_18_cap = 0+0*a13_cap+0*a14_cap+0*a15_cap+0*a16_cap
+dcgso_p_18_cap = -0.01535*(-6.528e-13*a13_cap-4.04702e-11*a14_cap-5.1e-13*a15_cap-1.038546e-11*a16_cap)
+dcgdo_p_18_cap = -0.01535*(-6.528e-13*a13_cap-4.04702e-11*a14_cap-5.1e-13*a15_cap-1.038546e-11*a16_cap)
+dcgsl_p_18_cap = -0.0699*(-6.528e-13*a13_cap-4.04702e-11*a14_cap-5.1e-13*a15_cap-1.038546e-11*a16_cap)
+dcgdl_p_18_cap = -0.0699*(-6.528e-13*a13_cap-4.04702e-11*a14_cap-5.1e-13*a15_cap-1.038546e-11*a16_cap)
+dcj_p_18_cap = 1.3e-5*a13_cap-5.3e-6*a14_cap-1.493e-5*a15_cap+3.7e-7*a16_cap
+dcjsw_p_18_cap = 1.1336e-7*(1.3e-5*a13_cap-5.3e-6*a14_cap-1.493e-5*a15_cap+3.7e-7*a16_cap)
+dcjswg_p_18_cap = 2.371e-7*(1.3e-5*a13_cap-5.3e-6*a14_cap-1.493e-5*a15_cap+3.7e-7*a16_cap)
include "gpdk045_moscap.scs"   section = moscap18
include "gpdk045_moscap.scs"   section = s1p8v_mac
endsection mccap_18

section moscap
model nch_mac bsim4 {
1:type=n  minr=1e-60
//*** flag parameter ***
+version = 4.3                 binunit = 2                   mobmod = 0
+capmod = 2                    rdsmod = 0                    igcmod = 1
+igbmod = 1                    rbodymod = 0                  trnqsmod = 0
+acnqsmod = 0                  fnoimod = 1                   tnoimod = 0
+diomod = 1                    tempmod = 0                   permod = 1
+rgatemod = 0                  wpemod = 1
//*** geometry range parameter ***
+lmin = 2E-6                   lmax = 1E-5                   wmin = 2E-6
+wmax = 1E-5
//*** process parameter ***
+epsrox = 3.9                  toxe = tox_n_cap                  toxm = tox_n_cap
+dtox = 3.15E-10               xj = 8.1E-8                   ndep = 1E17
+ngate = 1.6E20                nsd = 1E20                    rsh = 17.5
+rshg = 15.5
//*** dw and dl parameter ***
+wint = 2E-9                   wl = 0                        wln = 1
+ww = 0                        wwn = 1                       wwl = 0
+lint = 1E-9                   ll = 0                        lln = 1
+lw = 0                        lwn = 1                       lwl = 0
+llc = 0                       lwc = 0                       lwlc = 0
+wlc = 0                       wwc = 0                       wwlc = 0
+dwg = 0                       dwb = 0                       xl = 0.0+dxl_n_cap
+xw = 0.0+dxw_n_cap
//*** flicker noise model parameter ***
+noia = 2.6E42                 noib = 1.61E21                noic = 3E8
+em = 1E6                      ef = 0.94                     lintnoi = -5E-9
//***layout-dependent parasitics model parameter ***
+dmcg = 4E-8                   dmci = 4E-8                   dmdg = 0
+dmcgt = 0                     dwj = 0                       xgw = 0
+xgl = 0                       ngcon = 1
//*** vth related  parameter ***
+vth0 = 0.34925+dvth0_n_cap        lvth0 = 0.0+dlvth0_n_cap          wvth0 = 0.0+dwvth0_n_cap
+pvth0 = 0.0+dpvth0_n_cap          phin = 0                      k1 = 0.30264
+k2 = -0.012135                k3 = -7.284535                k3b = 2.454986
+w0 = 8.190018E-8              lpe0 = 6.610138E-8            lpeb = 2.000404E-8
+dvtp0 = 2.36094E-6            dvtp1 = 4.5                   dvt0 = 0.236381
+dvt1 = 0.537442               dvt2 = 5.56679E-2             dvt0w = 0
+dvt1w = 0                     dvt2w = 0                     vfbsdoff = 0.02
//*** mobility related parameter ***
+u0 = 0.0152801+du0_n_cap          lu0 = -2.636545E-10+dlu0_n_cap    wu0 = -3.215249E-10+dwu0_n_cap
+pu0 = 7.659855E-16+dpu0_n_cap     ua = -1.9203E-9               lua = -9.059977E-18
+wua = 1.401586E-17            pua = -4.284537E-24           ub = 2.276039E-18
+lub = -2.737235E-26           wub = -4.319124E-26           pub = 9.846961E-32
+uc = 7.443076E-11             luc = -1.669235E-17           wuc = -1.649254E-17
+puc = 3.331794E-23            ud = 0                        vsat = 137107.0+dvsat_n_cap
+lvsat = 0                     wvsat = 0                     pvsat = 0
+a0 = 1.930529                 la0 = -2.066163E-6            ags = 1.062652
+lags = 8.605063E-7            b0 = 0                        b1 = 0
+keta = -6.63214E-2            lketa = 4.616804E-8           wketa = 7.781602E-10
+pketa = -7.780046E-15         a1 = 0                        a2 = 1
+rdsw = 100.002354             prwb = 0                      prwg = 0
+wr = 1
//*** subthreshold related parameter ***
+voff = -0.15529               lvoff = 2.424242E-9           wvoff = 3.082726E-9
+pvoff = -4.838786E-15         voffl = -3.595178E-9          minv = -0.15
+nfactor = 0.980741            lnfactor = 2.278475E-7        wnfactor = 2.101514E-7
+pnfactor = -4.547836E-13      eta0 = 2.963491E-3            etab = -1.59363E-2
+dsub = 0.422235               cit = 7.212E-4                cdsc = 0
+cdscb = 0                     cdscd = 0
//*** output resistance related parameter ***
+pclm = 1.441266               pdiblc1 = 4.53031E-4          pdiblc2 = 8.652665E-3
+lpdiblc2 = -1.102969E-9       wpdiblc2 = 2.236938E-11       ppdiblc2 = -2.236491E-16
+pdiblcb = 1                   drout = 0.56                  pscbe1 = 1E9
+pscbe2 = 1E-20                pvag = 1.2                    delta = 7.595625E-3
+fprout = 300                  pdits = 0                     pditsl = 0
+pditsd = 0                    alpha0 = 2E-10                alpha1 = 0.01
+beta0 = 6.4                   agidl = 2.1505E-7             bgidl = 2.1392E9
+cgidl = 0.22                  egidl = 0.29734
//*** gate dielectric tunneling current ***
+aigbacc = 0.02                bigbacc = 2.47E-3             cigbacc = 0.3325
+nigbacc = 10                  aigbinv = 0.0158              bigbinv = 4.893E-3
+cigbinv = 6.1E-3              eigbinv = 1.1                 nigbinv = 10
+aigc = 0.0112                 bigc = 1.392E-3               cigc = 6.22E-4
+aigsd = 0.0106                bigsd = 1.235E-3              cigsd = 0.07
+dlcig = 2.48E-9               nigc = 3.07                   poxedge = 1
+pigcd = 2.591                 ntox = 1                      toxref = 3E-9
//*** capacitance parameter ***
+xpart = 1                     cgso = 5.53E-11+dcgso_n_cap       cgdo = 5.53E-11+dcgdo_n_cap
+cgbo = 0                      ckappas = 0.6                 ckappad = 0.6
+cf = 8.13E-11                 clc = 1.04E-7                 cle = 0.6
+dlc = 0                 dwc = 0                       noff = 2.96
+voffcv = -0.12                acde = 1                      moin = 5.67
+cgsl = 1.71E-11+dcgsl_n_cap       cgdl = 1.71E-11+dcgdl_n_cap
//*** souce/drain junction diode model parameter **
+ijthsrev = 0.01               ijthsfwd = 0.01               xjbvs = 1
+bvs = 10                      jss = 2.1E-7                  jsws = 3.4E-13
+jswgs = 1.2E-12               cjs = 8.61E-4+dcj_n_cap           mjs = 0.264
+mjsws = 0.011                 cjsws = 4.87E-11+dcjsw_n_cap      cjswgs = 2.56E-10+dcjswg_n_cap
+mjswgs = 0.511                pbs = 0.511                   pbsws = 0.786
+pbswgs = 0.464
//** rf model related parameter ***
+xrcrg1 = 12                   xrcrg2 = 1                    rbpb = 50
+rbpd = 50                     rbps = 50                     rbdb = 50
+rbsb = 50                     gbmin = 1E-12
//*** stress effect related parameter ***
+saref = 6.1E-7                sbref = 6.1E-7                wlod = 1.37E-7
+ku0 = -3.471E-8               kvsat = 0.342                 kvth0 = 2.461E-9
+tku0 = 0.097                  llodku0 = 1                   wlodku0 = 1
+llodvth = 1                   wlodvth = 1                   lku0 = 1.23E-8
+wku0 = 9.96E-8                pku0 = 4.6E-14                lkvth0 = -2.421E-11
+wkvth0 = 0                    pkvth0 = 0                    stk2 = 3.87E-10
+lodk2 = 0.5                   steta0 = 0                    lodeta0 = 1
//*** temperature coefficient ***
+tnom = 25                     ute = -1                      kt1 = -0.18098
+kt1l = 0                      kt2 = -0.036                  ua1 = 1.04E-9
+ub1 = -4.64E-19               uc1 = 8.71E-11                at = 1.4E5
+prt = 0                       njs = 1                       njd = 1
+xtis = 3                      xtid = 3                      tpb = 1.1E-3
+tpbsw = 1.9E-3                tpbswg = 1E-3                 tcj = 6.52E-4
+tcjsw = 3.57E-4               tcjswg = 1.5E-3               tvoff = 2.2428E-3
+tvfbsdoff = 0.022
//*** well proximity effect model parameters ***
+web = -210                    wec = -3.51E3                 kvth0we = 3.270022E-3
+k2we = 1.50195E-3             ku0we = -3.001501E-3          scref = 1E-6
2:type=n  minr=1e-60
//*** flag parameter ***
+version = 4.3                 binunit = 2                   mobmod = 0
+capmod = 2                    rdsmod = 0                    igcmod = 1
+igbmod = 1                    rbodymod = 0                  trnqsmod = 0
+acnqsmod = 0                  fnoimod = 1                   tnoimod = 0
+diomod = 1                    tempmod = 0                   permod = 1
+rgatemod = 0                  wpemod = 1
//*** geometry range parameter ***
+lmin = 1E-6                   lmax = 2E-6                   wmin = 2E-6
+wmax = 1E-5
//*** process parameter ***
+epsrox = 3.9                  toxe = tox_n_cap                  toxm = tox_n_cap
+dtox = 3.15E-10               xj = 8.1E-8                   ndep = 1E17
+ngate = 1.6E20                nsd = 1E20                    rsh = 17.5
+rshg = 15.5
//*** dw and dl parameter ***
+wint = 2E-9                   wl = 0                        wln = 1
+ww = 0                        wwn = 1                       wwl = 0
+lint = 1E-9                   ll = 0                        lln = 1
+lw = 0                        lwn = 1                       lwl = 0
+llc = 0                       lwc = 0                       lwlc = 0
+wlc = 0                       wwc = 0                       wwlc = 0
+dwg = 0                       dwb = 0                       xl = 0+dxl_n_cap
+xw = 0+dxw_n_cap
//*** flicker noise model parameter ***
+noia = 2.6E42                 noib = 1.61E21                noic = 3E8
+em = 1E6                      ef = 0.94                     lintnoi = -5E-9
//***layout-dependent parasitics model parameter ***
+dmcg = 4E-8                   dmci = 4E-8                   dmdg = 0
+dmcgt = 0                     dwj = 0                       xgw = 0
+xgl = 0                       ngcon = 1
//*** vth related  parameter ***
+vth0 = 0.348827+dvth0_n_cap       lvth0 = 8.442663E-10+dlvth0_n_cap wvth0 = -3.248163E-9+dwvth0_n_cap
+pvth0 = 6.48983E-15+dpvth0_n_cap  phin = 0                      k1 = 0.30264
+k2 = -0.012135                k3 = -7.284535                k3b = 2.454986
+w0 = 8.190018E-8              lpe0 = 6.610138E-8            lpeb = 2.000404E-8
+dvtp0 = 2.36094E-6            dvtp1 = 4.5                   dvt0 = 0.236381
+dvt1 = 0.537442               dvt2 = 5.56679E-2             dvt0w = 0
+dvt1w = 0                     dvt2w = 0                     vfbsdoff = 0.02
//*** mobility related parameter ***
+u0 = 1.53763E-2+du0_n_cap         lu0 = -4.559811E-10+dlu0_n_cap    wu0 = -3.06025E-10+dwu0_n_cap
+pu0 = 7.350168E-16+dpu0_n_cap     ua = -1.918445E-9             lua = -1.27667E-17
+wua = 7.107477E-18            pua = 9.518418E-24            ub = 2.275016E-18
+lub = -2.532801E-26           wub = -2.188103E-27           pub = 1.654534E-32
+uc = 6.607623E-11             wuc = 1.831096E-19            ud = 0
+vsat = 1.37107E5+dvsat_n_cap      lvsat = 0                     wvsat = 0
+pvsat = 0                     a0 = 0.230932                 la0 = 1.329631E-6
+wa0 = 3.747559E-7             pa0 = -7.487623E-13           ags = 0.164079
+lags = 2.655856E-6            wags = 1.170882E-7            pags = -2.339422E-13
+b0 = 0                        b1 = 0                        keta = -2.29457E-2
+lketa = -4.049659E-8          wketa = -6.200143E-9          pketa = 6.162604E-15
+a1 = 0                        a2 = 1                        rdsw = 100.002354
+prwb = 0                      prwg = 0                      wr = 1
//*** subthreshold related parameter ***
+voff = -0.156085              lvoff = 4.011719E-9           wvoff = 3.69253E-9
+pvoff = -6.057175E-15         voffl = -3.595178E-9          minv = -0.15
+nfactor = 0.963931            lnfactor = 2.614339E-7        wnfactor = 7.362414E-9
+pnfactor = -4.961115E-14      eta0 = 2.963491E-3            etab = -1.59363E-2
+dsub = 0.422235               cit = 7.212E-4                cdsc = 0
+cdscb = 0                     cdscd = 0
//*** output resistance related parameter ***
+pclm = 1.441266               pdiblc1 = 4.53031E-4          pdiblc2 = 8.076934E-3
+lpdiblc2 = 4.734049E-11       wpdiblc2 = 1.472775E-10       ppdiblc2 = -4.732155E-16
+pdiblcb = 1                   drout = 0.56                  pscbe1 = 1E9
+pscbe2 = 1E-20                pvag = 1.2                    delta = 7.595625E-3
+fprout = 300                  pdits = 0                     pditsl = 0
+pditsd = 0                    alpha0 = 2E-10                alpha1 = 0.01
+beta0 = 6.4                   agidl = 2.1505E-7             bgidl = 2.1392E9
+cgidl = 0.22                  egidl = 0.29734
//*** gate dielectric tunneling current ***
+aigbacc = 0.02                bigbacc = 2.47E-3             cigbacc = 0.3325
+nigbacc = 10                  aigbinv = 0.0158              bigbinv = 4.893E-3
+cigbinv = 6.1E-3              eigbinv = 1.1                 nigbinv = 10
+aigc = 0.0112                 bigc = 1.392E-3               cigc = 6.22E-4
+aigsd = 0.0106                bigsd = 1.235E-3              cigsd = 0.07
+dlcig = 2.48E-9               nigc = 3.07                   poxedge = 1
+pigcd = 2.591                 ntox = 1                      toxref = 3E-9
//*** capacitance parameter ***
+xpart = 1                     cgso = 5.53E-11+dcgso_n_cap       cgdo = 5.53E-11+dcgdo_n_cap
+cgbo = 0                      ckappas = 0.6                 ckappad = 0.6
+cf = 8.13E-11                 clc = 1.04E-7                 cle = 0.6
+dlc = 0                 dwc = 0                       noff = 2.96
+voffcv = -0.12                acde = 1                      moin = 5.67
+cgsl = 1.71E-11+dcgsl_n_cap       cgdl = 1.71E-11+dcgdl_n_cap
//*** souce/drain junction diode model parameter **
+ijthsrev = 0.01               ijthsfwd = 0.01               xjbvs = 1
+bvs = 10                      jss = 2.1E-7                  jsws = 3.4E-13
+jswgs = 1.2E-12               cjs = 8.61E-4+dcj_n_cap           mjs = 0.264
+mjsws = 0.011                 cjsws = 4.87E-11+dcjsw_n_cap      cjswgs = 2.56E-10+dcjswg_n_cap
+mjswgs = 0.511                pbs = 0.511                   pbsws = 0.786
+pbswgs = 0.464
//** rf model related parameter ***
+xrcrg1 = 12                   xrcrg2 = 1                    rbpb = 50
+rbpd = 50                     rbps = 50                     rbdb = 50
+rbsb = 50                     gbmin = 1E-12
//*** stress effect related parameter ***
+saref = 6.1E-7                sbref = 6.1E-7                wlod = 1.37E-7
+ku0 = -3.471E-8               kvsat = 0.342                 kvth0 = 2.461E-9
+tku0 = 0.097                  llodku0 = 1                   wlodku0 = 1
+llodvth = 1                   wlodvth = 1                   lku0 = 1.23E-8
+wku0 = 9.96E-8                pku0 = 4.6E-14                lkvth0 = -2.421E-11
+wkvth0 = 0                    pkvth0 = 0                    stk2 = 3.87E-10
+lodk2 = 0.5                   steta0 = 0                    lodeta0 = 1
//*** temperature coefficient ***
+tnom = 25                     ute = -1                      kt1 = -0.18098
+kt1l = 0                      kt2 = -0.036                  ua1 = 1.04E-9
+ub1 = -4.64E-19               uc1 = 8.71E-11                at = 1.4E5
+prt = 0                       njs = 1                       njd = 1
+xtis = 3                      xtid = 3                      tpb = 1.1E-3
+tpbsw = 1.9E-3                tpbswg = 1E-3                 tcj = 6.52E-4
+tcjsw = 3.57E-4               tcjswg = 1.5E-3               tvoff = 2.2428E-3
+tvfbsdoff = 0.022
//*** well proximity effect model parameters ***
+web = -210                    wec = -3.51E3                 kvth0we = 3.270022E-3
+k2we = 1.50195E-3             ku0we = -3.001501E-3          scref = 1E-6
3:type=n  minr=1e-60
//*** flag parameter ***
+version = 4.3                 binunit = 2                   mobmod = 0
+capmod = 2                    rdsmod = 0                    igcmod = 1
+igbmod = 1                    rbodymod = 0                  trnqsmod = 0
+acnqsmod = 0                  fnoimod = 1                   tnoimod = 0
+diomod = 1                    tempmod = 0                   permod = 1
+rgatemod = 0                  wpemod = 1
//*** geometry range parameter ***
+lmin = 5E-7                   lmax = 1E-6                   wmin = 2E-6
+wmax = 1E-5
//*** process parameter ***
+epsrox = 3.9                  toxe = tox_n_cap                  toxm = tox_n_cap
+dtox = 3.15E-10               xj = 8.1E-8                   ndep = 1E17
+ngate = 1.6E20                nsd = 1E20                    rsh = 17.5
+rshg = 15.5
//*** dw and dl parameter ***
+wint = 2E-9                   wl = 0                        wln = 1
+ww = 0                        wwn = 1                       wwl = 0
+lint = 1E-9                   ll = 0                        lln = 1
+lw = 0                        lwn = 1                       lwl = 0
+llc = 0                       lwc = 0                       lwlc = 0
+wlc = 0                       wwc = 0                       wwlc = 0
+dwg = 0                       dwb = 0                       xl = 0+dxl_n_cap
+xw = 0+dxw_n_cap
//*** flicker noise model parameter ***
+noia = 2.6E42                 noib = 1.61E21                noic = 3E8
+em = 1E6                      ef = 0.94                     lintnoi = -5E-9
//***layout-dependent parasitics model parameter ***
+dmcg = 4E-8                   dmci = 4E-8                   dmdg = 0
+dmcgt = 0                     dwj = 0                       xgw = 0
+xgl = 0                       ngcon = 1
//*** vth related  parameter ***
+vth0 = 0.352645+dvth0_n_cap       lvth0 = -2.965664E-9+dlvth0_n_cap wvth0 = 3.458363E-9+dwvth0_n_cap
+pvth0 = -2.032828E-16+dpvth0_n_cap phin = 0                      k1 = 0.30264
+k2 = -0.012135                k3 = -7.284535                k3b = 2.454986
+w0 = 8.190018E-8              lpe0 = 6.610138E-8            lpeb = 2.000404E-8
+dvtp0 = 2.36094E-6            dvtp1 = 4.5                   dvt0 = 0.236381
+dvt1 = 0.537442               dvt2 = 5.56679E-2             dvt0w = 0
+dvt1w = 0                     dvt2w = 0                     vfbsdoff = 0.02
//*** mobility related parameter ***
+u0 = 1.49678E-2+du0_n_cap         lu0 = -4.831396E-11+dlu0_n_cap    wu0 = 4.562986E-10+dwu0_n_cap
+pu0 = -2.57822E-17+dpu0_n_cap     ua = -1.918037E-9             lua = -1.317425E-17
+wua = -2.477865E-17           pua = 4.134077E-23            ub = 2.222816E-18
+lub = 2.67682E-26             wub = 7.98867E-26             pub = -6.536532E-32
+uc = 6.607623E-11             wuc = 1.831096E-19            ud = 0
+vsat = 1.37107E5+dvsat_n_cap      lvsat = 0                     wvsat = 0
+pvsat = 0                     a0 = 1.426295                 la0 = 1.366587E-7
+wa0 = -6.463353E-7            pa0 = 2.702867E-13            ags = 1.185611
+lags = 1.636367E-6            wags = -2.593172E-7           pags = 1.417104E-13
+b0 = 0                        b1 = 0                        keta = -6.35361E-2
+a1 = 0                        a2 = 1                        rdsw = 100.002354
+prwb = 0                      prwg = 0                      wr = 1
//*** subthreshold related parameter ***
+voff = -0.15272               lvoff = 6.530101E-10          wvoff = -3.353006E-9
+pvoff = 9.742698E-16          voffl = -3.595178E-9          minv = -0.15
+nfactor = 1.07151             lnfactor = 1.540699E-7        wnfactor = -9.169333E-8
+pnfactor = 4.924649E-14       eta0 = 2.963491E-3            etab = -1.59363E-2
+dsub = 0.422235               cit = 7.212E-4                cdsc = 0
+cdscb = 0                     cdscd = 0
//*** output resistance related parameter ***
+pclm = 1.441266               pdiblc1 = 4.53031E-4          pdiblc2 = 8.15239E-3
+lpdiblc2 = -2.79643E-11       wpdiblc2 = -6.069777E-10      ppdiblc2 = 2.795311E-16
+pdiblcb = 1                   drout = 0.56                  pscbe1 = 1E9
+pscbe2 = 1E-20                pvag = 1.2                    delta = 7.595625E-3
+fprout = 300                  pdits = 0                     pditsl = 0
+pditsd = 0                    alpha0 = 2E-10                alpha1 = 0.01
+beta0 = 6.4                   agidl = 2.1505E-7             bgidl = 2.1392E9
+cgidl = 0.22                  egidl = 0.29734
//*** gate dielectric tunneling current ***
+aigbacc = 0.02                bigbacc = 2.47E-3             cigbacc = 0.3325
+nigbacc = 10                  aigbinv = 0.0158              bigbinv = 4.893E-3
+cigbinv = 6.1E-3              eigbinv = 1.1                 nigbinv = 10
+aigc = 0.0112                 bigc = 1.392E-3               cigc = 6.22E-4
+aigsd = 0.0106                bigsd = 1.235E-3              cigsd = 0.07
+dlcig = 2.48E-9               nigc = 3.07                   poxedge = 1
+pigcd = 2.591                 ntox = 1                      toxref = 3E-9
//*** capacitance parameter ***
+xpart = 1                     cgso = 5.53E-11+dcgso_n_cap       cgdo = 5.53E-11+dcgdo_n_cap
+cgbo = 0                      ckappas = 0.6                 ckappad = 0.6
+cf = 8.13E-11                 clc = 1.04E-7                 cle = 0.6
+dlc = 0                 dwc = 0                       noff = 2.96
+voffcv = -0.12                acde = 1                      moin = 5.67
+cgsl = 1.71E-11+dcgsl_n_cap       cgdl = 1.71E-11+dcgdl_n_cap
//*** souce/drain junction diode model parameter **
+ijthsrev = 0.01               ijthsfwd = 0.01               xjbvs = 1
+bvs = 10                      jss = 2.1E-7                  jsws = 3.4E-13
+jswgs = 1.2E-12               cjs = 8.61E-4+dcj_n_cap           mjs = 0.264
+mjsws = 0.011                 cjsws = 4.87E-11+dcjsw_n_cap      cjswgs = 2.56E-10+dcjswg_n_cap
+mjswgs = 0.511                pbs = 0.511                   pbsws = 0.786
+pbswgs = 0.464
//** rf model related parameter ***
+xrcrg1 = 12                   xrcrg2 = 1                    rbpb = 50
+rbpd = 50                     rbps = 50                     rbdb = 50
+rbsb = 50                     gbmin = 1E-12
//*** stress effect related parameter ***
+saref = 6.1E-7                sbref = 6.1E-7                wlod = 1.37E-7
+ku0 = -3.471E-8               kvsat = 0.342                 kvth0 = 2.461E-9
+tku0 = 0.097                  llodku0 = 1                   wlodku0 = 1
+llodvth = 1                   wlodvth = 1                   lku0 = 1.23E-8
+wku0 = 9.96E-8                pku0 = 4.6E-14                lkvth0 = -2.421E-11
+wkvth0 = 0                    pkvth0 = 0                    stk2 = 3.87E-10
+lodk2 = 0.5                   steta0 = 0                    lodeta0 = 1
//*** temperature coefficient ***
+tnom = 25                     ute = -1                      kt1 = -0.18098
+kt1l = 0                      kt2 = -0.036                  ua1 = 1.04E-9
+ub1 = -4.64E-19               uc1 = 8.71E-11                at = 1.4E5
+prt = 0                       njs = 1                       njd = 1
+xtis = 3                      xtid = 3                      tpb = 1.1E-3
+tpbsw = 1.9E-3                tpbswg = 1E-3                 tcj = 6.52E-4
+tcjsw = 3.57E-4               tcjswg = 1.5E-3               tvoff = 2.2428E-3
+tvfbsdoff = 0.022
//*** well proximity effect model parameters ***
+web = -210                    wec = -3.51E3                 kvth0we = 3.270022E-3
+k2we = 1.50195E-3             ku0we = -3.001501E-3          scref = 1E-6
4:type=n  minr=1e-60
//*** flag parameter ***
+version = 4.3                 binunit = 2                   mobmod = 0
+capmod = 2                    rdsmod = 0                    igcmod = 1
+igbmod = 1                    rbodymod = 0                  trnqsmod = 0
+acnqsmod = 0                  fnoimod = 1                   tnoimod = 0
+diomod = 1                    tempmod = 0                   permod = 1
+rgatemod = 0                  wpemod = 1
//*** geometry range parameter ***
+lmin = 1E-7                   lmax = 5E-7                   wmin = 2E-6
+wmax = 1E-5
//*** process parameter ***
+epsrox = 3.9                  toxe = tox_n_cap                  toxm = tox_n_cap
+dtox = 3.15E-10               xj = 8.1E-8                   ndep = 1E17
+ngate = 1.6E20                nsd = 1E20                    rsh = 17.5
+rshg = 15.5
//*** dw and dl parameter ***
+wint = 2E-9                   wl = 0                        wln = 1
+ww = 0                        wwn = 1                       wwl = 0
+lint = 1E-9                   ll = 0                        lln = 1
+lw = 0                        lwn = 1                       lwl = 0
+llc = 0                       lwc = 0                       lwlc = 0
+wlc = 0                       wwc = 0                       wwlc = 0
+dwg = 0                       dwb = 0                       xl = 0+dxl_n_cap
+xw = 0+dxw_n_cap
//*** flicker noise model parameter ***
+noia = 2.6E42                 noib = 1.61E21                noic = 3E8
+em = 1E6                      ef = 0.94                     lintnoi = -5E-9
//***layout-dependent parasitics model parameter ***
+dmcg = 4E-8                   dmci = 4E-8                   dmdg = 0
+dmcgt = 0                     dwj = 0                       xgw = 0
+xgl = 0                       ngcon = 1
//*** vth related  parameter ***
+vth0 = 0.346512+dvth0_n_cap       lvth0 = 8.869664E-11+dlvth0_n_cap wvth0 = 3.006781E-9+dwvth0_n_cap
+pvth0 = 2.160485E-17+dpvth0_n_cap phin = 0                      k1 = 0.30264
+k2 = -0.012135                k3 = -7.284535                k3b = 2.454986
+w0 = 8.190018E-8              lpe0 = 6.610138E-8            lpeb = 2.000404E-8
+dvtp0 = 2.36094E-6            dvtp1 = 4.5                   dvt0 = 0.236381
+dvt1 = 0.537442               dvt2 = 5.56679E-2             dvt0w = 0
+dvt1w = 0                     dvt2w = 0                     vfbsdoff = 0.02
//*** mobility related parameter ***
+u0 = 1.49887E-2+du0_n_cap         lu0 = -5.868444E-11+dlu0_n_cap    wu0 = 4.724126E-10+dwu0_n_cap
+pu0 = -3.380697E-17+dpu0_n_cap    ua = -1.943415E-9             lua = -5.355717E-19
+wua = 6.168421E-17            pua = -1.717735E-24           ub = 2.268086E-18
+lub = 4.223629E-27            wub = -5.176552E-26           pub = 1.974863E-34
+uc = 6.095064E-11             luc = 2.552546E-18            wuc = 2.858476E-18
+puc = -1.332332E-24           ud = 0                        vsat = 1.371068E5+dvsat_n_cap
+lvsat = 0                     wvsat = 0                     pvsat = 0
+a0 = 2.117139                 la0 = -2.073816E-7            wa0 = -1.289706E-7
+pa0 = 1.263912E-14            ags = 4.142833                lags = 1.636699E-7
+wags = 2.338671E-8            pags = 9.238341E-16           b0 = 0
+b1 = 0                        keta = -6.84235E-2            lketa = 2.4402E-9
+wketa = -2.518942E-11         a1 = 0                        a2 = 1
+rdsw = 100.002354             prwb = 0                      prwg = 0
+wr = 1
//*** subthreshold related parameter ***
+voff = -0.149693              lvoff = -8.543634E-10         wvoff = -1.512737E-9
+pvoff = 5.78157E-17           voffl = -3.595178E-9          minv = -0.15
+nfactor = 1.279392            lnfactor = 5.054459E-8        wnfactor = 6.666043E-9
+pnfactor = 2.635179E-16       eta0 = 3.453491E-3            leta0 = -2.4402E-10
+etab = -1.49631E-2            letab = -4.846381E-10         wetab = -2.347268E-8
+petab = 1.168939E-14          dsub = 0.422235               cit = 7.212E-4
+cdsc = 0                      cdscb = 0                     cdscd = 0
//*** output resistance related parameter ***
+pclm = 1.441266               pdiblc1 = 5.130311E-4         lpdiblc1 = -2.988006E-11
+wpdiblc1 = -5.997613E-10      ppdiblc1 = 2.986811E-16       pdiblc2 = 8.131707E-3
+lpdiblc2 = -1.766403E-11      wpdiblc2 = 8.259697E-10       ppdiblc2 = -4.340767E-16
+pdiblcb = 1                   drout = 0.56                  pscbe1 = 1E9
+pscbe2 = 1E-20                pvag = 1.2                    delta = 7.595625E-3
+fprout = 300                  pdits = 0                     pditsl = 0
+pditsd = 0                    alpha0 = 2E-10                alpha1 = 0.01
+beta0 = 6.4                   agidl = 2.1505E-7             bgidl = 2.1392E9
+cgidl = 0.22                  egidl = 0.29734
//*** gate dielectric tunneling current ***
+aigbacc = 0.02                bigbacc = 2.47E-3             cigbacc = 0.3325
+nigbacc = 10                  aigbinv = 0.0158              bigbinv = 4.893E-3
+cigbinv = 6.1E-3              eigbinv = 1.1                 nigbinv = 10
+aigc = 0.0112                 bigc = 1.392E-3               cigc = 6.22E-4
+aigsd = 0.0106                bigsd = 1.235E-3              cigsd = 0.07
+dlcig = 2.48E-9               nigc = 3.07                   poxedge = 1
+pigcd = 2.591                 ntox = 1                      toxref = 3E-9
//*** capacitance parameter ***
+xpart = 1                     cgso = 5.53E-11+dcgso_n_cap       cgdo = 5.53E-11+dcgdo_n_cap
+cgbo = 0                      ckappas = 0.6                 ckappad = 0.6
+cf = 8.13E-11                 clc = 1.04E-7                 cle = 0.6
+dlc = 0                 dwc = 0                       noff = 2.96
+voffcv = -0.12                acde = 1                      moin = 5.67
+cgsl = 1.71E-11+dcgsl_n_cap       cgdl = 1.71E-11+dcgdl_n_cap
//*** souce/drain junction diode model parameter **
+ijthsrev = 0.01               ijthsfwd = 0.01               xjbvs = 1
+bvs = 10                      jss = 2.1E-7                  jsws = 3.4E-13
+jswgs = 1.2E-12               cjs = 8.61E-4+dcj_n_cap           mjs = 0.264
+mjsws = 0.011                 cjsws = 4.87E-11+dcjsw_n_cap      cjswgs = 2.56E-10+dcjswg_n_cap
+mjswgs = 0.511                pbs = 0.511                   pbsws = 0.786
+pbswgs = 0.464
//** rf model related parameter ***
+xrcrg1 = 12                   xrcrg2 = 1                    rbpb = 50
+rbpd = 50                     rbps = 50                     rbdb = 50
+rbsb = 50                     gbmin = 1E-12
//*** stress effect related parameter ***
+saref = 6.1E-7                sbref = 6.1E-7                wlod = 1.37E-7
+ku0 = -3.471E-8               kvsat = 0.342                 kvth0 = 2.461E-9
+tku0 = 0.097                  llodku0 = 1                   wlodku0 = 1
+llodvth = 1                   wlodvth = 1                   lku0 = 1.23E-8
+wku0 = 9.96E-8                pku0 = 4.6E-14                lkvth0 = -2.421E-11
+wkvth0 = 0                    pkvth0 = 0                    stk2 = 3.87E-10
+lodk2 = 0.5                   steta0 = 0                    lodeta0 = 1
//*** temperature coefficient ***
+tnom = 25                     ute = -1                      kt1 = -0.18098
+kt1l = 0                      kt2 = -0.036                  ua1 = 1.04E-9
+ub1 = -4.64E-19               uc1 = 8.71E-11                at = 1.4E5
+prt = 0                       njs = 1                       njd = 1
+xtis = 3                      xtid = 3                      tpb = 1.1E-3
+tpbsw = 1.9E-3                tpbswg = 1E-3                 tcj = 6.52E-4
+tcjsw = 3.57E-4               tcjswg = 1.5E-3               tvoff = 2.2428E-3
+tvfbsdoff = 0.022
//*** well proximity effect model parameters ***
+web = -210                    wec = -3.51E3                 kvth0we = 3.270022E-3
+k2we = 1.50195E-3             ku0we = -3.001501E-3          scref = 1E-6
5:type=n  minr=1e-60
//*** flag parameter ***
+version = 4.3                 binunit = 2                   mobmod = 0
+capmod = 2                    rdsmod = 0                    igcmod = 1
+igbmod = 1                    rbodymod = 0                  trnqsmod = 0
+acnqsmod = 0                  fnoimod = 1                   tnoimod = 0
+diomod = 1                    tempmod = 0                   permod = 1
+rgatemod = 0                  wpemod = 1
//*** geometry range parameter ***
+lmin = 6E-8                   lmax = 1E-7                   wmin = 2E-6
+wmax = 1E-5
//*** process parameter ***
+epsrox = 3.9                  toxe = tox_n_cap                  toxm = tox_n_cap
+dtox = 3.15E-10               xj = 8.1E-8                   ndep = 1E17
+ngate = 1.6E20                nsd = 1E20                    rsh = 17.5
+rshg = 15.5
//*** dw and dl parameter ***
+wint = 2E-9                   wl = 0                        wln = 1
+ww = 0                        wwn = 1                       wwl = 0
+lint = 1E-9                   ll = 0                        lln = 1
+lw = 0                        lwn = 1                       lwl = 0
+llc = 0                       lwc = 0                       lwlc = 0
+wlc = 0                       wwc = 0                       wwlc = 0
+dwg = 0                       dwb = 0                       xl = 0+dxl_n_cap
+xw = 0+dxw_n_cap
//*** flicker noise model parameter ***
+noia = 2.6E42                 noib = 1.61E21                noic = 3E8
+em = 1E6                      ef = 0.94                     lintnoi = -5E-9
//***layout-dependent parasitics model parameter ***
+dmcg = 4E-8                   dmci = 4E-8                   dmdg = 0
+dmcgt = 0                     dwj = 0                       xgw = 0
+xgl = 0                       ngcon = 1
//*** vth related  parameter ***
+vth0 = 0.339782+dvth0_n_cap       lvth0 = 7.482256E-10+dlvth0_n_cap wvth0 = -2.878078E-10+dwvth0_n_cap
+pvth0 = 3.444745E-16+dpvth0_n_cap phin = 0                      k1 = 0.30264
+k2 = -3.244617E-3             lk2 = -8.712575E-10           wk2 = -6.880378E-9
+pk2 = 6.74277E-16             k3 = -7.284535                k3b = 2.454986
+w0 = 8.190018E-8              lpe0 = 6.610138E-8            lpeb = 2.000404E-8
+dvtp0 = 2.36094E-6            dvtp1 = 4.5                   dvt0 = 0.236381
+dvt1 = 0.537442               dvt2 = 5.56679E-2             dvt0w = 0
+dvt1w = 0                     dvt2w = 0                     vfbsdoff = 0.02
//*** mobility related parameter ***
+u0 = 1.46581E-2+du0_n_cap         lu0 = -2.628521E-11+dlu0_n_cap    wu0 = 1.408238E-10+dwu0_n_cap
+pu0 = -1.311271E-18+dpu0_n_cap    ua = -2.013531E-9             lua = 6.335764E-18
+wua = 3.038181E-17            pua = 1.349901E-24            ub = 2.31846E-18
+lub = -7.130189E-28           wub = -8.336451E-27           pub = -4.058562E-33
+uc = 8.699702E-11             wuc = -1.073675E-17           ud = 0
+vsat = 1.37107E5+dvsat_n_cap      lvsat = 0                     wvsat = 0
+pvsat = 0                     a0 = 1E-3                     ags = 5.812934
+wags = 3.281358E-8            b0 = 0                        b1 = 0
+keta = -0.036288              lketa = -7.09079E-10          wketa = -7.235125E-8
+pketa = 7.087954E-15          a1 = 0                        a2 = 1
+rdsw = 100.002354             prwb = 0                      prwg = 0
+wr = 1
//*** subthreshold related parameter ***
+voff = -0.157109              lvoff = -1.275907E-10         wvoff = -1.689437E-9
+pvoff = 7.513231E-17          voffl = -3.595178E-9          minv = -0.15
+nfactor = 0.545726            lnfactor = 1.224439E-7        wnfactor = 2.845656E-9
+pnfactor = 6.379158E-16       eta0 = 9.63491E-4             etab = -2.30596E-2
+letab = 3.088173E-10          wetab = 2.105913E-7           petab = -1.124888E-14
+dsub = 0.422235               cit = 7.212E-4                cdsc = 0
+cdscb = 0                     cdscd = 0
//*** output resistance related parameter ***
+pclm = 1.441266               pdiblc1 = -5.88954E-3         lpdiblc1 = 5.975719E-10
+wpdiblc1 = 1.877094E-8        ppdiblc1 = -1.599648E-15      pdiblc2 = 4.317518E-3
+lpdiblc2 = 3.561265E-10       wpdiblc2 = 6.516453E-9        ppdiblc2 = -9.91744E-16
+pdiblcb = 1                   drout = 0.752025              ldrout = -1.881841E-8
+wdrout = -3.832811E-7         pdrout = 3.756155E-14         pscbe1 = 1E9
+pscbe2 = 1E-20                pvag = 1.2                    delta = 7.595625E-3
+fprout = 300                  pdits = 0                     pditsl = 0
+pditsd = 0                    alpha0 = 2E-10                alpha1 = 0.01
+beta0 = 6.4                   agidl = 2.1505E-7             bgidl = 2.1392E9
+cgidl = 0.22                  egidl = 0.29734
//*** gate dielectric tunneling current ***
+aigbacc = 0.02                bigbacc = 2.47E-3             cigbacc = 0.3325
+nigbacc = 10                  aigbinv = 0.0158              bigbinv = 4.893E-3
+cigbinv = 6.1E-3              eigbinv = 1.1                 nigbinv = 10
+aigc = 0.0112                 bigc = 1.392E-3               cigc = 6.22E-4
+aigsd = 0.0106                bigsd = 1.235E-3              cigsd = 0.07
+dlcig = 2.48E-9               nigc = 3.07                   poxedge = 1
+pigcd = 2.591                 ntox = 1                      toxref = 3E-9
//*** capacitance parameter ***
+xpart = 1                     cgso = 5.53E-11+dcgso_n_cap       cgdo = 5.53E-11+dcgdo_n_cap
+cgbo = 0                      ckappas = 0.6                 ckappad = 0.6
+cf = 8.13E-11                 clc = 1.04E-7                 cle = 0.6
+dlc = 0                 dwc = 0                       noff = 2.96
+voffcv = -0.12                acde = 1                      moin = 5.67
+cgsl = 1.71E-11+dcgsl_n_cap       cgdl = 1.71E-11+dcgdl_n_cap
//*** souce/drain junction diode model parameter **
+ijthsrev = 0.01               ijthsfwd = 0.01               xjbvs = 1
+bvs = 10                      jss = 2.1E-7                  jsws = 3.4E-13
+jswgs = 1.2E-12               cjs = 8.61E-4+dcj_n_cap           mjs = 0.264
+mjsws = 0.011                 cjsws = 4.87E-11+dcjsw_n_cap      cjswgs = 2.56E-10+dcjswg_n_cap
+mjswgs = 0.511                pbs = 0.511                   pbsws = 0.786
+pbswgs = 0.464
//** rf model related parameter ***
+xrcrg1 = 12                   xrcrg2 = 1                    rbpb = 50
+rbpd = 50                     rbps = 50                     rbdb = 50
+rbsb = 50                     gbmin = 1E-12
//*** stress effect related parameter ***
+saref = 6.1E-7                sbref = 6.1E-7                wlod = 1.37E-7
+ku0 = -3.471E-8               kvsat = 0.342                 kvth0 = 2.461E-9
+tku0 = 0.097                  llodku0 = 1                   wlodku0 = 1
+llodvth = 1                   wlodvth = 1                   lku0 = 1.23E-8
+wku0 = 9.96E-8                pku0 = 4.6E-14                lkvth0 = -2.421E-11
+wkvth0 = 0                    pkvth0 = 0                    stk2 = 3.87E-10
+lodk2 = 0.5                   steta0 = 0                    lodeta0 = 1
//*** temperature coefficient ***
+tnom = 25                     ute = -1                      kt1 = -0.18098
+kt1l = 0                      kt2 = -0.036                  ua1 = 1.04E-9
+ub1 = -4.64E-19               uc1 = 8.71E-11                at = 1.4E5
+prt = 0                       njs = 1                       njd = 1
+xtis = 3                      xtid = 3                      tpb = 1.1E-3
+tpbsw = 1.9E-3                tpbswg = 1E-3                 tcj = 6.52E-4
+tcjsw = 3.57E-4               tcjswg = 1.5E-3               tvoff = 2.2428E-3
+tvfbsdoff = 0.022
//*** well proximity effect model parameters ***
+web = -210                    wec = -3.51E3                 kvth0we = 3.270022E-3
+k2we = 1.50195E-3             ku0we = -3.001501E-3          scref = 1E-6
6:type=n  minr=1e-60
//*** flag parameter ***
+version = 4.3                 binunit = 2                   mobmod = 0
+capmod = 2                    rdsmod = 0                    igcmod = 1
+igbmod = 1                    rbodymod = 0                  trnqsmod = 0
+acnqsmod = 0                  fnoimod = 1                   tnoimod = 0
+diomod = 1                    tempmod = 0                   permod = 1
+rgatemod = 0                  wpemod = 1
//*** geometry range parameter ***
+lmin = 4E-8                   lmax = 6E-8                   wmin = 2E-6
+wmax = 1E-5
//*** process parameter ***
+epsrox = 3.9                  toxe = tox_n_cap                  toxm = tox_n_cap
+dtox = 3.15E-10               xj = 8.1E-8                   ndep = 1E17
+ngate = 1.6E20                nsd = 1E20                    rsh = 17.5
+rshg = 15.5
//*** dw and dl parameter ***
+wint = 2E-9                   wl = 0                        wln = 1
+ww = 0                        wwn = 1                       wwl = 0
+lint = 1E-9                   ll = 0                        lln = 1
+lw = 0                        lwn = 1                       lwl = 0
+llc = 0                       lwc = 0                       lwlc = 0
+wlc = 0                       wwc = 0                       wwlc = 0
+dwg = 0                       dwb = 0                       xl = 0+dxl_n_cap
+xw = 0+dxw_n_cap
//*** flicker noise model parameter ***
+noia = 2.6E42                 noib = 1.61E21                noic = 3E8
+em = 1E6                      ef = 0.94                     lintnoi = -5E-9
//***layout-dependent parasitics model parameter ***
+dmcg = 4E-8                   dmci = 4E-8                   dmdg = 0
+dmcgt = 0                     dwj = 0                       xgw = 0
+xgl = 0                       ngcon = 1
//*** vth related  parameter ***
+vth0 = 0.344879+dvth0_n_cap       lvth0 = 4.526312E-10+dlvth0_n_cap wvth0 = 4.5947E-9+dwvth0_n_cap
+pvth0 = 6.12891E-17+dpvth0_n_cap  phin = 0                      k1 = 0.30264
+k2 = -1.64348E-2              lk2 = -1.062293E-10           wk2 = -1.356298E-8
+pk2 = 1.061868E-15            k3 = -7.284535                k3b = 2.454986
+w0 = 8.190018E-8              lpe0 = 6.610138E-8            lpeb = 2.000404E-8
+dvtp0 = 2.36094E-6            dvtp1 = 4.5                   dvt0 = 0.236381
+dvt1 = 0.537442               dvt2 = 5.56679E-2             dvt0w = 0
+dvt1w = 0                     dvt2w = 0                     vfbsdoff = 0.02
//*** mobility related parameter ***
+u0 = 0.014758+du0_n_cap           lu0 = -3.207916E-11+dlu0_n_cap    wu0 = 8.87942E-9+dwu0_n_cap
+pu0 = -5.081499E-16+dpu0_n_cap    ua = -2.01495E-9              lua = 6.41809E-18
+wua = 8.840299E-16            pua = -4.816169E-23           ub = 2.3344E-18
+lub = -1.637544E-27           wub = -2.323731E-25           pub = 8.935566E-33
+uc = 8.699702E-11             wuc = -1.073675E-17           ud = 0
+vsat = 1.143112E5+dvsat_n_cap     lvsat = 1.322158E-3           wvsat = 1.89544E-2
+pvsat = -1.099356E-9          a0 = 1E-3                     ags = 5.812934
+lags = 0                      wags = 3.281358E-8            pags = 0
+b0 = 0                        b1 = 0                        keta = -4.85135E-2
+wketa = 4.985485E-8           a1 = 0                        a2 = 1
+rdsw = 100.002354             prwb = 0                      prwg = 0
+wr = 1
//*** subthreshold related parameter ***
+voff = -0.158578              lvoff = -4.238022E-11         wvoff = 2.690779E-9
+pvoff = -1.789202E-16         voffl = -3.595178E-9          minv = -0.15
+nfactor = 0.2338              lnfactor = 1.405356E-7        wnfactor = 1.220565E-9
+pnfactor = 7.321712E-16       eta0 = 9.63491E-4             etab = -1.33266E-2
+letab = -2.556967E-10         wetab = 4.495715E-8           petab = -1.642097E-15
+dsub = 0.422235               cit = 7.212E-4                cdsc = 0
+cdscb = 0                     cdscd = 0
//*** output resistance related parameter ***
+pclm = 1.441266               pdiblc1 = 5.91146E-3          lpdiblc1 = -8.688609E-11
+wpdiblc1 = -3.226781E-8       ppdiblc1 = 1.3606E-15         pdiblc2 = 7.963446E-3
+lpdiblc2 = 1.446627E-10       wpdiblc2 = -1.146998E-8       ppdiblc2 = 5.146883E-17
+pdiblcb = 1                   drout = 0.587767              ldrout = -9.291467E-9
+wdrout = 2.01152E-7           pdrout = 3.664429E-15         pscbe1 = 1E9
+pscbe2 = 1E-20                pvag = 1.2                    delta = 7.595625E-3
+fprout = 300                  pdits = 0                     pditsl = 0
+pditsd = 0                    alpha0 = 2E-10                alpha1 = 0.01
+beta0 = 6.4                   agidl = 2.1505E-7             bgidl = 2.1392E9
+cgidl = 0.22                  egidl = 0.29734
//*** gate dielectric tunneling current ***
+aigbacc = 0.02                bigbacc = 2.47E-3             cigbacc = 0.3325
+nigbacc = 10                  aigbinv = 0.0158              bigbinv = 4.893E-3
+cigbinv = 6.1E-3              eigbinv = 1.1                 nigbinv = 10
+aigc = 0.0112                 bigc = 1.392E-3               cigc = 6.22E-4
+aigsd = 0.0106                bigsd = 1.235E-3              cigsd = 0.07
+dlcig = 2.48E-9               nigc = 3.07                   poxedge = 1
+pigcd = 2.591                 ntox = 1                      toxref = 3E-9
//*** capacitance parameter ***
+xpart = 1                     cgso = 5.53E-11+dcgso_n_cap       cgdo = 5.53E-11+dcgdo_n_cap
+cgbo = 0                      ckappas = 0.6                 ckappad = 0.6
+cf = 8.13E-11                 clc = 1.04E-7                 cle = 0.6
+dlc = 0                 dwc = 0                       noff = 2.96
+voffcv = -0.12                acde = 1                      moin = 5.67
+cgsl = 1.71E-11+dcgsl_n_cap       cgdl = 1.71E-11+dcgdl_n_cap
//*** souce/drain junction diode model parameter **
+ijthsrev = 0.01               ijthsfwd = 0.01               xjbvs = 1
+bvs = 10                      jss = 2.1E-7                  jsws = 3.4E-13
+jswgs = 1.2E-12               cjs = 8.61E-4+dcj_n_cap           mjs = 0.264
+mjsws = 0.011                 cjsws = 4.87E-11+dcjsw_n_cap      cjswgs = 2.56E-10+dcjswg_n_cap
+mjswgs = 0.511                pbs = 0.511                   pbsws = 0.786
+pbswgs = 0.464
//** rf model related parameter ***
+xrcrg1 = 12                   xrcrg2 = 1                    rbpb = 50
+rbpd = 50                     rbps = 50                     rbdb = 50
+rbsb = 50                     gbmin = 1E-12
//*** stress effect related parameter ***
+saref = 6.1E-7                sbref = 6.1E-7                wlod = 1.37E-7
+ku0 = -3.471E-8               kvsat = 0.342                 kvth0 = 2.461E-9
+tku0 = 0.097                  llodku0 = 1                   wlodku0 = 1
+llodvth = 1                   wlodvth = 1                   lku0 = 1.23E-8
+wku0 = 9.96E-8                pku0 = 4.6E-14                lkvth0 = -2.421E-11
+wkvth0 = 0                    pkvth0 = 0                    stk2 = 3.87E-10
+lodk2 = 0.5                   steta0 = 0                    lodeta0 = 1
//*** temperature coefficient ***
+tnom = 25                     ute = -1                      kt1 = -0.18098
+kt1l = 0                      kt2 = -0.036                  ua1 = 1.04E-9
+ub1 = -4.64E-19               uc1 = 8.71E-11                at = 1.4E5
+prt = 0                       njs = 1                       njd = 1
+xtis = 3                      xtid = 3                      tpb = 1.1E-3
+tpbsw = 1.9E-3                tpbswg = 1E-3                 tcj = 6.52E-4
+tcjsw = 3.57E-4               tcjswg = 1.5E-3               tvoff = 2.2428E-3
+tvfbsdoff = 0.022
//*** well proximity effect model parameters ***
+web = -210                    wec = -3.51E3                 kvth0we = 3.270022E-3
+k2we = 1.50195E-3             ku0we = -3.001501E-3          scref = 1E-6
7:type=n  minr=1e-60
//*** flag parameter ***
+version = 4.3                 binunit = 2                   mobmod = 0
+capmod = 2                    rdsmod = 0                    igcmod = 1
+igbmod = 1                    rbodymod = 0                  trnqsmod = 0
+acnqsmod = 0                  fnoimod = 1                   tnoimod = 0
+diomod = 1                    tempmod = 0                   permod = 1
+rgatemod = 0                  wpemod = 1
//*** geometry range parameter ***
+lmin = 2E-6                   lmax = 1E-5                   wmin = 1E-6
+wmax = 2E-6
//*** process parameter ***
+epsrox = 3.9                  toxe = tox_n_cap                  toxm = tox_n_cap
+dtox = 3.15E-10               xj = 8.1E-8                   ndep = 1E17
+ngate = 1.6E20                nsd = 1E20                    rsh = 17.5
+rshg = 15.5
//*** dw and dl parameter ***
+wint = 2E-9                   wl = 0                        wln = 1
+ww = 0                        wwn = 1                       wwl = 0
+lint = 1E-9                   ll = 0                        lln = 1
+lw = 0                        lwn = 1                       lwl = 0
+llc = 0                       lwc = 0                       lwlc = 0
+wlc = 0                       wwc = 0                       wwlc = 0
+dwg = 0                       dwb = 0                       xl = 0+dxl_n_cap
+xw = 0+dxw_n_cap
//*** flicker noise model parameter ***
+noia = 2.6E42                 noib = 1.61E21                noic = 3E8
+em = 1E6                      ef = 0.94                     lintnoi = -5E-9
//***layout-dependent parasitics model parameter ***
+dmcg = 4E-8                   dmci = 4E-8                   dmdg = 0
+dmcgt = 0                     dwj = 0                       xgw = 0
+xgl = 0                       ngcon = 1
//*** vth related  parameter ***
+vth0 = 0.34925+dvth0_n_cap        lvth0 = 0+dlvth0_n_cap            wvth0 = 0+dwvth0_n_cap
+pvth0 = 0+dpvth0_n_cap            phin = 0                      k1 = 0.30264
+k2 = -0.012135                k3 = -7.284535                k3b = 2.454986
+w0 = 8.190018E-8              lpe0 = 6.610138E-8            lpeb = 2.000404E-8
+dvtp0 = 2.36094E-6            dvtp1 = 4.5                   dvt0 = 0.236381
+dvt1 = 0.537442               dvt2 = 5.56679E-2             dvt0w = 0
+dvt1w = 0                     dvt2w = 0                     vfbsdoff = 0.02
//*** mobility related parameter ***
+u0 = 1.52058E-2+du0_n_cap         lu0 = 8.653106E-11+dlu0_n_cap     wu0 = -1.732986E-10+dwu0_n_cap
+pu0 = 6.701504E-17+dpu0_n_cap     ua = -1.912987E-9             lua = -1.411386E-17
+wua = -5.804167E-19           pua = 5.803006E-24            ub = 2.253887E-18
+lub = 2.709183E-26            wub = 1.024294E-27            pub = -1.024089E-32
+uc = 6.616797E-11             ud = 0                        vsat = 1.37107E5+dvsat_n_cap
+lvsat = 0                     wvsat = 0                     pvsat = 0
+a0 = 1.930672                 la0 = -2.067598E-6            wa0 = -2.864845E-10
+pa0 = 2.864272E-15            ags = 1.062652                lags = 8.605063E-7
+b0 = 0                        b1 = 0                        keta = -6.58719E-2
+lketa = 4.167334E-8           wketa = -1.191617E-10         pketa = 1.191378E-15
+a1 = 0                        a2 = 1                        rdsw = 100.002354
+prwb = 0                      prwg = 0                      wr = 1
//*** subthreshold related parameter ***
+voff = -0.153746              voffl = -3.595178E-9          minv = -0.15
+nfactor = 1.086027            eta0 = 2.963491E-3            etab = -1.59363E-2
+dsub = 0.422235               cit = 7.212E-4                cdsc = 0
+cdscb = 0                     cdscd = 0
//*** output resistance related parameter ***
+pclm = 1.441266               pdiblc1 = 4.53031E-4          pdiblc2 = 8.662305E-3
+lpdiblc2 = -1.199355E-9       wpdiblc2 = 3.127001E-12       ppdiblc2 = -3.126376E-17
+pdiblcb = 1                   drout = 0.56                  pscbe1 = 1E9
+pscbe2 = 1E-20                pvag = 1.2                    delta = 7.595625E-3
+fprout = 300                  pdits = 0                     pditsl = 0
+pditsd = 0                    alpha0 = 2E-10                alpha1 = 0.01
+beta0 = 6.4                   agidl = 2.1505E-7             bgidl = 2.1392E9
+cgidl = 0.22                  egidl = 0.29734
//*** gate dielectric tunneling current ***
+aigbacc = 0.02                bigbacc = 2.47E-3             cigbacc = 0.3325
+nigbacc = 10                  aigbinv = 0.0158              bigbinv = 4.893E-3
+cigbinv = 6.1E-3              eigbinv = 1.1                 nigbinv = 10
+aigc = 0.0112                 bigc = 1.392E-3               cigc = 6.22E-4
+aigsd = 0.0106                bigsd = 1.235E-3              cigsd = 0.07
+dlcig = 2.48E-9               nigc = 3.07                   poxedge = 1
+pigcd = 2.591                 ntox = 1                      toxref = 3E-9
//*** capacitance parameter ***
+xpart = 1                     cgso = 5.53E-11+dcgso_n_cap       cgdo = 5.53E-11+dcgdo_n_cap
+cgbo = 0                      ckappas = 0.6                 ckappad = 0.6
+cf = 8.13E-11                 clc = 1.04E-7                 cle = 0.6
+dlc = 0                 dwc = 0                       noff = 2.96
+voffcv = -0.12                acde = 1                      moin = 5.67
+cgsl = 1.71E-11+dcgsl_n_cap       cgdl = 1.71E-11+dcgdl_n_cap
//*** souce/drain junction diode model parameter **
+ijthsrev = 0.01               ijthsfwd = 0.01               xjbvs = 1
+bvs = 10                      jss = 2.1E-7                  jsws = 3.4E-13
+jswgs = 1.2E-12               cjs = 8.61E-4+dcj_n_cap           mjs = 0.264
+mjsws = 0.011                 cjsws = 4.87E-11+dcjsw_n_cap      cjswgs = 2.56E-10+dcjswg_n_cap
+mjswgs = 0.511                pbs = 0.511                   pbsws = 0.786
+pbswgs = 0.464
//** rf model related parameter ***
+xrcrg1 = 12                   xrcrg2 = 1                    rbpb = 50
+rbpd = 50                     rbps = 50                     rbdb = 50
+rbsb = 50                     gbmin = 1E-12
//*** stress effect related parameter ***
+saref = 6.1E-7                sbref = 6.1E-7                wlod = 1.37E-7
+ku0 = -3.471E-8               kvsat = 0.342                 kvth0 = 2.461E-9
+tku0 = 0.097                  llodku0 = 1                   wlodku0 = 1
+llodvth = 1                   wlodvth = 1                   lku0 = 1.23E-8
+wku0 = 9.96E-8                pku0 = 4.6E-14                lkvth0 = -2.421E-11
+wkvth0 = 0                    pkvth0 = 0                    stk2 = 3.87E-10
+lodk2 = 0.5                   steta0 = 0                    lodeta0 = 1
//*** temperature coefficient ***
+tnom = 25                     ute = -1                      kt1 = -0.18098
+kt1l = 0                      kt2 = -0.036                  ua1 = 1.04E-9
+ub1 = -4.64E-19               uc1 = 8.71E-11                at = 1.4E5
+prt = 0                       njs = 1                       njd = 1
+xtis = 3                      xtid = 3                      tpb = 1.1E-3
+tpbsw = 1.9E-3                tpbswg = 1E-3                 tcj = 6.52E-4
+tcjsw = 3.57E-4               tcjswg = 1.5E-3               tvoff = 2.2428E-3
+tvfbsdoff = 0.022
//*** well proximity effect model parameters ***
+web = -210                    wec = -3.51E3                 kvth0we = 3.270022E-3
+k2we = 1.50195E-3             ku0we = -3.001501E-3          scref = 1E-6
8:type=n  minr=1e-60
//*** flag parameter ***
+version = 4.3                 binunit = 2                   mobmod = 0
+capmod = 2                    rdsmod = 0                    igcmod = 1
+igbmod = 1                    rbodymod = 0                  trnqsmod = 0
+acnqsmod = 0                  fnoimod = 1                   tnoimod = 0
+diomod = 1                    tempmod = 0                   permod = 1
+rgatemod = 0                  wpemod = 1
//*** geometry range parameter ***
+lmin = 1E-6                   lmax = 2E-6                   wmin = 1E-6
+wmax = 2E-6
//*** process parameter ***
+epsrox = 3.9                  toxe = tox_n_cap                  toxm = tox_n_cap
+dtox = 3.15E-10               xj = 8.1E-8                   ndep = 1E17
+ngate = 1.6E20                nsd = 1E20                    rsh = 17.5
+rshg = 15.5
//*** dw and dl parameter ***
+wint = 2E-9                   wl = 0                        wln = 1
+ww = 0                        wwn = 1                       wwl = 0
+lint = 1E-9                   ll = 0                        lln = 1
+lw = 0                        lwn = 1                       lwl = 0
+llc = 0                       lwc = 0                       lwlc = 0
+wlc = 0                       wwc = 0                       wwlc = 0
+dwg = 0                       dwb = 0                       xl = 0+dxl_n_cap
+xw = 0+dxw_n_cap
//*** flicker noise model parameter ***
+noia = 2.6E42                 noib = 1.61E21                noic = 3E8
+em = 1E6                      ef = 0.94                     lintnoi = -5E-9
//***layout-dependent parasitics model parameter ***
+dmcg = 4E-8                   dmci = 4E-8                   dmdg = 0
+dmcgt = 0                     dwj = 0                       xgw = 0
+xgl = 0                       ngcon = 1
//*** vth related  parameter ***
+vth0 = 0.347201+dvth0_n_cap       lvth0 = 4.093698E-9+dlvth0_n_cap  wvth0 = 0+dwvth0_n_cap
+pvth0 = 3.964112E-18+dpvth0_n_cap phin = 0                      k1 = 0.30264
+k2 = -0.012135                k3 = -7.284535                k3b = 2.454986
+w0 = 8.190018E-8              lpe0 = 6.610138E-8            lpeb = 2.000404E-8
+dvtp0 = 2.36094E-6            dvtp1 = 4.5                   dvt0 = 0.236381
+dvt1 = 0.537442               dvt2 = 5.56679E-2             dvt0w = 0
+dvt1w = 0                     dvt2w = 0                     vfbsdoff = 0.02
//*** mobility related parameter ***
+u0 = 1.52757E-2+du0_n_cap         lu0 = -5.317929E-11+dlu0_n_cap    wu0 = -1.052352E-10+dwu0_n_cap
+pu0 = -6.897555E-17+dpu0_n_cap    ua = -1.911737E-9             lua = -1.661135E-17
+wua = -6.280791E-18           pua = 1.719235E-23            ub = 2.273523E-18
+lub = -1.214122E-26           wub = 7.913656E-28            pub = -9.7755E-33
+uc = 6.616797E-11             ud = 0                        vsat = 1.37107E5+dvsat_n_cap
+lvsat = 0                     wvsat = 0                     pvsat = 0
+a0 = 0.572041                 la0 = 6.469475E-7             wa0 = -3.060974E-7
+pa0 = 6.138744E-13            ags = 0.261003                lags = 2.462202E-6
+wags = -7.637165E-8           pags = 1.525906E-13           b0 = 0
+b1 = 0                        keta = -2.75228E-2            lketa = -3.494802E-8
+wketa = 2.935746E-9           pketa = -4.912327E-15         a1 = 0
+a2 = 1                        rdsw = 100.002354             prwb = 0
+prwg = 0                      wr = 1
//*** subthreshold related parameter ***
+voff = -0.15424               lvoff = 9.869921E-10          wvoff = 9.9202E-12
+pvoff = -1.982056E-17         voffl = -3.595178E-9          minv = -0.15
+nfactor = 0.980141            lnfactor = 2.115606E-7        wnfactor = -2.499295E-8
+pnfactor = 4.993592E-14       eta0 = 2.963491E-3            etab = -1.59363E-2
+dsub = 0.422235               cit = 7.212E-4                cdsc = 0
+cdscb = 0                     cdscd = 0
//*** output resistance related parameter ***
+pclm = 1.441266               pdiblc1 = 4.53031E-4          pdiblc2 = 8.322699E-3
+lpdiblc2 = -5.208203E-10      wpdiblc2 = -3.432679E-10      ppdiblc2 = 6.608333E-16
+pdiblcb = 1                   drout = 0.56                  pscbe1 = 1E9
+pscbe2 = 1E-20                pvag = 1.2                    delta = 7.595625E-3
+fprout = 300                  pdits = 0                     pditsl = 0
+pditsd = 0                    alpha0 = 2E-10                alpha1 = 0.01
+beta0 = 6.4                   agidl = 2.1505E-7             bgidl = 2.1392E9
+cgidl = 0.22                  egidl = 0.29734
//*** gate dielectric tunneling current ***
+aigbacc = 0.02                bigbacc = 2.47E-3             cigbacc = 0.3325
+nigbacc = 10                  aigbinv = 0.0158              bigbinv = 4.893E-3
+cigbinv = 6.1E-3              eigbinv = 1.1                 nigbinv = 10
+aigc = 0.0112                 bigc = 1.392E-3               cigc = 6.22E-4
+aigsd = 0.0106                bigsd = 1.235E-3              cigsd = 0.07
+dlcig = 2.48E-9               nigc = 3.07                   poxedge = 1
+pigcd = 2.591                 ntox = 1                      toxref = 3E-9
//*** capacitance parameter ***
+xpart = 1                     cgso = 5.53E-11+dcgso_n_cap       cgdo = 5.53E-11+dcgdo_n_cap
+cgbo = 0                      ckappas = 0.6                 ckappad = 0.6
+cf = 8.13E-11                 clc = 1.04E-7                 cle = 0.6
+dlc = 0                 dwc = 0                       noff = 2.96
+voffcv = -0.12                acde = 1                      moin = 5.67
+cgsl = 1.71E-11+dcgsl_n_cap       cgdl = 1.71E-11+dcgdl_n_cap
//*** souce/drain junction diode model parameter **
+ijthsrev = 0.01               ijthsfwd = 0.01               xjbvs = 1
+bvs = 10                      jss = 2.1E-7                  jsws = 3.4E-13
+jswgs = 1.2E-12               cjs = 8.61E-4+dcj_n_cap           mjs = 0.264
+mjsws = 0.011                 cjsws = 4.87E-11+dcjsw_n_cap      cjswgs = 2.56E-10+dcjswg_n_cap
+mjswgs = 0.511                pbs = 0.511                   pbsws = 0.786
+pbswgs = 0.464
//** rf model related parameter ***
+xrcrg1 = 12                   xrcrg2 = 1                    rbpb = 50
+rbpd = 50                     rbps = 50                     rbdb = 50
+rbsb = 50                     gbmin = 1E-12
//*** stress effect related parameter ***
+saref = 6.1E-7                sbref = 6.1E-7                wlod = 1.37E-7
+ku0 = -3.471E-8               kvsat = 0.342                 kvth0 = 2.461E-9
+tku0 = 0.097                  llodku0 = 1                   wlodku0 = 1
+llodvth = 1                   wlodvth = 1                   lku0 = 1.23E-8
+wku0 = 9.96E-8                pku0 = 4.6E-14                lkvth0 = -2.421E-11
+wkvth0 = 0                    pkvth0 = 0                    stk2 = 3.87E-10
+lodk2 = 0.5                   steta0 = 0                    lodeta0 = 1
//*** temperature coefficient ***
+tnom = 25                     ute = -1                      kt1 = -0.18098
+kt1l = 0                      kt2 = -0.036                  ua1 = 1.04E-9
+ub1 = -4.64E-19               uc1 = 8.71E-11                at = 1.4E5
+prt = 0                       njs = 1                       njd = 1
+xtis = 3                      xtid = 3                      tpb = 1.1E-3
+tpbsw = 1.9E-3                tpbswg = 1E-3                 tcj = 6.52E-4
+tcjsw = 3.57E-4               tcjswg = 1.5E-3               tvoff = 2.2428E-3
+tvfbsdoff = 0.022
//*** well proximity effect model parameters ***
+web = -210                    wec = -3.51E3                 kvth0we = 3.270022E-3
+k2we = 1.50195E-3             ku0we = -3.001501E-3          scref = 1E-6
9:type=n  minr=1e-60
//*** flag parameter ***
+version = 4.3                 binunit = 2                   mobmod = 0
+capmod = 2                    rdsmod = 0                    igcmod = 1
+igbmod = 1                    rbodymod = 0                  trnqsmod = 0
+acnqsmod = 0                  fnoimod = 1                   tnoimod = 0
+diomod = 1                    tempmod = 0                   permod = 1
+rgatemod = 0                  wpemod = 1
//*** geometry range parameter ***
+lmin = 5E-7                   lmax = 1E-6                   wmin = 1E-6
+wmax = 2E-6
//*** process parameter ***
+epsrox = 3.9                  toxe = tox_n_cap                  toxm = tox_n_cap
+dtox = 3.15E-10               xj = 8.1E-8                   ndep = 1E17
+ngate = 1.6E20                nsd = 1E20                    rsh = 17.5
+rshg = 15.5
//*** dw and dl parameter ***
+wint = 2E-9                   wl = 0                        wln = 1
+ww = 0                        wwn = 1                       wwl = 0
+lint = 1E-9                   ll = 0                        lln = 1
+lw = 0                        lwn = 1                       lwl = 0
+llc = 0                       lwc = 0                       lwlc = 0
+wlc = 0                       wwc = 0                       wwlc = 0
+dwg = 0                       dwb = 0                       xl = 0+dxl_n_cap
+xw = 0+dxw_n_cap
//*** flicker noise model parameter ***
+noia = 2.6E42                 noib = 1.61E21                noic = 3E8
+em = 1E6                      ef = 0.94                     lintnoi = -5E-9
//***layout-dependent parasitics model parameter ***
+dmcg = 4E-8                   dmci = 4E-8                   dmdg = 0
+dmcgt = 0                     dwj = 0                       xgw = 0
+xgl = 0                       ngcon = 1
//*** vth related  parameter ***
+vth0 = 0.354115+dvth0_n_cap       lvth0 = -2.80614E-9+dlvth0_n_cap  wvth0 = 5.247249E-10+dwvth0_n_cap
+pvth0 = -5.216914E-16+dpvth0_n_cap phin = 0                      k1 = 0.30264
+k2 = -0.012135                k3 = -7.284535                k3b = 2.454986
+w0 = 8.190018E-8              lpe0 = 6.610138E-8            lpeb = 2.000404E-8
+dvtp0 = 2.36094E-6            dvtp1 = 4.5                   dvt0 = 0.236381
+dvt1 = 0.537442               dvt2 = 5.56679E-2             dvt0w = 0
+dvt1w = 0                     dvt2w = 0                     vfbsdoff = 0.02
//*** mobility related parameter ***
+u0 = 0.015143+du0_n_cap           lu0 = 7.925464E-11+dlu0_n_cap     wu0 = 1.066221E-10+dwu0_n_cap
+pu0 = -2.804091E-16+dpu0_n_cap    ua = -1.959977E-9             lua = 3.153198E-17
+wua = 5.893485E-17            pua = -4.789285E-23           ub = 2.285082E-18
+lub = -2.367677E-26           wub = -4.439737E-26           pub = 3.532286E-32
+uc = 6.616797E-11             ud = 0                        vsat = 1.37107E5+dvsat_n_cap
+lvsat = 0                     wvsat = 0                     pvsat = 0
+a0 = 0.852892                 la0 = 3.666576E-7             wa0 = 4.981766E-7
+pa0 = -1.88791E-13            ags = 0.896741                lags = 1.827735E-6
+wags = 3.172668E-7            pags = -2.402606E-13          b0 = 0
+b1 = 0                        keta = -6.25409E-2            wketa = -1.986426E-9
+a1 = 0                        a2 = 1                        rdsw = 100.002354
+prwb = 0                      prwg = 0                      wr = 1
//*** subthreshold related parameter ***
+voff = -0.15453               lvoff = 1.276756E-9           wvoff = 2.613287E-10
+pvoff = -2.707262E-16         voffl = -3.595178E-9          minv = -0.15
+nfactor = 0.9986              lnfactor = 1.931386E-7        wnfactor = 5.383515E-8
+pnfactor = -2.873453E-14      eta0 = 2.963491E-3            etab = -1.59363E-2
+dsub = 0.422235               cit = 7.212E-4                cdsc = 0
+cdscb = 0                     cdscd = 0
//*** output resistance related parameter ***
+pclm = 1.441266               pdiblc1 = 4.53031E-4          pdiblc2 = 7.576672E-3
+lpdiblc2 = 2.237144E-10       wpdiblc2 = 5.421558E-10       ppdiblc2 = -2.228195E-16
+pdiblcb = 1                   drout = 0.56                  pscbe1 = 1E9
+pscbe2 = 1E-20                pvag = 1.2                    delta = 7.595625E-3
+fprout = 300                  pdits = 0                     pditsl = 0
+pditsd = 0                    alpha0 = 2E-10                alpha1 = 0.01
+beta0 = 6.4                   agidl = 2.1505E-7             bgidl = 2.1392E9
+cgidl = 0.22                  egidl = 0.29734
//*** gate dielectric tunneling current ***
+aigbacc = 0.02                bigbacc = 2.47E-3             cigbacc = 0.3325
+nigbacc = 10                  aigbinv = 0.0158              bigbinv = 4.893E-3
+cigbinv = 6.1E-3              eigbinv = 1.1                 nigbinv = 10
+aigc = 0.0112                 bigc = 1.392E-3               cigc = 6.22E-4
+aigsd = 0.0106                bigsd = 1.235E-3              cigsd = 0.07
+dlcig = 2.48E-9               nigc = 3.07                   poxedge = 1
+pigcd = 2.591                 ntox = 1                      toxref = 3E-9
//*** capacitance parameter ***
+xpart = 1                     cgso = 5.53E-11+dcgso_n_cap       cgdo = 5.53E-11+dcgdo_n_cap
+cgbo = 0                      ckappas = 0.6                 ckappad = 0.6
+cf = 8.13E-11                 clc = 1.04E-7                 cle = 0.6
+dlc = 0                 dwc = 0                       noff = 2.96
+voffcv = -0.12                acde = 1                      moin = 5.67
+cgsl = 1.71E-11+dcgsl_n_cap       cgdl = 1.71E-11+dcgdl_n_cap
//*** souce/drain junction diode model parameter **
+ijthsrev = 0.01               ijthsfwd = 0.01               xjbvs = 1
+bvs = 10                      jss = 2.1E-7                  jsws = 3.4E-13
+jswgs = 1.2E-12               cjs = 8.61E-4+dcj_n_cap           mjs = 0.264
+mjsws = 0.011                 cjsws = 4.87E-11+dcjsw_n_cap      cjswgs = 2.56E-10+dcjswg_n_cap
+mjswgs = 0.511                pbs = 0.511                   pbsws = 0.786
+pbswgs = 0.464
//** rf model related parameter ***
+xrcrg1 = 12                   xrcrg2 = 1                    rbpb = 50
+rbpd = 50                     rbps = 50                     rbdb = 50
+rbsb = 50                     gbmin = 1E-12
//*** stress effect related parameter ***
+saref = 6.1E-7                sbref = 6.1E-7                wlod = 1.37E-7
+ku0 = -3.471E-8               kvsat = 0.342                 kvth0 = 2.461E-9
+tku0 = 0.097                  llodku0 = 1                   wlodku0 = 1
+llodvth = 1                   wlodvth = 1                   lku0 = 1.23E-8
+wku0 = 9.96E-8                pku0 = 4.6E-14                lkvth0 = -2.421E-11
+wkvth0 = 0                    pkvth0 = 0                    stk2 = 3.87E-10
+lodk2 = 0.5                   steta0 = 0                    lodeta0 = 1
//*** temperature coefficient ***
+tnom = 25                     ute = -1                      kt1 = -0.18098
+kt1l = 0                      kt2 = -0.036                  ua1 = 1.04E-9
+ub1 = -4.64E-19               uc1 = 8.71E-11                at = 1.4E5
+prt = 0                       njs = 1                       njd = 1
+xtis = 3                      xtid = 3                      tpb = 1.1E-3
+tpbsw = 1.9E-3                tpbswg = 1E-3                 tcj = 6.52E-4
+tcjsw = 3.57E-4               tcjswg = 1.5E-3               tvoff = 2.2428E-3
+tvfbsdoff = 0.022
//*** well proximity effect model parameters ***
+web = -210                    wec = -3.51E3                 kvth0we = 3.270022E-3
+k2we = 1.50195E-3             ku0we = -3.001501E-3          scref = 1E-6
10:type=n  minr=1e-60
//*** flag parameter ***
+version = 4.3                 binunit = 2                   mobmod = 0
+capmod = 2                    rdsmod = 0                    igcmod = 1
+igbmod = 1                    rbodymod = 0                  trnqsmod = 0
+acnqsmod = 0                  fnoimod = 1                   tnoimod = 0
+diomod = 1                    tempmod = 0                   permod = 1
+rgatemod = 0                  wpemod = 1
//*** geometry range parameter ***
+lmin = 1E-7                   lmax = 5E-7                   wmin = 1E-6
+wmax = 2E-6
//*** process parameter ***
+epsrox = 3.9                  toxe = tox_n_cap                  toxm = tox_n_cap
+dtox = 3.15E-10               xj = 8.1E-8                   ndep = 1E17
+ngate = 1.6E20                nsd = 1E20                    rsh = 17.5
+rshg = 15.5
//*** dw and dl parameter ***
+wint = 2E-9                   wl = 0                        wln = 1
+ww = 0                        wwn = 1                       wwl = 0
+lint = 1E-9                   ll = 0                        lln = 1
+lw = 0                        lwn = 1                       lwl = 0
+llc = 0                       lwc = 0                       lwlc = 0
+wlc = 0                       wwc = 0                       wwlc = 0
+dwg = 0                       dwb = 0                       xl = 0+dxl_n_cap
+xw = 0+dxw_n_cap
//*** flicker noise model parameter ***
+noia = 2.6E42                 noib = 1.61E21                noic = 3E8
+em = 1E6                      ef = 0.94                     lintnoi = -5E-9
//***layout-dependent parasitics model parameter ***
+dmcg = 4E-8                   dmci = 4E-8                   dmdg = 0
+dmcgt = 0                     dwj = 0                       xgw = 0
+xgl = 0                       ngcon = 1
//*** vth related  parameter ***
+vth0 = 0.348623+dvth0_n_cap       lvth0 = -7.119331E-11+dlvth0_n_cap wvth0 = -1.207173E-9+dwvth0_n_cap
+pvth0 = 3.407937E-16+dpvth0_n_cap phin = 0                      k1 = 0.30264
+k2 = -0.012135                k3 = -7.284535                k3b = 2.454986
+w0 = 8.190018E-8              lpe0 = 6.610138E-8            lpeb = 2.000404E-8
+dvtp0 = 2.36094E-6            dvtp1 = 4.5                   dvt0 = 0.236381
+dvt1 = 0.537442               dvt2 = 5.56679E-2             dvt0w = 0
+dvt1w = 0                     dvt2w = 0                     vfbsdoff = 0.02
//*** mobility related parameter ***
+u0 = 1.53686E-2+du0_n_cap         lu0 = -3.306481E-11+dlu0_n_cap    wu0 = -2.858787E-10+dwu0_n_cap
+pu0 = -8.494375E-17+dpu0_n_cap    ua = -1.899401E-9             lua = 1.365183E-18
+wua = -2.616799E-17           pua = -5.511642E-24           ub = 2.226137E-18
+lub = 5.677783E-27            wub = 3.19638E-26             pub = -2.705005E-33
+uc = 6.099261E-11             luc = 2.57733E-18             wuc = 2.774701E-18
+puc = -1.381801E-24           ud = 0                        vsat = 1.371068E5+dvsat_n_cap
+lvsat = 0                     wvsat = 0                     pvsat = 0
+a0 = 1.97825                  la0 = -1.937705E-7            wa0 = 1.482523E-7
+pa0 = -1.452873E-14           ags = 4.231225                lags = 1.671619E-7
+wags = -1.530432E-7           pags = -6.046239E-15          b0 = 0
+b1 = 0                        keta = -5.16684E-2            lketa = -5.414518E-9
+wketa = -3.346839E-8          pketa = 1.567802E-14          a1 = 0
+a2 = 1                        rdsw = 100.002354             prwb = 0
+prwg = 0                      wr = 1
//*** subthreshold related parameter ***
+voff = -0.150353              lvoff = -8.036452E-10         wvoff = -1.951138E-10
+pvoff = -4.341785E-17         voffl = -3.595178E-9          minv = -0.15
+nfactor = 1.284525            lnfactor = 5.074758E-8        wnfactor = -3.580258E-9
+pnfactor = -1.416538E-16      eta0 = 3.941531E-3            leta0 = -4.870639E-10
+weta0 = -9.741278E-10         peta0 = 4.851157E-16          etab = -0.026723
+letab = 5.371771E-9           dsub = 0.422235               cit = 7.212E-4
+cdsc = 0                      cdscb = 0                     cdscd = 0
//*** output resistance related parameter ***
+pclm = 1.441266               pdiblc1 = -2.697E-5           lpdiblc1 = 2.390405E-10
+wpdiblc1 = 4.78081E-10        ppdiblc1 = -2.380843E-16      pdiblc2 = 8.238968E-3
+lpdiblc2 = -1.061089E-10      wpdiblc2 = 6.118768E-10       ppdiblc2 = -2.575406E-16
+pdiblcb = 1                   drout = 0.56                  pscbe1 = 1E9
+pscbe2 = 1E-20                pvag = 1.2                    delta = 7.595625E-3
+fprout = 300                  pdits = 0                     pditsl = 0
+pditsd = 0                    alpha0 = 2E-10                alpha1 = 0.01
+beta0 = 6.4                   agidl = 2.1505E-7             bgidl = 2.1392E9
+cgidl = 0.22                  egidl = 0.29734
//*** gate dielectric tunneling current ***
+aigbacc = 0.02                bigbacc = 2.47E-3             cigbacc = 0.3325
+nigbacc = 10                  aigbinv = 0.0158              bigbinv = 4.893E-3
+cigbinv = 6.1E-3              eigbinv = 1.1                 nigbinv = 10
+aigc = 0.0112                 bigc = 1.392E-3               cigc = 6.22E-4
+aigsd = 0.0106                bigsd = 1.235E-3              cigsd = 0.07
+dlcig = 2.48E-9               nigc = 3.07                   poxedge = 1
+pigcd = 2.591                 ntox = 1                      toxref = 3E-9
//*** capacitance parameter ***
+xpart = 1                     cgso = 5.53E-11+dcgso_n_cap       cgdo = 5.53E-11+dcgdo_n_cap
+cgbo = 0                      ckappas = 0.6                 ckappad = 0.6
+cf = 8.13E-11                 clc = 1.04E-7                 cle = 0.6
+dlc = 0                 dwc = 0                       noff = 2.96
+voffcv = -0.12                acde = 1                      moin = 5.67
+cgsl = 1.71E-11+dcgsl_n_cap       cgdl = 1.71E-11+dcgdl_n_cap
//*** souce/drain junction diode model parameter **
+ijthsrev = 0.01               ijthsfwd = 0.01               xjbvs = 1
+bvs = 10                      jss = 2.1E-7                  jsws = 3.4E-13
+jswgs = 1.2E-12               cjs = 8.61E-4+dcj_n_cap           mjs = 0.264
+mjsws = 0.011                 cjsws = 4.87E-11+dcjsw_n_cap      cjswgs = 2.56E-10+dcjswg_n_cap
+mjswgs = 0.511                pbs = 0.511                   pbsws = 0.786
+pbswgs = 0.464
//** rf model related parameter ***
+xrcrg1 = 12                   xrcrg2 = 1                    rbpb = 50
+rbpd = 50                     rbps = 50                     rbdb = 50
+rbsb = 50                     gbmin = 1E-12
//*** stress effect related parameter ***
+saref = 6.1E-7                sbref = 6.1E-7                wlod = 1.37E-7
+ku0 = -3.471E-8               kvsat = 0.342                 kvth0 = 2.461E-9
+tku0 = 0.097                  llodku0 = 1                   wlodku0 = 1
+llodvth = 1                   wlodvth = 1                   lku0 = 1.23E-8
+wku0 = 9.96E-8                pku0 = 4.6E-14                lkvth0 = -2.421E-11
+wkvth0 = 0                    pkvth0 = 0                    stk2 = 3.87E-10
+lodk2 = 0.5                   steta0 = 0                    lodeta0 = 1
//*** temperature coefficient ***
+tnom = 25                     ute = -1                      kt1 = -0.18098
+kt1l = 0                      kt2 = -0.036                  ua1 = 1.04E-9
+ub1 = -4.64E-19               uc1 = 8.71E-11                at = 1.4E5
+prt = 0                       njs = 1                       njd = 1
+xtis = 3                      xtid = 3                      tpb = 1.1E-3
+tpbsw = 1.9E-3                tpbswg = 1E-3                 tcj = 6.52E-4
+tcjsw = 3.57E-4               tcjswg = 1.5E-3               tvoff = 2.2428E-3
+tvfbsdoff = 0.022
//*** well proximity effect model parameters ***
+web = -210                    wec = -3.51E3                 kvth0we = 3.270022E-3
+k2we = 1.50195E-3             ku0we = -3.001501E-3          scref = 1E-6
11:type=n  minr=1e-60
//*** flag parameter ***
+version = 4.3                 binunit = 2                   mobmod = 0
+capmod = 2                    rdsmod = 0                    igcmod = 1
+igbmod = 1                    rbodymod = 0                  trnqsmod = 0
+acnqsmod = 0                  fnoimod = 1                   tnoimod = 0
+diomod = 1                    tempmod = 0                   permod = 1
+rgatemod = 0                  wpemod = 1
//*** geometry range parameter ***
+lmin = 6E-8                   lmax = 1E-7                   wmin = 1E-6
+wmax = 2E-6
//*** process parameter ***
+epsrox = 3.9                  toxe = tox_n_cap                  toxm = tox_n_cap
+dtox = 3.15E-10               xj = 8.1E-8                   ndep = 1E17
+ngate = 1.6E20                nsd = 1E20                    rsh = 17.5
+rshg = 15.5
//*** dw and dl parameter ***
+wint = 2E-9                   wl = 0                        wln = 1
+ww = 0                        wwn = 1                       wwl = 0
+lint = 1E-9                   ll = 0                        lln = 1
+lw = 0                        lwn = 1                       lwl = 0
+llc = 0                       lwc = 0                       lwlc = 0
+wlc = 0                       wwc = 0                       wwlc = 0
+dwg = 0                       dwb = 0                       xl = 0+dxl_n_cap
+xw = 0+dxw_n_cap
//*** flicker noise model parameter ***
+noia = 2.6E42                 noib = 1.61E21                noic = 3E8
+em = 1E6                      ef = 0.94                     lintnoi = -5E-9
//***layout-dependent parasitics model parameter ***
+dmcg = 4E-8                   dmci = 4E-8                   dmdg = 0
+dmcgt = 0                     dwj = 0                       xgw = 0
+xgl = 0                       ngcon = 1
//*** vth related  parameter ***
+vth0 = 0.338826+dvth0_n_cap       lvth0 = 8.889634E-10+dlvth0_n_cap wvth0 = 1.621724E-9+dwvth0_n_cap
+pvth0 = 6.356184E-17+dpvth0_n_cap phin = 0                      k1 = 0.30264
+k2 = -1.270173E-3             lk2 = -1.064753E-9            wk2 = -1.082137E-8
+pk2 = 1.060494E-15            k3 = -7.284535                k3b = 2.454986
+w0 = 8.190018E-8              lpe0 = 6.610138E-8            lpeb = 2.000404E-8
+dvtp0 = 2.36094E-6            dvtp1 = 4.5                   dvt0 = 0.236381
+dvt1 = 0.537442               dvt2 = 5.56679E-2             dvt0w = 0
+dvt1w = 0                     dvt2w = 0                     vfbsdoff = 0.02
//*** mobility related parameter ***
+u0 = 1.43509E-2+du0_n_cap         lu0 = 6.666684E-11+dlu0_n_cap     wu0 = 7.539153E-10+dwu0_n_cap
+pu0 = -1.868436E-16+dpu0_n_cap    ua = -2.031672E-9             lua = 1.432769E-17
+wua = 6.659068E-17            pua = -1.460199E-23           ub = 2.303017E-18
+lub = -1.856416E-27           wub = 2.248764E-26            pub = -1.776342E-33
+uc = 1.007963E-10             luc = -1.323435E-18           wuc = -3.828017E-17
+puc = 2.641576E-24            ud = 0                        vsat = 1.37107E5+dvsat_n_cap
+lvsat = 0                     wvsat = 0                     pvsat = 0
+a0 = 1E-3                     ags = 5.936959                wags = -2.147395E-7
+b0 = 0                        b1 = 0                        keta = -0.164803
+lketa = 5.672632E-9           wketa = 1.841638E-7           pketa = -5.649941E-15
+a1 = 0                        a2 = 1                        rdsw = 100.002354
+prwb = 0                      prwg = 0                      wr = 1
//*** subthreshold related parameter ***
+voff = -0.156994              lvoff = -1.527893E-10         wvoff = -1.918038E-9
+pvoff = 1.254287E-16          voffl = -3.595178E-9          minv = -0.15
+nfactor = 0.547918            lnfactor = 1.229351E-7        wnfactor = -1.529083E-9
+pnfactor = -3.42669E-16       eta0 = -5.072269E-3           leta0 = 3.962885E-10
+weta0 = 1.204738E-8           peta0 = -7.909918E-16         etab = 9.25777E-2
+letab = -6.319699E-9          wetab = -2.022081E-8          petab = 1.98164E-15
+dsub = 0.422235               cit = 7.212E-4                cdsc = 0
+cdscb = 0                     cdscd = 0
//*** output resistance related parameter ***
+pclm = 1.441266               pdiblc1 = 7.321613E-3         lpdiblc1 = -4.811206E-10
+wpdiblc1 = -7.598517E-9       ppdiblc1 = 5.534222E-16       pdiblc2 = 7.799202E-3
+lpdiblc2 = -6.301194E-11      wpdiblc2 = -4.329896E-10      ppdiblc2 = -1.551437E-16
+pdiblcb = 1                   drout = 0.56                  pscbe1 = 1E9
+pscbe2 = 1E-20                pvag = 1.2                    delta = 7.595625E-3
+fprout = 300                  pdits = 0                     pditsl = 0
+pditsd = 0                    alpha0 = 2E-10                alpha1 = 0.01
+beta0 = 6.4                   agidl = 2.1505E-7             bgidl = 2.1392E9
+cgidl = 0.22                  egidl = 0.29734
//*** gate dielectric tunneling current ***
+aigbacc = 0.02                bigbacc = 2.47E-3             cigbacc = 0.3325
+nigbacc = 10                  aigbinv = 0.0158              bigbinv = 4.893E-3
+cigbinv = 6.1E-3              eigbinv = 1.1                 nigbinv = 10
+aigc = 0.0112                 bigc = 1.392E-3               cigc = 6.22E-4
+aigsd = 0.0106                bigsd = 1.235E-3              cigsd = 0.07
+dlcig = 2.48E-9               nigc = 3.07                   poxedge = 1
+pigcd = 2.591                 ntox = 1                      toxref = 3E-9
//*** capacitance parameter ***
+xpart = 1                     cgso = 5.53E-11+dcgso_n_cap       cgdo = 5.53E-11+dcgdo_n_cap
+cgbo = 0                      ckappas = 0.6                 ckappad = 0.6
+cf = 8.13E-11                 clc = 1.04E-7                 cle = 0.6
+dlc = 0                 dwc = 0                       noff = 2.96
+voffcv = -0.12                acde = 1                      moin = 5.67
+cgsl = 1.71E-11+dcgsl_n_cap       cgdl = 1.71E-11+dcgdl_n_cap
//*** souce/drain junction diode model parameter **
+ijthsrev = 0.01               ijthsfwd = 0.01               xjbvs = 1
+bvs = 10                      jss = 2.1E-7                  jsws = 3.4E-13
+jswgs = 1.2E-12               cjs = 8.61E-4+dcj_n_cap           mjs = 0.264
+mjsws = 0.011                 cjsws = 4.87E-11+dcjsw_n_cap      cjswgs = 2.56E-10+dcjswg_n_cap
+mjswgs = 0.511                pbs = 0.511                   pbsws = 0.786
+pbswgs = 0.464
//** rf model related parameter ***
+xrcrg1 = 12                   xrcrg2 = 1                    rbpb = 50
+rbpd = 50                     rbps = 50                     rbdb = 50
+rbsb = 50                     gbmin = 1E-12
//*** stress effect related parameter ***
+saref = 6.1E-7                sbref = 6.1E-7                wlod = 1.37E-7
+ku0 = -3.471E-8               kvsat = 0.342                 kvth0 = 2.461E-9
+tku0 = 0.097                  llodku0 = 1                   wlodku0 = 1
+llodvth = 1                   wlodvth = 1                   lku0 = 1.23E-8
+wku0 = 9.96E-8                pku0 = 4.6E-14                lkvth0 = -2.421E-11
+wkvth0 = 0                    pkvth0 = 0                    stk2 = 3.87E-10
+lodk2 = 0.5                   steta0 = 0                    lodeta0 = 1
//*** temperature coefficient ***
+tnom = 25                     ute = -1                      kt1 = -0.18098
+kt1l = 0                      kt2 = -0.036                  ua1 = 1.04E-9
+ub1 = -4.64E-19               uc1 = 8.71E-11                at = 1.4E5
+prt = 0                       njs = 1                       njd = 1
+xtis = 3                      xtid = 3                      tpb = 1.1E-3
+tpbsw = 1.9E-3                tpbswg = 1E-3                 tcj = 6.52E-4
+tcjsw = 3.57E-4               tcjswg = 1.5E-3               tvoff = 2.2428E-3
+tvfbsdoff = 0.022
//*** well proximity effect model parameters ***
+web = -210                    wec = -3.51E3                 kvth0we = 3.270022E-3
+k2we = 1.50195E-3             ku0we = -3.001501E-3          scref = 1E-6
12:type=n  minr=1e-60
//*** flag parameter ***
+version = 4.3                 binunit = 2                   mobmod = 0
+capmod = 2                    rdsmod = 0                    igcmod = 1
+igbmod = 1                    rbodymod = 0                  trnqsmod = 0
+acnqsmod = 0                  fnoimod = 1                   tnoimod = 0
+diomod = 1                    tempmod = 0                   permod = 1
+rgatemod = 0                  wpemod = 1
//*** geometry range parameter ***
+lmin = 4E-8                   lmax = 6E-8                   wmin = 1E-6
+wmax = 2E-6
//*** process parameter ***
+epsrox = 3.9                  toxe = tox_n_cap                  toxm = tox_n_cap
+dtox = 3.15E-10               xj = 8.1E-8                   ndep = 1E17
+ngate = 1.6E20                nsd = 1E20                    rsh = 17.5
+rshg = 15.5
//*** dw and dl parameter ***
+wint = 2E-9                   wl = 0                        wln = 1
+ww = 0                        wwn = 1                       wwl = 0
+lint = 1E-9                   ll = 0                        lln = 1
+lw = 0                        lwn = 1                       lwl = 0
+llc = 0                       lwc = 0                       lwlc = 0
+wlc = 0                       wwc = 0                       wwlc = 0
+dwg = 0                       dwb = 0                       xl = 0+dxl_n_cap
+xw = 0+dxw_n_cap
//*** flicker noise model parameter ***
+noia = 2.6E42                 noib = 1.61E21                noic = 3E8
+em = 1E6                      ef = 0.94                     lintnoi = -5E-9
//***layout-dependent parasitics model parameter ***
+dmcg = 4E-8                   dmci = 4E-8                   dmdg = 0
+dmcgt = 0                     dwj = 0                       xgw = 0
+xgl = 0                       ngcon = 1
//*** vth related  parameter ***
+vth0 = 0.354254+dvth0_n_cap       lvth0 = -5.87053E-12+dlvth0_n_cap wvth0 = -1.411788E-8+dwvth0_n_cap
+pvth0 = 9.764586E-16+dpvth0_n_cap phin = 0                      k1 = 0.30264
+k2 = -2.10085E-2              lk2 = 8.007246E-11            wk2 = -4.433707E-9
+pk2 = 6.900097E-16            k3 = -7.284535                k3b = 2.454986
+w0 = 8.190018E-8              lpe0 = 6.610138E-8            lpeb = 2.000404E-8
+dvtp0 = 2.36094E-6            dvtp1 = 4.5                   dvt0 = 0.236381
+dvt1 = 0.537442               dvt2 = 5.56679E-2             dvt0w = 0
+dvt1w = 0                     dvt2w = 0                     vfbsdoff = 0.02
//*** mobility related parameter ***
+u0 = 2.32553E-2+du0_n_cap         lu0 = -4.497874E-10+dlu0_n_cap    wu0 = -8.081245E-9+dwu0_n_cap
+pu0 = 3.255957E-16+dpu0_n_cap     ua = -1.204502E-9             lua = -3.364816E-17
+wua = -7.336254E-16           pua = 3.181054E-23            ub = 2.13422E-18
+lub = 7.933776E-27            wub = 1.67185E-25             pub = -1.016879E-32
+uc = 7.797849E-11             wuc = 7.26425E-18             ud = 0
+vsat = 1.238074E5+dvsat_n_cap     lvsat = 7.71378E-4            wvsat = -2.190794E-6
+pvsat = 1.27066E-13           a0 = 1E-3                     ags = 5.936959
+wags = -2.147395E-7           b0 = 0                        b1 = 0
+keta = -6.69986E-2            wketa = 8.675105E-8           a1 = 0
+a2 = 1                        rdsw = 100.002354             prwb = 0
+prwg = 0                      wr = 1
//*** subthreshold related parameter ***
+voff = -0.156783              lvoff = -1.650571E-10         wvoff = -8.924204E-10
+pvoff = 6.594289E-17          voffl = -3.595178E-9          minv = -0.15
+nfactor = 0.234741            lnfactor = 1.410994E-7        wnfactor = -6.570393E-10
+pnfactor = -3.932475E-16      eta0 = 1.760291E-3            weta0 = -1.590413E-9
+etab = -1.13964E-2            letab = -2.891974E-10         wetab = 4.110453E-8
+petab = -1.57523E-15          dsub = 0.422235               cit = 7.212E-4
+cdsc = 0                      cdscb = 0                     cdscd = 0
//*** output resistance related parameter ***
+pclm = 1.441266               pdiblc1 = -1.01684E-2         lpdiblc1 = 5.332986E-10
+wpdiblc1 = -1.724596E-10      ppdiblc1 = 1.227109E-16       pdiblc2 = 2.88314E-3
+lpdiblc2 = 2.221197E-10       wpdiblc2 = -1.329686E-9       ppdiblc2 = -1.031353E-16
+pdiblcb = 1                   drout = 0.767707              ldrout = -1.204703E-8
+wdrout = -1.580091E-7         pdrout = 9.164528E-15         pscbe1 = 1E9
+pscbe2 = 1E-20                pvag = 1.2                    delta = 7.595625E-3
+fprout = 300                  pdits = 0                     pditsl = 0
+pditsd = 0                    alpha0 = 2E-10                alpha1 = 0.01
+beta0 = 6.4                   agidl = 2.1505E-7             bgidl = 2.1392E9
+cgidl = 0.22                  egidl = 0.29734
//*** gate dielectric tunneling current ***
+aigbacc = 0.02                bigbacc = 2.47E-3             cigbacc = 0.3325
+nigbacc = 10                  aigbinv = 0.0158              bigbinv = 4.893E-3
+cigbinv = 6.1E-3              eigbinv = 1.1                 nigbinv = 10
+aigc = 0.0112                 bigc = 1.392E-3               cigc = 6.22E-4
+aigsd = 0.0106                bigsd = 1.235E-3              cigsd = 0.07
+dlcig = 2.48E-9               nigc = 3.07                   poxedge = 1
+pigcd = 2.591                 ntox = 1                      toxref = 3E-9
//*** capacitance parameter ***
+xpart = 1                     cgso = 5.53E-11+dcgso_n_cap       cgdo = 5.53E-11+dcgdo_n_cap
+cgbo = 0                      ckappas = 0.6                 ckappad = 0.6
+cf = 8.13E-11                 clc = 1.04E-7                 cle = 0.6
+dlc = 0                 dwc = 0                       noff = 2.96
+voffcv = -0.12                acde = 1                      moin = 5.67
+cgsl = 1.71E-11+dcgsl_n_cap       cgdl = 1.71E-11+dcgdl_n_cap
//*** souce/drain junction diode model parameter **
+ijthsrev = 0.01               ijthsfwd = 0.01               xjbvs = 1
+bvs = 10                      jss = 2.1E-7                  jsws = 3.4E-13
+jswgs = 1.2E-12               cjs = 8.61E-4+dcj_n_cap           mjs = 0.264
+mjsws = 0.011                 cjsws = 4.87E-11+dcjsw_n_cap      cjswgs = 2.56E-10+dcjswg_n_cap
+mjswgs = 0.511                pbs = 0.511                   pbsws = 0.786
+pbswgs = 0.464
//** rf model related parameter ***
+xrcrg1 = 12                   xrcrg2 = 1                    rbpb = 50
+rbpd = 50                     rbps = 50                     rbdb = 50
+rbsb = 50                     gbmin = 1E-12
//*** stress effect related parameter ***
+saref = 6.1E-7                sbref = 6.1E-7                wlod = 1.37E-7
+ku0 = -3.471E-8               kvsat = 0.342                 kvth0 = 2.461E-9
+tku0 = 0.097                  llodku0 = 1                   wlodku0 = 1
+llodvth = 1                   wlodvth = 1                   lku0 = 1.23E-8
+wku0 = 9.96E-8                pku0 = 4.6E-14                lkvth0 = -2.421E-11
+wkvth0 = 0                    pkvth0 = 0                    stk2 = 3.87E-10
+lodk2 = 0.5                   steta0 = 0                    lodeta0 = 1
//*** temperature coefficient ***
+tnom = 25                     ute = -1                      kt1 = -0.18098
+kt1l = 0                      kt2 = -0.036                  ua1 = 1.04E-9
+ub1 = -4.64E-19               uc1 = 8.71E-11                at = 1.4E5
+prt = 0                       njs = 1                       njd = 1
+xtis = 3                      xtid = 3                      tpb = 1.1E-3
+tpbsw = 1.9E-3                tpbswg = 1E-3                 tcj = 6.52E-4
+tcjsw = 3.57E-4               tcjswg = 1.5E-3               tvoff = 2.2428E-3
+tvfbsdoff = 0.022
//*** well proximity effect model parameters ***
+web = -210                    wec = -3.51E3                 kvth0we = 3.270022E-3
+k2we = 1.50195E-3             ku0we = -3.001501E-3          scref = 1E-6
13:type=n  minr=1e-60
//*** flag parameter ***
+version = 4.3                 binunit = 2                   mobmod = 0
+capmod = 2                    rdsmod = 0                    igcmod = 1
+igbmod = 1                    rbodymod = 0                  trnqsmod = 0
+acnqsmod = 0                  fnoimod = 1                   tnoimod = 0
+diomod = 1                    tempmod = 0                   permod = 1
+rgatemod = 0                  wpemod = 1
//*** geometry range parameter ***
+lmin = 2E-6                   lmax = 1E-5                   wmin = 5E-7
+wmax = 1E-6
//*** process parameter ***
+epsrox = 3.9                  toxe = tox_n_cap                  toxm = tox_n_cap
+dtox = 3.15E-10               xj = 8.1E-8                   ndep = 1E17
+ngate = 1.6E20                nsd = 1E20                    rsh = 17.5
+rshg = 15.5
//*** dw and dl parameter ***
+wint = 2E-9                   wl = 0                        wln = 1
+ww = 0                        wwn = 1                       wwl = 0
+lint = 1E-9                   ll = 0                        lln = 1
+lw = 0                        lwn = 1                       lwl = 0
+llc = 0                       lwc = 0                       lwlc = 0
+wlc = 0                       wwc = 0                       wwlc = 0
+dwg = 0                       dwb = 0                       xl = 0+dxl_n_cap
+xw = 0+dxw_n_cap
//*** flicker noise model parameter ***
+noia = 2.6E42                 noib = 1.61E21                noic = 3E8
+em = 1E6                      ef = 0.94                     lintnoi = -5E-9
//***layout-dependent parasitics model parameter ***
+dmcg = 4E-8                   dmci = 4E-8                   dmdg = 0
+dmcgt = 0                     dwj = 0                       xgw = 0
+xgl = 0                       ngcon = 1
//*** vth related  parameter ***
+vth0 = 0.34925+dvth0_n_cap        lvth0 = 0+dlvth0_n_cap            wvth0 = 0+dwvth0_n_cap
+pvth0 = 0+dpvth0_n_cap            phin = 0                      k1 = 0.30264
+k2 = -1.37822E-2              wk2 = 1.640627E-9             k3 = -7.284535
+k3b = 2.454986                w0 = 8.190018E-8              lpe0 = 6.610138E-8
+lpeb = 2.000404E-8            dvtp0 = 2.36094E-6            dvtp1 = 4.5
+dvt0 = 0.236381               dvt1 = 0.537442               dvt2 = 5.56679E-2
+dvt0w = 0                     dvt1w = 0                     dvt2w = 0
+vfbsdoff = 0.02
//*** mobility related parameter ***
+u0 = 1.51313E-2+du0_n_cap         lu0 = -5.040825E-10+dlu0_n_cap    wu0 = -9.913281E-11+dwu0_n_cap
+pu0 = 6.552661E-16+dpu0_n_cap     ua = -1.898517E-9             lua = -1.255994E-16
+wua = -1.499256E-17           pua = 1.168426E-22            ub = 2.219652E-18
+lub = 1.417534E-25            wub = 3.512221E-26            pub = -1.244438E-31
+uc = 6.616797E-11             ud = 0                        vsat = 1.37107E5+dvsat_n_cap
+lvsat = 0                     wvsat = 0                     pvsat = 0
+a0 = 2.040554                 la0 = -3.166193E-6            wa0 = -1.097284E-7
+pa0 = 1.097065E-12            ags = 1.062652                lags = 8.605063E-7
+b0 = 0                        b1 = 0                        keta = -6.64279E-2
+lketa = 4.723253E-8           wketa = 4.346448E-10          pketa = -4.345579E-15
+a1 = 0                        a2 = 1                        rdsw = 100.002354
+prwb = 0                      prwg = 0                      wr = 1
//*** subthreshold related parameter ***
+voff = -0.153675              lvoff = -7.08429E-10          wvoff = -7.057364E-11
+pvoff = 7.055953E-16          voffl = -3.595178E-9          minv = -0.15
+nfactor = 1.086027            eta0 = 2.963491E-3            etab = -1.59363E-2
+dsub = 0.422235               cit = 7.212E-4                cdsc = 0
+cdscb = 0                     cdscd = 0
//*** output resistance related parameter ***
+pclm = 1.441266               pdiblc1 = 4.53031E-4          pdiblc2 = 8.708636E-3
+lpdiblc2 = -1.662569E-9       wpdiblc2 = -4.301834E-11      ppdiblc2 = 4.300973E-16
+pdiblcb = 1                   drout = 0.56                  pscbe1 = 1E9
+pscbe2 = 1E-20                pvag = 1.2                    delta = 7.595625E-3
+fprout = 300                  pdits = 0                     pditsl = 0
+pditsd = 0                    alpha0 = 2E-10                alpha1 = 0.01
+beta0 = 6.4                   agidl = 2.1505E-7             bgidl = 2.1392E9
+cgidl = 0.22                  egidl = 0.29734
//*** gate dielectric tunneling current ***
+aigbacc = 0.02                bigbacc = 2.47E-3             cigbacc = 0.3325
+nigbacc = 10                  aigbinv = 0.0158              bigbinv = 4.893E-3
+cigbinv = 6.1E-3              eigbinv = 1.1                 nigbinv = 10
+aigc = 0.0112                 bigc = 1.392E-3               cigc = 6.22E-4
+aigsd = 0.0106                bigsd = 1.235E-3              cigsd = 0.07
+dlcig = 2.48E-9               nigc = 3.07                   poxedge = 1
+pigcd = 2.591                 ntox = 1                      toxref = 3E-9
//*** capacitance parameter ***
+xpart = 1                     cgso = 5.53E-11+dcgso_n_cap       cgdo = 5.53E-11+dcgdo_n_cap
+cgbo = 0                      ckappas = 0.6                 ckappad = 0.6
+cf = 8.13E-11                 clc = 1.04E-7                 cle = 0.6
+dlc = 0                 dwc = 0                       noff = 2.96
+voffcv = -0.12                acde = 1                      moin = 5.67
+cgsl = 1.71E-11+dcgsl_n_cap       cgdl = 1.71E-11+dcgdl_n_cap
//*** souce/drain junction diode model parameter **
+ijthsrev = 0.01               ijthsfwd = 0.01               xjbvs = 1
+bvs = 10                      jss = 2.1E-7                  jsws = 3.4E-13
+jswgs = 1.2E-12               cjs = 8.61E-4+dcj_n_cap           mjs = 0.264
+mjsws = 0.011                 cjsws = 4.87E-11+dcjsw_n_cap      cjswgs = 2.56E-10+dcjswg_n_cap
+mjswgs = 0.511                pbs = 0.511                   pbsws = 0.786
+pbswgs = 0.464
//** rf model related parameter ***
+xrcrg1 = 12                   xrcrg2 = 1                    rbpb = 50
+rbpd = 50                     rbps = 50                     rbdb = 50
+rbsb = 50                     gbmin = 1E-12
//*** stress effect related parameter ***
+saref = 6.1E-7                sbref = 6.1E-7                wlod = 1.37E-7
+ku0 = -3.471E-8               kvsat = 0.342                 kvth0 = 2.461E-9
+tku0 = 0.097                  llodku0 = 1                   wlodku0 = 1
+llodvth = 1                   wlodvth = 1                   lku0 = 1.23E-8
+wku0 = 9.96E-8                pku0 = 4.6E-14                lkvth0 = -2.421E-11
+wkvth0 = 0                    pkvth0 = 0                    stk2 = 3.87E-10
+lodk2 = 0.5                   steta0 = 0                    lodeta0 = 1
//*** temperature coefficient ***
+tnom = 25                     ute = -1                      kt1 = -0.18098
+kt1l = 0                      kt2 = -0.036                  ua1 = 1.04E-9
+ub1 = -4.64E-19               uc1 = 8.71E-11                at = 1.4E5
+prt = 0                       njs = 1                       njd = 1
+xtis = 3                      xtid = 3                      tpb = 1.1E-3
+tpbsw = 1.9E-3                tpbswg = 1E-3                 tcj = 6.52E-4
+tcjsw = 3.57E-4               tcjswg = 1.5E-3               tvoff = 2.2428E-3
+tvfbsdoff = 0.022
//*** well proximity effect model parameters ***
+web = -210                    wec = -3.51E3                 kvth0we = 3.270022E-3
+k2we = 1.50195E-3             ku0we = -3.001501E-3          scref = 1E-6
14:type=n  minr=1e-60
//*** flag parameter ***
+version = 4.3                 binunit = 2                   mobmod = 0
+capmod = 2                    rdsmod = 0                    igcmod = 1
+igbmod = 1                    rbodymod = 0                  trnqsmod = 0
+acnqsmod = 0                  fnoimod = 1                   tnoimod = 0
+diomod = 1                    tempmod = 0                   permod = 1
+rgatemod = 0                  wpemod = 1
//*** geometry range parameter ***
+lmin = 1E-6                   lmax = 2E-6                   wmin = 5E-7
+wmax = 1E-6
//*** process parameter ***
+epsrox = 3.9                  toxe = tox_n_cap                  toxm = tox_n_cap
+dtox = 3.15E-10               xj = 8.1E-8                   ndep = 1E17
+ngate = 1.6E20                nsd = 1E20                    rsh = 17.5
+rshg = 15.5
//*** dw and dl parameter ***
+wint = 2E-9                   wl = 0                        wln = 1
+ww = 0                        wwn = 1                       wwl = 0
+lint = 1E-9                   ll = 0                        lln = 1
+lw = 0                        lwn = 1                       lwl = 0
+llc = 0                       lwc = 0                       lwlc = 0
+wlc = 0                       wwc = 0                       wwlc = 0
+dwg = 0                       dwb = 0                       xl = 0+dxl_n_cap
+xw = 0+dxw_n_cap
//*** flicker noise model parameter ***
+noia = 2.6E42                 noib = 1.61E21                noic = 3E8
+em = 1E6                      ef = 0.94                     lintnoi = -5E-9
//***layout-dependent parasitics model parameter ***
+dmcg = 4E-8                   dmci = 4E-8                   dmdg = 0
+dmcgt = 0                     dwj = 0                       xgw = 0
+xgl = 0                       ngcon = 1
//*** vth related  parameter ***
+vth0 = 0.346552+dvth0_n_cap       lvth0 = 5.391324E-9+dlvth0_n_cap  wvth0 = 6.448806E-10+dwvth0_n_cap
+pvth0 = -1.288471E-15+dpvth0_n_cap phin = 0                      k1 = 0.30264
+k2 = -1.57781E-2              lk2 = 3.987753E-9             wk2 = 3.628516E-9
+pk2 = -3.971802E-15           k3 = -7.284535                k3b = 2.454986
+w0 = 8.190018E-8              lpe0 = 6.610138E-8            lpeb = 2.000404E-8
+dvtp0 = 2.36094E-6            dvtp1 = 4.5                   dvt0 = 0.236381
+dvt1 = 0.537442               dvt2 = 5.56679E-2             dvt0w = 0
+dvt1w = 0                     dvt2w = 0                     vfbsdoff = 0.02
//*** mobility related parameter ***
+u0 = 1.49573E-2+du0_n_cap         lu0 = -1.562565E-10+dlu0_n_cap    wu0 = 2.119667E-10+dwu0_n_cap
+pu0 = 3.368939E-17+dpu0_n_cap     ua = -1.971699E-9             lua = 2.061848E-17
+wua = 5.344148E-17            pua = -1.988856E-23           ub = 2.318703E-18
+lub = -5.615056E-26           wub = -4.420794E-26           pub = 3.405781E-32
+uc = 6.616797E-11             ud = 0                        vsat = 1.37107E5+dvsat_n_cap
+lvsat = 0                     wvsat = 0                     pvsat = 0
+a0 = -0.40514                 la0 = 1.720302E-6             wa0 = 6.671745E-7
+pa0 = -4.55187E-13            ags = 2.21022E-2              lags = 2.939525E-6
+wags = 1.615732E-7            pags = -3.228232E-13          b0 = 0
+b1 = 0                        keta = -0.022828              lketa = -3.988008E-8
+wketa = -1.74032E-9           a1 = 0                        a2 = 1
+rdsw = 100.002354             prwb = 0                      prwg = 0
+wr = 1
//*** subthreshold related parameter ***
+voff = -0.154994              lvoff = 1.926447E-9           wvoff = 7.608143E-10
+pvoff = -9.555178E-16         voffl = -3.595178E-9          minv = -0.15
+nfactor = 0.943029            lnfactor = 2.857106E-7        wnfactor = 1.197072E-8
+pnfactor = -2.39175E-14       eta0 = 2.963491E-3            etab = -1.59363E-2
+dsub = 0.422235               cit = 7.212E-4                cdsc = 0
+cdscb = 0                     cdscd = 0
//*** output resistance related parameter ***
+pclm = 1.441266               pdiblc1 = 4.53031E-4          pdiblc2 = 7.830016E-3
+lpdiblc2 = 9.291504E-11       wpdiblc2 = 1.474443E-10       ppdiblc2 = 4.955296E-17
+pdiblcb = 1                   drout = 0.56                  pscbe1 = 1E9
+pscbe2 = 1E-20                pvag = 1.2                    delta = 7.595625E-3
+fprout = 300                  pdits = 0                     pditsl = 0
+pditsd = 0                    alpha0 = 2E-10                alpha1 = 0.01
+beta0 = 6.4                   agidl = 2.1505E-7             bgidl = 2.1392E9
+cgidl = 0.22                  egidl = 0.29734
//*** gate dielectric tunneling current ***
+aigbacc = 0.02                bigbacc = 2.47E-3             cigbacc = 0.3325
+nigbacc = 10                  aigbinv = 0.0158              bigbinv = 4.893E-3
+cigbinv = 6.1E-3              eigbinv = 1.1                 nigbinv = 10
+aigc = 0.0112                 bigc = 1.392E-3               cigc = 6.22E-4
+aigsd = 0.0106                bigsd = 1.235E-3              cigsd = 0.07
+dlcig = 2.48E-9               nigc = 3.07                   poxedge = 1
+pigcd = 2.591                 ntox = 1                      toxref = 3E-9
//*** capacitance parameter ***
+xpart = 1                     cgso = 5.53E-11+dcgso_n_cap       cgdo = 5.53E-11+dcgdo_n_cap
+cgbo = 0                      ckappas = 0.6                 ckappad = 0.6
+cf = 8.13E-11                 clc = 1.04E-7                 cle = 0.6
+dlc = 0                 dwc = 0                       noff = 2.96
+voffcv = -0.12                acde = 1                      moin = 5.67
+cgsl = 1.71E-11+dcgsl_n_cap       cgdl = 1.71E-11+dcgdl_n_cap
//*** souce/drain junction diode model parameter **
+ijthsrev = 0.01               ijthsfwd = 0.01               xjbvs = 1
+bvs = 10                      jss = 2.1E-7                  jsws = 3.4E-13
+jswgs = 1.2E-12               cjs = 8.61E-4+dcj_n_cap           mjs = 0.264
+mjsws = 0.011                 cjsws = 4.87E-11+dcjsw_n_cap      cjswgs = 2.56E-10+dcjswg_n_cap
+mjswgs = 0.511                pbs = 0.511                   pbsws = 0.786
+pbswgs = 0.464
//** rf model related parameter ***
+xrcrg1 = 12                   xrcrg2 = 1                    rbpb = 50
+rbpd = 50                     rbps = 50                     rbdb = 50
+rbsb = 50                     gbmin = 1E-12
//*** stress effect related parameter ***
+saref = 6.1E-7                sbref = 6.1E-7                wlod = 1.37E-7
+ku0 = -3.471E-8               kvsat = 0.342                 kvth0 = 2.461E-9
+tku0 = 0.097                  llodku0 = 1                   wlodku0 = 1
+llodvth = 1                   wlodvth = 1                   lku0 = 1.23E-8
+wku0 = 9.96E-8                pku0 = 4.6E-14                lkvth0 = -2.421E-11
+wkvth0 = 0                    pkvth0 = 0                    stk2 = 3.87E-10
+lodk2 = 0.5                   steta0 = 0                    lodeta0 = 1
//*** temperature coefficient ***
+tnom = 25                     ute = -1                      kt1 = -0.18098
+kt1l = 0                      kt2 = -0.036                  ua1 = 1.04E-9
+ub1 = -4.64E-19               uc1 = 8.71E-11                at = 1.4E5
+prt = 0                       njs = 1                       njd = 1
+xtis = 3                      xtid = 3                      tpb = 1.1E-3
+tpbsw = 1.9E-3                tpbswg = 1E-3                 tcj = 6.52E-4
+tcjsw = 3.57E-4               tcjswg = 1.5E-3               tvoff = 2.2428E-3
+tvfbsdoff = 0.022
//*** well proximity effect model parameters ***
+web = -210                    wec = -3.51E3                 kvth0we = 3.270022E-3
+k2we = 1.50195E-3             ku0we = -3.001501E-3          scref = 1E-6
15:type=n  minr=1e-60
//*** flag parameter ***
+version = 4.3                 binunit = 2                   mobmod = 0
+capmod = 2                    rdsmod = 0                    igcmod = 1
+igbmod = 1                    rbodymod = 0                  trnqsmod = 0
+acnqsmod = 0                  fnoimod = 1                   tnoimod = 0
+diomod = 1                    tempmod = 0                   permod = 1
+rgatemod = 0                  wpemod = 1
//*** geometry range parameter ***
+lmin = 5E-7                   lmax = 1E-6                   wmin = 5E-7
+wmax = 1E-6
//*** process parameter ***
+epsrox = 3.9                  toxe = tox_n_cap                  toxm = tox_n_cap
+dtox = 3.15E-10               xj = 8.1E-8                   ndep = 1E17
+ngate = 1.6E20                nsd = 1E20                    rsh = 17.5
+rshg = 15.5
//*** dw and dl parameter ***
+wint = 2E-9                   wl = 0                        wln = 1
+ww = 0                        wwn = 1                       wwl = 0
+lint = 1E-9                   ll = 0                        lln = 1
+lw = 0                        lwn = 1                       lwl = 0
+llc = 0                       lwc = 0                       lwlc = 0
+wlc = 0                       wwc = 0                       wwlc = 0
+dwg = 0                       dwb = 0                       xl = 0+dxl_n_cap
+xw = 0+dxw_n_cap
//*** flicker noise model parameter ***
+noia = 2.6E42                 noib = 1.61E21                noic = 3E8
+em = 1E6                      ef = 0.94                     lintnoi = -5E-9
//***layout-dependent parasitics model parameter ***
+dmcg = 4E-8                   dmci = 4E-8                   dmdg = 0
+dmcgt = 0                     dwj = 0                       xgw = 0
+xgl = 0                       ngcon = 1
//*** vth related  parameter ***
+vth0 = 0.356799+dvth0_n_cap       lvth0 = -4.835634E-9+dlvth0_n_cap wvth0 = -2.148863E-9+dwvth0_n_cap
+pvth0 = 1.499685E-15+dpvth0_n_cap phin = 0                      k1 = 0.30264
+k2 = -1.17823E-2              wk2 = -3.512454E-10           k3 = -7.284535
+k3b = 2.454986                w0 = 8.190018E-8              lpe0 = 6.610138E-8
+lpeb = 2.000404E-8            dvtp0 = 2.36094E-6            dvtp1 = 4.5
+dvt0 = 0.236381               dvt1 = 0.537442               dvt2 = 5.56679E-2
+dvt0w = 0                     dvt1w = 0                     dvt2w = 0
+vfbsdoff = 0.02
//*** mobility related parameter ***
+u0 = 1.55148E-2+du0_n_cap         lu0 = -7.126632E-10+dlu0_n_cap    wu0 = -2.636362E-10+dwu0_n_cap
+pu0 = 5.08341E-16+dpu0_n_cap      ua = -1.871537E-9             lua = -7.934329E-17
+wua = -2.915118E-17           pua = 6.253891E-23            ub = 2.210337E-18
+lub = 5.19993E-26             wub = 3.00489E-26             pub = -4.005052E-32
+uc = 6.616797E-11             ud = 0                        vsat = 1.37107E5+dvsat_n_cap
+lvsat = 0                     wvsat = 0                     pvsat = 0
+a0 = 0.941253                 la0 = 3.766023E-7             wa0 = 4.101694E-7
+pa0 = -1.986959E-13           ags = 1.534856                lags = 1.429796E-6
+wags = -3.182958E-7           pags = 1.56086E-13            b0 = 0
+b1 = 0                        keta = -0.062788              wketa = -1.74032E-9
+a1 = 0                        a2 = 1                        rdsw = 100.002354
+prwb = 0                      prwg = 0                      wr = 1
//*** subthreshold related parameter ***
+voff = -0.15423               lvoff = 1.163697E-9           wvoff = -3.818151E-11
+pvoff = -1.5812E-16           voffl = -3.595178E-9          minv = -0.15
+nfactor = 1.067339            lnfactor = 1.61649E-7         wnfactor = -1.462909E-8
+pnfactor = 2.629113E-15       eta0 = 2.963491E-3            etab = -1.59363E-2
+dsub = 0.422235               cit = 7.212E-4                cdsc = 0
+cdscb = 0                     cdscd = 0
//*** output resistance related parameter ***
+pclm = 1.441266               pdiblc1 = 4.53031E-4          pdiblc2 = 7.664712E-3
+lpdiblc2 = 2.578881E-10       wpdiblc2 = 4.544679E-10       ppdiblc2 = -2.568566E-16
+pdiblcb = 1                   drout = 0.56                  pscbe1 = 1E9
+pscbe2 = 1E-20                pvag = 1.2                    delta = 7.595625E-3
+fprout = 300                  pdits = 0                     pditsl = 0
+pditsd = 0                    alpha0 = 2E-10                alpha1 = 0.01
+beta0 = 6.4                   agidl = 2.1505E-7             bgidl = 2.1392E9
+cgidl = 0.22                  egidl = 0.29734
//*** gate dielectric tunneling current ***
+aigbacc = 0.02                bigbacc = 2.47E-3             cigbacc = 0.3325
+nigbacc = 10                  aigbinv = 0.0158              bigbinv = 4.893E-3
+cigbinv = 6.1E-3              eigbinv = 1.1                 nigbinv = 10
+aigc = 0.0112                 bigc = 1.392E-3               cigc = 6.22E-4
+aigsd = 0.0106                bigsd = 1.235E-3              cigsd = 0.07
+dlcig = 2.48E-9               nigc = 3.07                   poxedge = 1
+pigcd = 2.591                 ntox = 1                      toxref = 3E-9
//*** capacitance parameter ***
+xpart = 1                     cgso = 5.53E-11+dcgso_n_cap       cgdo = 5.53E-11+dcgdo_n_cap
+cgbo = 0                      ckappas = 0.6                 ckappad = 0.6
+cf = 8.13E-11                 clc = 1.04E-7                 cle = 0.6
+dlc = 0                 dwc = 0                       noff = 2.96
+voffcv = -0.12                acde = 1                      moin = 5.67
+cgsl = 1.71E-11+dcgsl_n_cap       cgdl = 1.71E-11+dcgdl_n_cap
//*** souce/drain junction diode model parameter **
+ijthsrev = 0.01               ijthsfwd = 0.01               xjbvs = 1
+bvs = 10                      jss = 2.1E-7                  jsws = 3.4E-13
+jswgs = 1.2E-12               cjs = 8.61E-4+dcj_n_cap           mjs = 0.264
+mjsws = 0.011                 cjsws = 4.87E-11+dcjsw_n_cap      cjswgs = 2.56E-10+dcjswg_n_cap
+mjswgs = 0.511                pbs = 0.511                   pbsws = 0.786
+pbswgs = 0.464
//** rf model related parameter ***
+xrcrg1 = 12                   xrcrg2 = 1                    rbpb = 50
+rbpd = 50                     rbps = 50                     rbdb = 50
+rbsb = 50                     gbmin = 1E-12
//*** stress effect related parameter ***
+saref = 6.1E-7                sbref = 6.1E-7                wlod = 1.37E-7
+ku0 = -3.471E-8               kvsat = 0.342                 kvth0 = 2.461E-9
+tku0 = 0.097                  llodku0 = 1                   wlodku0 = 1
+llodvth = 1                   wlodvth = 1                   lku0 = 1.23E-8
+wku0 = 9.96E-8                pku0 = 4.6E-14                lkvth0 = -2.421E-11
+wkvth0 = 0                    pkvth0 = 0                    stk2 = 3.87E-10
+lodk2 = 0.5                   steta0 = 0                    lodeta0 = 1
//*** temperature coefficient ***
+tnom = 25                     ute = -1                      kt1 = -0.18098
+kt1l = 0                      kt2 = -0.036                  ua1 = 1.04E-9
+ub1 = -4.64E-19               uc1 = 8.71E-11                at = 1.4E5
+prt = 0                       njs = 1                       njd = 1
+xtis = 3                      xtid = 3                      tpb = 1.1E-3
+tpbsw = 1.9E-3                tpbswg = 1E-3                 tcj = 6.52E-4
+tcjsw = 3.57E-4               tcjswg = 1.5E-3               tvoff = 2.2428E-3
+tvfbsdoff = 0.022
//*** well proximity effect model parameters ***
+web = -210                    wec = -3.51E3                 kvth0we = 3.270022E-3
+k2we = 1.50195E-3             ku0we = -3.001501E-3          scref = 1E-6
16:type=n  minr=1e-60
//*** flag parameter ***
+version = 4.3                 binunit = 2                   mobmod = 0
+capmod = 2                    rdsmod = 0                    igcmod = 1
+igbmod = 1                    rbodymod = 0                  trnqsmod = 0
+acnqsmod = 0                  fnoimod = 1                   tnoimod = 0
+diomod = 1                    tempmod = 0                   permod = 1
+rgatemod = 0                  wpemod = 1
//*** geometry range parameter ***
+lmin = 1E-7                   lmax = 5E-7                   wmin = 5E-7
+wmax = 1E-6
//*** process parameter ***
+epsrox = 3.9                  toxe = tox_n_cap                  toxm = tox_n_cap
+dtox = 3.15E-10               xj = 8.1E-8                   ndep = 1E17
+ngate = 1.6E20                nsd = 1E20                    rsh = 17.5
+rshg = 15.5
//*** dw and dl parameter ***
+wint = 2E-9                   wl = 0                        wln = 1
+ww = 0                        wwn = 1                       wwl = 0
+lint = 1E-9                   ll = 0                        lln = 1
+lw = 0                        lwn = 1                       lwl = 0
+llc = 0                       lwc = 0                       lwlc = 0
+wlc = 0                       wwc = 0                       wwlc = 0
+dwg = 0                       dwb = 0                       xl = 0+dxl_n_cap
+xw = 0+dxw_n_cap
//*** flicker noise model parameter ***
+noia = 2.6E42                 noib = 1.61E21                noic = 3E8
+em = 1E6                      ef = 0.94                     lintnoi = -5E-9
//***layout-dependent parasitics model parameter ***
+dmcg = 4E-8                   dmci = 4E-8                   dmdg = 0
+dmcgt = 0                     dwj = 0                       xgw = 0
+xgl = 0                       ngcon = 1
//*** vth related  parameter ***
+vth0 = 0.347058+dvth0_n_cap       lvth0 = 1.546897E-11+dlvth0_n_cap wvth0 = 3.515467E-10+dwvth0_n_cap
+pvth0 = 2.544806E-16+dpvth0_n_cap phin = 0                      k1 = 0.30264
+k2 = -1.17823E-2              wk2 = -3.512454E-10           k3 = -7.284535
+k3b = 2.454986                w0 = 8.190018E-8              lpe0 = 6.610138E-8
+lpeb = 2.000404E-8            dvtp0 = 2.36094E-6            dvtp1 = 4.5
+dvt0 = 0.236381               dvt1 = 0.537442               dvt2 = 5.56679E-2
+dvt0w = 0                     dvt1w = 0                     dvt2w = 0
+vfbsdoff = 0.02
//*** mobility related parameter ***
+u0 = 1.43396E-2+du0_n_cap         lu0 = -1.27403E-10+dlu0_n_cap     wu0 = 7.390222E-10+dwu0_n_cap
+pu0 = 9.017124E-18+dpu0_n_cap     ua = -2.014187E-9             lua = -8.303839E-18
+wua = 8.815847E-17            pua = 4.118704E-24            ub = 2.296589E-18
+lub = 9.045685E-27            wub = -3.820628E-26           pub = -6.059435E-33
+uc = 6.259793E-11             luc = 1.77788E-18             wuc = 1.175801E-18
+puc = -5.855489E-25           ud = 0                        vsat = 1.371068E5+dvsat_n_cap
+lvsat = 0                     wvsat = 0                     pvsat = 0
+a0 = 2.113121                 la0 = -2.069878E-7            wa0 = 1.392104E-8
+pa0 = -1.364262E-15           ags = 4.082098                lags = 1.612703E-7
+wags = -4.512233E-9           pags = -1.781726E-16          b0 = 0
+b1 = 0                        keta = -0.099233              lketa = 1.814964E-8
+wketa = 1.390603E-8           pketa = -7.79188E-15          a1 = 0
+a2 = 1                        rdsw = 100.002354             prwb = 0
+prwg = 0                      wr = 1
//*** subthreshold related parameter ***
+voff = -0.150151              lvoff = -8.673291E-10         wvoff = -3.958748E-10
+pvoff = 2.001126E-17          voffl = -3.595178E-9          minv = -0.15
+nfactor = 1.289628            lnfactor = 5.094885E-8        wnfactor = -8.662758E-9
+pnfactor = -3.421203E-16      eta0 = 2.963491E-3            etab = -0.026723
+letab = 5.371771E-9           dsub = 0.422235               cit = 7.212E-4
+cdsc = 0                      cdscb = 0                     cdscd = 0
//*** output resistance related parameter ***
+pclm = 1.441266               pdiblc1 = 4.53031E-4          pdiblc2 = 8.873928E-3
+lpdiblc2 = -3.443013E-10      wpdiblc2 = -2.054318E-11      ppdiblc2 = -2.030107E-17
+pdiblcb = 1                   drout = 0.56                  pscbe1 = 1E9
+pscbe2 = 1E-20                pvag = 1.2                    delta = 7.595625E-3
+fprout = 300                  pdits = 0                     pditsl = 0
+pditsd = 0                    alpha0 = 2E-10                alpha1 = 0.01
+beta0 = 6.4                   agidl = 2.1505E-7             bgidl = 2.1392E9
+cgidl = 0.22                  egidl = 0.29734
//*** gate dielectric tunneling current ***
+aigbacc = 0.02                bigbacc = 2.47E-3             cigbacc = 0.3325
+nigbacc = 10                  aigbinv = 0.0158              bigbinv = 4.893E-3
+cigbinv = 6.1E-3              eigbinv = 1.1                 nigbinv = 10
+aigc = 0.0112                 bigc = 1.392E-3               cigc = 6.22E-4
+aigsd = 0.0106                bigsd = 1.235E-3              cigsd = 0.07
+dlcig = 2.48E-9               nigc = 3.07                   poxedge = 1
+pigcd = 2.591                 ntox = 1                      toxref = 3E-9
//*** capacitance parameter ***
+xpart = 1                     cgso = 5.53E-11+dcgso_n_cap       cgdo = 5.53E-11+dcgdo_n_cap
+cgbo = 0                      ckappas = 0.6                 ckappad = 0.6
+cf = 8.13E-11                 clc = 1.04E-7                 cle = 0.6
+dlc = 0                 dwc = 0                       noff = 2.96
+voffcv = -0.12                acde = 1                      moin = 5.67
+cgsl = 1.71E-11+dcgsl_n_cap       cgdl = 1.71E-11+dcgdl_n_cap
//*** souce/drain junction diode model parameter **
+ijthsrev = 0.01               ijthsfwd = 0.01               xjbvs = 1
+bvs = 10                      jss = 2.1E-7                  jsws = 3.4E-13
+jswgs = 1.2E-12               cjs = 8.61E-4+dcj_n_cap           mjs = 0.264
+mjsws = 0.011                 cjsws = 4.87E-11+dcjsw_n_cap      cjswgs = 2.56E-10+dcjswg_n_cap
+mjswgs = 0.511                pbs = 0.511                   pbsws = 0.786
+pbswgs = 0.464
//** rf model related parameter ***
+xrcrg1 = 12                   xrcrg2 = 1                    rbpb = 50
+rbpd = 50                     rbps = 50                     rbdb = 50
+rbsb = 50                     gbmin = 1E-12
//*** stress effect related parameter ***
+saref = 6.1E-7                sbref = 6.1E-7                wlod = 1.37E-7
+ku0 = -3.471E-8               kvsat = 0.342                 kvth0 = 2.461E-9
+tku0 = 0.097                  llodku0 = 1                   wlodku0 = 1
+llodvth = 1                   wlodvth = 1                   lku0 = 1.23E-8
+wku0 = 9.96E-8                pku0 = 4.6E-14                lkvth0 = -2.421E-11
+wkvth0 = 0                    pkvth0 = 0                    stk2 = 3.87E-10
+lodk2 = 0.5                   steta0 = 0                    lodeta0 = 1
//*** temperature coefficient ***
+tnom = 25                     ute = -1                      kt1 = -0.18098
+kt1l = 0                      kt2 = -0.036                  ua1 = 1.04E-9
+ub1 = -4.64E-19               uc1 = 8.71E-11                at = 1.4E5
+prt = 0                       njs = 1                       njd = 1
+xtis = 3                      xtid = 3                      tpb = 1.1E-3
+tpbsw = 1.9E-3                tpbswg = 1E-3                 tcj = 6.52E-4
+tcjsw = 3.57E-4               tcjswg = 1.5E-3               tvoff = 2.2428E-3
+tvfbsdoff = 0.022
//*** well proximity effect model parameters ***
+web = -210                    wec = -3.51E3                 kvth0we = 3.270022E-3
+k2we = 1.50195E-3             ku0we = -3.001501E-3          scref = 1E-6
17:type=n  minr=1e-60
//*** flag parameter ***
+version = 4.3                 binunit = 2                   mobmod = 0
+capmod = 2                    rdsmod = 0                    igcmod = 1
+igbmod = 1                    rbodymod = 0                  trnqsmod = 0
+acnqsmod = 0                  fnoimod = 1                   tnoimod = 0
+diomod = 1                    tempmod = 0                   permod = 1
+rgatemod = 0                  wpemod = 1
//*** geometry range parameter ***
+lmin = 6E-8                   lmax = 1E-7                   wmin = 5E-7
+wmax = 1E-6
//*** process parameter ***
+epsrox = 3.9                  toxe = tox_n_cap                  toxm = tox_n_cap
+dtox = 3.15E-10               xj = 8.1E-8                   ndep = 1E17
+ngate = 1.6E20                nsd = 1E20                    rsh = 17.5
+rshg = 15.5
//*** dw and dl parameter ***
+wint = 2E-9                   wl = 0                        wln = 1
+ww = 0                        wwn = 1                       wwl = 0
+lint = 1E-9                   ll = 0                        lln = 1
+lw = 0                        lwn = 1                       lwl = 0
+llc = 0                       lwc = 0                       lwlc = 0
+wlc = 0                       wwc = 0                       wwlc = 0
+dwg = 0                       dwb = 0                       xl = 0+dxl_n_cap
+xw = 0+dxw_n_cap
//*** flicker noise model parameter ***
+noia = 2.6E42                 noib = 1.61E21                noic = 3E8
+em = 1E6                      ef = 0.94                     lintnoi = -5E-9
//***layout-dependent parasitics model parameter ***
+dmcg = 4E-8                   dmci = 4E-8                   dmdg = 0
+dmcgt = 0                     dwj = 0                       xgw = 0
+xgl = 0                       ngcon = 1
//*** vth related  parameter ***
+vth0 = 0.340007+dvth0_n_cap       lvth0 = 7.065178E-10+dlvth0_n_cap wvth0 = 4.454542E-10+dwvth0_n_cap
+pvth0 = 2.452777E-16+dpvth0_n_cap phin = 0                      k1 = 0.30264
+k2 = -8.371754E-3             lk2 = -3.342378E-10           wk2 = -3.748193E-9
+pk2 = 3.329009E-16            k3 = -7.284535                k3b = 2.454986
+w0 = 8.190018E-8              lpe0 = 6.610138E-8            lpeb = 2.000404E-8
+dvtp0 = 2.36094E-6            dvtp1 = 4.5                   dvt0 = 0.236381
+dvt1 = 0.537442               dvt2 = 5.56679E-2             dvt0w = 0
+dvt1w = 0                     dvt2w = 0                     vfbsdoff = 0.02
//*** mobility related parameter ***
+u0 = 1.46604E-2+du0_n_cap         lu0 = -1.588462E-10+dlu0_n_cap    wu0 = 4.456518E-10+dwu0_n_cap
+pu0 = 3.776742E-17+dpu0_n_cap     ua = -2.067541E-9             lua = -3.075097E-18
+wua = 1.023168E-16            pua = 2.731189E-24            ub = 2.42677E-18
+lub = -3.712065E-27           wub = -1.007708E-25           pub = 7.188447E-35
+uc = 6.078779E-11             luc = 1.955274E-18            wuc = 1.568338E-18
+puc = -6.240175E-25           ud = 0                        vsat = 1.37107E5+dvsat_n_cap
+lvsat = 0                     wvsat = 0                     pvsat = 0
+a0 = 1E-3                     ags = 5.727713                wags = -6.330321E-9
+b0 = 0                        b1 = 0                        keta = 0.114735
+lketa = -2.819264E-9          wketa = -9.425588E-8          pketa = 2.807987E-15
+a1 = 0                        a2 = 1                        rdsw = 100.002354
+prwb = 0                      prwg = 0                      wr = 1
//*** subthreshold related parameter ***
+voff = -0.158952              lvoff = -4.866641E-12         wvoff = 3.181463E-11
+pvoff = -2.19023E-17          voffl = -3.595178E-9          minv = -0.15
+nfactor = 0.550091            lnfactor = 1.234235E-7        wnfactor = -3.694005E-9
+pnfactor = -8.290581E-16      eta0 = 6.788326E-3            leta0 = -3.748338E-10
+weta0 = 2.342248E-10          peta0 = -2.295403E-17         etab = 0.116107
+letab = -8.625562E-9          wetab = -4.365591E-8          petab = 4.278279E-15
+dsub = 0.422235               cit = 7.212E-4                cdsc = 0
+cdscb = 0                     cdscd = 0
//*** output resistance related parameter ***
+pclm = 1.441266               pdiblc1 = -6.12381E-4         lpdiblc1 = 1.484522E-10
+wpdiblc1 = 3.03741E-10        ppdiblc1 = -7.363231E-17      pdiblc2 = 2.757225E-3
+lpdiblc2 = 2.551356E-10       wpdiblc2 = 4.58882E-9         ppdiblc2 = -4.720187E-16
+pdiblcb = 1                   drout = 0.56                  pscbe1 = 1E9
+pscbe2 = 1E-20                pvag = 1.2                    delta = 7.595625E-3
+fprout = 300                  pdits = 0                     pditsl = 0
+pditsd = 0                    alpha0 = 2E-10                alpha1 = 0.01
+beta0 = 6.4                   agidl = 2.1505E-7             bgidl = 2.1392E9
+cgidl = 0.22                  egidl = 0.29734
//*** gate dielectric tunneling current ***
+aigbacc = 0.02                bigbacc = 2.47E-3             cigbacc = 0.3325
+nigbacc = 10                  aigbinv = 0.0158              bigbinv = 4.893E-3
+cigbinv = 6.1E-3              eigbinv = 1.1                 nigbinv = 10
+aigc = 0.0112                 bigc = 1.392E-3               cigc = 6.22E-4
+aigsd = 0.0106                bigsd = 1.235E-3              cigsd = 0.07
+dlcig = 2.48E-9               nigc = 3.07                   poxedge = 1
+pigcd = 2.591                 ntox = 1                      toxref = 3E-9
//*** capacitance parameter ***
+xpart = 1                     cgso = 5.53E-11+dcgso_n_cap       cgdo = 5.53E-11+dcgdo_n_cap
+cgbo = 0                      ckappas = 0.6                 ckappad = 0.6
+cf = 8.13E-11                 clc = 1.04E-7                 cle = 0.6
+dlc = 0                 dwc = 0                       noff = 2.96
+voffcv = -0.12                acde = 1                      moin = 5.67
+cgsl = 1.71E-11+dcgsl_n_cap       cgdl = 1.71E-11+dcgdl_n_cap
//*** souce/drain junction diode model parameter **
+ijthsrev = 0.01               ijthsfwd = 0.01               xjbvs = 1
+bvs = 10                      jss = 2.1E-7                  jsws = 3.4E-13
+jswgs = 1.2E-12               cjs = 8.61E-4+dcj_n_cap           mjs = 0.264
+mjsws = 0.011                 cjsws = 4.87E-11+dcjsw_n_cap      cjswgs = 2.56E-10+dcjswg_n_cap
+mjswgs = 0.511                pbs = 0.511                   pbsws = 0.786
+pbswgs = 0.464
//** rf model related parameter ***
+xrcrg1 = 12                   xrcrg2 = 1                    rbpb = 50
+rbpd = 50                     rbps = 50                     rbdb = 50
+rbsb = 50                     gbmin = 1E-12
//*** stress effect related parameter ***
+saref = 6.1E-7                sbref = 6.1E-7                wlod = 1.37E-7
+ku0 = -3.471E-8               kvsat = 0.342                 kvth0 = 2.461E-9
+tku0 = 0.097                  llodku0 = 1                   wlodku0 = 1
+llodvth = 1                   wlodvth = 1                   lku0 = 1.23E-8
+wku0 = 9.96E-8                pku0 = 4.6E-14                lkvth0 = -2.421E-11
+wkvth0 = 0                    pkvth0 = 0                    stk2 = 3.87E-10
+lodk2 = 0.5                   steta0 = 0                    lodeta0 = 1
//*** temperature coefficient ***
+tnom = 25                     ute = -1                      kt1 = -0.18098
+kt1l = 0                      kt2 = -0.036                  ua1 = 1.04E-9
+ub1 = -4.64E-19               uc1 = 8.71E-11                at = 1.4E5
+prt = 0                       njs = 1                       njd = 1
+xtis = 3                      xtid = 3                      tpb = 1.1E-3
+tpbsw = 1.9E-3                tpbswg = 1E-3                 tcj = 6.52E-4
+tcjsw = 3.57E-4               tcjswg = 1.5E-3               tvoff = 2.2428E-3
+tvfbsdoff = 0.022
//*** well proximity effect model parameters ***
+web = -210                    wec = -3.51E3                 kvth0we = 3.270022E-3
+k2we = 1.50195E-3             ku0we = -3.001501E-3          scref = 1E-6
18:type=n  minr=1e-60
//*** flag parameter ***
+version = 4.3                 binunit = 2                   mobmod = 0
+capmod = 2                    rdsmod = 0                    igcmod = 1
+igbmod = 1                    rbodymod = 0                  trnqsmod = 0
+acnqsmod = 0                  fnoimod = 1                   tnoimod = 0
+diomod = 1                    tempmod = 0                   permod = 1
+rgatemod = 0                  wpemod = 1
//*** geometry range parameter ***
+lmin = 4E-8                   lmax = 6E-8                   wmin = 5E-7
+wmax = 1E-6
//*** process parameter ***
+epsrox = 3.9                  toxe = tox_n_cap                  toxm = tox_n_cap
+dtox = 3.15E-10               xj = 8.1E-8                   ndep = 1E17
+ngate = 1.6E20                nsd = 1E20                    rsh = 17.5
+rshg = 15.5
//*** dw and dl parameter ***
+wint = 2E-9                   wl = 0                        wln = 1
+ww = 0                        wwn = 1                       wwl = 0
+lint = 1E-9                   ll = 0                        lln = 1
+lw = 0                        lwn = 1                       lwl = 0
+llc = 0                       lwc = 0                       lwlc = 0
+wlc = 0                       wwc = 0                       wwlc = 0
+dwg = 0                       dwb = 0                       xl = 0+dxl_n_cap
+xw = 0+dxw_n_cap
//*** flicker noise model parameter ***
+noia = 2.6E42                 noib = 1.61E21                noic = 3E8
+em = 1E6                      ef = 0.94                     lintnoi = -5E-9
//***layout-dependent parasitics model parameter ***
+dmcg = 4E-8                   dmci = 4E-8                   dmdg = 0
+dmcgt = 0                     dwj = 0                       xgw = 0
+xgl = 0                       ngcon = 1
//*** vth related  parameter ***
+vth0 = 0.346779+dvth0_n_cap       lvth0 = 3.136908E-10+dlvth0_n_cap wvth0 = -6.673474E-9+dwvth0_n_cap
+pvth0 = 6.581755E-16+dpvth0_n_cap phin = 0                      k1 = 0.30264
+k2 = -1.64376E-2              lk2 = 1.335793E-10            wk2 = -8.9864E-9
+pk2 = 6.367169E-16            k3 = -7.284535                k3b = 2.454986
+w0 = 8.190018E-8              lpe0 = 6.610138E-8            lpeb = 2.000404E-8
+dvtp0 = 2.36094E-6            dvtp1 = 4.5                   dvt0 = 0.236381
+dvt1 = 0.537442               dvt2 = 5.56679E-2             dvt0w = 0
+dvt1w = 0                     dvt2w = 0                     vfbsdoff = 0.02
//*** mobility related parameter ***
+u0 = 1.52269E-2+du0_n_cap         lu0 = -1.917E-10+dlu0_n_cap       wu0 = -8.492135E-11+dwu0_n_cap
+pu0 = 6.854067E-17+dpu0_n_cap     ua = -1.963803E-9             lua = -9.091916E-18
+wua = 2.263858E-17            pua = 7.352525E-24            ub = 2.369009E-18
+lub = -3.619039E-28           wub = -6.66643E-26            pub = -1.906291E-33
+uc = 1.268636E-10             luc = -1.877124E-18           wuc = -4.142533E-17
+puc = 1.869615E-24            ud = 0                        vsat = 1.207921E5+dvsat_n_cap
+lvsat = 9.462655E-4           wvsat = 3.003242E-3           pvsat = -1.74188E-10
+a0 = 1E-3                     ags = 5.727713                wags = -6.330321E-9
+b0 = 0                        b1 = 0                        keta = 6.61273E-2
+wketa = -4.584231E-8          a1 = 0                        a2 = 1
+rdsw = 100.002354             prwb = 0                      prwg = 0
+wr = 1
//*** subthreshold related parameter ***
+voff = -0.157691              lvoff = -7.796959E-11         wvoff = 1.274561E-11
+pvoff = -2.07963E-17          voffl = -3.595178E-9          minv = -0.15
+nfactor = 0.23567             lnfactor = 1.416599E-7        wnfactor = -1.582728E-9
+pnfactor = -9.515122E-16      eta0 = 0                      etab = -5.13546E-2
+letab = 1.087207E-9           wetab = 8.090284E-8           petab = -2.946129E-15
+dsub = 0.422235               cit = 7.212E-4                cdsc = 0
+cdscb = 0                     cdscd = 0
//*** output resistance related parameter ***
+pclm = 1.441266               pdiblc1 = -1.16079E-2         lpdiblc1 = 7.861951E-10
+wpdiblc1 = 1.261355E-9        ppdiblc1 = -1.291739E-16      pdiblc2 = 3.083844E-3
+lpdiblc2 = 2.361917E-10       wpdiblc2 = -1.529587E-9       ppdiblc2 = -1.171511E-16
+pdiblcb = 1                   drout = 0.492949              ldrout = 3.888975E-9
+wdrout = 1.156505E-7          pdrout = -6.707731E-15        pscbe1 = 1E9
+pscbe2 = 1E-20                pvag = 1.2                    delta = 7.595625E-3
+fprout = 300                  pdits = 0                     pditsl = 0
+pditsd = 0                    alpha0 = 2E-10                alpha1 = 0.01
+beta0 = 6.4                   agidl = 2.1505E-7             bgidl = 2.1392E9
+cgidl = 0.22                  egidl = 0.29734
//*** gate dielectric tunneling current ***
+aigbacc = 0.02                bigbacc = 2.47E-3             cigbacc = 0.3325
+nigbacc = 10                  aigbinv = 0.0158              bigbinv = 4.893E-3
+cigbinv = 6.1E-3              eigbinv = 1.1                 nigbinv = 10
+aigc = 0.0112                 bigc = 1.392E-3               cigc = 6.22E-4
+aigsd = 0.0106                bigsd = 1.235E-3              cigsd = 0.07
+dlcig = 2.48E-9               nigc = 3.07                   poxedge = 1
+pigcd = 2.591                 ntox = 1                      toxref = 3E-9
//*** capacitance parameter ***
+xpart = 1                     cgso = 5.53E-11+dcgso_n_cap       cgdo = 5.53E-11+dcgdo_n_cap
+cgbo = 0                      ckappas = 0.6                 ckappad = 0.6
+cf = 8.13E-11                 clc = 1.04E-7                 cle = 0.6
+dlc = 0                 dwc = 0                       noff = 2.96
+voffcv = -0.12                acde = 1                      moin = 5.67
+cgsl = 1.71E-11+dcgsl_n_cap       cgdl = 1.71E-11+dcgdl_n_cap
//*** souce/drain junction diode model parameter **
+ijthsrev = 0.01               ijthsfwd = 0.01               xjbvs = 1
+bvs = 10                      jss = 2.1E-7                  jsws = 3.4E-13
+jswgs = 1.2E-12               cjs = 8.61E-4+dcj_n_cap           mjs = 0.264
+mjsws = 0.011                 cjsws = 4.87E-11+dcjsw_n_cap      cjswgs = 2.56E-10+dcjswg_n_cap
+mjswgs = 0.511                pbs = 0.511                   pbsws = 0.786
+pbswgs = 0.464
//** rf model related parameter ***
+xrcrg1 = 12                   xrcrg2 = 1                    rbpb = 50
+rbpd = 50                     rbps = 50                     rbdb = 50
+rbsb = 50                     gbmin = 1E-12
//*** stress effect related parameter ***
+saref = 6.1E-7                sbref = 6.1E-7                wlod = 1.37E-7
+ku0 = -3.471E-8               kvsat = 0.342                 kvth0 = 2.461E-9
+tku0 = 0.097                  llodku0 = 1                   wlodku0 = 1
+llodvth = 1                   wlodvth = 1                   lku0 = 1.23E-8
+wku0 = 9.96E-8                pku0 = 4.6E-14                lkvth0 = -2.421E-11
+wkvth0 = 0                    pkvth0 = 0                    stk2 = 3.87E-10
+lodk2 = 0.5                   steta0 = 0                    lodeta0 = 1
//*** temperature coefficient ***
+tnom = 25                     ute = -1                      kt1 = -0.18098
+kt1l = 0                      kt2 = -0.036                  ua1 = 1.04E-9
+ub1 = -4.64E-19               uc1 = 8.71E-11                at = 1.4E5
+prt = 0                       njs = 1                       njd = 1
+xtis = 3                      xtid = 3                      tpb = 1.1E-3
+tpbsw = 1.9E-3                tpbswg = 1E-3                 tcj = 6.52E-4
+tcjsw = 3.57E-4               tcjswg = 1.5E-3               tvoff = 2.2428E-3
+tvfbsdoff = 0.022
//*** well proximity effect model parameters ***
+web = -210                    wec = -3.51E3                 kvth0we = 3.270022E-3
+k2we = 1.50195E-3             ku0we = -3.001501E-3          scref = 1E-6
19:type=n  minr=1e-60
//*** flag parameter ***
+version = 4.3                 binunit = 2                   mobmod = 0
+capmod = 2                    rdsmod = 0                    igcmod = 1
+igbmod = 1                    rbodymod = 0                  trnqsmod = 0
+acnqsmod = 0                  fnoimod = 1                   tnoimod = 0
+diomod = 1                    tempmod = 0                   permod = 1
+rgatemod = 0                  wpemod = 1
//*** geometry range parameter ***
+lmin = 2E-6                   lmax = 1E-5                   wmin = 3E-7
+wmax = 5E-7
//*** process parameter ***
+epsrox = 3.9                  toxe = tox_n_cap                  toxm = tox_n_cap
+dtox = 3.15E-10               xj = 8.1E-8                   ndep = 1E17
+ngate = 1.6E20                nsd = 1E20                    rsh = 17.5
+rshg = 15.5
//*** dw and dl parameter ***
+wint = 2E-9                   wl = 0                        wln = 1
+ww = 0                        wwn = 1                       wwl = 0
+lint = 1E-9                   ll = 0                        lln = 1
+lw = 0                        lwn = 1                       lwl = 0
+llc = 0                       lwc = 0                       lwlc = 0
+wlc = 0                       wwc = 0                       wwlc = 0
+dwg = 0                       dwb = 0                       xl = 0+dxl_n_cap
+xw = 0+dxw_n_cap
//*** flicker noise model parameter ***
+noia = 2.6E42                 noib = 1.61E21                noic = 3E8
+em = 1E6                      ef = 0.94                     lintnoi = -5E-9
//***layout-dependent parasitics model parameter ***
+dmcg = 4E-8                   dmci = 4E-8                   dmdg = 0
+dmcgt = 0                     dwj = 0                       xgw = 0
+xgl = 0                       ngcon = 1
//*** vth related  parameter ***
+vth0 = 0.34925+dvth0_n_cap        lvth0 = 0+dlvth0_n_cap            wvth0 = 0+dwvth0_n_cap
+pvth0 = 0+dpvth0_n_cap            phin = 0                      k1 = 0.30264
+k2 = -1.04745E-2              k3 = -7.284535                k3b = 2.454986
+w0 = 8.190018E-8              lpe0 = 6.610138E-8            lpeb = 2.000404E-8
+dvtp0 = 2.36094E-6            dvtp1 = 4.5                   dvt0 = 0.236381
+dvt1 = 0.537442               dvt2 = 5.56679E-2             dvt0w = 0
+dvt1w = 0                     dvt2w = 0                     vfbsdoff = 0.02
//*** mobility related parameter ***
+u0 = 1.49116E-2+du0_n_cap         lu0 = 2.28083E-9+dlu0_n_cap       wu0 = 9.85574E-12+dwu0_n_cap
+pu0 = -7.260506E-16+dpu0_n_cap    ua = -1.946422E-9             lua = 2.867106E-16
+wua = 8.768067E-18            pua = -8.766314E-23           ub = 2.288411E-18
+lub = -2.348348E-25           wub = 1.017804E-27            pub = 6.234393E-32
+uc = 6.616797E-11             ud = 0                        vsat = 1.37107E5+dvsat_n_cap
+lvsat = 0                     wvsat = 0                     pvsat = 0
+a0 = 1.812026                 la0 = -8.813739E-7            wa0 = 3.621262E-9
+pa0 = -3.620538E-14           ags = 1.130666                lags = 9.155813E-7
+wags = -3.373463E-8           pags = -2.731717E-14          b0 = 0
+b1 = 0                        keta = -6.38539E-2            lketa = 2.149758E-8
+wketa = -8.420645E-10         pketa = 8.41896E-15           a1 = 0
+a2 = 1                        rdsw = 100.002354             prwb = 0
+prwg = 0                      wr = 1
//*** subthreshold related parameter ***
+voff = -0.154478              lvoff = 1.771073E-9           wvoff = 3.277142E-10
+pvoff = -5.242375E-16         voffl = -3.595178E-9          minv = -0.15
+nfactor = 1.086027            eta0 = 2.963491E-3            etab = -1.59363E-2
+dsub = 0.422235               cit = 7.212E-4                cdsc = 0
+cdscb = 0                     cdscd = 0
//*** output resistance related parameter ***
+pclm = 1.441266               pdiblc1 = 4.53031E-4          pdiblc2 = 8.645462E-3
+lpdiblc2 = -1.030951E-9       wpdiblc2 = -1.168385E-11      ppdiblc2 = 1.168151E-16
+pdiblcb = 1                   drout = 0.56                  pscbe1 = 1E9
+pscbe2 = 1E-20                pvag = 1.2                    delta = 7.595625E-3
+fprout = 300                  pdits = 0                     pditsl = 0
+pditsd = 0                    alpha0 = 2E-10                alpha1 = 0.01
+beta0 = 6.4                   agidl = 2.1505E-7             bgidl = 2.1392E9
+cgidl = 0.22                  egidl = 0.29734
//*** gate dielectric tunneling current ***
+aigbacc = 0.02                bigbacc = 2.47E-3             cigbacc = 0.3325
+nigbacc = 10                  aigbinv = 0.0158              bigbinv = 4.893E-3
+cigbinv = 6.1E-3              eigbinv = 1.1                 nigbinv = 10
+aigc = 0.0112                 bigc = 1.392E-3               cigc = 6.22E-4
+aigsd = 0.0106                bigsd = 1.235E-3              cigsd = 0.07
+dlcig = 2.48E-9               nigc = 3.07                   poxedge = 1
+pigcd = 2.591                 ntox = 1                      toxref = 3E-9
//*** capacitance parameter ***
+xpart = 1                     cgso = 5.53E-11+dcgso_n_cap       cgdo = 5.53E-11+dcgdo_n_cap
+cgbo = 0                      ckappas = 0.6                 ckappad = 0.6
+cf = 8.13E-11                 clc = 1.04E-7                 cle = 0.6
+dlc = 0                 dwc = 0                       noff = 2.96
+voffcv = -0.12                acde = 1                      moin = 5.67
+cgsl = 1.71E-11+dcgsl_n_cap       cgdl = 1.71E-11+dcgdl_n_cap
//*** souce/drain junction diode model parameter **
+ijthsrev = 0.01               ijthsfwd = 0.01               xjbvs = 1
+bvs = 10                      jss = 2.1E-7                  jsws = 3.4E-13
+jswgs = 1.2E-12               cjs = 8.61E-4+dcj_n_cap           mjs = 0.264
+mjsws = 0.011                 cjsws = 4.87E-11+dcjsw_n_cap      cjswgs = 2.56E-10+dcjswg_n_cap
+mjswgs = 0.511                pbs = 0.511                   pbsws = 0.786
+pbswgs = 0.464
//** rf model related parameter ***
+xrcrg1 = 12                   xrcrg2 = 1                    rbpb = 50
+rbpd = 50                     rbps = 50                     rbdb = 50
+rbsb = 50                     gbmin = 1E-12
//*** stress effect related parameter ***
+saref = 6.1E-7                sbref = 6.1E-7                wlod = 1.37E-7
+ku0 = -3.471E-8               kvsat = 0.342                 kvth0 = 2.461E-9
+tku0 = 0.097                  llodku0 = 1                   wlodku0 = 1
+llodvth = 1                   wlodvth = 1                   lku0 = 1.23E-8
+wku0 = 9.96E-8                pku0 = 4.6E-14                lkvth0 = -2.421E-11
+wkvth0 = 0                    pkvth0 = 0                    stk2 = 3.87E-10
+lodk2 = 0.5                   steta0 = 0                    lodeta0 = 1
//*** temperature coefficient ***
+tnom = 25                     ute = -1                      kt1 = -0.18098
+kt1l = 0                      kt2 = -0.036                  ua1 = 1.04E-9
+ub1 = -4.64E-19               uc1 = 8.71E-11                at = 1.4E5
+prt = 0                       njs = 1                       njd = 1
+xtis = 3                      xtid = 3                      tpb = 1.1E-3
+tpbsw = 1.9E-3                tpbswg = 1E-3                 tcj = 6.52E-4
+tcjsw = 3.57E-4               tcjswg = 1.5E-3               tvoff = 2.2428E-3
+tvfbsdoff = 0.022
//*** well proximity effect model parameters ***
+web = -210                    wec = -3.51E3                 kvth0we = 3.270022E-3
+k2we = 1.50195E-3             ku0we = -3.001501E-3          scref = 1E-6
20:type=n  minr=1e-60
//*** flag parameter ***
+version = 4.3                 binunit = 2                   mobmod = 0
+capmod = 2                    rdsmod = 0                    igcmod = 1
+igbmod = 1                    rbodymod = 0                  trnqsmod = 0
+acnqsmod = 0                  fnoimod = 1                   tnoimod = 0
+diomod = 1                    tempmod = 0                   permod = 1
+rgatemod = 0                  wpemod = 1
//*** geometry range parameter ***
+lmin = 1E-6                   lmax = 2E-6                   wmin = 3E-7
+wmax = 5E-7
//*** process parameter ***
+epsrox = 3.9                  toxe = tox_n_cap                  toxm = tox_n_cap
+dtox = 3.15E-10               xj = 8.1E-8                   ndep = 1E17
+ngate = 1.6E20                nsd = 1E20                    rsh = 17.5
+rshg = 15.5
//*** dw and dl parameter ***
+wint = 2E-9                   wl = 0                        wln = 1
+ww = 0                        wwn = 1                       wwl = 0
+lint = 1E-9                   ll = 0                        lln = 1
+lw = 0                        lwn = 1                       lwl = 0
+llc = 0                       lwc = 0                       lwlc = 0
+wlc = 0                       wwc = 0                       wwlc = 0
+dwg = 0                       dwb = 0                       xl = 0+dxl_n_cap
+xw = 0+dxw_n_cap
//*** flicker noise model parameter ***
+noia = 2.6E42                 noib = 1.61E21                noic = 3E8
+em = 1E6                      ef = 0.94                     lintnoi = -5E-9
//***layout-dependent parasitics model parameter ***
+dmcg = 4E-8                   dmci = 4E-8                   dmdg = 0
+dmcgt = 0                     dwj = 0                       xgw = 0
+xgl = 0                       ngcon = 1
//*** vth related  parameter ***
+vth0 = 0.347226+dvth0_n_cap       lvth0 = 4.044877E-9+dlvth0_n_cap  wvth0 = 3.106274E-10+dwvth0_n_cap
+pvth0 = -6.206336E-16+dpvth0_n_cap phin = 0                      k1 = 0.30264
+k2 = -5.484819E-3             lk2 = -9.969382E-9            wk2 = -1.476945E-9
+pk2 = 2.950937E-15            k3 = -7.284535                k3b = 2.454986
+w0 = 8.190018E-8              lpe0 = 6.610138E-8            lpeb = 2.000404E-8
+dvtp0 = 2.36094E-6            dvtp1 = 4.5                   dvt0 = 0.236381
+dvt1 = 0.537442               dvt2 = 5.56679E-2             dvt0w = 0
+dvt1w = 0                     dvt2w = 0                     vfbsdoff = 0.02
//*** mobility related parameter ***
+u0 = 0.016115+du0_n_cap           lu0 = -1.234528E-10+dlu0_n_cap    wu0 = -3.62251E-10+dwu0_n_cap
+pu0 = 1.741873E-17+dpu0_n_cap     ua = -1.781269E-9             lua = -4.32655E-17
+wua = -4.101223E-17           pua = 1.179789E-23            ub = 2.155343E-18
+lub = 3.103564E-26            wub = 3.681885E-26            pub = -9.186548E-33
+uc = 6.616797E-11             ud = 0                        vsat = 1.37107E5+dvsat_n_cap
+lvsat = 0                     wvsat = 0                     pvsat = 0
+a0 = 0.880942                 la0 = 9.789311E-7             wa0 = 2.927767E-8
+pa0 = -8.746689E-14           ags = 0.478301                lags = 2.219005E-6
+wags = -6.470165E-8           pags = 3.455495E-14           b0 = 0
+b1 = 0                        keta = -3.31343E-2            lketa = -3.988008E-8
+wketa = 3.371629E-9           a1 = 0                        a2 = 1
+rdsw = 100.002354             prwb = 0                      prwg = 0
+wr = 1
//*** subthreshold related parameter ***
+voff = -0.152723              lvoff = -1.735262E-9          wvoff = -3.654426E-10
+pvoff = 8.6069E-16            voffl = -3.595178E-9          minv = -0.15
+nfactor = 0.988391            lnfactor = 1.950763E-7        wnfactor = -1.05291E-8
+pnfactor = 2.103714E-14       eta0 = 2.963491E-3            etab = -1.59363E-2
+dsub = 0.422235               cit = 7.212E-4                cdsc = 0
+cdscb = 0                     cdscd = 0
//*** output resistance related parameter ***
+pclm = 1.441266               pdiblc1 = 4.53031E-4          pdiblc2 = 7.890134E-3
+lpdiblc2 = 4.781941E-10       wpdiblc2 = 1.176257E-10       ppdiblc2 = -1.415454E-16
+pdiblcb = 1                   drout = 0.56                  pscbe1 = 1E9
+pscbe2 = 1E-20                pvag = 1.2                    delta = 7.595625E-3
+fprout = 300                  pdits = 0                     pditsl = 0
+pditsd = 0                    alpha0 = 2E-10                alpha1 = 0.01
+beta0 = 6.4                   agidl = 2.1505E-7             bgidl = 2.1392E9
+cgidl = 0.22                  egidl = 0.29734
//*** gate dielectric tunneling current ***
+aigbacc = 0.02                bigbacc = 2.47E-3             cigbacc = 0.3325
+nigbacc = 10                  aigbinv = 0.0158              bigbinv = 4.893E-3
+cigbinv = 6.1E-3              eigbinv = 1.1                 nigbinv = 10
+aigc = 0.0112                 bigc = 1.392E-3               cigc = 6.22E-4
+aigsd = 0.0106                bigsd = 1.235E-3              cigsd = 0.07
+dlcig = 2.48E-9               nigc = 3.07                   poxedge = 1
+pigcd = 2.591                 ntox = 1                      toxref = 3E-9
//*** capacitance parameter ***
+xpart = 1                     cgso = 5.53E-11+dcgso_n_cap       cgdo = 5.53E-11+dcgdo_n_cap
+cgbo = 0                      ckappas = 0.6                 ckappad = 0.6
+cf = 8.13E-11                 clc = 1.04E-7                 cle = 0.6
+dlc = 0                 dwc = 0                       noff = 2.96
+voffcv = -0.12                acde = 1                      moin = 5.67
+cgsl = 1.71E-11+dcgsl_n_cap       cgdl = 1.71E-11+dcgdl_n_cap
//*** souce/drain junction diode model parameter **
+ijthsrev = 0.01               ijthsfwd = 0.01               xjbvs = 1
+bvs = 10                      jss = 2.1E-7                  jsws = 3.4E-13
+jswgs = 1.2E-12               cjs = 8.61E-4+dcj_n_cap           mjs = 0.264
+mjsws = 0.011                 cjsws = 4.87E-11+dcjsw_n_cap      cjswgs = 2.56E-10+dcjswg_n_cap
+mjswgs = 0.511                pbs = 0.511                   pbsws = 0.786
+pbswgs = 0.464
//** rf model related parameter ***
+xrcrg1 = 12                   xrcrg2 = 1                    rbpb = 50
+rbpd = 50                     rbps = 50                     rbdb = 50
+rbsb = 50                     gbmin = 1E-12
//*** stress effect related parameter ***
+saref = 6.1E-7                sbref = 6.1E-7                wlod = 1.37E-7
+ku0 = -3.471E-8               kvsat = 0.342                 kvth0 = 2.461E-9
+tku0 = 0.097                  llodku0 = 1                   wlodku0 = 1
+llodvth = 1                   wlodvth = 1                   lku0 = 1.23E-8
+wku0 = 9.96E-8                pku0 = 4.6E-14                lkvth0 = -2.421E-11
+wkvth0 = 0                    pkvth0 = 0                    stk2 = 3.87E-10
+lodk2 = 0.5                   steta0 = 0                    lodeta0 = 1
//*** temperature coefficient ***
+tnom = 25                     ute = -1                      kt1 = -0.18098
+kt1l = 0                      kt2 = -0.036                  ua1 = 1.04E-9
+ub1 = -4.64E-19               uc1 = 8.71E-11                at = 1.4E5
+prt = 0                       njs = 1                       njd = 1
+xtis = 3                      xtid = 3                      tpb = 1.1E-3
+tpbsw = 1.9E-3                tpbswg = 1E-3                 tcj = 6.52E-4
+tcjsw = 3.57E-4               tcjswg = 1.5E-3               tvoff = 2.2428E-3
+tvfbsdoff = 0.022
//*** well proximity effect model parameters ***
+web = -210                    wec = -3.51E3                 kvth0we = 3.270022E-3
+k2we = 1.50195E-3             ku0we = -3.001501E-3          scref = 1E-6
21:type=n  minr=1e-60
//*** flag parameter ***
+version = 4.3                 binunit = 2                   mobmod = 0
+capmod = 2                    rdsmod = 0                    igcmod = 1
+igbmod = 1                    rbodymod = 0                  trnqsmod = 0
+acnqsmod = 0                  fnoimod = 1                   tnoimod = 0
+diomod = 1                    tempmod = 0                   permod = 1
+rgatemod = 0                  wpemod = 1
//*** geometry range parameter ***
+lmin = 5E-7                   lmax = 1E-6                   wmin = 3E-7
+wmax = 5E-7
//*** process parameter ***
+epsrox = 3.9                  toxe = tox_n_cap                  toxm = tox_n_cap
+dtox = 3.15E-10               xj = 8.1E-8                   ndep = 1E17
+ngate = 1.6E20                nsd = 1E20                    rsh = 17.5
+rshg = 15.5
//*** dw and dl parameter ***
+wint = 2E-9                   wl = 0                        wln = 1
+ww = 0                        wwn = 1                       wwl = 0
+lint = 1E-9                   ll = 0                        lln = 1
+lw = 0                        lwn = 1                       lwl = 0
+llc = 0                       lwc = 0                       lwlc = 0
+wlc = 0                       wwc = 0                       wwlc = 0
+dwg = 0                       dwb = 0                       xl = 0+dxl_n_cap
+xw = 0+dxw_n_cap
//*** flicker noise model parameter ***
+noia = 2.6E42                 noib = 1.61E21                noic = 3E8
+em = 1E6                      ef = 0.94                     lintnoi = -5E-9
//***layout-dependent parasitics model parameter ***
+dmcg = 4E-8                   dmci = 4E-8                   dmdg = 0
+dmcgt = 0                     dwj = 0                       xgw = 0
+xgl = 0                       ngcon = 1
//*** vth related  parameter ***
+vth0 = 0.355781+dvth0_n_cap       lvth0 = -4.49395E-9+dlvth0_n_cap  wvth0 = -1.644125E-9+dwvth0_n_cap
+pvth0 = 1.330209E-15+dpvth0_n_cap phin = 0                      k1 = 0.30264
+k2 = -1.90759E-2              lk2 = 3.594564E-9             wk2 = 3.266382E-9
+pk2 = -1.782904E-15           k3 = -7.284535                k3b = 2.454986
+w0 = 8.190018E-8              lpe0 = 6.610138E-8            lpeb = 2.000404E-8
+dvtp0 = 2.36094E-6            dvtp1 = 4.5                   dvt0 = 0.236381
+dvt1 = 0.537442               dvt2 = 5.56679E-2             dvt0w = 0
+dvt1w = 0                     dvt2w = 0                     vfbsdoff = 0.02
//*** mobility related parameter ***
+u0 = 1.59989E-2+du0_n_cap         lu0 = -7.606149E-12+dlu0_n_cap    wu0 = -5.03748E-10+dwu0_n_cap
+pu0 = 1.586327E-16+dpu0_n_cap     ua = -1.830042E-9             lua = 5.410306E-18
+wua = -4.97329E-17            pua = 2.050113E-23            ub = 2.168205E-18
+lub = 1.819905E-26            wub = 5.094614E-26            pub = -2.328559E-32
+uc = 6.24374E-11              luc = 3.723111E-18            wuc = 1.850364E-18
+puc = -1.846663E-24           ud = 0                        vsat = 1.37107E5+dvsat_n_cap
+lvsat = 0                     wvsat = 0                     pvsat = 0
+a0 = 2.022314                 la0 = -1.601579E-7            wa0 = -1.26037E-7
+pa0 = 6.753712E-14            ags = 0.973715                lags = 1.724582E-6
+wags = -3.996983E-8           pags = 9.872589E-15           b0 = 0
+b1 = 0                        keta = -7.30943E-2            wketa = 3.371629E-9
+a1 = 0                        a2 = 1                        rdsw = 100.002354
+prwb = 0                      prwg = 0                      wr = 1
//*** subthreshold related parameter ***
+voff = -0.157082              lvoff = 2.614678E-9           wvoff = 1.376538E-9
+pvoff = -8.778067E-16         voffl = -3.595178E-9          minv = -0.15
+nfactor = 1.003111            lnfactor = 1.803855E-7        wnfactor = 1.722773E-8
+pnfactor = -6.66418E-15       eta0 = 2.963491E-3            etab = -1.59363E-2
+dsub = 0.422235               cit = 7.212E-4                cdsc = 0
+cdscb = 0                     cdscd = 0
//*** output resistance related parameter ***
+pclm = 1.441266               pdiblc1 = 4.53031E-4          pdiblc2 = 9.015298E-3
+lpdiblc2 = -6.447203E-10      wpdiblc2 = -2.15423E-10       ppdiblc2 = 1.908372E-16
+pdiblcb = 1                   drout = 0.56                  pscbe1 = 1E9
+pscbe2 = 1E-20                pvag = 1.2                    delta = 7.595625E-3
+fprout = 300                  pdits = 0                     pditsl = 0
+pditsd = 0                    alpha0 = 2E-10                alpha1 = 0.01
+beta0 = 6.4                   agidl = 2.1505E-7             bgidl = 2.1392E9
+cgidl = 0.22                  egidl = 0.29734
//*** gate dielectric tunneling current ***
+aigbacc = 0.02                bigbacc = 2.47E-3             cigbacc = 0.3325
+nigbacc = 10                  aigbinv = 0.0158              bigbinv = 4.893E-3
+cigbinv = 6.1E-3              eigbinv = 1.1                 nigbinv = 10
+aigc = 0.0112                 bigc = 1.392E-3               cigc = 6.22E-4
+aigsd = 0.0106                bigsd = 1.235E-3              cigsd = 0.07
+dlcig = 2.48E-9               nigc = 3.07                   poxedge = 1
+pigcd = 2.591                 ntox = 1                      toxref = 3E-9
//*** capacitance parameter ***
+xpart = 1                     cgso = 5.53E-11+dcgso_n_cap       cgdo = 5.53E-11+dcgdo_n_cap
+cgbo = 0                      ckappas = 0.6                 ckappad = 0.6
+cf = 8.13E-11                 clc = 1.04E-7                 cle = 0.6
+dlc = 0                 dwc = 0                       noff = 2.96
+voffcv = -0.12                acde = 1                      moin = 5.67
+cgsl = 1.71E-11+dcgsl_n_cap       cgdl = 1.71E-11+dcgdl_n_cap
//*** souce/drain junction diode model parameter **
+ijthsrev = 0.01               ijthsfwd = 0.01               xjbvs = 1
+bvs = 10                      jss = 2.1E-7                  jsws = 3.4E-13
+jswgs = 1.2E-12               cjs = 8.61E-4+dcj_n_cap           mjs = 0.264
+mjsws = 0.011                 cjsws = 4.87E-11+dcjsw_n_cap      cjswgs = 2.56E-10+dcjswg_n_cap
+mjswgs = 0.511                pbs = 0.511                   pbsws = 0.786
+pbswgs = 0.464
//** rf model related parameter ***
+xrcrg1 = 12                   xrcrg2 = 1                    rbpb = 50
+rbpd = 50                     rbps = 50                     rbdb = 50
+rbsb = 50                     gbmin = 1E-12
//*** stress effect related parameter ***
+saref = 6.1E-7                sbref = 6.1E-7                wlod = 1.37E-7
+ku0 = -3.471E-8               kvsat = 0.342                 kvth0 = 2.461E-9
+tku0 = 0.097                  llodku0 = 1                   wlodku0 = 1
+llodvth = 1                   wlodvth = 1                   lku0 = 1.23E-8
+wku0 = 9.96E-8                pku0 = 4.6E-14                lkvth0 = -2.421E-11
+wkvth0 = 0                    pkvth0 = 0                    stk2 = 3.87E-10
+lodk2 = 0.5                   steta0 = 0                    lodeta0 = 1
//*** temperature coefficient ***
+tnom = 25                     ute = -1                      kt1 = -0.18098
+kt1l = 0                      kt2 = -0.036                  ua1 = 1.04E-9
+ub1 = -4.64E-19               uc1 = 8.71E-11                at = 1.4E5
+prt = 0                       njs = 1                       njd = 1
+xtis = 3                      xtid = 3                      tpb = 1.1E-3
+tpbsw = 1.9E-3                tpbswg = 1E-3                 tcj = 6.52E-4
+tcjsw = 3.57E-4               tcjswg = 1.5E-3               tvoff = 2.2428E-3
+tvfbsdoff = 0.022
//*** well proximity effect model parameters ***
+web = -210                    wec = -3.51E3                 kvth0we = 3.270022E-3
+k2we = 1.50195E-3             ku0we = -3.001501E-3          scref = 1E-6
22:type=n  minr=1e-60
//*** flag parameter ***
+version = 4.3                 binunit = 2                   mobmod = 0
+capmod = 2                    rdsmod = 0                    igcmod = 1
+igbmod = 1                    rbodymod = 0                  trnqsmod = 0
+acnqsmod = 0                  fnoimod = 1                   tnoimod = 0
+diomod = 1                    tempmod = 0                   permod = 1
+rgatemod = 0                  wpemod = 1
//*** geometry range parameter ***
+lmin = 1E-7                   lmax = 5E-7                   wmin = 3E-7
+wmax = 5E-7
//*** process parameter ***
+epsrox = 3.9                  toxe = tox_n_cap                  toxm = tox_n_cap
+dtox = 3.15E-10               xj = 8.1E-8                   ndep = 1E17
+ngate = 1.6E20                nsd = 1E20                    rsh = 17.5
+rshg = 15.5
//*** dw and dl parameter ***
+wint = 2E-9                   wl = 0                        wln = 1
+ww = 0                        wwn = 1                       wwl = 0
+lint = 1E-9                   ll = 0                        lln = 1
+lw = 0                        lwn = 1                       lwl = 0
+llc = 0                       lwc = 0                       lwlc = 0
+wlc = 0                       wwc = 0                       wwlc = 0
+dwg = 0                       dwb = 0                       xl = 0+dxl_n_cap
+xw = 0+dxw_n_cap
//*** flicker noise model parameter ***
+noia = 2.6E42                 noib = 1.61E21                noic = 3E8
+em = 1E6                      ef = 0.94                     lintnoi = -5E-9
//***layout-dependent parasitics model parameter ***
+dmcg = 4E-8                   dmci = 4E-8                   dmdg = 0
+dmcgt = 0                     dwj = 0                       xgw = 0
+xgl = 0                       ngcon = 1
//*** vth related  parameter ***
+vth0 = 0.346358+dvth0_n_cap       lvth0 = 1.98848E-10+dlvth0_n_cap  wvth0 = 6.985727E-10+dwvth0_n_cap
+pvth0 = 1.635459E-16+dpvth0_n_cap phin = 0                      k1 = 0.30264
+k2 = -1.18579E-2              wk2 = -3.137458E-10           k3 = -7.284535
+k3b = 2.454986                w0 = 8.190018E-8              lpe0 = 6.610138E-8
+lpeb = 2.000404E-8            dvtp0 = 2.36094E-6            dvtp1 = 4.5
+dvt0 = 0.236381               dvt1 = 0.537442               dvt2 = 5.56679E-2
+dvt0w = 0                     dvt1w = 0                     dvt2w = 0
+vfbsdoff = 0.02
//*** mobility related parameter ***
+u0 = 0.016219+du0_n_cap           lu0 = -1.172228E-10+dlu0_n_cap    wu0 = -1.931757E-10+dwu0_n_cap
+pu0 = 3.967734E-18+dpu0_n_cap     ua = -1.804614E-9             lua = -7.252967E-18
+wua = -1.578982E-17           pua = 3.597472E-24            ub = 2.188423E-18
+lub = 8.130537E-27            wub = 1.544399E-26            pub = -5.605521E-33
+uc = 6.976073E-11             luc = 7.609056E-20            wuc = -2.376949E-18
+puc = 2.585386E-25            ud = 0                        vsat = 1.371068E5+dvsat_n_cap
+lvsat = 0                     wvsat = 0                     pvsat = 0
+a0 = 2.117141                 la0 = -2.073819E-7            wa0 = 1.192678E-8
+pa0 = -1.168825E-15           ags = 4.110631                lags = 1.623977E-7
+wags = -1.866466E-8           pags = -7.373895E-16          b0 = 0
+b1 = 0                        keta = -7.79943E-2            lketa = 2.4402E-9
+wketa = 3.371629E-9           a1 = 0                        a2 = 1
+rdsw = 100.002354             prwb = 0                      prwg = 0
+wr = 1
//*** subthreshold related parameter ***
+voff = -0.149369              lvoff = -1.226235E-9          wvoff = -7.837735E-10
+pvoff = 1.980284E-16          voffl = -3.595178E-9          minv = -0.15
+nfactor = 1.264979            lnfactor = 4.997541E-8        wnfactor = 3.563301E-9
+pnfactor = 1.407068E-16       eta0 = 2.963491E-3            etab = -0.026723
+letab = 5.371771E-9           dsub = 0.422235               cit = 7.212E-4
+cdsc = 0                      cdscb = 0                     cdscd = 0
//*** output resistance related parameter ***
+pclm = 1.441266               pdiblc1 = 4.53031E-4          pdiblc2 = 8.242172E-3
+lpdiblc2 = -2.597034E-10      wpdiblc2 = 2.928076E-10       ppdiblc2 = -6.226163E-17
+pdiblcb = 1                   drout = 0.56                  pscbe1 = 1E9
+pscbe2 = 1E-20                pvag = 1.2                    delta = 7.595625E-3
+fprout = 300                  pdits = 0                     pditsl = 0
+pditsd = 0                    alpha0 = 2E-10                alpha1 = 0.01
+beta0 = 6.4                   agidl = 2.1505E-7             bgidl = 2.1392E9
+cgidl = 0.22                  egidl = 0.29734
//*** gate dielectric tunneling current ***
+aigbacc = 0.02                bigbacc = 2.47E-3             cigbacc = 0.3325
+nigbacc = 10                  aigbinv = 0.0158              bigbinv = 4.893E-3
+cigbinv = 6.1E-3              eigbinv = 1.1                 nigbinv = 10
+aigc = 0.0112                 bigc = 1.392E-3               cigc = 6.22E-4
+aigsd = 0.0106                bigsd = 1.235E-3              cigsd = 0.07
+dlcig = 2.48E-9               nigc = 3.07                   poxedge = 1
+pigcd = 2.591                 ntox = 1                      toxref = 3E-9
//*** capacitance parameter ***
+xpart = 1                     cgso = 5.53E-11+dcgso_n_cap       cgdo = 5.53E-11+dcgdo_n_cap
+cgbo = 0                      ckappas = 0.6                 ckappad = 0.6
+cf = 8.13E-11                 clc = 1.04E-7                 cle = 0.6
+dlc = 0                 dwc = 0                       noff = 2.96
+voffcv = -0.12                acde = 1                      moin = 5.67
+cgsl = 1.71E-11+dcgsl_n_cap       cgdl = 1.71E-11+dcgdl_n_cap
//*** souce/drain junction diode model parameter **
+ijthsrev = 0.01               ijthsfwd = 0.01               xjbvs = 1
+bvs = 10                      jss = 2.1E-7                  jsws = 3.4E-13
+jswgs = 1.2E-12               cjs = 8.61E-4+dcj_n_cap           mjs = 0.264
+mjsws = 0.011                 cjsws = 4.87E-11+dcjsw_n_cap      cjswgs = 2.56E-10+dcjswg_n_cap
+mjswgs = 0.511                pbs = 0.511                   pbsws = 0.786
+pbswgs = 0.464
//** rf model related parameter ***
+xrcrg1 = 12                   xrcrg2 = 1                    rbpb = 50
+rbpd = 50                     rbps = 50                     rbdb = 50
+rbsb = 50                     gbmin = 1E-12
//*** stress effect related parameter ***
+saref = 6.1E-7                sbref = 6.1E-7                wlod = 1.37E-7
+ku0 = -3.471E-8               kvsat = 0.342                 kvth0 = 2.461E-9
+tku0 = 0.097                  llodku0 = 1                   wlodku0 = 1
+llodvth = 1                   wlodvth = 1                   lku0 = 1.23E-8
+wku0 = 9.96E-8                pku0 = 4.6E-14                lkvth0 = -2.421E-11
+wkvth0 = 0                    pkvth0 = 0                    stk2 = 3.87E-10
+lodk2 = 0.5                   steta0 = 0                    lodeta0 = 1
//*** temperature coefficient ***
+tnom = 25                     ute = -1                      kt1 = -0.18098
+kt1l = 0                      kt2 = -0.036                  ua1 = 1.04E-9
+ub1 = -4.64E-19               uc1 = 8.71E-11                at = 1.4E5
+prt = 0                       njs = 1                       njd = 1
+xtis = 3                      xtid = 3                      tpb = 1.1E-3
+tpbsw = 1.9E-3                tpbswg = 1E-3                 tcj = 6.52E-4
+tcjsw = 3.57E-4               tcjswg = 1.5E-3               tvoff = 2.2428E-3
+tvfbsdoff = 0.022
//*** well proximity effect model parameters ***
+web = -210                    wec = -3.51E3                 kvth0we = 3.270022E-3
+k2we = 1.50195E-3             ku0we = -3.001501E-3          scref = 1E-6
23:type=n  minr=1e-60
//*** flag parameter ***
+version = 4.3                 binunit = 2                   mobmod = 0
+capmod = 2                    rdsmod = 0                    igcmod = 1
+igbmod = 1                    rbodymod = 0                  trnqsmod = 0
+acnqsmod = 0                  fnoimod = 1                   tnoimod = 0
+diomod = 1                    tempmod = 0                   permod = 1
+rgatemod = 0                  wpemod = 1
//*** geometry range parameter ***
+lmin = 6E-8                   lmax = 1E-7                   wmin = 3E-7
+wmax = 5E-7
//*** process parameter ***
+epsrox = 3.9                  toxe = tox_n_cap                  toxm = tox_n_cap
+dtox = 3.15E-10               xj = 8.1E-8                   ndep = 1E17
+ngate = 1.6E20                nsd = 1E20                    rsh = 17.5
+rshg = 15.5
//*** dw and dl parameter ***
+wint = 2E-9                   wl = 0                        wln = 1
+ww = 0                        wwn = 1                       wwl = 0
+lint = 1E-9                   ll = 0                        lln = 1
+lw = 0                        lwn = 1                       lwl = 0
+llc = 0                       lwc = 0                       lwlc = 0
+wlc = 0                       wwc = 0                       wwlc = 0
+dwg = 0                       dwb = 0                       xl = 0+dxl_n_cap
+xw = 0+dxw_n_cap
//*** flicker noise model parameter ***
+noia = 2.6E42                 noib = 1.61E21                noic = 3E8
+em = 1E6                      ef = 0.94                     lintnoi = -5E-9
//***layout-dependent parasitics model parameter ***
+dmcg = 4E-8                   dmci = 4E-8                   dmdg = 0
+dmcgt = 0                     dwj = 0                       xgw = 0
+xgl = 0                       ngcon = 1
//*** vth related  parameter ***
+vth0 = 0.33943+dvth0_n_cap        lvth0 = 8.777858E-10+dlvth0_n_cap wvth0 = 7.314006E-10+dwvth0_n_cap
+pvth0 = 1.603287E-16+dpvth0_n_cap phin = 0                      k1 = 0.30264
+k2 = -1.23791E-2              lk2 = 5.107721E-11            wk2 = -1.760528E-9
+pk2 = 1.417846E-16            k3 = -7.284535                k3b = 2.454986
+w0 = 8.190018E-8              lpe0 = 6.610138E-8            lpeb = 2.000404E-8
+dvtp0 = 2.36094E-6            dvtp1 = 4.5                   dvt0 = 0.236381
+dvt1 = 0.537442               dvt2 = 5.56679E-2             dvt0w = 0
+dvt1w = 0                     dvt2w = 0                     vfbsdoff = 0.02
//*** mobility related parameter ***
+u0 = 1.46585E-2+du0_n_cap         lu0 = 3.57012E-11+dlu0_n_cap      wu0 = 4.465776E-10+dwu0_n_cap
+pu0 = -5.872809E-17+dpu0_n_cap    ua = -1.993215E-9             lua = 1.122999E-17
+wua = 6.545105E-17            pua = -4.364133E-24           ub = 2.268421E-18
+lub = 2.907537E-28            wub = -2.222956E-26           pub = -1.913513E-33
+uc = 5.28944E-11              luc = 1.728991E-18            wuc = 5.483459E-18
+puc = -5.117814E-25           ud = 0                        vsat = 1.37107E5+dvsat_n_cap
+lvsat = 0                     wvsat = 0                     pvsat = 0
+a0 = 1E-3                     ags = 5.76775                 wags = -2.618904E-8
+b0 = 0                        b1 = 0                        keta = -8.20943E-2
+lketa = 2.842E-9              wketa = 3.371629E-9           a1 = 0
+a2 = 1                        rdsw = 100.002354             prwb = 0
+prwg = 0                      wr = 1
//*** subthreshold related parameter ***
+voff = -0.165553              lvoff = 3.598143E-10          wvoff = 3.30615E-9
+pvoff = -2.02784E-16          voffl = -3.595178E-9          minv = -0.15
+nfactor = 0.53958             lnfactor = 1.210645E-7        wnfactor = 1.519509E-9
+pnfactor = 3.409984E-16       eta0 = 7.260553E-3            leta0 = -4.211121E-10
+etab = 0.028091               dsub = 0.422235               cit = 7.212E-4
+cdsc = 0                      cdscb = 0                     cdscd = 0
//*** output resistance related parameter ***
+pclm = 1.441266               pdiblc1 = 4.53031E-4          pdiblc2 = 1.41108E-2
+lpdiblc2 = -8.348284E-10      wpdiblc2 = -1.042551E-9       ppdiblc2 = 6.860349E-17
+pdiblcb = 1                   drout = 0.56                  pscbe1 = 1E9
+pscbe2 = 1E-20                pvag = 1.2                    delta = 7.595625E-3
+fprout = 300                  pdits = 0                     pditsl = 0
+pditsd = 0                    alpha0 = 2E-10                alpha1 = 0.01
+beta0 = 6.4                   agidl = 2.1505E-7             bgidl = 2.1392E9
+cgidl = 0.22                  egidl = 0.29734
//*** gate dielectric tunneling current ***
+aigbacc = 0.02                bigbacc = 2.47E-3             cigbacc = 0.3325
+nigbacc = 10                  aigbinv = 0.0158              bigbinv = 4.893E-3
+cigbinv = 6.1E-3              eigbinv = 1.1                 nigbinv = 10
+aigc = 0.0112                 bigc = 1.392E-3               cigc = 6.22E-4
+aigsd = 0.0106                bigsd = 1.235E-3              cigsd = 0.07
+dlcig = 2.48E-9               nigc = 3.07                   poxedge = 1
+pigcd = 2.591                 ntox = 1                      toxref = 3E-9
//*** capacitance parameter ***
+xpart = 1                     cgso = 5.53E-11+dcgso_n_cap       cgdo = 5.53E-11+dcgdo_n_cap
+cgbo = 0                      ckappas = 0.6                 ckappad = 0.6
+cf = 8.13E-11                 clc = 1.04E-7                 cle = 0.6
+dlc = 0                 dwc = 0                       noff = 2.96
+voffcv = -0.12                acde = 1                      moin = 5.67
+cgsl = 1.71E-11+dcgsl_n_cap       cgdl = 1.71E-11+dcgdl_n_cap
//*** souce/drain junction diode model parameter **
+ijthsrev = 0.01               ijthsfwd = 0.01               xjbvs = 1
+bvs = 10                      jss = 2.1E-7                  jsws = 3.4E-13
+jswgs = 1.2E-12               cjs = 8.61E-4+dcj_n_cap           mjs = 0.264
+mjsws = 0.011                 cjsws = 4.87E-11+dcjsw_n_cap      cjswgs = 2.56E-10+dcjswg_n_cap
+mjswgs = 0.511                pbs = 0.511                   pbsws = 0.786
+pbswgs = 0.464
//** rf model related parameter ***
+xrcrg1 = 12                   xrcrg2 = 1                    rbpb = 50
+rbpd = 50                     rbps = 50                     rbdb = 50
+rbsb = 50                     gbmin = 1E-12
//*** stress effect related parameter ***
+saref = 6.1E-7                sbref = 6.1E-7                wlod = 1.37E-7
+ku0 = -3.471E-8               kvsat = 0.342                 kvth0 = 2.461E-9
+tku0 = 0.097                  llodku0 = 1                   wlodku0 = 1
+llodvth = 1                   wlodvth = 1                   lku0 = 1.23E-8
+wku0 = 9.96E-8                pku0 = 4.6E-14                lkvth0 = -2.421E-11
+wkvth0 = 0                    pkvth0 = 0                    stk2 = 3.87E-10
+lodk2 = 0.5                   steta0 = 0                    lodeta0 = 1
//*** temperature coefficient ***
+tnom = 25                     ute = -1                      kt1 = -0.18098
+kt1l = 0                      kt2 = -0.036                  ua1 = 1.04E-9
+ub1 = -4.64E-19               uc1 = 8.71E-11                at = 1.4E5
+prt = 0                       njs = 1                       njd = 1
+xtis = 3                      xtid = 3                      tpb = 1.1E-3
+tpbsw = 1.9E-3                tpbswg = 1E-3                 tcj = 6.52E-4
+tcjsw = 3.57E-4               tcjswg = 1.5E-3               tvoff = 2.2428E-3
+tvfbsdoff = 0.022
//*** well proximity effect model parameters ***
+web = -210                    wec = -3.51E3                 kvth0we = 3.270022E-3
+k2we = 1.50195E-3             ku0we = -3.001501E-3          scref = 1E-6
24:type=n  minr=1e-60
//*** flag parameter ***
+version = 4.3                 binunit = 2                   mobmod = 0
+capmod = 2                    rdsmod = 0                    igcmod = 1
+igbmod = 1                    rbodymod = 0                  trnqsmod = 0
+acnqsmod = 0                  fnoimod = 1                   tnoimod = 0
+diomod = 1                    tempmod = 0                   permod = 1
+rgatemod = 0                  wpemod = 1
//*** geometry range parameter ***
+lmin = 4E-8                   lmax = 6E-8                   wmin = 3E-7
+wmax = 5E-7
//*** process parameter ***
+epsrox = 3.9                  toxe = tox_n_cap                  toxm = tox_n_cap
+dtox = 3.15E-10               xj = 8.1E-8                   ndep = 1E17
+ngate = 1.6E20                nsd = 1E20                    rsh = 17.5
+rshg = 15.5
//*** dw and dl parameter ***
+wint = 2E-9                   wl = 0                        wln = 1
+ww = 0                        wwn = 1                       wwl = 0
+lint = 1E-9                   ll = 0                        lln = 1
+lw = 0                        lwn = 1                       lwl = 0
+llc = 0                       lwc = 0                       lwlc = 0
+wlc = 0                       wwc = 0                       wwlc = 0
+dwg = 0                       dwb = 0                       xl = 0+dxl_n_cap
+xw = 0+dxw_n_cap
//*** flicker noise model parameter ***
+noia = 2.6E42                 noib = 1.61E21                noic = 3E8
+em = 1E6                      ef = 0.94                     lintnoi = -5E-9
//***layout-dependent parasitics model parameter ***
+dmcg = 4E-8                   dmci = 4E-8                   dmdg = 0
+dmcgt = 0                     dwj = 0                       xgw = 0
+xgl = 0                       ngcon = 1
//*** vth related  parameter ***
+vth0 = 0.342412+dvth0_n_cap       lvth0 = 7.048128E-10+dlvth0_n_cap wvth0 = -4.507398E-9+dwvth0_n_cap
+pvth0 = 4.64179E-16+dpvth0_n_cap  phin = 0                      k1 = 0.30264
+k2 = -6.64756E-2              lk2 = 3.188669E-9             wk2 = 1.583244E-8
+pk2 = -8.786077E-16           k3 = -7.284535                k3b = 2.454986
+w0 = 8.190018E-8              lpe0 = 6.610138E-8            lpeb = 2.000404E-8
+dvtp0 = 2.36094E-6            dvtp1 = 4.5                   dvt0 = 0.236381
+dvt1 = 0.537442               dvt2 = 5.56679E-2             dvt0w = 0
+dvt1w = 0                     dvt2w = 0                     vfbsdoff = 0.02
//*** mobility related parameter ***
+u0 = 1.47947E-2+du0_n_cap         lu0 = 2.780655E-11+dlu0_n_cap     wu0 = 1.294477E-10+dwu0_n_cap
+pu0 = -4.033455E-17+dpu0_n_cap    ua = -2.036757E-9             lua = 1.375539E-17
+wua = 5.882359E-17            pua = -3.979741E-24           ub = 2.350322E-18
+lub = -4.459499E-27           wub = -5.739559E-26           pub = 1.261163E-34
+uc = -9.460524E-11            luc = 1.028397E-17            wuc = 6.842322E-17
+puc = -4.162287E-24           ud = 0                        vsat = 1.186922E5+dvsat_n_cap
+lvsat = 1.068058E-3           wvsat = 4.044781E-3           pvsat = -2.345973E-10
+a0 = 1E-3                     ags = 5.76775                 lags = 0
+wags = -2.618904E-8           pags = 0                      b0 = 0
+b1 = 0                        keta = 2.31457E-2             lketa = -3.26192E-9
+wketa = -2.452341E-8          pketa = 1.617912E-15          a1 = 0
+a2 = 1                        rdsw = 100.002354             prwb = 0
+prwg = 0                      wr = 1
//*** subthreshold related parameter ***
+voff = -0.157693              lvoff = -9.608558E-11         wvoff = 1.350707E-11
+pvoff = -1.181076E-17         voffl = -3.595178E-9          minv = -0.15
+nfactor = 0.231167            lnfactor = 1.389525E-7        wnfactor = 6.509821E-10
+pnfactor = 3.91373E-16        eta0 = 0                      etab = 0.132798
+letab = -6.073033E-9          wetab = -1.043707E-8          petab = 6.0535E-16
+dsub = 0.422235               cit = 7.212E-4                cdsc = 0
+cdscb = 0                     cdscd = 0
//*** output resistance related parameter ***
+pclm = 1.441266               pdiblc1 = -1.75958E-2         lpdiblc1 = 1.020559E-9
+wpdiblc1 = 4.231353E-9        ppdiblc1 = -2.454185E-16      pdiblc2 = 1.910801E-4
+pdiblcb = 1                   drout = 0.871183              ldrout = -1.804864E-8
+wdrout = -7.195386E-8         pdrout = 4.173324E-15         pscbe1 = 1E9
+pscbe2 = 1E-20                pvag = 1.2                    delta = 7.595625E-3
+fprout = 300                  pdits = 0                     pditsl = 0
+pditsd = 0                    alpha0 = 2E-10                alpha1 = 0.01
+beta0 = 6.4                   agidl = 2.1505E-7             bgidl = 2.1392E9
+cgidl = 0.22                  egidl = 0.29734
//*** gate dielectric tunneling current ***
+aigbacc = 0.02                bigbacc = 2.47E-3             cigbacc = 0.3325
+nigbacc = 10                  aigbinv = 0.0158              bigbinv = 4.893E-3
+cigbinv = 6.1E-3              eigbinv = 1.1                 nigbinv = 10
+aigc = 0.0112                 bigc = 1.392E-3               cigc = 6.22E-4
+aigsd = 0.0106                bigsd = 1.235E-3              cigsd = 0.07
+dlcig = 2.48E-9               nigc = 3.07                   poxedge = 1
+pigcd = 2.591                 ntox = 1                      toxref = 3E-9
//*** capacitance parameter ***
+xpart = 1                     cgso = 5.53E-11+dcgso_n_cap       cgdo = 5.53E-11+dcgdo_n_cap
+cgbo = 0                      ckappas = 0.6                 ckappad = 0.6
+cf = 8.13E-11                 clc = 1.04E-7                 cle = 0.6
+dlc = 0                 dwc = 0                       noff = 2.96
+voffcv = -0.12                acde = 1                      moin = 5.67
+cgsl = 1.71E-11+dcgsl_n_cap       cgdl = 1.71E-11+dcgdl_n_cap
//*** souce/drain junction diode model parameter **
+ijthsrev = 0.01               ijthsfwd = 0.01               xjbvs = 1
+bvs = 10                      jss = 2.1E-7                  jsws = 3.4E-13
+jswgs = 1.2E-12               cjs = 8.61E-4+dcj_n_cap           mjs = 0.264
+mjsws = 0.011                 cjsws = 4.87E-11+dcjsw_n_cap      cjswgs = 2.56E-10+dcjswg_n_cap
+mjswgs = 0.511                pbs = 0.511                   pbsws = 0.786
+pbswgs = 0.464
//** rf model related parameter ***
+xrcrg1 = 12                   xrcrg2 = 1                    rbpb = 50
+rbpd = 50                     rbps = 50                     rbdb = 50
+rbsb = 50                     gbmin = 1E-12
//*** stress effect related parameter ***
+saref = 6.1E-7                sbref = 6.1E-7                wlod = 1.37E-7
+ku0 = -3.471E-8               kvsat = 0.342                 kvth0 = 2.461E-9
+tku0 = 0.097                  llodku0 = 1                   wlodku0 = 1
+llodvth = 1                   wlodvth = 1                   lku0 = 1.23E-8
+wku0 = 9.96E-8                pku0 = 4.6E-14                lkvth0 = -2.421E-11
+wkvth0 = 0                    pkvth0 = 0                    stk2 = 3.87E-10
+lodk2 = 0.5                   steta0 = 0                    lodeta0 = 1
//*** temperature coefficient ***
+tnom = 25                     ute = -1                      kt1 = -0.18098
+kt1l = 0                      kt2 = -0.036                  ua1 = 1.04E-9
+ub1 = -4.64E-19               uc1 = 8.71E-11                at = 1.4E5
+prt = 0                       njs = 1                       njd = 1
+xtis = 3                      xtid = 3                      tpb = 1.1E-3
+tpbsw = 1.9E-3                tpbswg = 1E-3                 tcj = 6.52E-4
+tcjsw = 3.57E-4               tcjswg = 1.5E-3               tvoff = 2.2428E-3
+tvfbsdoff = 0.022
//*** well proximity effect model parameters ***
+web = -210                    wec = -3.51E3                 kvth0we = 3.270022E-3
+k2we = 1.50195E-3             ku0we = -3.001501E-3          scref = 1E-6
25:type=n  minr=1e-60
//*** flag parameter ***
+version = 4.3                 binunit = 2                   mobmod = 0
+capmod = 2                    rdsmod = 0                    igcmod = 1
+igbmod = 1                    rbodymod = 0                  trnqsmod = 0
+acnqsmod = 0                  fnoimod = 1                   tnoimod = 0
+diomod = 1                    tempmod = 0                   permod = 1
+rgatemod = 0                  wpemod = 1
//*** geometry range parameter ***
+lmin = 2E-6                   lmax = 1E-5                   wmin = 1.2E-7
+wmax = 3E-7
//*** process parameter ***
+epsrox = 3.9                  toxe = tox_n_cap                  toxm = tox_n_cap
+dtox = 3.15E-10               xj = 8.1E-8                   ndep = 1E17
+ngate = 1.6E20                nsd = 1E20                    rsh = 17.5
+rshg = 15.5
//*** dw and dl parameter ***
+wint = 2E-9                   wl = 0                        wln = 1
+ww = 0                        wwn = 1                       wwl = 0
+lint = 1E-9                   ll = 0                        lln = 1
+lw = 0                        lwn = 1                       lwl = 0
+llc = 0                       lwc = 0                       lwlc = 0
+wlc = 0                       wwc = 0                       wwlc = 0
+dwg = 0                       dwb = 0                       xl = 0+dxl_n_cap
+xw = 0+dxw_n_cap
//*** flicker noise model parameter ***
+noia = 2.6E42                 noib = 1.61E21                noic = 3E8
+em = 1E6                      ef = 0.94                     lintnoi = -5E-9
//***layout-dependent parasitics model parameter ***
+dmcg = 4E-8                   dmci = 4E-8                   dmdg = 0
+dmcgt = 0                     dwj = 0                       xgw = 0
+xgl = 0                       ngcon = 1
//*** vth related  parameter ***
+vth0 = 0.349488+dvth0_n_cap       lvth0 = 0+dlvth0_n_cap            wvth0 = 0+dwvth0_n_cap
+pvth0 = 0+dpvth0_n_cap            phin = 0                      k1 = 0.30264
+k2 = -1.21781E-2              lk2 = 3.043477E-9             wk2 = 5.042589E-10
+pk2 = -9.008692E-16           k3 = -7.284535                k3b = 2.454986
+w0 = 8.190018E-8              lpe0 = 6.610138E-8            lpeb = 2.000404E-8
+dvtp0 = 2.36094E-6            dvtp1 = 4.5                   dvt0 = 0.236381
+dvt1 = 0.537442               dvt2 = 5.56679E-2             dvt0w = 0
+dvt1w = 0                     dvt2w = 0                     vfbsdoff = 0.02
//*** mobility related parameter ***
+u0 = 1.49507E-2+du0_n_cap         lu0 = -2.610309E-10+dlu0_n_cap    wu0 = -1.699856E-12+dwu0_n_cap
+pu0 = 2.634031E-17+dpu0_n_cap     ua = -1.936611E-9             lua = -3.118543E-17
+wua = 5.864088E-18            pua = 6.434086E-24            ub = 2.26587E-18
+lub = 8.774737E-27            wub = 7.689905E-27            pub = -9.764493E-33
+uc = 6.616797E-11             ud = 0                        vsat = 1.37107E5+dvsat_n_cap
+lvsat = 0                     wvsat = 0                     pvsat = 0
+a0 = 1.770469                 la0 = -1.057674E-6            wa0 = 1.592225E-8
+pa0 = 1.597947E-14            ags = 1.016697                lags = 8.232935E-7
+b0 = 0                        b1 = 0                        keta = -6.78466E-2
+lketa = 6.141699E-8           wketa = 3.397866E-10          pketa = -3.397186E-15
+a1 = 0                        a2 = 1                        rdsw = 100.002354
+prwb = 0                      prwg = 0                      wr = 1
//*** subthreshold related parameter ***
+voff = -0.153733              lvoff = -6.034418E-10         wvoff = 1.072702E-10
+pvoff = 1.786188E-16          voffl = -3.595178E-9          minv = -0.15
+nfactor = 1.073035            lnfactor = -6.661836E-8       wnfactor = 3.845746E-9
+pnfactor = 1.971904E-14       eta0 = 2.963491E-3            etab = -1.59363E-2
+dsub = 0.422235               cit = 7.212E-4                cdsc = 0
+cdscb = 0                     cdscd = 0
//*** output resistance related parameter ***
+pclm = 1.441266               pdiblc1 = 4.53031E-4          pdiblc2 = 8.622754E-3
+lpdiblc2 = -8.039144E-10      wpdiblc2 = -4.962212E-12      ppdiblc2 = 4.96122E-17
+pdiblcb = 1                   drout = 0.56                  pscbe1 = 1E9
+pscbe2 = 1E-20                pvag = 1.2                    delta = 7.595625E-3
+fprout = 300                  pdits = 0                     pditsl = 0
+pditsd = 0                    alpha0 = 2E-10                alpha1 = 0.01
+beta0 = 6.4                   agidl = 2.1505E-7             bgidl = 2.1392E9
+cgidl = 0.22                  egidl = 0.29734
//*** gate dielectric tunneling current ***
+aigbacc = 0.02                bigbacc = 2.47E-3             cigbacc = 0.3325
+nigbacc = 10                  aigbinv = 0.0158              bigbinv = 4.893E-3
+cigbinv = 6.1E-3              eigbinv = 1.1                 nigbinv = 10
+aigc = 0.0112                 bigc = 1.392E-3               cigc = 6.22E-4
+aigsd = 0.0106                bigsd = 1.235E-3              cigsd = 0.07
+dlcig = 2.48E-9               nigc = 3.07                   poxedge = 1
+pigcd = 2.591                 ntox = 1                      toxref = 3E-9
//*** capacitance parameter ***
+xpart = 1                     cgso = 5.53E-11+dcgso_n_cap       cgdo = 5.53E-11+dcgdo_n_cap
+cgbo = 0                      ckappas = 0.6                 ckappad = 0.6
+cf = 8.13E-11                 clc = 1.04E-7                 cle = 0.6
+dlc = 0                 dwc = 0                       noff = 2.96
+voffcv = -0.12                acde = 1                      moin = 5.67
+cgsl = 1.71E-11+dcgsl_n_cap       cgdl = 1.71E-11+dcgdl_n_cap
//*** souce/drain junction diode model parameter **
+ijthsrev = 0.01               ijthsfwd = 0.01               xjbvs = 1
+bvs = 10                      jss = 2.1E-7                  jsws = 3.4E-13
+jswgs = 1.2E-12               cjs = 8.61E-4+dcj_n_cap           mjs = 0.264
+mjsws = 0.011                 cjsws = 4.87E-11+dcjsw_n_cap      cjswgs = 2.56E-10+dcjswg_n_cap
+mjswgs = 0.511                pbs = 0.511                   pbsws = 0.786
+pbswgs = 0.464
//** rf model related parameter ***
+xrcrg1 = 12                   xrcrg2 = 1                    rbpb = 50
+rbpd = 50                     rbps = 50                     rbdb = 50
+rbsb = 50                     gbmin = 1E-12
//*** stress effect related parameter ***
+saref = 6.1E-7                sbref = 6.1E-7                wlod = 1.37E-7
+ku0 = -3.471E-8               kvsat = 0.342                 kvth0 = 2.461E-9
+tku0 = 0.097                  llodku0 = 1                   wlodku0 = 1
+llodvth = 1                   wlodvth = 1                   lku0 = 1.23E-8
+wku0 = 9.96E-8                pku0 = 4.6E-14                lkvth0 = -2.421E-11
+wkvth0 = 0                    pkvth0 = 0                    stk2 = 3.87E-10
+lodk2 = 0.5                   steta0 = 0                    lodeta0 = 1
//*** temperature coefficient ***
+tnom = 25                     ute = -1                      kt1 = -0.18098
+kt1l = 0                      kt2 = -0.036                  ua1 = 1.04E-9
+ub1 = -4.64E-19               uc1 = 8.71E-11                at = 1.4E5
+prt = 0                       njs = 1                       njd = 1
+xtis = 3                      xtid = 3                      tpb = 1.1E-3
+tpbsw = 1.9E-3                tpbswg = 1E-3                 tcj = 6.52E-4
+tcjsw = 3.57E-4               tcjswg = 1.5E-3               tvoff = 2.2428E-3
+tvfbsdoff = 0.022
//*** well proximity effect model parameters ***
+web = -210                    wec = -3.51E3                 kvth0we = 3.270022E-3
+k2we = 1.50195E-3             ku0we = -3.001501E-3          scref = 1E-6
26:type=n  minr=1e-60
//*** flag parameter ***
+version = 4.3                 binunit = 2                   mobmod = 0
+capmod = 2                    rdsmod = 0                    igcmod = 1
+igbmod = 1                    rbodymod = 0                  trnqsmod = 0
+acnqsmod = 0                  fnoimod = 1                   tnoimod = 0
+diomod = 1                    tempmod = 0                   permod = 1
+rgatemod = 0                  wpemod = 1
//*** geometry range parameter ***
+lmin = 1E-6                   lmax = 2E-6                   wmin = 1.2E-7
+wmax = 3E-7
//*** process parameter ***
+epsrox = 3.9                  toxe = tox_n_cap                  toxm = tox_n_cap
+dtox = 3.15E-10               xj = 8.1E-8                   ndep = 1E17
+ngate = 1.6E20                nsd = 1E20                    rsh = 17.5
+rshg = 15.5
//*** dw and dl parameter ***
+wint = 2E-9                   wl = 0                        wln = 1
+ww = 0                        wwn = 1                       wwl = 0
+lint = 1E-9                   ll = 0                        lln = 1
+lw = 0                        lwn = 1                       lwl = 0
+llc = 0                       lwc = 0                       lwlc = 0
+wlc = 0                       wwc = 0                       wwlc = 0
+dwg = 0                       dwb = 0                       xl = 0+dxl_n_cap
+xw = 0+dxw_n_cap
//*** flicker noise model parameter ***
+noia = 2.6E42                 noib = 1.61E21                noic = 3E8
+em = 1E6                      ef = 0.94                     lintnoi = -5E-9
//***layout-dependent parasitics model parameter ***
+dmcg = 4E-8                   dmci = 4E-8                   dmdg = 0
+dmcgt = 0                     dwj = 0                       xgw = 0
+xgl = 0                       ngcon = 1
//*** vth related  parameter ***
+vth0 = 0.349059+dvth0_n_cap       lvth0 = 7.586077E-11+dlvth0_n_cap wvth0 = -2.319752E-10+dwvth0_n_cap
+pvth0 = 5.541952E-16+dpvth0_n_cap phin = 0                      k1 = 0.30264
+k2 = -1.23769E-2              lk2 = 3.440782E-9             wk2 = 5.631189E-10
+pk2 = -1.018472E-15           k3 = -7.284535                k3b = 2.454986
+w0 = 8.190018E-8              lpe0 = 6.610138E-8            lpeb = 2.000404E-8
+dvtp0 = 2.36094E-6            dvtp1 = 4.5                   dvt0 = 0.236381
+dvt1 = 0.537442               dvt2 = 5.56679E-2             dvt0w = 0
+dvt1w = 0                     dvt2w = 0                     vfbsdoff = 0.02
//*** mobility related parameter ***
+u0 = 1.51036E-2+du0_n_cap         lu0 = -5.665364E-10+dlu0_n_cap    wu0 = -6.287662E-11+dwu0_n_cap
+pu0 = 1.485715E-16+dpu0_n_cap     ua = -1.909483E-9             lua = -8.538719E-17
+wua = -3.060751E-18           pua = 2.426591E-23            ub = 2.225764E-18
+lub = 8.89083E-26             wub = 1.597437E-26            pub = -2.631686E-32
+uc = 6.616797E-11             ud = 0                        vsat = 1.37107E5+dvsat_n_cap
+lvsat = 0                     wvsat = 0                     pvsat = 0
+a0 = 0.931772                 la0 = 6.180413E-7             wa0 = 1.423204E-8
+pa0 = 1.935651E-14            ags = 0.162436                lags = 2.530107E-6
+wags = 2.879445E-8            pags = -5.753132E-14          b0 = 0
+b1 = 0                        keta = -1.61281E-2            lketa = -4.191659E-8
+wketa = -1.662212E-9          pketa = 6.028062E-16          a1 = 0
+a2 = 1                        rdsw = 100.002354             prwb = 0
+prwg = 0                      wr = 1
//*** subthreshold related parameter ***
+voff = -0.15528               lvoff = 2.487055E-9           wvoff = 3.914216E-10
+pvoff = -3.891158E-16         voffl = -3.595178E-9          minv = -0.15
+nfactor = 0.885301            lnfactor = 3.084726E-7        wnfactor = 1.998548E-8
+pnfactor = -1.252816E-14      eta0 = 2.963491E-3            etab = -1.59363E-2
+dsub = 0.422235               cit = 7.212E-4                cdsc = 0
+cdscb = 0                     cdscd = 0
//*** output resistance related parameter ***
+pclm = 1.441266               pdiblc1 = 4.53031E-4          pdiblc2 = 8.969552E-3
+lpdiblc2 = -1.496819E-9       wpdiblc2 = -2.018822E-10      ppdiblc2 = 4.430583E-16
+pdiblcb = 1                   drout = 0.56                  pscbe1 = 1E9
+pscbe2 = 1E-20                pvag = 1.2                    delta = 7.595625E-3
+fprout = 300                  pdits = 0                     pditsl = 0
+pditsd = 0                    alpha0 = 2E-10                alpha1 = 0.01
+beta0 = 6.4                   agidl = 2.1505E-7             bgidl = 2.1392E9
+cgidl = 0.22                  egidl = 0.29734
//*** gate dielectric tunneling current ***
+aigbacc = 0.02                bigbacc = 2.47E-3             cigbacc = 0.3325
+nigbacc = 10                  aigbinv = 0.0158              bigbinv = 4.893E-3
+cigbinv = 6.1E-3              eigbinv = 1.1                 nigbinv = 10
+aigc = 0.0112                 bigc = 1.392E-3               cigc = 6.22E-4
+aigsd = 0.0106                bigsd = 1.235E-3              cigsd = 0.07
+dlcig = 2.48E-9               nigc = 3.07                   poxedge = 1
+pigcd = 2.591                 ntox = 1                      toxref = 3E-9
//*** capacitance parameter ***
+xpart = 1                     cgso = 5.53E-11+dcgso_n_cap       cgdo = 5.53E-11+dcgdo_n_cap
+cgbo = 0                      ckappas = 0.6                 ckappad = 0.6
+cf = 8.13E-11                 clc = 1.04E-7                 cle = 0.6
+dlc = 0                 dwc = 0                       noff = 2.96
+voffcv = -0.12                acde = 1                      moin = 5.67
+cgsl = 1.71E-11+dcgsl_n_cap       cgdl = 1.71E-11+dcgdl_n_cap
//*** souce/drain junction diode model parameter **
+ijthsrev = 0.01               ijthsfwd = 0.01               xjbvs = 1
+bvs = 10                      jss = 2.1E-7                  jsws = 3.4E-13
+jswgs = 1.2E-12               cjs = 8.61E-4+dcj_n_cap           mjs = 0.264
+mjsws = 0.011                 cjsws = 4.87E-11+dcjsw_n_cap      cjswgs = 2.56E-10+dcjswg_n_cap
+mjswgs = 0.511                pbs = 0.511                   pbsws = 0.786
+pbswgs = 0.464
//** rf model related parameter ***
+xrcrg1 = 12                   xrcrg2 = 1                    rbpb = 50
+rbpd = 50                     rbps = 50                     rbdb = 50
+rbsb = 50                     gbmin = 1E-12
//*** stress effect related parameter ***
+saref = 6.1E-7                sbref = 6.1E-7                wlod = 1.37E-7
+ku0 = -3.471E-8               kvsat = 0.342                 kvth0 = 2.461E-9
+tku0 = 0.097                  llodku0 = 1                   wlodku0 = 1
+llodvth = 1                   wlodvth = 1                   lku0 = 1.23E-8
+wku0 = 9.96E-8                pku0 = 4.6E-14                lkvth0 = -2.421E-11
+wkvth0 = 0                    pkvth0 = 0                    stk2 = 3.87E-10
+lodk2 = 0.5                   steta0 = 0                    lodeta0 = 1
//*** temperature coefficient ***
+tnom = 25                     ute = -1                      kt1 = -0.18098
+kt1l = 0                      kt2 = -0.036                  ua1 = 1.04E-9
+ub1 = -4.64E-19               uc1 = 8.71E-11                at = 1.4E5
+prt = 0                       njs = 1                       njd = 1
+xtis = 3                      xtid = 3                      tpb = 1.1E-3
+tpbsw = 1.9E-3                tpbswg = 1E-3                 tcj = 6.52E-4
+tcjsw = 3.57E-4               tcjswg = 1.5E-3               tvoff = 2.2428E-3
+tvfbsdoff = 0.022
//*** well proximity effect model parameters ***
+web = -210                    wec = -3.51E3                 kvth0we = 3.270022E-3
+k2we = 1.50195E-3             ku0we = -3.001501E-3          scref = 1E-6
27:type=n  minr=1e-60
//*** flag parameter ***
+version = 4.3                 binunit = 2                   mobmod = 0
+capmod = 2                    rdsmod = 0                    igcmod = 1
+igbmod = 1                    rbodymod = 0                  trnqsmod = 0
+acnqsmod = 0                  fnoimod = 1                   tnoimod = 0
+diomod = 1                    tempmod = 0                   permod = 1
+rgatemod = 0                  wpemod = 1
//*** geometry range parameter ***
+lmin = 5E-7                   lmax = 1E-6                   wmin = 1.2E-7
+wmax = 3E-7
//*** process parameter ***
+epsrox = 3.9                  toxe = tox_n_cap                  toxm = tox_n_cap
+dtox = 3.15E-10               xj = 8.1E-8                   ndep = 1E17
+ngate = 1.6E20                nsd = 1E20                    rsh = 17.5
+rshg = 15.5
//*** dw and dl parameter ***
+wint = 2E-9                   wl = 0                        wln = 1
+ww = 0                        wwn = 1                       wwl = 0
+lint = 1E-9                   ll = 0                        lln = 1
+lw = 0                        lwn = 1                       lwl = 0
+llc = 0                       lwc = 0                       lwlc = 0
+wlc = 0                       wwc = 0                       wwlc = 0
+dwg = 0                       dwb = 0                       xl = 0+dxl_n_cap
+xw = 0+dxw_n_cap
//*** flicker noise model parameter ***
+noia = 2.6E42                 noib = 1.61E21                noic = 3E8
+em = 1E6                      ef = 0.94                     lintnoi = -5E-9
//***layout-dependent parasitics model parameter ***
+dmcg = 4E-8                   dmci = 4E-8                   dmdg = 0
+dmcgt = 0                     dwj = 0                       xgw = 0
+xgl = 0                       ngcon = 1
//*** vth related  parameter ***
+vth0 = 0.348784+dvth0_n_cap       lvth0 = 3.503989E-10+dlvth0_n_cap wvth0 = 4.272566E-10+dwvth0_n_cap
+pvth0 = -1.037181E-16+dpvth0_n_cap phin = 0                      k1 = 0.30264
+k2 = -6.528617E-3             lk2 = -2.395833E-9            wk2 = -4.476281E-10
+pk2 = -9.746085E-18           k3 = -7.284535                k3b = 2.454986
+w0 = 8.190018E-8              lpe0 = 6.610138E-8            lpeb = 2.000404E-8
+dvtp0 = 2.36094E-6            dvtp1 = 4.5                   dvt0 = 0.236381
+dvt1 = 0.537442               dvt2 = 5.56679E-2             dvt0w = 0
+dvt1w = 0                     dvt2w = 0                     vfbsdoff = 0.02
//*** mobility related parameter ***
+u0 = 1.34204E-2+du0_n_cap         lu0 = 1.113296E-9+dlu0_n_cap      wu0 = 2.594938E-10+dwu0_n_cap
+pu0 = -1.731542E-16+dpu0_n_cap    ua = -2.1266E-9               lua = 1.312952E-16
+wua = 3.804818E-17            pua = -1.67608E-23            ub = 2.398431E-18
+lub = -8.341353E-26           wub = -1.720057E-26           pub = 6.791732E-33
+uc = 6.698292E-11             luc = -8.133177E-19           wuc = 5.0489E-19
+puc = -5.038802E-25           ud = 0                        vsat = 1.37107E5+dvsat_n_cap
+lvsat = 0                     wvsat = 0                     pvsat = 0
+a0 = 1.438993                 la0 = 1.118354E-7             wa0 = 4.662625E-8
+pa0 = -1.297291E-14           ags = 0.876787                lags = 1.817185E-6
+wags = -1.127899E-8           pags = -1.753802E-14          b0 = 0
+b1 = 0                        keta = -5.81287E-2            wketa = -1.058197E-9
+a1 = 0                        a2 = 1                        rdsw = 100.002354
+prwb = 0                      prwg = 0                      wr = 1
//*** subthreshold related parameter ***
+voff = -0.151803              lvoff = -9.831402E-10         wvoff = -1.859966E-10
+pvoff = 1.871476E-16          voffl = -3.595178E-9          minv = -0.15
+nfactor = 1.015576            lnfactor = 1.784584E-7        wnfactor = 1.35382E-8
+pnfactor = -6.093768E-15      eta0 = 2.963491E-3            etab = -1.59363E-2
+dsub = 0.422235               cit = 7.212E-4                cdsc = 0
+cdscb = 0                     cdscd = 0
//*** output resistance related parameter ***
+pclm = 1.441266               pdiblc1 = 4.53031E-4          pdiblc2 = 6.946556E-3
+lpdiblc2 = 5.221321E-10       wpdiblc2 = 3.969249E-10       ppdiblc2 = -1.545511E-16
+pdiblcb = 1                   drout = 0.56                  pscbe1 = 1E9
+pscbe2 = 1E-20                pvag = 1.2                    delta = 7.595625E-3
+fprout = 300                  pdits = 0                     pditsl = 0
+pditsd = 0                    alpha0 = 2E-10                alpha1 = 0.01
+beta0 = 6.4                   agidl = 2.1505E-7             bgidl = 2.1392E9
+cgidl = 0.22                  egidl = 0.29734
//*** gate dielectric tunneling current ***
+aigbacc = 0.02                bigbacc = 2.47E-3             cigbacc = 0.3325
+nigbacc = 10                  aigbinv = 0.0158              bigbinv = 4.893E-3
+cigbinv = 6.1E-3              eigbinv = 1.1                 nigbinv = 10
+aigc = 0.0112                 bigc = 1.392E-3               cigc = 6.22E-4
+aigsd = 0.0106                bigsd = 1.235E-3              cigsd = 0.07
+dlcig = 2.48E-9               nigc = 3.07                   poxedge = 1
+pigcd = 2.591                 ntox = 1                      toxref = 3E-9
//*** capacitance parameter ***
+xpart = 1                     cgso = 5.53E-11+dcgso_n_cap       cgdo = 5.53E-11+dcgdo_n_cap
+cgbo = 0                      ckappas = 0.6                 ckappad = 0.6
+cf = 8.13E-11                 clc = 1.04E-7                 cle = 0.6
+dlc = 0                 dwc = 0                       noff = 2.96
+voffcv = -0.12                acde = 1                      moin = 5.67
+cgsl = 1.71E-11+dcgsl_n_cap       cgdl = 1.71E-11+dcgdl_n_cap
//*** souce/drain junction diode model parameter **
+ijthsrev = 0.01               ijthsfwd = 0.01               xjbvs = 1
+bvs = 10                      jss = 2.1E-7                  jsws = 3.4E-13
+jswgs = 1.2E-12               cjs = 8.61E-4+dcj_n_cap           mjs = 0.264
+mjsws = 0.011                 cjsws = 4.87E-11+dcjsw_n_cap      cjswgs = 2.56E-10+dcjswg_n_cap
+mjswgs = 0.511                pbs = 0.511                   pbsws = 0.786
+pbswgs = 0.464
//** rf model related parameter ***
+xrcrg1 = 12                   xrcrg2 = 1                    rbpb = 50
+rbpd = 50                     rbps = 50                     rbdb = 50
+rbsb = 50                     gbmin = 1E-12
//*** stress effect related parameter ***
+saref = 6.1E-7                sbref = 6.1E-7                wlod = 1.37E-7
+ku0 = -3.471E-8               kvsat = 0.342                 kvth0 = 2.461E-9
+tku0 = 0.097                  llodku0 = 1                   wlodku0 = 1
+llodvth = 1                   wlodvth = 1                   lku0 = 1.23E-8
+wku0 = 9.96E-8                pku0 = 4.6E-14                lkvth0 = -2.421E-11
+wkvth0 = 0                    pkvth0 = 0                    stk2 = 3.87E-10
+lodk2 = 0.5                   steta0 = 0                    lodeta0 = 1
//*** temperature coefficient ***
+tnom = 25                     ute = -1                      kt1 = -0.18098
+kt1l = 0                      kt2 = -0.036                  ua1 = 1.04E-9
+ub1 = -4.64E-19               uc1 = 8.71E-11                at = 1.4E5
+prt = 0                       njs = 1                       njd = 1
+xtis = 3                      xtid = 3                      tpb = 1.1E-3
+tpbsw = 1.9E-3                tpbswg = 1E-3                 tcj = 6.52E-4
+tcjsw = 3.57E-4               tcjswg = 1.5E-3               tvoff = 2.2428E-3
+tvfbsdoff = 0.022
//*** well proximity effect model parameters ***
+web = -210                    wec = -3.51E3                 kvth0we = 3.270022E-3
+k2we = 1.50195E-3             ku0we = -3.001501E-3          scref = 1E-6
28:type=n  minr=1e-60
//*** flag parameter ***
+version = 4.3                 binunit = 2                   mobmod = 0
+capmod = 2                    rdsmod = 0                    igcmod = 1
+igbmod = 1                    rbodymod = 0                  trnqsmod = 0
+acnqsmod = 0                  fnoimod = 1                   tnoimod = 0
+diomod = 1                    tempmod = 0                   permod = 1
+rgatemod = 0                  wpemod = 1
//*** geometry range parameter ***
+lmin = 1E-7                   lmax = 5E-7                   wmin = 1.2E-7
+wmax = 3E-7
//*** process parameter ***
+epsrox = 3.9                  toxe = tox_n_cap                  toxm = tox_n_cap
+dtox = 3.15E-10               xj = 8.1E-8                   ndep = 1E17
+ngate = 1.6E20                nsd = 1E20                    rsh = 17.5
+rshg = 15.5
//*** dw and dl parameter ***
+wint = 2E-9                   wl = 0                        wln = 1
+ww = 0                        wwn = 1                       wwl = 0
+lint = 1E-9                   ll = 0                        lln = 1
+lw = 0                        lwn = 1                       lwl = 0
+llc = 0                       lwc = 0                       lwlc = 0
+wlc = 0                       wwc = 0                       wwlc = 0
+dwg = 0                       dwb = 0                       xl = 0+dxl_n_cap
+xw = 0+dxw_n_cap
//*** flicker noise model parameter ***
+noia = 2.6E42                 noib = 1.61E21                noic = 3E8
+em = 1E6                      ef = 0.94                     lintnoi = -5E-9
//***layout-dependent parasitics model parameter ***
+dmcg = 4E-8                   dmci = 4E-8                   dmdg = 0
+dmcgt = 0                     dwj = 0                       xgw = 0
+xgl = 0                       ngcon = 1
//*** vth related  parameter ***
+vth0 = 0.349255+dvth0_n_cap       lvth0 = 1.157435E-10+dlvth0_n_cap wvth0 = -1.587726E-10+dwvth0_n_cap
+pvth0 = 1.881244E-16+dpvth0_n_cap phin = 0                      k1 = 0.30264
+k2 = -1.34549E-2              lk2 = 1.053451E-9             wk2 = 1.589492E-10
+pk2 = -3.118215E-16           k3 = -7.284535                k3b = 2.454986
+w0 = 8.190018E-8              lpe0 = 6.610138E-8            lpeb = 2.000404E-8
+dvtp0 = 2.36094E-6            dvtp1 = 4.5                   dvt0 = 0.236381
+dvt1 = 0.537442               dvt2 = 5.56679E-2             dvt0w = 0
+dvt1w = 0                     dvt2w = 0                     vfbsdoff = 0.02
//*** mobility related parameter ***
+u0 = 1.56718E-2+du0_n_cap         lu0 = -7.907061E-12+dlu0_n_cap    wu0 = -3.119788E-11+dwu0_n_cap
+pu0 = -2.838973E-17+dpu0_n_cap    ua = -1.872153E-9             lua = 4.580635E-18
+wua = 4.201744E-18            pua = 9.472553E-26            ub = 2.225573E-18
+lub = 2.669682E-27            wub = 4.447707E-27            pub = -3.989108E-33
+uc = 5.932589E-11             luc = 2.99988E-18             wuc = 7.11763E-19
+puc = -6.06903E-25            ud = 0                        vsat = 1.371068E5+dvsat_n_cap
+lvsat = 0                     wvsat = 0                     pvsat = 0
+a0 = 2.070889                 la0 = -2.028492E-7            wa0 = 2.561741E-8
+pa0 = -2.510506E-15           ags = 4.19311                 lags = 1.656562E-7
+wags = -4.307845E-8           pags = -1.701894E-15          b0 = 0
+b1 = 0                        keta = -5.79318E-2            lketa = -9.804344E-11
+wketa = -2.566872E-9          pketa = 7.513201E-16          a1 = 0
+a2 = 1                        rdsw = 100.002354             prwb = 0
+prwg = 0                      wr = 1
//*** subthreshold related parameter ***
+voff = -0.152827              lvoff = -4.731656E-10         wvoff = 2.397616E-10
+pvoff = -2.488E-17            voffl = -3.595178E-9          minv = -0.15
+nfactor = 1.272943            lnfactor = 5.028982E-8        wnfactor = 1.206049E-9
+pnfactor = 4.764205E-17       eta0 = 2.647713E-3            leta0 = 1.572573E-10
+weta0 = 9.347022E-11          peta0 = -4.654817E-17         etab = -0.026723
+letab = 5.371771E-9           dsub = 0.422235               cit = 7.212E-4
+cdsc = 0                      cdscb = 0                     cdscd = 0
//*** output resistance related parameter ***
+pclm = 1.441266               pdiblc1 = 4.53031E-4          pdiblc2 = 8.799015E-3
+lpdiblc2 = -4.003927E-10      wpdiblc2 = 1.27982E-10        ppdiblc2 = -2.061758E-17
+pdiblcb = 1                   drout = 0.56                  pscbe1 = 1E9
+pscbe2 = 1E-20                pvag = 1.2                    delta = 7.595625E-3
+fprout = 300                  pdits = 0                     pditsl = 0
+pditsd = 0                    alpha0 = 2E-10                alpha1 = 0.01
+beta0 = 6.4                   agidl = 2.1505E-7             bgidl = 2.1392E9
+cgidl = 0.22                  egidl = 0.29734
//*** gate dielectric tunneling current ***
+aigbacc = 0.02                bigbacc = 2.47E-3             cigbacc = 0.3325
+nigbacc = 10                  aigbinv = 0.0158              bigbinv = 4.893E-3
+cigbinv = 6.1E-3              eigbinv = 1.1                 nigbinv = 10
+aigc = 0.0112                 bigc = 1.392E-3               cigc = 6.22E-4
+aigsd = 0.0106                bigsd = 1.235E-3              cigsd = 0.07
+dlcig = 2.48E-9               nigc = 3.07                   poxedge = 1
+pigcd = 2.591                 ntox = 1                      toxref = 3E-9
//*** capacitance parameter ***
+xpart = 1                     cgso = 5.53E-11+dcgso_n_cap       cgdo = 5.53E-11+dcgdo_n_cap
+cgbo = 0                      ckappas = 0.6                 ckappad = 0.6
+cf = 8.13E-11                 clc = 1.04E-7                 cle = 0.6
+dlc = 0                 dwc = 0                       noff = 2.96
+voffcv = -0.12                acde = 1                      moin = 5.67
+cgsl = 1.71E-11+dcgsl_n_cap       cgdl = 1.71E-11+dcgdl_n_cap
//*** souce/drain junction diode model parameter **
+ijthsrev = 0.01               ijthsfwd = 0.01               xjbvs = 1
+bvs = 10                      jss = 2.1E-7                  jsws = 3.4E-13
+jswgs = 1.2E-12               cjs = 8.61E-4+dcj_n_cap           mjs = 0.264
+mjsws = 0.011                 cjsws = 4.87E-11+dcjsw_n_cap      cjswgs = 2.56E-10+dcjswg_n_cap
+mjswgs = 0.511                pbs = 0.511                   pbsws = 0.786
+pbswgs = 0.464
//** rf model related parameter ***
+xrcrg1 = 12                   xrcrg2 = 1                    rbpb = 50
+rbpd = 50                     rbps = 50                     rbdb = 50
+rbsb = 50                     gbmin = 1E-12
//*** stress effect related parameter ***
+saref = 6.1E-7                sbref = 6.1E-7                wlod = 1.37E-7
+ku0 = -3.471E-8               kvsat = 0.342                 kvth0 = 2.461E-9
+tku0 = 0.097                  llodku0 = 1                   wlodku0 = 1
+llodvth = 1                   wlodvth = 1                   lku0 = 1.23E-8
+wku0 = 9.96E-8                pku0 = 4.6E-14                lkvth0 = -2.421E-11
+wkvth0 = 0                    pkvth0 = 0                    stk2 = 3.87E-10
+lodk2 = 0.5                   steta0 = 0                    lodeta0 = 1
//*** temperature coefficient ***
+tnom = 25                     ute = -1                      kt1 = -0.18098
+kt1l = 0                      kt2 = -0.036                  ua1 = 1.04E-9
+ub1 = -4.64E-19               uc1 = 8.71E-11                at = 1.4E5
+prt = 0                       njs = 1                       njd = 1
+xtis = 3                      xtid = 3                      tpb = 1.1E-3
+tpbsw = 1.9E-3                tpbswg = 1E-3                 tcj = 6.52E-4
+tcjsw = 3.57E-4               tcjswg = 1.5E-3               tvoff = 2.2428E-3
+tvfbsdoff = 0.022
//*** well proximity effect model parameters ***
+web = -210                    wec = -3.51E3                 kvth0we = 3.270022E-3
+k2we = 1.50195E-3             ku0we = -3.001501E-3          scref = 1E-6
29:type=n  minr=1e-60
//*** flag parameter ***
+version = 4.3                 binunit = 2                   mobmod = 0
+capmod = 2                    rdsmod = 0                    igcmod = 1
+igbmod = 1                    rbodymod = 0                  trnqsmod = 0
+acnqsmod = 0                  fnoimod = 1                   tnoimod = 0
+diomod = 1                    tempmod = 0                   permod = 1
+rgatemod = 0                  wpemod = 1
//*** geometry range parameter ***
+lmin = 6E-8                   lmax = 1E-7                   wmin = 1.2E-7
+wmax = 3E-7
//*** process parameter ***
+epsrox = 3.9                  toxe = tox_n_cap                  toxm = tox_n_cap
+dtox = 3.15E-10               xj = 8.1E-8                   ndep = 1E17
+ngate = 1.6E20                nsd = 1E20                    rsh = 17.5
+rshg = 15.5
//*** dw and dl parameter ***
+wint = 2E-9                   wl = 0                        wln = 1
+ww = 0                        wwn = 1                       wwl = 0
+lint = 1E-9                   ll = 0                        lln = 1
+lw = 0                        lwn = 1                       lwl = 0
+llc = 0                       lwc = 0                       lwlc = 0
+wlc = 0                       wwc = 0                       wwlc = 0
+dwg = 0                       dwb = 0                       xl = 0+dxl_n_cap
+xw = 0+dxw_n_cap
//*** flicker noise model parameter ***
+noia = 2.6E42                 noib = 1.61E21                noic = 3E8
+em = 1E6                      ef = 0.94                     lintnoi = -5E-9
//***layout-dependent parasitics model parameter ***
+dmcg = 4E-8                   dmci = 4E-8                   dmdg = 0
+dmcgt = 0                     dwj = 0                       xgw = 0
+xgl = 0                       ngcon = 1
//*** vth related  parameter ***
+vth0 = 0.344382+dvth0_n_cap       lvth0 = 5.933338E-10+dlvth0_n_cap wvth0 = -7.34304E-10+dwvth0_n_cap
+pvth0 = 2.445265E-16+dpvth0_n_cap phin = 0                      k1 = 0.30264
+k2 = -1.16001E-2              lk2 = 8.71686E-10             wk2 = -1.991112E-9
+pk2 = -1.011156E-16           k3 = -7.284535                k3b = 2.454986
+w0 = 8.190018E-8              lpe0 = 6.610138E-8            lpeb = 2.000404E-8
+dvtp0 = 2.36094E-6            dvtp1 = 4.5                   dvt0 = 0.236381
+dvt1 = 0.537442               dvt2 = 5.56679E-2             dvt0w = 0
+dvt1w = 0                     dvt2w = 0                     vfbsdoff = 0.02
//*** mobility related parameter ***
+u0 = 1.91549E-2+du0_n_cap         lu0 = -3.492531E-10+dlu0_n_cap    wu0 = -8.843418E-10+dwu0_n_cap
+pu0 = 5.521838E-17+dpu0_n_cap     ua = -1.519581E-9             lua = -2.997144E-17
+wua = -7.474483E-17           pua = 7.831489E-24            ub = 2.091451E-18
+lub = 1.581366E-26            wub = 3.015367E-26            pub = -6.508292E-33
+uc = 9.555014E-11             luc = -5.500962E-19           wuc = -7.142639E-18
+puc = 1.628285E-25            ud = 0                        vsat = 1.37107E5+dvsat_n_cap
+lvsat = 0                     wvsat = 0                     pvsat = 0
+a0 = 1E-3                     ags = 5.883479                wags = -6.044471E-8
+b0 = 0                        b1 = 0                        keta = -9.75185E-2
+lketa = 3.781446E-9           wketa = 7.937171E-9           pketa = -2.780761E-16
+a1 = 0                        a2 = 1                        rdsw = 100.002354
+prwb = 0                      prwg = 0                      wr = 1
//*** subthreshold related parameter ***
+voff = -0.154763              lvoff = -2.834169E-10         wvoff = 1.122883E-10
+pvoff = -1.238761E-17         voffl = -3.595178E-9          minv = -0.15
+nfactor = 0.542976            lnfactor = 1.218266E-7        wnfactor = 5.144487E-10
+pnfactor = 1.154189E-16       eta0 = 1.13187E-2             leta0 = -6.924954E-10
+weta0 = -1.2012E-9            peta0 = 8.032947E-17          etab = 0.028091
+dsub = 0.422235               cit = 7.212E-4                cdsc = 0
+cdscb = 0                     cdscd = 0
//*** output resistance related parameter ***
+pclm = 1.441266               pdiblc1 = 4.53031E-4          pdiblc2 = 1.10921E-2
+lpdiblc2 = -6.251199E-10      wpdiblc2 = -1.490316E-10      ppdiblc2 = 6.529758E-18
+pdiblcb = 1                   drout = 0.56                  pscbe1 = 1E9
+pscbe2 = 1E-20                pvag = 1.2                    delta = 7.595625E-3
+fprout = 300                  pdits = 0                     pditsl = 0
+pditsd = 0                    alpha0 = 2E-10                alpha1 = 0.01
+beta0 = 6.4                   agidl = 2.1505E-7             bgidl = 2.1392E9
+cgidl = 0.22                  egidl = 0.29734
//*** gate dielectric tunneling current ***
+aigbacc = 0.02                bigbacc = 2.47E-3             cigbacc = 0.3325
+nigbacc = 10                  aigbinv = 0.0158              bigbinv = 4.893E-3
+cigbinv = 6.1E-3              eigbinv = 1.1                 nigbinv = 10
+aigc = 0.0112                 bigc = 1.392E-3               cigc = 6.22E-4
+aigsd = 0.0106                bigsd = 1.235E-3              cigsd = 0.07
+dlcig = 2.48E-9               nigc = 3.07                   poxedge = 1
+pigcd = 2.591                 ntox = 1                      toxref = 3E-9
//*** capacitance parameter ***
+xpart = 1                     cgso = 5.53E-11+dcgso_n_cap       cgdo = 5.53E-11+dcgdo_n_cap
+cgbo = 0                      ckappas = 0.6                 ckappad = 0.6
+cf = 8.13E-11                 clc = 1.04E-7                 cle = 0.6
+dlc = 0                 dwc = 0                       noff = 2.96
+voffcv = -0.12                acde = 1                      moin = 5.67
+cgsl = 1.71E-11+dcgsl_n_cap       cgdl = 1.71E-11+dcgdl_n_cap
//*** souce/drain junction diode model parameter **
+ijthsrev = 0.01               ijthsfwd = 0.01               xjbvs = 1
+bvs = 10                      jss = 2.1E-7                  jsws = 3.4E-13
+jswgs = 1.2E-12               cjs = 8.61E-4+dcj_n_cap           mjs = 0.264
+mjsws = 0.011                 cjsws = 4.87E-11+dcjsw_n_cap      cjswgs = 2.56E-10+dcjswg_n_cap
+mjswgs = 0.511                pbs = 0.511                   pbsws = 0.786
+pbswgs = 0.464
//** rf model related parameter ***
+xrcrg1 = 12                   xrcrg2 = 1                    rbpb = 50
+rbpd = 50                     rbps = 50                     rbdb = 50
+rbsb = 50                     gbmin = 1E-12
//*** stress effect related parameter ***
+saref = 6.1E-7                sbref = 6.1E-7                wlod = 1.37E-7
+ku0 = -3.471E-8               kvsat = 0.342                 kvth0 = 2.461E-9
+tku0 = 0.097                  llodku0 = 1                   wlodku0 = 1
+llodvth = 1                   wlodvth = 1                   lku0 = 1.23E-8
+wku0 = 9.96E-8                pku0 = 4.6E-14                lkvth0 = -2.421E-11
+wkvth0 = 0                    pkvth0 = 0                    stk2 = 3.87E-10
+lodk2 = 0.5                   steta0 = 0                    lodeta0 = 1
//*** temperature coefficient ***
+tnom = 25                     ute = -1                      kt1 = -0.18098
+kt1l = 0                      kt2 = -0.036                  ua1 = 1.04E-9
+ub1 = -4.64E-19               uc1 = 8.71E-11                at = 1.4E5
+prt = 0                       njs = 1                       njd = 1
+xtis = 3                      xtid = 3                      tpb = 1.1E-3
+tpbsw = 1.9E-3                tpbswg = 1E-3                 tcj = 6.52E-4
+tcjsw = 3.57E-4               tcjswg = 1.5E-3               tvoff = 2.2428E-3
+tvfbsdoff = 0.022
//*** well proximity effect model parameters ***
+web = -210                    wec = -3.51E3                 kvth0we = 3.270022E-3
+k2we = 1.50195E-3             ku0we = -3.001501E-3          scref = 1E-6
30:type=n  minr=1e-60
//*** flag parameter ***
+version = 4.3                 binunit = 2                   mobmod = 0
+capmod = 2                    rdsmod = 0                    igcmod = 1
+igbmod = 1                    rbodymod = 0                  trnqsmod = 0
+acnqsmod = 0                  fnoimod = 1                   tnoimod = 0
+diomod = 1                    tempmod = 0                   permod = 1
+rgatemod = 0                  wpemod = 1
//*** geometry range parameter ***
+lmin = 4E-8                   lmax = 6E-8                   wmin = 1.2E-7
+wmax = 3E-7
//*** process parameter ***
+epsrox = 3.9                  toxe = tox_n_cap                  toxm = tox_n_cap
+dtox = 3.15E-10               xj = 8.1E-8                   ndep = 1E17
+ngate = 1.6E20                nsd = 1E20                    rsh = 17.5
+rshg = 15.5
//*** dw and dl parameter ***
+wint = 2E-9                   wl = 0                        wln = 1
+ww = 0                        wwn = 1                       wwl = 0
+lint = 1E-9                   ll = 0                        lln = 1
+lw = 0                        lwn = 1                       lwl = 0
+llc = 0                       lwc = 0                       lwlc = 0
+wlc = 0                       wwc = 0                       wwlc = 0
+dwg = 0                       dwb = 0                       xl = 0+dxl_n_cap
+xw = 0+dxw_n_cap
//*** flicker noise model parameter ***
+noia = 2.6E42                 noib = 1.61E21                noic = 3E8
+em = 1E6                      ef = 0.94                     lintnoi = -5E-9
//***layout-dependent parasitics model parameter ***
+dmcg = 4E-8                   dmci = 4E-8                   dmdg = 0
+dmcgt = 0                     dwj = 0                       xgw = 0
+xgl = 0                       ngcon = 1
//*** vth related  parameter ***
+vth0 = 0.31918+dvth0_n_cap        lvth0 = 2.055032E-9+dlvth0_n_cap  wvth0 = 2.369356E-9+dwvth0_n_cap
+pvth0 = 6.451425E-17+dpvth0_n_cap phin = 0                      k1 = 0.30264
+k2 = 1.44261E-2               lk2 = -6.378356E-10           wk2 = -8.114445E-9
+pk2 = 2.540377E-16            k3 = -7.284535                k3b = 2.454986
+w0 = 8.190018E-8              lpe0 = 6.610138E-8            lpeb = 2.000404E-8
+dvtp0 = 2.36094E-6            dvtp1 = 4.5                   dvt0 = 0.236381
+dvt1 = 0.537442               dvt2 = 5.56679E-2             dvt0w = 0
+dvt1w = 0                     dvt2w = 0                     vfbsdoff = 0.02
//*** mobility related parameter ***
+u0 = 1.54945E-2+du0_n_cap         lu0 = -1.369512E-10+dlu0_n_cap    wu0 = -7.771E-11+dwu0_n_cap
+pu0 = 8.43373E-18+dpu0_n_cap      ua = -2.002662E-9             lua = -1.952729E-18
+wua = 4.873148E-17            pua = 6.698635E-25            ub = 2.386834E-18
+lub = -1.318563E-27           wub = -6.820308E-26           pub = -8.036008E-34
+uc = 2.056029E-10             luc = -6.933158E-18           wuc = -2.04384E-17
+puc = 9.339827E-25            ud = 0                        vsat = 1.464295E5+dvsat_n_cap
+lvsat = -5.407079E-4          wvsat = -4.165475E-3          pvsat = 2.415975E-10
+a0 = 1E-3                     ags = 5.439739                lags = 2.573695E-8
+wags = 7.090303E-8            pags = -7.61817E-15           b0 = 0
+b1 = 0                        keta = -0.09481               lketa = 3.624356E-9
+wketa = 1.039147E-8           pketa = -4.204252E-16         a1 = 0
+a2 = 1                        rdsw = 100.002354             prwb = 0
+prwg = 0                      wr = 1
//*** subthreshold related parameter ***
+voff = -0.156762              lvoff = -1.675187E-10         wvoff = -2.622126E-10
+pvoff = 9.33344E-18           voffl = -3.595178E-9          minv = -0.15
+nfactor = 0.232622            lnfactor = 1.398271E-7        wnfactor = 2.203608E-10
+pnfactor = 1.32476E-16        eta0 = 9.63491E-4             etab = 0.142293
+letab = -6.623709E-9          wetab = -1.324742E-8          petab = 7.683503E-16
+dsub = 0.422235               cit = 7.212E-4                cdsc = 0
+cdscb = 0                     cdscd = 0
//*** output resistance related parameter ***
+pclm = 1.441266               pdiblc1 = -5.427875E-3        lpdiblc1 = 3.148168E-10
+wpdiblc1 = 6.296336E-10       ppdiblc1 = -3.651875E-17      pdiblc2 = 0
+pdiblcb = 1                   drout = 0.67198               ldrout = -6.494845E-9
+wdrout = -1.298969E-8         pdrout = 7.53402E-16          pscbe1 = 1E9
+pscbe2 = 1E-20                pvag = 1.2                    delta = 7.595625E-3
+fprout = 300                  pdits = 0                     pditsl = 0
+pditsd = 0                    alpha0 = 2E-10                alpha1 = 0.01
+beta0 = 6.4                   agidl = 2.1505E-7             bgidl = 2.1392E9
+cgidl = 0.22                  egidl = 0.29734
//*** gate dielectric tunneling current ***
+aigbacc = 0.02                bigbacc = 2.47E-3             cigbacc = 0.3325
+nigbacc = 10                  aigbinv = 0.0158              bigbinv = 4.893E-3
+cigbinv = 6.1E-3              eigbinv = 1.1                 nigbinv = 10
+aigc = 0.0112                 bigc = 1.392E-3               cigc = 6.22E-4
+aigsd = 0.0106                bigsd = 1.235E-3              cigsd = 0.07
+dlcig = 2.48E-9               nigc = 3.07                   poxedge = 1
+pigcd = 2.591                 ntox = 1                      toxref = 3E-9
//*** capacitance parameter ***
+xpart = 1                     cgso = 5.53E-11+dcgso_n_cap       cgdo = 5.53E-11+dcgdo_n_cap
+cgbo = 0                      ckappas = 0.6                 ckappad = 0.6
+cf = 8.13E-11                 clc = 1.04E-7                 cle = 0.6
+dlc = 0                 dwc = 0                       noff = 2.96
+voffcv = -0.12                acde = 1                      moin = 5.67
+cgsl = 1.71E-11+dcgsl_n_cap       cgdl = 1.71E-11+dcgdl_n_cap
//*** souce/drain junction diode model parameter **
+ijthsrev = 0.01               ijthsfwd = 0.01               xjbvs = 1
+bvs = 10                      jss = 2.1E-7                  jsws = 3.4E-13
+jswgs = 1.2E-12               cjs = 8.61E-4+dcj_n_cap           mjs = 0.264
+mjsws = 0.011                 cjsws = 4.87E-11+dcjsw_n_cap      cjswgs = 2.56E-10+dcjswg_n_cap
+mjswgs = 0.511                pbs = 0.511                   pbsws = 0.786
+pbswgs = 0.464
//** rf model related parameter ***
+xrcrg1 = 12                   xrcrg2 = 1                    rbpb = 50
+rbpd = 50                     rbps = 50                     rbdb = 50
+rbsb = 50                     gbmin = 1E-12
//*** stress effect related parameter ***
+saref = 6.1E-7                sbref = 6.1E-7                wlod = 1.37E-7
+ku0 = -3.471E-8               kvsat = 0.342                 kvth0 = 2.461E-9
+tku0 = 0.097                  llodku0 = 1                   wlodku0 = 1
+llodvth = 1                   wlodvth = 1                   lku0 = 1.23E-8
+wku0 = 9.96E-8                pku0 = 4.6E-14                lkvth0 = -2.421E-11
+wkvth0 = 0                    pkvth0 = 0                    stk2 = 3.87E-10
+lodk2 = 0.5                   steta0 = 0                    lodeta0 = 1
//*** temperature coefficient ***
+tnom = 25                     ute = -1                      kt1 = -0.18098
+kt1l = 0                      kt2 = -0.036                  ua1 = 1.04E-9
+ub1 = -4.64E-19               uc1 = 8.71E-11                at = 1.4E5
+prt = 0                       njs = 1                       njd = 1
+xtis = 3                      xtid = 3                      tpb = 1.1E-3
+tpbsw = 1.9E-3                tpbswg = 1E-3                 tcj = 6.52E-4
+tcjsw = 3.57E-4               tcjswg = 1.5E-3               tvoff = 2.2428E-3
+tvfbsdoff = 0.022
//*** well proximity effect model parameters ***
+web = -210                    wec = -3.51E3                 kvth0we = 3.270022E-3
+k2we = 1.50195E-3             ku0we = -3.001501E-3          scref = 1E-6
31:type=n  minr=1e-60
//*** flag parameter ***
+version = 4.3                 binunit = 2                   mobmod = 0
+capmod = 2                    rdsmod = 0                    igcmod = 1
+igbmod = 1                    rbodymod = 0                  trnqsmod = 0
+acnqsmod = 0                  fnoimod = 1                   tnoimod = 0
+diomod = 1                    tempmod = 0                   permod = 1
+rgatemod = 0                  wpemod = 1
//*** geometry range parameter ***
+lmin = 1E-5                   lmax = 9E-4                   wmin = 1.2E-7
+wmax = 3E-7
//*** process parameter ***
+epsrox = 3.9                  toxe = tox_n_cap                  toxm = tox_n_cap
+dtox = 3.15E-10               xj = 8.1E-8                   ndep = 1E17
+ngate = 1.6E20                nsd = 1E20                    rsh = 17.5
+rshg = 15.5
//*** dw and dl parameter ***
+wint = 2E-9                   wl = 0                        wln = 1
+ww = 0                        wwn = 1                       wwl = 0
+lint = 1E-9                   ll = 0                        lln = 1
+lw = 0                        lwn = 1                       lwl = 0
+lwc = 0                       lwlc = 0                      wwc = 0
+wwlc = 0                      dwg = 0                       dwb = 0
+xl = 0.0+dxl_n_cap                xw = 0.0+dxw_n_cap
//*** flicker noise model parameter ***
+noia = 2.6E42                 noib = 1.61E21                noic = 3E8
+em = 1E6                      ef = 0.94                     lintnoi = -5E-9
//***layout-dependent parasitics model parameter ***
+dmcg = 4E-8                   dmci = 4E-8                   dmdg = 0
+dmcgt = 0                     dwj = 0                       xgw = 0
+xgl = 0                       ngcon = 1
//*** vth related  parameter ***
+vth0 = ( 0.34925+dvth0_n_cap) + 2.38E-4 lvth0 = 0.0+dlvth0_n_cap          wvth0 = 0.0+dwvth0_n_cap
+pvth0 = 0.0+dpvth0_n_cap          phin = 0                      k1 = 0.30264
+k2 = -1.18737E-2              wk2 = 4.141496E-10            k3 = -7.284535
+k3b = 2.454986                w0 = 8.190018E-8              lpe0 = 6.610138E-8
+lpeb = 2.000404E-8            dvtp0 = 2.36094E-6            dvtp1 = 4.5
+dvt0 = 0.236381               dvt1 = 0.537442               dvt2 = 5.56679E-2
+dvt0w = 0                     dvt1w = 0                     dvt2w = 0
+vfbsdoff = 0.02
//*** mobility related parameter ***
+u0 = ( 0.0152801+du0_n_cap) -3.474505E-4 lu0 = ( -2.636545E-10+dlu0_n_cap) + 2.636545E-10
+wu0 = ( -3.215249E-10+dwu0_n_cap) + 3.215249E-10
+pu0 = ( 7.659855E-16+dpu0_n_cap) -7.659855E-16
+ua = -1.939731E-9             wua = 6.507675E-18            ub = 2.266748E-18
+wub = 6.713238E-27            uc = 6.616797E-11             ud = 0
+vsat = 137107.0+dvsat_n_cap       a0 = 1.66468                  wa0 = 1.752059E-8
+ags = 1.099043                b0 = 0                        b1 = 0
+keta = -6.17037E-2            a1 = 0                        a2 = 1
+rdsw = 100.002354             prwb = 0                      prwg = 0
+wr = 1
//*** subthreshold related parameter ***
+voff = -0.153794              wvoff = 1.251846E-10          voffl = -3.595178E-9
+minv = -0.15                  nfactor = 1.066371            wnfactor = 5.818118E-9
+eta0 = 2.963491E-3            etab = -1.59363E-2            dsub = 0.422235
+cit = 7.212E-4                cdsc = 0                      cdscb = 0
+cdscd = 0
//*** output resistance related parameter ***
+pclm = 1.441266               pdiblc1 = 4.53031E-4          pdiblc2 = 8.542346E-3
+pdiblcb = 1                   drout = 0.56                  pscbe1 = 1E9
+pscbe2 = 1E-20                pvag = 1.2                    delta = 7.595625E-3
+fprout = 300                  pdits = 0                     pditsl = 0
+pditsd = 0                    lc = 0                        alpha0 = 2E-10
+alpha1 = 0.01                 beta0 = 6.4                   agidl = 2.1505E-7
+bgidl = 2.1392E9              cgidl = 0.22                  egidl = 0.29734
//*** gate dielectric tunneling current ***
+aigbacc = 0.02                bigbacc = 2.47E-3             cigbacc = 0.3325
+nigbacc = 10                  aigbinv = 0.0158              bigbinv = 4.893E-3
+cigbinv = 6.1E-3              eigbinv = 1.1                 nigbinv = 10
+aigc = 0.0112                 bigc = 1.392E-3               cigc = 6.22E-4
+aigsd = 0.0106                bigsd = 1.235E-3              cigsd = 0.07
+dlcig = 2.48E-9               nigc = 3.07                   poxedge = 1
+pigcd = 2.591                 ntox = 1                      toxref = 3E-9
//*** capacitance parameter ***
+xpart = 1                     cgso = 5.53E-11+dcgso_n_cap       cgdo = 5.53E-11+dcgdo_n_cap
+cgbo = 0                      ckappas = 0.6                 ckappad = 0.6
+cf = 8.13E-11                 clc = 1.04E-7                 cle = 0.6
+dlc = 0                 dwc = 0                       noff = 2.96
+voffcv = -0.12                acde = 1                      moin = 5.67
+cgsl = 1.71E-11+dcgsl_n_cap       cgdl = 1.71E-11+dcgdl_n_cap
//*** souce/drain junction diode model parameter **
+ijthsrev = 0.01               ijthsfwd = 0.01               xjbvs = 1
+bvs = 10                      jss = 2.1E-7                  jsws = 3.4E-13
+jswgs = 1.2E-12               cjs = 8.61E-4+dcj_n_cap           mjs = 0.264
+mjsws = 0.011                 cjsws = 4.87E-11+dcjsw_n_cap      cjswgs = 2.56E-10+dcjswg_n_cap
+mjswgs = 0.511                pbs = 0.511                   pbsws = 0.786
+pbswgs = 0.464
//** rf model related parameter ***
+xrcrg1 = 12                   xrcrg2 = 1                    rbpb = 50
+rbpd = 50                     rbps = 50                     rbdb = 50
+rbsb = 50                     gbmin = 1E-12
//*** stress effect related parameter ***
+saref = 6.1E-7                sbref = 6.1E-7                wlod = 1.37E-7
+ku0 = -3.471E-8               kvsat = 0.342                 kvth0 = 2.461E-9
+tku0 = 0.097                  llodku0 = 1                   wlodku0 = 1
+llodvth = 1                   wlodvth = 1                   lku0 = 1.23E-8
+wku0 = 9.96E-8                pku0 = 4.6E-14                lkvth0 = -2.421E-11
+wkvth0 = 0                    pkvth0 = 0                    stk2 = 3.87E-10
+lodk2 = 0.5                   steta0 = 0                    lodeta0 = 1
//*** temperature coefficient ***
+tnom = 25                     ute = -1                      kt1 = -0.18098
+kt1l = 0                      kt2 = -0.036                  ua1 = 1.04E-9
+ub1 = -4.64E-19               uc1 = 8.71E-11                at = 1.4E5
+prt = 0                       njs = 1                       njd = 1
+xtis = 3                      xtid = 3                      tpb = 1.1E-3
+tpbsw = 1.9E-3                tpbswg = 1E-3                 tcj = 6.52E-4
+tcjsw = 3.57E-4               tcjswg = 1.5E-3               tvoff = 2.2428E-3
+tvfbsdoff = 0.022
//*** well proximity effect model parameters ***
+web = -210                    wec = -3.51E3                 kvth0we = 3.270022E-3
+k2we = 1.50195E-3             ku0we = -3.001501E-3          scref = 1E-6
32:type=n  minr=1e-60
//*** flag parameter ***
+version = 4.3                 binunit = 2                   mobmod = 0
+capmod = 2                    rdsmod = 0                    igcmod = 1
+igbmod = 1                    rbodymod = 0                  trnqsmod = 0
+acnqsmod = 0                  fnoimod = 1                   tnoimod = 0
+diomod = 1                    tempmod = 0                   permod = 1
+rgatemod = 0                  wpemod = 1
//*** geometry range parameter ***
+lmin = 1E-5                   lmax = 9E-4                   wmin = 3E-7
+wmax = 5E-7
//*** process parameter ***
+epsrox = 3.9                  toxe = tox_n_cap                  toxm = tox_n_cap
+dtox = 3.15E-10               xj = 8.1E-8                   ndep = 1E17
+ngate = 1.6E20                nsd = 1E20                    rsh = 17.5
+rshg = 15.5
//*** dw and dl parameter ***
+wint = 2E-9                   wl = 0                        wln = 1
+ww = 0                        wwn = 1                       wwl = 0
+lint = 1E-9                   ll = 0                        lln = 1
+lw = 0                        lwn = 1                       lwl = 0
+lwc = 0                       lwlc = 0                      wwc = 0
+wwlc = 0                      dwg = 0                       dwb = 0
+xl = 0.0+dxl_n_cap                xw = 0.0+dxw_n_cap
//*** flicker noise model parameter ***
+noia = 2.6E42                 noib = 1.61E21                noic = 3E8
+em = 1E6                      ef = 0.94                     lintnoi = -5E-9
//***layout-dependent parasitics model parameter ***
+dmcg = 4E-8                   dmci = 4E-8                   dmdg = 0
+dmcgt = 0                     dwj = 0                       xgw = 0
+xgl = 0                       ngcon = 1
//*** vth related  parameter ***
+vth0 = 0.34925+dvth0_n_cap        lvth0 = 0.0+dlvth0_n_cap          wvth0 = 0.0+dwvth0_n_cap
+pvth0 = 0.0+dpvth0_n_cap          phin = 0                      k1 = 0.30264
+k2 = -1.04745E-2              k3 = -7.284535                k3b = 2.454986
+w0 = 8.190018E-8              lpe0 = 6.610138E-8            lpeb = 2.000404E-8
+dvtp0 = 2.36094E-6            dvtp1 = 4.5                   dvt0 = 0.236381
+dvt1 = 0.537442               dvt2 = 5.56679E-2             dvt0w = 0
+dvt1w = 0                     dvt2w = 0                     vfbsdoff = 0.02
//*** mobility related parameter ***
+u0 = ( 0.0152801+du0_n_cap) -1.404581E-4 lu0 = ( -2.636545E-10+dlu0_n_cap) + 2.636545E-10
+wu0 = ( -3.215249E-10+dwu0_n_cap) + 2.587867E-10
+pu0 = ( 7.659855E-16+dpu0_n_cap) -7.659855E-16
+ua = -1.917745E-9             ub = 2.264923E-18             wub = 7.253527E-27
+uc = 6.616797E-11             ud = 0                        vsat = 137107.0+dvsat_n_cap
+a0 = 1.723871                 ags = 1.222241                wags = -3.646642E-8
+b0 = 0                        b1 = 0                        keta = -6.17037E-2
+a1 = 0                        a2 = 1                        rdsw = 100.002354
+prwb = 0                      prwg = 0                      wr = 1
//*** subthreshold related parameter ***
+voff = -0.154301              wvoff = 2.752798E-10          voffl = -3.595178E-9
+minv = -0.15                  nfactor = 1.086027            eta0 = 2.963491E-3
+etab = -1.59363E-2            dsub = 0.422235               cit = 7.212E-4
+cdsc = 0                      cdscb = 0                     cdscd = 0
//*** output resistance related parameter ***
+pclm = 1.441266               pdiblc1 = 4.53031E-4          pdiblc2 = 8.542346E-3
+pdiblcb = 1                   drout = 0.56                  pscbe1 = 1E9
+pscbe2 = 1E-20                pvag = 1.2                    delta = 7.595625E-3
+fprout = 300                  pdits = 0                     pditsl = 0
+pditsd = 0                    lc = 0                        alpha0 = 2E-10
+alpha1 = 0.01                 beta0 = 6.4                   agidl = 2.1505E-7
+bgidl = 2.1392E9              cgidl = 0.22                  egidl = 0.29734
//*** gate dielectric tunneling current ***
+aigbacc = 0.02                bigbacc = 2.47E-3             cigbacc = 0.3325
+nigbacc = 10                  aigbinv = 0.0158              bigbinv = 4.893E-3
+cigbinv = 6.1E-3              eigbinv = 1.1                 nigbinv = 10
+aigc = 0.0112                 bigc = 1.392E-3               cigc = 6.22E-4
+aigsd = 0.0106                bigsd = 1.235E-3              cigsd = 0.07
+dlcig = 2.48E-9               nigc = 3.07                   poxedge = 1
+pigcd = 2.591                 ntox = 1                      toxref = 3E-9
//*** capacitance parameter ***
+xpart = 1                     cgso = 5.53E-11+dcgso_n_cap       cgdo = 5.53E-11+dcgdo_n_cap
+cgbo = 0                      ckappas = 0.6                 ckappad = 0.6
+cf = 8.13E-11                 clc = 1.04E-7                 cle = 0.6
+dlc = 0                 dwc = 0                       noff = 2.96
+voffcv = -0.12                acde = 1                      moin = 5.67
+cgsl = 1.71E-11+dcgsl_n_cap       cgdl = 1.71E-11+dcgdl_n_cap
//*** souce/drain junction diode model parameter **
+ijthsrev = 0.01               ijthsfwd = 0.01               xjbvs = 1
+bvs = 10                      jss = 2.1E-7                  jsws = 3.4E-13
+jswgs = 1.2E-12               cjs = 8.61E-4+dcj_n_cap           mjs = 0.264
+mjsws = 0.011                 cjsws = 4.87E-11+dcjsw_n_cap      cjswgs = 2.56E-10+dcjswg_n_cap
+mjswgs = 0.511                pbs = 0.511                   pbsws = 0.786
+pbswgs = 0.464
//** rf model related parameter ***
+xrcrg1 = 12                   xrcrg2 = 1                    rbpb = 50
+rbpd = 50                     rbps = 50                     rbdb = 50
+rbsb = 50                     gbmin = 1E-12
//*** stress effect related parameter ***
+saref = 6.1E-7                sbref = 6.1E-7                wlod = 1.37E-7
+ku0 = -3.471E-8               kvsat = 0.342                 kvth0 = 2.461E-9
+tku0 = 0.097                  llodku0 = 1                   wlodku0 = 1
+llodvth = 1                   wlodvth = 1                   lku0 = 1.23E-8
+wku0 = 9.96E-8                pku0 = 4.6E-14                lkvth0 = -2.421E-11
+wkvth0 = 0                    pkvth0 = 0                    stk2 = 3.87E-10
+lodk2 = 0.5                   steta0 = 0                    lodeta0 = 1
//*** temperature coefficient ***
+tnom = 25                     ute = -1                      kt1 = -0.18098
+kt1l = 0                      kt2 = -0.036                  ua1 = 1.04E-9
+ub1 = -4.64E-19               uc1 = 8.71E-11                at = 1.4E5
+prt = 0                       njs = 1                       njd = 1
+xtis = 3                      xtid = 3                      tpb = 1.1E-3
+tpbsw = 1.9E-3                tpbswg = 1E-3                 tcj = 6.52E-4
+tcjsw = 3.57E-4               tcjswg = 1.5E-3               tvoff = 2.2428E-3
+tvfbsdoff = 0.022
//*** well proximity effect model parameters ***
+web = -210                    wec = -3.51E3                 kvth0we = 3.270022E-3
+k2we = 1.50195E-3             ku0we = -3.001501E-3          scref = 1E-6
33:type=n  minr=1e-60
//*** flag parameter ***
+version = 4.3                 binunit = 2                   mobmod = 0
+capmod = 2                    rdsmod = 0                    igcmod = 1
+igbmod = 1                    rbodymod = 0                  trnqsmod = 0
+acnqsmod = 0                  fnoimod = 1                   tnoimod = 0
+diomod = 1                    tempmod = 0                   permod = 1
+rgatemod = 0                  wpemod = 1
//*** geometry range parameter ***
+lmin = 1E-5                   lmax = 9E-4                   wmin = 5E-7
+wmax = 1E-6
//*** process parameter ***
+epsrox = 3.9                  toxe = tox_n_cap                  toxm = tox_n_cap
+dtox = 3.15E-10               xj = 8.1E-8                   ndep = 1E17
+ngate = 1.6E20                nsd = 1E20                    rsh = 17.5
+rshg = 15.5
//*** dw and dl parameter ***
+wint = 2E-9                   wl = 0                        wln = 1
+ww = 0                        wwn = 1                       wwl = 0
+lint = 1E-9                   ll = 0                        lln = 1
+lw = 0                        lwn = 1                       lwl = 0
+lwc = 0                       lwlc = 0                      wwc = 0
+wwlc = 0                      dwg = 0                       dwb = 0
+xl = 0.0+dxl_n_cap                xw = 0.0+dxw_n_cap
//*** flicker noise model parameter ***
+noia = 2.6E42                 noib = 1.61E21                noic = 3E8
+em = 1E6                      ef = 0.94                     lintnoi = -5E-9
//***layout-dependent parasitics model parameter ***
+dmcg = 4E-8                   dmci = 4E-8                   dmdg = 0
+dmcgt = 0                     dwj = 0                       xgw = 0
+xgl = 0                       ngcon = 1
//*** vth related  parameter ***
+vth0 = 0.34925+dvth0_n_cap        lvth0 = 0.0+dlvth0_n_cap          wvth0 = 0.0+dwvth0_n_cap
+pvth0 = 0.0+dpvth0_n_cap          phin = 0                      k1 = 0.30264
+k2 = -1.37822E-2              wk2 = 1.640643E-9             k3 = -7.284535
+k3b = 2.454986                w0 = 8.190018E-8              lpe0 = 6.610138E-8
+lpeb = 2.000404E-8            dvtp0 = 2.36094E-6            dvtp1 = 4.5
+dvt0 = 0.236381               dvt1 = 0.537442               dvt2 = 5.56679E-2
+dvt0w = 0                     dvt1w = 0                     dvt2w = 0
+vfbsdoff = 0.02
//*** mobility related parameter ***
+u0 = ( 0.0152801+du0_n_cap) -1.991459E-4 lu0 = ( -2.636545E-10+dlu0_n_cap) + 2.636545E-10
+wu0 = ( -3.215249E-10+dwu0_n_cap) + 2.878959E-10
+pu0 = ( 7.659855E-16+dpu0_n_cap) -7.659855E-16
+ua = -1.911079E-9             wua = -3.305986E-18           ub = 2.23383E-18
+wub = 2.26752E-26             uc = 6.616797E-11             ud = 0
+vsat = 137107.0+dvsat_n_cap       a0 = 1.723871                 ags = 1.14872
+b0 = 0                        b1 = 0                        keta = -6.17037E-2
+a1 = 0                        a2 = 1                        rdsw = 100.002354
+prwb = 0                      prwg = 0                      wr = 1
//*** subthreshold related parameter ***
+voff = -0.153746              voffl = -3.595178E-9          minv = -0.15
+nfactor = 1.086027            eta0 = 2.963491E-3            etab = -1.59363E-2
+dsub = 0.422235               cit = 7.212E-4                cdsc = 0
+cdscb = 0                     cdscd = 0
//*** output resistance related parameter ***
+pclm = 1.441266               pdiblc1 = 4.53031E-4          pdiblc2 = 8.542346E-3
+pdiblcb = 1                   drout = 0.56                  pscbe1 = 1E9
+pscbe2 = 1E-20                pvag = 1.2                    delta = 7.595625E-3
+fprout = 300                  pdits = 0                     pditsl = 0
+pditsd = 0                    lc = 0                        alpha0 = 2E-10
+alpha1 = 0.01                 beta0 = 6.4                   agidl = 2.1505E-7
+bgidl = 2.1392E9              cgidl = 0.22                  egidl = 0.29734
//*** gate dielectric tunneling current ***
+aigbacc = 0.02                bigbacc = 2.47E-3             cigbacc = 0.3325
+nigbacc = 10                  aigbinv = 0.0158              bigbinv = 4.893E-3
+cigbinv = 6.1E-3              eigbinv = 1.1                 nigbinv = 10
+aigc = 0.0112                 bigc = 1.392E-3               cigc = 6.22E-4
+aigsd = 0.0106                bigsd = 1.235E-3              cigsd = 0.07
+dlcig = 2.48E-9               nigc = 3.07                   poxedge = 1
+pigcd = 2.591                 ntox = 1                      toxref = 3E-9
//*** capacitance parameter ***
+xpart = 1                     cgso = 5.53E-11+dcgso_n_cap       cgdo = 5.53E-11+dcgdo_n_cap
+cgbo = 0                      ckappas = 0.6                 ckappad = 0.6
+cf = 8.13E-11                 clc = 1.04E-7                 cle = 0.6
+dlc = 0                 dwc = 0                       noff = 2.96
+voffcv = -0.12                acde = 1                      moin = 5.67
+cgsl = 1.71E-11+dcgsl_n_cap       cgdl = 1.71E-11+dcgdl_n_cap
//*** souce/drain junction diode model parameter **
+ijthsrev = 0.01               ijthsfwd = 0.01               xjbvs = 1
+bvs = 10                      jss = 2.1E-7                  jsws = 3.4E-13
+jswgs = 1.2E-12               cjs = 8.61E-4+dcj_n_cap           mjs = 0.264
+mjsws = 0.011                 cjsws = 4.87E-11+dcjsw_n_cap      cjswgs = 2.56E-10+dcjswg_n_cap
+mjswgs = 0.511                pbs = 0.511                   pbsws = 0.786
+pbswgs = 0.464
//** rf model related parameter ***
+xrcrg1 = 12                   xrcrg2 = 1                    rbpb = 50
+rbpd = 50                     rbps = 50                     rbdb = 50
+rbsb = 50                     gbmin = 1E-12
//*** stress effect related parameter ***
+saref = 6.1E-7                sbref = 6.1E-7                wlod = 1.37E-7
+ku0 = -3.471E-8               kvsat = 0.342                 kvth0 = 2.461E-9
+tku0 = 0.097                  llodku0 = 1                   wlodku0 = 1
+llodvth = 1                   wlodvth = 1                   lku0 = 1.23E-8
+wku0 = 9.96E-8                pku0 = 4.6E-14                lkvth0 = -2.421E-11
+wkvth0 = 0                    pkvth0 = 0                    stk2 = 3.87E-10
+lodk2 = 0.5                   steta0 = 0                    lodeta0 = 1
//*** temperature coefficient ***
+tnom = 25                     ute = -1                      kt1 = -0.18098
+kt1l = 0                      kt2 = -0.036                  ua1 = 1.04E-9
+ub1 = -4.64E-19               uc1 = 8.71E-11                at = 1.4E5
+prt = 0                       njs = 1                       njd = 1
+xtis = 3                      xtid = 3                      tpb = 1.1E-3
+tpbsw = 1.9E-3                tpbswg = 1E-3                 tcj = 6.52E-4
+tcjsw = 3.57E-4               tcjswg = 1.5E-3               tvoff = 2.2428E-3
+tvfbsdoff = 0.022
//*** well proximity effect model parameters ***
+web = -210                    wec = -3.51E3                 kvth0we = 3.270022E-3
+k2we = 1.50195E-3             ku0we = -3.001501E-3          scref = 1E-6
34:type=n  minr=1e-60
//*** flag parameter ***
+version = 4.3                 binunit = 2                   mobmod = 0
+capmod = 2                    rdsmod = 0                    igcmod = 1
+igbmod = 1                    rbodymod = 0                  trnqsmod = 0
+acnqsmod = 0                  fnoimod = 1                   tnoimod = 0
+diomod = 1                    tempmod = 0                   permod = 1
+rgatemod = 0                  wpemod = 1
//*** geometry range parameter ***
+lmin = 1E-5                   lmax = 9E-4                   wmin = 1E-6
+wmax = 2E-6
//*** process parameter ***
+epsrox = 3.9                  toxe = tox_n_cap                  toxm = tox_n_cap
+dtox = 3.15E-10               xj = 8.1E-8                   ndep = 1E17
+ngate = 1.6E20                nsd = 1E20                    rsh = 17.5
+rshg = 15.5
//*** dw and dl parameter ***
+wint = 2E-9                   wl = 0                        wln = 1
+ww = 0                        wwn = 1                       wwl = 0
+lint = 1E-9                   ll = 0                        lln = 1
+lw = 0                        lwn = 1                       lwl = 0
+lwc = 0                       lwlc = 0                      wwc = 0
+wwlc = 0                      dwg = 0                       dwb = 0
+xl = 0.0+dxl_n_cap                xw = 0.0+dxw_n_cap
//*** flicker noise model parameter ***
+noia = 2.6E42                 noib = 1.61E21                noic = 3E8
+em = 1E6                      ef = 0.94                     lintnoi = -5E-9
//***layout-dependent parasitics model parameter ***
+dmcg = 4E-8                   dmci = 4E-8                   dmdg = 0
+dmcgt = 0                     dwj = 0                       xgw = 0
+xgl = 0                       ngcon = 1
//*** vth related  parameter ***
+vth0 = 0.34925+dvth0_n_cap        lvth0 = 0.0+dlvth0_n_cap          wvth0 = 0.0+dwvth0_n_cap
+pvth0 = 0.0+dpvth0_n_cap          phin = 0                      k1 = 0.30264
+k2 = -0.012135                k3 = -7.284535                k3b = 2.454986
+w0 = 8.190018E-8              lpe0 = 6.610138E-8            lpeb = 2.000404E-8
+dvtp0 = 2.36094E-6            dvtp1 = 4.5                   dvt0 = 0.236381
+dvt1 = 0.537442               dvt2 = 5.56679E-2             dvt0w = 0
+dvt1w = 0                     dvt2w = 0                     vfbsdoff = 0.02
//*** mobility related parameter ***
+u0 = ( 0.0152801+du0_n_cap) -6.556865E-5 lu0 = ( -2.636545E-10+dlu0_n_cap) + 2.636545E-10
+wu0 = ( -3.215249E-10+dwu0_n_cap) + 1.548529E-10
+pu0 = ( 7.659855E-16+dpu0_n_cap) -7.659855E-16
+ua = -1.914399E-9             ub = 2.256597E-18             uc = 6.616797E-11
+ud = 0                        vsat = 137107.0+dvsat_n_cap       a0 = 1.723871
+ags = 1.14872                 b0 = 0                        b1 = 0
+keta = -6.17037E-2            a1 = 0                        a2 = 1
+rdsw = 100.002354             prwb = 0                      prwg = 0
+wr = 1
//*** subthreshold related parameter ***
+voff = -0.153746              voffl = -3.595178E-9          minv = -0.15
+nfactor = 1.086027            eta0 = 2.963491E-3            etab = -1.59363E-2
+dsub = 0.422235               cit = 7.212E-4                cdsc = 0
+cdscb = 0                     cdscd = 0
//*** output resistance related parameter ***
+pclm = 1.441266               pdiblc1 = 4.53031E-4          pdiblc2 = 8.542346E-3
+pdiblcb = 1                   drout = 0.56                  pscbe1 = 1E9
+pscbe2 = 1E-20                pvag = 1.2                    delta = 7.595625E-3
+fprout = 300                  pdits = 0                     pditsl = 0
+pditsd = 0                    lc = 0                        alpha0 = 2E-10
+alpha1 = 0.01                 beta0 = 6.4                   agidl = 2.1505E-7
+bgidl = 2.1392E9              cgidl = 0.22                  egidl = 0.29734
//*** gate dielectric tunneling current ***
+aigbacc = 0.02                bigbacc = 2.47E-3             cigbacc = 0.3325
+nigbacc = 10                  aigbinv = 0.0158              bigbinv = 4.893E-3
+cigbinv = 6.1E-3              eigbinv = 1.1                 nigbinv = 10
+aigc = 0.0112                 bigc = 1.392E-3               cigc = 6.22E-4
+aigsd = 0.0106                bigsd = 1.235E-3              cigsd = 0.07
+dlcig = 2.48E-9               nigc = 3.07                   poxedge = 1
+pigcd = 2.591                 ntox = 1                      toxref = 3E-9
//*** capacitance parameter ***
+xpart = 1                     cgso = 5.53E-11+dcgso_n_cap       cgdo = 5.53E-11+dcgdo_n_cap
+cgbo = 0                      ckappas = 0.6                 ckappad = 0.6
+cf = 8.13E-11                 clc = 1.04E-7                 cle = 0.6
+dlc = 0                 dwc = 0                       noff = 2.96
+voffcv = -0.12                acde = 1                      moin = 5.67
+cgsl = 1.71E-11+dcgsl_n_cap       cgdl = 1.71E-11+dcgdl_n_cap
//*** souce/drain junction diode model parameter **
+ijthsrev = 0.01               ijthsfwd = 0.01               xjbvs = 1
+bvs = 10                      jss = 2.1E-7                  jsws = 3.4E-13
+jswgs = 1.2E-12               cjs = 8.61E-4+dcj_n_cap           mjs = 0.264
+mjsws = 0.011                 cjsws = 4.87E-11+dcjsw_n_cap      cjswgs = 2.56E-10+dcjswg_n_cap
+mjswgs = 0.511                pbs = 0.511                   pbsws = 0.786
+pbswgs = 0.464
//** rf model related parameter ***
+xrcrg1 = 12                   xrcrg2 = 1                    rbpb = 50
+rbpd = 50                     rbps = 50                     rbdb = 50
+rbsb = 50                     gbmin = 1E-12
//*** stress effect related parameter ***
+saref = 6.1E-7                sbref = 6.1E-7                wlod = 1.37E-7
+ku0 = -3.471E-8               kvsat = 0.342                 kvth0 = 2.461E-9
+tku0 = 0.097                  llodku0 = 1                   wlodku0 = 1
+llodvth = 1                   wlodvth = 1                   lku0 = 1.23E-8
+wku0 = 9.96E-8                pku0 = 4.6E-14                lkvth0 = -2.421E-11
+wkvth0 = 0                    pkvth0 = 0                    stk2 = 3.87E-10
+lodk2 = 0.5                   steta0 = 0                    lodeta0 = 1
//*** temperature coefficient ***
+tnom = 25                     ute = -1                      kt1 = -0.18098
+kt1l = 0                      kt2 = -0.036                  ua1 = 1.04E-9
+ub1 = -4.64E-19               uc1 = 8.71E-11                at = 1.4E5
+prt = 0                       njs = 1                       njd = 1
+xtis = 3                      xtid = 3                      tpb = 1.1E-3
+tpbsw = 1.9E-3                tpbswg = 1E-3                 tcj = 6.52E-4
+tcjsw = 3.57E-4               tcjswg = 1.5E-3               tvoff = 2.2428E-3
+tvfbsdoff = 0.022
//*** well proximity effect model parameters ***
+web = -210                    wec = -3.51E3                 kvth0we = 3.270022E-3
+k2we = 1.50195E-3             ku0we = -3.001501E-3          scref = 1E-6
35:type=n  minr=1e-60
//*** flag parameter ***
+version = 4.3                 binunit = 2                   mobmod = 0
+capmod = 2                    rdsmod = 0                    igcmod = 1
+igbmod = 1                    rbodymod = 0                  trnqsmod = 0
+acnqsmod = 0                  fnoimod = 1                   tnoimod = 0
+diomod = 1                    tempmod = 0                   permod = 1
+rgatemod = 0                  wpemod = 1
//*** geometry range parameter ***
+lmin = 1E-5                   lmax = 9E-4                   wmin = 2E-6
+wmax = 1E-5
//*** process parameter ***
+epsrox = 3.9                  toxe = tox_n_cap                  toxm = tox_n_cap
+dtox = 3.15E-10               xj = 8.1E-8                   ndep = 1E17
+ngate = 1.6E20                nsd = 1E20                    rsh = 17.5
+rshg = 15.5
//*** dw and dl parameter ***
+wint = 2E-9                   wl = 0                        wln = 1
+ww = 0                        wwn = 1                       wwl = 0
+lint = 1E-9                   ll = 0                        lln = 1
+lw = 0                        lwn = 1                       lwl = 0
+lwc = 0                       lwlc = 0                      wwc = 0
+wwlc = 0                      dwg = 0                       dwb = 0
+xl = 0.0+dxl_n_cap                xw = 0.0+dxw_n_cap
//*** flicker noise model parameter ***
+noia = 2.6E42                 noib = 1.61E21                noic = 3E8
+em = 1E6                      ef = 0.94                     lintnoi = -5E-9
//***layout-dependent parasitics model parameter ***
+dmcg = 4E-8                   dmci = 4E-8                   dmdg = 0
+dmcgt = 0                     dwj = 0                       xgw = 0
+xgl = 0                       ngcon = 1
//*** vth related  parameter ***
+vth0 = 0.34925+dvth0_n_cap        lvth0 = 0.0+dlvth0_n_cap          wvth0 = 0.0+dwvth0_n_cap
+pvth0 = 0.0+dpvth0_n_cap          phin = 0                      k1 = 0.30264
+k2 = -0.012135                k3 = -7.284535                k3b = 2.454986
+w0 = 8.190018E-8              lpe0 = 6.610138E-8            lpeb = 2.000404E-8
+dvtp0 = 2.36094E-6            dvtp1 = 4.5                   dvt0 = 0.236381
+dvt1 = 0.537442               dvt2 = 5.56679E-2             dvt0w = 0
+dvt1w = 0                     dvt2w = 0                     vfbsdoff = 0.02
//*** mobility related parameter ***
+u0 = ( 0.0152801+du0_n_cap) -2.637072E-5 lu0 = ( -2.636545E-10+dlu0_n_cap) + 2.636545E-10
+wu0 = ( -3.215249E-10+dwu0_n_cap) + 7.661387E-11
+pu0 = ( 7.659855E-16+dpu0_n_cap) -7.659855E-16
+ua = -1.921206E-9             wua = 1.358732E-17            ub = 2.273301E-18
+wub = -3.334231E-26           uc = 7.276119E-11             wuc = -1.316008E-17
+ud = 0                        vsat = 137107.0+dvsat_n_cap       a0 = 1.723871
+ags = 1.14872                 b0 = 0                        b1 = 0
+keta = -6.17037E-2            a1 = 0                        a2 = 1
+rdsw = 100.002354             prwb = 0                      prwg = 0
+wr = 1
//*** subthreshold related parameter ***
+voff = -0.155048              wvoff = 2.598751E-9           voffl = -3.595178E-9
+minv = -0.15                  nfactor = 1.00353             wnfactor = 1.646639E-7
+eta0 = 2.963491E-3            etab = -1.59363E-2            dsub = 0.422235
+cit = 7.212E-4                cdsc = 0                      cdscb = 0
+cdscd = 0
//*** output resistance related parameter ***
+pclm = 1.441266               pdiblc1 = 4.53031E-4          pdiblc2 = 8.542346E-3
+pdiblcb = 1                   drout = 0.56                  pscbe1 = 1E9
+pscbe2 = 1E-20                pvag = 1.2                    delta = 7.595625E-3
+fprout = 300                  pdits = 0                     pditsl = 0
+pditsd = 0                    lc = 0                        alpha0 = 2E-10
+alpha1 = 0.01                 beta0 = 6.4                   agidl = 2.1505E-7
+bgidl = 2.1392E9              cgidl = 0.22                  egidl = 0.29734
//*** gate dielectric tunneling current ***
+aigbacc = 0.02                bigbacc = 2.47E-3             cigbacc = 0.3325
+nigbacc = 10                  aigbinv = 0.0158              bigbinv = 4.893E-3
+cigbinv = 6.1E-3              eigbinv = 1.1                 nigbinv = 10
+aigc = 0.0112                 bigc = 1.392E-3               cigc = 6.22E-4
+aigsd = 0.0106                bigsd = 1.235E-3              cigsd = 0.07
+dlcig = 2.48E-9               nigc = 3.07                   poxedge = 1
+pigcd = 2.591                 ntox = 1                      toxref = 3E-9
//*** capacitance parameter ***
+xpart = 1                     cgso = 5.53E-11+dcgso_n_cap       cgdo = 5.53E-11+dcgdo_n_cap
+cgbo = 0                      ckappas = 0.6                 ckappad = 0.6
+cf = 8.13E-11                 clc = 1.04E-7                 cle = 0.6
+dlc = 0                 dwc = 0                       noff = 2.96
+voffcv = -0.12                acde = 1                      moin = 5.67
+cgsl = 1.71E-11+dcgsl_n_cap       cgdl = 1.71E-11+dcgdl_n_cap
//*** souce/drain junction diode model parameter **
+ijthsrev = 0.01               ijthsfwd = 0.01               xjbvs = 1
+bvs = 10                      jss = 2.1E-7                  jsws = 3.4E-13
+jswgs = 1.2E-12               cjs = 8.61E-4+dcj_n_cap           mjs = 0.264
+mjsws = 0.011                 cjsws = 4.87E-11+dcjsw_n_cap      cjswgs = 2.56E-10+dcjswg_n_cap
+mjswgs = 0.511                pbs = 0.511                   pbsws = 0.786
+pbswgs = 0.464
//** rf model related parameter ***
+xrcrg1 = 12                   xrcrg2 = 1                    rbpb = 50
+rbpd = 50                     rbps = 50                     rbdb = 50
+rbsb = 50                     gbmin = 1E-12
//*** stress effect related parameter ***
+saref = 6.1E-7                sbref = 6.1E-7                wlod = 1.37E-7
+ku0 = -3.471E-8               kvsat = 0.342                 kvth0 = 2.461E-9
+tku0 = 0.097                  llodku0 = 1                   wlodku0 = 1
+llodvth = 1                   wlodvth = 1                   lku0 = 1.23E-8
+wku0 = 9.96E-8                pku0 = 4.6E-14                lkvth0 = -2.421E-11
+wkvth0 = 0                    pkvth0 = 0                    stk2 = 3.87E-10
+lodk2 = 0.5                   steta0 = 0                    lodeta0 = 1
//*** temperature coefficient ***
+tnom = 25                     ute = -1                      kt1 = -0.18098
+kt1l = 0                      kt2 = -0.036                  ua1 = 1.04E-9
+ub1 = -4.64E-19               uc1 = 8.71E-11                at = 1.4E5
+prt = 0                       njs = 1                       njd = 1
+xtis = 3                      xtid = 3                      tpb = 1.1E-3
+tpbsw = 1.9E-3                tpbswg = 1E-3                 tcj = 6.52E-4
+tcjsw = 3.57E-4               tcjswg = 1.5E-3               tvoff = 2.2428E-3
+tvfbsdoff = 0.022
//*** well proximity effect model parameters ***
+web = -210                    wec = -3.51E3                 kvth0we = 3.270022E-3
+k2we = 1.50195E-3             ku0we = -3.001501E-3          scref = 1E-6
36:type=n  minr=1e-60
//*** flag parameter ***
+version = 4.3                 binunit = 2                   mobmod = 0
+capmod = 2                    rdsmod = 0                    igcmod = 1
+igbmod = 1                    rbodymod = 0                  trnqsmod = 0
+acnqsmod = 0                  fnoimod = 1                   tnoimod = 0
+diomod = 1                    tempmod = 0                   permod = 1
+rgatemod = 0                  wpemod = 1
//*** geometry range parameter ***
+lmin = 4E-8                   lmax = 6E-8                   wmin = 1E-5
+wmax = 9E-4
//*** process parameter ***
+epsrox = 3.9                  toxe = tox_n_cap                  toxm = tox_n_cap
+dtox = 3.15E-10               xj = 8.1E-8                   ndep = 1E17
+ngate = 1.6E20                nsd = 1E20                    rsh = 17.5
+rshg = 15.5
//*** dw and dl parameter ***
+wint = 2E-9                   wl = 0                        wln = 1
+ww = 0                        wwn = 1                       wwl = 0
+lint = 1E-9                   ll = 0                        lln = 1
+lw = 0                        lwn = 1                       lwl = 0
+lwc = 0                       lwlc = 0                      wwc = 0
+wwlc = 0                      dwg = 0                       dwb = 0
+xl = 0.0+dxl_n_cap                xw = 0.0+dxw_n_cap
//*** flicker noise model parameter ***
+noia = 2.6E42                 noib = 1.61E21                noic = 3E8
+em = 1E6                      ef = 0.94                     lintnoi = -5E-9
//***layout-dependent parasitics model parameter ***
+dmcg = 4E-8                   dmci = 4E-8                   dmdg = 0
+dmcgt = 0                     dwj = 0                       xgw = 0
+xgl = 0                       ngcon = 1
//*** vth related  parameter ***
+vth0 = ( 0.34925+dvth0_n_cap) -3.912926E-3 lvth0 = ( 0.0+dlvth0_n_cap) + 4.588226E-10 wvth0 = 0.0+dwvth0_n_cap
+pvth0 = 0.0+dpvth0_n_cap          phin = 0                      k1 = 0.30264
+k2 = -1.77916E-2              k3 = -7.284535                k3b = 2.454986
+w0 = 8.190018E-8              lpe0 = 6.610138E-8            lpeb = 2.000404E-8
+dvtp0 = 2.36094E-6            dvtp1 = 4.5                   dvt0 = 0.236381
+dvt1 = 0.537442               dvt2 = 5.56679E-2             dvt0w = 0
+dvt1w = 0                     dvt2w = 0                     vfbsdoff = 0.02
//*** mobility related parameter ***
+u0 = ( 0.0152801+du0_n_cap) + 3.661851E-4 lu0 = ( -2.636545E-10+dlu0_n_cap) + 1.807405E-10
+wu0 = ( -3.215249E-10+dwu0_n_cap) + 3.215249E-10
+pu0 = ( 7.659855E-16+dpu0_n_cap) -7.659855E-16
+ua = -1.926513E-9             lua = 1.600039E-18            ub = 2.311154E-18
+lub = -7.436391E-28           uc = 8.592292E-11             ud = 0
+vsat = ( 137107.0+dvsat_n_cap)  -2.089968E4 lvsat = 1.212181E-3           a0 = 1E-3
+ags = 5.816217                b0 = 0                        b1 = 0
+keta = -0.043526              a1 = 0                        a2 = 1
+rdsw = 100.002354             prwb = 0                      prwg = 0
+wr = 1
//*** subthreshold related parameter ***
+voff = -0.158309              lvoff = -6.026328E-11         voffl = -3.595178E-9
+minv = -0.15                  nfactor = 0.233923            lnfactor = 1.406088E-7
+eta0 = 9.63491E-4             etab = -8.829097E-3           letab = -4.199717E-10
+dsub = 0.422235               cit = 7.212E-4                cdsc = 0
+cdscb = 0                     cdscd = 0
//*** output resistance related parameter ***
+pclm = 1.441266               pdiblc1 = 2.683385E-3         lpdiblc1 = 4.922847E-11
+pdiblc2 = 6.815989E-3         lpdiblc2 = 1.498116E-10       pdiblcb = 1
+drout = 0.607891              ldrout = -8.924918E-9         pscbe1 = 1E9
+pscbe2 = 1E-20                pvag = 1.2                    delta = 7.595625E-3
+fprout = 300                  pdits = 0                     pditsl = 0
+pditsd = 0                    lc = 0                        alpha0 = 2E-10
+alpha1 = 0.01                 beta0 = 6.4                   agidl = 2.1505E-7
+bgidl = 2.1392E9              cgidl = 0.22                  egidl = 0.29734
//*** gate dielectric tunneling current ***
+aigbacc = 0.02                bigbacc = 2.47E-3             cigbacc = 0.3325
+nigbacc = 10                  aigbinv = 0.0158              bigbinv = 4.893E-3
+cigbinv = 6.1E-3              eigbinv = 1.1                 nigbinv = 10
+aigc = 0.0112                 bigc = 1.392E-3               cigc = 6.22E-4
+aigsd = 0.0106                bigsd = 1.235E-3              cigsd = 0.07
+dlcig = 2.48E-9               nigc = 3.07                   poxedge = 1
+pigcd = 2.591                 ntox = 1                      toxref = 3E-9
//*** capacitance parameter ***
+xpart = 1                     cgso = 5.53E-11+dcgso_n_cap       cgdo = 5.53E-11+dcgdo_n_cap
+cgbo = 0                      ckappas = 0.6                 ckappad = 0.6
+cf = 8.13E-11                 clc = 1.04E-7                 cle = 0.6
+dlc = 0                 dwc = 0                       noff = 2.96
+voffcv = -0.12                acde = 1                      moin = 5.67
+cgsl = 1.71E-11+dcgsl_n_cap       cgdl = 1.71E-11+dcgdl_n_cap
//*** souce/drain junction diode model parameter **
+ijthsrev = 0.01               ijthsfwd = 0.01               xjbvs = 1
+bvs = 10                      jss = 2.1E-7                  jsws = 3.4E-13
+jswgs = 1.2E-12               cjs = 8.61E-4+dcj_n_cap           mjs = 0.264
+mjsws = 0.011                 cjsws = 4.87E-11+dcjsw_n_cap      cjswgs = 2.56E-10+dcjswg_n_cap
+mjswgs = 0.511                pbs = 0.511                   pbsws = 0.786
+pbswgs = 0.464
//** rf model related parameter ***
+xrcrg1 = 12                   xrcrg2 = 1                    rbpb = 50
+rbpd = 50                     rbps = 50                     rbdb = 50
+rbsb = 50                     gbmin = 1E-12
//*** stress effect related parameter ***
+saref = 6.1E-7                sbref = 6.1E-7                wlod = 1.37E-7
+ku0 = -3.471E-8               kvsat = 0.342                 kvth0 = 2.461E-9
+tku0 = 0.097                  llodku0 = 1                   wlodku0 = 1
+llodvth = 1                   wlodvth = 1                   lku0 = 1.23E-8
+wku0 = 9.96E-8                pku0 = 4.6E-14                lkvth0 = -2.421E-11
+wkvth0 = 0                    pkvth0 = 0                    stk2 = 3.87E-10
+lodk2 = 0.5                   steta0 = 0                    lodeta0 = 1
//*** temperature coefficient ***
+tnom = 25                     ute = -1                      kt1 = -0.18098
+kt1l = 0                      kt2 = -0.036                  ua1 = 1.04E-9
+ub1 = -4.64E-19               uc1 = 8.71E-11                at = 1.4E5
+prt = 0                       njs = 1                       njd = 1
+xtis = 3                      xtid = 3                      tpb = 1.1E-3
+tpbsw = 1.9E-3                tpbswg = 1E-3                 tcj = 6.52E-4
+tcjsw = 3.57E-4               tcjswg = 1.5E-3               tvoff = 2.2428E-3
+tvfbsdoff = 0.022
//*** well proximity effect model parameters ***
+web = -210                    wec = -3.51E3                 kvth0we = 3.270022E-3
+k2we = 1.50195E-3             ku0we = -3.001501E-3          scref = 1E-6
37:type=n  minr=1e-60
//*** flag parameter ***
+version = 4.3                 binunit = 2                   mobmod = 0
+capmod = 2                    rdsmod = 0                    igcmod = 1
+igbmod = 1                    rbodymod = 0                  trnqsmod = 0
+acnqsmod = 0                  fnoimod = 1                   tnoimod = 0
+diomod = 1                    tempmod = 0                   permod = 1
+rgatemod = 0                  wpemod = 1
//*** geometry range parameter ***
+lmin = 6E-8                   lmax = 1E-7                   wmin = 1E-5
+wmax = 9E-4
//*** process parameter ***
+epsrox = 3.9                  toxe = tox_n_cap                  toxm = tox_n_cap
+dtox = 3.15E-10               xj = 8.1E-8                   ndep = 1E17
+ngate = 1.6E20                nsd = 1E20                    rsh = 17.5
+rshg = 15.5
//*** dw and dl parameter ***
+wint = 2E-9                   wl = 0                        wln = 1
+ww = 0                        wwn = 1                       wwl = 0
+lint = 1E-9                   ll = 0                        lln = 1
+lw = 0                        lwn = 1                       lwl = 0
+lwc = 0                       lwlc = 0                      wwc = 0
+wwlc = 0                      dwg = 0                       dwb = 0
+xl = 0.0+dxl_n_cap                xw = 0.0+dxw_n_cap
//*** flicker noise model parameter ***
+noia = 2.6E42                 noib = 1.61E21                noic = 3E8
+em = 1E6                      ef = 0.94                     lintnoi = -5E-9
//***layout-dependent parasitics model parameter ***
+dmcg = 4E-8                   dmci = 4E-8                   dmdg = 0
+dmcgt = 0                     dwj = 0                       xgw = 0
+xgl = 0                       ngcon = 1
//*** vth related  parameter ***
+vth0 = ( 0.34925+dvth0_n_cap) -9.496516E-3 lvth0 = ( 0.0+dlvth0_n_cap) + 7.826708E-10 wvth0 = 0.0+dwvth0_n_cap
+pvth0 = 0.0+dpvth0_n_cap          phin = 0                      k1 = 0.30264
+k2 = -3.932931E-3             lk2 = -8.038028E-10           k3 = -7.284535
+k3b = 2.454986                w0 = 8.190018E-8              lpe0 = 6.610138E-8
+lpeb = 2.000404E-8            dvtp0 = 2.36094E-6            dvtp1 = 4.5
+dvt0 = 0.236381               dvt1 = 0.537442               dvt2 = 5.56679E-2
+dvt0w = 0                     dvt1w = 0                     dvt2w = 0
+vfbsdoff = 0.02
//*** mobility related parameter ***
+u0 = ( 0.0152801+du0_n_cap) -6.079227E-4 lu0 = ( -2.636545E-10+dlu0_n_cap) + 2.372387E-10
+wu0 = ( -3.215249E-10+dwu0_n_cap) + 3.215249E-10
+pu0 = ( 7.659855E-16+dpu0_n_cap) -7.659855E-16
+ua = -2.010491E-9             lua = 6.470761E-18            ub = 2.317626E-18
+lub = -1.119031E-27           uc = 8.592292E-11             ud = 0
+vsat = 137107.0+dvsat_n_cap       a0 = 1E-3                     ags = 5.816217
+b0 = 0                        b1 = 0                        keta = -0.043526
+a1 = 0                        a2 = 1                        rdsw = 100.002354
+prwb = 0                      prwg = 0                      wr = 1
//*** subthreshold related parameter ***
+voff = -0.157278              lvoff = -1.200676E-10         voffl = -3.595178E-9
+minv = -0.15                  nfactor = 0.54601             lnfactor = 1.225078E-7
+eta0 = 9.63491E-4             etab = -1.992003E-3           letab = -8.165231E-10
+dsub = 0.422235               cit = 7.212E-4                cdsc = 0
+cdscb = 0                     cdscd = 0
//*** output resistance related parameter ***
+pclm = 1.441266               pdiblc1 = -4.011694E-3        lpdiblc1 = 4.37543E-10
+pdiblc2 = 4.969424E-3         lpdiblc2 = 2.569124E-10       pdiblcb = 1
+drout = 0.713681              ldrout = -1.506069E-8         pscbe1 = 1E9
+pscbe2 = 1E-20                pvag = 1.2                    delta = 7.595625E-3
+fprout = 300                  pdits = 0                     pditsl = 0
+pditsd = 0                    lc = 0                        alpha0 = 2E-10
+alpha1 = 0.01                 beta0 = 6.4                   agidl = 2.1505E-7
+bgidl = 2.1392E9              cgidl = 0.22                  egidl = 0.29734
//*** gate dielectric tunneling current ***
+aigbacc = 0.02                bigbacc = 2.47E-3             cigbacc = 0.3325
+nigbacc = 10                  aigbinv = 0.0158              bigbinv = 4.893E-3
+cigbinv = 6.1E-3              eigbinv = 1.1                 nigbinv = 10
+aigc = 0.0112                 bigc = 1.392E-3               cigc = 6.22E-4
+aigsd = 0.0106                bigsd = 1.235E-3              cigsd = 0.07
+dlcig = 2.48E-9               nigc = 3.07                   poxedge = 1
+pigcd = 2.591                 ntox = 1                      toxref = 3E-9
//*** capacitance parameter ***
+xpart = 1                     cgso = 5.53E-11+dcgso_n_cap       cgdo = 5.53E-11+dcgdo_n_cap
+cgbo = 0                      ckappas = 0.6                 ckappad = 0.6
+cf = 8.13E-11                 clc = 1.04E-7                 cle = 0.6
+dlc = 0                 dwc = 0                       noff = 2.96
+voffcv = -0.12                acde = 1                      moin = 5.67
+cgsl = 1.71E-11+dcgsl_n_cap       cgdl = 1.71E-11+dcgdl_n_cap
//*** souce/drain junction diode model parameter **
+ijthsrev = 0.01               ijthsfwd = 0.01               xjbvs = 1
+bvs = 10                      jss = 2.1E-7                  jsws = 3.4E-13
+jswgs = 1.2E-12               cjs = 8.61E-4+dcj_n_cap           mjs = 0.264
+mjsws = 0.011                 cjsws = 4.87E-11+dcjsw_n_cap      cjswgs = 2.56E-10+dcjswg_n_cap
+mjswgs = 0.511                pbs = 0.511                   pbsws = 0.786
+pbswgs = 0.464
//** rf model related parameter ***
+xrcrg1 = 12                   xrcrg2 = 1                    rbpb = 50
+rbpd = 50                     rbps = 50                     rbdb = 50
+rbsb = 50                     gbmin = 1E-12
//*** stress effect related parameter ***
+saref = 6.1E-7                sbref = 6.1E-7                wlod = 1.37E-7
+ku0 = -3.471E-8               kvsat = 0.342                 kvth0 = 2.461E-9
+tku0 = 0.097                  llodku0 = 1                   wlodku0 = 1
+llodvth = 1                   wlodvth = 1                   lku0 = 1.23E-8
+wku0 = 9.96E-8                pku0 = 4.6E-14                lkvth0 = -2.421E-11
+wkvth0 = 0                    pkvth0 = 0                    stk2 = 3.87E-10
+lodk2 = 0.5                   steta0 = 0                    lodeta0 = 1
//*** temperature coefficient ***
+tnom = 25                     ute = -1                      kt1 = -0.18098
+kt1l = 0                      kt2 = -0.036                  ua1 = 1.04E-9
+ub1 = -4.64E-19               uc1 = 8.71E-11                at = 1.4E5
+prt = 0                       njs = 1                       njd = 1
+xtis = 3                      xtid = 3                      tpb = 1.1E-3
+tpbsw = 1.9E-3                tpbswg = 1E-3                 tcj = 6.52E-4
+tcjsw = 3.57E-4               tcjswg = 1.5E-3               tvoff = 2.2428E-3
+tvfbsdoff = 0.022
//*** well proximity effect model parameters ***
+web = -210                    wec = -3.51E3                 kvth0we = 3.270022E-3
+k2we = 1.50195E-3             ku0we = -3.001501E-3          scref = 1E-6
38:type=n  minr=1e-60
//*** flag parameter ***
+version = 4.3                 binunit = 2                   mobmod = 0
+capmod = 2                    rdsmod = 0                    igcmod = 1
+igbmod = 1                    rbodymod = 0                  trnqsmod = 0
+acnqsmod = 0                  fnoimod = 1                   tnoimod = 0
+diomod = 1                    tempmod = 0                   permod = 1
+rgatemod = 0                  wpemod = 1
//*** geometry range parameter ***
+lmin = 1E-7                   lmax = 5E-7                   wmin = 1E-5
+wmax = 9E-4
//*** process parameter ***
+epsrox = 3.9                  toxe = tox_n_cap                  toxm = tox_n_cap
+dtox = 3.15E-10               xj = 8.1E-8                   ndep = 1E17
+ngate = 1.6E20                nsd = 1E20                    rsh = 17.5
+rshg = 15.5
//*** dw and dl parameter ***
+wint = 2E-9                   wl = 0                        wln = 1
+ww = 0                        wwn = 1                       wwl = 0
+lint = 1E-9                   ll = 0                        lln = 1
+lw = 0                        lwn = 1                       lwl = 0
+lwc = 0                       lwlc = 0                      wwc = 0
+wwlc = 0                      dwg = 0                       dwb = 0
+xl = 0.0+dxl_n_cap                xw = 0.0+dxw_n_cap
//*** flicker noise model parameter ***
+noia = 2.6E42                 noib = 1.61E21                noic = 3E8
+em = 1E6                      ef = 0.94                     lintnoi = -5E-9
//***layout-dependent parasitics model parameter ***
+dmcg = 4E-8                   dmci = 4E-8                   dmdg = 0
+dmcgt = 0                     dwj = 0                       xgw = 0
+xgl = 0                       ngcon = 1
//*** vth related  parameter ***
+vth0 = ( 0.34925+dvth0_n_cap) -2.437518E-3 lvth0 = ( 0.0+dlvth0_n_cap) + 9.088901E-11 wvth0 = 0.0+dwvth0_n_cap
+pvth0 = 0.0+dpvth0_n_cap          phin = 0                      k1 = 0.30264
+k2 = -0.012135                k3 = -7.284535                k3b = 2.454986
+w0 = 8.190018E-8              lpe0 = 6.610138E-8            lpeb = 2.000404E-8
+dvtp0 = 2.36094E-6            dvtp1 = 4.5                   dvt0 = 0.236381
+dvt1 = 0.537442               dvt2 = 5.56679E-2             dvt0w = 0
+dvt1w = 0                     dvt2w = 0                     vfbsdoff = 0.02
//*** mobility related parameter ***
+u0 = ( 0.0152801+du0_n_cap) -2.442341E-4 lu0 = ( -2.636545E-10+dlu0_n_cap) + 2.015973E-10
+wu0 = ( -3.215249E-10+dwu0_n_cap) + 3.215249E-10
+pu0 = ( 7.659855E-16+dpu0_n_cap) -7.659855E-16
+ua = -1.937245E-9             lua = -7.073076E-19           ub = 2.262908E-18
+lub = 4.243358E-27            uc = 6.12366E-11              luc = 2.41926E-18
+ud = 0                        vsat = ( 137107.0+dvsat_n_cap)  -0.2 a0 = 2.104237
+la0 = -2.061172E-7            ags = 4.145174                lags = 1.637622E-7
+b0 = 0                        b1 = 0                        keta = -6.84386E-2
+lketa = 2.44143E-9            a1 = 0                        a2 = 1
+rdsw = 100.002354             prwb = 0                      prwg = 0
+wr = 1
//*** subthreshold related parameter ***
+voff = -0.149845              lvoff = -8.485618E-10         voffl = -3.595178E-9
+minv = -0.15                  nfactor = 1.280059            lnfactor = 5.057093E-8
+eta0 = 3.453491E-3            leta0 = -2.4402E-10           etab = -1.73113E-2
+letab = 6.847723E-10          dsub = 0.422235               cit = 7.212E-4
+cdsc = 0                      cdscb = 0                     cdscd = 0
//*** output resistance related parameter ***
+pclm = 1.441266               pdiblc1 = 4.53031E-4          pdiblc2 = 8.214337E-3
+lpdiblc2 = -6.108904E-11      pdiblcb = 1                   drout = 0.56
+pscbe1 = 1E9                  pscbe2 = 1E-20                pvag = 1.2
+delta = 7.595625E-3           fprout = 300                  pdits = 0
+pditsl = 0                    pditsd = 0                    lc = 0
+alpha0 = 2E-10                alpha1 = 0.01                 beta0 = 6.4
+agidl = 2.1505E-7             bgidl = 2.1392E9              cgidl = 0.22
+egidl = 0.29734
//*** gate dielectric tunneling current ***
+aigbacc = 0.02                bigbacc = 2.47E-3             cigbacc = 0.3325
+nigbacc = 10                  aigbinv = 0.0158              bigbinv = 4.893E-3
+cigbinv = 6.1E-3              eigbinv = 1.1                 nigbinv = 10
+aigc = 0.0112                 bigc = 1.392E-3               cigc = 6.22E-4
+aigsd = 0.0106                bigsd = 1.235E-3              cigsd = 0.07
+dlcig = 2.48E-9               nigc = 3.07                   poxedge = 1
+pigcd = 2.591                 ntox = 1                      toxref = 3E-9
//*** capacitance parameter ***
+xpart = 1                     cgso = 5.53E-11+dcgso_n_cap       cgdo = 5.53E-11+dcgdo_n_cap
+cgbo = 0                      ckappas = 0.6                 ckappad = 0.6
+cf = 8.13E-11                 clc = 1.04E-7                 cle = 0.6
+dlc = 0                 dwc = 0                       noff = 2.96
+voffcv = -0.12                acde = 1                      moin = 5.67
+cgsl = 1.71E-11+dcgsl_n_cap       cgdl = 1.71E-11+dcgdl_n_cap
//*** souce/drain junction diode model parameter **
+ijthsrev = 0.01               ijthsfwd = 0.01               xjbvs = 1
+bvs = 10                      jss = 2.1E-7                  jsws = 3.4E-13
+jswgs = 1.2E-12               cjs = 8.61E-4+dcj_n_cap           mjs = 0.264
+mjsws = 0.011                 cjsws = 4.87E-11+dcjsw_n_cap      cjswgs = 2.56E-10+dcjswg_n_cap
+mjswgs = 0.511                pbs = 0.511                   pbsws = 0.786
+pbswgs = 0.464
//** rf model related parameter ***
+xrcrg1 = 12                   xrcrg2 = 1                    rbpb = 50
+rbpd = 50                     rbps = 50                     rbdb = 50
+rbsb = 50                     gbmin = 1E-12
//*** stress effect related parameter ***
+saref = 6.1E-7                sbref = 6.1E-7                wlod = 1.37E-7
+ku0 = -3.471E-8               kvsat = 0.342                 kvth0 = 2.461E-9
+tku0 = 0.097                  llodku0 = 1                   wlodku0 = 1
+llodvth = 1                   wlodvth = 1                   lku0 = 1.23E-8
+wku0 = 9.96E-8                pku0 = 4.6E-14                lkvth0 = -2.421E-11
+wkvth0 = 0                    pkvth0 = 0                    stk2 = 3.87E-10
+lodk2 = 0.5                   steta0 = 0                    lodeta0 = 1
//*** temperature coefficient ***
+tnom = 25                     ute = -1                      kt1 = -0.18098
+kt1l = 0                      kt2 = -0.036                  ua1 = 1.04E-9
+ub1 = -4.64E-19               uc1 = 8.71E-11                at = 1.4E5
+prt = 0                       njs = 1                       njd = 1
+xtis = 3                      xtid = 3                      tpb = 1.1E-3
+tpbsw = 1.9E-3                tpbswg = 1E-3                 tcj = 6.52E-4
+tcjsw = 3.57E-4               tcjswg = 1.5E-3               tvoff = 2.2428E-3
+tvfbsdoff = 0.022
//*** well proximity effect model parameters ***
+web = -210                    wec = -3.51E3                 kvth0we = 3.270022E-3
+k2we = 1.50195E-3             ku0we = -3.001501E-3          scref = 1E-6
39:type=n  minr=1e-60
//*** flag parameter ***
+version = 4.3                 binunit = 2                   mobmod = 0
+capmod = 2                    rdsmod = 0                    igcmod = 1
+igbmod = 1                    rbodymod = 0                  trnqsmod = 0
+acnqsmod = 0                  fnoimod = 1                   tnoimod = 0
+diomod = 1                    tempmod = 0                   permod = 1
+rgatemod = 0                  wpemod = 1
//*** geometry range parameter ***
+lmin = 5E-7                   lmax = 1E-6                   wmin = 1E-5
+wmax = 9E-4
//*** process parameter ***
+epsrox = 3.9                  toxe = tox_n_cap                  toxm = tox_n_cap
+dtox = 3.15E-10               xj = 8.1E-8                   ndep = 1E17
+ngate = 1.6E20                nsd = 1E20                    rsh = 17.5
+rshg = 15.5
//*** dw and dl parameter ***
+wint = 2E-9                   wl = 0                        wln = 1
+ww = 0                        wwn = 1                       wwl = 0
+lint = 1E-9                   ll = 0                        lln = 1
+lw = 0                        lwn = 1                       lwl = 0
+lwc = 0                       lwlc = 0                      wwc = 0
+wwlc = 0                      dwg = 0                       dwb = 0
+xl = 0.0+dxl_n_cap                xw = 0.0+dxw_n_cap
//*** flicker noise model parameter ***
+noia = 2.6E42                 noib = 1.61E21                noic = 3E8
+em = 1E6                      ef = 0.94                     lintnoi = -5E-9
//***layout-dependent parasitics model parameter ***
+dmcg = 4E-8                   dmci = 4E-8                   dmdg = 0
+dmcgt = 0                     dwj = 0                       xgw = 0
+xgl = 0                       ngcon = 1
//*** vth related  parameter ***
+vth0 = ( 0.34925+dvth0_n_cap) + 3.740107E-3 lvth0 = ( 0.0+dlvth0_n_cap) -2.985568E-9 wvth0 = 0.0+dwvth0_n_cap
+pvth0 = 0.0+dpvth0_n_cap          phin = 0                      k1 = 0.30264
+k2 = -0.012135                k3 = -7.284535                k3b = 2.454986
+w0 = 8.190018E-8              lpe0 = 6.610138E-8            lpeb = 2.000404E-8
+dvtp0 = 2.36094E-6            dvtp1 = 4.5                   dvt0 = 0.236381
+dvt1 = 0.537442               dvt2 = 5.56679E-2             dvt0w = 0
+dvt1w = 0                     dvt2w = 0                     vfbsdoff = 0.02
//*** mobility related parameter ***
+u0 = ( 0.0152801+du0_n_cap) -2.666202E-4 lu0 = ( -2.636545E-10+dlu0_n_cap) + 2.127455E-10
+wu0 = ( -3.215249E-10+dwu0_n_cap) + 3.215249E-10
+pu0 = ( 7.659855E-16+dpu0_n_cap) -7.659855E-16
+ua = -1.920515E-9             lua = -9.038884E-18           ub = 2.230807E-18
+lub = 2.022966E-26            uc = 6.609455E-11             ud = 0
+vsat = 137107.0+dvsat_n_cap       a0 = 1.361636                 la0 = 1.636982E-7
+ags = 1.159669                lags = 1.650544E-6            b0 = 0
+b1 = 0                        keta = -6.35361E-2            a1 = 0
+a2 = 1                        rdsw = 100.002354             prwb = 0
+prwg = 0                      wr = 1
//*** subthreshold related parameter ***
+voff = -0.153055              lvoff = 7.500389E-10          voffl = -3.595178E-9
+minv = -0.15                  nfactor = 1.062337            lnfactor = 1.589964E-7
+eta0 = 2.963491E-3            etab = -1.59363E-2            dsub = 0.422235
+cit = 7.212E-4                cdsc = 0                      cdscb = 0
+cdscd = 0
//*** output resistance related parameter ***
+pclm = 1.441266               pdiblc1 = 4.53031E-4          pdiblc2 = 8.091668E-3
+pdiblcb = 1                   drout = 0.56                  pscbe1 = 1E9
+pscbe2 = 1E-20                pvag = 1.2                    delta = 7.595625E-3
+fprout = 300                  pdits = 0                     pditsl = 0
+pditsd = 0                    lc = 0                        alpha0 = 2E-10
+alpha1 = 0.01                 beta0 = 6.4                   agidl = 2.1505E-7
+bgidl = 2.1392E9              cgidl = 0.22                  egidl = 0.29734
//*** gate dielectric tunneling current ***
+aigbacc = 0.02                bigbacc = 2.47E-3             cigbacc = 0.3325
+nigbacc = 10                  aigbinv = 0.0158              bigbinv = 4.893E-3
+cigbinv = 6.1E-3              eigbinv = 1.1                 nigbinv = 10
+aigc = 0.0112                 bigc = 1.392E-3               cigc = 6.22E-4
+aigsd = 0.0106                bigsd = 1.235E-3              cigsd = 0.07
+dlcig = 2.48E-9               nigc = 3.07                   poxedge = 1
+pigcd = 2.591                 ntox = 1                      toxref = 3E-9
//*** capacitance parameter ***
+xpart = 1                     cgso = 5.53E-11+dcgso_n_cap       cgdo = 5.53E-11+dcgdo_n_cap
+cgbo = 0                      ckappas = 0.6                 ckappad = 0.6
+cf = 8.13E-11                 clc = 1.04E-7                 cle = 0.6
+dlc = 0                 dwc = 0                       noff = 2.96
+voffcv = -0.12                acde = 1                      moin = 5.67
+cgsl = 1.71E-11+dcgsl_n_cap       cgdl = 1.71E-11+dcgdl_n_cap
//*** souce/drain junction diode model parameter **
+ijthsrev = 0.01               ijthsfwd = 0.01               xjbvs = 1
+bvs = 10                      jss = 2.1E-7                  jsws = 3.4E-13
+jswgs = 1.2E-12               cjs = 8.61E-4+dcj_n_cap           mjs = 0.264
+mjsws = 0.011                 cjsws = 4.87E-11+dcjsw_n_cap      cjswgs = 2.56E-10+dcjswg_n_cap
+mjswgs = 0.511                pbs = 0.511                   pbsws = 0.786
+pbswgs = 0.464
//** rf model related parameter ***
+xrcrg1 = 12                   xrcrg2 = 1                    rbpb = 50
+rbpd = 50                     rbps = 50                     rbdb = 50
+rbsb = 50                     gbmin = 1E-12
//*** stress effect related parameter ***
+saref = 6.1E-7                sbref = 6.1E-7                wlod = 1.37E-7
+ku0 = -3.471E-8               kvsat = 0.342                 kvth0 = 2.461E-9
+tku0 = 0.097                  llodku0 = 1                   wlodku0 = 1
+llodvth = 1                   wlodvth = 1                   lku0 = 1.23E-8
+wku0 = 9.96E-8                pku0 = 4.6E-14                lkvth0 = -2.421E-11
+wkvth0 = 0                    pkvth0 = 0                    stk2 = 3.87E-10
+lodk2 = 0.5                   steta0 = 0                    lodeta0 = 1
//*** temperature coefficient ***
+tnom = 25                     ute = -1                      kt1 = -0.18098
+kt1l = 0                      kt2 = -0.036                  ua1 = 1.04E-9
+ub1 = -4.64E-19               uc1 = 8.71E-11                at = 1.4E5
+prt = 0                       njs = 1                       njd = 1
+xtis = 3                      xtid = 3                      tpb = 1.1E-3
+tpbsw = 1.9E-3                tpbswg = 1E-3                 tcj = 6.52E-4
+tcjsw = 3.57E-4               tcjswg = 1.5E-3               tvoff = 2.2428E-3
+tvfbsdoff = 0.022
//*** well proximity effect model parameters ***
+web = -210                    wec = -3.51E3                 kvth0we = 3.270022E-3
+k2we = 1.50195E-3             ku0we = -3.001501E-3          scref = 1E-6
40:type=n  minr=1e-60
//*** flag parameter ***
+version = 4.3                 binunit = 2                   mobmod = 0
+capmod = 2                    rdsmod = 0                    igcmod = 1
+igbmod = 1                    rbodymod = 0                  trnqsmod = 0
+acnqsmod = 0                  fnoimod = 1                   tnoimod = 0
+diomod = 1                    tempmod = 0                   permod = 1
+rgatemod = 0                  wpemod = 1
//*** geometry range parameter ***
+lmin = 1E-6                   lmax = 2E-6                   wmin = 1E-5
+wmax = 9E-4
//*** process parameter ***
+epsrox = 3.9                  toxe = tox_n_cap                  toxm = tox_n_cap
+dtox = 3.15E-10               xj = 8.1E-8                   ndep = 1E17
+ngate = 1.6E20                nsd = 1E20                    rsh = 17.5
+rshg = 15.5
//*** dw and dl parameter ***
+wint = 2E-9                   wl = 0                        wln = 1
+ww = 0                        wwn = 1                       wwl = 0
+lint = 1E-9                   ll = 0                        lln = 1
+lw = 0                        lwn = 1                       lwl = 0
+lwc = 0                       lwlc = 0                      wwc = 0
+wwlc = 0                      dwg = 0                       dwb = 0
+xl = 0.0+dxl_n_cap                xw = 0.0+dxw_n_cap
//*** flicker noise model parameter ***
+noia = 2.6E42                 noib = 1.61E21                noic = 3E8
+em = 1E6                      ef = 0.94                     lintnoi = -5E-9
//***layout-dependent parasitics model parameter ***
+dmcg = 4E-8                   dmci = 4E-8                   dmdg = 0
+dmcgt = 0                     dwj = 0                       xgw = 0
+xgl = 0                       ngcon = 1
//*** vth related  parameter ***
+vth0 = ( 0.34925+dvth0_n_cap) -7.470586E-4 lvth0 = ( 0.0+dlvth0_n_cap) + 1.492623E-9 wvth0 = 0.0+dwvth0_n_cap
+pvth0 = 0.0+dpvth0_n_cap          phin = 0                      k1 = 0.30264
+k2 = -0.012135                k3 = -7.284535                k3b = 2.454986
+w0 = 8.190018E-8              lpe0 = 6.610138E-8            lpeb = 2.000404E-8
+dvtp0 = 2.36094E-6            dvtp1 = 4.5                   dvt0 = 0.236381
+dvt1 = 0.537442               dvt2 = 5.56679E-2             dvt0w = 0
+dvt1w = 0                     dvt2w = 0                     vfbsdoff = 0.02
//*** mobility related parameter ***
+u0 = ( 0.0152801+du0_n_cap) + 6.570424E-5 lu0 = ( -2.636545E-10+dlu0_n_cap) -1.189143E-10
+wu0 = ( -3.215249E-10+dwu0_n_cap) + 3.215249E-10
+pu0 = ( 7.659855E-16+dpu0_n_cap) -7.659855E-16
+ua = -1.917734E-9             lua = -1.181491E-17           ub = 2.274797E-18
+lub = -2.367243E-26           uc = 6.609455E-11             ud = 0
+vsat = 137107.0+dvsat_n_cap       a0 = 0.268423                 la0 = 1.254724E-6
+ags = 0.175792                lags = 2.632453E-6            b0 = 0
+b1 = 0                        keta = -0.023566              lketa = -3.988006E-8
+a1 = 0                        a2 = 1                        rdsw = 100.002354
+prwb = 0                      prwg = 0                      wr = 1
//*** subthreshold related parameter ***
+voff = -0.155715              lvoff = 3.404828E-9           voffl = -3.595178E-9
+minv = -0.15                  nfactor = 0.964668            lnfactor = 2.564708E-7
+eta0 = 2.963491E-3            etab = -1.59363E-2            dsub = 0.422235
+cit = 7.212E-4                cdsc = 0                      cdscb = 0
+cdscd = 0
//*** output resistance related parameter ***
+pclm = 1.441266               pdiblc1 = 4.53031E-4          pdiblc2 = 8.091668E-3
+pdiblcb = 1                   drout = 0.56                  pscbe1 = 1E9
+pscbe2 = 1E-20                pvag = 1.2                    delta = 7.595625E-3
+fprout = 300                  pdits = 0                     pditsl = 0
+pditsd = 0                    lc = 0                        alpha0 = 2E-10
+alpha1 = 0.01                 beta0 = 6.4                   agidl = 2.1505E-7
+bgidl = 2.1392E9              cgidl = 0.22                  egidl = 0.29734
//*** gate dielectric tunneling current ***
+aigbacc = 0.02                bigbacc = 2.47E-3             cigbacc = 0.3325
+nigbacc = 10                  aigbinv = 0.0158              bigbinv = 4.893E-3
+cigbinv = 6.1E-3              eigbinv = 1.1                 nigbinv = 10
+aigc = 0.0112                 bigc = 1.392E-3               cigc = 6.22E-4
+aigsd = 0.0106                bigsd = 1.235E-3              cigsd = 0.07
+dlcig = 2.48E-9               nigc = 3.07                   poxedge = 1
+pigcd = 2.591                 ntox = 1                      toxref = 3E-9
//*** capacitance parameter ***
+xpart = 1                     cgso = 5.53E-11+dcgso_n_cap       cgdo = 5.53E-11+dcgdo_n_cap
+cgbo = 0                      ckappas = 0.6                 ckappad = 0.6
+cf = 8.13E-11                 clc = 1.04E-7                 cle = 0.6
+dlc = 0                 dwc = 0                       noff = 2.96
+voffcv = -0.12                acde = 1                      moin = 5.67
+cgsl = 1.71E-11+dcgsl_n_cap       cgdl = 1.71E-11+dcgdl_n_cap
//*** souce/drain junction diode model parameter **
+ijthsrev = 0.01               ijthsfwd = 0.01               xjbvs = 1
+bvs = 10                      jss = 2.1E-7                  jsws = 3.4E-13
+jswgs = 1.2E-12               cjs = 8.61E-4+dcj_n_cap           mjs = 0.264
+mjsws = 0.011                 cjsws = 4.87E-11+dcjsw_n_cap      cjswgs = 2.56E-10+dcjswg_n_cap
+mjswgs = 0.511                pbs = 0.511                   pbsws = 0.786
+pbswgs = 0.464
//** rf model related parameter ***
+xrcrg1 = 12                   xrcrg2 = 1                    rbpb = 50
+rbpd = 50                     rbps = 50                     rbdb = 50
+rbsb = 50                     gbmin = 1E-12
//*** stress effect related parameter ***
+saref = 6.1E-7                sbref = 6.1E-7                wlod = 1.37E-7
+ku0 = -3.471E-8               kvsat = 0.342                 kvth0 = 2.461E-9
+tku0 = 0.097                  llodku0 = 1                   wlodku0 = 1
+llodvth = 1                   wlodvth = 1                   lku0 = 1.23E-8
+wku0 = 9.96E-8                pku0 = 4.6E-14                lkvth0 = -2.421E-11
+wkvth0 = 0                    pkvth0 = 0                    stk2 = 3.87E-10
+lodk2 = 0.5                   steta0 = 0                    lodeta0 = 1
//*** temperature coefficient ***
+tnom = 25                     ute = -1                      kt1 = -0.18098
+kt1l = 0                      kt2 = -0.036                  ua1 = 1.04E-9
+ub1 = -4.64E-19               uc1 = 8.71E-11                at = 1.4E5
+prt = 0                       njs = 1                       njd = 1
+xtis = 3                      xtid = 3                      tpb = 1.1E-3
+tpbsw = 1.9E-3                tpbswg = 1E-3                 tcj = 6.52E-4
+tcjsw = 3.57E-4               tcjswg = 1.5E-3               tvoff = 2.2428E-3
+tvfbsdoff = 0.022
//*** well proximity effect model parameters ***
+web = -210                    wec = -3.51E3                 kvth0we = 3.270022E-3
+k2we = 1.50195E-3             ku0we = -3.001501E-3          scref = 1E-6
41:type=n  minr=1e-60
//*** flag parameter ***
+version = 4.3                 binunit = 2                   mobmod = 0
+capmod = 2                    rdsmod = 0                    igcmod = 1
+igbmod = 1                    rbodymod = 0                  trnqsmod = 0
+acnqsmod = 0                  fnoimod = 1                   tnoimod = 0
+diomod = 1                    tempmod = 0                   permod = 1
+rgatemod = 0                  wpemod = 1
//*** geometry range parameter ***
+lmin = 2E-6                   lmax = 1E-5                   wmin = 1E-5
+wmax = 9E-4
//*** process parameter ***
+epsrox = 3.9                  toxe = tox_n_cap                  toxm = tox_n_cap
+dtox = 3.15E-10               xj = 8.1E-8                   ndep = 1E17
+ngate = 1.6E20                nsd = 1E20                    rsh = 17.5
+rshg = 15.5
//*** dw and dl parameter ***
+wint = 2E-9                   wl = 0                        wln = 1
+ww = 0                        wwn = 1                       wwl = 0
+lint = 1E-9                   ll = 0                        lln = 1
+lw = 0                        lwn = 1                       lwl = 0
+lwc = 0                       lwlc = 0                      wwc = 0
+wwlc = 0                      dwg = 0                       dwb = 0
+xl = 0.0+dxl_n_cap                xw = 0.0+dxw_n_cap
//*** flicker noise model parameter ***
+noia = 2.6E42                 noib = 1.61E21                noic = 3E8
+em = 1E6                      ef = 0.94                     lintnoi = -5E-9
//***layout-dependent parasitics model parameter ***
+dmcg = 4E-8                   dmci = 4E-8                   dmdg = 0
+dmcgt = 0                     dwj = 0                       xgw = 0
+xgl = 0                       ngcon = 1
//*** vth related  parameter ***
+vth0 = 0.34925+dvth0_n_cap        lvth0 = 0.0+dlvth0_n_cap          wvth0 = 0.0+dwvth0_n_cap
+pvth0 = 0.0+dpvth0_n_cap          phin = 0                      k1 = 0.30264
+k2 = -0.012135                k3 = -7.284535                k3b = 2.454986
+w0 = 8.190018E-8              lpe0 = 6.610138E-8            lpeb = 2.000404E-8
+dvtp0 = 2.36094E-6            dvtp1 = 4.5                   dvt0 = 0.236381
+dvt1 = 0.537442               dvt2 = 5.56679E-2             dvt0w = 0
+dvt1w = 0                     dvt2w = 0                     vfbsdoff = 0.02
//*** mobility related parameter ***
+u0 = ( 0.0152801+du0_n_cap) -3.216536E-5 lu0 = ( -2.636545E-10+dlu0_n_cap) + 7.66292E-11
+wu0 = ( -3.215249E-10+dwu0_n_cap) + 3.215249E-10
+pu0 = ( 7.659855E-16+dpu0_n_cap) -7.659855E-16
+ua = -1.918898E-9             lua = -9.488602E-18           ub = 2.271718E-18
+lub = -1.752145E-26           uc = 7.278085E-11             luc = -1.335922E-17
+ud = 0                        vsat = 137107.0+dvsat_n_cap       a0 = 1.930529
+la0 = -2.066163E-6            ags = 1.062652                lags = 8.605063E-7
+b0 = 0                        b1 = 0                        keta = -6.62436E-2
+lketa = 4.538972E-8           a1 = 0                        a2 = 1
+rdsw = 100.002354             prwb = 0                      prwg = 0
+wr = 1
//*** subthreshold related parameter ***
+voff = -0.154982              lvoff = 1.94017E-9            voffl = -3.595178E-9
+minv = -0.15                  nfactor = 1.001765            lnfactor = 1.823509E-7
+eta0 = 2.963491E-3            etab = -1.59363E-2            dsub = 0.422235
+cit = 7.212E-4                cdsc = 0                      cdscb = 0
+cdscd = 0
//*** output resistance related parameter ***
+pclm = 1.441266               pdiblc1 = 4.53031E-4          pdiblc2 = 8.654903E-3
+lpdiblc2 = -1.125343E-9       pdiblcb = 1                   drout = 0.56
+pscbe1 = 1E9                  pscbe2 = 1E-20                pvag = 1.2
+delta = 7.595625E-3           fprout = 300                  pdits = 0
+pditsl = 0                    pditsd = 0                    lc = 0
+alpha0 = 2E-10                alpha1 = 0.01                 beta0 = 6.4
+agidl = 2.1505E-7             bgidl = 2.1392E9              cgidl = 0.22
+egidl = 0.29734
//*** gate dielectric tunneling current ***
+aigbacc = 0.02                bigbacc = 2.47E-3             cigbacc = 0.3325
+nigbacc = 10                  aigbinv = 0.0158              bigbinv = 4.893E-3
+cigbinv = 6.1E-3              eigbinv = 1.1                 nigbinv = 10
+aigc = 0.0112                 bigc = 1.392E-3               cigc = 6.22E-4
+aigsd = 0.0106                bigsd = 1.235E-3              cigsd = 0.07
+dlcig = 2.48E-9               nigc = 3.07                   poxedge = 1
+pigcd = 2.591                 ntox = 1                      toxref = 3E-9
//*** capacitance parameter ***
+xpart = 1                     cgso = 5.53E-11+dcgso_n_cap       cgdo = 5.53E-11+dcgdo_n_cap
+cgbo = 0                      ckappas = 0.6                 ckappad = 0.6
+cf = 8.13E-11                 clc = 1.04E-7                 cle = 0.6
+dlc = 0                 dwc = 0                       noff = 2.96
+voffcv = -0.12                acde = 1                      moin = 5.67
+cgsl = 1.71E-11+dcgsl_n_cap       cgdl = 1.71E-11+dcgdl_n_cap
//*** souce/drain junction diode model parameter **
+ijthsrev = 0.01               ijthsfwd = 0.01               xjbvs = 1
+bvs = 10                      jss = 2.1E-7                  jsws = 3.4E-13
+jswgs = 1.2E-12               cjs = 8.61E-4+dcj_n_cap           mjs = 0.264
+mjsws = 0.011                 cjsws = 4.87E-11+dcjsw_n_cap      cjswgs = 2.56E-10+dcjswg_n_cap
+mjswgs = 0.511                pbs = 0.511                   pbsws = 0.786
+pbswgs = 0.464
//** rf model related parameter ***
+xrcrg1 = 12                   xrcrg2 = 1                    rbpb = 50
+rbpd = 50                     rbps = 50                     rbdb = 50
+rbsb = 50                     gbmin = 1E-12
//*** stress effect related parameter ***
+saref = 6.1E-7                sbref = 6.1E-7                wlod = 1.37E-7
+ku0 = -3.471E-8               kvsat = 0.342                 kvth0 = 2.461E-9
+tku0 = 0.097                  llodku0 = 1                   wlodku0 = 1
+llodvth = 1                   wlodvth = 1                   lku0 = 1.23E-8
+wku0 = 9.96E-8                pku0 = 4.6E-14                lkvth0 = -2.421E-11
+wkvth0 = 0                    pkvth0 = 0                    stk2 = 3.87E-10
+lodk2 = 0.5                   steta0 = 0                    lodeta0 = 1
//*** temperature coefficient ***
+tnom = 25                     ute = -1                      kt1 = -0.18098
+kt1l = 0                      kt2 = -0.036                  ua1 = 1.04E-9
+ub1 = -4.64E-19               uc1 = 8.71E-11                at = 1.4E5
+prt = 0                       njs = 1                       njd = 1
+xtis = 3                      xtid = 3                      tpb = 1.1E-3
+tpbsw = 1.9E-3                tpbswg = 1E-3                 tcj = 6.52E-4
+tcjsw = 3.57E-4               tcjswg = 1.5E-3               tvoff = 2.2428E-3
+tvfbsdoff = 0.022
//*** well proximity effect model parameters ***
+web = -210                    wec = -3.51E3                 kvth0we = 3.270022E-3
+k2we = 1.50195E-3             ku0we = -3.001501E-3          scref = 1E-6
42:type=n  minr=1e-60
//*** flag parameter ***
+version = 4.3                 binunit = 2                   mobmod = 0
+capmod = 2                    rdsmod = 0                    igcmod = 1
+igbmod = 1                    rbodymod = 0                  trnqsmod = 0
+acnqsmod = 0                  fnoimod = 1                   tnoimod = 0
+diomod = 1                    tempmod = 0                   permod = 1
+rgatemod = 0                  wpemod = 1
//*** geometry range parameter ***
+lmin = 1E-5                   lmax = 9E-4                   wmin = 1E-5
+wmax = 9E-4
//*** process parameter ***
+epsrox = 3.9                  toxe = tox_n_cap                  toxm = tox_n_cap
+dtox = 3.15E-10               xj = 8.1E-8                   ndep = 1E17
+ngate = 1.6E20                nsd = 1E20                    rsh = 17.5
+rshg = 15.5
//*** dw and dl parameter ***
+wint = 2E-9                   wl = 0                        wln = 1
+ww = 0                        wwn = 1                       wwl = 0
+lint = 1E-9                   ll = 0                        lln = 1
+lw = 0                        lwn = 1                       lwl = 0
+lwc = 0                       lwlc = 0                      wwc = 0
+wwlc = 0                      dwg = 0                       dwb = 0
+xl = 0.0+dxl_n_cap                xw = 0.0+dxw_n_cap
//*** flicker noise model parameter ***
+noia = 2.6E42                 noib = 1.61E21                noic = 3E8
+em = 1E6                      ef = 0.94                     lintnoi = -5E-9
//***layout-dependent parasitics model parameter ***
+dmcg = 4E-8                   dmci = 4E-8                   dmdg = 0
+dmcgt = 0                     dwj = 0                       xgw = 0
+xgl = 0                       ngcon = 1
//*** vth related  parameter ***
+vth0 = 0.34925+dvth0_n_cap        lvth0 = 0.0+dlvth0_n_cap          wvth0 = 0.0+dwvth0_n_cap
+pvth0 = 0.0+dpvth0_n_cap          phin = 0                      k1 = 0.30264
+k2 = -0.012135                k3 = -7.284535                k3b = 2.454986
+w0 = 8.190018E-8              lpe0 = 6.610138E-8            lpeb = 2.000404E-8
+dvtp0 = 2.36094E-6            dvtp1 = 4.5                   dvt0 = 0.236381
+dvt1 = 0.537442               dvt2 = 5.56679E-2             dvt0w = 0
+dvt1w = 0                     dvt2w = 0                     vfbsdoff = 0.02
//*** mobility related parameter ***
+u0 = ( 0.0152801+du0_n_cap) -5.087163E-5 lu0 = ( -2.636545E-10+dlu0_n_cap) + 2.636545E-10
+wu0 = ( -3.215249E-10+dwu0_n_cap) + 3.215249E-10
+pu0 = ( 7.659855E-16+dpu0_n_cap) -7.659855E-16
+ua = -1.919847E-9             ub = 2.269966E-18             uc = 7.144466E-11
+ud = 0                        vsat = 137107.0+dvsat_n_cap       a0 = 1.723871
+ags = 1.14872                 b0 = 0                        b1 = 0
+keta = -6.17037E-2            a1 = 0                        a2 = 1
+rdsw = 100.002354             prwb = 0                      prwg = 0
+wr = 1
//*** subthreshold related parameter ***
+voff = -0.154788              voffl = -3.595178E-9          minv = -0.15
+nfactor = 1.020003            eta0 = 2.963491E-3            etab = -1.59363E-2
+dsub = 0.422235               cit = 7.212E-4                cdsc = 0
+cdscb = 0                     cdscd = 0
//*** output resistance related parameter ***
+pclm = 1.441266               pdiblc1 = 4.53031E-4          pdiblc2 = 8.542346E-3
+pdiblcb = 1                   drout = 0.56                  pscbe1 = 1E9
+pscbe2 = 1E-20                pvag = 1.2                    delta = 7.595625E-3
+fprout = 300                  pdits = 0                     pditsl = 0
+pditsd = 0                    lc = 0                        alpha0 = 2E-10
+alpha1 = 0.01                 beta0 = 6.4                   agidl = 2.1505E-7
+bgidl = 2.1392E9              cgidl = 0.22                  egidl = 0.29734
//*** gate dielectric tunneling current ***
+aigbacc = 0.02                bigbacc = 2.47E-3             cigbacc = 0.3325
+nigbacc = 10                  aigbinv = 0.0158              bigbinv = 4.893E-3
+cigbinv = 6.1E-3              eigbinv = 1.1                 nigbinv = 10
+aigc = 0.0112                 bigc = 1.392E-3               cigc = 6.22E-4
+aigsd = 0.0106                bigsd = 1.235E-3              cigsd = 0.07
+dlcig = 2.48E-9               nigc = 3.07                   poxedge = 1
+pigcd = 2.591                 ntox = 1                      toxref = 3E-9
//*** capacitance parameter ***
+xpart = 1                     cgso = 5.53E-11+dcgso_n_cap       cgdo = 5.53E-11+dcgdo_n_cap
+cgbo = 0                      ckappas = 0.6                 ckappad = 0.6
+cf = 8.13E-11                 clc = 1.04E-7                 cle = 0.6
+dlc = 0                 dwc = 0                       noff = 2.96
+voffcv = -0.12                acde = 1                      moin = 5.67
+cgsl = 1.71E-11+dcgsl_n_cap       cgdl = 1.71E-11+dcgdl_n_cap
//*** souce/drain junction diode model parameter **
+ijthsrev = 0.01               ijthsfwd = 0.01               xjbvs = 1
+bvs = 10                      jss = 2.1E-7                  jsws = 3.4E-13
+jswgs = 1.2E-12               cjs = 8.61E-4+dcj_n_cap           mjs = 0.264
+mjsws = 0.011                 cjsws = 4.87E-11+dcjsw_n_cap      cjswgs = 2.56E-10+dcjswg_n_cap
+mjswgs = 0.511                pbs = 0.511                   pbsws = 0.786
+pbswgs = 0.464
//** rf model related parameter ***
+xrcrg1 = 12                   xrcrg2 = 1                    rbpb = 50
+rbpd = 50                     rbps = 50                     rbdb = 50
+rbsb = 50                     gbmin = 1E-12
//*** stress effect related parameter ***
+saref = 6.1E-7                sbref = 6.1E-7                wlod = 1.37E-7
+ku0 = -3.471E-8               kvsat = 0.342                 kvth0 = 2.461E-9
+tku0 = 0.097                  llodku0 = 1                   wlodku0 = 1
+llodvth = 1                   wlodvth = 1                   lku0 = 1.23E-8
+wku0 = 9.96E-8                pku0 = 4.6E-14                lkvth0 = -2.421E-11
+wkvth0 = 0                    pkvth0 = 0                    stk2 = 3.87E-10
+lodk2 = 0.5                   steta0 = 0                    lodeta0 = 1
//*** temperature coefficient ***
+tnom = 25                     ute = -1                      kt1 = -0.18098
+kt1l = 0                      kt2 = -0.036                  ua1 = 1.04E-9
+ub1 = -4.64E-19               uc1 = 8.71E-11                at = 1.4E5
+prt = 0                       njs = 1                       njd = 1
+xtis = 3                      xtid = 3                      tpb = 1.1E-3
+tpbsw = 1.9E-3                tpbswg = 1E-3                 tcj = 6.52E-4
+tcjsw = 3.57E-4               tcjswg = 1.5E-3               tvoff = 2.2428E-3
+tvfbsdoff = 0.022
//*** well proximity effect model parameters ***
+web = -210                    wec = -3.51E3                 kvth0we = 3.270022E-3
+k2we = 1.50195E-3             ku0we = -3.001501E-3          scref = 1E-6
}

model pch_mac bsim4 {
1:type=p  minr=1e-60
//*** flag parameter ***
+version = 4.3                 binunit = 2                   mobmod = 0
+capmod = 2                    rdsmod = 0                    igcmod = 1
+igbmod = 1                    rbodymod = 0                  trnqsmod = 0
+acnqsmod = 0                  fnoimod = 1                   tnoimod = 0
+diomod = 1                    permod = 1                    rgatemod = 0
+wpemod = 0
//*** geometry range parameter ***
+lmin = 2E-6                   lmax = 1E-5                   wmin = 2E-6
+wmax = 1E-5
//*** process parameter ***
+epsrox = 3.9                  toxe = tox_p_cap                  toxm = tox_p_cap
+dtox = 3.29E-10               xj = 1.7E-7                   ndep = 8.5E17
+ngate = 8E19                  nsd = 1E20                    rsh = 9.68
+rshg = 0.1
//*** dw and dl parameter ***
+wint = 1.089287E-8            wl = 0                        wln = 1
+ww = 0                        wwn = 1                       wwl = 0
+lint = 2E-24                  ll = 0                        lln = 1
+lw = 0                        lwn = 1                       lwl = 0
+llc = 0                       lwc = 0                       lwlc = 0
+wlc = 0                       wwc = 0                       wwlc = 0
+dwg = 0                       dwb = 0                       xl = 0.0+dxl_p_cap
+xw = 0.0+dxw_p_cap
//*** flicker noise model parameter ***
+noia = 1.45E42                noib = 3.57E26                noic = 2E10
+em = 2.1E7                    ef = 1.147
//***layout-dependent parasitics model parameter ***
+dmcg = 8.5E-8                 dmci = 8.5E-8                 dmdg = 0
+dmcgt = 0                     dwj = 0                       xgw = 0
+xgl = 0                       ngcon = 1
//*** vth related  parameter ***
+vth0 = -0.288698+dvth0_p_cap      lvth0 = 9.263001E-9+dlvth0_p_cap  wvth0 = 1.029638E-8+dwvth0_p_cap
+pvth0 = -6.341168E-15+dpvth0_p_cap phin = 0                      k1 = 0.25
+k2 = -8.103705E-3             lk2 = -3.276035E-9            wk2 = 3.410333E-10
+pk2 = -3.410333E-15           k3 = -1.700953                k3b = 1.200306
+w0 = 1.585076E-7              lpe0 = 7.519925E-8            lpeb = 5.608072E-8
+dvtp0 = 2.2E-6                dvtp1 = 0.2                   dvt0 = 0.20341
+dvt1 = 0.95146                dvt2 = 0.01                   dvt0w = 0
+dvt1w = 5.366499E6            dvt2w = 0
//*** mobility related parameter ***
+u0 = 0.0230515+du0_p_cap          lu0 = -2.679199E-9+dlu0_p_cap     wu0 = -3.385616E-9+dwu0_p_cap
+pu0 = 3.783728E-15+dpu0_p_cap     ua = 5.151217E-11             lua = -3.362198E-17
+wua = -5.231372E-17           pua = 1.338104E-23            ub = 1.55638E-18
+lub = -4.491856E-25           wub = -5.285709E-25           pub = 6.597406E-31
+uc = 7.043061E-11             luc = -4.913762E-17           ud = 0
+vsat = 117731.5+dvsat_p_cap       a0 = 2.353824                 la0 = 1.639705E-7
+wa0 = 6.701246E-7             pa0 = -1.636132E-12           ags = 1.121996
+lags = 9.247601E-7            wags = 1.432197E-7            pags = -3.175827E-13
+b0 = 0                        b1 = 0                        keta = -0.105855
+lketa = -8.503601E-9          wketa = -8.485076E-9          pketa = 8.485076E-14
+a1 = 0                        a2 = 1                        rdsw = 327.6
+prwb = -0.249981              prwg = 0.25                   wr = 1
//*** subthreshold related parameter ***
+voff = -4.98938E-2            lvoff = 1.151389E-8           wvoff = 1.102253E-8
+pvoff = -1.25565E-14          voffl = -6.036214E-9          minv = 0
+nfactor = 0.33243             lnfactor = 6.322266E-8        wnfactor = -3.033706E-8
+pnfactor = 5.237016E-15       eta0 = 3.11538E-2             etab = -2.38505E-2
+dsub = 1.2725                 cit = 1E-4                    cdsc = 0
+cdscb = 0                     cdscd = 0
//*** output resistance related parameter ***
+pclm = 0.627258               pdiblc1 = 0                   pdiblc2 = 1.09524E-2
+lpdiblc2 = 9.314481E-10       wpdiblc2 = 1.282359E-9        ppdiblc2 = -3.274831E-15
+pdiblcb = 0                   drout = 1.132692              pscbe1 = 9.264E8
+pscbe2 = 1E-20                pvag = 1.425                  delta = 0.02
+fprout = 390.234144           pdits = 5.042617E-3           pditsl = 100
+pditsd = 0                    alpha0 = 0                    alpha1 = 0.06
+beta0 = 13.5                  agidl = 9E-8                  bgidl = 3.404E9
+cgidl = 0.5                   egidl = 0.15
//*** gate dielectric tunneling current ***
+aigbacc = 0.012               bigbacc = 3.49E-3             cigbacc = 0.131
+nigbacc = 5.2                 aigbinv = 0.347               bigbinv = 0.0312
+cigbinv = 6.1E-3              eigbinv = 1.1                 nigbinv = 1
+aigc = 7.12E-3                bigc = 6.31E-4                cigc = 0
+aigsd = 5.9E-3                bigsd = 2.48E-4               cigsd = 0.032
+dlcig = 2.52E-9               nigc = 2.28                   poxedge = 1
+pigcd = 2.28                  ntox = 1                      toxref = 3E-9
//*** capacitance parameter ***
+xpart = 1                     cgso = 3.1E-11+dcgso_p_cap        cgdo = 3.1E-11+dcgdo_p_cap
+cgbo = 0                      ckappas = 0.6                 ckappad = 0.6
+cf = 1.18E-10                 clc = 1E-7                    cle = 0.6
+dlc = 0                 dwc = 0                       noff = 2.5
+voffcv = -0.0486              acde = 1.2                    moin = 8
+cgsl = 0.54E-10+dcgsl_p_cap       cgdl = 0.54E-10+dcgdl_p_cap
//*** souce/drain junction diode model parameter **
+ijthsrev = 0.01               ijthsfwd = 0.01               xjbvs = 1
+bvs = 10                      jss = 1.51E-7                 jsws = 3.98E-13
+jswgs = 2.47E-12              cjs = 9.98E-4+dcj_p_cap           mjs = 0.34
+mjsws = 0.012                 cjsws = 6.21E-11+dcjsw_p_cap      cjswgs = 2.53E-10+dcjswg_p_cap
+mjswgs = 0.86                 pbs = 0.75                    pbsws = 0.49
+pbswgs = 0.71
//** rf model related parameter ***
+xrcrg1 = 12                   xrcrg2 = 1                    rbpb = 50
+rbpd = 50                     rbps = 50                     rbdb = 50
+rbsb = 50                     gbmin = 1E-12
//*** stress effect related parameter ***
+saref = 6.1E-7                sbref = 6.1E-7                wlod = 2.86E-7
+ku0 = 1E-7                    kvsat = -0.386                kvth0 = 2E-10
+tku0 = 0.24                   llodku0 = 1                   wlodku0 = 1
+llodvth = 1.8                 wlodvth = 1                   lku0 = 1.871E-7
+wku0 = 2.4E-7                 pku0 = -3.24E-14              lkvth0 = 2.4E-10
+wkvth0 = 1.8E-10              pkvth0 = 0                    stk2 = 0
+lodk2 = 1.9                   steta0 = 0                    lodeta0 = 1
//*** temperature coefficient ***
+tnom = 25                     ute = -1.524                  kt1 = -0.229
+kt1l = 0                      kt2 = -0.01232                ua1 = 4.549E-9
+ub1 = -5.441E-18              uc1 = -5E-11                  at = 4.00001E4
+prt = 0                       njs = 1                       xtis = 3
+tpb = 1.9E-3                  tpbsw = 1.9E-3                tpbswg = 1.9E-3
+tcj = 7.98E-4                 tcjsw = 2.4E-4                tcjswg = 4.77E-3
//*** well proximity effect model parameters ***
+web = -220                    wec = -3E3                    kvth0we = -3.197498E-3
+k2we = 3E-4                   ku0we = -3.482487E-3          scref = 1E-6
2:type=p  minr=1e-60
//*** flag parameter ***
+version = 4.3                 binunit = 2                   mobmod = 0
+capmod = 2                    rdsmod = 0                    igcmod = 1
+igbmod = 1                    rbodymod = 0                  trnqsmod = 0
+acnqsmod = 0                  fnoimod = 1                   tnoimod = 0
+diomod = 1                    permod = 1                    rgatemod = 0
+wpemod = 0
//*** geometry range parameter ***
+lmin = 1E-6                   lmax = 2E-6                   wmin = 2E-6
+wmax = 1E-5
//*** process parameter ***
+epsrox = 3.9                  toxe = tox_p_cap                  toxm = tox_p_cap
+dtox = 3.29E-10               xj = 1.7E-7                   ndep = 8.5E17
+ngate = 8E19                  nsd = 1E20                    rsh = 9.68
+rshg = 0.1
//*** dw and dl parameter ***
+wint = 1.089287E-8            wl = 0                        wln = 1
+ww = 0                        wwn = 1                       wwl = 0
+lint = 2E-24                  ll = 0                        lln = 1
+lw = 0                        lwn = 1                       lwl = 0
+llc = 0                       lwc = 0                       lwlc = 0
+wlc = 0                       wwc = 0                       wwlc = 0
+dwg = 0                       dwb = 0                       xl = 0+dxl_p_cap
+xw = 0+dxw_p_cap
//*** flicker noise model parameter ***
+noia = 1.45E42                noib = 3.57E26                noic = 2E10
+em = 2.1E7                    ef = 1.147
//***layout-dependent parasitics model parameter ***
+dmcg = 8.5E-8                 dmci = 8.5E-8                 dmdg = 0
+dmcgt = 0                     dwj = 0                       xgw = 0
+xgl = 0                       ngcon = 1
//*** vth related  parameter ***
+vth0 = -0.286578+dvth0_p_cap      lvth0 = 5.023342E-9+dlvth0_p_cap  wvth0 = 1.285999E-8+dwvth0_p_cap
+pvth0 = -1.146839E-14+dpvth0_p_cap phin = 0                      k1 = 0.25
+k2 = -9.741722E-3             wk2 = -1.364133E-9            k3 = -1.700953
+k3b = 1.200306                w0 = 1.585076E-7              lpe0 = 7.519925E-8
+lpeb = 5.608072E-8            dvtp0 = 2.2E-6                dvtp1 = 0.2
+dvt0 = 0.20341                dvt1 = 0.95146                dvt2 = 0.01
+dvt0w = 0                     dvt1w = 5.366499E6            dvt2w = 0
//*** mobility related parameter ***
+u0 = 2.23473E-2+du0_p_cap         lu0 = -1.270823E-9+dlu0_p_cap     wu0 = -2.593464E-9+dwu0_p_cap
+pu0 = 2.199423E-15+dpu0_p_cap     ua = 4.59749E-11              lua = -2.254745E-17
+wua = -6.792504E-17           pua = 4.460368E-23            ub = 1.394442E-18
+lub = -1.253081E-25           wub = -2.720312E-25           pub = 1.466611E-31
+uc = 4.245963E-11             luc = 6.804335E-18            wuc = 3.394756E-17
+puc = -6.789511E-23           ud = 0                        vsat = 1.177315E5+dvsat_p_cap
+a0 = 2.435809                 wa0 = -1.479417E-7            ags = 1.103433
+lags = 9.618857E-7            wags = 4.527397E-8            pags = -1.216912E-13
+b0 = 0                        b1 = 0                        keta = -0.135073
+lketa = 4.993248E-8           wketa = 8.332888E-8           pketa = -9.877715E-14
+a1 = 0                        a2 = 1                        rdsw = 327.6
+prwb = -0.249981              prwg = 0.25                   wr = 1
//*** subthreshold related parameter ***
+voff = -4.64666E-2            lvoff = 4.659386E-9           wvoff = 8.261531E-9
+pvoff = -7.034502E-15         voffl = -6.036214E-9          minv = 0
+nfactor = 0.328351            lnfactor = 7.138037E-8        wnfactor = -2.471329E-8
+pnfactor = -6.010539E-15      eta0 = 3.11538E-2             etab = -2.38505E-2
+dsub = 1.2725                 cit = 1E-4                    cdsc = 0
+cdscb = 0                     cdscd = 0
//*** output resistance related parameter ***
+pclm = 0.627258               pdiblc1 = 0                   pdiblc2 = 1.12459E-2
+lpdiblc2 = 3.443418E-10       wpdiblc2 = -3.51355E-10       ppdiblc2 = -7.402142E-18
+pdiblcb = 0                   drout = 1.132692              pscbe1 = 9.264E8
+pscbe2 = 1E-20                pvag = 1.425                  delta = 0.02
+fprout = 390.234144           pdits = 5.042617E-3           pditsl = 100
+pditsd = 0                    alpha0 = 0                    alpha1 = 0.06
+beta0 = 13.5                  agidl = 9E-8                  bgidl = 3.404E9
+cgidl = 0.5                   egidl = 0.15
//*** gate dielectric tunneling current ***
+aigbacc = 0.012               bigbacc = 3.49E-3             cigbacc = 0.131
+nigbacc = 5.2                 aigbinv = 0.347               bigbinv = 0.0312
+cigbinv = 6.1E-3              eigbinv = 1.1                 nigbinv = 1
+aigc = 7.12E-3                bigc = 6.31E-4                cigc = 0
+aigsd = 5.9E-3                bigsd = 2.48E-4               cigsd = 0.032
+dlcig = 2.52E-9               nigc = 2.28                   poxedge = 1
+pigcd = 2.28                  ntox = 1                      toxref = 3E-9
//*** capacitance parameter ***
+xpart = 1                     cgso = 3.1E-11+dcgso_p_cap        cgdo = 3.1E-11+dcgdo_p_cap
+cgbo = 0                      ckappas = 0.6                 ckappad = 0.6
+cf = 1.18E-10                 clc = 1E-7                    cle = 0.6
+dlc = 0                 dwc = 0                       noff = 2.5
+voffcv = -0.0486              acde = 1.2                    moin = 8
+cgsl = 0.54E-10+dcgsl_p_cap       cgdl = 0.54E-10+dcgdl_p_cap
//*** souce/drain junction diode model parameter **
+ijthsrev = 0.01               ijthsfwd = 0.01               xjbvs = 1
+bvs = 10                      jss = 1.51E-7                 jsws = 3.98E-13
+jswgs = 2.47E-12              cjs = 9.98E-4+dcj_p_cap           mjs = 0.34
+mjsws = 0.012                 cjsws = 6.21E-11+dcjsw_p_cap      cjswgs = 2.53E-10+dcjswg_p_cap
+mjswgs = 0.86                 pbs = 0.75                    pbsws = 0.49
+pbswgs = 0.71
//** rf model related parameter ***
+xrcrg1 = 12                   xrcrg2 = 1                    rbpb = 50
+rbpd = 50                     rbps = 50                     rbdb = 50
+rbsb = 50                     gbmin = 1E-12
//*** stress effect related parameter ***
+saref = 6.1E-7                sbref = 6.1E-7                wlod = 2.86E-7
+ku0 = 1E-7                    kvsat = -0.386                kvth0 = 2E-10
+tku0 = 0.24                   llodku0 = 1                   wlodku0 = 1
+llodvth = 1.8                 wlodvth = 1                   lku0 = 1.871E-7
+wku0 = 2.4E-7                 pku0 = -3.24E-14              lkvth0 = 2.4E-10
+wkvth0 = 1.8E-10              pkvth0 = 0                    stk2 = 0
+lodk2 = 1.9                   steta0 = 0                    lodeta0 = 1
//*** temperature coefficient ***
+tnom = 25                     ute = -1.524                  kt1 = -0.229
+kt1l = 0                      kt2 = -0.01232                ua1 = 4.549E-9
+ub1 = -5.441E-18              uc1 = -5E-11                  at = 4.00001E4
+prt = 0                       njs = 1                       xtis = 3
+tpb = 1.9E-3                  tpbsw = 1.9E-3                tpbswg = 1.9E-3
+tcj = 7.98E-4                 tcjsw = 2.4E-4                tcjswg = 4.77E-3
//*** well proximity effect model parameters ***
+web = -220                    wec = -3E3                    kvth0we = -3.197498E-3
+k2we = 3E-4                   ku0we = -3.482487E-3          scref = 1E-6
3:type=p  minr=1e-60
//*** flag parameter ***
+version = 4.3                 binunit = 2                   mobmod = 0
+capmod = 2                    rdsmod = 0                    igcmod = 1
+igbmod = 1                    rbodymod = 0                  trnqsmod = 0
+acnqsmod = 0                  fnoimod = 1                   tnoimod = 0
+diomod = 1                    permod = 1                    rgatemod = 0
+wpemod = 0
//*** geometry range parameter ***
+lmin = 5E-7                   lmax = 1E-6                   wmin = 2E-6
+wmax = 1E-5
//*** process parameter ***
+epsrox = 3.9                  toxe = tox_p_cap                  toxm = tox_p_cap
+dtox = 3.29E-10               xj = 1.7E-7                   ndep = 8.5E17
+ngate = 8E19                  nsd = 1E20                    rsh = 9.68
+rshg = 0.1
//*** dw and dl parameter ***
+wint = 1.089287E-8            wl = 0                        wln = 1
+ww = 0                        wwn = 1                       wwl = 0
+lint = 2E-24                  ll = 0                        lln = 1
+lw = 0                        lwn = 1                       lwl = 0
+llc = 0                       lwc = 0                       lwlc = 0
+wlc = 0                       wwc = 0                       wwlc = 0
+dwg = 0                       dwb = 0                       xl = 0+dxl_p_cap
+xw = 0+dxw_p_cap
//*** flicker noise model parameter ***
+noia = 1.45E42                noib = 3.57E26                noic = 2E10
+em = 2.1E7                    ef = 1.147
//***layout-dependent parasitics model parameter ***
+dmcg = 8.5E-8                 dmci = 8.5E-8                 dmdg = 0
+dmcgt = 0                     dwj = 0                       xgw = 0
+xgl = 0                       ngcon = 1
//*** vth related  parameter ***
+vth0 = -0.281971+dvth0_p_cap      lvth0 = 4.161374E-10+dlvth0_p_cap wvth0 = 5.344347E-9+dwvth0_p_cap
+pvth0 = -3.952744E-15+dpvth0_p_cap phin = 0                      k1 = 0.25
+k2 = -9.741722E-3             wk2 = -1.364133E-9            k3 = -1.700953
+k3b = 1.200306                w0 = 1.585076E-7              lpe0 = 7.519925E-8
+lpeb = 5.608072E-8            dvtp0 = 2.2E-6                dvtp1 = 0.2
+dvt0 = 0.20341                dvt1 = 0.95146                dvt2 = 0.01
+dvt0w = 0                     dvt1w = 5.366499E6            dvt2w = 0
//*** mobility related parameter ***
+u0 = 2.09644E-2+du0_p_cap         lu0 = 1.121201E-10+dlu0_p_cap     wu0 = -9.785632E-10+dwu0_p_cap
+pu0 = 5.845225E-16+dpu0_p_cap     ua = 3.658013E-11             lua = -1.315267E-17
+wua = -4.934016E-17           pua = 2.60188E-23             ub = 1.20891E-18
+lub = 6.022366E-26            wub = -2.324297E-25           pub = 1.070596E-31
+uc = 6.221217E-11             luc = -1.29482E-17            wuc = -4.050973E-17
+puc = 6.562172E-24            ud = 0                        vsat = 1.177315E5+dvsat_p_cap
+a0 = 3.175174                 la0 = -7.393642E-7            wa0 = -2.093795E-7
+pa0 = 6.143778E-14            ags = 1.263312                lags = 8.020065E-7
+wags = -3.837517E-7           pags = 3.073345E-13           b0 = 0
+b1 = 0                        keta = -8.27813E-2            lketa = -2.358872E-9
+wketa = -3.89856E-8           pketa = 2.353733E-14          a1 = 0
+a2 = 1                        rdsw = 327.6                  prwb = -0.249981
+prwg = 0.25                   wr = 1
//*** subthreshold related parameter ***
+voff = -4.17999E-2            lvoff = -7.225053E-12         wvoff = 4.126448E-9
+pvoff = -2.899419E-15         voffl = -6.036214E-9          minv = 0
+nfactor = 0.333318            lnfactor = 6.641339E-8        wnfactor = -4.149641E-8
+pnfactor = 1.077258E-14       eta0 = 3.11538E-2             etab = -2.38505E-2
+dsub = 1.2725                 cit = 1E-4                    cdsc = 0
+cdscb = 0                     cdscd = 0
//*** output resistance related parameter ***
+pclm = 0.627258               pdiblc1 = 0                   pdiblc2 = 1.27197E-2
+lpdiblc2 = -1.129468E-9       wpdiblc2 = -1.5658E-9         ppdiblc2 = 1.207043E-15
+pdiblcb = 0                   drout = 1.132692              pscbe1 = 9.264E8
+pscbe2 = 1E-20                pvag = 1.425                  delta = 0.02
+fprout = 390.234144           pdits = 5.042617E-3           pditsl = 100
+pditsd = 0                    alpha0 = 0                    alpha1 = 0.06
+beta0 = 13.5                  agidl = 9E-8                  bgidl = 3.404E9
+cgidl = 0.5                   egidl = 0.15
//*** gate dielectric tunneling current ***
+aigbacc = 0.012               bigbacc = 3.49E-3             cigbacc = 0.131
+nigbacc = 5.2                 aigbinv = 0.347               bigbinv = 0.0312
+cigbinv = 6.1E-3              eigbinv = 1.1                 nigbinv = 1
+aigc = 7.12E-3                bigc = 6.31E-4                cigc = 0
+aigsd = 5.9E-3                bigsd = 2.48E-4               cigsd = 0.032
+dlcig = 2.52E-9               nigc = 2.28                   poxedge = 1
+pigcd = 2.28                  ntox = 1                      toxref = 3E-9
//*** capacitance parameter ***
+xpart = 1                     cgso = 3.1E-11+dcgso_p_cap        cgdo = 3.1E-11+dcgdo_p_cap
+cgbo = 0                      ckappas = 0.6                 ckappad = 0.6
+cf = 1.18E-10                 clc = 1E-7                    cle = 0.6
+dlc = 0                 dwc = 0                       noff = 2.5
+voffcv = -0.0486              acde = 1.2                    moin = 8
+cgsl = 0.54E-10+dcgsl_p_cap       cgdl = 0.54E-10+dcgdl_p_cap
//*** souce/drain junction diode model parameter **
+ijthsrev = 0.01               ijthsfwd = 0.01               xjbvs = 1
+bvs = 10                      jss = 1.51E-7                 jsws = 3.98E-13
+jswgs = 2.47E-12              cjs = 9.98E-4+dcj_p_cap           mjs = 0.34
+mjsws = 0.012                 cjsws = 6.21E-11+dcjsw_p_cap      cjswgs = 2.53E-10+dcjswg_p_cap
+mjswgs = 0.86                 pbs = 0.75                    pbsws = 0.49
+pbswgs = 0.71
//** rf model related parameter ***
+xrcrg1 = 12                   xrcrg2 = 1                    rbpb = 50
+rbpd = 50                     rbps = 50                     rbdb = 50
+rbsb = 50                     gbmin = 1E-12
//*** stress effect related parameter ***
+saref = 6.1E-7                sbref = 6.1E-7                wlod = 2.86E-7
+ku0 = 1E-7                    kvsat = -0.386                kvth0 = 2E-10
+tku0 = 0.24                   llodku0 = 1                   wlodku0 = 1
+llodvth = 1.8                 wlodvth = 1                   lku0 = 1.871E-7
+wku0 = 2.4E-7                 pku0 = -3.24E-14              lkvth0 = 2.4E-10
+wkvth0 = 1.8E-10              pkvth0 = 0                    stk2 = 0
+lodk2 = 1.9                   steta0 = 0                    lodeta0 = 1
//*** temperature coefficient ***
+tnom = 25                     ute = -1.524                  kt1 = -0.229
+kt1l = 0                      kt2 = -0.01232                ua1 = 4.549E-9
+ub1 = -5.441E-18              uc1 = -5E-11                  at = 4.00001E4
+prt = 0                       njs = 1                       xtis = 3
+tpb = 1.9E-3                  tpbsw = 1.9E-3                tpbswg = 1.9E-3
+tcj = 7.98E-4                 tcjsw = 2.4E-4                tcjswg = 4.77E-3
//*** well proximity effect model parameters ***
+web = -220                    wec = -3E3                    kvth0we = -3.197498E-3
+k2we = 3E-4                   ku0we = -3.482487E-3          scref = 1E-6
4:type=p  minr=1e-60
//*** flag parameter ***
+version = 4.3                 binunit = 2                   mobmod = 0
+capmod = 2                    rdsmod = 0                    igcmod = 1
+igbmod = 1                    rbodymod = 0                  trnqsmod = 0
+acnqsmod = 0                  fnoimod = 1                   tnoimod = 0
+diomod = 1                    permod = 1                    rgatemod = 0
+wpemod = 0
//*** geometry range parameter ***
+lmin = 1E-7                   lmax = 5E-7                   wmin = 2E-6
+wmax = 1E-5
//*** process parameter ***
+epsrox = 3.9                  toxe = tox_p_cap                  toxm = tox_p_cap
+dtox = 3.29E-10               xj = 1.7E-7                   ndep = 8.5E17
+ngate = 8E19                  nsd = 1E20                    rsh = 9.68
+rshg = 0.1
//*** dw and dl parameter ***
+wint = 1.089287E-8            wl = 0                        wln = 1
+ww = 0                        wwn = 1                       wwl = 0
+lint = 2E-24                  ll = 0                        lln = 1
+lw = 0                        lwn = 1                       lwl = 0
+llc = 0                       lwc = 0                       lwlc = 0
+wlc = 0                       wwc = 0                       wwlc = 0
+dwg = 0                       dwb = 0                       xl = 0+dxl_p_cap
+xw = 0+dxw_p_cap
//*** flicker noise model parameter ***
+noia = 1.45E42                noib = 3.57E26                noic = 2E10
+em = 2.1E7                    ef = 1.147
//***layout-dependent parasitics model parameter ***
+dmcg = 8.5E-8                 dmci = 8.5E-8                 dmdg = 0
+dmcgt = 0                     dwj = 0                       xgw = 0
+xgl = 0                       ngcon = 1
//*** vth related  parameter ***
+vth0 = -0.275585+dvth0_p_cap      lvth0 = -2.776426E-9+dlvth0_p_cap wvth0 = -1.39222E-9+dwvth0_p_cap
+pvth0 = -5.844608E-16+dpvth0_p_cap phin = 0                      k1 = 0.25
+k2 = -8.734273E-3             lk2 = -5.037244E-10           wk2 = -1.520113E-9
+pk2 = 7.798989E-17            k3 = -1.700953                k3b = 1.200306
+w0 = 1.585076E-7              lpe0 = 7.519925E-8            lpeb = 5.608072E-8
+dvtp0 = 2.2E-6                dvtp1 = 0.2                   dvt0 = 0.20341
+dvt1 = 0.95146                dvt2 = 0.01                   dvt0w = 0
+dvt1w = 5.366499E6            dvt2w = 0
//*** mobility related parameter ***
+u0 = 2.07851E-2+du0_p_cap         lu0 = 2.017547E-10+dlu0_p_cap     wu0 = 5.89704E-10+dwu0_p_cap
+pu0 = -1.996111E-16+dpu0_p_cap    ua = 1.049063E-11             lua = -1.079212E-19
+wua = 5.437182E-19            pua = 1.076861E-24            ub = 1.183295E-18
+lub = 7.303113E-26            wub = 7.477397E-26            pub = -4.65422E-32
+uc = 3.108169E-11             luc = 2.617039E-18            wuc = -1.703126E-17
+puc = -5.177064E-24           ud = 0                        vsat = 1.177315E5+dvsat_p_cap
+a0 = 2.120307                 la0 = -2.119307E-7            wa0 = -1.081299E-7
+pa0 = 1.081299E-14            ags = 2.472015                lags = 1.976549E-7
+wags = 5.701919E-7            pags = -1.696374E-13          b0 = 0
+b1 = 0                        keta = -9.97782E-2            lketa = 6.139585E-9
+wketa = 2.248882E-8           pketa = -7.199879E-15         a1 = 0
+a2 = 1                        rdsw = 327.6                  prwb = -0.249981
+prwg = 0.25                   wr = 1
//*** subthreshold related parameter ***
+voff = -3.79697E-2            lvoff = -1.922371E-9          wvoff = 1.102919E-10
+pvoff = -8.913413E-16         voffl = -6.036214E-9          minv = 0
+nfactor = 0.392253            lnfactor = 3.69457E-8         wnfactor = 1.796006E-8
+pnfactor = -1.895565E-14      eta0 = 3.11538E-2             etab = -2.38505E-2
+dsub = 1.2725                 cit = 1E-4                    cdsc = 0
+cdscb = 0                     cdscd = 0
//*** output resistance related parameter ***
+pclm = 0.627258               pdiblc1 = 0                   pdiblc2 = 1.08806E-2
+lpdiblc2 = -2.098993E-10      wpdiblc2 = 7.910077E-10       ppdiblc2 = 2.863889E-17
+pdiblcb = 0                   drout = 1.132692              pscbe1 = 9.264E8
+pscbe2 = 1E-20                pvag = 1.425                  delta = 0.02
+fprout = 390.234144           pdits = 5.042617E-3           pditsl = 100
+pditsd = 0                    alpha0 = 0                    alpha1 = 0.06
+beta0 = 13.5                  agidl = 9E-8                  bgidl = 3.404E9
+cgidl = 0.5                   egidl = 0.15
//*** gate dielectric tunneling current ***
+aigbacc = 0.012               bigbacc = 3.49E-3             cigbacc = 0.131
+nigbacc = 5.2                 aigbinv = 0.347               bigbinv = 0.0312
+cigbinv = 6.1E-3              eigbinv = 1.1                 nigbinv = 1
+aigc = 7.12E-3                bigc = 6.31E-4                cigc = 0
+aigsd = 5.9E-3                bigsd = 2.48E-4               cigsd = 0.032
+dlcig = 2.52E-9               nigc = 2.28                   poxedge = 1
+pigcd = 2.28                  ntox = 1                      toxref = 3E-9
//*** capacitance parameter ***
+xpart = 1                     cgso = 3.1E-11+dcgso_p_cap        cgdo = 3.1E-11+dcgdo_p_cap
+cgbo = 0                      ckappas = 0.6                 ckappad = 0.6
+cf = 1.18E-10                 clc = 1E-7                    cle = 0.6
+dlc = 0                 dwc = 0                       noff = 2.5
+voffcv = -0.0486              acde = 1.2                    moin = 8
+cgsl = 0.54E-10+dcgsl_p_cap       cgdl = 0.54E-10+dcgdl_p_cap
//*** souce/drain junction diode model parameter **
+ijthsrev = 0.01               ijthsfwd = 0.01               xjbvs = 1
+bvs = 10                      jss = 1.51E-7                 jsws = 3.98E-13
+jswgs = 2.47E-12              cjs = 9.98E-4+dcj_p_cap           mjs = 0.34
+mjsws = 0.012                 cjsws = 6.21E-11+dcjsw_p_cap      cjswgs = 2.53E-10+dcjswg_p_cap
+mjswgs = 0.86                 pbs = 0.75                    pbsws = 0.49
+pbswgs = 0.71
//** rf model related parameter ***
+xrcrg1 = 12                   xrcrg2 = 1                    rbpb = 50
+rbpd = 50                     rbps = 50                     rbdb = 50
+rbsb = 50                     gbmin = 1E-12
//*** stress effect related parameter ***
+saref = 6.1E-7                sbref = 6.1E-7                wlod = 2.86E-7
+ku0 = 1E-7                    kvsat = -0.386                kvth0 = 2E-10
+tku0 = 0.24                   llodku0 = 1                   wlodku0 = 1
+llodvth = 1.8                 wlodvth = 1                   lku0 = 1.871E-7
+wku0 = 2.4E-7                 pku0 = -3.24E-14              lkvth0 = 2.4E-10
+wkvth0 = 1.8E-10              pkvth0 = 0                    stk2 = 0
+lodk2 = 1.9                   steta0 = 0                    lodeta0 = 1
//*** temperature coefficient ***
+tnom = 25                     ute = -1.524                  kt1 = -0.229
+kt1l = 0                      kt2 = -0.01232                ua1 = 4.549E-9
+ub1 = -5.441E-18              uc1 = -5E-11                  at = 4.00001E4
+prt = 0                       njs = 1                       xtis = 3
+tpb = 1.9E-3                  tpbsw = 1.9E-3                tpbswg = 1.9E-3
+tcj = 7.98E-4                 tcjsw = 2.4E-4                tcjswg = 4.77E-3
//*** well proximity effect model parameters ***
+web = -220                    wec = -3E3                    kvth0we = -3.197498E-3
+k2we = 3E-4                   ku0we = -3.482487E-3          scref = 1E-6
5:type=p  minr=1e-60
//*** flag parameter ***
+version = 4.3                 binunit = 2                   mobmod = 0
+capmod = 2                    rdsmod = 0                    igcmod = 1
+igbmod = 1                    rbodymod = 0                  trnqsmod = 0
+acnqsmod = 0                  fnoimod = 1                   tnoimod = 0
+diomod = 1                    permod = 1                    rgatemod = 0
+wpemod = 0
//*** geometry range parameter ***
+lmin = 6E-8                   lmax = 1E-7                   wmin = 2E-6
+wmax = 1E-5
//*** process parameter ***
+epsrox = 3.9                  toxe = tox_p_cap                  toxm = tox_p_cap
+dtox = 3.29E-10               xj = 1.7E-7                   ndep = 8.5E17
+ngate = 8E19                  nsd = 1E20                    rsh = 9.68
+rshg = 0.1
//*** dw and dl parameter ***
+wint = 1.089287E-8            wl = 0                        wln = 1
+ww = 0                        wwn = 1                       wwl = 0
+lint = 2E-24                  ll = 0                        lln = 1
+lw = 0                        lwn = 1                       lwl = 0
+llc = 0                       lwc = 0                       lwlc = 0
+wlc = 0                       wwc = 0                       wwlc = 0
+dwg = 0                       dwb = 0                       xl = 0+dxl_p_cap
+xw = 0+dxw_p_cap
//*** flicker noise model parameter ***
+noia = 1.45E42                noib = 3.57E26                noic = 2E10
+em = 2.1E7                    ef = 1.147
//***layout-dependent parasitics model parameter ***
+dmcg = 8.5E-8                 dmci = 8.5E-8                 dmdg = 0
+dmcgt = 0                     dwj = 0                       xgw = 0
+xgl = 0                       ngcon = 1
//*** vth related  parameter ***
+vth0 = -0.310337+dvth0_p_cap      lvth0 = 6.98694E-10+dlvth0_p_cap  wvth0 = -2.806521E-9+dwvth0_p_cap
+pvth0 = -4.430304E-16+dpvth0_p_cap phin = 0                      k1 = 0.25
+k2 = -7.660604E-4             lk2 = -1.300546E-9            wk2 = -2.433084E-9
+pk2 = 1.69287E-16             k3 = -1.700953                k3b = 1.200306
+w0 = 1.585076E-7              lpe0 = 7.519925E-8            lpeb = 5.608072E-8
+dvtp0 = 2.2E-6                dvtp1 = 0.2                   dvt0 = 0.20341
+dvt1 = 0.95146                dvt2 = 0.01                   dvt0w = 0
+dvt1w = 5.366499E6            dvt2w = 0
//*** mobility related parameter ***
+u0 = 2.39733E-2+du0_p_cap         lu0 = -1.170701E-10+dlu0_p_cap    wu0 = -8.823129E-9+dwu0_p_cap
+pu0 = 7.416722E-16+dpu0_p_cap     ua = 9.411414E-12             wua = 1.131233E-17
+pua = -1.223948E-30           ub = 1.448845E-18             lub = 4.647614E-26
+wub = -1.46372E-24            pub = 1.073072E-31            uc = 2.898805E-11
+luc = 2.826403E-18            wuc = -1.28896E-17            puc = -5.59123E-24
+ud = 0                        vsat = 8.83204E4+dvsat_p_cap      lvsat = 2.94111E-3
+wvsat = 1.85036E-2            pvsat = -1.850502E-9          a0 = 1E-3
+ags = 4.448564                wags = -1.126182E-6           b0 = 0
+b1 = 0                        keta = 5.302681E-3            lketa = -4.368507E-9
+wketa = 7.072747E-9           pketa = -5.658271E-15         a1 = 0
+a2 = 1                        rdsw = 327.6                  prwb = -0.249981
+prwg = 0.25                   wr = 1
//*** subthreshold related parameter ***
+voff = -7.82839E-2            lvoff = 2.109055E-9           wvoff = -1.09305E-8
+pvoff = 2.127376E-16          voffl = -6.036214E-9          minv = 0
+nfactor = 0.213279            lnfactor = 5.484309E-8        wnfactor = -4.80473E-8
+pnfactor = -1.235492E-14      eta0 = 3.11538E-2             etab = -2.38505E-2
+dsub = 1.2725                 cit = 1E-4                    cdsc = 0
+cdscb = 0                     cdscd = 0
//*** output resistance related parameter ***
+pclm = 0.627258               pdiblc1 = 0                   pdiblc2 = 1.05063E-2
+lpdiblc2 = -1.724729E-10      wpdiblc2 = 4.725202E-9        ppdiblc2 = -3.647805E-16
+pdiblcb = 0                   drout = 1.132692              pscbe1 = 9.264E8
+pscbe2 = 1E-20                pvag = 1.425                  delta = 0.02
+fprout = 390.234144           pdits = 5.042617E-3           pditsl = 100
+pditsd = 0                    alpha0 = 0                    alpha1 = 0.06
+beta0 = 13.5                  agidl = 9E-8                  bgidl = 3.404E9
+cgidl = 0.5                   egidl = 0.15
//*** gate dielectric tunneling current ***
+aigbacc = 0.012               bigbacc = 3.49E-3             cigbacc = 0.131
+nigbacc = 5.2                 aigbinv = 0.347               bigbinv = 0.0312
+cigbinv = 6.1E-3              eigbinv = 1.1                 nigbinv = 1
+aigc = 7.12E-3                bigc = 6.31E-4                cigc = 0
+aigsd = 5.9E-3                bigsd = 2.48E-4               cigsd = 0.032
+dlcig = 2.52E-9               nigc = 2.28                   poxedge = 1
+pigcd = 2.28                  ntox = 1                      toxref = 3E-9
//*** capacitance parameter ***
+xpart = 1                     cgso = 3.1E-11+dcgso_p_cap        cgdo = 3.1E-11+dcgdo_p_cap
+cgbo = 0                      ckappas = 0.6                 ckappad = 0.6
+cf = 1.18E-10                 clc = 1E-7                    cle = 0.6
+dlc = 0                 dwc = 0                       noff = 2.5
+voffcv = -0.0486              acde = 1.2                    moin = 8
+cgsl = 0.54E-10+dcgsl_p_cap       cgdl = 0.54E-10+dcgdl_p_cap
//*** souce/drain junction diode model parameter **
+ijthsrev = 0.01               ijthsfwd = 0.01               xjbvs = 1
+bvs = 10                      jss = 1.51E-7                 jsws = 3.98E-13
+jswgs = 2.47E-12              cjs = 9.98E-4+dcj_p_cap           mjs = 0.34
+mjsws = 0.012                 cjsws = 6.21E-11+dcjsw_p_cap      cjswgs = 2.53E-10+dcjswg_p_cap
+mjswgs = 0.86                 pbs = 0.75                    pbsws = 0.49
+pbswgs = 0.71
//** rf model related parameter ***
+xrcrg1 = 12                   xrcrg2 = 1                    rbpb = 50
+rbpd = 50                     rbps = 50                     rbdb = 50
+rbsb = 50                     gbmin = 1E-12
//*** stress effect related parameter ***
+saref = 6.1E-7                sbref = 6.1E-7                wlod = 2.86E-7
+ku0 = 1E-7                    kvsat = -0.386                kvth0 = 2E-10
+tku0 = 0.24                   llodku0 = 1                   wlodku0 = 1
+llodvth = 1.8                 wlodvth = 1                   lku0 = 1.871E-7
+wku0 = 2.4E-7                 pku0 = -3.24E-14              lkvth0 = 2.4E-10
+wkvth0 = 1.8E-10              pkvth0 = 0                    stk2 = 0
+lodk2 = 1.9                   steta0 = 0                    lodeta0 = 1
//*** temperature coefficient ***
+tnom = 25                     ute = -1.524                  kt1 = -0.229
+kt1l = 0                      kt2 = -0.01232                ua1 = 4.549E-9
+ub1 = -5.441E-18              uc1 = -5E-11                  at = 4.00001E4
+prt = 0                       njs = 1                       xtis = 3
+tpb = 1.9E-3                  tpbsw = 1.9E-3                tpbswg = 1.9E-3
+tcj = 7.98E-4                 tcjsw = 2.4E-4                tcjswg = 4.77E-3
//*** well proximity effect model parameters ***
+web = -220                    wec = -3E3                    kvth0we = -3.197498E-3
+k2we = 3E-4                   ku0we = -3.482487E-3          scref = 1E-6
6:type=p  minr=1e-60
//*** flag parameter ***
+version = 4.3                 binunit = 2                   mobmod = 0
+capmod = 2                    rdsmod = 0                    igcmod = 1
+igbmod = 1                    rbodymod = 0                  trnqsmod = 0
+acnqsmod = 0                  fnoimod = 1                   tnoimod = 0
+diomod = 1                    permod = 1                    rgatemod = 0
+wpemod = 0
//*** geometry range parameter ***
+lmin = 4E-8                   lmax = 6E-8                   wmin = 2E-6
+wmax = 1E-5
//*** process parameter ***
+epsrox = 3.9                  toxe = tox_p_cap                  toxm = tox_p_cap
+dtox = 3.29E-10               xj = 1.7E-7                   ndep = 8.5E17
+ngate = 8E19                  nsd = 1E20                    rsh = 9.68
+rshg = 0.1
//*** dw and dl parameter ***
+wint = 1.089287E-8            wl = 0                        wln = 1
+ww = 0                        wwn = 1                       wwl = 0
+lint = 2E-24                  ll = 0                        lln = 1
+lw = 0                        lwn = 1                       lwl = 0
+llc = 0                       lwc = 0                       lwlc = 0
+wlc = 0                       wwc = 0                       wwlc = 0
+dwg = 0                       dwb = 0                       xl = 0+dxl_p_cap
+xw = 0+dxw_p_cap
//*** flicker noise model parameter ***
+noia = 1.45E42                noib = 3.57E26                noic = 2E10
+em = 2.1E7                    ef = 1.147
//***layout-dependent parasitics model parameter ***
+dmcg = 8.5E-8                 dmci = 8.5E-8                 dmdg = 0
+dmcgt = 0                     dwj = 0                       xgw = 0
+xgl = 0                       ngcon = 1
//*** vth related  parameter ***
+vth0 = -0.361251+dvth0_p_cap      lvth0 = 3.75355E-9+dlvth0_p_cap   wvth0 = -3.46667E-9+dwvth0_p_cap
+pvth0 = -4.034214E-16+dpvth0_p_cap phin = 0                      k1 = 0.25
+k2 = -2.10585E-2              lk2 = -8.299958E-11           wk2 = 1.06507E-8
+pk2 = -6.157398E-16           k3 = -1.700953                k3b = 1.200306
+w0 = 1.585076E-7              lpe0 = 7.519925E-8            lpeb = 5.608072E-8
+dvtp0 = 2.2E-6                dvtp1 = 0.2                   dvt0 = 0.20341
+dvt1 = 0.95146                dvt2 = 0.01                   dvt0w = 0
+dvt1w = 5.366499E6            dvt2w = 0
//*** mobility related parameter ***
+u0 = 2.87262E-2+du0_p_cap         lu0 = -4.022427E-10+dlu0_p_cap    wu0 = -2.002279E-9+dwu0_p_cap
+pu0 = 3.324212E-16+dpu0_p_cap     ua = 9.411419E-12             lua = 0
+wua = 1.131231E-17            ub = 1.801744E-18             lub = 2.530217E-26
+wub = -2.448186E-25           pub = 3.41731E-32             uc = -4.172837E-10
+luc = 2.960271E-17            wuc = 8.699316E-16            puc = -5.85605E-23
+ud = 0                        vsat = 1.191535E5+dvsat_p_cap     lvsat = 1.091123E-3
+wvsat = -2.112115E-6          pvsat = -7.401602E-10         a0 = 1E-3
+ags = 4.448564                wags = -1.126182E-6           b0 = 0
+b1 = 0                        keta = -0.137522              lketa = 4.200956E-9
+wketa = 2.122737E-7           pketa = -1.797033E-14         a1 = 0
+a2 = 1                        rdsw = 327.6                  prwb = -0.249981
+prwg = 0.25                   wr = 1
//*** subthreshold related parameter ***
+voff = -0.107133              lvoff = 3.84E-9               wvoff = -7.38487E-9
+voffl = -6.036214E-9          minv = 0                      nfactor = 0.450931
+lnfactor = 4.058396E-8        wnfactor = -1.015821E-7       pnfactor = -9.14283E-15
+eta0 = 3.11538E-2             etab = 0.175493               letab = -1.196063E-8
+wetab = -1.048193E-7          petab = 6.289156E-15          dsub = 1.2725
+cit = 1E-4                    cdsc = 0                      cdscb = 0
+cdscd = 0
//*** output resistance related parameter ***
+pclm = 0.627258               pdiblc1 = 0                   pdiblc2 = 1.04829E-2
+lpdiblc2 = -1.710651E-10      wpdiblc2 = 9.61405E-10        ppdiblc2 = -1.389527E-16
+pdiblcb = 0                   drout = 1.132692              pscbe1 = 9.264E8
+pscbe2 = 1E-20                pvag = 1.425                  delta = 0.02
+fprout = 390.234144           pdits = 5.042617E-3           pditsl = 100
+pditsd = 0                    alpha0 = 0                    alpha1 = 0.06
+beta0 = 13.5                  agidl = 9E-8                  bgidl = 3.404E9
+cgidl = 0.5                   egidl = 0.15
//*** gate dielectric tunneling current ***
+aigbacc = 0.012               bigbacc = 3.49E-3             cigbacc = 0.131
+nigbacc = 5.2                 aigbinv = 0.347               bigbinv = 0.0312
+cigbinv = 6.1E-3              eigbinv = 1.1                 nigbinv = 1
+aigc = 7.12E-3                bigc = 6.31E-4                cigc = 0
+aigsd = 5.9E-3                bigsd = 2.48E-4               cigsd = 0.032
+dlcig = 2.52E-9               nigc = 2.28                   poxedge = 1
+pigcd = 2.28                  ntox = 1                      toxref = 3E-9
//*** capacitance parameter ***
+xpart = 1                     cgso = 3.1E-11+dcgso_p_cap        cgdo = 3.1E-11+dcgdo_p_cap
+cgbo = 0                      ckappas = 0.6                 ckappad = 0.6
+cf = 1.18E-10                 clc = 1E-7                    cle = 0.6
+dlc = 0                 dwc = 0                       noff = 2.5
+voffcv = -0.0486              acde = 1.2                    moin = 8
+cgsl = 0.54E-10+dcgsl_p_cap       cgdl = 0.54E-10+dcgdl_p_cap
//*** souce/drain junction diode model parameter **
+ijthsrev = 0.01               ijthsfwd = 0.01               xjbvs = 1
+bvs = 10                      jss = 1.51E-7                 jsws = 3.98E-13
+jswgs = 2.47E-12              cjs = 9.98E-4+dcj_p_cap           mjs = 0.34
+mjsws = 0.012                 cjsws = 6.21E-11+dcjsw_p_cap      cjswgs = 2.53E-10+dcjswg_p_cap
+mjswgs = 0.86                 pbs = 0.75                    pbsws = 0.49
+pbswgs = 0.71
//** rf model related parameter ***
+xrcrg1 = 12                   xrcrg2 = 1                    rbpb = 50
+rbpd = 50                     rbps = 50                     rbdb = 50
+rbsb = 50                     gbmin = 1E-12
//*** stress effect related parameter ***
+saref = 6.1E-7                sbref = 6.1E-7                wlod = 2.86E-7
+ku0 = 1E-7                    kvsat = -0.386                kvth0 = 2E-10
+tku0 = 0.24                   llodku0 = 1                   wlodku0 = 1
+llodvth = 1.8                 wlodvth = 1                   lku0 = 1.871E-7
+wku0 = 2.4E-7                 pku0 = -3.24E-14              lkvth0 = 2.4E-10
+wkvth0 = 1.8E-10              pkvth0 = 0                    stk2 = 0
+lodk2 = 1.9                   steta0 = 0                    lodeta0 = 1
//*** temperature coefficient ***
+tnom = 25                     ute = -1.524                  kt1 = -0.229
+kt1l = 0                      kt2 = -0.01232                ua1 = 4.549E-9
+ub1 = -5.441E-18              uc1 = -5E-11                  at = 4.00001E4
+prt = 0                       njs = 1                       xtis = 3
+tpb = 1.9E-3                  tpbsw = 1.9E-3                tpbswg = 1.9E-3
+tcj = 7.98E-4                 tcjsw = 2.4E-4                tcjswg = 4.77E-3
//*** well proximity effect model parameters ***
+web = -220                    wec = -3E3                    kvth0we = -3.197498E-3
+k2we = 3E-4                   ku0we = -3.482487E-3          scref = 1E-6
7:type=p  minr=1e-60
//*** flag parameter ***
+version = 4.3                 binunit = 2                   mobmod = 0
+capmod = 2                    rdsmod = 0                    igcmod = 1
+igbmod = 1                    rbodymod = 0                  trnqsmod = 0
+acnqsmod = 0                  fnoimod = 1                   tnoimod = 0
+diomod = 1                    permod = 1                    rgatemod = 0
+wpemod = 0
//*** geometry range parameter ***
+lmin = 2E-6                   lmax = 1E-5                   wmin = 1E-6
+wmax = 2E-6
//*** process parameter ***
+epsrox = 3.9                  toxe = tox_p_cap                  toxm = tox_p_cap
+dtox = 3.29E-10               xj = 1.7E-7                   ndep = 8.5E17
+ngate = 8E19                  nsd = 1E20                    rsh = 9.68
+rshg = 0.1
//*** dw and dl parameter ***
+wint = 1.089287E-8            wl = 0                        wln = 1
+ww = 0                        wwn = 1                       wwl = 0
+lint = 2E-24                  ll = 0                        lln = 1
+lw = 0                        lwn = 1                       lwl = 0
+llc = 0                       lwc = 0                       lwlc = 0
+wlc = 0                       wwc = 0                       wwlc = 0
+dwg = 0                       dwb = 0                       xl = 0+dxl_p_cap
+xw = 0+dxw_p_cap
//*** flicker noise model parameter ***
+noia = 1.45E42                noib = 3.57E26                noic = 2E10
+em = 2.1E7                    ef = 1.147
//***layout-dependent parasitics model parameter ***
+dmcg = 8.5E-8                 dmci = 8.5E-8                 dmdg = 0
+dmcgt = 0                     dwj = 0                       xgw = 0
+xgl = 0                       ngcon = 1
//*** vth related  parameter ***
+vth0 = -0.287228+dvth0_p_cap      lvth0 = 9.894545E-9+dlvth0_p_cap  wvth0 = 7.388762E-9+dwvth0_p_cap
+pvth0 = -7.590498E-15+dpvth0_p_cap phin = 0                      k1 = 0.25
+k2 = -7.93131E-3              lk2 = -4.99998E-9             k3 = -1.700953
+k3b = 1.200306                w0 = 1.585076E-7              lpe0 = 7.519925E-8
+lpeb = 5.608072E-8            dvtp0 = 2.2E-6                dvtp1 = 0.2
+dvt0 = 0.20341                dvt1 = 0.95146                dvt2 = 0.01
+dvt0w = 0                     dvt1w = 5.366499E6            dvt2w = 0
//*** mobility related parameter ***
+u0 = 2.19348E-2+du0_p_cap         lu0 = -1.401117E-9+dlu0_p_cap     wu0 = -1.176503E-9+dwu0_p_cap
+pu0 = 1.255407E-15+dpu0_p_cap     ua = 3.789645E-11             lua = -5.313043E-17
+wua = -2.537891E-17           pua = 5.197295E-23            ub = 1.381669E-18
+lub = -1.677064E-25           wub = -1.829542E-25           pub = 1.029144E-31
+uc = 6.754658E-11             luc = -2.029733E-17           wuc = 5.705229E-18
+puc = -5.705229E-23           ud = 0                        vsat = 1.177315E5+dvsat_p_cap
+a0 = 2.692968                 la0 = -6.670179E-7            wa0 = -7.74047E-10
+pa0 = 7.74047E-15             ags = 1.189838                lags = 8.097828E-7
+wags = 9.013293E-9            pags = -9.013293E-14          b0 = 0
+b1 = 0                        keta = -0.109517              lketa = 2.811767E-8
+wketa = -1.240604E-9          pketa = 1.240604E-14          a1 = 0
+a2 = 1                        rdsw = 327.6                  prwb = -0.249981
+prwg = 0.25                   wr = 1
//*** subthreshold related parameter ***
+voff = -4.67608E-2            lvoff = 6.899651E-9           wvoff = 4.82478E-9
+pvoff = -3.428544E-15         voffl = -6.036214E-9          minv = 0
+nfactor = 0.333318            lnfactor = 6.415813E-8        wnfactor = -3.209392E-8
+pnfactor = 3.386455E-15       eta0 = 3.11538E-2             etab = -2.38505E-2
+dsub = 1.2725                 cit = 1E-4                    cdsc = 0
+cdscb = 0                     cdscd = 0
//*** output resistance related parameter ***
+pclm = 0.627258               pdiblc1 = 0                   pdiblc2 = 1.15966E-2
+lpdiblc2 = -6.843823E-10      wpdiblc2 = 7.837225E-12       ppdiblc2 = -7.837225E-17
+pdiblcb = 0                   drout = 1.132692              pscbe1 = 9.264E8
+pscbe2 = 1E-20                pvag = 1.425                  delta = 0.02
+fprout = 390.234144           pdits = 5.042617E-3           pditsl = 100
+pditsd = 0                    alpha0 = 0                    alpha1 = 0.06
+beta0 = 13.5                  agidl = 9E-8                  bgidl = 3.404E9
+cgidl = 0.5                   egidl = 0.15
//*** gate dielectric tunneling current ***
+aigbacc = 0.012               bigbacc = 3.49E-3             cigbacc = 0.131
+nigbacc = 5.2                 aigbinv = 0.347               bigbinv = 0.0312
+cigbinv = 6.1E-3              eigbinv = 1.1                 nigbinv = 1
+aigc = 7.12E-3                bigc = 6.31E-4                cigc = 0
+aigsd = 5.9E-3                bigsd = 2.48E-4               cigsd = 0.032
+dlcig = 2.52E-9               nigc = 2.28                   poxedge = 1
+pigcd = 2.28                  ntox = 1                      toxref = 3E-9
//*** capacitance parameter ***
+xpart = 1                     cgso = 3.1E-11+dcgso_p_cap        cgdo = 3.1E-11+dcgdo_p_cap
+cgbo = 0                      ckappas = 0.6                 ckappad = 0.6
+cf = 1.18E-10                 clc = 1E-7                    cle = 0.6
+dlc = 0                 dwc = 0                       noff = 2.5
+voffcv = -0.0486              acde = 1.2                    moin = 8
+cgsl = 0.54E-10+dcgsl_p_cap       cgdl = 0.54E-10+dcgdl_p_cap
//*** souce/drain junction diode model parameter **
+ijthsrev = 0.01               ijthsfwd = 0.01               xjbvs = 1
+bvs = 10                      jss = 1.51E-7                 jsws = 3.98E-13
+jswgs = 2.47E-12              cjs = 9.98E-4+dcj_p_cap           mjs = 0.34
+mjsws = 0.012                 cjsws = 6.21E-11+dcjsw_p_cap      cjswgs = 2.53E-10+dcjswg_p_cap
+mjswgs = 0.86                 pbs = 0.75                    pbsws = 0.49
+pbswgs = 0.71
//** rf model related parameter ***
+xrcrg1 = 12                   xrcrg2 = 1                    rbpb = 50
+rbpd = 50                     rbps = 50                     rbdb = 50
+rbsb = 50                     gbmin = 1E-12
//*** stress effect related parameter ***
+saref = 6.1E-7                sbref = 6.1E-7                wlod = 2.86E-7
+ku0 = 1E-7                    kvsat = -0.386                kvth0 = 2E-10
+tku0 = 0.24                   llodku0 = 1                   wlodku0 = 1
+llodvth = 1.8                 wlodvth = 1                   lku0 = 1.871E-7
+wku0 = 2.4E-7                 pku0 = -3.24E-14              lkvth0 = 2.4E-10
+wkvth0 = 1.8E-10              pkvth0 = 0                    stk2 = 0
+lodk2 = 1.9                   steta0 = 0                    lodeta0 = 1
//*** temperature coefficient ***
+tnom = 25                     ute = -1.524                  kt1 = -0.229
+kt1l = 0                      kt2 = -0.01232                ua1 = 4.549E-9
+ub1 = -5.441E-18              uc1 = -5E-11                  at = 4.00001E4
+prt = 0                       njs = 1                       xtis = 3
+tpb = 1.9E-3                  tpbsw = 1.9E-3                tpbswg = 1.9E-3
+tcj = 7.98E-4                 tcjsw = 2.4E-4                tcjswg = 4.77E-3
//*** well proximity effect model parameters ***
+web = -220                    wec = -3E3                    kvth0we = -3.197498E-3
+k2we = 3E-4                   ku0we = -3.482487E-3          scref = 1E-6
8:type=p  minr=1e-60
//*** flag parameter ***
+version = 4.3                 binunit = 2                   mobmod = 0
+capmod = 2                    rdsmod = 0                    igcmod = 1
+igbmod = 1                    rbodymod = 0                  trnqsmod = 0
+acnqsmod = 0                  fnoimod = 1                   tnoimod = 0
+diomod = 1                    permod = 1                    rgatemod = 0
+wpemod = 0
//*** geometry range parameter ***
+lmin = 1E-6                   lmax = 2E-6                   wmin = 1E-6
+wmax = 2E-6
//*** process parameter ***
+epsrox = 3.9                  toxe = tox_p_cap                  toxm = tox_p_cap
+dtox = 3.29E-10               xj = 1.7E-7                   ndep = 8.5E17
+ngate = 8E19                  nsd = 1E20                    rsh = 9.68
+rshg = 0.1
//*** dw and dl parameter ***
+wint = 1.089287E-8            wl = 0                        wln = 1
+ww = 0                        wwn = 1                       wwl = 0
+lint = 2E-24                  ll = 0                        lln = 1
+lw = 0                        lwn = 1                       lwl = 0
+llc = 0                       lwc = 0                       lwlc = 0
+wlc = 0                       wwc = 0                       wwlc = 0
+dwg = 0                       dwb = 0                       xl = 0+dxl_p_cap
+xw = 0+dxw_p_cap
//*** flicker noise model parameter ***
+noia = 1.45E42                noib = 3.57E26                noic = 2E10
+em = 2.1E7                    ef = 1.147
//***layout-dependent parasitics model parameter ***
+dmcg = 8.5E-8                 dmci = 8.5E-8                 dmdg = 0
+dmcgt = 0                     dwj = 0                       xgw = 0
+xgl = 0                       ngcon = 1
//*** vth related  parameter ***
+vth0 = -0.283174+dvth0_p_cap      lvth0 = 1.786965E-9+dlvth0_p_cap  wvth0 = 6.126582E-9+dwvth0_p_cap
+pvth0 = -5.066137E-15+dpvth0_p_cap phin = 0                      k1 = 0.25
+k2 = -1.04313E-2              k3 = -1.700953                k3b = 1.200306
+w0 = 1.585076E-7              lpe0 = 7.519925E-8            lpeb = 5.608072E-8
+dvtp0 = 2.2E-6                dvtp1 = 0.2                   dvt0 = 0.20341
+dvt1 = 0.95146                dvt2 = 0.01                   dvt0w = 0
+dvt1w = 5.366499E6            dvt2w = 0
//*** mobility related parameter ***
+u0 = 0.021425+du0_p_cap           lu0 = -3.816416E-10+dlu0_p_cap    wu0 = -7.690157E-10+dwu0_p_cap
+pu0 = 4.404327E-16+dpu0_p_cap     ua = 1.133123E-11             wua = 6.075688E-19
+ub = 1.348428E-18             lub = -1.012252E-25           wub = -1.81007E-25
+pub = 9.901996E-32            uc = 7.461729E-11             luc = -3.443875E-17
+wuc = -2.966719E-17           puc = 1.369254E-23            ud = 0
+vsat = 1.177315E5+dvsat_p_cap     a0 = 2.362624                 ags = 1.161347
+lags = 8.667644E-7            wags = -6.929268E-8           pags = 6.647902E-14
+b0 = 0                        b1 = 0                        keta = -0.095458
+wketa = 4.962415E-9           a1 = 0                        a2 = 1
+rdsw = 327.6                  prwb = -0.249981              prwg = 0.25
+wr = 1
//*** subthreshold related parameter ***
+voff = -4.50565E-2            lvoff = 3.491025E-9           wvoff = 5.472125E-9
+pvoff = -4.723235E-15         voffl = -6.036214E-9          minv = 0
+nfactor = 0.334016            lnfactor = 6.276227E-8        wnfactor = -3.591965E-8
+pnfactor = 1.103791E-14       eta0 = 3.11538E-2             etab = -2.38505E-2
+dsub = 1.2725                 cit = 1E-4                    cdsc = 0
+cdscb = 0                     cdscd = 0
//*** output resistance related parameter ***
+pclm = 0.627258               pdiblc1 = 0                   pdiblc2 = 0.011114
+lpdiblc2 = 2.809289E-10       wpdiblc2 = -9.036998E-11      ppdiblc2 = 1.180422E-16
+pdiblcb = 0                   drout = 1.132692              pscbe1 = 9.264E8
+pscbe2 = 1E-20                pvag = 1.425                  delta = 0.02
+fprout = 390.234144           pdits = 5.042617E-3           pditsl = 100
+pditsd = 0                    alpha0 = 0                    alpha1 = 0.06
+beta0 = 13.5                  agidl = 9E-8                  bgidl = 3.404E9
+cgidl = 0.5                   egidl = 0.15
//*** gate dielectric tunneling current ***
+aigbacc = 0.012               bigbacc = 3.49E-3             cigbacc = 0.131
+nigbacc = 5.2                 aigbinv = 0.347               bigbinv = 0.0312
+cigbinv = 6.1E-3              eigbinv = 1.1                 nigbinv = 1
+aigc = 7.12E-3                bigc = 6.31E-4                cigc = 0
+aigsd = 5.9E-3                bigsd = 2.48E-4               cigsd = 0.032
+dlcig = 2.52E-9               nigc = 2.28                   poxedge = 1
+pigcd = 2.28                  ntox = 1                      toxref = 3E-9
//*** capacitance parameter ***
+xpart = 1                     cgso = 3.1E-11+dcgso_p_cap        cgdo = 3.1E-11+dcgdo_p_cap
+cgbo = 0                      ckappas = 0.6                 ckappad = 0.6
+cf = 1.18E-10                 clc = 1E-7                    cle = 0.6
+dlc = 0                 dwc = 0                       noff = 2.5
+voffcv = -0.0486              acde = 1.2                    moin = 8
+cgsl = 0.54E-10+dcgsl_p_cap       cgdl = 0.54E-10+dcgdl_p_cap
//*** souce/drain junction diode model parameter **
+ijthsrev = 0.01               ijthsfwd = 0.01               xjbvs = 1
+bvs = 10                      jss = 1.51E-7                 jsws = 3.98E-13
+jswgs = 2.47E-12              cjs = 9.98E-4+dcj_p_cap           mjs = 0.34
+mjsws = 0.012                 cjsws = 6.21E-11+dcjsw_p_cap      cjswgs = 2.53E-10+dcjswg_p_cap
+mjswgs = 0.86                 pbs = 0.75                    pbsws = 0.49
+pbswgs = 0.71
//** rf model related parameter ***
+xrcrg1 = 12                   xrcrg2 = 1                    rbpb = 50
+rbpd = 50                     rbps = 50                     rbdb = 50
+rbsb = 50                     gbmin = 1E-12
//*** stress effect related parameter ***
+saref = 6.1E-7                sbref = 6.1E-7                wlod = 2.86E-7
+ku0 = 1E-7                    kvsat = -0.386                kvth0 = 2E-10
+tku0 = 0.24                   llodku0 = 1                   wlodku0 = 1
+llodvth = 1.8                 wlodvth = 1                   lku0 = 1.871E-7
+wku0 = 2.4E-7                 pku0 = -3.24E-14              lkvth0 = 2.4E-10
+wkvth0 = 1.8E-10              pkvth0 = 0                    stk2 = 0
+lodk2 = 1.9                   steta0 = 0                    lodeta0 = 1
//*** temperature coefficient ***
+tnom = 25                     ute = -1.524                  kt1 = -0.229
+kt1l = 0                      kt2 = -0.01232                ua1 = 4.549E-9
+ub1 = -5.441E-18              uc1 = -5E-11                  at = 4.00001E4
+prt = 0                       njs = 1                       xtis = 3
+tpb = 1.9E-3                  tpbsw = 1.9E-3                tpbswg = 1.9E-3
+tcj = 7.98E-4                 tcjsw = 2.4E-4                tcjswg = 4.77E-3
//*** well proximity effect model parameters ***
+web = -220                    wec = -3E3                    kvth0we = -3.197498E-3
+k2we = 3E-4                   ku0we = -3.482487E-3          scref = 1E-6
9:type=p  minr=1e-60
//*** flag parameter ***
+version = 4.3                 binunit = 2                   mobmod = 0
+capmod = 2                    rdsmod = 0                    igcmod = 1
+igbmod = 1                    rbodymod = 0                  trnqsmod = 0
+acnqsmod = 0                  fnoimod = 1                   tnoimod = 0
+diomod = 1                    permod = 1                    rgatemod = 0
+wpemod = 0
//*** geometry range parameter ***
+lmin = 5E-7                   lmax = 1E-6                   wmin = 1E-6
+wmax = 2E-6
//*** process parameter ***
+epsrox = 3.9                  toxe = tox_p_cap                  toxm = tox_p_cap
+dtox = 3.29E-10               xj = 1.7E-7                   ndep = 8.5E17
+ngate = 8E19                  nsd = 1E20                    rsh = 9.68
+rshg = 0.1
//*** dw and dl parameter ***
+wint = 1.089287E-8            wl = 0                        wln = 1
+ww = 0                        wwn = 1                       wwl = 0
+lint = 2E-24                  ll = 0                        lln = 1
+lw = 0                        lwn = 1                       lwl = 0
+llc = 0                       lwc = 0                       lwlc = 0
+wlc = 0                       wwc = 0                       wwlc = 0
+dwg = 0                       dwb = 0                       xl = 0+dxl_p_cap
+xw = 0+dxw_p_cap
//*** flicker noise model parameter ***
+noia = 1.45E42                noib = 3.57E26                noic = 2E10
+em = 2.1E7                    ef = 1.147
//***layout-dependent parasitics model parameter ***
+dmcg = 8.5E-8                 dmci = 8.5E-8                 dmdg = 0
+dmcgt = 0                     dwj = 0                       xgw = 0
+xgl = 0                       ngcon = 1
//*** vth related  parameter ***
+vth0 = -0.279875+dvth0_p_cap      lvth0 = -1.512547E-9+dlvth0_p_cap wvth0 = 1.197838E-9+dwvth0_p_cap
+pvth0 = -1.373933E-16+dpvth0_p_cap phin = 0                      k1 = 0.25
+k2 = -1.04313E-2              k3 = -1.700953                k3b = 1.200306
+w0 = 1.585076E-7              lpe0 = 7.519925E-8            lpeb = 5.608072E-8
+dvtp0 = 2.2E-6                dvtp1 = 0.2                   dvt0 = 0.20341
+dvt1 = 0.95146                dvt2 = 0.01                   dvt0w = 0
+dvt1w = 5.366499E6            dvt2w = 0
//*** mobility related parameter ***
+u0 = 2.06527E-2+du0_p_cap         lu0 = 3.906769E-10+dlu0_p_cap     wu0 = -3.620605E-10+dwu0_p_cap
+pu0 = 3.347753E-17+dpu0_p_cap     ua = 1.133123E-11             wua = 6.075688E-19
+ub = 1.137011E-18             lub = 1.101924E-25            wub = -9.019776E-26
+pub = 8.210703E-33            uc = 5.923069E-11             luc = -1.905214E-17
+wuc = -3.461172E-17           puc = 1.863708E-23            ud = 0
+vsat = 1.177315E5+dvsat_p_cap     a0 = 3.067296                 la0 = -7.078375E-7
+wa0 = 4.025044E-9             pa0 = -9.288564E-16           ags = 1.085171
+lags = 9.429403E-7            wags = -3.135084E-8           pags = 2.853718E-14
+b0 = 0                        b1 = 0                        keta = -0.114329
+lketa = 1.887098E-8           wketa = 2.342227E-8           pketa = -1.845986E-14
+a1 = 0                        a2 = 1                        rdsw = 327.6
+prwb = -0.249981              prwg = 0.25                   wr = 1
//*** subthreshold related parameter ***
+voff = -4.02618E-2            lvoff = -1.303669E-9          wvoff = 1.083666E-9
+pvoff = -3.347753E-16         voffl = -6.036214E-9          minv = 0
+nfactor = 0.327794            lnfactor = 6.898403E-8        wnfactor = -3.056905E-8
+pnfactor = 5.68731E-15        eta0 = 3.11538E-2             etab = -2.38505E-2
+dsub = 1.2725                 cit = 1E-4                    cdsc = 0
+cdscb = 0                     cdscd = 0
//*** output resistance related parameter ***
+pclm = 0.627258               pdiblc1 = 0                   pdiblc2 = 1.17624E-2
+lpdiblc2 = -3.674811E-10      wpdiblc2 = 3.280024E-10       ppdiblc2 = -3.003302E-16
+pdiblcb = 0                   drout = 1.132692              pscbe1 = 9.264E8
+pscbe2 = 1E-20                pvag = 1.425                  delta = 0.02
+fprout = 390.234144           pdits = 5.042617E-3           pditsl = 100
+pditsd = 0                    alpha0 = 0                    alpha1 = 0.06
+beta0 = 13.5                  agidl = 9E-8                  bgidl = 3.404E9
+cgidl = 0.5                   egidl = 0.15
//*** gate dielectric tunneling current ***
+aigbacc = 0.012               bigbacc = 3.49E-3             cigbacc = 0.131
+nigbacc = 5.2                 aigbinv = 0.347               bigbinv = 0.0312
+cigbinv = 6.1E-3              eigbinv = 1.1                 nigbinv = 1
+aigc = 7.12E-3                bigc = 6.31E-4                cigc = 0
+aigsd = 5.9E-3                bigsd = 2.48E-4               cigsd = 0.032
+dlcig = 2.52E-9               nigc = 2.28                   poxedge = 1
+pigcd = 2.28                  ntox = 1                      toxref = 3E-9
//*** capacitance parameter ***
+xpart = 1                     cgso = 3.1E-11+dcgso_p_cap        cgdo = 3.1E-11+dcgdo_p_cap
+cgbo = 0                      ckappas = 0.6                 ckappad = 0.6
+cf = 1.18E-10                 clc = 1E-7                    cle = 0.6
+dlc = 0                 dwc = 0                       noff = 2.5
+voffcv = -0.0486              acde = 1.2                    moin = 8
+cgsl = 0.54E-10+dcgsl_p_cap       cgdl = 0.54E-10+dcgdl_p_cap
//*** souce/drain junction diode model parameter **
+ijthsrev = 0.01               ijthsfwd = 0.01               xjbvs = 1
+bvs = 10                      jss = 1.51E-7                 jsws = 3.98E-13
+jswgs = 2.47E-12              cjs = 9.98E-4+dcj_p_cap           mjs = 0.34
+mjsws = 0.012                 cjsws = 6.21E-11+dcjsw_p_cap      cjswgs = 2.53E-10+dcjswg_p_cap
+mjswgs = 0.86                 pbs = 0.75                    pbsws = 0.49
+pbswgs = 0.71
//** rf model related parameter ***
+xrcrg1 = 12                   xrcrg2 = 1                    rbpb = 50
+rbpd = 50                     rbps = 50                     rbdb = 50
+rbsb = 50                     gbmin = 1E-12
//*** stress effect related parameter ***
+saref = 6.1E-7                sbref = 6.1E-7                wlod = 2.86E-7
+ku0 = 1E-7                    kvsat = -0.386                kvth0 = 2E-10
+tku0 = 0.24                   llodku0 = 1                   wlodku0 = 1
+llodvth = 1.8                 wlodvth = 1                   lku0 = 1.871E-7
+wku0 = 2.4E-7                 pku0 = -3.24E-14              lkvth0 = 2.4E-10
+wkvth0 = 1.8E-10              pkvth0 = 0                    stk2 = 0
+lodk2 = 1.9                   steta0 = 0                    lodeta0 = 1
//*** temperature coefficient ***
+tnom = 25                     ute = -1.524                  kt1 = -0.229
+kt1l = 0                      kt2 = -0.01232                ua1 = 4.549E-9
+ub1 = -5.441E-18              uc1 = -5E-11                  at = 4.00001E4
+prt = 0                       njs = 1                       xtis = 3
+tpb = 1.9E-3                  tpbsw = 1.9E-3                tpbswg = 1.9E-3
+tcj = 7.98E-4                 tcjsw = 2.4E-4                tcjswg = 4.77E-3
//*** well proximity effect model parameters ***
+web = -220                    wec = -3E3                    kvth0we = -3.197498E-3
+k2we = 3E-4                   ku0we = -3.482487E-3          scref = 1E-6
10:type=p  minr=1e-60
//*** flag parameter ***
+version = 4.3                 binunit = 2                   mobmod = 0
+capmod = 2                    rdsmod = 0                    igcmod = 1
+igbmod = 1                    rbodymod = 0                  trnqsmod = 0
+acnqsmod = 0                  fnoimod = 1                   tnoimod = 0
+diomod = 1                    permod = 1                    rgatemod = 0
+wpemod = 0
//*** geometry range parameter ***
+lmin = 1E-7                   lmax = 5E-7                   wmin = 1E-6
+wmax = 2E-6
//*** process parameter ***
+epsrox = 3.9                  toxe = tox_p_cap                  toxm = tox_p_cap
+dtox = 3.29E-10               xj = 1.7E-7                   ndep = 8.5E17
+ngate = 8E19                  nsd = 1E20                    rsh = 9.68
+rshg = 0.1
//*** dw and dl parameter ***
+wint = 1.089287E-8            wl = 0                        wln = 1
+ww = 0                        wwn = 1                       wwl = 0
+lint = 2E-24                  ll = 0                        lln = 1
+lw = 0                        lwn = 1                       lwl = 0
+llc = 0                       lwc = 0                       lwlc = 0
+wlc = 0                       wwc = 0                       wwlc = 0
+dwg = 0                       dwb = 0                       xl = 0+dxl_p_cap
+xw = 0+dxw_p_cap
//*** flicker noise model parameter ***
+noia = 1.45E42                noib = 3.57E26                noic = 2E10
+em = 2.1E7                    ef = 1.147
//***layout-dependent parasitics model parameter ***
+dmcg = 8.5E-8                 dmci = 8.5E-8                 dmdg = 0
+dmcgt = 0                     dwj = 0                       xgw = 0
+xgl = 0                       ngcon = 1
//*** vth related  parameter ***
+vth0 = -0.276557+dvth0_p_cap      lvth0 = -3.171164E-9+dlvth0_p_cap wvth0 = 5.302222E-10+dwvth0_p_cap
+pvth0 = 1.964144E-16+dpvth0_p_cap phin = 0                      k1 = 0.25
+k2 = -9.413316E-3             lk2 = -5.089922E-10           wk2 = -1.768214E-10
+pk2 = 8.841068E-17            k3 = -1.700953                k3b = 1.200306
+w0 = 1.585076E-7              lpe0 = 7.519925E-8            lpeb = 5.608072E-8
+dvtp0 = 2.2E-6                dvtp1 = 0.2                   dvt0 = 0.20341
+dvt1 = 0.95146                dvt2 = 0.01                   dvt0w = 0
+dvt1w = 5.366499E6            dvt2w = 0
//*** mobility related parameter ***
+u0 = 2.11806E-2+du0_p_cap         lu0 = 1.267238E-10+dlu0_p_cap     wu0 = -1.927377E-10+dwu0_p_cap
+pu0 = -5.118386E-17+dpu0_p_cap    ua = 9.604491E-12             lua = 8.633694E-19
+wua = 2.296689E-18            pua = -8.445602E-25           ub = 1.255591E-18
+lub = 5.090223E-26            wub = -6.824337E-26           pub = -2.766492E-33
+uc = 2.11264E-11              wuc = 2.662431E-18            ud = 0
+vsat = 1.177315E5+dvsat_p_cap     a0 = 2.064277                 la0 = -2.063277E-7
+wa0 = 2.709164E-9             pa0 = -2.709164E-16           ags = 2.748222
+lags = 1.114146E-7            wags = 2.379469E-8            pags = 9.644141E-16
+b0 = 0                        b1 = 0                        keta = -0.074884
+lketa = -8.514476E-10         wketa = -2.675721E-8          pketa = 6.629882E-15
+a1 = 0                        a2 = 1                        rdsw = 327.6
+prwb = -0.249981              prwg = 0.25                   wr = 1
//*** subthreshold related parameter ***
+voff = -3.80642E-2            lvoff = -2.402455E-9          wvoff = 2.973792E-10
+pvoff = 5.836798E-17          voffl = -6.036214E-9          minv = 0
+nfactor = 0.409871            lnfactor = 2.794566E-8        wnfactor = -1.689116E-8
+pnfactor = -1.151637E-15      eta0 = 3.11538E-2             etab = -2.38505E-2
+dsub = 1.2725                 cit = 1E-4                    cdsc = 0
+cdscb = 0                     cdscd = 0
//*** output resistance related parameter ***
+pclm = 0.627258               pdiblc1 = 0                   pdiblc2 = 0.011319
+lpdiblc2 = -1.458055E-10      wpdiblc2 = -7.635344E-11      ppdiblc2 = -9.81523E-17
+pdiblcb = 0                   drout = 1.132692              pscbe1 = 9.264E8
+pscbe2 = 1E-20                pvag = 1.425                  delta = 0.02
+fprout = 390.234144           pdits = 5.042617E-3           pditsl = 100
+pditsd = 0                    alpha0 = 0                    alpha1 = 0.06
+beta0 = 13.5                  agidl = 9E-8                  bgidl = 3.404E9
+cgidl = 0.5                   egidl = 0.15
//*** gate dielectric tunneling current ***
+aigbacc = 0.012               bigbacc = 3.49E-3             cigbacc = 0.131
+nigbacc = 5.2                 aigbinv = 0.347               bigbinv = 0.0312
+cigbinv = 6.1E-3              eigbinv = 1.1                 nigbinv = 1
+aigc = 7.12E-3                bigc = 6.31E-4                cigc = 0
+aigsd = 5.9E-3                bigsd = 2.48E-4               cigsd = 0.032
+dlcig = 2.52E-9               nigc = 2.28                   poxedge = 1
+pigcd = 2.28                  ntox = 1                      toxref = 3E-9
//*** capacitance parameter ***
+xpart = 1                     cgso = 3.1E-11+dcgso_p_cap        cgdo = 3.1E-11+dcgdo_p_cap
+cgbo = 0                      ckappas = 0.6                 ckappad = 0.6
+cf = 1.18E-10                 clc = 1E-7                    cle = 0.6
+dlc = 0                 dwc = 0                       noff = 2.5
+voffcv = -0.0486              acde = 1.2                    moin = 8
+cgsl = 0.54E-10+dcgsl_p_cap       cgdl = 0.54E-10+dcgdl_p_cap
//*** souce/drain junction diode model parameter **
+ijthsrev = 0.01               ijthsfwd = 0.01               xjbvs = 1
+bvs = 10                      jss = 1.51E-7                 jsws = 3.98E-13
+jswgs = 2.47E-12              cjs = 9.98E-4+dcj_p_cap           mjs = 0.34
+mjsws = 0.012                 cjsws = 6.21E-11+dcjsw_p_cap      cjswgs = 2.53E-10+dcjswg_p_cap
+mjswgs = 0.86                 pbs = 0.75                    pbsws = 0.49
+pbswgs = 0.71
//** rf model related parameter ***
+xrcrg1 = 12                   xrcrg2 = 1                    rbpb = 50
+rbpd = 50                     rbps = 50                     rbdb = 50
+rbsb = 50                     gbmin = 1E-12
//*** stress effect related parameter ***
+saref = 6.1E-7                sbref = 6.1E-7                wlod = 2.86E-7
+ku0 = 1E-7                    kvsat = -0.386                kvth0 = 2E-10
+tku0 = 0.24                   llodku0 = 1                   wlodku0 = 1
+llodvth = 1.8                 wlodvth = 1                   lku0 = 1.871E-7
+wku0 = 2.4E-7                 pku0 = -3.24E-14              lkvth0 = 2.4E-10
+wkvth0 = 1.8E-10              pkvth0 = 0                    stk2 = 0
+lodk2 = 1.9                   steta0 = 0                    lodeta0 = 1
//*** temperature coefficient ***
+tnom = 25                     ute = -1.524                  kt1 = -0.229
+kt1l = 0                      kt2 = -0.01232                ua1 = 4.549E-9
+ub1 = -5.441E-18              uc1 = -5E-11                  at = 4.00001E4
+prt = 0                       njs = 1                       xtis = 3
+tpb = 1.9E-3                  tpbsw = 1.9E-3                tpbswg = 1.9E-3
+tcj = 7.98E-4                 tcjsw = 2.4E-4                tcjswg = 4.77E-3
//*** well proximity effect model parameters ***
+web = -220                    wec = -3E3                    kvth0we = -3.197498E-3
+k2we = 3E-4                   ku0we = -3.482487E-3          scref = 1E-6
11:type=p  minr=1e-60
//*** flag parameter ***
+version = 4.3                 binunit = 2                   mobmod = 0
+capmod = 2                    rdsmod = 0                    igcmod = 1
+igbmod = 1                    rbodymod = 0                  trnqsmod = 0
+acnqsmod = 0                  fnoimod = 1                   tnoimod = 0
+diomod = 1                    permod = 1                    rgatemod = 0
+wpemod = 0
//*** geometry range parameter ***
+lmin = 6E-8                   lmax = 1E-7                   wmin = 1E-6
+wmax = 2E-6
//*** process parameter ***
+epsrox = 3.9                  toxe = tox_p_cap                  toxm = tox_p_cap
+dtox = 3.29E-10               xj = 1.7E-7                   ndep = 8.5E17
+ngate = 8E19                  nsd = 1E20                    rsh = 9.68
+rshg = 0.1
//*** dw and dl parameter ***
+wint = 1.089287E-8            wl = 0                        wln = 1
+ww = 0                        wwn = 1                       wwl = 0
+lint = 2E-24                  ll = 0                        lln = 1
+lw = 0                        lwn = 1                       lwl = 0
+llc = 0                       lwc = 0                       lwlc = 0
+wlc = 0                       wwc = 0                       wwlc = 0
+dwg = 0                       dwb = 0                       xl = 0+dxl_p_cap
+xw = 0+dxw_p_cap
//*** flicker noise model parameter ***
+noia = 1.45E42                noib = 3.57E26                noic = 2E10
+em = 2.1E7                    ef = 1.147
//***layout-dependent parasitics model parameter ***
+dmcg = 8.5E-8                 dmci = 8.5E-8                 dmdg = 0
+dmcgt = 0                     dwj = 0                       xgw = 0
+xgl = 0                       ngcon = 1
//*** vth related  parameter ***
+vth0 = -0.318192+dvth0_p_cap      lvth0 = 9.923601E-10+dlvth0_p_cap wvth0 = 1.273562E-8+dwvth0_p_cap
+pvth0 = -1.024125E-15+dpvth0_p_cap phin = 0                      k1 = 0.25
+k2 = -2.426757E-3             lk2 = -1.207648E-9            wk2 = 8.521289E-10
+pk2 = -1.448435E-17           k3 = -1.700953                k3b = 1.200306
+w0 = 1.585076E-7              lpe0 = 7.519925E-8            lpeb = 5.608072E-8
+dvtp0 = 2.2E-6                dvtp1 = 0.2                   dvt0 = 0.20341
+dvt1 = 0.95146                dvt2 = 0.01                   dvt0w = 0
+dvt1w = 5.366499E6            dvt2w = 0
//*** mobility related parameter ***
+u0 = 0.018311+du0_p_cap           lu0 = 4.136891E-10+dlu0_p_cap     wu0 = 2.378464E-9+dwu0_p_cap
+pu0 = -3.083041E-16+dpu0_p_cap    ua = 1.823818E-11             wua = -6.148913E-18
+ub = 4.894937E-19             lub = 1.275119E-25            wub = 4.340809E-25
+pub = -5.299892E-32           uc = 2.11264E-11              wuc = 2.662431E-18
+ud = 0                        vsat = 1.225451E5+dvsat_p_cap     lvsat = -4.813637E-4
+wvsat = -4.91989E-2           pvsat = 4.919801E-9           a0 = 1E-3
+ags = 3.862368                wags = 3.343883E-8            b0 = 0
+b1 = 0                        keta = 2.37312E-3             lketa = -8.577166E-9
+wketa = 1.286805E-8           pketa = 2.667356E-15          a1 = 0
+a2 = 1                        rdsw = 327.6                  prwb = -0.249981
+prwg = 0.25                   wr = 1
//*** subthreshold related parameter ***
+voff = -8.70239E-2            lvoff = 2.493508E-9           wvoff = 6.358989E-9
+pvoff = -5.47793E-16          voffl = -6.036214E-9          minv = 0
+nfactor = 0.193012            lnfactor = 4.963147E-8        wnfactor = -7.955268E-9
+pnfactor = -2.045226E-15      eta0 = 3.11538E-2             etab = -2.38505E-2
+dsub = 1.2725                 cit = 1E-4                    cdsc = 0
+cdscb = 0                     cdscd = 0
//*** output resistance related parameter ***
+pclm = 0.627258               pdiblc1 = 0                   pdiblc2 = 1.32245E-2
+lpdiblc2 = -3.363508E-10      wpdiblc2 = -6.519285E-10      ppdiblc2 = -4.05948E-17
+pdiblcb = 0                   drout = 1.132692              pscbe1 = 9.264E8
+pscbe2 = 1E-20                pvag = 1.425                  delta = 0.02
+fprout = 390.234144           pdits = 5.042617E-3           pditsl = 100
+pditsd = 0                    alpha0 = 0                    alpha1 = 0.06
+beta0 = 13.5                  agidl = 9E-8                  bgidl = 3.404E9
+cgidl = 0.5                   egidl = 0.15
//*** gate dielectric tunneling current ***
+aigbacc = 0.012               bigbacc = 3.49E-3             cigbacc = 0.131
+nigbacc = 5.2                 aigbinv = 0.347               bigbinv = 0.0312
+cigbinv = 6.1E-3              eigbinv = 1.1                 nigbinv = 1
+aigc = 7.12E-3                bigc = 6.31E-4                cigc = 0
+aigsd = 5.9E-3                bigsd = 2.48E-4               cigsd = 0.032
+dlcig = 2.52E-9               nigc = 2.28                   poxedge = 1
+pigcd = 2.28                  ntox = 1                      toxref = 3E-9
//*** capacitance parameter ***
+xpart = 1                     cgso = 3.1E-11+dcgso_p_cap        cgdo = 3.1E-11+dcgdo_p_cap
+cgbo = 0                      ckappas = 0.6                 ckappad = 0.6
+cf = 1.18E-10                 clc = 1E-7                    cle = 0.6
+dlc = 0                 dwc = 0                       noff = 2.5
+voffcv = -0.0486              acde = 1.2                    moin = 8
+cgsl = 0.54E-10+dcgsl_p_cap       cgdl = 0.54E-10+dcgdl_p_cap
//*** souce/drain junction diode model parameter **
+ijthsrev = 0.01               ijthsfwd = 0.01               xjbvs = 1
+bvs = 10                      jss = 1.51E-7                 jsws = 3.98E-13
+jswgs = 2.47E-12              cjs = 9.98E-4+dcj_p_cap           mjs = 0.34
+mjsws = 0.012                 cjsws = 6.21E-11+dcjsw_p_cap      cjswgs = 2.53E-10+dcjswg_p_cap
+mjswgs = 0.86                 pbs = 0.75                    pbsws = 0.49
+pbswgs = 0.71
//** rf model related parameter ***
+xrcrg1 = 12                   xrcrg2 = 1                    rbpb = 50
+rbpd = 50                     rbps = 50                     rbdb = 50
+rbsb = 50                     gbmin = 1E-12
//*** stress effect related parameter ***
+saref = 6.1E-7                sbref = 6.1E-7                wlod = 2.86E-7
+ku0 = 1E-7                    kvsat = -0.386                kvth0 = 2E-10
+tku0 = 0.24                   llodku0 = 1                   wlodku0 = 1
+llodvth = 1.8                 wlodvth = 1                   lku0 = 1.871E-7
+wku0 = 2.4E-7                 pku0 = -3.24E-14              lkvth0 = 2.4E-10
+wkvth0 = 1.8E-10              pkvth0 = 0                    stk2 = 0
+lodk2 = 1.9                   steta0 = 0                    lodeta0 = 1
//*** temperature coefficient ***
+tnom = 25                     ute = -1.524                  kt1 = -0.229
+kt1l = 0                      kt2 = -0.01232                ua1 = 4.549E-9
+ub1 = -5.441E-18              uc1 = -5E-11                  at = 4.00001E4
+prt = 0                       njs = 1                       xtis = 3
+tpb = 1.9E-3                  tpbsw = 1.9E-3                tpbswg = 1.9E-3
+tcj = 7.98E-4                 tcjsw = 2.4E-4                tcjswg = 4.77E-3
//*** well proximity effect model parameters ***
+web = -220                    wec = -3E3                    kvth0we = -3.197498E-3
+k2we = 3E-4                   ku0we = -3.482487E-3          scref = 1E-6
12:type=p  minr=1e-60
//*** flag parameter ***
+version = 4.3                 binunit = 2                   mobmod = 0
+capmod = 2                    rdsmod = 0                    igcmod = 1
+igbmod = 1                    rbodymod = 0                  trnqsmod = 0
+acnqsmod = 0                  fnoimod = 1                   tnoimod = 0
+diomod = 1                    permod = 1                    rgatemod = 0
+wpemod = 0
//*** geometry range parameter ***
+lmin = 4E-8                   lmax = 6E-8                   wmin = 1E-6
+wmax = 2E-6
//*** process parameter ***
+epsrox = 3.9                  toxe = tox_p_cap                  toxm = tox_p_cap
+dtox = 3.29E-10               xj = 1.7E-7                   ndep = 8.5E17
+ngate = 8E19                  nsd = 1E20                    rsh = 9.68
+rshg = 0.1
//*** dw and dl parameter ***
+wint = 1.089287E-8            wl = 0                        wln = 1
+ww = 0                        wwn = 1                       wwl = 0
+lint = 2E-24                  ll = 0                        lln = 1
+lw = 0                        lwn = 1                       lwl = 0
+llc = 0                       lwc = 0                       lwlc = 0
+wlc = 0                       wwc = 0                       wwlc = 0
+dwg = 0                       dwb = 0                       xl = 0+dxl_p_cap
+xw = 0+dxw_p_cap
//*** flicker noise model parameter ***
+noia = 1.45E42                noib = 3.57E26                noic = 2E10
+em = 2.1E7                    ef = 1.147
//***layout-dependent parasitics model parameter ***
+dmcg = 8.5E-8                 dmci = 8.5E-8                 dmdg = 0
+dmcgt = 0                     dwj = 0                       xgw = 0
+xgl = 0                       ngcon = 1
//*** vth related  parameter ***
+vth0 = -0.372351+dvth0_p_cap      lvth0 = 4.241926E-9+dlvth0_p_cap  wvth0 = 1.849244E-8+dwvth0_p_cap
+pvth0 = -1.369535E-15+dpvth0_p_cap phin = 0                      k1 = 0.25
+k2 = -1.51879E-2              lk2 = -4.419773E-10           wk2 = -9.625274E-10
+pk2 = 9.439503E-17            k3 = -1.700953                k3b = 1.200306
+w0 = 1.585076E-7              lpe0 = 7.519925E-8            lpeb = 5.608072E-8
+dvtp0 = 2.2E-6                dvtp1 = 0.2                   dvt0 = 0.20341
+dvt1 = 0.95146                dvt2 = 0.01                   dvt0w = 0
+dvt1w = 5.366499E6            dvt2w = 0
//*** mobility related parameter ***
+u0 = 2.77783E-2+du0_p_cap         lu0 = -1.543481E-10+dlu0_p_cap    wu0 = -1.271445E-10+dwu0_p_cap
+pu0 = -1.579675E-16+dpu0_p_cap    ua = 1.823818E-11             lua = 0
+wua = -6.148913E-18           ub = 1.656104E-18             lub = 5.75153E-26
+wub = 4.328858E-26            pub = -2.955138E-32           uc = 2.11264E-11
+wuc = 2.662431E-18            ud = 0                        vsat = 1.289341E5+dvsat_p_cap
+lvsat = -8.647015E-4          wvsat = -1.93502E-2           pvsat = 3.12888E-9
+a0 = 1E-3                     ags = 3.862368                wags = 3.343883E-8
+b0 = 0                        b1 = 0                        keta = -0.216991
+lketa = 4.584702E-9           wketa = 3.694816E-7           pketa = -1.872946E-14
+a1 = 0                        a2 = 1                        rdsw = 327.6
+prwb = -0.249981              prwg = 0.25                   wr = 1
//*** subthreshold related parameter ***
+voff = -0.115477              lvoff = 4.200668E-9           wvoff = 9.120402E-9
+pvoff = -7.134778E-16         voffl = -6.036214E-9          minv = 0
+nfactor = 0.408082            lnfactor = 3.672732E-8        wnfactor = -1.681617E-8
+pnfactor = -1.513571E-15      eta0 = 3.11538E-2             etab = 0.156383
+letab = -1.081399E-8          wetab = -6.701428E-8          petab = 4.020857E-15
+dsub = 1.2725                 cit = 1E-4                    cdsc = 0
+cdscb = 0                     cdscd = 0
//*** output resistance related parameter ***
+pclm = 0.627258               pdiblc1 = 0                   pdiblc2 = 1.30818E-2
+lpdiblc2 = -3.277863E-10      wpdiblc2 = -4.179765E-9       ppdiblc2 = 1.710754E-16
+pdiblcb = 0                   drout = 1.132692              pscbe1 = 9.264E8
+pscbe2 = 1E-20                pvag = 1.425                  delta = 0.02
+fprout = 390.234144           pdits = 5.042617E-3           pditsl = 100
+pditsd = 0                    alpha0 = 0                    alpha1 = 0.06
+beta0 = 13.5                  agidl = 9E-8                  bgidl = 3.404E9
+cgidl = 0.5                   egidl = 0.15
//*** gate dielectric tunneling current ***
+aigbacc = 0.012               bigbacc = 3.49E-3             cigbacc = 0.131
+nigbacc = 5.2                 aigbinv = 0.347               bigbinv = 0.0312
+cigbinv = 6.1E-3              eigbinv = 1.1                 nigbinv = 1
+aigc = 7.12E-3                bigc = 6.31E-4                cigc = 0
+aigsd = 5.9E-3                bigsd = 2.48E-4               cigsd = 0.032
+dlcig = 2.52E-9               nigc = 2.28                   poxedge = 1
+pigcd = 2.28                  ntox = 1                      toxref = 3E-9
//*** capacitance parameter ***
+xpart = 1                     cgso = 3.1E-11+dcgso_p_cap        cgdo = 3.1E-11+dcgdo_p_cap
+cgbo = 0                      ckappas = 0.6                 ckappad = 0.6
+cf = 1.18E-10                 clc = 1E-7                    cle = 0.6
+dlc = 0                 dwc = 0                       noff = 2.5
+voffcv = -0.0486              acde = 1.2                    moin = 8
+cgsl = 0.54E-10+dcgsl_p_cap       cgdl = 0.54E-10+dcgdl_p_cap
//*** souce/drain junction diode model parameter **
+ijthsrev = 0.01               ijthsfwd = 0.01               xjbvs = 1
+bvs = 10                      jss = 1.51E-7                 jsws = 3.98E-13
+jswgs = 2.47E-12              cjs = 9.98E-4+dcj_p_cap           mjs = 0.34
+mjsws = 0.012                 cjsws = 6.21E-11+dcjsw_p_cap      cjswgs = 2.53E-10+dcjswg_p_cap
+mjswgs = 0.86                 pbs = 0.75                    pbsws = 0.49
+pbswgs = 0.71
//** rf model related parameter ***
+xrcrg1 = 12                   xrcrg2 = 1                    rbpb = 50
+rbpd = 50                     rbps = 50                     rbdb = 50
+rbsb = 50                     gbmin = 1E-12
//*** stress effect related parameter ***
+saref = 6.1E-7                sbref = 6.1E-7                wlod = 2.86E-7
+ku0 = 1E-7                    kvsat = -0.386                kvth0 = 2E-10
+tku0 = 0.24                   llodku0 = 1                   wlodku0 = 1
+llodvth = 1.8                 wlodvth = 1                   lku0 = 1.871E-7
+wku0 = 2.4E-7                 pku0 = -3.24E-14              lkvth0 = 2.4E-10
+wkvth0 = 1.8E-10              pkvth0 = 0                    stk2 = 0
+lodk2 = 1.9                   steta0 = 0                    lodeta0 = 1
//*** temperature coefficient ***
+tnom = 25                     ute = -1.524                  kt1 = -0.229
+kt1l = 0                      kt2 = -0.01232                ua1 = 4.549E-9
+ub1 = -5.441E-18              uc1 = -5E-11                  at = 4.00001E4
+prt = 0                       njs = 1                       xtis = 3
+tpb = 1.9E-3                  tpbsw = 1.9E-3                tpbswg = 1.9E-3
+tcj = 7.98E-4                 tcjsw = 2.4E-4                tcjswg = 4.77E-3
//*** well proximity effect model parameters ***
+web = -220                    wec = -3E3                    kvth0we = -3.197498E-3
+k2we = 3E-4                   ku0we = -3.482487E-3          scref = 1E-6
13:type=p  minr=1e-60
//*** flag parameter ***
+version = 4.3                 binunit = 2                   mobmod = 0
+capmod = 2                    rdsmod = 0                    igcmod = 1
+igbmod = 1                    rbodymod = 0                  trnqsmod = 0
+acnqsmod = 0                  fnoimod = 1                   tnoimod = 0
+diomod = 1                    permod = 1                    rgatemod = 0
+wpemod = 0
//*** geometry range parameter ***
+lmin = 2E-6                   lmax = 1E-5                   wmin = 5E-7
+wmax = 1E-6
//*** process parameter ***
+epsrox = 3.9                  toxe = tox_p_cap                  toxm = tox_p_cap
+dtox = 3.29E-10               xj = 1.7E-7                   ndep = 8.5E17
+ngate = 8E19                  nsd = 1E20                    rsh = 9.68
+rshg = 0.1
//*** dw and dl parameter ***
+wint = 1.089287E-8            wl = 0                        wln = 1
+ww = 0                        wwn = 1                       wwl = 0
+lint = 2E-24                  ll = 0                        lln = 1
+lw = 0                        lwn = 1                       lwl = 0
+llc = 0                       lwc = 0                       lwlc = 0
+wlc = 0                       wwc = 0                       wwlc = 0
+dwg = 0                       dwb = 0                       xl = 0+dxl_p_cap
+xw = 0+dxw_p_cap
//*** flicker noise model parameter ***
+noia = 1.45E42                noib = 3.57E26                noic = 2E10
+em = 2.1E7                    ef = 1.147
//***layout-dependent parasitics model parameter ***
+dmcg = 8.5E-8                 dmci = 8.5E-8                 dmdg = 0
+dmcgt = 0                     dwj = 0                       xgw = 0
+xgl = 0                       ngcon = 1
//*** vth related  parameter ***
+vth0 = -0.280565+dvth0_p_cap      lvth0 = 4.176975E-9+dlvth0_p_cap  wvth0 = 8.71504E-10+dwvth0_p_cap
+pvth0 = -1.997489E-15+dpvth0_p_cap phin = 0                      k1 = 0.25
+k2 = -7.847288E-3             lk2 = -5.840202E-9            wk2 = -8.219176E-11
+pk2 = 8.219176E-16            k3 = -1.700953                k3b = 1.200306
+w0 = 1.585076E-7              lpe0 = 7.519925E-8            lpeb = 5.608072E-8
+dvtp0 = 2.2E-6                dvtp1 = 0.2                   dvt0 = 0.20341
+dvt1 = 0.95146                dvt2 = 0.01                   dvt0w = 0
+dvt1w = 5.366499E6            dvt2w = 0
//*** mobility related parameter ***
+u0 = 0.020731+du0_p_cap           lu0 = -1.285098E-10+dlu0_p_cap    wu0 = 1.099321E-12+dwu0_p_cap
+pu0 = 1.052541E-17+dpu0_p_cap     ua = 1.109496E-11             lua = 8.573662E-18
+wua = 8.386878E-19            pua = -8.386878E-24           ub = 1.27088E-18
+lub = -6.928108E-26           wub = -7.457885E-26           pub = 6.633347E-33
+uc = 9.640722E-11             luc = -1.209172E-16           wuc = -2.252666E-17
+puc = 4.13755E-23             ud = 0                        vsat = 1.177315E5+dvsat_p_cap
+a0 = 2.755215                 la0 = -1.289492E-6            wa0 = -6.166534E-8
+pa0 = 6.166534E-13            ags = 1.230207                lags = 7.229842E-7
+wags = -3.047644E-8           pags = -5.225281E-15          b0 = 0
+b1 = 0                        keta = -0.124888              lketa = 7.982228E-8
+wketa = 1.379624E-8           pketa = -3.817215E-14         a1 = 0
+a2 = 1                        rdsw = 327.6                  prwb = -0.249981
+prwg = 0.25                   wr = 1
//*** subthreshold related parameter ***
+voff = -4.27781E-2            lvoff = 5.859945E-9           wvoff = 9.28809E-10
+pvoff = -2.411488E-15         voffl = -6.036214E-9          minv = 0
+nfactor = 0.325062            lnfactor = 6.586256E-8        wnfactor = -2.401828E-8
+pnfactor = 1.71915E-15        eta0 = 3.11538E-2             etab = -2.38505E-2
+dsub = 1.2725                 cit = 1E-4                    cdsc = 0
+cdscb = 0                     cdscd = 0
//*** output resistance related parameter ***
+pclm = 0.627258               pdiblc1 = 0                   pdiblc2 = 0.011707
+lpdiblc2 = -1.787639E-9       wpdiblc2 = -1.00085E-10       ppdiblc2 = 1.00085E-15
+pdiblcb = 0                   drout = 1.132692              pscbe1 = 9.264E8
+pscbe2 = 1E-20                pvag = 1.425                  delta = 0.02
+fprout = 390.234144           pdits = 5.042617E-3           pditsl = 100
+pditsd = 0                    alpha0 = 0                    alpha1 = 0.06
+beta0 = 13.5                  agidl = 9E-8                  bgidl = 3.404E9
+cgidl = 0.5                   egidl = 0.15
//*** gate dielectric tunneling current ***
+aigbacc = 0.012               bigbacc = 3.49E-3             cigbacc = 0.131
+nigbacc = 5.2                 aigbinv = 0.347               bigbinv = 0.0312
+cigbinv = 6.1E-3              eigbinv = 1.1                 nigbinv = 1
+aigc = 7.12E-3                bigc = 6.31E-4                cigc = 0
+aigsd = 5.9E-3                bigsd = 2.48E-4               cigsd = 0.032
+dlcig = 2.52E-9               nigc = 2.28                   poxedge = 1
+pigcd = 2.28                  ntox = 1                      toxref = 3E-9
//*** capacitance parameter ***
+xpart = 1                     cgso = 3.1E-11+dcgso_p_cap        cgdo = 3.1E-11+dcgdo_p_cap
+cgbo = 0                      ckappas = 0.6                 ckappad = 0.6
+cf = 1.18E-10                 clc = 1E-7                    cle = 0.6
+dlc = 0                 dwc = 0                       noff = 2.5
+voffcv = -0.0486              acde = 1.2                    moin = 8
+cgsl = 0.54E-10+dcgsl_p_cap       cgdl = 0.54E-10+dcgdl_p_cap
//*** souce/drain junction diode model parameter **
+ijthsrev = 0.01               ijthsfwd = 0.01               xjbvs = 1
+bvs = 10                      jss = 1.51E-7                 jsws = 3.98E-13
+jswgs = 2.47E-12              cjs = 9.98E-4+dcj_p_cap           mjs = 0.34
+mjsws = 0.012                 cjsws = 6.21E-11+dcjsw_p_cap      cjswgs = 2.53E-10+dcjswg_p_cap
+mjswgs = 0.86                 pbs = 0.75                    pbsws = 0.49
+pbswgs = 0.71
//** rf model related parameter ***
+xrcrg1 = 12                   xrcrg2 = 1                    rbpb = 50
+rbpd = 50                     rbps = 50                     rbdb = 50
+rbsb = 50                     gbmin = 1E-12
//*** stress effect related parameter ***
+saref = 6.1E-7                sbref = 6.1E-7                wlod = 2.86E-7
+ku0 = 1E-7                    kvsat = -0.386                kvth0 = 2E-10
+tku0 = 0.24                   llodku0 = 1                   wlodku0 = 1
+llodvth = 1.8                 wlodvth = 1                   lku0 = 1.871E-7
+wku0 = 2.4E-7                 pku0 = -3.24E-14              lkvth0 = 2.4E-10
+wkvth0 = 1.8E-10              pkvth0 = 0                    stk2 = 0
+lodk2 = 1.9                   steta0 = 0                    lodeta0 = 1
//*** temperature coefficient ***
+tnom = 25                     ute = -1.524                  kt1 = -0.229
+kt1l = 0                      kt2 = -0.01232                ua1 = 4.549E-9
+ub1 = -5.441E-18              uc1 = -5E-11                  at = 4.00001E4
+prt = 0                       njs = 1                       xtis = 3
+tpb = 1.9E-3                  tpbsw = 1.9E-3                tpbswg = 1.9E-3
+tcj = 7.98E-4                 tcjsw = 2.4E-4                tcjswg = 4.77E-3
//*** well proximity effect model parameters ***
+web = -220                    wec = -3E3                    kvth0we = -3.197498E-3
+k2we = 3E-4                   ku0we = -3.482487E-3          scref = 1E-6
14:type=p  minr=1e-60
//*** flag parameter ***
+version = 4.3                 binunit = 2                   mobmod = 0
+capmod = 2                    rdsmod = 0                    igcmod = 1
+igbmod = 1                    rbodymod = 0                  trnqsmod = 0
+acnqsmod = 0                  fnoimod = 1                   tnoimod = 0
+diomod = 1                    permod = 1                    rgatemod = 0
+wpemod = 0
//*** geometry range parameter ***
+lmin = 1E-6                   lmax = 2E-6                   wmin = 5E-7
+wmax = 1E-6
//*** process parameter ***
+epsrox = 3.9                  toxe = tox_p_cap                  toxm = tox_p_cap
+dtox = 3.29E-10               xj = 1.7E-7                   ndep = 8.5E17
+ngate = 8E19                  nsd = 1E20                    rsh = 9.68
+rshg = 0.1
//*** dw and dl parameter ***
+wint = 1.089287E-8            wl = 0                        wln = 1
+ww = 0                        wwn = 1                       wwl = 0
+lint = 2E-24                  ll = 0                        lln = 1
+lw = 0                        lwn = 1                       lwl = 0
+llc = 0                       lwc = 0                       lwlc = 0
+wlc = 0                       wwc = 0                       wwlc = 0
+dwg = 0                       dwb = 0                       xl = 0+dxl_p_cap
+xw = 0+dxw_p_cap
//*** flicker noise model parameter ***
+noia = 1.45E42                noib = 3.57E26                noic = 2E10
+em = 2.1E7                    ef = 1.147
//***layout-dependent parasitics model parameter ***
+dmcg = 8.5E-8                 dmci = 8.5E-8                 dmdg = 0
+dmcgt = 0                     dwj = 0                       xgw = 0
+xgl = 0                       ngcon = 1
//*** vth related  parameter ***
+vth0 = -0.276146+dvth0_p_cap      lvth0 = -4.662137E-9+dlvth0_p_cap wvth0 = -7.484736E-10+dwvth0_p_cap
+pvth0 = 1.242466E-15+dpvth0_p_cap phin = 0                      k1 = 0.25
+k2 = -1.07674E-2              wk2 = 3.28767E-10             k3 = -1.700953
+k3b = 1.200306                w0 = 1.585076E-7              lpe0 = 7.519925E-8
+lpeb = 5.608072E-8            dvtp0 = 2.2E-6                dvtp1 = 0.2
+dvt0 = 0.20341                dvt1 = 0.95146                dvt2 = 0.01
+dvt0w = 0                     dvt1w = 5.366499E6            dvt2w = 0
//*** mobility related parameter ***
+u0 = 2.06421E-2+du0_p_cap         lu0 = 4.928014E-11+dlu0_p_cap     wu0 = -3.087454E-12+dwu0_p_cap
+pu0 = 1.889896E-17+dpu0_p_cap     ua = 1.538179E-11             wua = -3.354751E-18
+ub = 1.278187E-18             lub = -8.3896E-26             wub = -1.122963E-25
+pub = 8.206826E-32            uc = 4.673321E-11             luc = -2.156918E-17
+wuc = -2.390578E-18           puc = 1.103344E-24            ud = 0
+vsat = 1.177315E5+dvsat_p_cap     a0 = 1.634615                 la0 = 9.517076E-7
+wa0 = 7.121483E-7             pa0 = -9.309739E-13           ags = 1.114189
+lags = 9.550194E-7            wags = -2.316245E-8           pags = -1.985326E-14
+b0 = 0                        b1 = 0                        keta = -8.49774E-2
+wketa = -5.289837E-9          a1 = 0                        a2 = 1
+rdsw = 327.6                  prwb = -0.249981              prwg = 0.25
+wr = 1
//*** subthreshold related parameter ***
+voff = -3.89808E-2            lvoff = -1.734509E-9          wvoff = -4.711641E-10
+pvoff = 3.884578E-16          voffl = -6.036214E-9          minv = 0
+nfactor = 0.319765            lnfactor = 7.64562E-8         wnfactor = -2.197986E-8
+pnfactor = -2.357692E-15      eta0 = 3.11538E-2             etab = -2.38505E-2
+dsub = 1.2725                 cit = 1E-4                    cdsc = 0
+cdscb = 0                     cdscd = 0
//*** output resistance related parameter ***
+pclm = 0.627258               pdiblc1 = 0                   pdiblc2 = 9.704885E-3
+lpdiblc2 = 2.216519E-9        wpdiblc2 = 1.28803E-9         ppdiblc2 = -1.775379E-15
+pdiblcb = 0                   drout = 1.132692              pscbe1 = 9.264E8
+pscbe2 = 1E-20                pvag = 1.425                  delta = 0.02
+fprout = 390.234144           pdits = 5.042617E-3           pditsl = 100
+pditsd = 0                    alpha0 = 0                    alpha1 = 0.06
+beta0 = 13.5                  agidl = 9E-8                  bgidl = 3.404E9
+cgidl = 0.5                   egidl = 0.15
//*** gate dielectric tunneling current ***
+aigbacc = 0.012               bigbacc = 3.49E-3             cigbacc = 0.131
+nigbacc = 5.2                 aigbinv = 0.347               bigbinv = 0.0312
+cigbinv = 6.1E-3              eigbinv = 1.1                 nigbinv = 1
+aigc = 7.12E-3                bigc = 6.31E-4                cigc = 0
+aigsd = 5.9E-3                bigsd = 2.48E-4               cigsd = 0.032
+dlcig = 2.52E-9               nigc = 2.28                   poxedge = 1
+pigcd = 2.28                  ntox = 1                      toxref = 3E-9
//*** capacitance parameter ***
+xpart = 1                     cgso = 3.1E-11+dcgso_p_cap        cgdo = 3.1E-11+dcgdo_p_cap
+cgbo = 0                      ckappas = 0.6                 ckappad = 0.6
+cf = 1.18E-10                 clc = 1E-7                    cle = 0.6
+dlc = 0                 dwc = 0                       noff = 2.5
+voffcv = -0.0486              acde = 1.2                    moin = 8
+cgsl = 0.54E-10+dcgsl_p_cap       cgdl = 0.54E-10+dcgdl_p_cap
//*** souce/drain junction diode model parameter **
+ijthsrev = 0.01               ijthsfwd = 0.01               xjbvs = 1
+bvs = 10                      jss = 1.51E-7                 jsws = 3.98E-13
+jswgs = 2.47E-12              cjs = 9.98E-4+dcj_p_cap           mjs = 0.34
+mjsws = 0.012                 cjsws = 6.21E-11+dcjsw_p_cap      cjswgs = 2.53E-10+dcjswg_p_cap
+mjswgs = 0.86                 pbs = 0.75                    pbsws = 0.49
+pbswgs = 0.71
//** rf model related parameter ***
+xrcrg1 = 12                   xrcrg2 = 1                    rbpb = 50
+rbpd = 50                     rbps = 50                     rbdb = 50
+rbsb = 50                     gbmin = 1E-12
//*** stress effect related parameter ***
+saref = 6.1E-7                sbref = 6.1E-7                wlod = 2.86E-7
+ku0 = 1E-7                    kvsat = -0.386                kvth0 = 2E-10
+tku0 = 0.24                   llodku0 = 1                   wlodku0 = 1
+llodvth = 1.8                 wlodvth = 1                   lku0 = 1.871E-7
+wku0 = 2.4E-7                 pku0 = -3.24E-14              lkvth0 = 2.4E-10
+wkvth0 = 1.8E-10              pkvth0 = 0                    stk2 = 0
+lodk2 = 1.9                   steta0 = 0                    lodeta0 = 1
//*** temperature coefficient ***
+tnom = 25                     ute = -1.524                  kt1 = -0.229
+kt1l = 0                      kt2 = -0.01232                ua1 = 4.549E-9
+ub1 = -5.441E-18              uc1 = -5E-11                  at = 4.00001E4
+prt = 0                       njs = 1                       xtis = 3
+tpb = 1.9E-3                  tpbsw = 1.9E-3                tpbswg = 1.9E-3
+tcj = 7.98E-4                 tcjsw = 2.4E-4                tcjswg = 4.77E-3
//*** well proximity effect model parameters ***
+web = -220                    wec = -3E3                    kvth0we = -3.197498E-3
+k2we = 3E-4                   ku0we = -3.482487E-3          scref = 1E-6
15:type=p  minr=1e-60
//*** flag parameter ***
+version = 4.3                 binunit = 2                   mobmod = 0
+capmod = 2                    rdsmod = 0                    igcmod = 1
+igbmod = 1                    rbodymod = 0                  trnqsmod = 0
+acnqsmod = 0                  fnoimod = 1                   tnoimod = 0
+diomod = 1                    permod = 1                    rgatemod = 0
+wpemod = 0
//*** geometry range parameter ***
+lmin = 5E-7                   lmax = 1E-6                   wmin = 5E-7
+wmax = 1E-6
//*** process parameter ***
+epsrox = 3.9                  toxe = tox_p_cap                  toxm = tox_p_cap
+dtox = 3.29E-10               xj = 1.7E-7                   ndep = 8.5E17
+ngate = 8E19                  nsd = 1E20                    rsh = 9.68
+rshg = 0.1
//*** dw and dl parameter ***
+wint = 1.089287E-8            wl = 0                        wln = 1
+ww = 0                        wwn = 1                       wwl = 0
+lint = 2E-24                  ll = 0                        lln = 1
+lw = 0                        lwn = 1                       lwl = 0
+llc = 0                       lwc = 0                       lwlc = 0
+wlc = 0                       wwc = 0                       wwlc = 0
+dwg = 0                       dwb = 0                       xl = 0+dxl_p_cap
+xw = 0+dxw_p_cap
//*** flicker noise model parameter ***
+noia = 1.45E42                noib = 3.57E26                noic = 2E10
+em = 2.1E7                    ef = 1.147
//***layout-dependent parasitics model parameter ***
+dmcg = 8.5E-8                 dmci = 8.5E-8                 dmdg = 0
+dmcgt = 0                     dwj = 0                       xgw = 0
+xgl = 0                       ngcon = 1
//*** vth related  parameter ***
+vth0 = -0.28002+dvth0_p_cap       lvth0 = -7.883886E-10+dlvth0_p_cap wvth0 = 1.339768E-9+dwvth0_p_cap
+pvth0 = -8.457752E-16+dpvth0_p_cap phin = 0                      k1 = 0.25
+k2 = -1.07674E-2              wk2 = 3.28767E-10             k3 = -1.700953
+k3b = 1.200306                w0 = 1.585076E-7              lpe0 = 7.519925E-8
+lpeb = 5.608072E-8            dvtp0 = 2.2E-6                dvtp1 = 0.2
+dvt0 = 0.20341                dvt1 = 0.95146                dvt2 = 0.01
+dvt0w = 0                     dvt1w = 5.366499E6            dvt2w = 0
//*** mobility related parameter ***
+u0 = 2.02118E-2+du0_p_cap         lu0 = 4.795121E-10+dlu0_p_cap     wu0 = 6.923381E-11+dwu0_p_cap
+pu0 = -5.34223E-17+dpu0_p_cap     ua = 1.538179E-11             wua = -3.354751E-18
+ub = 1.051241E-18             lub = 1.430505E-25            wub = -6.296534E-27
+pub = -2.393151E-32           uc = 2.516403E-11             wuc = -1.287234E-18
+ud = 0                        vsat = 1.177315E5+dvsat_p_cap     a0 = 3.36222
+la0 = -7.758967E-7            wa0 = -2.844733E-7            pa0 = 6.564769E-14
+ags = 1.075988                lags = 9.932204E-7            wags = -2.236813E-8
+pags = -2.064758E-14          b0 = 0                        b1 = 0
+keta = -8.49774E-2            wketa = -5.289837E-9          a1 = 0
+a2 = 1                        rdsw = 327.6                  prwb = -0.249981
+prwg = 0.25                   wr = 1
//*** subthreshold related parameter ***
+voff = -0.039418              lvoff = -1.297377E-9          wvoff = 2.582234E-10
+pvoff = -3.409297E-16         voffl = -6.036214E-9          minv = 0
+nfactor = 0.322906            lnfactor = 7.331554E-8        wnfactor = -2.578772E-8
+pnfactor = 1.450168E-15       eta0 = 3.11538E-2             etab = -2.38505E-2
+dsub = 1.2725                 cit = 1E-4                    cdsc = 0
+cdscb = 0                     cdscd = 0
//*** output resistance related parameter ***
+pclm = 0.627258               pdiblc1 = 0                   pdiblc2 = 1.27919E-2
+lpdiblc2 = -8.704722E-10      wpdiblc2 = -6.790527E-10      ppdiblc2 = 1.917028E-16
+pdiblcb = 0                   drout = 1.132692              pscbe1 = 9.264E8
+pscbe2 = 1E-20                pvag = 1.425                  delta = 0.02
+fprout = 390.234144           pdits = 5.042617E-3           pditsl = 100
+pditsd = 0                    alpha0 = 0                    alpha1 = 0.06
+beta0 = 13.5                  agidl = 9E-8                  bgidl = 3.404E9
+cgidl = 0.5                   egidl = 0.15
//*** gate dielectric tunneling current ***
+aigbacc = 0.012               bigbacc = 3.49E-3             cigbacc = 0.131
+nigbacc = 5.2                 aigbinv = 0.347               bigbinv = 0.0312
+cigbinv = 6.1E-3              eigbinv = 1.1                 nigbinv = 1
+aigc = 7.12E-3                bigc = 6.31E-4                cigc = 0
+aigsd = 5.9E-3                bigsd = 2.48E-4               cigsd = 0.032
+dlcig = 2.52E-9               nigc = 2.28                   poxedge = 1
+pigcd = 2.28                  ntox = 1                      toxref = 3E-9
//*** capacitance parameter ***
+xpart = 1                     cgso = 3.1E-11+dcgso_p_cap        cgdo = 3.1E-11+dcgdo_p_cap
+cgbo = 0                      ckappas = 0.6                 ckappad = 0.6
+cf = 1.18E-10                 clc = 1E-7                    cle = 0.6
+dlc = 0                 dwc = 0                       noff = 2.5
+voffcv = -0.0486              acde = 1.2                    moin = 8
+cgsl = 0.54E-10+dcgsl_p_cap       cgdl = 0.54E-10+dcgdl_p_cap
//*** souce/drain junction diode model parameter **
+ijthsrev = 0.01               ijthsfwd = 0.01               xjbvs = 1
+bvs = 10                      jss = 1.51E-7                 jsws = 3.98E-13
+jswgs = 2.47E-12              cjs = 9.98E-4+dcj_p_cap           mjs = 0.34
+mjsws = 0.012                 cjsws = 6.21E-11+dcjsw_p_cap      cjswgs = 2.53E-10+dcjswg_p_cap
+mjswgs = 0.86                 pbs = 0.75                    pbsws = 0.49
+pbswgs = 0.71
//** rf model related parameter ***
+xrcrg1 = 12                   xrcrg2 = 1                    rbpb = 50
+rbpd = 50                     rbps = 50                     rbdb = 50
+rbsb = 50                     gbmin = 1E-12
//*** stress effect related parameter ***
+saref = 6.1E-7                sbref = 6.1E-7                wlod = 2.86E-7
+ku0 = 1E-7                    kvsat = -0.386                kvth0 = 2E-10
+tku0 = 0.24                   llodku0 = 1                   wlodku0 = 1
+llodvth = 1.8                 wlodvth = 1                   lku0 = 1.871E-7
+wku0 = 2.4E-7                 pku0 = -3.24E-14              lkvth0 = 2.4E-10
+wkvth0 = 1.8E-10              pkvth0 = 0                    stk2 = 0
+lodk2 = 1.9                   steta0 = 0                    lodeta0 = 1
//*** temperature coefficient ***
+tnom = 25                     ute = -1.524                  kt1 = -0.229
+kt1l = 0                      kt2 = -0.01232                ua1 = 4.549E-9
+ub1 = -5.441E-18              uc1 = -5E-11                  at = 4.00001E4
+prt = 0                       njs = 1                       xtis = 3
+tpb = 1.9E-3                  tpbsw = 1.9E-3                tpbswg = 1.9E-3
+tcj = 7.98E-4                 tcjsw = 2.4E-4                tcjswg = 4.77E-3
//*** well proximity effect model parameters ***
+web = -220                    wec = -3E3                    kvth0we = -3.197498E-3
+k2we = 3E-4                   ku0we = -3.482487E-3          scref = 1E-6
16:type=p  minr=1e-60
//*** flag parameter ***
+version = 4.3                 binunit = 2                   mobmod = 0
+capmod = 2                    rdsmod = 0                    igcmod = 1
+igbmod = 1                    rbodymod = 0                  trnqsmod = 0
+acnqsmod = 0                  fnoimod = 1                   tnoimod = 0
+diomod = 1                    permod = 1                    rgatemod = 0
+wpemod = 0
//*** geometry range parameter ***
+lmin = 1E-7                   lmax = 5E-7                   wmin = 5E-7
+wmax = 1E-6
//*** process parameter ***
+epsrox = 3.9                  toxe = tox_p_cap                  toxm = tox_p_cap
+dtox = 3.29E-10               xj = 1.7E-7                   ndep = 8.5E17
+ngate = 8E19                  nsd = 1E20                    rsh = 9.68
+rshg = 0.1
//*** dw and dl parameter ***
+wint = 1.089287E-8            wl = 0                        wln = 1
+ww = 0                        wwn = 1                       wwl = 0
+lint = 2E-24                  ll = 0                        lln = 1
+lw = 0                        lwn = 1                       lwl = 0
+llc = 0                       lwc = 0                       lwlc = 0
+wlc = 0                       wwc = 0                       wwlc = 0
+dwg = 0                       dwb = 0                       xl = 0+dxl_p_cap
+xw = 0+dxw_p_cap
//*** flicker noise model parameter ***
+noia = 1.45E42                noib = 3.57E26                noic = 2E10
+em = 2.1E7                    ef = 1.147
//***layout-dependent parasitics model parameter ***
+dmcg = 8.5E-8                 dmci = 8.5E-8                 dmdg = 0
+dmcgt = 0                     dwj = 0                       xgw = 0
+xgl = 0                       ngcon = 1
//*** vth related  parameter ***
+vth0 = -0.275439+dvth0_p_cap      lvth0 = -3.07881E-9+dlvth0_p_cap  wvth0 = -5.639281E-10+dwvth0_p_cap
+pvth0 = 1.060727E-16+dpvth0_p_cap phin = 0                      k1 = 0.25
+k2 = -9.927653E-3             lk2 = -4.198678E-10           wk2 = 3.263111E-10
+pk2 = 1.227965E-18            k3 = -1.700953                k3b = 1.200306
+w0 = 1.585076E-7              lpe0 = 7.519925E-8            lpeb = 5.608072E-8
+dvtp0 = 2.2E-6                dvtp1 = 0.2                   dvt0 = 0.20341
+dvt1 = 0.95146                dvt2 = 0.01                   dvt0w = 0
+dvt1w = 5.366499E6            dvt2w = 0
//*** mobility related parameter ***
+u0 = 2.09695E-2+du0_p_cap         lu0 = 1.006898E-10+dlu0_p_cap     wu0 = 1.382337E-11+dwu0_p_cap
+pu0 = -2.571709E-17+dpu0_p_cap    ua = 1.538179E-11             wua = -3.354751E-18
+ub = 1.237041E-18             lub = 5.015041E-26            wub = -5.009744E-26
+pub = -2.031053E-33           uc = 2.516403E-11             wuc = -1.287234E-18
+ud = 0                        vsat = 1.177315E5+dvsat_p_cap     a0 = 2.262783
+la0 = -2.261783E-7            wa0 = -1.914724E-7            pa0 = 1.914724E-14
+ags = 2.622622                lags = 2.199035E-7            wags = 1.466587E-7
+pags = -1.05161E-13           b0 = 0                        b1 = 0
+keta = -0.097409              lketa = 6.215849E-9           wketa = -4.722939E-9
+pketa = -2.834493E-16         a1 = 0                        a2 = 1
+rdsw = 327.6                  prwb = -0.249981              prwg = 0.25
+wr = 1
//*** subthreshold related parameter ***
+voff = -0.037344              lvoff = -2.334359E-9          wvoff = -4.071463E-10
+pvoff = -8.244905E-18         voffl = -6.036214E-9          minv = 0
+nfactor = 0.413193            lnfactor = 2.817217E-8        wnfactor = -2.014096E-8
+pnfactor = -1.373215E-15      eta0 = 3.11538E-2             etab = -2.38505E-2
+dsub = 1.2725                 cit = 1E-4                    cdsc = 0
+cdscb = 0                     cdscd = 0
//*** output resistance related parameter ***
+pclm = 0.627258               pdiblc1 = 0                   pdiblc2 = 1.14519E-2
+lpdiblc2 = -2.004746E-10      wpdiblc2 = -2.062987E-10      ppdiblc2 = -4.467417E-17
+pdiblcb = 0                   drout = 1.132692              pscbe1 = 9.264E8
+pscbe2 = 1E-20                pvag = 1.425                  delta = 0.02
+fprout = 390.234144           pdits = 5.042617E-3           pditsl = 100
+pditsd = 0                    alpha0 = 0                    alpha1 = 0.06
+beta0 = 13.5                  agidl = 9E-8                  bgidl = 3.404E9
+cgidl = 0.5                   egidl = 0.15
//*** gate dielectric tunneling current ***
+aigbacc = 0.012               bigbacc = 3.49E-3             cigbacc = 0.131
+nigbacc = 5.2                 aigbinv = 0.347               bigbinv = 0.0312
+cigbinv = 6.1E-3              eigbinv = 1.1                 nigbinv = 1
+aigc = 7.12E-3                bigc = 6.31E-4                cigc = 0
+aigsd = 5.9E-3                bigsd = 2.48E-4               cigsd = 0.032
+dlcig = 2.52E-9               nigc = 2.28                   poxedge = 1
+pigcd = 2.28                  ntox = 1                      toxref = 3E-9
//*** capacitance parameter ***
+xpart = 1                     cgso = 3.1E-11+dcgso_p_cap        cgdo = 3.1E-11+dcgdo_p_cap
+cgbo = 0                      ckappas = 0.6                 ckappad = 0.6
+cf = 1.18E-10                 clc = 1E-7                    cle = 0.6
+dlc = 0                 dwc = 0                       noff = 2.5
+voffcv = -0.0486              acde = 1.2                    moin = 8
+cgsl = 0.54E-10+dcgsl_p_cap       cgdl = 0.54E-10+dcgdl_p_cap
//*** souce/drain junction diode model parameter **
+ijthsrev = 0.01               ijthsfwd = 0.01               xjbvs = 1
+bvs = 10                      jss = 1.51E-7                 jsws = 3.98E-13
+jswgs = 2.47E-12              cjs = 9.98E-4+dcj_p_cap           mjs = 0.34
+mjsws = 0.012                 cjsws = 6.21E-11+dcjsw_p_cap      cjswgs = 2.53E-10+dcjswg_p_cap
+mjswgs = 0.86                 pbs = 0.75                    pbsws = 0.49
+pbswgs = 0.71
//** rf model related parameter ***
+xrcrg1 = 12                   xrcrg2 = 1                    rbpb = 50
+rbpd = 50                     rbps = 50                     rbdb = 50
+rbsb = 50                     gbmin = 1E-12
//*** stress effect related parameter ***
+saref = 6.1E-7                sbref = 6.1E-7                wlod = 2.86E-7
+ku0 = 1E-7                    kvsat = -0.386                kvth0 = 2E-10
+tku0 = 0.24                   llodku0 = 1                   wlodku0 = 1
+llodvth = 1.8                 wlodvth = 1                   lku0 = 1.871E-7
+wku0 = 2.4E-7                 pku0 = -3.24E-14              lkvth0 = 2.4E-10
+wkvth0 = 1.8E-10              pkvth0 = 0                    stk2 = 0
+lodk2 = 1.9                   steta0 = 0                    lodeta0 = 1
//*** temperature coefficient ***
+tnom = 25                     ute = -1.524                  kt1 = -0.229
+kt1l = 0                      kt2 = -0.01232                ua1 = 4.549E-9
+ub1 = -5.441E-18              uc1 = -5E-11                  at = 4.00001E4
+prt = 0                       njs = 1                       xtis = 3
+tpb = 1.9E-3                  tpbsw = 1.9E-3                tpbswg = 1.9E-3
+tcj = 7.98E-4                 tcjsw = 2.4E-4                tcjswg = 4.77E-3
//*** well proximity effect model parameters ***
+web = -220                    wec = -3E3                    kvth0we = -3.197498E-3
+k2we = 3E-4                   ku0we = -3.482487E-3          scref = 1E-6
17:type=p  minr=1e-60
//*** flag parameter ***
+version = 4.3                 binunit = 2                   mobmod = 0
+capmod = 2                    rdsmod = 0                    igcmod = 1
+igbmod = 1                    rbodymod = 0                  trnqsmod = 0
+acnqsmod = 0                  fnoimod = 1                   tnoimod = 0
+diomod = 1                    permod = 1                    rgatemod = 0
+wpemod = 0
//*** geometry range parameter ***
+lmin = 6E-8                   lmax = 1E-7                   wmin = 5E-7
+wmax = 1E-6
//*** process parameter ***
+epsrox = 3.9                  toxe = tox_p_cap                  toxm = tox_p_cap
+dtox = 3.29E-10               xj = 1.7E-7                   ndep = 8.5E17
+ngate = 8E19                  nsd = 1E20                    rsh = 9.68
+rshg = 0.1
//*** dw and dl parameter ***
+wint = 1.089287E-8            wl = 0                        wln = 1
+ww = 0                        wwn = 1                       wwl = 0
+lint = 2E-24                  ll = 0                        lln = 1
+lw = 0                        lwn = 1                       lwl = 0
+llc = 0                       lwc = 0                       lwlc = 0
+wlc = 0                       wwc = 0                       wwlc = 0
+dwg = 0                       dwb = 0                       xl = 0+dxl_p_cap
+xw = 0+dxw_p_cap
//*** flicker noise model parameter ***
+noia = 1.45E42                noib = 3.57E26                noic = 2E10
+em = 2.1E7                    ef = 1.147
//***layout-dependent parasitics model parameter ***
+dmcg = 8.5E-8                 dmci = 8.5E-8                 dmdg = 0
+dmcgt = 0                     dwj = 0                       xgw = 0
+xgl = 0                       ngcon = 1
//*** vth related  parameter ***
+vth0 = -0.303883+dvth0_p_cap      lvth0 = -2.315703E-10+dlvth0_p_cap wvth0 = -1.194003E-9+dwvth0_p_cap
+pvth0 = 1.690802E-16+dpvth0_p_cap phin = 0                      k1 = 0.25
+k2 = -1.667648E-3             lk2 = -1.245868E-9            wk2 = 1.095578E-10
+pk2 = 2.290329E-17            k3 = -1.700953                k3b = 1.200306
+w0 = 1.585076E-7              lpe0 = 7.519925E-8            lpeb = 5.608072E-8
+dvtp0 = 2.2E-6                dvtp1 = 0.2                   dvt0 = 0.20341
+dvt1 = 0.95146                dvt2 = 0.01                   dvt0w = 0
+dvt1w = 5.366499E6            dvt2w = 0
//*** mobility related parameter ***
+u0 = 1.93044E-2+du0_p_cap         lu0 = 2.672019E-10+dlu0_p_cap     wu0 = 1.406683E-9+dwu0_p_cap
+pu0 = -1.650031E-16+dpu0_p_cap    ua = 1.538179E-11             wua = -3.354752E-18
+pua = 8.175722E-32            ub = 8.296347E-19             lub = 9.089101E-26
+wub = 1.013503E-25            pub = -1.717583E-32           uc = 2.516403E-11
+wuc = -1.287234E-18           ud = 0                        vsat = 7.943018E4+dvsat_p_cap
+lvsat = 3.830132E-3           wvsat = -7.017973E-3          pvsat = 7.019194E-10
+a0 = 1E-3                     ags = 4.821657                wags = -9.049514E-7
+b0 = 0                        b1 = 0                        keta = 5.588306E-3
+lketa = -4.083886E-9          wketa = 9.722906E-9           pketa = -1.728034E-15
+a1 = 0                        a2 = 1                        rdsw = 327.6
+prwb = -0.249981              prwg = 0.25                   wr = 1
//*** subthreshold related parameter ***
+voff = -8.24351E-2            lvoff = 2.17475E-9            wvoff = 1.870202E-9
+pvoff = -2.359797E-16         voffl = -6.036214E-9          minv = 0
+nfactor = 0.194575            lnfactor = 5.003397E-8        wnfactor = -9.483628E-9
+pnfactor = -2.438948E-15      eta0 = 3.11538E-2             etab = -2.38505E-2
+dsub = 1.2725                 cit = 1E-4                    cdsc = 0
+cdscb = 0                     cdscd = 0
//*** output resistance related parameter ***
+pclm = 0.627258               pdiblc1 = 0                   pdiblc2 = 0.012442
+lpdiblc2 = -2.994882E-10      wpdiblc2 = 1.135027E-10       ppdiblc2 = -7.665432E-17
+pdiblcb = 0                   drout = 1.132692              pscbe1 = 9.264E8
+pscbe2 = 1E-20                pvag = 1.425                  delta = 0.02
+fprout = 390.234144           pdits = 5.042617E-3           pditsl = 100
+pditsd = 0                    alpha0 = 0                    alpha1 = 0.06
+beta0 = 13.5                  agidl = 9E-8                  bgidl = 3.404E9
+cgidl = 0.5                   egidl = 0.15
//*** gate dielectric tunneling current ***
+aigbacc = 0.012               bigbacc = 3.49E-3             cigbacc = 0.131
+nigbacc = 5.2                 aigbinv = 0.347               bigbinv = 0.0312
+cigbinv = 6.1E-3              eigbinv = 1.1                 nigbinv = 1
+aigc = 7.12E-3                bigc = 6.31E-4                cigc = 0
+aigsd = 5.9E-3                bigsd = 2.48E-4               cigsd = 0.032
+dlcig = 2.52E-9               nigc = 2.28                   poxedge = 1
+pigcd = 2.28                  ntox = 1                      toxref = 3E-9
//*** capacitance parameter ***
+xpart = 1                     cgso = 3.1E-11+dcgso_p_cap        cgdo = 3.1E-11+dcgdo_p_cap
+cgbo = 0                      ckappas = 0.6                 ckappad = 0.6
+cf = 1.18E-10                 clc = 1E-7                    cle = 0.6
+dlc = 0                 dwc = 0                       noff = 2.5
+voffcv = -0.0486              acde = 1.2                    moin = 8
+cgsl = 0.54E-10+dcgsl_p_cap       cgdl = 0.54E-10+dcgdl_p_cap
//*** souce/drain junction diode model parameter **
+ijthsrev = 0.01               ijthsfwd = 0.01               xjbvs = 1
+bvs = 10                      jss = 1.51E-7                 jsws = 3.98E-13
+jswgs = 2.47E-12              cjs = 9.98E-4+dcj_p_cap           mjs = 0.34
+mjsws = 0.012                 cjsws = 6.21E-11+dcjsw_p_cap      cjswgs = 2.53E-10+dcjswg_p_cap
+mjswgs = 0.86                 pbs = 0.75                    pbsws = 0.49
+pbswgs = 0.71
//** rf model related parameter ***
+xrcrg1 = 12                   xrcrg2 = 1                    rbpb = 50
+rbpd = 50                     rbps = 50                     rbdb = 50
+rbsb = 50                     gbmin = 1E-12
//*** stress effect related parameter ***
+saref = 6.1E-7                sbref = 6.1E-7                wlod = 2.86E-7
+ku0 = 1E-7                    kvsat = -0.386                kvth0 = 2E-10
+tku0 = 0.24                   llodku0 = 1                   wlodku0 = 1
+llodvth = 1.8                 wlodvth = 1                   lku0 = 1.871E-7
+wku0 = 2.4E-7                 pku0 = -3.24E-14              lkvth0 = 2.4E-10
+wkvth0 = 1.8E-10              pkvth0 = 0                    stk2 = 0
+lodk2 = 1.9                   steta0 = 0                    lodeta0 = 1
//*** temperature coefficient ***
+tnom = 25                     ute = -1.524                  kt1 = -0.229
+kt1l = 0                      kt2 = -0.01232                ua1 = 4.549E-9
+ub1 = -5.441E-18              uc1 = -5E-11                  at = 4.00001E4
+prt = 0                       njs = 1                       xtis = 3
+tpb = 1.9E-3                  tpbsw = 1.9E-3                tpbswg = 1.9E-3
+tcj = 7.98E-4                 tcjsw = 2.4E-4                tcjswg = 4.77E-3
//*** well proximity effect model parameters ***
+web = -220                    wec = -3E3                    kvth0we = -3.197498E-3
+k2we = 3E-4                   ku0we = -3.482487E-3          scref = 1E-6
18:type=p  minr=1e-60
//*** flag parameter ***
+version = 4.3                 binunit = 2                   mobmod = 0
+capmod = 2                    rdsmod = 0                    igcmod = 1
+igbmod = 1                    rbodymod = 0                  trnqsmod = 0
+acnqsmod = 0                  fnoimod = 1                   tnoimod = 0
+diomod = 1                    permod = 1                    rgatemod = 0
+wpemod = 0
//*** geometry range parameter ***
+lmin = 4E-8                   lmax = 6E-8                   wmin = 5E-7
+wmax = 1E-6
//*** process parameter ***
+epsrox = 3.9                  toxe = tox_p_cap                  toxm = tox_p_cap
+dtox = 3.29E-10               xj = 1.7E-7                   ndep = 8.5E17
+ngate = 8E19                  nsd = 1E20                    rsh = 9.68
+rshg = 0.1
//*** dw and dl parameter ***
+wint = 1.089287E-8            wl = 0                        wln = 1
+ww = 0                        wwn = 1                       wwl = 0
+lint = 2E-24                  ll = 0                        lln = 1
+lw = 0                        lwn = 1                       lwl = 0
+llc = 0                       lwc = 0                       lwlc = 0
+wlc = 0                       wwc = 0                       wwlc = 0
+dwg = 0                       dwb = 0                       xl = 0+dxl_p_cap
+xw = 0+dxw_p_cap
//*** flicker noise model parameter ***
+noia = 1.45E42                noib = 3.57E26                noic = 2E10
+em = 2.1E7                    ef = 1.147
//***layout-dependent parasitics model parameter ***
+dmcg = 8.5E-8                 dmci = 8.5E-8                 dmdg = 0
+dmcgt = 0                     dwj = 0                       xgw = 0
+xgl = 0                       ngcon = 1
//*** vth related  parameter ***
+vth0 = -0.353018+dvth0_p_cap      lvth0 = 2.7165E-9+dlvth0_p_cap    wvth0 = -4.203147E-10+dwvth0_p_cap
+pvth0 = 1.226589E-16+dpvth0_p_cap phin = 0                      k1 = 0.25
+k2 = -1.97479E-2              lk2 = -1.610538E-10           wk2 = 3.498085E-9
+pk2 = -1.804083E-16           k3 = -1.700953                k3b = 1.200306
+w0 = 1.585076E-7              lpe0 = 7.519925E-8            lpeb = 5.608072E-8
+dvtp0 = 2.2E-6                dvtp1 = 0.2                   dvt0 = 0.20341
+dvt1 = 0.95146                dvt2 = 0.01                   dvt0w = 0
+dvt1w = 5.366499E6            dvt2w = 0
//*** mobility related parameter ***
+u0 = 2.82327E-2+du0_p_cap         lu0 = -2.684997E-10+dlu0_p_cap    wu0 = -5.716553E-10+dwu0_p_cap
+pu0 = -4.630277E-17+dpu0_p_cap    ua = 1.538179E-11             wua = -3.35475E-18
+ub = 1.697597E-18             lub = 3.881325E-26            wub = 2.699781E-27
+pub = -1.125677E-32           uc = 2.516403E-11             wuc = -1.287234E-18
+ud = 0                        vsat = 1.034144E5+dvsat_p_cap     lvsat = 2.391226E-3
+wvsat = 5.61351E-3            pvsat = -5.611507E-11         a0 = 1E-3
+ags = 4.821657                wags = -9.049514E-7           b0 = 0
+b1 = 0                        keta = 0.241349               lketa = -1.822952E-8
+wketa = -7.887321E-8          pketa = 3.587733E-15          a1 = 0
+a2 = 1                        rdsw = 327.6                  prwb = -0.249981
+prwg = 0.25                   wr = 1
//*** subthreshold related parameter ***
+voff = -0.103675              lvoff = 3.449149E-9           wvoff = -2.423932E-9
+pvoff = 2.166831E-17          voffl = -6.036214E-9          minv = 0
+nfactor = 0.411391            lnfactor = 3.702499E-8        wnfactor = -2.005348E-8
+pnfactor = -1.804757E-15      eta0 = 3.11538E-2             etab = 7.71088E-2
+letab = -6.057559E-9          wetab = 1.053252E-8           petab = -6.319512E-16
+dsub = 1.2725                 cit = 1E-4                    cdsc = 0
+cdscb = 0                     cdscd = 0
//*** output resistance related parameter ***
+pclm = 0.627258               pdiblc1 = 0                   pdiblc2 = 6.678874E-3
+lpdiblc2 = 4.63003E-11        wpdiblc2 = 2.083621E-9        ppdiblc2 = -1.948614E-16
+pdiblcb = 0                   drout = 1.132692              pscbe1 = 9.264E8
+pscbe2 = 1E-20                pvag = 1.425                  delta = 0.02
+fprout = 390.234144           pdits = 5.042617E-3           pditsl = 100
+pditsd = 0                    alpha0 = 0                    alpha1 = 0.06
+beta0 = 13.5                  agidl = 9E-8                  bgidl = 3.404E9
+cgidl = 0.5                   egidl = 0.15
//*** gate dielectric tunneling current ***
+aigbacc = 0.012               bigbacc = 3.49E-3             cigbacc = 0.131
+nigbacc = 5.2                 aigbinv = 0.347               bigbinv = 0.0312
+cigbinv = 6.1E-3              eigbinv = 1.1                 nigbinv = 1
+aigc = 7.12E-3                bigc = 6.31E-4                cigc = 0
+aigsd = 5.9E-3                bigsd = 2.48E-4               cigsd = 0.032
+dlcig = 2.52E-9               nigc = 2.28                   poxedge = 1
+pigcd = 2.28                  ntox = 1                      toxref = 3E-9
//*** capacitance parameter ***
+xpart = 1                     cgso = 3.1E-11+dcgso_p_cap        cgdo = 3.1E-11+dcgdo_p_cap
+cgbo = 0                      ckappas = 0.6                 ckappad = 0.6
+cf = 1.18E-10                 clc = 1E-7                    cle = 0.6
+dlc = 0                 dwc = 0                       noff = 2.5
+voffcv = -0.0486              acde = 1.2                    moin = 8
+cgsl = 0.54E-10+dcgsl_p_cap       cgdl = 0.54E-10+dcgdl_p_cap
//*** souce/drain junction diode model parameter **
+ijthsrev = 0.01               ijthsfwd = 0.01               xjbvs = 1
+bvs = 10                      jss = 1.51E-7                 jsws = 3.98E-13
+jswgs = 2.47E-12              cjs = 9.98E-4+dcj_p_cap           mjs = 0.34
+mjsws = 0.012                 cjsws = 6.21E-11+dcjsw_p_cap      cjswgs = 2.53E-10+dcjswg_p_cap
+mjswgs = 0.86                 pbs = 0.75                    pbsws = 0.49
+pbswgs = 0.71
//** rf model related parameter ***
+xrcrg1 = 12                   xrcrg2 = 1                    rbpb = 50
+rbpd = 50                     rbps = 50                     rbdb = 50
+rbsb = 50                     gbmin = 1E-12
//*** stress effect related parameter ***
+saref = 6.1E-7                sbref = 6.1E-7                wlod = 2.86E-7
+ku0 = 1E-7                    kvsat = -0.386                kvth0 = 2E-10
+tku0 = 0.24                   llodku0 = 1                   wlodku0 = 1
+llodvth = 1.8                 wlodvth = 1                   lku0 = 1.871E-7
+wku0 = 2.4E-7                 pku0 = -3.24E-14              lkvth0 = 2.4E-10
+wkvth0 = 1.8E-10              pkvth0 = 0                    stk2 = 0
+lodk2 = 1.9                   steta0 = 0                    lodeta0 = 1
//*** temperature coefficient ***
+tnom = 25                     ute = -1.524                  kt1 = -0.229
+kt1l = 0                      kt2 = -0.01232                ua1 = 4.549E-9
+ub1 = -5.441E-18              uc1 = -5E-11                  at = 4.00001E4
+prt = 0                       njs = 1                       xtis = 3
+tpb = 1.9E-3                  tpbsw = 1.9E-3                tpbswg = 1.9E-3
+tcj = 7.98E-4                 tcjsw = 2.4E-4                tcjswg = 4.77E-3
//*** well proximity effect model parameters ***
+web = -220                    wec = -3E3                    kvth0we = -3.197498E-3
+k2we = 3E-4                   ku0we = -3.482487E-3          scref = 1E-6
19:type=p  minr=1e-60
//*** flag parameter ***
+version = 4.3                 binunit = 2                   mobmod = 0
+capmod = 2                    rdsmod = 0                    igcmod = 1
+igbmod = 1                    rbodymod = 0                  trnqsmod = 0
+acnqsmod = 0                  fnoimod = 1                   tnoimod = 0
+diomod = 1                    permod = 1                    rgatemod = 0
+wpemod = 0
//*** geometry range parameter ***
+lmin = 2E-6                   lmax = 1E-5                   wmin = 3E-7
+wmax = 5E-7
//*** process parameter ***
+epsrox = 3.9                  toxe = tox_p_cap                  toxm = tox_p_cap
+dtox = 3.29E-10               xj = 1.7E-7                   ndep = 8.5E17
+ngate = 8E19                  nsd = 1E20                    rsh = 9.68
+rshg = 0.1
//*** dw and dl parameter ***
+wint = 1.089287E-8            wl = 0                        wln = 1
+ww = 0                        wwn = 1                       wwl = 0
+lint = 2E-24                  ll = 0                        lln = 1
+lw = 0                        lwn = 1                       lwl = 0
+llc = 0                       lwc = 0                       lwlc = 0
+wlc = 0                       wwc = 0                       wwlc = 0
+dwg = 0                       dwb = 0                       xl = 0+dxl_p_cap
+xw = 0+dxw_p_cap
//*** flicker noise model parameter ***
+noia = 1.45E42                noib = 3.57E26                noic = 2E10
+em = 2.1E7                    ef = 1.147
//***layout-dependent parasitics model parameter ***
+dmcg = 8.5E-8                 dmci = 8.5E-8                 dmdg = 0
+dmcgt = 0                     dwj = 0                       xgw = 0
+xgl = 0                       ngcon = 1
//*** vth related  parameter ***
+vth0 = -0.279025+dvth0_p_cap      lvth0 = 2.823875E-9+dlvth0_p_cap  wvth0 = 1.350417E-10+dwvth0_p_cap
+pvth0 = -1.350417E-15+dpvth0_p_cap phin = 0                      k1 = 0.25
+k2 = -7.93129E-3              lk2 = -5.000185E-9            wk2 = -4.202092E-11
+pk2 = 4.202092E-16            k3 = -1.700953                k3b = 1.200306
+w0 = 1.585076E-7              lpe0 = 7.519925E-8            lpeb = 5.608072E-8
+dvtp0 = 2.2E-6                dvtp1 = 0.2                   dvt0 = 0.20341
+dvt1 = 0.95146                dvt2 = 0.01                   dvt0w = 0
+dvt1w = 5.366499E6            dvt2w = 0
//*** mobility related parameter ***
+u0 = 2.05849E-2+du0_p_cap         lu0 = -6.062424E-10+dlu0_p_cap    wu0 = 7.096342E-11+dwu0_p_cap
+pu0 = 2.389839E-16+dpu0_p_cap     ua = 1.409575E-11             lua = -2.143415E-17
+wua = -5.963288E-19           pua = 5.963288E-24            ub = 1.232665E-18
+lub = -8.739768E-26           wub = -5.630408E-26           pub = 1.529697E-32
+uc = 4.930144E-11             luc = -3.439635E-17           ud = 0
+vsat = 1.177315E5+dvsat_p_cap     a0 = 2.493231                 la0 = 1.330351E-6
+wa0 = 6.361928E-8             pa0 = -6.361928E-13           ags = 1.163903
+lags = 7.377958E-7            wags = 1.230842E-9            pags = -1.230842E-14
+b0 = 0                        b1 = 0                        keta = -8.94086E-2
+lketa = -6.630367E-8          wketa = -3.170736E-9          pketa = 3.170736E-14
+a1 = 0                        a2 = 1                        rdsw = 327.6
+prwb = -0.249981              prwg = 0.25                   wr = 1
//*** subthreshold related parameter ***
+voff = -4.11187E-2            lvoff = 3.645993E-9           wvoff = 1.352745E-10
+pvoff = -1.352745E-15         voffl = -6.036214E-9          minv = 0
+nfactor = 0.315827            lnfactor = 5.977564E-8        wnfactor = -1.960167E-8
+pnfactor = 4.630002E-15       eta0 = 3.11538E-2             etab = -2.38505E-2
+dsub = 1.2725                 cit = 1E-4                    cdsc = 0
+cdscb = 0                     cdscd = 0
//*** output resistance related parameter ***
+pclm = 0.627258               pdiblc1 = 0                   pdiblc2 = 1.12289E-2
+lpdiblc2 = 2.993495E-9        wpdiblc2 = 1.285557E-10       ppdiblc2 = -1.285557E-15
+pdiblcb = 0                   drout = 1.132692              pscbe1 = 9.264E8
+pscbe2 = 1E-20                pvag = 1.425                  delta = 0.02
+fprout = 390.234144           pdits = 5.042617E-3           pditsl = 100
+pditsd = 0                    alpha0 = 0                    alpha1 = 0.06
+beta0 = 13.5                  agidl = 9E-8                  bgidl = 3.404E9
+cgidl = 0.5                   egidl = 0.15
//*** gate dielectric tunneling current ***
+aigbacc = 0.012               bigbacc = 3.49E-3             cigbacc = 0.131
+nigbacc = 5.2                 aigbinv = 0.347               bigbinv = 0.0312
+cigbinv = 6.1E-3              eigbinv = 1.1                 nigbinv = 1
+aigc = 7.12E-3                bigc = 6.31E-4                cigc = 0
+aigsd = 5.9E-3                bigsd = 2.48E-4               cigsd = 0.032
+dlcig = 2.52E-9               nigc = 2.28                   poxedge = 1
+pigcd = 2.28                  ntox = 1                      toxref = 3E-9
//*** capacitance parameter ***
+xpart = 1                     cgso = 3.1E-11+dcgso_p_cap        cgdo = 3.1E-11+dcgdo_p_cap
+cgbo = 0                      ckappas = 0.6                 ckappad = 0.6
+cf = 1.18E-10                 clc = 1E-7                    cle = 0.6
+dlc = 0                 dwc = 0                       noff = 2.5
+voffcv = -0.0486              acde = 1.2                    moin = 8
+cgsl = 0.54E-10+dcgsl_p_cap       cgdl = 0.54E-10+dcgdl_p_cap
//*** souce/drain junction diode model parameter **
+ijthsrev = 0.01               ijthsfwd = 0.01               xjbvs = 1
+bvs = 10                      jss = 1.51E-7                 jsws = 3.98E-13
+jswgs = 2.47E-12              cjs = 9.98E-4+dcj_p_cap           mjs = 0.34
+mjsws = 0.012                 cjsws = 6.21E-11+dcjsw_p_cap      cjswgs = 2.53E-10+dcjswg_p_cap
+mjswgs = 0.86                 pbs = 0.75                    pbsws = 0.49
+pbswgs = 0.71
//** rf model related parameter ***
+xrcrg1 = 12                   xrcrg2 = 1                    rbpb = 50
+rbpd = 50                     rbps = 50                     rbdb = 50
+rbsb = 50                     gbmin = 1E-12
//*** stress effect related parameter ***
+saref = 6.1E-7                sbref = 6.1E-7                wlod = 2.86E-7
+ku0 = 1E-7                    kvsat = -0.386                kvth0 = 2E-10
+tku0 = 0.24                   llodku0 = 1                   wlodku0 = 1
+llodvth = 1.8                 wlodvth = 1                   lku0 = 1.871E-7
+wku0 = 2.4E-7                 pku0 = -3.24E-14              lkvth0 = 2.4E-10
+wkvth0 = 1.8E-10              pkvth0 = 0                    stk2 = 0
+lodk2 = 1.9                   steta0 = 0                    lodeta0 = 1
//*** temperature coefficient ***
+tnom = 25                     ute = -1.524                  kt1 = -0.229
+kt1l = 0                      kt2 = -0.01232                ua1 = 4.549E-9
+ub1 = -5.441E-18              uc1 = -5E-11                  at = 4.00001E4
+prt = 0                       njs = 1                       xtis = 3
+tpb = 1.9E-3                  tpbsw = 1.9E-3                tpbswg = 1.9E-3
+tcj = 7.98E-4                 tcjsw = 2.4E-4                tcjswg = 4.77E-3
//*** well proximity effect model parameters ***
+web = -220                    wec = -3E3                    kvth0we = -3.197498E-3
+k2we = 3E-4                   ku0we = -3.482487E-3          scref = 1E-6
20:type=p  minr=1e-60
//*** flag parameter ***
+version = 4.3                 binunit = 2                   mobmod = 0
+capmod = 2                    rdsmod = 0                    igcmod = 1
+igbmod = 1                    rbodymod = 0                  trnqsmod = 0
+acnqsmod = 0                  fnoimod = 1                   tnoimod = 0
+diomod = 1                    permod = 1                    rgatemod = 0
+wpemod = 0
//*** geometry range parameter ***
+lmin = 1E-6                   lmax = 2E-6                   wmin = 3E-7
+wmax = 5E-7
//*** process parameter ***
+epsrox = 3.9                  toxe = tox_p_cap                  toxm = tox_p_cap
+dtox = 3.29E-10               xj = 1.7E-7                   ndep = 8.5E17
+ngate = 8E19                  nsd = 1E20                    rsh = 9.68
+rshg = 0.1
//*** dw and dl parameter ***
+wint = 1.089287E-8            wl = 0                        wln = 1
+ww = 0                        wwn = 1                       wwl = 0
+lint = 2E-24                  ll = 0                        lln = 1
+lw = 0                        lwn = 1                       lwl = 0
+llc = 0                       lwc = 0                       lwlc = 0
+wlc = 0                       wwc = 0                       wwlc = 0
+dwg = 0                       dwb = 0                       xl = 0+dxl_p_cap
+xw = 0+dxw_p_cap
//*** flicker noise model parameter ***
+noia = 1.45E42                noib = 3.57E26                noic = 2E10
+em = 2.1E7                    ef = 1.147
//***layout-dependent parasitics model parameter ***
+dmcg = 8.5E-8                 dmci = 8.5E-8                 dmdg = 0
+dmcgt = 0                     dwj = 0                       xgw = 0
+xgl = 0                       ngcon = 1
//*** vth related  parameter ***
+vth0 = -0.277675+dvth0_p_cap      lvth0 = 1.227641E-10+dlvth0_p_cap wvth0 = -1.729598E-11+dwvth0_p_cap
+pvth0 = -1.045742E-15+dpvth0_p_cap phin = 0                      k1 = 0.25
+k2 = -1.04314E-2              wk2 = 1.680837E-10            k3 = -1.700953
+k3b = 1.200306                w0 = 1.585076E-7              lpe0 = 7.519925E-8
+lpeb = 5.608072E-8            dvtp0 = 2.2E-6                dvtp1 = 0.2
+dvt0 = 0.20341                dvt1 = 0.95146                dvt2 = 0.01
+dvt0w = 0                     dvt1w = 5.366499E6            dvt2w = 0
//*** mobility related parameter ***
+u0 = 2.02494E-2+du0_p_cap         lu0 = 6.459536E-11+dlu0_p_cap     wu0 = 1.846679E-10+dwu0_p_cap
+pu0 = 1.1575E-17+dpu0_p_cap       ua = 3.378668E-12             wua = 2.385315E-18
+ub = 1.084096E-18             lub = 2.0974E-25              wub = -1.947927E-26
+pub = -5.835266E-32           uc = 4.173424E-11             luc = -1.926196E-17
+ud = 0                        vsat = 1.177315E5+dvsat_p_cap     a0 = 4.348041
+la0 = -2.379269E-6            wa0 = -5.854504E-7            pa0 = 6.619466E-13
+ags = 1.07296                 lags = 9.196831E-7            wags = -3.445892E-9
+pags = -2.954952E-15          b0 = 0                        b1 = 0
+keta = -0.12256               wketa = 1.268295E-8           a1 = 0
+a2 = 1                        rdsw = 327.6                  prwb = -0.249981
+prwg = 0.25                   wr = 1
//*** subthreshold related parameter ***
+voff = -3.89515E-2            lvoff = -6.885E-10            wvoff = -4.852189E-10
+pvoff = -1.117587E-16         voffl = -6.036214E-9          minv = 0
+nfactor = 0.312675            lnfactor = 6.607856E-8        wnfactor = -1.858919E-8
+pnfactor = 2.605041E-15       eta0 = 3.11538E-2             etab = -2.38505E-2
+dsub = 1.2725                 cit = 1E-4                    cdsc = 0
+cdscb = 0                     cdscd = 0
//*** output resistance related parameter ***
+pclm = 0.627258               pdiblc1 = 0                   pdiblc2 = 1.46621E-2
+lpdiblc2 = -3.873063E-9       wpdiblc2 = -1.082596E-9       ppdiblc2 = 1.136745E-15
+pdiblcb = 0                   drout = 1.132692              pscbe1 = 9.264E8
+pscbe2 = 1E-20                pvag = 1.425                  delta = 0.02
+fprout = 390.234144           pdits = 5.042617E-3           pditsl = 100
+pditsd = 0                    alpha0 = 0                    alpha1 = 0.06
+beta0 = 13.5                  agidl = 9E-8                  bgidl = 3.404E9
+cgidl = 0.5                   egidl = 0.15
//*** gate dielectric tunneling current ***
+aigbacc = 0.012               bigbacc = 3.49E-3             cigbacc = 0.131
+nigbacc = 5.2                 aigbinv = 0.347               bigbinv = 0.0312
+cigbinv = 6.1E-3              eigbinv = 1.1                 nigbinv = 1
+aigc = 7.12E-3                bigc = 6.31E-4                cigc = 0
+aigsd = 5.9E-3                bigsd = 2.48E-4               cigsd = 0.032
+dlcig = 2.52E-9               nigc = 2.28                   poxedge = 1
+pigcd = 2.28                  ntox = 1                      toxref = 3E-9
//*** capacitance parameter ***
+xpart = 1                     cgso = 3.1E-11+dcgso_p_cap        cgdo = 3.1E-11+dcgdo_p_cap
+cgbo = 0                      ckappas = 0.6                 ckappad = 0.6
+cf = 1.18E-10                 clc = 1E-7                    cle = 0.6
+dlc = 0                 dwc = 0                       noff = 2.5
+voffcv = -0.0486              acde = 1.2                    moin = 8
+cgsl = 0.54E-10+dcgsl_p_cap       cgdl = 0.54E-10+dcgdl_p_cap
//*** souce/drain junction diode model parameter **
+ijthsrev = 0.01               ijthsfwd = 0.01               xjbvs = 1
+bvs = 10                      jss = 1.51E-7                 jsws = 3.98E-13
+jswgs = 2.47E-12              cjs = 9.98E-4+dcj_p_cap           mjs = 0.34
+mjsws = 0.012                 cjsws = 6.21E-11+dcjsw_p_cap      cjswgs = 2.53E-10+dcjswg_p_cap
+mjswgs = 0.86                 pbs = 0.75                    pbsws = 0.49
+pbswgs = 0.71
//** rf model related parameter ***
+xrcrg1 = 12                   xrcrg2 = 1                    rbpb = 50
+rbpd = 50                     rbps = 50                     rbdb = 50
+rbsb = 50                     gbmin = 1E-12
//*** stress effect related parameter ***
+saref = 6.1E-7                sbref = 6.1E-7                wlod = 2.86E-7
+ku0 = 1E-7                    kvsat = -0.386                kvth0 = 2E-10
+tku0 = 0.24                   llodku0 = 1                   wlodku0 = 1
+llodvth = 1.8                 wlodvth = 1                   lku0 = 1.871E-7
+wku0 = 2.4E-7                 pku0 = -3.24E-14              lkvth0 = 2.4E-10
+wkvth0 = 1.8E-10              pkvth0 = 0                    stk2 = 0
+lodk2 = 1.9                   steta0 = 0                    lodeta0 = 1
//*** temperature coefficient ***
+tnom = 25                     ute = -1.524                  kt1 = -0.229
+kt1l = 0                      kt2 = -0.01232                ua1 = 4.549E-9
+ub1 = -5.441E-18              uc1 = -5E-11                  at = 4.00001E4
+prt = 0                       njs = 1                       xtis = 3
+tpb = 1.9E-3                  tpbsw = 1.9E-3                tpbswg = 1.9E-3
+tcj = 7.98E-4                 tcjsw = 2.4E-4                tcjswg = 4.77E-3
//*** well proximity effect model parameters ***
+web = -220                    wec = -3E3                    kvth0we = -3.197498E-3
+k2we = 3E-4                   ku0we = -3.482487E-3          scref = 1E-6
21:type=p  minr=1e-60
//*** flag parameter ***
+version = 4.3                 binunit = 2                   mobmod = 0
+capmod = 2                    rdsmod = 0                    igcmod = 1
+igbmod = 1                    rbodymod = 0                  trnqsmod = 0
+acnqsmod = 0                  fnoimod = 1                   tnoimod = 0
+diomod = 1                    permod = 1                    rgatemod = 0
+wpemod = 0
//*** geometry range parameter ***
+lmin = 5E-7                   lmax = 1E-6                   wmin = 3E-7
+wmax = 5E-7
//*** process parameter ***
+epsrox = 3.9                  toxe = tox_p_cap                  toxm = tox_p_cap
+dtox = 3.29E-10               xj = 1.7E-7                   ndep = 8.5E17
+ngate = 8E19                  nsd = 1E20                    rsh = 9.68
+rshg = 0.1
//*** dw and dl parameter ***
+wint = 1.089287E-8            wl = 0                        wln = 1
+ww = 0                        wwn = 1                       wwl = 0
+lint = 2E-24                  ll = 0                        lln = 1
+lw = 0                        lwn = 1                       lwl = 0
+llc = 0                       lwc = 0                       lwlc = 0
+wlc = 0                       wwc = 0                       wwlc = 0
+dwg = 0                       dwb = 0                       xl = 0+dxl_p_cap
+xw = 0+dxw_p_cap
//*** flicker noise model parameter ***
+noia = 1.45E42                noib = 3.57E26                noic = 2E10
+em = 2.1E7                    ef = 1.147
//***layout-dependent parasitics model parameter ***
+dmcg = 8.5E-8                 dmci = 8.5E-8                 dmdg = 0
+dmcgt = 0                     dwj = 0                       xgw = 0
+xgl = 0                       ngcon = 1
//*** vth related  parameter ***
+vth0 = -0.271438+dvth0_p_cap      lvth0 = -6.113969E-9+dlvth0_p_cap wvth0 = -2.764031E-9+dwvth0_p_cap
+pvth0 = 1.700993E-15+dpvth0_p_cap phin = 0                      k1 = 0.25
+k2 = -1.04314E-2              wk2 = 1.680837E-10            k3 = -1.700953
+k3b = 1.200306                w0 = 1.585076E-7              lpe0 = 7.519925E-8
+lpeb = 5.608072E-8            dvtp0 = 2.2E-6                dvtp1 = 0.2
+dvt0 = 0.20341                dvt1 = 0.95146                dvt2 = 0.01
+dvt0w = 0                     dvt1w = 5.366499E6            dvt2w = 0
//*** mobility related parameter ***
+u0 = 1.97725E-2+du0_p_cap         lu0 = 5.415448E-10+dlu0_p_cap     wu0 = 2.793301E-10+dwu0_p_cap
+pu0 = -8.308724E-17+dpu0_p_cap    ua = 3.378668E-12             wua = 2.385315E-18
+ub = 1.259104E-18             lub = 3.473224E-26            wub = -1.056997E-25
+pub = 2.786782E-32            uc = 2.247228E-11             ud = 0
+vsat = 1.177315E5+dvsat_p_cap     a0 = 2.559403                 la0 = -5.906308E-7
+wa0 = 9.944525E-8             pa0 = -2.294911E-14           ags = 1.036174
+lags = 9.564694E-7            wags = -3.328146E-9           pags = -3.072698E-15
+b0 = 0                        b1 = 0                        keta = -0.12256
+wketa = 1.268295E-8           a1 = 0                        a2 = 1
+rdsw = 327.6                  prwb = -0.249981              prwg = 0.25
+wr = 1
//*** subthreshold related parameter ***
+voff = -0.036359              lvoff = -3.280905E-9          wvoff = -1.204599E-9
+pvoff = 6.076212E-16          voffl = -6.036214E-9          minv = 0
+nfactor = 0.287815            lnfactor = 9.093895E-8        wnfactor = -9.006551E-9
+pnfactor = -6.977599E-15      eta0 = 3.11538E-2             etab = -2.38505E-2
+dsub = 1.2725                 cit = 1E-4                    cdsc = 0
+cdscb = 0                     cdscd = 0
//*** output resistance related parameter ***
+pclm = 0.627258               pdiblc1 = 0                   pdiblc2 = 1.05922E-2
+lpdiblc2 = 1.968623E-10       wpdiblc2 = 3.728615E-10       ppdiblc2 = -3.187118E-16
+pdiblcb = 0                   drout = 1.132692              pscbe1 = 9.264E8
+pscbe2 = 1E-20                pvag = 1.425                  delta = 0.02
+fprout = 390.234144           pdits = 5.042617E-3           pditsl = 100
+pditsd = 0                    alpha0 = 0                    alpha1 = 0.06
+beta0 = 13.5                  agidl = 9E-8                  bgidl = 3.404E9
+cgidl = 0.5                   egidl = 0.15
//*** gate dielectric tunneling current ***
+aigbacc = 0.012               bigbacc = 3.49E-3             cigbacc = 0.131
+nigbacc = 5.2                 aigbinv = 0.347               bigbinv = 0.0312
+cigbinv = 6.1E-3              eigbinv = 1.1                 nigbinv = 1
+aigc = 7.12E-3                bigc = 6.31E-4                cigc = 0
+aigsd = 5.9E-3                bigsd = 2.48E-4               cigsd = 0.032
+dlcig = 2.52E-9               nigc = 2.28                   poxedge = 1
+pigcd = 2.28                  ntox = 1                      toxref = 3E-9
//*** capacitance parameter ***
+xpart = 1                     cgso = 3.1E-11+dcgso_p_cap        cgdo = 3.1E-11+dcgdo_p_cap
+cgbo = 0                      ckappas = 0.6                 ckappad = 0.6
+cf = 1.18E-10                 clc = 1E-7                    cle = 0.6
+dlc = 0                 dwc = 0                       noff = 2.5
+voffcv = -0.0486              acde = 1.2                    moin = 8
+cgsl = 0.54E-10+dcgsl_p_cap       cgdl = 0.54E-10+dcgdl_p_cap
//*** souce/drain junction diode model parameter **
+ijthsrev = 0.01               ijthsfwd = 0.01               xjbvs = 1
+bvs = 10                      jss = 1.51E-7                 jsws = 3.98E-13
+jswgs = 2.47E-12              cjs = 9.98E-4+dcj_p_cap           mjs = 0.34
+mjsws = 0.012                 cjsws = 6.21E-11+dcjsw_p_cap      cjswgs = 2.53E-10+dcjswg_p_cap
+mjswgs = 0.86                 pbs = 0.75                    pbsws = 0.49
+pbswgs = 0.71
//** rf model related parameter ***
+xrcrg1 = 12                   xrcrg2 = 1                    rbpb = 50
+rbpd = 50                     rbps = 50                     rbdb = 50
+rbsb = 50                     gbmin = 1E-12
//*** stress effect related parameter ***
+saref = 6.1E-7                sbref = 6.1E-7                wlod = 2.86E-7
+ku0 = 1E-7                    kvsat = -0.386                kvth0 = 2E-10
+tku0 = 0.24                   llodku0 = 1                   wlodku0 = 1
+llodvth = 1.8                 wlodvth = 1                   lku0 = 1.871E-7
+wku0 = 2.4E-7                 pku0 = -3.24E-14              lkvth0 = 2.4E-10
+wkvth0 = 1.8E-10              pkvth0 = 0                    stk2 = 0
+lodk2 = 1.9                   steta0 = 0                    lodeta0 = 1
//*** temperature coefficient ***
+tnom = 25                     ute = -1.524                  kt1 = -0.229
+kt1l = 0                      kt2 = -0.01232                ua1 = 4.549E-9
+ub1 = -5.441E-18              uc1 = -5E-11                  at = 4.00001E4
+prt = 0                       njs = 1                       xtis = 3
+tpb = 1.9E-3                  tpbsw = 1.9E-3                tpbswg = 1.9E-3
+tcj = 7.98E-4                 tcjsw = 2.4E-4                tcjswg = 4.77E-3
//*** well proximity effect model parameters ***
+web = -220                    wec = -3E3                    kvth0we = -3.197498E-3
+k2we = 3E-4                   ku0we = -3.482487E-3          scref = 1E-6
22:type=p  minr=1e-60
//*** flag parameter ***
+version = 4.3                 binunit = 2                   mobmod = 0
+capmod = 2                    rdsmod = 0                    igcmod = 1
+igbmod = 1                    rbodymod = 0                  trnqsmod = 0
+acnqsmod = 0                  fnoimod = 1                   tnoimod = 0
+diomod = 1                    permod = 1                    rgatemod = 0
+wpemod = 0
//*** geometry range parameter ***
+lmin = 1E-7                   lmax = 5E-7                   wmin = 3E-7
+wmax = 5E-7
//*** process parameter ***
+epsrox = 3.9                  toxe = tox_p_cap                  toxm = tox_p_cap
+dtox = 3.29E-10               xj = 1.7E-7                   ndep = 8.5E17
+ngate = 8E19                  nsd = 1E20                    rsh = 9.68
+rshg = 0.1
//*** dw and dl parameter ***
+wint = 1.089287E-8            wl = 0                        wln = 1
+ww = 0                        wwn = 1                       wwl = 0
+lint = 2E-24                  ll = 0                        lln = 1
+lw = 0                        lwn = 1                       lwl = 0
+llc = 0                       lwc = 0                       lwlc = 0
+wlc = 0                       wwc = 0                       wwlc = 0
+dwg = 0                       dwb = 0                       xl = 0+dxl_p_cap
+xw = 0+dxw_p_cap
//*** flicker noise model parameter ***
+noia = 1.45E42                noib = 3.57E26                noic = 2E10
+em = 2.1E7                    ef = 1.147
//***layout-dependent parasitics model parameter ***
+dmcg = 8.5E-8                 dmci = 8.5E-8                 dmdg = 0
+dmcgt = 0                     dwj = 0                       xgw = 0
+xgl = 0                       ngcon = 1
//*** vth related  parameter ***
+vth0 = -0.277431+dvth0_p_cap      lvth0 = -3.117652E-9+dlvth0_p_cap wvth0 = 3.886607E-10+dwvth0_p_cap
+pvth0 = 1.246475E-16+dpvth0_p_cap phin = 0                      k1 = 0.25
+k2 = -9.131319E-3             lk2 = -6.500314E-10           wk2 = -5.450729E-11
+pk2 = 1.112955E-16            k3 = -1.700953                k3b = 1.200306
+w0 = 1.585076E-7              lpe0 = 7.519925E-8            lpeb = 5.608072E-8
+dvtp0 = 2.2E-6                dvtp1 = 0.2                   dvt0 = 0.20341
+dvt1 = 0.95146                dvt2 = 0.01                   dvt0w = 0
+dvt1w = 5.366499E6            dvt2w = 0
//*** mobility related parameter ***
+u0 = 2.07214E-2+du0_p_cap         lu0 = 6.708303E-11+dlu0_p_cap     wu0 = 1.324473E-10+dwu0_p_cap
+pu0 = -9.645837E-18+dpu0_p_cap    ua = 3.378668E-12             wua = 2.385315E-18
+ub = 1.228926E-18             lub = 4.98212E-26             wub = -4.621686E-26
+pub = -1.873621E-33           uc = 2.247228E-11             ud = 0
+vsat = 1.177315E5+dvsat_p_cap     a0 = 1.722426                 la0 = -1.721426E-7
+wa0 = 6.693379E-8             pa0 = -6.693379E-15           ags = 2.949112
+wags = -9.473542E-9           b0 = 0                        b1 = 0
+keta = -0.149451              lketa = 1.344529E-8           wketa = 2.016429E-8
+pketa = -3.740672E-15         a1 = 0                        a2 = 1
+rdsw = 327.6                  prwb = -0.249981              prwg = 0.25
+wr = 1
//*** subthreshold related parameter ***
+voff = -3.84328E-2            lvoff = -2.244035E-9          wvoff = 1.135215E-10
+pvoff = -5.143892E-17         voffl = -6.036214E-9          minv = 0
+nfactor = 0.41333             lnfactor = 2.818153E-8        wnfactor = -2.020637E-8
+pnfactor = -1.377692E-15      eta0 = 3.11538E-2             etab = -2.38505E-2
+dsub = 1.2725                 cit = 1E-4                    cdsc = 0
+cdscb = 0                     cdscd = 0
//*** output resistance related parameter ***
+pclm = 0.627258               pdiblc1 = 0                   pdiblc2 = 1.12807E-2
+lpdiblc2 = -1.473864E-10      wpdiblc2 = -1.244386E-10      ppdiblc2 = -7.00617E-17
+pdiblcb = 0                   drout = 1.132692              pscbe1 = 9.264E8
+pscbe2 = 1E-20                pvag = 1.425                  delta = 0.02
+fprout = 390.234144           pdits = 5.042617E-3           pditsl = 100
+pditsd = 0                    alpha0 = 0                    alpha1 = 0.06
+beta0 = 13.5                  agidl = 9E-8                  bgidl = 3.404E9
+cgidl = 0.5                   egidl = 0.15
//*** gate dielectric tunneling current ***
+aigbacc = 0.012               bigbacc = 3.49E-3             cigbacc = 0.131
+nigbacc = 5.2                 aigbinv = 0.347               bigbinv = 0.0312
+cigbinv = 6.1E-3              eigbinv = 1.1                 nigbinv = 1
+aigc = 7.12E-3                bigc = 6.31E-4                cigc = 0
+aigsd = 5.9E-3                bigsd = 2.48E-4               cigsd = 0.032
+dlcig = 2.52E-9               nigc = 2.28                   poxedge = 1
+pigcd = 2.28                  ntox = 1                      toxref = 3E-9
//*** capacitance parameter ***
+xpart = 1                     cgso = 3.1E-11+dcgso_p_cap        cgdo = 3.1E-11+dcgdo_p_cap
+cgbo = 0                      ckappas = 0.6                 ckappad = 0.6
+cf = 1.18E-10                 clc = 1E-7                    cle = 0.6
+dlc = 0                 dwc = 0                       noff = 2.5
+voffcv = -0.0486              acde = 1.2                    moin = 8
+cgsl = 0.54E-10+dcgsl_p_cap       cgdl = 0.54E-10+dcgdl_p_cap
//*** souce/drain junction diode model parameter **
+ijthsrev = 0.01               ijthsfwd = 0.01               xjbvs = 1
+bvs = 10                      jss = 1.51E-7                 jsws = 3.98E-13
+jswgs = 2.47E-12              cjs = 9.98E-4+dcj_p_cap           mjs = 0.34
+mjsws = 0.012                 cjsws = 6.21E-11+dcjsw_p_cap      cjswgs = 2.53E-10+dcjswg_p_cap
+mjswgs = 0.86                 pbs = 0.75                    pbsws = 0.49
+pbswgs = 0.71
//** rf model related parameter ***
+xrcrg1 = 12                   xrcrg2 = 1                    rbpb = 50
+rbpd = 50                     rbps = 50                     rbdb = 50
+rbsb = 50                     gbmin = 1E-12
//*** stress effect related parameter ***
+saref = 6.1E-7                sbref = 6.1E-7                wlod = 2.86E-7
+ku0 = 1E-7                    kvsat = -0.386                kvth0 = 2E-10
+tku0 = 0.24                   llodku0 = 1                   wlodku0 = 1
+llodvth = 1.8                 wlodvth = 1                   lku0 = 1.871E-7
+wku0 = 2.4E-7                 pku0 = -3.24E-14              lkvth0 = 2.4E-10
+wkvth0 = 1.8E-10              pkvth0 = 0                    stk2 = 0
+lodk2 = 1.9                   steta0 = 0                    lodeta0 = 1
//*** temperature coefficient ***
+tnom = 25                     ute = -1.524                  kt1 = -0.229
+kt1l = 0                      kt2 = -0.01232                ua1 = 4.549E-9
+ub1 = -5.441E-18              uc1 = -5E-11                  at = 4.00001E4
+prt = 0                       njs = 1                       xtis = 3
+tpb = 1.9E-3                  tpbsw = 1.9E-3                tpbswg = 1.9E-3
+tcj = 7.98E-4                 tcjsw = 2.4E-4                tcjswg = 4.77E-3
//*** well proximity effect model parameters ***
+web = -220                    wec = -3E3                    kvth0we = -3.197498E-3
+k2we = 3E-4                   ku0we = -3.482487E-3          scref = 1E-6
23:type=p  minr=1e-60
//*** flag parameter ***
+version = 4.3                 binunit = 2                   mobmod = 0
+capmod = 2                    rdsmod = 0                    igcmod = 1
+igbmod = 1                    rbodymod = 0                  trnqsmod = 0
+acnqsmod = 0                  fnoimod = 1                   tnoimod = 0
+diomod = 1                    permod = 1                    rgatemod = 0
+wpemod = 0
//*** geometry range parameter ***
+lmin = 6E-8                   lmax = 1E-7                   wmin = 3E-7
+wmax = 5E-7
//*** process parameter ***
+epsrox = 3.9                  toxe = tox_p_cap                  toxm = tox_p_cap
+dtox = 3.29E-10               xj = 1.7E-7                   ndep = 8.5E17
+ngate = 8E19                  nsd = 1E20                    rsh = 9.68
+rshg = 0.1
//*** dw and dl parameter ***
+wint = 1.089287E-8            wl = 0                        wln = 1
+ww = 0                        wwn = 1                       wwl = 0
+lint = 2E-24                  ll = 0                        lln = 1
+lw = 0                        lwn = 1                       lwl = 0
+llc = 0                       lwc = 0                       lwlc = 0
+wlc = 0                       wwc = 0                       wwlc = 0
+dwg = 0                       dwb = 0                       xl = 0+dxl_p_cap
+xw = 0+dxw_p_cap
//*** flicker noise model parameter ***
+noia = 1.45E42                noib = 3.57E26                noic = 2E10
+em = 2.1E7                    ef = 1.147
//***layout-dependent parasitics model parameter ***
+dmcg = 8.5E-8                 dmci = 8.5E-8                 dmdg = 0
+dmcgt = 0                     dwj = 0                       xgw = 0
+xgl = 0                       ngcon = 1
//*** vth related  parameter ***
+vth0 = -0.301242+dvth0_p_cap      lvth0 = -7.364622E-10+dlvth0_p_cap wvth0 = -2.489982E-9+dwvth0_p_cap
+pvth0 = 4.125117E-16+dpvth0_p_cap phin = 0                      k1 = 0.25
+k2 = -3.986993E-3             lk2 = -1.164464E-9            wk2 = 1.218702E-9
+pk2 = -1.602539E-17           k3 = -1.700953                k3b = 1.200306
+w0 = 1.585076E-7              lpe0 = 7.519925E-8            lpeb = 5.608072E-8
+dvtp0 = 2.2E-6                dvtp1 = 0.2                   dvt0 = 0.20341
+dvt1 = 0.95146                dvt2 = 0.01                   dvt0w = 0
+dvt1w = 5.366499E6            dvt2w = 0
//*** mobility related parameter ***
+u0 = 2.16202E-2+du0_p_cap         lu0 = -2.279875E-11+dlu0_p_cap    wu0 = 2.991554E-10+dwu0_p_cap
+pu0 = -2.631665E-17+dpu0_p_cap    ua = 3.378668E-12             wua = 2.385315E-18
+ub = 1.215498E-18             lub = 5.116405E-26            wub = -8.317472E-26
+pub = 1.822165E-33            uc = 2.247228E-11             ud = 0
+vsat = 6.475225E4+dvsat_p_cap     lvsat = 5.297925E-3           a0 = 1E-3
+ags = 2.949112                wags = -9.473542E-9           b0 = 0
+b1 = 0                        keta = 4.38547E-2             lketa = -5.885286E-9
+wketa = -8.576646E-9          pketa = -8.665787E-16         a1 = 0
+a2 = 1                        rdsw = 327.6                  prwb = -0.249981
+prwg = 0.25                   wr = 1
//*** subthreshold related parameter ***
+voff = -8.28665E-2            lvoff = 2.199332E-9           wvoff = 2.076483E-9
+pvoff = -2.47735E-16          voffl = -6.036214E-9          minv = 0
+nfactor = 0.194643            lnfactor = 5.005021E-8        wnfactor = -9.516117E-9
+pnfactor = -2.446716E-15      eta0 = 3.11538E-2             etab = -2.38505E-2
+dsub = 1.2725                 cit = 1E-4                    cdsc = 0
+cdscb = 0                     cdscd = 0
//*** output resistance related parameter ***
+pclm = 0.627258               pdiblc1 = 0                   pdiblc2 = 1.33727E-2
+lpdiblc2 = -3.565839E-10      wpdiblc2 = -3.315524E-10      ppdiblc2 = -4.935033E-17
+pdiblcb = 0                   drout = 1.132692              pscbe1 = 9.264E8
+pscbe2 = 1E-20                pvag = 1.425                  delta = 0.02
+fprout = 390.234144           pdits = 5.042617E-3           pditsl = 100
+pditsd = 0                    alpha0 = 0                    alpha1 = 0.06
+beta0 = 13.5                  agidl = 9E-8                  bgidl = 3.404E9
+cgidl = 0.5                   egidl = 0.15
//*** gate dielectric tunneling current ***
+aigbacc = 0.012               bigbacc = 3.49E-3             cigbacc = 0.131
+nigbacc = 5.2                 aigbinv = 0.347               bigbinv = 0.0312
+cigbinv = 6.1E-3              eigbinv = 1.1                 nigbinv = 1
+aigc = 7.12E-3                bigc = 6.31E-4                cigc = 0
+aigsd = 5.9E-3                bigsd = 2.48E-4               cigsd = 0.032
+dlcig = 2.52E-9               nigc = 2.28                   poxedge = 1
+pigcd = 2.28                  ntox = 1                      toxref = 3E-9
//*** capacitance parameter ***
+xpart = 1                     cgso = 3.1E-11+dcgso_p_cap        cgdo = 3.1E-11+dcgdo_p_cap
+cgbo = 0                      ckappas = 0.6                 ckappad = 0.6
+cf = 1.18E-10                 clc = 1E-7                    cle = 0.6
+dlc = 0                 dwc = 0                       noff = 2.5
+voffcv = -0.0486              acde = 1.2                    moin = 8
+cgsl = 0.54E-10+dcgsl_p_cap       cgdl = 0.54E-10+dcgdl_p_cap
//*** souce/drain junction diode model parameter **
+ijthsrev = 0.01               ijthsfwd = 0.01               xjbvs = 1
+bvs = 10                      jss = 1.51E-7                 jsws = 3.98E-13
+jswgs = 2.47E-12              cjs = 9.98E-4+dcj_p_cap           mjs = 0.34
+mjsws = 0.012                 cjsws = 6.21E-11+dcjsw_p_cap      cjswgs = 2.53E-10+dcjswg_p_cap
+mjswgs = 0.86                 pbs = 0.75                    pbsws = 0.49
+pbswgs = 0.71
//** rf model related parameter ***
+xrcrg1 = 12                   xrcrg2 = 1                    rbpb = 50
+rbpd = 50                     rbps = 50                     rbdb = 50
+rbsb = 50                     gbmin = 1E-12
//*** stress effect related parameter ***
+saref = 6.1E-7                sbref = 6.1E-7                wlod = 2.86E-7
+ku0 = 1E-7                    kvsat = -0.386                kvth0 = 2E-10
+tku0 = 0.24                   llodku0 = 1                   wlodku0 = 1
+llodvth = 1.8                 wlodvth = 1                   lku0 = 1.871E-7
+wku0 = 2.4E-7                 pku0 = -3.24E-14              lkvth0 = 2.4E-10
+wkvth0 = 1.8E-10              pkvth0 = 0                    stk2 = 0
+lodk2 = 1.9                   steta0 = 0                    lodeta0 = 1
//*** temperature coefficient ***
+tnom = 25                     ute = -1.524                  kt1 = -0.229
+kt1l = 0                      kt2 = -0.01232                ua1 = 4.549E-9
+ub1 = -5.441E-18              uc1 = -5E-11                  at = 4.00001E4
+prt = 0                       njs = 1                       xtis = 3
+tpb = 1.9E-3                  tpbsw = 1.9E-3                tpbswg = 1.9E-3
+tcj = 7.98E-4                 tcjsw = 2.4E-4                tcjswg = 4.77E-3
//*** well proximity effect model parameters ***
+web = -220                    wec = -3E3                    kvth0we = -3.197498E-3
+k2we = 3E-4                   ku0we = -3.482487E-3          scref = 1E-6
24:type=p  minr=1e-60
//*** flag parameter ***
+version = 4.3                 binunit = 2                   mobmod = 0
+capmod = 2                    rdsmod = 0                    igcmod = 1
+igbmod = 1                    rbodymod = 0                  trnqsmod = 0
+acnqsmod = 0                  fnoimod = 1                   tnoimod = 0
+diomod = 1                    permod = 1                    rgatemod = 0
+wpemod = 0
//*** geometry range parameter ***
+lmin = 4E-8                   lmax = 6E-8                   wmin = 3E-7
+wmax = 5E-7
//*** process parameter ***
+epsrox = 3.9                  toxe = tox_p_cap                  toxm = tox_p_cap
+dtox = 3.29E-10               xj = 1.7E-7                   ndep = 8.5E17
+ngate = 8E19                  nsd = 1E20                    rsh = 9.68
+rshg = 0.1
//*** dw and dl parameter ***
+wint = 1.089287E-8            wl = 0                        wln = 1
+ww = 0                        wwn = 1                       wwl = 0
+lint = 2E-24                  ll = 0                        lln = 1
+lw = 0                        lwn = 1                       lwl = 0
+llc = 0                       lwc = 0                       lwlc = 0
+wlc = 0                       wwc = 0                       wwlc = 0
+dwg = 0                       dwb = 0                       xl = 0+dxl_p_cap
+xw = 0+dxw_p_cap
//*** flicker noise model parameter ***
+noia = 1.45E42                noib = 3.57E26                noic = 2E10
+em = 2.1E7                    ef = 1.147
//***layout-dependent parasitics model parameter ***
+dmcg = 8.5E-8                 dmci = 8.5E-8                 dmdg = 0
+dmcgt = 0                     dwj = 0                       xgw = 0
+xgl = 0                       ngcon = 1
//*** vth related  parameter ***
+vth0 = -0.363005+dvth0_p_cap      lvth0 = 2.969312E-9+dlvth0_p_cap  wvth0 = 4.355781E-9+dwvth0_p_cap
+pvth0 = 1.760766E-18+dpvth0_p_cap phin = 0                      k1 = 0.25
+k2 = -1.59612E-2              lk2 = -4.460132E-10           wk2 = 1.687223E-9
+pk2 = -4.413669E-17           k3 = -1.700953                k3b = 1.200306
+w0 = 1.585076E-7              lpe0 = 7.519925E-8            lpeb = 5.608072E-8
+dvtp0 = 2.2E-6                dvtp1 = 0.2                   dvt0 = 0.20341
+dvt1 = 0.95146                dvt2 = 0.01                   dvt0w = 0
+dvt1w = 5.366499E6            dvt2w = 0
//*** mobility related parameter ***
+u0 = 2.77547E-2+du0_p_cap         lu0 = -3.908753E-10+dlu0_p_cap    wu0 = -3.430577E-10+dwu0_p_cap
+pu0 = 1.2219E-17+dpu0_p_cap       ua = 3.378668E-12             wua = 2.385315E-18
+ub = 1.790032E-18             lub = 1.669197E-26            wub = -4.150437E-26
+pub = -6.780558E-34           uc = 2.247228E-11             ud = 0
+vsat = 1.234994E5+dvsat_p_cap     lvsat = 1.773095E-3           wvsat = -3.991381E-3
+pvsat = 2.394828E-10          a0 = 1E-3                     ags = 2.949112
+wags = -9.473542E-9           b0 = 0                        b1 = 0
+keta = 0.145602               lketa = -1.199014E-8          wketa = -3.308589E-8
+pketa = 6.039757E-16          a1 = 0                        a2 = 1
+rdsw = 327.6                  prwb = -0.249981              prwg = 0.25
+wr = 1
//*** subthreshold related parameter ***
+voff = -0.104307              lvoff = 3.485746E-9           wvoff = -2.121885E-9
+pvoff = 4.167002E-18          voffl = -6.036214E-9          minv = 0
+nfactor = 0.411527            lnfactor = 3.703715E-8        wnfactor = -2.011855E-8
+pnfactor = -1.81057E-15       eta0 = 3.11538E-2             etab = 2.57253E-2
+letab = -2.974547E-9          wetab = 3.510486E-8           petab = -2.106292E-15
+dsub = 1.2725                 cit = 1E-4                    cdsc = 0
+cdscb = 0                     cdscd = 0
//*** output resistance related parameter ***
+pclm = 0.627258               pdiblc1 = 0                   pdiblc2 = 1.63451E-2
+lpdiblc2 = -5.349321E-10      wpdiblc2 = -2.538927E-9       ppdiblc2 = 8.309217E-17
+pdiblcb = 0                   drout = 1.132692              pscbe1 = 9.264E8
+pscbe2 = 1E-20                pvag = 1.425                  delta = 0.02
+fprout = 390.234144           pdits = 5.042617E-3           pditsl = 100
+pditsd = 0                    alpha0 = 0                    alpha1 = 0.06
+beta0 = 13.5                  agidl = 9E-8                  bgidl = 3.404E9
+cgidl = 0.5                   egidl = 0.15
//*** gate dielectric tunneling current ***
+aigbacc = 0.012               bigbacc = 3.49E-3             cigbacc = 0.131
+nigbacc = 5.2                 aigbinv = 0.347               bigbinv = 0.0312
+cigbinv = 6.1E-3              eigbinv = 1.1                 nigbinv = 1
+aigc = 7.12E-3                bigc = 6.31E-4                cigc = 0
+aigsd = 5.9E-3                bigsd = 2.48E-4               cigsd = 0.032
+dlcig = 2.52E-9               nigc = 2.28                   poxedge = 1
+pigcd = 2.28                  ntox = 1                      toxref = 3E-9
//*** capacitance parameter ***
+xpart = 1                     cgso = 3.1E-11+dcgso_p_cap        cgdo = 3.1E-11+dcgdo_p_cap
+cgbo = 0                      ckappas = 0.6                 ckappad = 0.6
+cf = 1.18E-10                 clc = 1E-7                    cle = 0.6
+dlc = 0                 dwc = 0                       noff = 2.5
+voffcv = -0.0486              acde = 1.2                    moin = 8
+cgsl = 0.54E-10+dcgsl_p_cap       cgdl = 0.54E-10+dcgdl_p_cap
//*** souce/drain junction diode model parameter **
+ijthsrev = 0.01               ijthsfwd = 0.01               xjbvs = 1
+bvs = 10                      jss = 1.51E-7                 jsws = 3.98E-13
+jswgs = 2.47E-12              cjs = 9.98E-4+dcj_p_cap           mjs = 0.34
+mjsws = 0.012                 cjsws = 6.21E-11+dcjsw_p_cap      cjswgs = 2.53E-10+dcjswg_p_cap
+mjswgs = 0.86                 pbs = 0.75                    pbsws = 0.49
+pbswgs = 0.71
//** rf model related parameter ***
+xrcrg1 = 12                   xrcrg2 = 1                    rbpb = 50
+rbpd = 50                     rbps = 50                     rbdb = 50
+rbsb = 50                     gbmin = 1E-12
//*** stress effect related parameter ***
+saref = 6.1E-7                sbref = 6.1E-7                wlod = 2.86E-7
+ku0 = 1E-7                    kvsat = -0.386                kvth0 = 2E-10
+tku0 = 0.24                   llodku0 = 1                   wlodku0 = 1
+llodvth = 1.8                 wlodvth = 1                   lku0 = 1.871E-7
+wku0 = 2.4E-7                 pku0 = -3.24E-14              lkvth0 = 2.4E-10
+wkvth0 = 1.8E-10              pkvth0 = 0                    stk2 = 0
+lodk2 = 1.9                   steta0 = 0                    lodeta0 = 1
//*** temperature coefficient ***
+tnom = 25                     ute = -1.524                  kt1 = -0.229
+kt1l = 0                      kt2 = -0.01232                ua1 = 4.549E-9
+ub1 = -5.441E-18              uc1 = -5E-11                  at = 4.00001E4
+prt = 0                       njs = 1                       xtis = 3
+tpb = 1.9E-3                  tpbsw = 1.9E-3                tpbswg = 1.9E-3
+tcj = 7.98E-4                 tcjsw = 2.4E-4                tcjswg = 4.77E-3
//*** well proximity effect model parameters ***
+web = -220                    wec = -3E3                    kvth0we = -3.197498E-3
+k2we = 3E-4                   ku0we = -3.482487E-3          scref = 1E-6
25:type=p  minr=1e-60
//*** flag parameter ***
+version = 4.3                 binunit = 2                   mobmod = 0
+capmod = 2                    rdsmod = 0                    igcmod = 1
+igbmod = 1                    rbodymod = 0                  trnqsmod = 0
+acnqsmod = 0                  fnoimod = 1                   tnoimod = 0
+diomod = 1                    permod = 1                    rgatemod = 0
+wpemod = 0
//*** geometry range parameter ***
+lmin = 2E-6                   lmax = 1E-5                   wmin = 1.2E-7
+wmax = 3E-7
//*** process parameter ***
+epsrox = 3.9                  toxe = tox_p_cap                  toxm = tox_p_cap
+dtox = 3.29E-10               xj = 1.7E-7                   ndep = 8.5E17
+ngate = 8E19                  nsd = 1E20                    rsh = 9.68
+rshg = 0.1
//*** dw and dl parameter ***
+wint = 1.089287E-8            wl = 0                        wln = 1
+ww = 0                        wwn = 1                       wwl = 0
+lint = 2E-24                  ll = 0                        lln = 1
+lw = 0                        lwn = 1                       lwl = 0
+llc = 0                       lwc = 0                       lwlc = 0
+wlc = 0                       wwc = 0                       wwlc = 0
+dwg = 0                       dwb = 0                       xl = 0+dxl_p_cap
+xw = 0+dxw_p_cap
//*** flicker noise model parameter ***
+noia = 1.45E42                noib = 3.57E26                noic = 2E10
+em = 2.1E7                    ef = 1.147
//***layout-dependent parasitics model parameter ***
+dmcg = 8.5E-8                 dmci = 8.5E-8                 dmdg = 0
+dmcgt = 0                     dwj = 0                       xgw = 0
+xgl = 0                       ngcon = 1
//*** vth related  parameter ***
+vth0 = -0.278429+dvth0_p_cap      lvth0 = -3.137639E-9+dlvth0_p_cap wvth0 = -3.081609E-11+dwvth0_p_cap
+pvth0 = 3.081609E-16+dpvth0_p_cap phin = 0                      k1 = 0.25
+k2 = -7.891912E-3             lk2 = -5.393964E-9            wk2 = -5.297642E-11
+pk2 = 5.297642E-16            k3 = -1.700953                k3b = 1.200306
+w0 = 1.585076E-7              lpe0 = 7.519925E-8            lpeb = 5.608072E-8
+dvtp0 = 2.2E-6                dvtp1 = 0.2                   dvt0 = 0.20341
+dvt1 = 0.95146                dvt2 = 0.01                   dvt0w = 0
+dvt1w = 5.366499E6            dvt2w = 0
//*** mobility related parameter ***
+u0 = 1.92035E-2+du0_p_cap         lu0 = 3.906592E-10+dlu0_p_cap     wu0 = 4.552849E-10+dwu0_p_cap
+pu0 = -3.83683E-17+dpu0_p_cap     ua = 1.195233E-11             ub = 1.200175E-18
+lub = -5.010175E-26           wub = -4.726483E-26           pub = 4.920706E-33
+uc = 5.737161E-11             luc = -4.00267E-17            wuc = -2.245237E-18
+puc = 1.566444E-24            ud = 0                        vsat = 1.177315E5+dvsat_p_cap
+a0 = 2.712976                 la0 = -8.671005E-7            wa0 = 2.483048E-9
+pa0 = -2.483048E-14           ags = 1.174967                lags = 6.271594E-7
+wags = -1.847219E-9           pags = 1.847219E-14           b0 = 0
+b1 = 0                        keta = -0.11312               lketa = 6.167879E-8
+wketa = 3.425986E-9           pketa = -3.899184E-15         a1 = 0
+a2 = 1                        rdsw = 327.6                  prwb = -0.249981
+prwg = 0.25                   wr = 1
//*** subthreshold related parameter ***
+voff = -4.09858E-2            lvoff = -1.46997E-9           wvoff = 9.829269E-11
+pvoff = 7.058857E-17          voffl = -6.036214E-9          minv = 0
+nfactor = 0.298047            lnfactor = 8.664679E-8        wnfactor = -1.465514E-8
+pnfactor = -2.845934E-15      eta0 = 3.11538E-2             etab = -2.38505E-2
+dsub = 1.2725                 cit = 1E-4                    cdsc = 0
+cdscb = 0                     cdscd = 0
//*** output resistance related parameter ***
+pclm = 0.627258               pdiblc1 = 0                   pdiblc2 = 1.15757E-2
+lpdiblc2 = -4.747329E-10      wpdiblc2 = 3.206467E-11       ppdiblc2 = -3.206467E-16
+pdiblcb = 0                   drout = 1.132692              pscbe1 = 9.264E8
+pscbe2 = 1E-20                pvag = 1.425                  delta = 0.02
+fprout = 390.234144           pdits = 5.042617E-3           pditsl = 100
+pditsd = 0                    alpha0 = 0                    alpha1 = 0.06
+beta0 = 13.5                  agidl = 9E-8                  bgidl = 3.404E9
+cgidl = 0.5                   egidl = 0.15
//*** gate dielectric tunneling current ***
+aigbacc = 0.012               bigbacc = 3.49E-3             cigbacc = 0.131
+nigbacc = 5.2                 aigbinv = 0.347               bigbinv = 0.0312
+cigbinv = 6.1E-3              eigbinv = 1.1                 nigbinv = 1
+aigc = 7.12E-3                bigc = 6.31E-4                cigc = 0
+aigsd = 5.9E-3                bigsd = 2.48E-4               cigsd = 0.032
+dlcig = 2.52E-9               nigc = 2.28                   poxedge = 1
+pigcd = 2.28                  ntox = 1                      toxref = 3E-9
//*** capacitance parameter ***
+xpart = 1                     cgso = 3.1E-11+dcgso_p_cap        cgdo = 3.1E-11+dcgdo_p_cap
+cgbo = 0                      ckappas = 0.6                 ckappad = 0.6
+cf = 1.18E-10                 clc = 1E-7                    cle = 0.6
+dlc = 0                 dwc = 0                       noff = 2.5
+voffcv = -0.0486              acde = 1.2                    moin = 8
+cgsl = 0.54E-10+dcgsl_p_cap       cgdl = 0.54E-10+dcgdl_p_cap
//*** souce/drain junction diode model parameter **
+ijthsrev = 0.01               ijthsfwd = 0.01               xjbvs = 1
+bvs = 10                      jss = 1.51E-7                 jsws = 3.98E-13
+jswgs = 2.47E-12              cjs = 9.98E-4+dcj_p_cap           mjs = 0.34
+mjsws = 0.012                 cjsws = 6.21E-11+dcjsw_p_cap      cjswgs = 2.53E-10+dcjswg_p_cap
+mjswgs = 0.86                 pbs = 0.75                    pbsws = 0.49
+pbswgs = 0.71
//** rf model related parameter ***
+xrcrg1 = 12                   xrcrg2 = 1                    rbpb = 50
+rbpd = 50                     rbps = 50                     rbdb = 50
+rbsb = 50                     gbmin = 1E-12
//*** stress effect related parameter ***
+saref = 6.1E-7                sbref = 6.1E-7                wlod = 2.86E-7
+ku0 = 1E-7                    kvsat = -0.386                kvth0 = 2E-10
+tku0 = 0.24                   llodku0 = 1                   wlodku0 = 1
+llodvth = 1.8                 wlodvth = 1                   lku0 = 1.871E-7
+wku0 = 2.4E-7                 pku0 = -3.24E-14              lkvth0 = 2.4E-10
+wkvth0 = 1.8E-10              pkvth0 = 0                    stk2 = 0
+lodk2 = 1.9                   steta0 = 0                    lodeta0 = 1
//*** temperature coefficient ***
+tnom = 25                     ute = -1.524                  kt1 = -0.229
+kt1l = 0                      kt2 = -0.01232                ua1 = 4.549E-9
+ub1 = -5.441E-18              uc1 = -5E-11                  at = 4.00001E4
+prt = 0                       njs = 1                       xtis = 3
+tpb = 1.9E-3                  tpbsw = 1.9E-3                tpbswg = 1.9E-3
+tcj = 7.98E-4                 tcjsw = 2.4E-4                tcjswg = 4.77E-3
//*** well proximity effect model parameters ***
+web = -220                    wec = -3E3                    kvth0we = -3.197498E-3
+k2we = 3E-4                   ku0we = -3.482487E-3          scref = 1E-6
26:type=p  minr=1e-60
//*** flag parameter ***
+version = 4.3                 binunit = 2                   mobmod = 0
+capmod = 2                    rdsmod = 0                    igcmod = 1
+igbmod = 1                    rbodymod = 0                  trnqsmod = 0
+acnqsmod = 0                  fnoimod = 1                   tnoimod = 0
+diomod = 1                    permod = 1                    rgatemod = 0
+wpemod = 0
//*** geometry range parameter ***
+lmin = 1E-6                   lmax = 2E-6                   wmin = 1.2E-7
+wmax = 3E-7
//*** process parameter ***
+epsrox = 3.9                  toxe = tox_p_cap                  toxm = tox_p_cap
+dtox = 3.29E-10               xj = 1.7E-7                   ndep = 8.5E17
+ngate = 8E19                  nsd = 1E20                    rsh = 9.68
+rshg = 0.1
//*** dw and dl parameter ***
+wint = 1.089287E-8            wl = 0                        wln = 1
+ww = 0                        wwn = 1                       wwl = 0
+lint = 2E-24                  ll = 0                        lln = 1
+lw = 0                        lwn = 1                       lwl = 0
+llc = 0                       lwc = 0                       lwlc = 0
+wlc = 0                       wwc = 0                       wwlc = 0
+dwg = 0                       dwb = 0                       xl = 0+dxl_p_cap
+xw = 0+dxw_p_cap
//*** flicker noise model parameter ***
+noia = 1.45E42                noib = 3.57E26                noic = 2E10
+em = 2.1E7                    ef = 1.147
//***layout-dependent parasitics model parameter ***
+dmcg = 8.5E-8                 dmci = 8.5E-8                 dmdg = 0
+dmcgt = 0                     dwj = 0                       xgw = 0
+xgl = 0                       ngcon = 1
//*** vth related  parameter ***
+vth0 = -0.27786+dvth0_p_cap       lvth0 = -4.275484E-9+dlvth0_p_cap wvth0 = 3.430756E-11+dwvth0_p_cap
+pvth0 = 1.779136E-16+dpvth0_p_cap phin = 0                      k1 = 0.25
+k2 = -1.16802E-2              lk2 = 2.18253E-9              wk2 = 5.155112E-10
+pk2 = -6.072111E-16           k3 = -1.700953                k3b = 1.200306
+w0 = 1.585076E-7              lpe0 = 7.519925E-8            lpeb = 5.608072E-8
+dvtp0 = 2.2E-6                dvtp1 = 0.2                   dvt0 = 0.20341
+dvt1 = 0.95146                dvt2 = 0.01                   dvt0w = 0
+dvt1w = 5.366499E6            dvt2w = 0
//*** mobility related parameter ***
+u0 = 1.93673E-2+du0_p_cap         lu0 = 6.298573E-11+dlu0_p_cap     wu0 = 4.300893E-10+dwu0_p_cap
+pu0 = 1.202283E-17+dpu0_p_cap     ua = 1.195233E-11             ub = 1.175124E-18
+wub = -4.480448E-26           uc = 4.635864E-11             luc = -1.800077E-17
+wuc = -1.286575E-18           puc = -3.508814E-25           ud = 0
+vsat = 1.177315E5+dvsat_p_cap     a0 = 2.279426                 wa0 = -9.932191E-9
+ags = 1.041984                lags = 8.931262E-7            wags = 5.172093E-9
+pags = 4.433569E-15           b0 = 0                        b1 = 0
+keta = -8.22802E-2            wketa = 1.476394E-9           a1 = 0
+a2 = 1                        rdsw = 327.6                  prwb = -0.249981
+prwg = 0.25                   wr = 1
//*** subthreshold related parameter ***
+voff = -4.13972E-2            lvoff = -6.471446E-10         wvoff = 1.952191E-10
+pvoff = -1.232643E-16         voffl = -6.036214E-9          minv = 0
+nfactor = 0.302568            lnfactor = 7.76038E-8         wnfactor = -1.577738E-8
+pnfactor = -6.01445E-16       eta0 = 3.11538E-2             etab = -2.38505E-2
+dsub = 1.2725                 cit = 1E-4                    cdsc = 0
+cdscb = 0                     cdscd = 0
//*** output resistance related parameter ***
+pclm = 0.627258               pdiblc1 = 0                   pdiblc2 = 1.14534E-2
+lpdiblc2 = -2.302554E-10      wpdiblc2 = -1.898908E-10      ppdiblc2 = 1.232643E-16
+pdiblcb = 0                   drout = 1.132692              pscbe1 = 9.264E8
+pscbe2 = 1E-20                pvag = 1.425                  delta = 0.02
+fprout = 390.234144           pdits = 5.042617E-3           pditsl = 100
+pditsd = 0                    alpha0 = 0                    alpha1 = 0.06
+beta0 = 13.5                  agidl = 9E-8                  bgidl = 3.404E9
+cgidl = 0.5                   egidl = 0.15
//*** gate dielectric tunneling current ***
+aigbacc = 0.012               bigbacc = 3.49E-3             cigbacc = 0.131
+nigbacc = 5.2                 aigbinv = 0.347               bigbinv = 0.0312
+cigbinv = 6.1E-3              eigbinv = 1.1                 nigbinv = 1
+aigc = 7.12E-3                bigc = 6.31E-4                cigc = 0
+aigsd = 5.9E-3                bigsd = 2.48E-4               cigsd = 0.032
+dlcig = 2.52E-9               nigc = 2.28                   poxedge = 1
+pigcd = 2.28                  ntox = 1                      toxref = 3E-9
//*** capacitance parameter ***
+xpart = 1                     cgso = 3.1E-11+dcgso_p_cap        cgdo = 3.1E-11+dcgdo_p_cap
+cgbo = 0                      ckappas = 0.6                 ckappad = 0.6
+cf = 1.18E-10                 clc = 1E-7                    cle = 0.6
+dlc = 0                 dwc = 0                       noff = 2.5
+voffcv = -0.0486              acde = 1.2                    moin = 8
+cgsl = 0.54E-10+dcgsl_p_cap       cgdl = 0.54E-10+dcgdl_p_cap
//*** souce/drain junction diode model parameter **
+ijthsrev = 0.01               ijthsfwd = 0.01               xjbvs = 1
+bvs = 10                      jss = 1.51E-7                 jsws = 3.98E-13
+jswgs = 2.47E-12              cjs = 9.98E-4+dcj_p_cap           mjs = 0.34
+mjsws = 0.012                 cjsws = 6.21E-11+dcjsw_p_cap      cjswgs = 2.53E-10+dcjswg_p_cap
+mjswgs = 0.86                 pbs = 0.75                    pbsws = 0.49
+pbswgs = 0.71
//** rf model related parameter ***
+xrcrg1 = 12                   xrcrg2 = 1                    rbpb = 50
+rbpd = 50                     rbps = 50                     rbdb = 50
+rbsb = 50                     gbmin = 1E-12
//*** stress effect related parameter ***
+saref = 6.1E-7                sbref = 6.1E-7                wlod = 2.86E-7
+ku0 = 1E-7                    kvsat = -0.386                kvth0 = 2E-10
+tku0 = 0.24                   llodku0 = 1                   wlodku0 = 1
+llodvth = 1.8                 wlodvth = 1                   lku0 = 1.871E-7
+wku0 = 2.4E-7                 pku0 = -3.24E-14              lkvth0 = 2.4E-10
+wkvth0 = 1.8E-10              pkvth0 = 0                    stk2 = 0
+lodk2 = 1.9                   steta0 = 0                    lodeta0 = 1
//*** temperature coefficient ***
+tnom = 25                     ute = -1.524                  kt1 = -0.229
+kt1l = 0                      kt2 = -0.01232                ua1 = 4.549E-9
+ub1 = -5.441E-18              uc1 = -5E-11                  at = 4.00001E4
+prt = 0                       njs = 1                       xtis = 3
+tpb = 1.9E-3                  tpbsw = 1.9E-3                tpbswg = 1.9E-3
+tcj = 7.98E-4                 tcjsw = 2.4E-4                tcjswg = 4.77E-3
//*** well proximity effect model parameters ***
+web = -220                    wec = -3E3                    kvth0we = -3.197498E-3
+k2we = 3E-4                   ku0we = -3.482487E-3          scref = 1E-6
27:type=p  minr=1e-60
//*** flag parameter ***
+version = 4.3                 binunit = 2                   mobmod = 0
+capmod = 2                    rdsmod = 0                    igcmod = 1
+igbmod = 1                    rbodymod = 0                  trnqsmod = 0
+acnqsmod = 0                  fnoimod = 1                   tnoimod = 0
+diomod = 1                    permod = 1                    rgatemod = 0
+wpemod = 0
//*** geometry range parameter ***
+lmin = 5E-7                   lmax = 1E-6                   wmin = 1.2E-7
+wmax = 3E-7
//*** process parameter ***
+epsrox = 3.9                  toxe = tox_p_cap                  toxm = tox_p_cap
+dtox = 3.29E-10               xj = 1.7E-7                   ndep = 8.5E17
+ngate = 8E19                  nsd = 1E20                    rsh = 9.68
+rshg = 0.1
//*** dw and dl parameter ***
+wint = 1.089287E-8            wl = 0                        wln = 1
+ww = 0                        wwn = 1                       wwl = 0
+lint = 2E-24                  ll = 0                        lln = 1
+lw = 0                        lwn = 1                       lwl = 0
+llc = 0                       lwc = 0                       lwlc = 0
+wlc = 0                       wwc = 0                       wwlc = 0
+dwg = 0                       dwb = 0                       xl = 0+dxl_p_cap
+xw = 0+dxw_p_cap
//*** flicker noise model parameter ***
+noia = 1.45E42                noib = 3.57E26                noic = 2E10
+em = 2.1E7                    ef = 1.147
//***layout-dependent parasitics model parameter ***
+dmcg = 8.5E-8                 dmci = 8.5E-8                 dmdg = 0
+dmcgt = 0                     dwj = 0                       xgw = 0
+xgl = 0                       ngcon = 1
//*** vth related  parameter ***
+vth0 = -0.281659+dvth0_p_cap      lvth0 = -4.763392E-10+dlvth0_p_cap wvth0 = 7.969677E-11+dwvth0_p_cap
+pvth0 = 1.325243E-16+dpvth0_p_cap phin = 0                      k1 = 0.25
+k2 = -1.11124E-2              lk2 = 1.614806E-9             wk2 = 3.575622E-10
+pk2 = -4.492621E-16           k3 = -1.700953                k3b = 1.200306
+w0 = 1.585076E-7              lpe0 = 7.519925E-8            lpeb = 5.608072E-8
+dvtp0 = 2.2E-6                dvtp1 = 0.2                   dvt0 = 0.20341
+dvt1 = 0.95146                dvt2 = 0.01                   dvt0w = 0
+dvt1w = 5.366499E6            dvt2w = 0
//*** mobility related parameter ***
+u0 = 1.93511E-2+du0_p_cap         lu0 = 7.920957E-11+dlu0_p_cap     wu0 = 3.965711E-10+dwu0_p_cap
+pu0 = 4.554101E-17+dpu0_p_cap     ua = 1.195233E-11             ub = 1.06643E-18
+lub = 1.086942E-25            wub = -5.209502E-26           pub = 7.290539E-33
+uc = 2.835787E-11             wuc = -1.637456E-18           ud = 0
+vsat = 1.177315E5+dvsat_p_cap     a0 = 2.795285                 la0 = -5.158595E-7
+wa0 = 3.381936E-8             pa0 = -4.375155E-14           ags = 1.265817
+lags = 6.692929E-7            wags = -6.721823E-8           pags = 7.682389E-14
+b0 = 0                        b1 = 0                        keta = -8.22802E-2
+wketa = 1.476394E-9           a1 = 0                        a2 = 1
+rdsw = 327.6                  prwb = -0.249981              prwg = 0.25
+wr = 1
//*** subthreshold related parameter ***
+voff = -4.11305E-2            lvoff = -9.13785E-10          wvoff = 1.229E-10
+pvoff = -5.094521E-17         voffl = -6.036214E-9          minv = 0
+nfactor = 0.312731            lnfactor = 6.74408E-8         wnfactor = -1.593875E-8
+pnfactor = -4.40078E-16       eta0 = 3.11538E-2             etab = -2.38505E-2
+dsub = 1.2725                 cit = 1E-4                    cdsc = 0
+cdscb = 0                     cdscd = 0
//*** output resistance related parameter ***
+pclm = 0.627258               pdiblc1 = 0                   pdiblc2 = 1.09634E-2
+lpdiblc2 = 2.597392E-10       wpdiblc2 = 2.695785E-10       ppdiblc2 = -3.36205E-16
+pdiblcb = 0                   drout = 1.132692              pscbe1 = 9.264E8
+pscbe2 = 1E-20                pvag = 1.425                  delta = 0.02
+fprout = 390.234144           pdits = 5.042617E-3           pditsl = 100
+pditsd = 0                    alpha0 = 0                    alpha1 = 0.06
+beta0 = 13.5                  agidl = 9E-8                  bgidl = 3.404E9
+cgidl = 0.5                   egidl = 0.15
//*** gate dielectric tunneling current ***
+aigbacc = 0.012               bigbacc = 3.49E-3             cigbacc = 0.131
+nigbacc = 5.2                 aigbinv = 0.347               bigbinv = 0.0312
+cigbinv = 6.1E-3              eigbinv = 1.1                 nigbinv = 1
+aigc = 7.12E-3                bigc = 6.31E-4                cigc = 0
+aigsd = 5.9E-3                bigsd = 2.48E-4               cigsd = 0.032
+dlcig = 2.52E-9               nigc = 2.28                   poxedge = 1
+pigcd = 2.28                  ntox = 1                      toxref = 3E-9
//*** capacitance parameter ***
+xpart = 1                     cgso = 3.1E-11+dcgso_p_cap        cgdo = 3.1E-11+dcgdo_p_cap
+cgbo = 0                      ckappas = 0.6                 ckappad = 0.6
+cf = 1.18E-10                 clc = 1E-7                    cle = 0.6
+dlc = 0                 dwc = 0                       noff = 2.5
+voffcv = -0.0486              acde = 1.2                    moin = 8
+cgsl = 0.54E-10+dcgsl_p_cap       cgdl = 0.54E-10+dcgdl_p_cap
//*** souce/drain junction diode model parameter **
+ijthsrev = 0.01               ijthsfwd = 0.01               xjbvs = 1
+bvs = 10                      jss = 1.51E-7                 jsws = 3.98E-13
+jswgs = 2.47E-12              cjs = 9.98E-4+dcj_p_cap           mjs = 0.34
+mjsws = 0.012                 cjsws = 6.21E-11+dcjsw_p_cap      cjswgs = 2.53E-10+dcjswg_p_cap
+mjswgs = 0.86                 pbs = 0.75                    pbsws = 0.49
+pbswgs = 0.71
//** rf model related parameter ***
+xrcrg1 = 12                   xrcrg2 = 1                    rbpb = 50
+rbpd = 50                     rbps = 50                     rbdb = 50
+rbsb = 50                     gbmin = 1E-12
//*** stress effect related parameter ***
+saref = 6.1E-7                sbref = 6.1E-7                wlod = 2.86E-7
+ku0 = 1E-7                    kvsat = -0.386                kvth0 = 2E-10
+tku0 = 0.24                   llodku0 = 1                   wlodku0 = 1
+llodvth = 1.8                 wlodvth = 1                   lku0 = 1.871E-7
+wku0 = 2.4E-7                 pku0 = -3.24E-14              lkvth0 = 2.4E-10
+wkvth0 = 1.8E-10              pkvth0 = 0                    stk2 = 0
+lodk2 = 1.9                   steta0 = 0                    lodeta0 = 1
//*** temperature coefficient ***
+tnom = 25                     ute = -1.524                  kt1 = -0.229
+kt1l = 0                      kt2 = -0.01232                ua1 = 4.549E-9
+ub1 = -5.441E-18              uc1 = -5E-11                  at = 4.00001E4
+prt = 0                       njs = 1                       xtis = 3
+tpb = 1.9E-3                  tpbsw = 1.9E-3                tpbswg = 1.9E-3
+tcj = 7.98E-4                 tcjsw = 2.4E-4                tcjswg = 4.77E-3
//*** well proximity effect model parameters ***
+web = -220                    wec = -3E3                    kvth0we = -3.197498E-3
+k2we = 3E-4                   ku0we = -3.482487E-3          scref = 1E-6
28:type=p  minr=1e-60
//*** flag parameter ***
+version = 4.3                 binunit = 2                   mobmod = 0
+capmod = 2                    rdsmod = 0                    igcmod = 1
+igbmod = 1                    rbodymod = 0                  trnqsmod = 0
+acnqsmod = 0                  fnoimod = 1                   tnoimod = 0
+diomod = 1                    permod = 1                    rgatemod = 0
+wpemod = 0
//*** geometry range parameter ***
+lmin = 1E-7                   lmax = 5E-7                   wmin = 1.2E-7
+wmax = 3E-7
//*** process parameter ***
+epsrox = 3.9                  toxe = tox_p_cap                  toxm = tox_p_cap
+dtox = 3.29E-10               xj = 1.7E-7                   ndep = 8.5E17
+ngate = 8E19                  nsd = 1E20                    rsh = 9.68
+rshg = 0.1
//*** dw and dl parameter ***
+wint = 1.089287E-8            wl = 0                        wln = 1
+ww = 0                        wwn = 1                       wwl = 0
+lint = 2E-24                  ll = 0                        lln = 1
+lw = 0                        lwn = 1                       lwl = 0
+llc = 0                       lwc = 0                       lwlc = 0
+wlc = 0                       wwc = 0                       wwlc = 0
+dwg = 0                       dwb = 0                       xl = 0+dxl_p_cap
+xw = 0+dxw_p_cap
//*** flicker noise model parameter ***
+noia = 1.45E42                noib = 3.57E26                noic = 2E10
+em = 2.1E7                    ef = 1.147
//***layout-dependent parasitics model parameter ***
+dmcg = 8.5E-8                 dmci = 8.5E-8                 dmdg = 0
+dmcgt = 0                     dwj = 0                       xgw = 0
+xgl = 0                       ngcon = 1
//*** vth related  parameter ***
+vth0 = -0.276412+dvth0_p_cap      lvth0 = -3.100063E-9+dlvth0_p_cap wvth0 = 1.052377E-10+dwvth0_p_cap
+pvth0 = 1.197539E-16+dpvth0_p_cap phin = 0                      k1 = 0.25
+k2 = -7.809711E-3             lk2 = -3.655552E-11           wk2 = -4.221974E-10
+pk2 = -5.938225E-17           k3 = -1.700953                k3b = 1.200306
+w0 = 1.585076E-7              lpe0 = 7.519925E-8            lpeb = 5.608072E-8
+dvtp0 = 2.2E-6                dvtp1 = 0.2                   dvt0 = 0.20341
+dvt1 = 0.95146                dvt2 = 0.01                   dvt0w = 0
+dvt1w = 5.366499E6            dvt2w = 0
//*** mobility related parameter ***
+u0 = 1.96163E-2+du0_p_cap         lu0 = -5.338175E-11+dlu0_p_cap    wu0 = 4.399148E-10+dwu0_p_cap
+pu0 = 2.386918E-17+dpu0_p_cap     ua = 1.195233E-11             ub = 1.209676E-18
+lub = 3.707127E-26            wub = -4.086112E-26           pub = 1.673592E-33
+uc = 2.835787E-11             wuc = -1.637456E-18           ud = 0
+vsat = 1.225494E5+dvsat_p_cap     lvsat = -2.408943E-3          wvsat = -1.340405E-3
+pvsat = 6.702024E-10          a0 = 2.204208                 la0 = -2.203208E-7
+wa0 = -6.710468E-8            pa0 = 6.710468E-15            ags = 2.604403
+wags = 8.642956E-8            b0 = 0                        b1 = 0
+keta = -9.49368E-2            lketa = 6.328286E-9           wketa = 4.997633E-9
+pketa = -1.760619E-15         a1 = 0                        a2 = 1
+rdsw = 327.6                  prwb = -0.249981              prwg = 0.25
+wr = 1
//*** subthreshold related parameter ***
+voff = -3.85647E-2            lvoff = -2.196689E-9          wvoff = 1.502322E-10
+pvoff = -6.461131E-17         voffl = -6.036214E-9          minv = 0
+nfactor = 0.393899            lnfactor = 2.68568E-8         wnfactor = -1.480064E-8
+pnfactor = -1.009132E-15      eta0 = 3.11538E-2             etab = -2.38505E-2
+dsub = 1.2725                 cit = 1E-4                    cdsc = 0
+cdscb = 0                     cdscd = 0
//*** output resistance related parameter ***
+pclm = 0.627258               pdiblc1 = 0                   pdiblc2 = 1.18902E-2
+lpdiblc2 = -2.036576E-10      wpdiblc2 = -2.94019E-10       ppdiblc2 = -5.440625E-17
+pdiblcb = 0                   drout = 1.132692              pscbe1 = 9.264E8
+pscbe2 = 1E-20                pvag = 1.425                  delta = 0.02
+fprout = 390.234144           pdits = 5.042617E-3           pditsl = 100
+pditsd = 0                    alpha0 = 0                    alpha1 = 0.06
+beta0 = 13.5                  agidl = 9E-8                  bgidl = 3.404E9
+cgidl = 0.5                   egidl = 0.15
//*** gate dielectric tunneling current ***
+aigbacc = 0.012               bigbacc = 3.49E-3             cigbacc = 0.131
+nigbacc = 5.2                 aigbinv = 0.347               bigbinv = 0.0312
+cigbinv = 6.1E-3              eigbinv = 1.1                 nigbinv = 1
+aigc = 7.12E-3                bigc = 6.31E-4                cigc = 0
+aigsd = 5.9E-3                bigsd = 2.48E-4               cigsd = 0.032
+dlcig = 2.52E-9               nigc = 2.28                   poxedge = 1
+pigcd = 2.28                  ntox = 1                      toxref = 3E-9
//*** capacitance parameter ***
+xpart = 1                     cgso = 3.1E-11+dcgso_p_cap        cgdo = 3.1E-11+dcgdo_p_cap
+cgbo = 0                      ckappas = 0.6                 ckappad = 0.6
+cf = 1.18E-10                 clc = 1E-7                    cle = 0.6
+dlc = 0                 dwc = 0                       noff = 2.5
+voffcv = -0.0486              acde = 1.2                    moin = 8
+cgsl = 0.54E-10+dcgsl_p_cap       cgdl = 0.54E-10+dcgdl_p_cap
//*** souce/drain junction diode model parameter **
+ijthsrev = 0.01               ijthsfwd = 0.01               xjbvs = 1
+bvs = 10                      jss = 1.51E-7                 jsws = 3.98E-13
+jswgs = 2.47E-12              cjs = 9.98E-4+dcj_p_cap           mjs = 0.34
+mjsws = 0.012                 cjsws = 6.21E-11+dcjsw_p_cap      cjswgs = 2.53E-10+dcjswg_p_cap
+mjswgs = 0.86                 pbs = 0.75                    pbsws = 0.49
+pbswgs = 0.71
//** rf model related parameter ***
+xrcrg1 = 12                   xrcrg2 = 1                    rbpb = 50
+rbpd = 50                     rbps = 50                     rbdb = 50
+rbsb = 50                     gbmin = 1E-12
//*** stress effect related parameter ***
+saref = 6.1E-7                sbref = 6.1E-7                wlod = 2.86E-7
+ku0 = 1E-7                    kvsat = -0.386                kvth0 = 2E-10
+tku0 = 0.24                   llodku0 = 1                   wlodku0 = 1
+llodvth = 1.8                 wlodvth = 1                   lku0 = 1.871E-7
+wku0 = 2.4E-7                 pku0 = -3.24E-14              lkvth0 = 2.4E-10
+wkvth0 = 1.8E-10              pkvth0 = 0                    stk2 = 0
+lodk2 = 1.9                   steta0 = 0                    lodeta0 = 1
//*** temperature coefficient ***
+tnom = 25                     ute = -1.524                  kt1 = -0.229
+kt1l = 0                      kt2 = -0.01232                ua1 = 4.549E-9
+ub1 = -5.441E-18              uc1 = -5E-11                  at = 4.00001E4
+prt = 0                       njs = 1                       xtis = 3
+tpb = 1.9E-3                  tpbsw = 1.9E-3                tpbswg = 1.9E-3
+tcj = 7.98E-4                 tcjsw = 2.4E-4                tcjswg = 4.77E-3
//*** well proximity effect model parameters ***
+web = -220                    wec = -3E3                    kvth0we = -3.197498E-3
+k2we = 3E-4                   ku0we = -3.482487E-3          scref = 1E-6
29:type=p  minr=1e-60
//*** flag parameter ***
+version = 4.3                 binunit = 2                   mobmod = 0
+capmod = 2                    rdsmod = 0                    igcmod = 1
+igbmod = 1                    rbodymod = 0                  trnqsmod = 0
+acnqsmod = 0                  fnoimod = 1                   tnoimod = 0
+diomod = 1                    permod = 1                    rgatemod = 0
+wpemod = 0
//*** geometry range parameter ***
+lmin = 6E-8                   lmax = 1E-7                   wmin = 1.2E-7
+wmax = 3E-7
//*** process parameter ***
+epsrox = 3.9                  toxe = tox_p_cap                  toxm = tox_p_cap
+dtox = 3.29E-10               xj = 1.7E-7                   ndep = 8.5E17
+ngate = 8E19                  nsd = 1E20                    rsh = 9.68
+rshg = 0.1
//*** dw and dl parameter ***
+wint = 1.089287E-8            wl = 0                        wln = 1
+ww = 0                        wwn = 1                       wwl = 0
+lint = 2E-24                  ll = 0                        lln = 1
+lw = 0                        lwn = 1                       lwl = 0
+llc = 0                       lwc = 0                       lwlc = 0
+wlc = 0                       wwc = 0                       wwlc = 0
+dwg = 0                       dwb = 0                       xl = 0+dxl_p_cap
+xw = 0+dxw_p_cap
//*** flicker noise model parameter ***
+noia = 1.45E42                noib = 3.57E26                noic = 2E10
+em = 2.1E7                    ef = 1.147
//***layout-dependent parasitics model parameter ***
+dmcg = 8.5E-8                 dmci = 8.5E-8                 dmdg = 0
+dmcgt = 0                     dwj = 0                       xgw = 0
+xgl = 0                       ngcon = 1
//*** vth related  parameter ***
+vth0 = -0.324011+dvth0_p_cap      lvth0 = 1.659806E-9+dlvth0_p_cap  wvth0 = 3.84442E-9+dwvth0_p_cap
+pvth0 = -2.541644E-16+dpvth0_p_cap phin = 0                      k1 = 0.25
+k2 = -5.319755E-3             lk2 = -2.855511E-10           wk2 = 1.589495E-9
+pk2 = -2.605515E-16           k3 = -1.700953                k3b = 1.200306
+w0 = 1.585076E-7              lpe0 = 7.519925E-8            lpeb = 5.608072E-8
+dvtp0 = 2.2E-6                dvtp1 = 0.2                   dvt0 = 0.20341
+dvt1 = 0.95146                dvt2 = 0.01                   dvt0w = 0
+dvt1w = 5.366499E6            dvt2w = 0
//*** mobility related parameter ***
+u0 = 2.12229E-2+du0_p_cap         lu0 = -2.14041E-10+dlu0_p_cap     wu0 = 4.097097E-10+dwu0_p_cap
+pu0 = 2.688969E-17+dpu0_p_cap     ua = 1.195233E-11             ub = 1.016076E-18
+lub = 5.64312E-26             wub = -2.769288E-26           pub = 3.567683E-34
+uc = 2.835787E-11             wuc = -1.637456E-18           ud = 0
+vsat = 1.657338E4+dvsat_p_cap     lvsat = 8.188657E-3           wvsat = 0.013404
+pvsat = -8.042429E-10         a0 = 1E-3                     ags = 2.604403
+wags = 8.642956E-8            b0 = 0                        b1 = 0
+keta = 0.152975               lketa = -1.84629E-8           wketa = -3.893548E-8
+pketa = 2.632692E-15          a1 = 0                        a2 = 1
+rdsw = 327.6                  prwb = -0.249981              prwg = 0.25
+wr = 1
//*** subthreshold related parameter ***
+voff = -0.086049              lvoff = 2.551746E-9           wvoff = 2.961934E-9
+pvoff = -3.457815E-16         voffl = -6.036214E-9          minv = 0
+nfactor = 0.18549             lnfactor = 4.769772E-8        wnfactor = -6.969748E-9
+pnfactor = -1.792221E-15      eta0 = 3.11538E-2             etab = -2.38505E-2
+dsub = 1.2725                 cit = 1E-4                    cdsc = 0
+cdscb = 0                     cdscd = 0
//*** output resistance related parameter ***
+pclm = 0.627258               pdiblc1 = 0                   pdiblc2 = 1.74584E-2
+lpdiblc2 = -7.60473E-10       wpdiblc2 = -1.468255E-9       ppdiblc2 = 6.301736E-17
+pdiblcb = 0                   drout = 1.132692              pscbe1 = 9.264E8
+pscbe2 = 1E-20                pvag = 1.425                  delta = 0.02
+fprout = 390.234144           pdits = 5.042617E-3           pditsl = 100
+pditsd = 0                    alpha0 = 0                    alpha1 = 0.06
+beta0 = 13.5                  agidl = 9E-8                  bgidl = 3.404E9
+cgidl = 0.5                   egidl = 0.15
//*** gate dielectric tunneling current ***
+aigbacc = 0.012               bigbacc = 3.49E-3             cigbacc = 0.131
+nigbacc = 5.2                 aigbinv = 0.347               bigbinv = 0.0312
+cigbinv = 6.1E-3              eigbinv = 1.1                 nigbinv = 1
+aigc = 7.12E-3                bigc = 6.31E-4                cigc = 0
+aigsd = 5.9E-3                bigsd = 2.48E-4               cigsd = 0.032
+dlcig = 2.52E-9               nigc = 2.28                   poxedge = 1
+pigcd = 2.28                  ntox = 1                      toxref = 3E-9
//*** capacitance parameter ***
+xpart = 1                     cgso = 3.1E-11+dcgso_p_cap        cgdo = 3.1E-11+dcgdo_p_cap
+cgbo = 0                      ckappas = 0.6                 ckappad = 0.6
+cf = 1.18E-10                 clc = 1E-7                    cle = 0.6
+dlc = 0                 dwc = 0                       noff = 2.5
+voffcv = -0.0486              acde = 1.2                    moin = 8
+cgsl = 0.54E-10+dcgsl_p_cap       cgdl = 0.54E-10+dcgdl_p_cap
//*** souce/drain junction diode model parameter **
+ijthsrev = 0.01               ijthsfwd = 0.01               xjbvs = 1
+bvs = 10                      jss = 1.51E-7                 jsws = 3.98E-13
+jswgs = 2.47E-12              cjs = 9.98E-4+dcj_p_cap           mjs = 0.34
+mjsws = 0.012                 cjsws = 6.21E-11+dcjsw_p_cap      cjswgs = 2.53E-10+dcjswg_p_cap
+mjswgs = 0.86                 pbs = 0.75                    pbsws = 0.49
+pbswgs = 0.71
//** rf model related parameter ***
+xrcrg1 = 12                   xrcrg2 = 1                    rbpb = 50
+rbpd = 50                     rbps = 50                     rbdb = 50
+rbsb = 50                     gbmin = 1E-12
//*** stress effect related parameter ***
+saref = 6.1E-7                sbref = 6.1E-7                wlod = 2.86E-7
+ku0 = 1E-7                    kvsat = -0.386                kvth0 = 2E-10
+tku0 = 0.24                   llodku0 = 1                   wlodku0 = 1
+llodvth = 1.8                 wlodvth = 1                   lku0 = 1.871E-7
+wku0 = 2.4E-7                 pku0 = -3.24E-14              lkvth0 = 2.4E-10
+wkvth0 = 1.8E-10              pkvth0 = 0                    stk2 = 0
+lodk2 = 1.9                   steta0 = 0                    lodeta0 = 1
//*** temperature coefficient ***
+tnom = 25                     ute = -1.524                  kt1 = -0.229
+kt1l = 0                      kt2 = -0.01232                ua1 = 4.549E-9
+ub1 = -5.441E-18              uc1 = -5E-11                  at = 4.00001E4
+prt = 0                       njs = 1                       xtis = 3
+tpb = 1.9E-3                  tpbsw = 1.9E-3                tpbswg = 1.9E-3
+tcj = 7.98E-4                 tcjsw = 2.4E-4                tcjswg = 4.77E-3
//*** well proximity effect model parameters ***
+web = -220                    wec = -3E3                    kvth0we = -3.197498E-3
+k2we = 3E-4                   ku0we = -3.482487E-3          scref = 1E-6
30:type=p  minr=1e-60
//*** flag parameter ***
+version = 4.3                 binunit = 2                   mobmod = 0
+capmod = 2                    rdsmod = 0                    igcmod = 1
+igbmod = 1                    rbodymod = 0                  trnqsmod = 0
+acnqsmod = 0                  fnoimod = 1                   tnoimod = 0
+diomod = 1                    permod = 1                    rgatemod = 0
+wpemod = 0
//*** geometry range parameter ***
+lmin = 4E-8                   lmax = 6E-8                   wmin = 1.2E-7
+wmax = 3E-7
//*** process parameter ***
+epsrox = 3.9                  toxe = tox_p_cap                  toxm = tox_p_cap
+dtox = 3.29E-10               xj = 1.7E-7                   ndep = 8.5E17
+ngate = 8E19                  nsd = 1E20                    rsh = 9.68
+rshg = 0.1
//*** dw and dl parameter ***
+wint = 1.089287E-8            wl = 0                        wln = 1
+ww = 0                        wwn = 1                       wwl = 0
+lint = 2E-24                  ll = 0                        lln = 1
+lw = 0                        lwn = 1                       lwl = 0
+llc = 0                       lwc = 0                       lwlc = 0
+wlc = 0                       wwc = 0                       wwlc = 0
+dwg = 0                       dwb = 0                       xl = 0+dxl_p_cap
+xw = 0+dxw_p_cap
//*** flicker noise model parameter ***
+noia = 1.45E42                noib = 3.57E26                noic = 2E10
+em = 2.1E7                    ef = 1.147
//***layout-dependent parasitics model parameter ***
+dmcg = 8.5E-8                 dmci = 8.5E-8                 dmdg = 0
+dmcgt = 0                     dwj = 0                       xgw = 0
+xgl = 0                       ngcon = 1
//*** vth related  parameter ***
+vth0 = -0.369135+dvth0_p_cap      lvth0 = 4.367271E-9+dlvth0_p_cap  wvth0 = 6.061205E-9+dwvth0_p_cap
+pvth0 = -3.871715E-16+dpvth0_p_cap phin = 0                      k1 = 0.25
+k2 = -7.128531E-3             lk2 = -1.770246E-10           wk2 = -7.701441E-10
+pk2 = -1.189732E-16           k3 = -1.700953                k3b = 1.200306
+w0 = 1.585076E-7              lpe0 = 7.519925E-8            lpeb = 5.608072E-8
+dvtp0 = 2.2E-6                dvtp1 = 0.2                   dvt0 = 0.20341
+dvt1 = 0.95146                dvt2 = 0.01                   dvt0w = 0
+dvt1w = 5.366499E6            dvt2w = 0
//*** mobility related parameter ***
+u0 = 2.47139E-2+du0_p_cap         lu0 = -4.235042E-10+dlu0_p_cap    wu0 = 5.029246E-10+dwu0_p_cap
+pu0 = 2.12968E-17+dpu0_p_cap      ua = 1.195233E-11             ub = 1.495572E-18
+lub = 2.766144E-26            wub = 4.041856E-26            pub = -3.729918E-33
+uc = 2.835787E-11             wuc = -1.637456E-18           ud = 0
+vsat = 1.25522E5+dvsat_p_cap      lvsat = 1.651738E-3           wvsat = -4.554101E-3
+pvsat = 2.732461E-10          a0 = 1E-3                     ags = 2.604403
+wags = 8.642956E-8            b0 = 0                        b1 = 0
+keta = 0.076145               lketa = -1.38531E-8           wketa = -1.376189E-8
+pketa = 1.122276E-15          a1 = 0                        a2 = 1
+rdsw = 327.6                  prwb = -0.249981              prwg = 0.25
+wr = 1
//*** subthreshold related parameter ***
+voff = -0.131916              lvoff = 5.303768E-9           wvoff = 5.559449E-9
+pvoff = -5.016324E-16         voffl = -6.036214E-9          minv = 0
+nfactor = 0.511088            lnfactor = 2.816183E-8        wnfactor = -4.781791E-8
+pnfactor = 6.586688E-16       eta0 = 3.11538E-2             etab = 0.247803
+letab = -1.629918E-8          wetab = -2.66802E-8           petab = 1.600812E-15
+dsub = 1.2725                 cit = 1E-4                    cdsc = 0
+cdscb = 0                     cdscd = 0
//*** output resistance related parameter ***
+pclm = 0.627258               pdiblc1 = 0                   pdiblc2 = 1.06974E-2
+lpdiblc2 = -3.548114E-10      wpdiblc2 = -9.67633E-10       ppdiblc2 = 3.298003E-17
+pdiblcb = 0                   drout = 0.962144              ldrout = 1.023288E-8
+wdrout = 4.744888E-8          pdrout = -2.846933E-15        pscbe1 = 9.264E8
+pscbe2 = 1E-20                pvag = 1.425                  delta = 0.02
+fprout = 390.234144           pdits = 5.042617E-3           pditsl = 100
+pditsd = 0                    alpha0 = 0                    alpha1 = 0.06
+beta0 = 13.5                  agidl = 9E-8                  bgidl = 3.404E9
+cgidl = 0.5                   egidl = 0.15
//*** gate dielectric tunneling current ***
+aigbacc = 0.012               bigbacc = 3.49E-3             cigbacc = 0.131
+nigbacc = 5.2                 aigbinv = 0.347               bigbinv = 0.0312
+cigbinv = 6.1E-3              eigbinv = 1.1                 nigbinv = 1
+aigc = 7.12E-3                bigc = 6.31E-4                cigc = 0
+aigsd = 5.9E-3                bigsd = 2.48E-4               cigsd = 0.032
+dlcig = 2.52E-9               nigc = 2.28                   poxedge = 1
+pigcd = 2.28                  ntox = 1                      toxref = 3E-9
//*** capacitance parameter ***
+xpart = 1                     cgso = 3.1E-11+dcgso_p_cap        cgdo = 3.1E-11+dcgdo_p_cap
+cgbo = 0                      ckappas = 0.6                 ckappad = 0.6
+cf = 1.18E-10                 clc = 1E-7                    cle = 0.6
+dlc = 0                 dwc = 0                       noff = 2.5
+voffcv = -0.0486              acde = 1.2                    moin = 8
+cgsl = 0.54E-10+dcgsl_p_cap       cgdl = 0.54E-10+dcgdl_p_cap
//*** souce/drain junction diode model parameter **
+ijthsrev = 0.01               ijthsfwd = 0.01               xjbvs = 1
+bvs = 10                      jss = 1.51E-7                 jsws = 3.98E-13
+jswgs = 2.47E-12              cjs = 9.98E-4+dcj_p_cap           mjs = 0.34
+mjsws = 0.012                 cjsws = 6.21E-11+dcjsw_p_cap      cjswgs = 2.53E-10+dcjswg_p_cap
+mjswgs = 0.86                 pbs = 0.75                    pbsws = 0.49
+pbswgs = 0.71
//** rf model related parameter ***
+xrcrg1 = 12                   xrcrg2 = 1                    rbpb = 50
+rbpd = 50                     rbps = 50                     rbdb = 50
+rbsb = 50                     gbmin = 1E-12
//*** stress effect related parameter ***
+saref = 6.1E-7                sbref = 6.1E-7                wlod = 2.86E-7
+ku0 = 1E-7                    kvsat = -0.386                kvth0 = 2E-10
+tku0 = 0.24                   llodku0 = 1                   wlodku0 = 1
+llodvth = 1.8                 wlodvth = 1                   lku0 = 1.871E-7
+wku0 = 2.4E-7                 pku0 = -3.24E-14              lkvth0 = 2.4E-10
+wkvth0 = 1.8E-10              pkvth0 = 0                    stk2 = 0
+lodk2 = 1.9                   steta0 = 0                    lodeta0 = 1
//*** temperature coefficient ***
+tnom = 25                     ute = -1.524                  kt1 = -0.229
+kt1l = 0                      kt2 = -0.01232                ua1 = 4.549E-9
+ub1 = -5.441E-18              uc1 = -5E-11                  at = 4.00001E4
+prt = 0                       njs = 1                       xtis = 3
+tpb = 1.9E-3                  tpbsw = 1.9E-3                tpbswg = 1.9E-3
+tcj = 7.98E-4                 tcjsw = 2.4E-4                tcjswg = 4.77E-3
//*** well proximity effect model parameters ***
+web = -220                    wec = -3E3                    kvth0we = -3.197498E-3
+k2we = 3E-4                   ku0we = -3.482487E-3          scref = 1E-6
31:type=p  minr=1e-60
//*** flag parameter ***
+version = 4.3                 binunit = 2                   mobmod = 0
+capmod = 2                    rdsmod = 0                    igcmod = 1
+igbmod = 1                    rbodymod = 0                  trnqsmod = 0
+acnqsmod = 0                  fnoimod = 1                   tnoimod = 0
+diomod = 1                    permod = 1                    rgatemod = 0
+wpemod = 0
//*** geometry range parameter ***
+lmin = 1E-5                   lmax = 9E-4                   wmin = 1.2E-7
+wmax = 3E-7
//*** process parameter ***
+epsrox = 3.9                  toxe = tox_p_cap                  toxm = tox_p_cap
+dtox = 3.29E-10               xj = 1.7E-7                   ndep = 8.5E17
+ngate = 8E19                  nsd = 1E20                    rsh = 9.68
+rshg = 0.1
//*** dw and dl parameter ***
+wint = 1.089287E-8            wl = 0                        wln = 1
+ww = 0                        wwn = 1                       wwl = 0
+lint = 2E-24                  ll = 0                        lln = 1
+lw = 0                        lwn = 1                       lwl = 0
+lwc = 0                       lwlc = 0                      wwc = 0
+wwlc = 0                      dwg = 0                       dwb = 0
+xl = 0.0+dxl_p_cap                xw = 0.0+dxw_p_cap
//*** flicker noise model parameter ***
+noia = 1.45E42                noib = 3.57E26                noic = 2E10
+em = 2.1E7                    ef = 1.147
//***layout-dependent parasitics model parameter ***
+dmcg = 8.5E-8                 dmci = 8.5E-8                 dmdg = 0
+dmcgt = 0                     dwj = 0                       xgw = 0
+xgl = 0                       ngcon = 1
//*** vth related  parameter ***
+vth0 = ( -0.288698+dvth0_p_cap) + 9.955236E-3
+lvth0 = ( 9.263001E-9+dlvth0_p_cap) -9.263001E-9
+wvth0 = ( 1.029638E-8+dwvth0_p_cap)  -1.029638E-8
+pvth0 = ( -6.341168E-15+dpvth0_p_cap)  + 6.341168E-15
+phin = 0                      k1 = 0.25                     k2 = -8.431308E-3
+k3 = -1.700953                k3b = 1.200306                w0 = 1.585076E-7
+lpe0 = 7.519925E-8            lpeb = 5.608072E-8            dvtp0 = 2.2E-6
+dvtp1 = 0.2                   dvt0 = 0.20341                dvt1 = 0.95146
+dvt2 = 0.01                   dvt0w = 0                     dvt1w = 5.366499E6
+dvt2w = 0
//*** mobility related parameter ***
+u0 = ( 0.0230515+du0_p_cap) -3.808914E-3 lu0 = ( -2.679199E-9+dlu0_p_cap) + 2.679199E-9
+wu0 = ( -3.385616E-9+dwu0_p_cap) + 3.837062E-9
+pu0 = ( 3.783728E-15+dpu0_p_cap) -3.783728E-15
+ua = 1.195233E-11             ub = 1.195164E-18             wub = -4.677272E-26
+uc = 5.336894E-11             wuc = -2.088593E-18           ud = 0
+vsat = 117731.5+dvsat_p_cap       a0 = 2.626266                 ags = 1.237683
+b0 = 0                        b1 = 0                        keta = -0.106951
+wketa = 3.035998E-9           a1 = 0                        a2 = 1
+rdsw = 327.6                  prwb = -0.249981              prwg = 0.25
+wr = 1
//*** subthreshold related parameter ***
+voff = -4.11328E-2            wvoff = 1.053476E-10          voffl = -6.036214E-9
+minv = 0                      nfactor = 0.306712            wnfactor = -1.49398E-8
+eta0 = 3.11538E-2             etab = -2.38505E-2            dsub = 1.2725
+cit = 1E-4                    cdsc = 0                      cdscb = 0
+cdscd = 0
//*** output resistance related parameter ***
+pclm = 0.627258               pdiblc1 = 0                   pdiblc2 = 1.15282E-2
+pdiblcb = 0                   drout = 1.132692              pscbe1 = 9.264E8
+pscbe2 = 1E-20                pvag = 1.425                  delta = 0.02
+fprout = 390.234144           pdits = 5.042617E-3           pditsl = 100
+pditsd = 0                    lc = 0                        alpha0 = 0
+alpha1 = 0.06                 beta0 = 13.5                  agidl = 9E-8
+bgidl = 3.404E9               cgidl = 0.5                   egidl = 0.15
//*** gate dielectric tunneling current ***
+aigbacc = 0.012               bigbacc = 3.49E-3             cigbacc = 0.131
+nigbacc = 5.2                 aigbinv = 0.347               bigbinv = 0.0312
+cigbinv = 6.1E-3              eigbinv = 1.1                 nigbinv = 1
+aigc = 7.12E-3                bigc = 6.31E-4                cigc = 0
+aigsd = 5.9E-3                bigsd = 2.48E-4               cigsd = 0.032
+dlcig = 2.52E-9               nigc = 2.28                   poxedge = 1
+pigcd = 2.28                  ntox = 1                      toxref = 3E-9
//*** capacitance parameter ***
+xpart = 1                     cgso = 3.1E-11+dcgso_p_cap        cgdo = 3.1E-11+dcgdo_p_cap
+cgbo = 0                      ckappas = 0.6                 ckappad = 0.6
+cf = 1.18E-10                 clc = 1E-7                    cle = 0.6
+dlc = 0                 dwc = 0                       noff = 2.5
+voffcv = -0.0486              acde = 1.2                    moin = 8
+cgsl = 0.54E-10+dcgsl_p_cap       cgdl = 0.54E-10+dcgdl_p_cap
//*** souce/drain junction diode model parameter **
+ijthsrev = 0.01               ijthsfwd = 0.01               xjbvs = 1
+bvs = 10                      jss = 1.51E-7                 jsws = 3.98E-13
+jswgs = 2.47E-12              cjs = 9.98E-4+dcj_p_cap           mjs = 0.34
+mjsws = 0.012                 cjsws = 6.21E-11+dcjsw_p_cap      cjswgs = 2.53E-10+dcjswg_p_cap
+mjswgs = 0.86                 pbs = 0.75                    pbsws = 0.49
+pbswgs = 0.71
//** rf model related parameter ***
+xrcrg1 = 12                   xrcrg2 = 1                    rbpb = 50
+rbpd = 50                     rbps = 50                     rbdb = 50
+rbsb = 50                     gbmin = 1E-12
//*** stress effect related parameter ***
+saref = 6.1E-7                sbref = 6.1E-7                wlod = 2.86E-7
+ku0 = 1E-7                    kvsat = -0.386                kvth0 = 2E-10
+tku0 = 0.24                   llodku0 = 1                   wlodku0 = 1
+llodvth = 1.8                 wlodvth = 1                   lku0 = 1.871E-7
+wku0 = 2.4E-7                 pku0 = -3.24E-14              lkvth0 = 2.4E-10
+wkvth0 = 1.8E-10              pkvth0 = 0                    stk2 = 0
+lodk2 = 1.9                   steta0 = 0                    lodeta0 = 1
//*** temperature coefficient ***
+tnom = 25                     ute = -1.524                  kt1 = -0.229
+kt1l = 0                      kt2 = -0.01232                ua1 = 4.549E-9
+ub1 = -5.441E-18              uc1 = -5E-11                  at = 4.00001E4
+prt = 0                       njs = 1                       xtis = 3
+tpb = 1.9E-3                  tpbsw = 1.9E-3                tpbswg = 1.9E-3
+tcj = 7.98E-4                 tcjsw = 2.4E-4                tcjswg = 4.77E-3
//*** well proximity effect model parameters ***
+web = -220                    wec = -3E3                    kvth0we = -3.197498E-3
+k2we = 3E-4                   ku0we = -3.482487E-3          scref = 1E-6
32:type=p  minr=1e-60
//*** flag parameter ***
+version = 4.3                 binunit = 2                   mobmod = 0
+capmod = 2                    rdsmod = 0                    igcmod = 1
+igbmod = 1                    rbodymod = 0                  trnqsmod = 0
+acnqsmod = 0                  fnoimod = 1                   tnoimod = 0
+diomod = 1                    permod = 1                    rgatemod = 0
+wpemod = 0
//*** geometry range parameter ***
+lmin = 1E-5                   lmax = 9E-4                   wmin = 3E-7
+wmax = 5E-7
//*** process parameter ***
+epsrox = 3.9                  toxe = tox_p_cap                  toxm = tox_p_cap
+dtox = 3.29E-10               xj = 1.7E-7                   ndep = 8.5E17
+ngate = 8E19                  nsd = 1E20                    rsh = 9.68
+rshg = 0.1
//*** dw and dl parameter ***
+wint = 1.089287E-8            wl = 0                        wln = 1
+ww = 0                        wwn = 1                       wwl = 0
+lint = 2E-24                  ll = 0                        lln = 1
+lw = 0                        lwn = 1                       lwl = 0
+lwc = 0                       lwlc = 0                      wwc = 0
+wwlc = 0                      dwg = 0                       dwb = 0
+xl = 0.0+dxl_p_cap                xw = 0.0+dxw_p_cap
//*** flicker noise model parameter ***
+noia = 1.45E42                noib = 3.57E26                noic = 2E10
+em = 2.1E7                    ef = 1.147
//***layout-dependent parasitics model parameter ***
+dmcg = 8.5E-8                 dmci = 8.5E-8                 dmdg = 0
+dmcgt = 0                     dwj = 0                       xgw = 0
+xgl = 0                       ngcon = 1
//*** vth related  parameter ***
+vth0 = ( -0.288698+dvth0_p_cap) + 9.955387E-3
+lvth0 = ( 9.263001E-9+dlvth0_p_cap) -9.263001E-9
+wvth0 = ( 1.029638E-8+dwvth0_p_cap)  -1.029638E-8
+pvth0 = ( -6.341168E-15+dpvth0_p_cap)  + 6.341168E-15
+phin = 0                      k1 = 0.25                     k2 = -8.431308E-3
+k3 = -1.700953                k3b = 1.200306                w0 = 1.585076E-7
+lpe0 = 7.519925E-8            lpeb = 5.608072E-8            dvtp0 = 2.2E-6
+dvtp1 = 0.2                   dvt0 = 0.20341                dvt1 = 0.95146
+dvt2 = 0.01                   dvt0w = 0                     dvt1w = 5.366499E6
+dvt2w = 0
//*** mobility related parameter ***
+u0 = ( 0.0230515+du0_p_cap) -2.527209E-3 lu0 = ( -2.679199E-9+dlu0_p_cap) + 2.679199E-9
+wu0 = ( -3.385616E-9+dwu0_p_cap) + 3.480474E-9
+pu0 = ( 3.783728E-15+dpu0_p_cap) -3.783728E-15
+ua = 1.195234E-11             ub = 1.223926E-18             wub = -5.477464E-26
+uc = 4.58618E-11              ud = 0                        vsat = 117731.5+dvsat_p_cap
+a0 = 2.626266                 ags = 1.237683                b0 = 0
+b1 = 0                        keta = -0.096039              a1 = 0
+a2 = 1                        rdsw = 327.6                  prwb = -0.249981
+prwg = 0.25                   wr = 1
//*** subthreshold related parameter ***
+voff = -4.07541E-2            voffl = -6.036214E-9          minv = 0
+nfactor = 0.321803            wnfactor = -1.913825E-8       eta0 = 3.11538E-2
+etab = -2.38505E-2            dsub = 1.2725                 cit = 1E-4
+cdsc = 0                      cdscb = 0                     cdscd = 0
//*** output resistance related parameter ***
+pclm = 0.627258               pdiblc1 = 0                   pdiblc2 = 1.15282E-2
+pdiblcb = 0                   drout = 1.132692              pscbe1 = 9.264E8
+pscbe2 = 1E-20                pvag = 1.425                  delta = 0.02
+fprout = 390.234144           pdits = 5.042617E-3           pditsl = 100
+pditsd = 0                    lc = 0                        alpha0 = 0
+alpha1 = 0.06                 beta0 = 13.5                  agidl = 9E-8
+bgidl = 3.404E9               cgidl = 0.5                   egidl = 0.15
//*** gate dielectric tunneling current ***
+aigbacc = 0.012               bigbacc = 3.49E-3             cigbacc = 0.131
+nigbacc = 5.2                 aigbinv = 0.347               bigbinv = 0.0312
+cigbinv = 6.1E-3              eigbinv = 1.1                 nigbinv = 1
+aigc = 7.12E-3                bigc = 6.31E-4                cigc = 0
+aigsd = 5.9E-3                bigsd = 2.48E-4               cigsd = 0.032
+dlcig = 2.52E-9               nigc = 2.28                   poxedge = 1
+pigcd = 2.28                  ntox = 1                      toxref = 3E-9
//*** capacitance parameter ***
+xpart = 1                     cgso = 3.1E-11+dcgso_p_cap        cgdo = 3.1E-11+dcgdo_p_cap
+cgbo = 0                      ckappas = 0.6                 ckappad = 0.6
+cf = 1.18E-10                 clc = 1E-7                    cle = 0.6
+dlc = 0                 dwc = 0                       noff = 2.5
+voffcv = -0.0486              acde = 1.2                    moin = 8
+cgsl = 0.54E-10+dcgsl_p_cap       cgdl = 0.54E-10+dcgdl_p_cap
//*** souce/drain junction diode model parameter **
+ijthsrev = 0.01               ijthsfwd = 0.01               xjbvs = 1
+bvs = 10                      jss = 1.51E-7                 jsws = 3.98E-13
+jswgs = 2.47E-12              cjs = 9.98E-4+dcj_p_cap           mjs = 0.34
+mjsws = 0.012                 cjsws = 6.21E-11+dcjsw_p_cap      cjswgs = 2.53E-10+dcjswg_p_cap
+mjswgs = 0.86                 pbs = 0.75                    pbsws = 0.49
+pbswgs = 0.71
//** rf model related parameter ***
+xrcrg1 = 12                   xrcrg2 = 1                    rbpb = 50
+rbpd = 50                     rbps = 50                     rbdb = 50
+rbsb = 50                     gbmin = 1E-12
//*** stress effect related parameter ***
+saref = 6.1E-7                sbref = 6.1E-7                wlod = 2.86E-7
+ku0 = 1E-7                    kvsat = -0.386                kvth0 = 2E-10
+tku0 = 0.24                   llodku0 = 1                   wlodku0 = 1
+llodvth = 1.8                 wlodvth = 1                   lku0 = 1.871E-7
+wku0 = 2.4E-7                 pku0 = -3.24E-14              lkvth0 = 2.4E-10
+wkvth0 = 1.8E-10              pkvth0 = 0                    stk2 = 0
+lodk2 = 1.9                   steta0 = 0                    lodeta0 = 1
//*** temperature coefficient ***
+tnom = 25                     ute = -1.524                  kt1 = -0.229
+kt1l = 0                      kt2 = -0.01232                ua1 = 4.549E-9
+ub1 = -5.441E-18              uc1 = -5E-11                  at = 4.00001E4
+prt = 0                       njs = 1                       xtis = 3
+tpb = 1.9E-3                  tpbsw = 1.9E-3                tpbswg = 1.9E-3
+tcj = 7.98E-4                 tcjsw = 2.4E-4                tcjswg = 4.77E-3
//*** well proximity effect model parameters ***
+web = -220                    wec = -3E3                    kvth0we = -3.197498E-3
+k2we = 3E-4                   ku0we = -3.482487E-3          scref = 1E-6
33:type=p  minr=1e-60
//*** flag parameter ***
+version = 4.3                 binunit = 2                   mobmod = 0
+capmod = 2                    rdsmod = 0                    igcmod = 1
+igbmod = 1                    rbodymod = 0                  trnqsmod = 0
+acnqsmod = 0                  fnoimod = 1                   tnoimod = 0
+diomod = 1                    permod = 1                    rgatemod = 0
+wpemod = 0
//*** geometry range parameter ***
+lmin = 1E-5                   lmax = 9E-4                   wmin = 5E-7
+wmax = 1E-6
//*** process parameter ***
+epsrox = 3.9                  toxe = tox_p_cap                  toxm = tox_p_cap
+dtox = 3.29E-10               xj = 1.7E-7                   ndep = 8.5E17
+ngate = 8E19                  nsd = 1E20                    rsh = 9.68
+rshg = 0.1
//*** dw and dl parameter ***
+wint = 1.089287E-8            wl = 0                        wln = 1
+ww = 0                        wwn = 1                       wwl = 0
+lint = 2E-24                  ll = 0                        lln = 1
+lw = 0                        lwn = 1                       lwl = 0
+lwc = 0                       lwlc = 0                      wwc = 0
+wwlc = 0                      dwg = 0                       dwb = 0
+xl = 0.0+dxl_p_cap                xw = 0.0+dxw_p_cap
//*** flicker noise model parameter ***
+noia = 1.45E42                noib = 3.57E26                noic = 2E10
+em = 2.1E7                    ef = 1.147
//***layout-dependent parasitics model parameter ***
+dmcg = 8.5E-8                 dmci = 8.5E-8                 dmdg = 0
+dmcgt = 0                     dwj = 0                       xgw = 0
+xgl = 0                       ngcon = 1
//*** vth related  parameter ***
+vth0 = ( -0.288698+dvth0_p_cap) + 8.54953E-3
+lvth0 = ( 9.263001E-9+dlvth0_p_cap) -9.263001E-9
+wvth0 = ( 1.029638E-8+dwvth0_p_cap)  -9.624067E-9
+pvth0 = ( -6.341168E-15+dpvth0_p_cap)  + 6.341168E-15
+phin = 0                      k1 = 0.25                     k2 = -8.431308E-3
+k3 = -1.700953                k3b = 1.200306                w0 = 1.585076E-7
+lpe0 = 7.519925E-8            lpeb = 5.608072E-8            dvtp0 = 2.2E-6
+dvtp1 = 0.2                   dvt0 = 0.20341                dvt1 = 0.95146
+dvt2 = 0.01                   dvt0w = 0                     dvt1w = 5.366499E6
+dvt2w = 0
//*** mobility related parameter ***
+u0 = ( 0.0230515+du0_p_cap) -2.328851E-3 lu0 = ( -2.679199E-9+dlu0_p_cap) + 2.679199E-9
+wu0 = ( -3.385616E-9+dwu0_p_cap) + 3.385616E-9
+pu0 = ( 3.783728E-15+dpu0_p_cap) -3.783728E-15
+ua = 1.195233E-11             ub = 1.263952E-18             wub = -7.391554E-26
+uc = 8.43155E-11              wuc = -1.838911E-17           ud = 0
+vsat = 117731.5+dvsat_p_cap       a0 = 2.626266                 ags = 1.302506
+wags = -3.099916E-8           b0 = 0                        b1 = 0
+keta = -0.116907              wketa = 9.979706E-9           a1 = 0
+a2 = 1                        rdsw = 327.6                  prwb = -0.249981
+prwg = 0.25                   wr = 1
//*** subthreshold related parameter ***
+voff = -0.042192              wvoff = 6.876248E-10          voffl = -6.036214E-9
+minv = 0                      nfactor = 0.331649            wnfactor = -2.384684E-8
+eta0 = 3.11538E-2             etab = -2.38505E-2            dsub = 1.2725
+cit = 1E-4                    cdsc = 0                      cdscb = 0
+cdscd = 0
//*** output resistance related parameter ***
+pclm = 0.627258               pdiblc1 = 0                   pdiblc2 = 1.15282E-2
+pdiblcb = 0                   drout = 1.132692              pscbe1 = 9.264E8
+pscbe2 = 1E-20                pvag = 1.425                  delta = 0.02
+fprout = 390.234144           pdits = 5.042617E-3           pditsl = 100
+pditsd = 0                    lc = 0                        alpha0 = 0
+alpha1 = 0.06                 beta0 = 13.5                  agidl = 9E-8
+bgidl = 3.404E9               cgidl = 0.5                   egidl = 0.15
//*** gate dielectric tunneling current ***
+aigbacc = 0.012               bigbacc = 3.49E-3             cigbacc = 0.131
+nigbacc = 5.2                 aigbinv = 0.347               bigbinv = 0.0312
+cigbinv = 6.1E-3              eigbinv = 1.1                 nigbinv = 1
+aigc = 7.12E-3                bigc = 6.31E-4                cigc = 0
+aigsd = 5.9E-3                bigsd = 2.48E-4               cigsd = 0.032
+dlcig = 2.52E-9               nigc = 2.28                   poxedge = 1
+pigcd = 2.28                  ntox = 1                      toxref = 3E-9
//*** capacitance parameter ***
+xpart = 1                     cgso = 3.1E-11+dcgso_p_cap        cgdo = 3.1E-11+dcgdo_p_cap
+cgbo = 0                      ckappas = 0.6                 ckappad = 0.6
+cf = 1.18E-10                 clc = 1E-7                    cle = 0.6
+dlc = 0                 dwc = 0                       noff = 2.5
+voffcv = -0.0486              acde = 1.2                    moin = 8
+cgsl = 0.54E-10+dcgsl_p_cap       cgdl = 0.54E-10+dcgdl_p_cap
//*** souce/drain junction diode model parameter **
+ijthsrev = 0.01               ijthsfwd = 0.01               xjbvs = 1
+bvs = 10                      jss = 1.51E-7                 jsws = 3.98E-13
+jswgs = 2.47E-12              cjs = 9.98E-4+dcj_p_cap           mjs = 0.34
+mjsws = 0.012                 cjsws = 6.21E-11+dcjsw_p_cap      cjswgs = 2.53E-10+dcjswg_p_cap
+mjswgs = 0.86                 pbs = 0.75                    pbsws = 0.49
+pbswgs = 0.71
//** rf model related parameter ***
+xrcrg1 = 12                   xrcrg2 = 1                    rbpb = 50
+rbpd = 50                     rbps = 50                     rbdb = 50
+rbsb = 50                     gbmin = 1E-12
//*** stress effect related parameter ***
+saref = 6.1E-7                sbref = 6.1E-7                wlod = 2.86E-7
+ku0 = 1E-7                    kvsat = -0.386                kvth0 = 2E-10
+tku0 = 0.24                   llodku0 = 1                   wlodku0 = 1
+llodvth = 1.8                 wlodvth = 1                   lku0 = 1.871E-7
+wku0 = 2.4E-7                 pku0 = -3.24E-14              lkvth0 = 2.4E-10
+wkvth0 = 1.8E-10              pkvth0 = 0                    stk2 = 0
+lodk2 = 1.9                   steta0 = 0                    lodeta0 = 1
//*** temperature coefficient ***
+tnom = 25                     ute = -1.524                  kt1 = -0.229
+kt1l = 0                      kt2 = -0.01232                ua1 = 4.549E-9
+ub1 = -5.441E-18              uc1 = -5E-11                  at = 4.00001E4
+prt = 0                       njs = 1                       xtis = 3
+tpb = 1.9E-3                  tpbsw = 1.9E-3                tpbswg = 1.9E-3
+tcj = 7.98E-4                 tcjsw = 2.4E-4                tcjswg = 4.77E-3
//*** well proximity effect model parameters ***
+web = -220                    wec = -3E3                    kvth0we = -3.197498E-3
+k2we = 3E-4                   ku0we = -3.482487E-3          scref = 1E-6
34:type=p  minr=1e-60
//*** flag parameter ***
+version = 4.3                 binunit = 2                   mobmod = 0
+capmod = 2                    rdsmod = 0                    igcmod = 1
+igbmod = 1                    rbodymod = 0                  trnqsmod = 0
+acnqsmod = 0                  fnoimod = 1                   tnoimod = 0
+diomod = 1                    permod = 1                    rgatemod = 0
+wpemod = 0
//*** geometry range parameter ***
+lmin = 1E-5                   lmax = 9E-4                   wmin = 1E-6
+wmax = 2E-6
//*** process parameter ***
+epsrox = 3.9                  toxe = tox_p_cap                  toxm = tox_p_cap
+dtox = 3.29E-10               xj = 1.7E-7                   ndep = 8.5E17
+ngate = 8E19                  nsd = 1E20                    rsh = 9.68
+rshg = 0.1
//*** dw and dl parameter ***
+wint = 1.089287E-8            wl = 0                        wln = 1
+ww = 0                        wwn = 1                       wwl = 0
+lint = 2E-24                  ll = 0                        lln = 1
+lw = 0                        lwn = 1                       lwl = 0
+lwc = 0                       lwlc = 0                      wwc = 0
+wwlc = 0                      dwg = 0                       dwb = 0
+xl = 0.0+dxl_p_cap                xw = 0.0+dxw_p_cap
//*** flicker noise model parameter ***
+noia = 1.45E42                noib = 3.57E26                noic = 2E10
+em = 2.1E7                    ef = 1.147
//***layout-dependent parasitics model parameter ***
+dmcg = 8.5E-8                 dmci = 8.5E-8                 dmdg = 0
+dmcgt = 0                     dwj = 0                       xgw = 0
+xgl = 0                       ngcon = 1
//*** vth related  parameter ***
+vth0 = ( -0.288698+dvth0_p_cap) + 2.459098E-3
+lvth0 = ( 9.263001E-9+dlvth0_p_cap) -9.263001E-9
+wvth0 = ( 1.029638E-8+dwvth0_p_cap)  -3.666319E-9
+pvth0 = ( -6.341168E-15+dpvth0_p_cap)  + 6.341168E-15
+phin = 0                      k1 = 0.25                     k2 = -8.431308E-3
+k3 = -1.700953                k3b = 1.200306                w0 = 1.585076E-7
+lpe0 = 7.519925E-8            lpeb = 5.608072E-8            dvtp0 = 2.2E-6
+dvtp1 = 0.2                   dvt0 = 0.20341                dvt1 = 0.95146
+dvt2 = 0.01                   dvt0w = 0                     dvt1w = 5.366499E6
+dvt2w = 0
//*** mobility related parameter ***
+u0 = ( 0.0230515+du0_p_cap) -1.256853E-3 lu0 = ( -2.679199E-9+dlu0_p_cap) + 2.679199E-9
+wu0 = ( -3.385616E-9+dwu0_p_cap) + 2.334694E-9
+pu0 = ( 3.783728E-15+dpu0_p_cap) -3.783728E-15
+ua = 3.258341E-11             wua = -2.018161E-17           ub = 1.364897E-18
+wub = -1.726619E-25           uc = 6.551685E-11             ud = 0
+vsat = 117731.5+dvsat_p_cap       a0 = 2.626266                 ags = 1.270816
+b0 = 0                        b1 = 0                        keta = -0.106705
+a1 = 0                        a2 = 1                        rdsw = 327.6
+prwb = -0.249981              prwg = 0.25                   wr = 1
//*** subthreshold related parameter ***
+voff = -4.60708E-2            wvoff = 4.481921E-9           voffl = -6.036214E-9
+minv = 0                      nfactor = 0.339734            wnfactor = -3.175548E-8
+eta0 = 3.11538E-2             etab = -2.38505E-2            dsub = 1.2725
+cit = 1E-4                    cdsc = 0                      cdscb = 0
+cdscd = 0
//*** output resistance related parameter ***
+pclm = 0.627258               pdiblc1 = 0                   pdiblc2 = 1.15282E-2
+pdiblcb = 0                   drout = 1.132692              pscbe1 = 9.264E8
+pscbe2 = 1E-20                pvag = 1.425                  delta = 0.02
+fprout = 390.234144           pdits = 5.042617E-3           pditsl = 100
+pditsd = 0                    lc = 0                        alpha0 = 0
+alpha1 = 0.06                 beta0 = 13.5                  agidl = 9E-8
+bgidl = 3.404E9               cgidl = 0.5                   egidl = 0.15
//*** gate dielectric tunneling current ***
+aigbacc = 0.012               bigbacc = 3.49E-3             cigbacc = 0.131
+nigbacc = 5.2                 aigbinv = 0.347               bigbinv = 0.0312
+cigbinv = 6.1E-3              eigbinv = 1.1                 nigbinv = 1
+aigc = 7.12E-3                bigc = 6.31E-4                cigc = 0
+aigsd = 5.9E-3                bigsd = 2.48E-4               cigsd = 0.032
+dlcig = 2.52E-9               nigc = 2.28                   poxedge = 1
+pigcd = 2.28                  ntox = 1                      toxref = 3E-9
//*** capacitance parameter ***
+xpart = 1                     cgso = 3.1E-11+dcgso_p_cap        cgdo = 3.1E-11+dcgdo_p_cap
+cgbo = 0                      ckappas = 0.6                 ckappad = 0.6
+cf = 1.18E-10                 clc = 1E-7                    cle = 0.6
+dlc = 0                 dwc = 0                       noff = 2.5
+voffcv = -0.0486              acde = 1.2                    moin = 8
+cgsl = 0.54E-10+dcgsl_p_cap       cgdl = 0.54E-10+dcgdl_p_cap
//*** souce/drain junction diode model parameter **
+ijthsrev = 0.01               ijthsfwd = 0.01               xjbvs = 1
+bvs = 10                      jss = 1.51E-7                 jsws = 3.98E-13
+jswgs = 2.47E-12              cjs = 9.98E-4+dcj_p_cap           mjs = 0.34
+mjsws = 0.012                 cjsws = 6.21E-11+dcjsw_p_cap      cjswgs = 2.53E-10+dcjswg_p_cap
+mjswgs = 0.86                 pbs = 0.75                    pbsws = 0.49
+pbswgs = 0.71
//** rf model related parameter ***
+xrcrg1 = 12                   xrcrg2 = 1                    rbpb = 50
+rbpd = 50                     rbps = 50                     rbdb = 50
+rbsb = 50                     gbmin = 1E-12
//*** stress effect related parameter ***
+saref = 6.1E-7                sbref = 6.1E-7                wlod = 2.86E-7
+ku0 = 1E-7                    kvsat = -0.386                kvth0 = 2E-10
+tku0 = 0.24                   llodku0 = 1                   wlodku0 = 1
+llodvth = 1.8                 wlodvth = 1                   lku0 = 1.871E-7
+wku0 = 2.4E-7                 pku0 = -3.24E-14              lkvth0 = 2.4E-10
+wkvth0 = 1.8E-10              pkvth0 = 0                    stk2 = 0
+lodk2 = 1.9                   steta0 = 0                    lodeta0 = 1
//*** temperature coefficient ***
+tnom = 25                     ute = -1.524                  kt1 = -0.229
+kt1l = 0                      kt2 = -0.01232                ua1 = 4.549E-9
+ub1 = -5.441E-18              uc1 = -5E-11                  at = 4.00001E4
+prt = 0                       njs = 1                       xtis = 3
+tpb = 1.9E-3                  tpbsw = 1.9E-3                tpbswg = 1.9E-3
+tcj = 7.98E-4                 tcjsw = 2.4E-4                tcjswg = 4.77E-3
//*** well proximity effect model parameters ***
+web = -220                    wec = -3E3                    kvth0we = -3.197498E-3
+k2we = 3E-4                   ku0we = -3.482487E-3          scref = 1E-6
35:type=p  minr=1e-60
//*** flag parameter ***
+version = 4.3                 binunit = 2                   mobmod = 0
+capmod = 2                    rdsmod = 0                    igcmod = 1
+igbmod = 1                    rbodymod = 0                  trnqsmod = 0
+acnqsmod = 0                  fnoimod = 1                   tnoimod = 0
+diomod = 1                    permod = 1                    rgatemod = 0
+wpemod = 0
//*** geometry range parameter ***
+lmin = 1E-5                   lmax = 9E-4                   wmin = 2E-6
+wmax = 1E-5
//*** process parameter ***
+epsrox = 3.9                  toxe = tox_p_cap                  toxm = tox_p_cap
+dtox = 3.29E-10               xj = 1.7E-7                   ndep = 8.5E17
+ngate = 8E19                  nsd = 1E20                    rsh = 9.68
+rshg = 0.1
//*** dw and dl parameter ***
+wint = 1.089287E-8            wl = 0                        wln = 1
+ww = 0                        wwn = 1                       wwl = 0
+lint = 2E-24                  ll = 0                        lln = 1
+lw = 0                        lwn = 1                       lwl = 0
+lwc = 0                       lwlc = 0                      wwc = 0
+wwlc = 0                      dwg = 0                       dwb = 0
+xl = 0.0+dxl_p_cap                xw = 0.0+dxw_p_cap
//*** flicker noise model parameter ***
+noia = 1.45E42                noib = 3.57E26                noic = 2E10
+em = 2.1E7                    ef = 1.147
//***layout-dependent parasitics model parameter ***
+dmcg = 8.5E-8                 dmci = 8.5E-8                 dmdg = 0
+dmcgt = 0                     dwj = 0                       xgw = 0
+xgl = 0                       ngcon = 1
//*** vth related  parameter ***
+vth0 = ( -0.288698+dvth0_p_cap) + 9.263001E-4
+lvth0 = ( 9.263001E-9+dlvth0_p_cap) -9.263001E-9
+wvth0 = ( 1.029638E-8+dwvth0_p_cap)  -6.341168E-10
+pvth0 = ( -6.341168E-15+dpvth0_p_cap)  + 6.341168E-15
+phin = 0                      k1 = 0.25                     k2 = -8.431308E-3
+k3 = -1.700953                k3b = 1.200306                w0 = 1.585076E-7
+lpe0 = 7.519925E-8            lpeb = 5.608072E-8            dvtp0 = 2.2E-6
+dvtp1 = 0.2                   dvt0 = 0.20341                dvt1 = 0.95146
+dvt2 = 0.01                   dvt0w = 0                     dvt1w = 5.366499E6
+dvt2w = 0
//*** mobility related parameter ***
+u0 = ( 0.0230515+du0_p_cap) -2.679199E-4 lu0 = ( -2.679199E-9+dlu0_p_cap) + 2.679199E-9
+wu0 = ( -3.385616E-9+dwu0_p_cap) + 3.783728E-10
+pu0 = ( 3.783728E-15+dpu0_p_cap) -3.783728E-15
+ua = 4.814997E-11             wua = -5.097562E-17           ub = 1.511461E-18
+wub = -4.625968E-25           uc = 6.551685E-11             ud = 0
+vsat = 117731.5+dvsat_p_cap       a0 = 2.370221                 wa0 = 5.065114E-7
+ags = 1.214472                wags = 1.114614E-7            b0 = 0
+b1 = 0                        keta = -0.106705              a1 = 0
+a2 = 1                        rdsw = 327.6                  prwb = -0.249981
+prwg = 0.25                   wr = 1
//*** subthreshold related parameter ***
+voff = -4.87424E-2            wvoff = 9.76688E-9            voffl = -6.036214E-9
+minv = 0                      nfactor = 0.338752            wnfactor = -2.981336E-8
+eta0 = 3.11538E-2             etab = -2.38505E-2            dsub = 1.2725
+cit = 1E-4                    cdsc = 0                      cdscb = 0
+cdscd = 0
//*** output resistance related parameter ***
+pclm = 0.627258               pdiblc1 = 0                   pdiblc2 = 1.10455E-2
+wpdiblc2 = 9.548759E-10       pdiblcb = 0                   drout = 1.132692
+pscbe1 = 9.264E8              pscbe2 = 1E-20                pvag = 1.425
+delta = 0.02                  fprout = 390.234144           pdits = 5.042617E-3
+pditsl = 100                  pditsd = 0                    lc = 0
+alpha0 = 0                    alpha1 = 0.06                 beta0 = 13.5
+agidl = 9E-8                  bgidl = 3.404E9               cgidl = 0.5
+egidl = 0.15
//*** gate dielectric tunneling current ***
+aigbacc = 0.012               bigbacc = 3.49E-3             cigbacc = 0.131
+nigbacc = 5.2                 aigbinv = 0.347               bigbinv = 0.0312
+cigbinv = 6.1E-3              eigbinv = 1.1                 nigbinv = 1
+aigc = 7.12E-3                bigc = 6.31E-4                cigc = 0
+aigsd = 5.9E-3                bigsd = 2.48E-4               cigsd = 0.032
+dlcig = 2.52E-9               nigc = 2.28                   poxedge = 1
+pigcd = 2.28                  ntox = 1                      toxref = 3E-9
//*** capacitance parameter ***
+xpart = 1                     cgso = 3.1E-11+dcgso_p_cap        cgdo = 3.1E-11+dcgdo_p_cap
+cgbo = 0                      ckappas = 0.6                 ckappad = 0.6
+cf = 1.18E-10                 clc = 1E-7                    cle = 0.6
+dlc = 0                 dwc = 0                       noff = 2.5
+voffcv = -0.0486              acde = 1.2                    moin = 8
+cgsl = 0.54E-10+dcgsl_p_cap       cgdl = 0.54E-10+dcgdl_p_cap
//*** souce/drain junction diode model parameter **
+ijthsrev = 0.01               ijthsfwd = 0.01               xjbvs = 1
+bvs = 10                      jss = 1.51E-7                 jsws = 3.98E-13
+jswgs = 2.47E-12              cjs = 9.98E-4+dcj_p_cap           mjs = 0.34
+mjsws = 0.012                 cjsws = 6.21E-11+dcjsw_p_cap      cjswgs = 2.53E-10+dcjswg_p_cap
+mjswgs = 0.86                 pbs = 0.75                    pbsws = 0.49
+pbswgs = 0.71
//** rf model related parameter ***
+xrcrg1 = 12                   xrcrg2 = 1                    rbpb = 50
+rbpd = 50                     rbps = 50                     rbdb = 50
+rbsb = 50                     gbmin = 1E-12
//*** stress effect related parameter ***
+saref = 6.1E-7                sbref = 6.1E-7                wlod = 2.86E-7
+ku0 = 1E-7                    kvsat = -0.386                kvth0 = 2E-10
+tku0 = 0.24                   llodku0 = 1                   wlodku0 = 1
+llodvth = 1.8                 wlodvth = 1                   lku0 = 1.871E-7
+wku0 = 2.4E-7                 pku0 = -3.24E-14              lkvth0 = 2.4E-10
+wkvth0 = 1.8E-10              pkvth0 = 0                    stk2 = 0
+lodk2 = 1.9                   steta0 = 0                    lodeta0 = 1
//*** temperature coefficient ***
+tnom = 25                     ute = -1.524                  kt1 = -0.229
+kt1l = 0                      kt2 = -0.01232                ua1 = 4.549E-9
+ub1 = -5.441E-18              uc1 = -5E-11                  at = 4.00001E4
+prt = 0                       njs = 1                       xtis = 3
+tpb = 1.9E-3                  tpbsw = 1.9E-3                tpbswg = 1.9E-3
+tcj = 7.98E-4                 tcjsw = 2.4E-4                tcjswg = 4.77E-3
//*** well proximity effect model parameters ***
+web = -220                    wec = -3E3                    kvth0we = -3.197498E-3
+k2we = 3E-4                   ku0we = -3.482487E-3          scref = 1E-6
36:type=p  minr=1e-60
//*** flag parameter ***
+version = 4.3                 binunit = 2                   mobmod = 0
+capmod = 2                    rdsmod = 0                    igcmod = 1
+igbmod = 1                    rbodymod = 0                  trnqsmod = 0
+acnqsmod = 0                  fnoimod = 1                   tnoimod = 0
+diomod = 1                    permod = 1                    rgatemod = 0
+wpemod = 0
//*** geometry range parameter ***
+lmin = 4E-8                   lmax = 6E-8                   wmin = 1E-5
+wmax = 9E-4
//*** process parameter ***
+epsrox = 3.9                  toxe = tox_p_cap                  toxm = tox_p_cap
+dtox = 3.29E-10               xj = 1.7E-7                   ndep = 8.5E17
+ngate = 8E19                  nsd = 1E20                    rsh = 9.68
+rshg = 0.1
//*** dw and dl parameter ***
+wint = 1.089287E-8            wl = 0                        wln = 1
+ww = 0                        wwn = 1                       wwl = 0
+lint = 2E-24                  ll = 0                        lln = 1
+lw = 0                        lwn = 1                       lwl = 0
+lwc = 0                       lwlc = 0                      wwc = 0
+wwlc = 0                      dwg = 0                       dwb = 0
+xl = 0.0+dxl_p_cap                xw = 0.0+dxw_p_cap
//*** flicker noise model parameter ***
+noia = 1.45E42                noib = 3.57E26                noic = 2E10
+em = 2.1E7                    ef = 1.147
//***layout-dependent parasitics model parameter ***
+dmcg = 8.5E-8                 dmci = 8.5E-8                 dmdg = 0
+dmcgt = 0                     dwj = 0                       xgw = 0
+xgl = 0                       ngcon = 1
//*** vth related  parameter ***
+vth0 = ( -0.288698+dvth0_p_cap) -0.072901 lvth0 = ( 9.263001E-9+dlvth0_p_cap) -5.549849E-9
+wvth0 = ( 1.029638E-8+dwvth0_p_cap)  -1.029638E-8
+pvth0 = ( -6.341168E-15+dpvth0_p_cap)  + 6.341168E-15
+phin = 0                      k1 = 0.25                     k2 = -1.99911E-2
+lk2 = -1.447079E-10           k3 = -1.700953                k3b = 1.200306
+w0 = 1.585076E-7              lpe0 = 7.519925E-8            lpeb = 5.608072E-8
+dvtp0 = 2.2E-6                dvtp1 = 0.2                   dvt0 = 0.20341
+dvt1 = 0.95146                dvt2 = 0.01                   dvt0w = 0
+dvt1w = 5.366499E6            dvt2w = 0
//*** mobility related parameter ***
+u0 = ( 0.0230515+du0_p_cap) + 5.473965E-3 lu0 = ( -2.679199E-9+dlu0_p_cap) + 2.310274E-9
+wu0 = ( -3.385616E-9+dwu0_p_cap) + 3.385616E-9
+pu0 = ( 3.783728E-15+dpu0_p_cap) -3.783728E-15
+ua = 1.054512E-11             ub = 1.77721E-18              lub = 2.872688E-26
+uc = -3.301007E-10            luc = 2.373388E-17            ud = 0
+vsat = ( 117731.5+dvsat_p_cap) + 1.421843E3 lvsat = 1.016943E-3           a0 = 1E-3
+ags = 4.3357                  b0 = 0                        b1 = 0
+keta = -0.116247              lketa = 2.399963E-9           a1 = 0
+a2 = 1                        rdsw = 327.6                  prwb = -0.249981
+prwg = 0.25                   wr = 1
//*** subthreshold related parameter ***
+voff = -0.107873              lvoff = 3.839998E-9           voffl = -6.036214E-9
+minv = 0                      nfactor = 0.440751            lnfactor = 3.966766E-8
+eta0 = 3.11538E-2             etab = 0.164989               letab = -1.133038E-8
+dsub = 1.2725                 cit = 1E-4                    cdsc = 0
+cdscb = 0                     cdscd = 0
//*** output resistance related parameter ***
+pclm = 0.627258               pdiblc1 = 0                   pdiblc2 = 1.05791E-2
+lpdiblc2 = -1.849831E-10      pdiblcb = 0                   drout = 1.132692
+pscbe1 = 9.264E8              pscbe2 = 1E-20                pvag = 1.425
+delta = 0.02                  fprout = 390.234144           pdits = 5.042617E-3
+pditsl = 100                  pditsd = 0                    lc = 0
+alpha0 = 0                    alpha1 = 0.06                 beta0 = 13.5
+agidl = 9E-8                  bgidl = 3.404E9               cgidl = 0.5
+egidl = 0.15
//*** gate dielectric tunneling current ***
+aigbacc = 0.012               bigbacc = 3.49E-3             cigbacc = 0.131
+nigbacc = 5.2                 aigbinv = 0.347               bigbinv = 0.0312
+cigbinv = 6.1E-3              eigbinv = 1.1                 nigbinv = 1
+aigc = 7.12E-3                bigc = 6.31E-4                cigc = 0
+aigsd = 5.9E-3                bigsd = 2.48E-4               cigsd = 0.032
+dlcig = 2.52E-9               nigc = 2.28                   poxedge = 1
+pigcd = 2.28                  ntox = 1                      toxref = 3E-9
//*** capacitance parameter ***
+xpart = 1                     cgso = 3.1E-11+dcgso_p_cap        cgdo = 3.1E-11+dcgdo_p_cap
+cgbo = 0                      ckappas = 0.6                 ckappad = 0.6
+cf = 1.18E-10                 clc = 1E-7                    cle = 0.6
+dlc = 0                 dwc = 0                       noff = 2.5
+voffcv = -0.0486              acde = 1.2                    moin = 8
+cgsl = 0.54E-10+dcgsl_p_cap       cgdl = 0.54E-10+dcgdl_p_cap
//*** souce/drain junction diode model parameter **
+ijthsrev = 0.01               ijthsfwd = 0.01               xjbvs = 1
+bvs = 10                      jss = 1.51E-7                 jsws = 3.98E-13
+jswgs = 2.47E-12              cjs = 9.98E-4+dcj_p_cap           mjs = 0.34
+mjsws = 0.012                 cjsws = 6.21E-11+dcjsw_p_cap      cjswgs = 2.53E-10+dcjswg_p_cap
+mjswgs = 0.86                 pbs = 0.75                    pbsws = 0.49
+pbswgs = 0.71
//** rf model related parameter ***
+xrcrg1 = 12                   xrcrg2 = 1                    rbpb = 50
+rbpd = 50                     rbps = 50                     rbdb = 50
+rbsb = 50                     gbmin = 1E-12
//*** stress effect related parameter ***
+saref = 6.1E-7                sbref = 6.1E-7                wlod = 2.86E-7
+ku0 = 1E-7                    kvsat = -0.386                kvth0 = 2E-10
+tku0 = 0.24                   llodku0 = 1                   wlodku0 = 1
+llodvth = 1.8                 wlodvth = 1                   lku0 = 1.871E-7
+wku0 = 2.4E-7                 pku0 = -3.24E-14              lkvth0 = 2.4E-10
+wkvth0 = 1.8E-10              pkvth0 = 0                    stk2 = 0
+lodk2 = 1.9                   steta0 = 0                    lodeta0 = 1
//*** temperature coefficient ***
+tnom = 25                     ute = -1.524                  kt1 = -0.229
+kt1l = 0                      kt2 = -0.01232                ua1 = 4.549E-9
+ub1 = -5.441E-18              uc1 = -5E-11                  at = 4.00001E4
+prt = 0                       njs = 1                       xtis = 3
+tpb = 1.9E-3                  tpbsw = 1.9E-3                tpbswg = 1.9E-3
+tcj = 7.98E-4                 tcjsw = 2.4E-4                tcjswg = 4.77E-3
//*** well proximity effect model parameters ***
+web = -220                    wec = -3E3                    kvth0we = -3.197498E-3
+k2we = 3E-4                   ku0we = -3.482487E-3          scref = 1E-6
37:type=p  minr=1e-60
//*** flag parameter ***
+version = 4.3                 binunit = 2                   mobmod = 0
+capmod = 2                    rdsmod = 0                    igcmod = 1
+igbmod = 1                    rbodymod = 0                  trnqsmod = 0
+acnqsmod = 0                  fnoimod = 1                   tnoimod = 0
+diomod = 1                    permod = 1                    rgatemod = 0
+wpemod = 0
//*** geometry range parameter ***
+lmin = 6E-8                   lmax = 1E-7                   wmin = 1E-5
+wmax = 9E-4
//*** process parameter ***
+epsrox = 3.9                  toxe = tox_p_cap                  toxm = tox_p_cap
+dtox = 3.29E-10               xj = 1.7E-7                   ndep = 8.5E17
+ngate = 8E19                  nsd = 1E20                    rsh = 9.68
+rshg = 0.1
//*** dw and dl parameter ***
+wint = 1.089287E-8            wl = 0                        wln = 1
+ww = 0                        wwn = 1                       wwl = 0
+lint = 2E-24                  ll = 0                        lln = 1
+lw = 0                        lwn = 1                       lwl = 0
+lwc = 0                       lwlc = 0                      wwc = 0
+wwlc = 0                      dwg = 0                       dwb = 0
+xl = 0.0+dxl_p_cap                xw = 0.0+dxw_p_cap
//*** flicker noise model parameter ***
+noia = 1.45E42                noib = 3.57E26                noic = 2E10
+em = 2.1E7                    ef = 1.147
//***layout-dependent parasitics model parameter ***
+dmcg = 8.5E-8                 dmci = 8.5E-8                 dmdg = 0
+dmcgt = 0                     dwj = 0                       xgw = 0
+xgl = 0                       ngcon = 1
//*** vth related  parameter ***
+vth0 = ( -0.288698+dvth0_p_cap) -0.021918 lvth0 = ( 9.263001E-9+dlvth0_p_cap) -8.608827E-9
+wvth0 = ( 1.029638E-8+dwvth0_p_cap)  -1.029638E-8
+pvth0 = ( -6.341168E-15+dpvth0_p_cap)  + 6.341168E-15
+phin = 0                      k1 = 0.25                     k2 = -1.009892E-3
+lk2 = -1.283581E-9            k3 = -1.700953                k3b = 1.200306
+w0 = 1.585076E-7              lpe0 = 7.519925E-8            lpeb = 5.608072E-8
+dvtp0 = 2.2E-6                dvtp1 = 0.2                   dvt0 = 0.20341
+dvt1 = 0.95146                dvt2 = 0.01                   dvt0w = 0
+dvt1w = 5.366499E6            dvt2w = 0
//*** mobility related parameter ***
+u0 = ( 0.0230515+du0_p_cap) + 3.768072E-5 lu0 = ( -2.679199E-9+dlu0_p_cap) + 2.636451E-9
+wu0 = ( -3.385616E-9+dwu0_p_cap) + 3.385616E-9
+pu0 = ( 3.783728E-15+dpu0_p_cap) -3.783728E-15
+ua = 1.054511E-11             ub = 1.302153E-18             lub = 5.72303E-26
+uc = 2.769628E-11             luc = 2.266059E-18            ud = 0
+vsat = ( 117731.5+dvsat_p_cap) -2.755634E4 lvsat = 2.755634E-3           a0 = 1E-3
+ags = 4.3357                  b0 = 0                        b1 = 0
+keta = 6.011596E-3            lketa = -4.935575E-9          a1 = 0
+a2 = 1                        rdsw = 327.6                  prwb = -0.249981
+prwg = 0.25                   wr = 1
//*** subthreshold related parameter ***
+voff = -7.93795E-2            lvoff = 2.130384E-9           voffl = -6.036214E-9
+minv = 0                      nfactor = 0.208464            lnfactor = 5.360488E-8
+eta0 = 3.11538E-2             etab = -2.38505E-2            dsub = 1.2725
+cit = 1E-4                    cdsc = 0                      cdscb = 0
+cdscd = 0
//*** output resistance related parameter ***
+pclm = 0.627258               pdiblc1 = 0                   pdiblc2 = 1.09799E-2
+lpdiblc2 = -2.09036E-10       pdiblcb = 0                   drout = 1.132692
+pscbe1 = 9.264E8              pscbe2 = 1E-20                pvag = 1.425
+delta = 0.02                  fprout = 390.234144           pdits = 5.042617E-3
+pditsl = 100                  pditsd = 0                    lc = 0
+alpha0 = 0                    alpha1 = 0.06                 beta0 = 13.5
+agidl = 9E-8                  bgidl = 3.404E9               cgidl = 0.5
+egidl = 0.15
//*** gate dielectric tunneling current ***
+aigbacc = 0.012               bigbacc = 3.49E-3             cigbacc = 0.131
+nigbacc = 5.2                 aigbinv = 0.347               bigbinv = 0.0312
+cigbinv = 6.1E-3              eigbinv = 1.1                 nigbinv = 1
+aigc = 7.12E-3                bigc = 6.31E-4                cigc = 0
+aigsd = 5.9E-3                bigsd = 2.48E-4               cigsd = 0.032
+dlcig = 2.52E-9               nigc = 2.28                   poxedge = 1
+pigcd = 2.28                  ntox = 1                      toxref = 3E-9
//*** capacitance parameter ***
+xpart = 1                     cgso = 3.1E-11+dcgso_p_cap        cgdo = 3.1E-11+dcgdo_p_cap
+cgbo = 0                      ckappas = 0.6                 ckappad = 0.6
+cf = 1.18E-10                 clc = 1E-7                    cle = 0.6
+dlc = 0                 dwc = 0                       noff = 2.5
+voffcv = -0.0486              acde = 1.2                    moin = 8
+cgsl = 0.54E-10+dcgsl_p_cap       cgdl = 0.54E-10+dcgdl_p_cap
//*** souce/drain junction diode model parameter **
+ijthsrev = 0.01               ijthsfwd = 0.01               xjbvs = 1
+bvs = 10                      jss = 1.51E-7                 jsws = 3.98E-13
+jswgs = 2.47E-12              cjs = 9.98E-4+dcj_p_cap           mjs = 0.34
+mjsws = 0.012                 cjsws = 6.21E-11+dcjsw_p_cap      cjswgs = 2.53E-10+dcjswg_p_cap
+mjswgs = 0.86                 pbs = 0.75                    pbsws = 0.49
+pbswgs = 0.71
//** rf model related parameter ***
+xrcrg1 = 12                   xrcrg2 = 1                    rbpb = 50
+rbpd = 50                     rbps = 50                     rbdb = 50
+rbsb = 50                     gbmin = 1E-12
//*** stress effect related parameter ***
+saref = 6.1E-7                sbref = 6.1E-7                wlod = 2.86E-7
+ku0 = 1E-7                    kvsat = -0.386                kvth0 = 2E-10
+tku0 = 0.24                   llodku0 = 1                   wlodku0 = 1
+llodvth = 1.8                 wlodvth = 1                   lku0 = 1.871E-7
+wku0 = 2.4E-7                 pku0 = -3.24E-14              lkvth0 = 2.4E-10
+wkvth0 = 1.8E-10              pkvth0 = 0                    stk2 = 0
+lodk2 = 1.9                   steta0 = 0                    lodeta0 = 1
//*** temperature coefficient ***
+tnom = 25                     ute = -1.524                  kt1 = -0.229
+kt1l = 0                      kt2 = -0.01232                ua1 = 4.549E-9
+ub1 = -5.441E-18              uc1 = -5E-11                  at = 4.00001E4
+prt = 0                       njs = 1                       xtis = 3
+tpb = 1.9E-3                  tpbsw = 1.9E-3                tpbswg = 1.9E-3
+tcj = 7.98E-4                 tcjsw = 2.4E-4                tcjswg = 4.77E-3
//*** well proximity effect model parameters ***
+web = -220                    wec = -3E3                    kvth0we = -3.197498E-3
+k2we = 3E-4                   ku0we = -3.482487E-3          scref = 1E-6
38:type=p  minr=1e-60
//*** flag parameter ***
+version = 4.3                 binunit = 2                   mobmod = 0
+capmod = 2                    rdsmod = 0                    igcmod = 1
+igbmod = 1                    rbodymod = 0                  trnqsmod = 0
+acnqsmod = 0                  fnoimod = 1                   tnoimod = 0
+diomod = 1                    permod = 1                    rgatemod = 0
+wpemod = 0
//*** geometry range parameter ***
+lmin = 1E-7                   lmax = 5E-7                   wmin = 1E-5
+wmax = 9E-4
//*** process parameter ***
+epsrox = 3.9                  toxe = tox_p_cap                  toxm = tox_p_cap
+dtox = 3.29E-10               xj = 1.7E-7                   ndep = 8.5E17
+ngate = 8E19                  nsd = 1E20                    rsh = 9.68
+rshg = 0.1
//*** dw and dl parameter ***
+wint = 1.089287E-8            wl = 0                        wln = 1
+ww = 0                        wwn = 1                       wwl = 0
+lint = 2E-24                  ll = 0                        lln = 1
+lw = 0                        lwn = 1                       lwl = 0
+lwc = 0                       lwlc = 0                      wwc = 0
+wwlc = 0                      dwg = 0                       dwb = 0
+xl = 0.0+dxl_p_cap                xw = 0.0+dxw_p_cap
//*** flicker noise model parameter ***
+noia = 1.45E42                noib = 3.57E26                noic = 2E10
+em = 2.1E7                    ef = 1.147
//***layout-dependent parasitics model parameter ***
+dmcg = 8.5E-8                 dmci = 8.5E-8                 dmdg = 0
+dmcgt = 0                     dwj = 0                       xgw = 0
+xgl = 0                       ngcon = 1
//*** vth related  parameter ***
+vth0 = ( -0.288698+dvth0_p_cap) + 0.012972 lvth0 = ( 9.263001E-9+dlvth0_p_cap) -1.209789E-8
+wvth0 = ( 1.029638E-8+dwvth0_p_cap)  -1.029638E-8
+pvth0 = ( -6.341168E-15+dpvth0_p_cap)  + 6.341168E-15
+phin = 0                      k1 = 0.25                     k2 = -8.886616E-3
+lk2 = -4.959084E-10           k3 = -1.700953                k3b = 1.200306
+w0 = 1.585076E-7              lpe0 = 7.519925E-8            lpeb = 5.608072E-8
+dvtp0 = 2.2E-6                dvtp1 = 0.2                   dvt0 = 0.20341
+dvt1 = 0.95146                dvt2 = 0.01                   dvt0w = 0
+dvt1w = 5.366499E6            dvt2w = 0
//*** mobility related parameter ***
+u0 = ( 0.0230515+du0_p_cap) -2.207262E-3 lu0 = ( -2.679199E-9+dlu0_p_cap) + 2.860945E-9
+wu0 = ( -3.385616E-9+dwu0_p_cap) + 3.385616E-9
+pu0 = ( 3.783728E-15+dpu0_p_cap) -3.783728E-15
+ua = 1.054512E-11             ub = 1.190789E-18             lub = 6.836674E-26
+uc = 2.937485E-11             luc = 2.098202E-18            ud = 0
+vsat = 117731.5+dvsat_p_cap       a0 = 2.10947                  la0 = -2.10847E-7
+ags = 2.529159                lags = 1.806541E-7            b0 = 0
+b1 = 0                        keta = -9.75244E-2            lketa = 5.418027E-9
+a1 = 0                        a2 = 1                        rdsw = 327.6
+prwb = -0.249981              prwg = 0.25                   wr = 1
//*** subthreshold related parameter ***
+voff = -3.79585E-2            lvoff = -2.011711E-9          voffl = -6.036214E-9
+minv = 0                      nfactor = 0.394053            lnfactor = 3.504595E-8
+eta0 = 3.11538E-2             etab = -2.38505E-2            dsub = 1.2725
+cit = 1E-4                    cdsc = 0                      cdscb = 0
+cdscd = 0
//*** output resistance related parameter ***
+pclm = 0.627258               pdiblc1 = 0                   pdiblc2 = 1.09598E-2
+lpdiblc2 = -2.070245E-10      pdiblcb = 0                   drout = 1.132692
+pscbe1 = 9.264E8              pscbe2 = 1E-20                pvag = 1.425
+delta = 0.02                  fprout = 390.234144           pdits = 5.042617E-3
+pditsl = 100                  pditsd = 0                    lc = 0
+alpha0 = 0                    alpha1 = 0.06                 beta0 = 13.5
+agidl = 9E-8                  bgidl = 3.404E9               cgidl = 0.5
+egidl = 0.15
//*** gate dielectric tunneling current ***
+aigbacc = 0.012               bigbacc = 3.49E-3             cigbacc = 0.131
+nigbacc = 5.2                 aigbinv = 0.347               bigbinv = 0.0312
+cigbinv = 6.1E-3              eigbinv = 1.1                 nigbinv = 1
+aigc = 7.12E-3                bigc = 6.31E-4                cigc = 0
+aigsd = 5.9E-3                bigsd = 2.48E-4               cigsd = 0.032
+dlcig = 2.52E-9               nigc = 2.28                   poxedge = 1
+pigcd = 2.28                  ntox = 1                      toxref = 3E-9
//*** capacitance parameter ***
+xpart = 1                     cgso = 3.1E-11+dcgso_p_cap        cgdo = 3.1E-11+dcgdo_p_cap
+cgbo = 0                      ckappas = 0.6                 ckappad = 0.6
+cf = 1.18E-10                 clc = 1E-7                    cle = 0.6
+dlc = 0                 dwc = 0                       noff = 2.5
+voffcv = -0.0486              acde = 1.2                    moin = 8
+cgsl = 0.54E-10+dcgsl_p_cap       cgdl = 0.54E-10+dcgdl_p_cap
//*** souce/drain junction diode model parameter **
+ijthsrev = 0.01               ijthsfwd = 0.01               xjbvs = 1
+bvs = 10                      jss = 1.51E-7                 jsws = 3.98E-13
+jswgs = 2.47E-12              cjs = 9.98E-4+dcj_p_cap           mjs = 0.34
+mjsws = 0.012                 cjsws = 6.21E-11+dcjsw_p_cap      cjswgs = 2.53E-10+dcjswg_p_cap
+mjswgs = 0.86                 pbs = 0.75                    pbsws = 0.49
+pbswgs = 0.71
//** rf model related parameter ***
+xrcrg1 = 12                   xrcrg2 = 1                    rbpb = 50
+rbpd = 50                     rbps = 50                     rbdb = 50
+rbsb = 50                     gbmin = 1E-12
//*** stress effect related parameter ***
+saref = 6.1E-7                sbref = 6.1E-7                wlod = 2.86E-7
+ku0 = 1E-7                    kvsat = -0.386                kvth0 = 2E-10
+tku0 = 0.24                   llodku0 = 1                   wlodku0 = 1
+llodvth = 1.8                 wlodvth = 1                   lku0 = 1.871E-7
+wku0 = 2.4E-7                 pku0 = -3.24E-14              lkvth0 = 2.4E-10
+wkvth0 = 1.8E-10              pkvth0 = 0                    stk2 = 0
+lodk2 = 1.9                   steta0 = 0                    lodeta0 = 1
//*** temperature coefficient ***
+tnom = 25                     ute = -1.524                  kt1 = -0.229
+kt1l = 0                      kt2 = -0.01232                ua1 = 4.549E-9
+ub1 = -5.441E-18              uc1 = -5E-11                  at = 4.00001E4
+prt = 0                       njs = 1                       xtis = 3
+tpb = 1.9E-3                  tpbsw = 1.9E-3                tpbswg = 1.9E-3
+tcj = 7.98E-4                 tcjsw = 2.4E-4                tcjswg = 4.77E-3
//*** well proximity effect model parameters ***
+web = -220                    wec = -3E3                    kvth0we = -3.197498E-3
+k2we = 3E-4                   ku0we = -3.482487E-3          scref = 1E-6
39:type=p  minr=1e-60
//*** flag parameter ***
+version = 4.3                 binunit = 2                   mobmod = 0
+capmod = 2                    rdsmod = 0                    igcmod = 1
+igbmod = 1                    rbodymod = 0                  trnqsmod = 0
+acnqsmod = 0                  fnoimod = 1                   tnoimod = 0
+diomod = 1                    permod = 1                    rgatemod = 0
+wpemod = 0
//*** geometry range parameter ***
+lmin = 5E-7                   lmax = 1E-6                   wmin = 1E-5
+wmax = 9E-4
//*** process parameter ***
+epsrox = 3.9                  toxe = tox_p_cap                  toxm = tox_p_cap
+dtox = 3.29E-10               xj = 1.7E-7                   ndep = 8.5E17
+ngate = 8E19                  nsd = 1E20                    rsh = 9.68
+rshg = 0.1
//*** dw and dl parameter ***
+wint = 1.089287E-8            wl = 0                        wln = 1
+ww = 0                        wwn = 1                       wwl = 0
+lint = 2E-24                  ll = 0                        lln = 1
+lw = 0                        lwn = 1                       lwl = 0
+lwc = 0                       lwlc = 0                      wwc = 0
+wwlc = 0                      dwg = 0                       dwb = 0
+xl = 0.0+dxl_p_cap                xw = 0.0+dxw_p_cap
//*** flicker noise model parameter ***
+noia = 1.45E42                noib = 3.57E26                noic = 2E10
+em = 2.1E7                    ef = 1.147
//***layout-dependent parasitics model parameter ***
+dmcg = 8.5E-8                 dmci = 8.5E-8                 dmdg = 0
+dmcgt = 0                     dwj = 0                       xgw = 0
+xgl = 0                       ngcon = 1
//*** vth related  parameter ***
+vth0 = ( -0.288698+dvth0_p_cap) + 7.302602E-3
+lvth0 = ( 9.263001E-9+dlvth0_p_cap) -9.263001E-9
+wvth0 = ( 1.029638E-8+dwvth0_p_cap)  -1.029638E-8
+pvth0 = ( -6.341168E-15+dpvth0_p_cap)  + 6.341168E-15
+phin = 0                      k1 = 0.25                     k2 = -9.878433E-3
+k3 = -1.700953                k3b = 1.200306                w0 = 1.585076E-7
+lpe0 = 7.519925E-8            lpeb = 5.608072E-8            dvtp0 = 2.2E-6
+dvtp1 = 0.2                   dvt0 = 0.20341                dvt1 = 0.95146
+dvt2 = 0.01                   dvt0w = 0                     dvt1w = 5.366499E6
+dvt2w = 0
//*** mobility related parameter ***
+u0 = ( 0.0230515+du0_p_cap) -2.185256E-3 lu0 = ( -2.679199E-9+dlu0_p_cap) + 2.849942E-9
+wu0 = ( -3.385616E-9+dwu0_p_cap) + 3.385616E-9
+pu0 = ( 3.783728E-15+dpu0_p_cap) -3.783728E-15
+ua = 3.163532E-11             lua = -1.05451E-17            ub = 1.185617E-18
+lub = 7.095275E-26            uc = 5.815234E-11             luc = -1.229055E-17
+ud = 0                        vsat = 117731.5+dvsat_p_cap       a0 = 3.154189
+la0 = -7.332062E-7            ags = 1.224853                lags = 8.328069E-7
+b0 = 0                        b1 = 0                        keta = -8.66884E-2
+a1 = 0                        a2 = 1                        rdsw = 327.6
+prwb = -0.249981              prwg = 0.25                   wr = 1
//*** subthreshold related parameter ***
+voff = -4.13865E-2            lvoff = -2.97711E-10          voffl = -6.036214E-9
+minv = 0                      nfactor = 0.329159            lnfactor = 6.749302E-8
+eta0 = 3.11538E-2             etab = -2.38505E-2            dsub = 1.2725
+cit = 1E-4                    cdsc = 0                      cdscb = 0
+cdscd = 0
//*** output resistance related parameter ***
+pclm = 0.627258               pdiblc1 = 0                   pdiblc2 = 1.25628E-2
+lpdiblc2 = -1.00851E-9        pdiblcb = 0                   drout = 1.132692
+pscbe1 = 9.264E8              pscbe2 = 1E-20                pvag = 1.425
+delta = 0.02                  fprout = 390.234144           pdits = 5.042617E-3
+pditsl = 100                  pditsd = 0                    lc = 0
+alpha0 = 0                    alpha1 = 0.06                 beta0 = 13.5
+agidl = 9E-8                  bgidl = 3.404E9               cgidl = 0.5
+egidl = 0.15
//*** gate dielectric tunneling current ***
+aigbacc = 0.012               bigbacc = 3.49E-3             cigbacc = 0.131
+nigbacc = 5.2                 aigbinv = 0.347               bigbinv = 0.0312
+cigbinv = 6.1E-3              eigbinv = 1.1                 nigbinv = 1
+aigc = 7.12E-3                bigc = 6.31E-4                cigc = 0
+aigsd = 5.9E-3                bigsd = 2.48E-4               cigsd = 0.032
+dlcig = 2.52E-9               nigc = 2.28                   poxedge = 1
+pigcd = 2.28                  ntox = 1                      toxref = 3E-9
//*** capacitance parameter ***
+xpart = 1                     cgso = 3.1E-11+dcgso_p_cap        cgdo = 3.1E-11+dcgdo_p_cap
+cgbo = 0                      ckappas = 0.6                 ckappad = 0.6
+cf = 1.18E-10                 clc = 1E-7                    cle = 0.6
+dlc = 0                 dwc = 0                       noff = 2.5
+voffcv = -0.0486              acde = 1.2                    moin = 8
+cgsl = 0.54E-10+dcgsl_p_cap       cgdl = 0.54E-10+dcgdl_p_cap
//*** souce/drain junction diode model parameter **
+ijthsrev = 0.01               ijthsfwd = 0.01               xjbvs = 1
+bvs = 10                      jss = 1.51E-7                 jsws = 3.98E-13
+jswgs = 2.47E-12              cjs = 9.98E-4+dcj_p_cap           mjs = 0.34
+mjsws = 0.012                 cjsws = 6.21E-11+dcjsw_p_cap      cjswgs = 2.53E-10+dcjswg_p_cap
+mjswgs = 0.86                 pbs = 0.75                    pbsws = 0.49
+pbswgs = 0.71
//** rf model related parameter ***
+xrcrg1 = 12                   xrcrg2 = 1                    rbpb = 50
+rbpd = 50                     rbps = 50                     rbdb = 50
+rbsb = 50                     gbmin = 1E-12
//*** stress effect related parameter ***
+saref = 6.1E-7                sbref = 6.1E-7                wlod = 2.86E-7
+ku0 = 1E-7                    kvsat = -0.386                kvth0 = 2E-10
+tku0 = 0.24                   llodku0 = 1                   wlodku0 = 1
+llodvth = 1.8                 wlodvth = 1                   lku0 = 1.871E-7
+wku0 = 2.4E-7                 pku0 = -3.24E-14              lkvth0 = 2.4E-10
+wkvth0 = 1.8E-10              pkvth0 = 0                    stk2 = 0
+lodk2 = 1.9                   steta0 = 0                    lodeta0 = 1
//*** temperature coefficient ***
+tnom = 25                     ute = -1.524                  kt1 = -0.229
+kt1l = 0                      kt2 = -0.01232                ua1 = 4.549E-9
+ub1 = -5.441E-18              uc1 = -5E-11                  at = 4.00001E4
+prt = 0                       njs = 1                       xtis = 3
+tpb = 1.9E-3                  tpbsw = 1.9E-3                tpbswg = 1.9E-3
+tcj = 7.98E-4                 tcjsw = 2.4E-4                tcjswg = 4.77E-3
//*** well proximity effect model parameters ***
+web = -220                    wec = -3E3                    kvth0we = -3.197498E-3
+k2we = 3E-4                   ku0we = -3.482487E-3          scref = 1E-6
40:type=p  minr=1e-60
//*** flag parameter ***
+version = 4.3                 binunit = 2                   mobmod = 0
+capmod = 2                    rdsmod = 0                    igcmod = 1
+igbmod = 1                    rbodymod = 0                  trnqsmod = 0
+acnqsmod = 0                  fnoimod = 1                   tnoimod = 0
+diomod = 1                    permod = 1                    rgatemod = 0
+wpemod = 0
//*** geometry range parameter ***
+lmin = 1E-6                   lmax = 2E-6                   wmin = 1E-5
+wmax = 9E-4
//*** process parameter ***
+epsrox = 3.9                  toxe = tox_p_cap                  toxm = tox_p_cap
+dtox = 3.29E-10               xj = 1.7E-7                   ndep = 8.5E17
+ngate = 8E19                  nsd = 1E20                    rsh = 9.68
+rshg = 0.1
//*** dw and dl parameter ***
+wint = 1.089287E-8            wl = 0                        wln = 1
+ww = 0                        wwn = 1                       wwl = 0
+lint = 2E-24                  ll = 0                        lln = 1
+lw = 0                        lwn = 1                       lwl = 0
+lwc = 0                       lwlc = 0                      wwc = 0
+wwlc = 0                      dwg = 0                       dwb = 0
+xl = 0.0+dxl_p_cap                xw = 0.0+dxw_p_cap
//*** flicker noise model parameter ***
+noia = 1.45E42                noib = 3.57E26                noic = 2E10
+em = 2.1E7                    ef = 1.147
//***layout-dependent parasitics model parameter ***
+dmcg = 8.5E-8                 dmci = 8.5E-8                 dmdg = 0
+dmcgt = 0                     dwj = 0                       xgw = 0
+xgl = 0                       ngcon = 1
//*** vth related  parameter ***
+vth0 = ( -0.288698+dvth0_p_cap) + 3.408466E-3
+lvth0 = ( 9.263001E-9+dlvth0_p_cap) -5.388661E-9
+wvth0 = ( 1.029638E-8+dwvth0_p_cap)  -1.029638E-8
+pvth0 = ( -6.341168E-15+dpvth0_p_cap)  + 6.341168E-15
+phin = 0                      k1 = 0.25                     k2 = -9.878433E-3
+k3 = -1.700953                k3b = 1.200306                w0 = 1.585076E-7
+lpe0 = 7.519925E-8            lpeb = 5.608072E-8            dvtp0 = 2.2E-6
+dvtp1 = 0.2                   dvt0 = 0.20341                dvt1 = 0.95146
+dvt2 = 0.01                   dvt0w = 0                     dvt1w = 5.366499E6
+dvt2w = 0
//*** mobility related parameter ***
+u0 = ( 0.0230515+du0_p_cap) -9.640885E-4 lu0 = ( -2.679199E-9+dlu0_p_cap) + 1.628774E-9
+wu0 = ( -3.385616E-9+dwu0_p_cap) + 3.385616E-9
+pu0 = ( 3.783728E-15+dpu0_p_cap) -3.783728E-15
+ua = 3.916758E-11             lua = -1.807735E-17           ub = 1.367178E-18
+lub = -1.106085E-25           uc = 4.58618E-11              ud = 0
+vsat = 117731.5+dvsat_p_cap       a0 = 2.420983                 ags = 1.107971
+lags = 9.496896E-7            b0 = 0                        b1 = 0
+keta = -0.126722              lketa = 4.003328E-8           a1 = 0
+a2 = 1                        rdsw = 327.6                  prwb = -0.249981
+prwg = 0.25                   wr = 1
//*** subthreshold related parameter ***
+voff = -4.56385E-2            lvoff = 3.954296E-9           voffl = -6.036214E-9
+minv = 0                      nfactor = 0.325875            lnfactor = 7.077771E-8
+eta0 = 3.11538E-2             etab = -2.38505E-2            dsub = 1.2725
+cit = 1E-4                    cdsc = 0                      cdscb = 0
+cdscd = 0
//*** output resistance related parameter ***
+pclm = 0.627258               pdiblc1 = 0                   pdiblc2 = 1.12108E-2
+lpdiblc2 = 3.434938E-10       pdiblcb = 0                   drout = 1.132692
+pscbe1 = 9.264E8              pscbe2 = 1E-20                pvag = 1.425
+delta = 0.02                  fprout = 390.234144           pdits = 5.042617E-3
+pditsl = 100                  pditsd = 0                    lc = 0
+alpha0 = 0                    alpha1 = 0.06                 beta0 = 13.5
+agidl = 9E-8                  bgidl = 3.404E9               cgidl = 0.5
+egidl = 0.15
//*** gate dielectric tunneling current ***
+aigbacc = 0.012               bigbacc = 3.49E-3             cigbacc = 0.131
+nigbacc = 5.2                 aigbinv = 0.347               bigbinv = 0.0312
+cigbinv = 6.1E-3              eigbinv = 1.1                 nigbinv = 1
+aigc = 7.12E-3                bigc = 6.31E-4                cigc = 0
+aigsd = 5.9E-3                bigsd = 2.48E-4               cigsd = 0.032
+dlcig = 2.52E-9               nigc = 2.28                   poxedge = 1
+pigcd = 2.28                  ntox = 1                      toxref = 3E-9
//*** capacitance parameter ***
+xpart = 1                     cgso = 3.1E-11+dcgso_p_cap        cgdo = 3.1E-11+dcgdo_p_cap
+cgbo = 0                      ckappas = 0.6                 ckappad = 0.6
+cf = 1.18E-10                 clc = 1E-7                    cle = 0.6
+dlc = 0                 dwc = 0                       noff = 2.5
+voffcv = -0.0486              acde = 1.2                    moin = 8
+cgsl = 0.54E-10+dcgsl_p_cap       cgdl = 0.54E-10+dcgdl_p_cap
//*** souce/drain junction diode model parameter **
+ijthsrev = 0.01               ijthsfwd = 0.01               xjbvs = 1
+bvs = 10                      jss = 1.51E-7                 jsws = 3.98E-13
+jswgs = 2.47E-12              cjs = 9.98E-4+dcj_p_cap           mjs = 0.34
+mjsws = 0.012                 cjsws = 6.21E-11+dcjsw_p_cap      cjswgs = 2.53E-10+dcjswg_p_cap
+mjswgs = 0.86                 pbs = 0.75                    pbsws = 0.49
+pbswgs = 0.71
//** rf model related parameter ***
+xrcrg1 = 12                   xrcrg2 = 1                    rbpb = 50
+rbpd = 50                     rbps = 50                     rbdb = 50
+rbsb = 50                     gbmin = 1E-12
//*** stress effect related parameter ***
+saref = 6.1E-7                sbref = 6.1E-7                wlod = 2.86E-7
+ku0 = 1E-7                    kvsat = -0.386                kvth0 = 2E-10
+tku0 = 0.24                   llodku0 = 1                   wlodku0 = 1
+llodvth = 1.8                 wlodvth = 1                   lku0 = 1.871E-7
+wku0 = 2.4E-7                 pku0 = -3.24E-14              lkvth0 = 2.4E-10
+wkvth0 = 1.8E-10              pkvth0 = 0                    stk2 = 0
+lodk2 = 1.9                   steta0 = 0                    lodeta0 = 1
//*** temperature coefficient ***
+tnom = 25                     ute = -1.524                  kt1 = -0.229
+kt1l = 0                      kt2 = -0.01232                ua1 = 4.549E-9
+ub1 = -5.441E-18              uc1 = -5E-11                  at = 4.00001E4
+prt = 0                       njs = 1                       xtis = 3
+tpb = 1.9E-3                  tpbsw = 1.9E-3                tpbswg = 1.9E-3
+tcj = 7.98E-4                 tcjsw = 2.4E-4                tcjswg = 4.77E-3
//*** well proximity effect model parameters ***
+web = -220                    wec = -3E3                    kvth0we = -3.197498E-3
+k2we = 3E-4                   ku0we = -3.482487E-3          scref = 1E-6
41:type=p  minr=1e-60
//*** flag parameter ***
+version = 4.3                 binunit = 2                   mobmod = 0
+capmod = 2                    rdsmod = 0                    igcmod = 1
+igbmod = 1                    rbodymod = 0                  trnqsmod = 0
+acnqsmod = 0                  fnoimod = 1                   tnoimod = 0
+diomod = 1                    permod = 1                    rgatemod = 0
+wpemod = 0
//*** geometry range parameter ***
+lmin = 2E-6                   lmax = 1E-5                   wmin = 1E-5
+wmax = 9E-4
//*** process parameter ***
+epsrox = 3.9                  toxe = tox_p_cap                  toxm = tox_p_cap
+dtox = 3.29E-10               xj = 1.7E-7                   ndep = 8.5E17
+ngate = 8E19                  nsd = 1E20                    rsh = 9.68
+rshg = 0.1
//*** dw and dl parameter ***
+wint = 1.089287E-8            wl = 0                        wln = 1
+ww = 0                        wwn = 1                       wwl = 0
+lint = 2E-24                  ll = 0                        lln = 1
+lw = 0                        lwn = 1                       lwl = 0
+lwc = 0                       lwlc = 0                      wwc = 0
+wwlc = 0                      dwg = 0                       dwb = 0
+xl = 0.0+dxl_p_cap                xw = 0.0+dxw_p_cap
//*** flicker noise model parameter ***
+noia = 1.45E42                noib = 3.57E26                noic = 2E10
+em = 2.1E7                    ef = 1.147
//***layout-dependent parasitics model parameter ***
+dmcg = 8.5E-8                 dmci = 8.5E-8                 dmdg = 0
+dmcgt = 0                     dwj = 0                       xgw = 0
+xgl = 0                       ngcon = 1
//*** vth related  parameter ***
+vth0 = ( -0.288698+dvth0_p_cap) + 1.031886E-3
+lvth0 = ( 9.263001E-9+dlvth0_p_cap) -6.355013E-10
+wvth0 = ( 1.029638E-8+dwvth0_p_cap)  -1.029638E-8
+pvth0 = ( -6.341168E-15+dpvth0_p_cap)  + 6.341168E-15
+phin = 0                      k1 = 0.25                     k2 = -8.069527E-3
+lk2 = -3.617813E-9            k3 = -1.700953                k3b = 1.200306
+w0 = 1.585076E-7              lpe0 = 7.519925E-8            lpeb = 5.608072E-8
+dvtp0 = 2.2E-6                dvtp1 = 0.2                   dvt0 = 0.20341
+dvt1 = 0.95146                dvt2 = 0.01                   dvt0w = 0
+dvt1w = 5.366499E6            dvt2w = 0
//*** mobility related parameter ***
+u0 = ( 0.0230515+du0_p_cap) -3.393008E-4 lu0 = ( -2.679199E-9+dlu0_p_cap) + 3.791989E-10
+wu0 = ( -3.385616E-9+dwu0_p_cap) + 3.385616E-9
+pu0 = ( 3.783728E-15+dpu0_p_cap) -3.783728E-15
+ua = 4.626938E-11             lua = -3.228095E-17           ub = 1.503408E-18
+lub = -3.830675E-25           uc = 7.043061E-11             luc = -4.913762E-17
+ud = 0                        vsat = 117731.5+dvsat_p_cap       a0 = 2.420983
+ags = 1.136349                lags = 8.929325E-7            b0 = 0
+b1 = 0                        keta = -0.106705              a1 = 0
+a2 = 1                        rdsw = 327.6                  prwb = -0.249981
+prwg = 0.25                   wr = 1
//*** subthreshold related parameter ***
+voff = -4.87891E-2            lvoff = 1.02555E-8            voffl = -6.036214E-9
+minv = 0                      nfactor = 0.32939             lnfactor = 6.374751E-8
+eta0 = 3.11538E-2             etab = -2.38505E-2            dsub = 1.2725
+cit = 1E-4                    cdsc = 0                      cdscb = 0
+cdscd = 0
//*** output resistance related parameter ***
+pclm = 0.627258               pdiblc1 = 0                   pdiblc2 = 1.10809E-2
+lpdiblc2 = 6.0325E-10         pdiblcb = 0                   drout = 1.132692
+pscbe1 = 9.264E8              pscbe2 = 1E-20                pvag = 1.425
+delta = 0.02                  fprout = 390.234144           pdits = 5.042617E-3
+pditsl = 100                  pditsd = 0                    lc = 0
+alpha0 = 0                    alpha1 = 0.06                 beta0 = 13.5
+agidl = 9E-8                  bgidl = 3.404E9               cgidl = 0.5
+egidl = 0.15
//*** gate dielectric tunneling current ***
+aigbacc = 0.012               bigbacc = 3.49E-3             cigbacc = 0.131
+nigbacc = 5.2                 aigbinv = 0.347               bigbinv = 0.0312
+cigbinv = 6.1E-3              eigbinv = 1.1                 nigbinv = 1
+aigc = 7.12E-3                bigc = 6.31E-4                cigc = 0
+aigsd = 5.9E-3                bigsd = 2.48E-4               cigsd = 0.032
+dlcig = 2.52E-9               nigc = 2.28                   poxedge = 1
+pigcd = 2.28                  ntox = 1                      toxref = 3E-9
//*** capacitance parameter ***
+xpart = 1                     cgso = 3.1E-11+dcgso_p_cap        cgdo = 3.1E-11+dcgdo_p_cap
+cgbo = 0                      ckappas = 0.6                 ckappad = 0.6
+cf = 1.18E-10                 clc = 1E-7                    cle = 0.6
+dlc = 0                 dwc = 0                       noff = 2.5
+voffcv = -0.0486              acde = 1.2                    moin = 8
+cgsl = 0.54E-10+dcgsl_p_cap       cgdl = 0.54E-10+dcgdl_p_cap
//*** souce/drain junction diode model parameter **
+ijthsrev = 0.01               ijthsfwd = 0.01               xjbvs = 1
+bvs = 10                      jss = 1.51E-7                 jsws = 3.98E-13
+jswgs = 2.47E-12              cjs = 9.98E-4+dcj_p_cap           mjs = 0.34
+mjsws = 0.012                 cjsws = 6.21E-11+dcjsw_p_cap      cjswgs = 2.53E-10+dcjswg_p_cap
+mjswgs = 0.86                 pbs = 0.75                    pbsws = 0.49
+pbswgs = 0.71
//** rf model related parameter ***
+xrcrg1 = 12                   xrcrg2 = 1                    rbpb = 50
+rbpd = 50                     rbps = 50                     rbdb = 50
+rbsb = 50                     gbmin = 1E-12
//*** stress effect related parameter ***
+saref = 6.1E-7                sbref = 6.1E-7                wlod = 2.86E-7
+ku0 = 1E-7                    kvsat = -0.386                kvth0 = 2E-10
+tku0 = 0.24                   llodku0 = 1                   wlodku0 = 1
+llodvth = 1.8                 wlodvth = 1                   lku0 = 1.871E-7
+wku0 = 2.4E-7                 pku0 = -3.24E-14              lkvth0 = 2.4E-10
+wkvth0 = 1.8E-10              pkvth0 = 0                    stk2 = 0
+lodk2 = 1.9                   steta0 = 0                    lodeta0 = 1
//*** temperature coefficient ***
+tnom = 25                     ute = -1.524                  kt1 = -0.229
+kt1l = 0                      kt2 = -0.01232                ua1 = 4.549E-9
+ub1 = -5.441E-18              uc1 = -5E-11                  at = 4.00001E4
+prt = 0                       njs = 1                       xtis = 3
+tpb = 1.9E-3                  tpbsw = 1.9E-3                tpbswg = 1.9E-3
+tcj = 7.98E-4                 tcjsw = 2.4E-4                tcjswg = 4.77E-3
//*** well proximity effect model parameters ***
+web = -220                    wec = -3E3                    kvth0we = -3.197498E-3
+k2we = 3E-4                   ku0we = -3.482487E-3          scref = 1E-6
42:type=p  minr=1e-60
//*** flag parameter ***
+version = 4.3                 binunit = 2                   mobmod = 0
+capmod = 2                    rdsmod = 0                    igcmod = 1
+igbmod = 1                    rbodymod = 0                  trnqsmod = 0
+acnqsmod = 0                  fnoimod = 1                   tnoimod = 0
+diomod = 1                    permod = 1                    rgatemod = 0
+wpemod = 0
//*** geometry range parameter ***
+lmin = 1E-5                   lmax = 9E-4                   wmin = 1E-5
+wmax = 9E-4
//*** process parameter ***
+epsrox = 3.9                  toxe = tox_p_cap                  toxm = tox_p_cap
+dtox = 3.29E-10               xj = 1.7E-7                   ndep = 8.5E17
+ngate = 8E19                  nsd = 1E20                    rsh = 9.68
+rshg = 0.1
//*** dw and dl parameter ***
+wint = 1.089287E-8            wl = 0                        wln = 1
+ww = 0                        wwn = 1                       wwl = 0
+lint = 2E-24                  ll = 0                        lln = 1
+lw = 0                        lwn = 1                       lwl = 0
+lwc = 0                       lwlc = 0                      wwc = 0
+wwlc = 0                      dwg = 0                       dwb = 0
+xl = 0.0+dxl_p_cap                xw = 0.0+dxw_p_cap
//*** flicker noise model parameter ***
+noia = 1.45E42                noib = 3.57E26                noic = 2E10
+em = 2.1E7                    ef = 1.147
//***layout-dependent parasitics model parameter ***
+dmcg = 8.5E-8                 dmci = 8.5E-8                 dmdg = 0
+dmcgt = 0                     dwj = 0                       xgw = 0
+xgl = 0                       ngcon = 1
//*** vth related  parameter ***
+vth0 = ( -0.288698+dvth0_p_cap) + 1.894636E-3
+lvth0 = ( 9.263001E-9+dlvth0_p_cap) -9.263001E-9
+wvth0 = ( 1.029638E-8+dwvth0_p_cap)  -1.029638E-8
+pvth0 = ( -6.341168E-15+dpvth0_p_cap)  + 6.341168E-15
+phin = 0                      k1 = 0.25                     k2 = -8.431308E-3
+k3 = -1.700953                k3b = 1.200306                w0 = 1.585076E-7
+lpe0 = 7.519925E-8            lpeb = 5.608072E-8            dvtp0 = 2.2E-6
+dvtp1 = 0.2                   dvt0 = 0.20341                dvt1 = 0.95146
+dvt2 = 0.01                   dvt0w = 0                     dvt1w = 5.366499E6
+dvt2w = 0
//*** mobility related parameter ***
+u0 = ( 0.0230515+du0_p_cap) -5.693008E-4 lu0 = ( -2.679199E-9+dlu0_p_cap) + 2.679199E-9
+wu0 = ( -3.385616E-9+dwu0_p_cap) + 3.385616E-9
+pu0 = ( 3.783728E-15+dpu0_p_cap) -3.783728E-15
+ua = 4.304128E-11             ub = 1.465101E-18             uc = 6.551685E-11
+ud = 0                        vsat = 117731.5+dvsat_p_cap       a0 = 2.420983
+ags = 1.225642                b0 = 0                        b1 = 0
+keta = -0.106705              a1 = 0                        a2 = 1
+rdsw = 327.6                  prwb = -0.249981              prwg = 0.25
+wr = 1
//*** subthreshold related parameter ***
+voff = -4.77636E-2            voffl = -6.036214E-9          minv = 0
+nfactor = 0.335764            eta0 = 3.11538E-2             etab = -2.38505E-2
+dsub = 1.2725                 cit = 1E-4                    cdsc = 0
+cdscb = 0                     cdscd = 0
//*** output resistance related parameter ***
+pclm = 0.627258               pdiblc1 = 0                   pdiblc2 = 1.11412E-2
+pdiblcb = 0                   drout = 1.132692              pscbe1 = 9.264E8
+pscbe2 = 1E-20                pvag = 1.425                  delta = 0.02
+fprout = 390.234144           pdits = 5.042617E-3           pditsl = 100
+pditsd = 0                    lc = 0                        alpha0 = 0
+alpha1 = 0.06                 beta0 = 13.5                  agidl = 9E-8
+bgidl = 3.404E9               cgidl = 0.5                   egidl = 0.15
//*** gate dielectric tunneling current ***
+aigbacc = 0.012               bigbacc = 3.49E-3             cigbacc = 0.131
+nigbacc = 5.2                 aigbinv = 0.347               bigbinv = 0.0312
+cigbinv = 6.1E-3              eigbinv = 1.1                 nigbinv = 1
+aigc = 7.12E-3                bigc = 6.31E-4                cigc = 0
+aigsd = 5.9E-3                bigsd = 2.48E-4               cigsd = 0.032
+dlcig = 2.52E-9               nigc = 2.28                   poxedge = 1
+pigcd = 2.28                  ntox = 1                      toxref = 3E-9
//*** capacitance parameter ***
+xpart = 1                     cgso = 3.1E-11+dcgso_p_cap        cgdo = 3.1E-11+dcgdo_p_cap
+cgbo = 0                      ckappas = 0.6                 ckappad = 0.6
+cf = 1.18E-10                 clc = 1E-7                    cle = 0.6
+dlc = 0                 dwc = 0                       noff = 2.5
+voffcv = -0.0486              acde = 1.2                    moin = 8
+cgsl = 0.54E-10+dcgsl_p_cap       cgdl = 0.54E-10+dcgdl_p_cap
//*** souce/drain junction diode model parameter **
+ijthsrev = 0.01               ijthsfwd = 0.01               xjbvs = 1
+bvs = 10                      jss = 1.51E-7                 jsws = 3.98E-13
+jswgs = 2.47E-12              cjs = 9.98E-4+dcj_p_cap           mjs = 0.34
+mjsws = 0.012                 cjsws = 6.21E-11+dcjsw_p_cap      cjswgs = 2.53E-10+dcjswg_p_cap
+mjswgs = 0.86                 pbs = 0.75                    pbsws = 0.49
+pbswgs = 0.71
//** rf model related parameter ***
+xrcrg1 = 12                   xrcrg2 = 1                    rbpb = 50
+rbpd = 50                     rbps = 50                     rbdb = 50
+rbsb = 50                     gbmin = 1E-12
//*** stress effect related parameter ***
+saref = 6.1E-7                sbref = 6.1E-7                wlod = 2.86E-7
+ku0 = 1E-7                    kvsat = -0.386                kvth0 = 2E-10
+tku0 = 0.24                   llodku0 = 1                   wlodku0 = 1
+llodvth = 1.8                 wlodvth = 1                   lku0 = 1.871E-7
+wku0 = 2.4E-7                 pku0 = -3.24E-14              lkvth0 = 2.4E-10
+wkvth0 = 1.8E-10              pkvth0 = 0                    stk2 = 0
+lodk2 = 1.9                   steta0 = 0                    lodeta0 = 1
//*** temperature coefficient ***
+tnom = 25                     ute = -1.524                  kt1 = -0.229
+kt1l = 0                      kt2 = -0.01232                ua1 = 4.549E-9
+ub1 = -5.441E-18              uc1 = -5E-11                  at = 4.00001E4
+prt = 0                       njs = 1                       xtis = 3
+tpb = 1.9E-3                  tpbsw = 1.9E-3                tpbswg = 1.9E-3
+tcj = 7.98E-4                 tcjsw = 2.4E-4                tcjswg = 4.77E-3
//*** well proximity effect model parameters ***
+web = -220                    wec = -3E3                    kvth0we = -3.197498E-3
+k2we = 3E-4                   ku0we = -3.482487E-3          scref = 1E-6
}

endsection moscap

section moscap18

simulator lang = spectre
model nch18_mac bsim4 {
1:type=n  minr=1e-60
//*** flag parameter ***
+version = 4.3                 binunit = 2                   mobmod = 0
+capmod = 2                    rdsmod = 0                    igcmod = 1
+igbmod = 1                    rbodymod = 0                  trnqsmod = 0
+acnqsmod = 0                  fnoimod = 1                   tnoimod = 0
+diomod = 1                    tempmod = 0                   permod = 1
+rgatemod = 0                  wpemod = 1
//*** geometry range parameter ***
+lmin = 2E-6                   lmax = 1E-5                   wmin = 2E-6
+wmax = 1E-5
//*** process parameter ***
+epsrox = 3.9                  toxe = tox_n_18_cap               toxm = tox_n_18_cap
+dtox = 3.2E-10                xj = 8.1E-8                   ndep = 1E17
+ngate = 1.6E20                nsd = 1E20                    rsh = 17.5
+rshg = 15.5
//*** dw and dl parameter ***
+wint = 2E-9                   wl = 0                        wln = 1
+ww = 0                        wwn = 1                       wwl = 0
+lint = 1E-9                   ll = 0                        lln = 1
+lw = 0                        lwn = 1                       lwl = 0
+llc = 0                       lwc = 0                       lwlc = 0
+wlc = 0                       wwc = 0                       wwlc = 0
+dwg = 0                       dwb = 0                       xl = 0.0+dxl_n_18_cap
+xw = 0.0+dxw_n_18_cap
//*** flicker noise model parameter ***
+noia = 3.1E42                 noib = 1.81E21                noic = 3E8
+em = 1E6                      ef = 0.86                     lintnoi = -5E-9
//***layout-dependent parasitics model parameter ***
+dmcg = 4E-8                   dmci = 4E-8                   dmdg = 0
+dmcgt = 0                     dwj = 0                       xgw = 0
+xgl = 0                       ngcon = 1
//*** vth related  parameter ***
+vth0 = 0.4207+dvth0_n_18_cap      lvth0 = 0.0+dlvth0_n_18_cap       wvth0 = 0.0+dwvth0_n_18_cap
+pvth0 = 0.0+dpvth0_n_18_cap       phin = 0                      k1 = 0.30264
+k2 = -0.012135                k3 = -5.68454                 k3b = 2.454986
+w0 = 8.190018E-8              lpe0 = 6.610138E-8            lpeb = 2.000404E-8
+dvtp0 = 2.36094E-6            dvtp1 = 4.5                   dvt0 = 0.236381
+dvt1 = 0.537442               dvt2 = 5.56679E-2             dvt0w = 0
+dvt1w = 0                     dvt2w = 0                     vfbsdoff = 0.02
//*** mobility related parameter ***
+u0 = 0.0298009+du0_n_18_cap       lu0 = 0.0+dlu0_n_18_cap           wu0 = 0.0+dwu0_n_18_cap
+pu0 = 0.0+dpu0_n_18_cap           ua = -9.49994E-10             ub = 2.091579E-18
+uc = 7.758295E-11             ud = 0                        vsat = 115107.0+dvsat_n_18_cap
+wvsat = -2.499988E-3          a0 = 1.08155                  ags = 1.051675
+wags = -4.999975E-8           b0 = 0                        b1 = 0
+keta = -5.19382E-2            a1 = 0                        a2 = 1
+rdsw = 100.002354             prwb = 0                      prwg = 0
+wr = 1
//*** subthreshold related parameter ***
+voff = -0.155578              voffl = -3.595178E-9          minv = -0.15
+nfactor = 1.621754            eta0 = 1.804707E-3            etab = -1.26845E-2
+dsub = 0.422235               cit = 7.212E-4                cdsc = 0
+cdscb = 0                     cdscd = 0
//*** output resistance related parameter ***
+pclm = 1.239489               pdiblc1 = 4.53031E-4          pdiblc2 = 7.801573E-3
+pdiblcb = 1                   drout = 0.56                  pscbe1 = 1E9
+pscbe2 = 1E-20                pvag = 0.9                    delta = 7.595625E-3
+fprout = 300                  pdits = 0                     pditsl = 0
+pditsd = 0                    alpha0 = 2E-10                alpha1 = 0.01
+beta0 = 6.4                   agidl = 1.1505E-7             bgidl = 2.692E9
+cgidl = 0.24                  egidl = 0.24
//*** gate dielectric tunneling current ***
+aigbacc = 0.0211              bigbacc = 2.44E-3             cigbacc = 0.312
+nigbacc = 6                   aigbinv = 0.017               bigbinv = 4.3E-3
+cigbinv = 5.7E-3              eigbinv = 1.04                nigbinv = 6
+aigc = 0.012                  bigc = 1.41E-3                cigc = 5.72E-4
+aigsd = 0.0116                bigsd = 1.3E-3                cigsd = 0.073
+dlcig = 2.43E-9               nigc = 2.97                   poxedge = 1
+pigcd = 2.4                   ntox = 1                      toxref = 3E-9
//*** capacitance parameter ***
+xpart = 1                     cgso = 3.13E-11+dcgso_n_18_cap    cgdo = 3.13E-11+dcgdo_n_18_cap
+cgbo = 0                      ckappas = 0.6                 ckappad = 0.6
+cf = 6.13E-11                 clc = 1.04E-7                 cle = 0.6
+dlc = 0                 dwc = 0                       noff = 1.6
+voffcv = -0.097               acde = 1                      moin = 5.67
+cgsl = 2.71E-11+dcgsl_n_18_cap    cgdl = 2.71E-11+dcgdl_n_18_cap
//*** souce/drain junction diode model parameter **
+ijthsrev = 0.01               ijthsfwd = 0.01               xjbvs = 1
+bvs = 10                      jss = 4.14E-7                 jsws = 9.7E-13
+jswgs = 1.4E-12               cjs = 8.41E-4+dcj_n_18_cap        mjs = 0.31
+mjsws = 0.081                 cjsws = 1.02E-10+dcjsw_n_18_cap   cjswgs = 1.2E-10+dcjswg_n_18_cap
+mjswgs = 0.511                pbs = 0.511                   pbsws = 0.786
+pbswgs = 0.7
//** rf model related parameter ***
+xrcrg1 = 12                   xrcrg2 = 1                    rbpb = 50
+rbpd = 50                     rbps = 50                     rbdb = 50
+rbsb = 50                     gbmin = 1E-12
//*** stress effect related parameter ***
+saref = 6.1E-7                sbref = 6.1E-7                wlod = 1.37E-7
+ku0 = -2.471E-8               kvsat = 0.3                   kvth0 = 2.1E-9
+tku0 = 0.097                  llodku0 = 1                   wlodku0 = 1
+llodvth = 1                   wlodvth = 1                   lku0 = 1.23E-8
+wku0 = 9.96E-8                pku0 = 4.6E-14                lkvth0 = -2.421E-11
+wkvth0 = 0                    pkvth0 = 0                    stk2 = 3.87E-10
+lodk2 = 0.5                   steta0 = 0                    lodeta0 = 1
//*** temperature coefficient ***
+tnom = 25                     ute = -0.9                    kt1 = -0.235274
+kt1l = 0                      kt2 = -0.036                  ua1 = 8.32E-10
+ub1 = 0                       uc1 = 4.355E-11               at = 7E4
+prt = 0                       njs = 1                       njd = 1
+xtis = 3                      xtid = 3                      tpb = 1.1E-3
+tpbsw = 1.9E-3                tpbswg = 1E-3                 tcj = 6.52E-4
+tcjsw = 3.57E-4               tcjswg = 1.5E-3               tvoff = 2.2428E-3
+tvfbsdoff = 0.022
//*** well proximity effect model parameters ***
+web = 0                       wec = 0                       kvth0we = 2.1E-3
+k2we = 0                      ku0we = -4.21E-3              scref = 1E-6
2:type=n  minr=1e-60
//*** flag parameter ***
+version = 4.3                 binunit = 2                   mobmod = 0
+capmod = 2                    rdsmod = 0                    igcmod = 1
+igbmod = 1                    rbodymod = 0                  trnqsmod = 0
+acnqsmod = 0                  fnoimod = 1                   tnoimod = 0
+diomod = 1                    tempmod = 0                   permod = 1
+rgatemod = 0                  wpemod = 1
//*** geometry range parameter ***
+lmin = 1E-6                   lmax = 2E-6                   wmin = 2E-6
+wmax = 1E-5
//*** process parameter ***
+epsrox = 3.9                  toxe = tox_n_18_cap               toxm = tox_n_18_cap
+dtox = 3.2E-10                xj = 8.1E-8                   ndep = 1E17
+ngate = 1.6E20                nsd = 1E20                    rsh = 17.5
+rshg = 15.5
//*** dw and dl parameter ***
+wint = 2E-9                   wl = 0                        wln = 1
+ww = 0                        wwn = 1                       wwl = 0
+lint = 1E-9                   ll = 0                        lln = 1
+lw = 0                        lwn = 1                       lwl = 0
+llc = 0                       lwc = 0                       lwlc = 0
+wlc = 0                       wwc = 0                       wwlc = 0
+dwg = 0                       dwb = 0                       xl = 0+dxl_n_18_cap
+xw = 0+dxw_n_18_cap
//*** flicker noise model parameter ***
+noia = 3.1E42                 noib = 1.81E21                noic = 3E8
+em = 1E6                      ef = 0.86                     lintnoi = -5E-9
//***layout-dependent parasitics model parameter ***
+dmcg = 4E-8                   dmci = 4E-8                   dmdg = 0
+dmcgt = 0                     dwj = 0                       xgw = 0
+xgl = 0                       ngcon = 1
//*** vth related  parameter ***
+vth0 = 0.4207+dvth0_n_18_cap      lvth0 = 0+dlvth0_n_18_cap         wvth0 = 0+dwvth0_n_18_cap
+pvth0 = 0+dpvth0_n_18_cap         phin = 0                      k1 = 0.30264
+k2 = -0.012135                k3 = -5.68454                 k3b = 2.454986
+w0 = 8.190018E-8              lpe0 = 6.610138E-8            lpeb = 2.000404E-8
+dvtp0 = 2.36094E-6            dvtp1 = 4.5                   dvt0 = 0.236381
+dvt1 = 0.537442               dvt2 = 5.56679E-2             dvt0w = 0
+dvt1w = 0                     dvt2w = 0                     vfbsdoff = 0.02
//*** mobility related parameter ***
+u0 = 2.98009E-2+du0_n_18_cap      lu0 = 0+dlu0_n_18_cap             wu0 = 0+dwu0_n_18_cap
+pu0 = 0+dpu0_n_18_cap             ua = -9.49994E-10             ub = 2.091579E-18
+uc = 7.758295E-11             ud = 0                        vsat = 1.15107E5+dvsat_n_18_cap
+wvsat = -2.499988E-3          a0 = 1.08155                  ags = 1.051675
+wags = -4.999975E-8           b0 = 0                        b1 = 0
+keta = -5.19382E-2            a1 = 0                        a2 = 1
+rdsw = 100.002354             prwb = 0                      prwg = 0
+wr = 1
//*** subthreshold related parameter ***
+voff = -0.155578              voffl = -3.595178E-9          minv = -0.15
+nfactor = 1.621754            eta0 = 1.804707E-3            etab = -1.26845E-2
+dsub = 0.422235               cit = 7.212E-4                cdsc = 0
+cdscb = 0                     cdscd = 0
//*** output resistance related parameter ***
+pclm = 1.239489               pdiblc1 = 4.53031E-4          pdiblc2 = 7.801573E-3
+pdiblcb = 1                   drout = 0.56                  pscbe1 = 1E9
+pscbe2 = 1E-20                pvag = 0.9                    delta = 7.595625E-3
+fprout = 300                  pdits = 0                     pditsl = 0
+pditsd = 0                    alpha0 = 2E-10                alpha1 = 0.01
+beta0 = 6.4                   agidl = 1.1505E-7             bgidl = 2.692E9
+cgidl = 0.24                  egidl = 0.24
//*** gate dielectric tunneling current ***
+aigbacc = 0.0211              bigbacc = 2.44E-3             cigbacc = 0.312
+nigbacc = 6                   aigbinv = 0.017               bigbinv = 4.3E-3
+cigbinv = 5.7E-3              eigbinv = 1.04                nigbinv = 6
+aigc = 0.012                  bigc = 1.41E-3                cigc = 5.72E-4
+aigsd = 0.0116                bigsd = 1.3E-3                cigsd = 0.073
+dlcig = 2.43E-9               nigc = 2.97                   poxedge = 1
+pigcd = 2.4                   ntox = 1                      toxref = 3E-9
//*** capacitance parameter ***
+xpart = 1                     cgso = 3.13E-11+dcgso_n_18_cap    cgdo = 3.13E-11+dcgdo_n_18_cap
+cgbo = 0                      ckappas = 0.6                 ckappad = 0.6
+cf = 6.13E-11                 clc = 1.04E-7                 cle = 0.6
+dlc = 0                 dwc = 0                       noff = 1.6
+voffcv = -0.097               acde = 1                      moin = 5.67
+cgsl = 2.71E-11+dcgsl_n_18_cap    cgdl = 2.71E-11+dcgdl_n_18_cap
//*** souce/drain junction diode model parameter **
+ijthsrev = 0.01               ijthsfwd = 0.01               xjbvs = 1
+bvs = 10                      jss = 4.14E-7                 jsws = 9.7E-13
+jswgs = 1.4E-12               cjs = 8.41E-4+dcj_n_18_cap        mjs = 0.31
+mjsws = 0.081                 cjsws = 1.02E-10+dcjsw_n_18_cap   cjswgs = 1.2E-10+dcjswg_n_18_cap
+mjswgs = 0.511                pbs = 0.511                   pbsws = 0.786
+pbswgs = 0.7
//** rf model related parameter ***
+xrcrg1 = 12                   xrcrg2 = 1                    rbpb = 50
+rbpd = 50                     rbps = 50                     rbdb = 50
+rbsb = 50                     gbmin = 1E-12
//*** stress effect related parameter ***
+saref = 6.1E-7                sbref = 6.1E-7                wlod = 1.37E-7
+ku0 = -2.471E-8               kvsat = 0.3                   kvth0 = 2.1E-9
+tku0 = 0.097                  llodku0 = 1                   wlodku0 = 1
+llodvth = 1                   wlodvth = 1                   lku0 = 1.23E-8
+wku0 = 9.96E-8                pku0 = 4.6E-14                lkvth0 = -2.421E-11
+wkvth0 = 0                    pkvth0 = 0                    stk2 = 3.87E-10
+lodk2 = 0.5                   steta0 = 0                    lodeta0 = 1
//*** temperature coefficient ***
+tnom = 25                     ute = -0.9                    kt1 = -0.235274
+kt1l = 0                      kt2 = -0.036                  ua1 = 8.32E-10
+ub1 = 0                       uc1 = 4.355E-11               at = 7E4
+prt = 0                       njs = 1                       njd = 1
+xtis = 3                      xtid = 3                      tpb = 1.1E-3
+tpbsw = 1.9E-3                tpbswg = 1E-3                 tcj = 6.52E-4
+tcjsw = 3.57E-4               tcjswg = 1.5E-3               tvoff = 2.2428E-3
+tvfbsdoff = 0.022
//*** well proximity effect model parameters ***
+web = 0                       wec = 0                       kvth0we = 2.1E-3
+k2we = 0                      ku0we = -4.21E-3              scref = 1E-6
3:type=n  minr=1e-60
//*** flag parameter ***
+version = 4.3                 binunit = 2                   mobmod = 0
+capmod = 2                    rdsmod = 0                    igcmod = 1
+igbmod = 1                    rbodymod = 0                  trnqsmod = 0
+acnqsmod = 0                  fnoimod = 1                   tnoimod = 0
+diomod = 1                    tempmod = 0                   permod = 1
+rgatemod = 0                  wpemod = 1
//*** geometry range parameter ***
+lmin = 1.5E-7                 lmax = 1E-6                   wmin = 2E-6
+wmax = 1E-5
//*** process parameter ***
+epsrox = 3.9                  toxe = tox_n_18_cap               toxm = tox_n_18_cap
+dtox = 3.2E-10                xj = 8.1E-8                   ndep = 1E17
+ngate = 1.6E20                nsd = 1E20                    rsh = 17.5
+rshg = 15.5
//*** dw and dl parameter ***
+wint = 2E-9                   wl = 0                        wln = 1
+ww = 0                        wwn = 1                       wwl = 0
+lint = 1E-9                   ll = 0                        lln = 1
+lw = 0                        lwn = 1                       lwl = 0
+llc = 0                       lwc = 0                       lwlc = 0
+wlc = 0                       wwc = 0                       wwlc = 0
+dwg = 0                       dwb = 0                       xl = 0+dxl_n_18_cap
+xw = 0+dxw_n_18_cap
//*** flicker noise model parameter ***
+noia = 3.1E42                 noib = 1.81E21                noic = 3E8
+em = 1E6                      ef = 0.86                     lintnoi = -5E-9
//***layout-dependent parasitics model parameter ***
+dmcg = 4E-8                   dmci = 4E-8                   dmdg = 0
+dmcgt = 0                     dwj = 0                       xgw = 0
+xgl = 0                       ngcon = 1
//*** vth related  parameter ***
+vth0 = 0.4207+dvth0_n_18_cap      lvth0 = 0+dlvth0_n_18_cap         wvth0 = 0+dwvth0_n_18_cap
+pvth0 = 0+dpvth0_n_18_cap         phin = 0                      k1 = 0.30264
+k2 = -0.012135                k3 = -5.68454                 k3b = 2.454986
+w0 = 8.190018E-8              lpe0 = 6.610138E-8            lpeb = 2.000404E-8
+dvtp0 = 2.36094E-6            dvtp1 = 4.5                   dvt0 = 0.236381
+dvt1 = 0.537442               dvt2 = 5.56679E-2             dvt0w = 0
+dvt1w = 0                     dvt2w = 0                     vfbsdoff = 0.02
//*** mobility related parameter ***
+u0 = 2.98009E-2+du0_n_18_cap      lu0 = 0+dlu0_n_18_cap             wu0 = 0+dwu0_n_18_cap
+pu0 = 0+dpu0_n_18_cap             ua = -9.49994E-10             ub = 2.091579E-18
+uc = 7.758295E-11             ud = 0                        vsat = 1.15107E5+dvsat_n_18_cap
+wvsat = -2.499988E-3          a0 = 1.08155                  ags = 1.051675
+wags = -4.999975E-8           b0 = 0                        b1 = 0
+keta = -5.19382E-2            a1 = 0                        a2 = 1
+rdsw = 100.002354             prwb = 0                      prwg = 0
+wr = 1
//*** subthreshold related parameter ***
+voff = -0.155578              voffl = -3.595178E-9          minv = -0.15
+nfactor = 1.621754            eta0 = 1.804707E-3            etab = -1.26845E-2
+dsub = 0.422235               cit = 7.212E-4                cdsc = 0
+cdscb = 0                     cdscd = 0
//*** output resistance related parameter ***
+pclm = 1.239489               pdiblc1 = 4.53031E-4          pdiblc2 = 7.801573E-3
+pdiblcb = 1                   drout = 0.56                  pscbe1 = 1E9
+pscbe2 = 1E-20                pvag = 0.9                    delta = 7.595625E-3
+fprout = 300                  pdits = 0                     pditsl = 0
+pditsd = 0                    alpha0 = 2E-10                alpha1 = 0.01
+beta0 = 6.4                   agidl = 1.1505E-7             bgidl = 2.692E9
+cgidl = 0.24                  egidl = 0.24
//*** gate dielectric tunneling current ***
+aigbacc = 0.0211              bigbacc = 2.44E-3             cigbacc = 0.312
+nigbacc = 6                   aigbinv = 0.017               bigbinv = 4.3E-3
+cigbinv = 5.7E-3              eigbinv = 1.04                nigbinv = 6
+aigc = 0.012                  bigc = 1.41E-3                cigc = 5.72E-4
+aigsd = 0.0116                bigsd = 1.3E-3                cigsd = 0.073
+dlcig = 2.43E-9               nigc = 2.97                   poxedge = 1
+pigcd = 2.4                   ntox = 1                      toxref = 3E-9
//*** capacitance parameter ***
+xpart = 1                     cgso = 3.13E-11+dcgso_n_18_cap    cgdo = 3.13E-11+dcgdo_n_18_cap
+cgbo = 0                      ckappas = 0.6                 ckappad = 0.6
+cf = 6.13E-11                 clc = 1.04E-7                 cle = 0.6
+dlc = 0                 dwc = 0                       noff = 1.6
+voffcv = -0.097               acde = 1                      moin = 5.67
+cgsl = 2.71E-11+dcgsl_n_18_cap    cgdl = 2.71E-11+dcgdl_n_18_cap
//*** souce/drain junction diode model parameter **
+ijthsrev = 0.01               ijthsfwd = 0.01               xjbvs = 1
+bvs = 10                      jss = 4.14E-7                 jsws = 9.7E-13
+jswgs = 1.4E-12               cjs = 8.41E-4+dcj_n_18_cap        mjs = 0.31
+mjsws = 0.081                 cjsws = 1.02E-10+dcjsw_n_18_cap   cjswgs = 1.2E-10+dcjswg_n_18_cap
+mjswgs = 0.511                pbs = 0.511                   pbsws = 0.786
+pbswgs = 0.7
//** rf model related parameter ***
+xrcrg1 = 12                   xrcrg2 = 1                    rbpb = 50
+rbpd = 50                     rbps = 50                     rbdb = 50
+rbsb = 50                     gbmin = 1E-12
//*** stress effect related parameter ***
+saref = 6.1E-7                sbref = 6.1E-7                wlod = 1.37E-7
+ku0 = -2.471E-8               kvsat = 0.3                   kvth0 = 2.1E-9
+tku0 = 0.097                  llodku0 = 1                   wlodku0 = 1
+llodvth = 1                   wlodvth = 1                   lku0 = 1.23E-8
+wku0 = 9.96E-8                pku0 = 4.6E-14                lkvth0 = -2.421E-11
+wkvth0 = 0                    pkvth0 = 0                    stk2 = 3.87E-10
+lodk2 = 0.5                   steta0 = 0                    lodeta0 = 1
//*** temperature coefficient ***
+tnom = 25                     ute = -0.9                    kt1 = -0.235274
+kt1l = 0                      kt2 = -0.036                  ua1 = 8.32E-10
+ub1 = 0                       uc1 = 4.355E-11               at = 7E4
+prt = 0                       njs = 1                       njd = 1
+xtis = 3                      xtid = 3                      tpb = 1.1E-3
+tpbsw = 1.9E-3                tpbswg = 1E-3                 tcj = 6.52E-4
+tcjsw = 3.57E-4               tcjswg = 1.5E-3               tvoff = 2.2428E-3
+tvfbsdoff = 0.022
//*** well proximity effect model parameters ***
+web = 0                       wec = 0                       kvth0we = 2.1E-3
+k2we = 0                      ku0we = -4.21E-3              scref = 1E-6
4:type=n  minr=1e-60
//*** flag parameter ***
+version = 4.3                 binunit = 2                   mobmod = 0
+capmod = 2                    rdsmod = 0                    igcmod = 1
+igbmod = 1                    rbodymod = 0                  trnqsmod = 0
+acnqsmod = 0                  fnoimod = 1                   tnoimod = 0
+diomod = 1                    tempmod = 0                   permod = 1
+rgatemod = 0                  wpemod = 1
//*** geometry range parameter ***
+lmin = 2E-6                   lmax = 1E-5                   wmin = 1E-6
+wmax = 2E-6
//*** process parameter ***
+epsrox = 3.9                  toxe = tox_n_18_cap               toxm = tox_n_18_cap
+dtox = 3.2E-10                xj = 8.1E-8                   ndep = 1E17
+ngate = 1.6E20                nsd = 1E20                    rsh = 17.5
+rshg = 15.5
//*** dw and dl parameter ***
+wint = 2E-9                   wl = 0                        wln = 1
+ww = 0                        wwn = 1                       wwl = 0
+lint = 1E-9                   ll = 0                        lln = 1
+lw = 0                        lwn = 1                       lwl = 0
+llc = 0                       lwc = 0                       lwlc = 0
+wlc = 0                       wwc = 0                       wwlc = 0
+dwg = 0                       dwb = 0                       xl = 0+dxl_n_18_cap
+xw = 0+dxw_n_18_cap
//*** flicker noise model parameter ***
+noia = 3.1E42                 noib = 1.81E21                noic = 3E8
+em = 1E6                      ef = 0.86                     lintnoi = -5E-9
//***layout-dependent parasitics model parameter ***
+dmcg = 4E-8                   dmci = 4E-8                   dmdg = 0
+dmcgt = 0                     dwj = 0                       xgw = 0
+xgl = 0                       ngcon = 1
//*** vth related  parameter ***
+vth0 = 0.4207+dvth0_n_18_cap      lvth0 = 0+dlvth0_n_18_cap         wvth0 = 0+dwvth0_n_18_cap
+pvth0 = 0+dpvth0_n_18_cap         phin = 0                      k1 = 0.30264
+k2 = -0.012135                k3 = -5.68454                 k3b = 2.454986
+w0 = 8.190018E-8              lpe0 = 6.610138E-8            lpeb = 2.000404E-8
+dvtp0 = 2.36094E-6            dvtp1 = 4.5                   dvt0 = 0.236381
+dvt1 = 0.537442               dvt2 = 5.56679E-2             dvt0w = 0
+dvt1w = 0                     dvt2w = 0                     vfbsdoff = 0.02
//*** mobility related parameter ***
+u0 = 2.98009E-2+du0_n_18_cap      lu0 = 0+dlu0_n_18_cap             wu0 = 0+dwu0_n_18_cap
+pu0 = 0+dpu0_n_18_cap             ua = -9.49994E-10             ub = 2.091579E-18
+uc = 7.758295E-11             ud = 0                        vsat = 1.15107E5+dvsat_n_18_cap
+wvsat = -2.49993E-3           a0 = 1.08155                  ags = 1.051675
+wags = -5.000059E-8           b0 = 0                        b1 = 0
+keta = -5.19382E-2            a1 = 0                        a2 = 1
+rdsw = 100.002354             prwb = 0                      prwg = 0
+wr = 1
//*** subthreshold related parameter ***
+voff = -0.155578              voffl = -3.595178E-9          minv = -0.15
+nfactor = 1.621754            eta0 = 1.804707E-3            etab = -1.26845E-2
+dsub = 0.422235               cit = 7.212E-4                cdsc = 0
+cdscb = 0                     cdscd = 0
//*** output resistance related parameter ***
+pclm = 1.239489               pdiblc1 = 4.53031E-4          pdiblc2 = 7.801573E-3
+pdiblcb = 1                   drout = 0.56                  pscbe1 = 1E9
+pscbe2 = 1E-20                pvag = 0.9                    delta = 7.595625E-3
+fprout = 300                  pdits = 0                     pditsl = 0
+pditsd = 0                    alpha0 = 2E-10                alpha1 = 0.01
+beta0 = 6.4                   agidl = 1.1505E-7             bgidl = 2.692E9
+cgidl = 0.24                  egidl = 0.24
//*** gate dielectric tunneling current ***
+aigbacc = 0.0211              bigbacc = 2.44E-3             cigbacc = 0.312
+nigbacc = 6                   aigbinv = 0.017               bigbinv = 4.3E-3
+cigbinv = 5.7E-3              eigbinv = 1.04                nigbinv = 6
+aigc = 0.012                  bigc = 1.41E-3                cigc = 5.72E-4
+aigsd = 0.0116                bigsd = 1.3E-3                cigsd = 0.073
+dlcig = 2.43E-9               nigc = 2.97                   poxedge = 1
+pigcd = 2.4                   ntox = 1                      toxref = 3E-9
//*** capacitance parameter ***
+xpart = 1                     cgso = 3.13E-11+dcgso_n_18_cap    cgdo = 3.13E-11+dcgdo_n_18_cap
+cgbo = 0                      ckappas = 0.6                 ckappad = 0.6
+cf = 6.13E-11                 clc = 1.04E-7                 cle = 0.6
+dlc = 0                 dwc = 0                       noff = 1.6
+voffcv = -0.097               acde = 1                      moin = 5.67
+cgsl = 2.71E-11+dcgsl_n_18_cap    cgdl = 2.71E-11+dcgdl_n_18_cap
//*** souce/drain junction diode model parameter **
+ijthsrev = 0.01               ijthsfwd = 0.01               xjbvs = 1
+bvs = 10                      jss = 4.14E-7                 jsws = 9.7E-13
+jswgs = 1.4E-12               cjs = 8.41E-4+dcj_n_18_cap        mjs = 0.31
+mjsws = 0.081                 cjsws = 1.02E-10+dcjsw_n_18_cap   cjswgs = 1.2E-10+dcjswg_n_18_cap
+mjswgs = 0.511                pbs = 0.511                   pbsws = 0.786
+pbswgs = 0.7
//** rf model related parameter ***
+xrcrg1 = 12                   xrcrg2 = 1                    rbpb = 50
+rbpd = 50                     rbps = 50                     rbdb = 50
+rbsb = 50                     gbmin = 1E-12
//*** stress effect related parameter ***
+saref = 6.1E-7                sbref = 6.1E-7                wlod = 1.37E-7
+ku0 = -2.471E-8               kvsat = 0.3                   kvth0 = 2.1E-9
+tku0 = 0.097                  llodku0 = 1                   wlodku0 = 1
+llodvth = 1                   wlodvth = 1                   lku0 = 1.23E-8
+wku0 = 9.96E-8                pku0 = 4.6E-14                lkvth0 = -2.421E-11
+wkvth0 = 0                    pkvth0 = 0                    stk2 = 3.87E-10
+lodk2 = 0.5                   steta0 = 0                    lodeta0 = 1
//*** temperature coefficient ***
+tnom = 25                     ute = -0.9                    kt1 = -0.235274
+kt1l = 0                      kt2 = -0.036                  ua1 = 8.32E-10
+ub1 = 0                       uc1 = 4.355E-11               at = 7E4
+prt = 0                       njs = 1                       njd = 1
+xtis = 3                      xtid = 3                      tpb = 1.1E-3
+tpbsw = 1.9E-3                tpbswg = 1E-3                 tcj = 6.52E-4
+tcjsw = 3.57E-4               tcjswg = 1.5E-3               tvoff = 2.2428E-3
+tvfbsdoff = 0.022
//*** well proximity effect model parameters ***
+web = 0                       wec = 0                       kvth0we = 2.1E-3
+k2we = 0                      ku0we = -4.21E-3              scref = 1E-6
5:type=n  minr=1e-60
//*** flag parameter ***
+version = 4.3                 binunit = 2                   mobmod = 0
+capmod = 2                    rdsmod = 0                    igcmod = 1
+igbmod = 1                    rbodymod = 0                  trnqsmod = 0
+acnqsmod = 0                  fnoimod = 1                   tnoimod = 0
+diomod = 1                    tempmod = 0                   permod = 1
+rgatemod = 0                  wpemod = 1
//*** geometry range parameter ***
+lmin = 1E-6                   lmax = 2E-6                   wmin = 1E-6
+wmax = 2E-6
//*** process parameter ***
+epsrox = 3.9                  toxe = tox_n_18_cap               toxm = tox_n_18_cap
+dtox = 3.2E-10                xj = 8.1E-8                   ndep = 1E17
+ngate = 1.6E20                nsd = 1E20                    rsh = 17.5
+rshg = 15.5
//*** dw and dl parameter ***
+wint = 2E-9                   wl = 0                        wln = 1
+ww = 0                        wwn = 1                       wwl = 0
+lint = 1E-9                   ll = 0                        lln = 1
+lw = 0                        lwn = 1                       lwl = 0
+llc = 0                       lwc = 0                       lwlc = 0
+wlc = 0                       wwc = 0                       wwlc = 0
+dwg = 0                       dwb = 0                       xl = 0+dxl_n_18_cap
+xw = 0+dxw_n_18_cap
//*** flicker noise model parameter ***
+noia = 3.1E42                 noib = 1.81E21                noic = 3E8
+em = 1E6                      ef = 0.86                     lintnoi = -5E-9
//***layout-dependent parasitics model parameter ***
+dmcg = 4E-8                   dmci = 4E-8                   dmdg = 0
+dmcgt = 0                     dwj = 0                       xgw = 0
+xgl = 0                       ngcon = 1
//*** vth related  parameter ***
+vth0 = 0.4207+dvth0_n_18_cap      lvth0 = 0+dlvth0_n_18_cap         wvth0 = 0+dwvth0_n_18_cap
+pvth0 = 0+dpvth0_n_18_cap         phin = 0                      k1 = 0.30264
+k2 = -0.012135                k3 = -5.68454                 k3b = 2.454986
+w0 = 8.190018E-8              lpe0 = 6.610138E-8            lpeb = 2.000404E-8
+dvtp0 = 2.36094E-6            dvtp1 = 4.5                   dvt0 = 0.236381
+dvt1 = 0.537442               dvt2 = 5.56679E-2             dvt0w = 0
+dvt1w = 0                     dvt2w = 0                     vfbsdoff = 0.02
//*** mobility related parameter ***
+u0 = 2.98009E-2+du0_n_18_cap      lu0 = 0+dlu0_n_18_cap             wu0 = 0+dwu0_n_18_cap
+pu0 = 0+dpu0_n_18_cap             ua = -9.49994E-10             ub = 2.091579E-18
+uc = 7.758295E-11             ud = 0                        vsat = 1.15107E5+dvsat_n_18_cap
+wvsat = -2.49993E-3           a0 = 1.08155                  ags = 1.051675
+wags = -5.000059E-8           b0 = 0                        b1 = 0
+keta = -5.19382E-2            a1 = 0                        a2 = 1
+rdsw = 100.002354             prwb = 0                      prwg = 0
+wr = 1
//*** subthreshold related parameter ***
+voff = -0.155578              voffl = -3.595178E-9          minv = -0.15
+nfactor = 1.621754            eta0 = 1.804707E-3            etab = -1.26845E-2
+dsub = 0.422235               cit = 7.212E-4                cdsc = 0
+cdscb = 0                     cdscd = 0
//*** output resistance related parameter ***
+pclm = 1.239489               pdiblc1 = 4.53031E-4          pdiblc2 = 7.801573E-3
+pdiblcb = 1                   drout = 0.56                  pscbe1 = 1E9
+pscbe2 = 1E-20                pvag = 0.9                    delta = 7.595625E-3
+fprout = 300                  pdits = 0                     pditsl = 0
+pditsd = 0                    alpha0 = 2E-10                alpha1 = 0.01
+beta0 = 6.4                   agidl = 1.1505E-7             bgidl = 2.692E9
+cgidl = 0.24                  egidl = 0.24
//*** gate dielectric tunneling current ***
+aigbacc = 0.0211              bigbacc = 2.44E-3             cigbacc = 0.312
+nigbacc = 6                   aigbinv = 0.017               bigbinv = 4.3E-3
+cigbinv = 5.7E-3              eigbinv = 1.04                nigbinv = 6
+aigc = 0.012                  bigc = 1.41E-3                cigc = 5.72E-4
+aigsd = 0.0116                bigsd = 1.3E-3                cigsd = 0.073
+dlcig = 2.43E-9               nigc = 2.97                   poxedge = 1
+pigcd = 2.4                   ntox = 1                      toxref = 3E-9
//*** capacitance parameter ***
+xpart = 1                     cgso = 3.13E-11+dcgso_n_18_cap    cgdo = 3.13E-11+dcgdo_n_18_cap
+cgbo = 0                      ckappas = 0.6                 ckappad = 0.6
+cf = 6.13E-11                 clc = 1.04E-7                 cle = 0.6
+dlc = 0                 dwc = 0                       noff = 1.6
+voffcv = -0.097               acde = 1                      moin = 5.67
+cgsl = 2.71E-11+dcgsl_n_18_cap    cgdl = 2.71E-11+dcgdl_n_18_cap
//*** souce/drain junction diode model parameter **
+ijthsrev = 0.01               ijthsfwd = 0.01               xjbvs = 1
+bvs = 10                      jss = 4.14E-7                 jsws = 9.7E-13
+jswgs = 1.4E-12               cjs = 8.41E-4+dcj_n_18_cap        mjs = 0.31
+mjsws = 0.081                 cjsws = 1.02E-10+dcjsw_n_18_cap   cjswgs = 1.2E-10+dcjswg_n_18_cap
+mjswgs = 0.511                pbs = 0.511                   pbsws = 0.786
+pbswgs = 0.7
//** rf model related parameter ***
+xrcrg1 = 12                   xrcrg2 = 1                    rbpb = 50
+rbpd = 50                     rbps = 50                     rbdb = 50
+rbsb = 50                     gbmin = 1E-12
//*** stress effect related parameter ***
+saref = 6.1E-7                sbref = 6.1E-7                wlod = 1.37E-7
+ku0 = -2.471E-8               kvsat = 0.3                   kvth0 = 2.1E-9
+tku0 = 0.097                  llodku0 = 1                   wlodku0 = 1
+llodvth = 1                   wlodvth = 1                   lku0 = 1.23E-8
+wku0 = 9.96E-8                pku0 = 4.6E-14                lkvth0 = -2.421E-11
+wkvth0 = 0                    pkvth0 = 0                    stk2 = 3.87E-10
+lodk2 = 0.5                   steta0 = 0                    lodeta0 = 1
//*** temperature coefficient ***
+tnom = 25                     ute = -0.9                    kt1 = -0.235274
+kt1l = 0                      kt2 = -0.036                  ua1 = 8.32E-10
+ub1 = 0                       uc1 = 4.355E-11               at = 7E4
+prt = 0                       njs = 1                       njd = 1
+xtis = 3                      xtid = 3                      tpb = 1.1E-3
+tpbsw = 1.9E-3                tpbswg = 1E-3                 tcj = 6.52E-4
+tcjsw = 3.57E-4               tcjswg = 1.5E-3               tvoff = 2.2428E-3
+tvfbsdoff = 0.022
//*** well proximity effect model parameters ***
+web = 0                       wec = 0                       kvth0we = 2.1E-3
+k2we = 0                      ku0we = -4.21E-3              scref = 1E-6
6:type=n  minr=1e-60
//*** flag parameter ***
+version = 4.3                 binunit = 2                   mobmod = 0
+capmod = 2                    rdsmod = 0                    igcmod = 1
+igbmod = 1                    rbodymod = 0                  trnqsmod = 0
+acnqsmod = 0                  fnoimod = 1                   tnoimod = 0
+diomod = 1                    tempmod = 0                   permod = 1
+rgatemod = 0                  wpemod = 1
//*** geometry range parameter ***
+lmin = 1.5E-7                 lmax = 1E-6                   wmin = 1E-6
+wmax = 2E-6
//*** process parameter ***
+epsrox = 3.9                  toxe = tox_n_18_cap               toxm = tox_n_18_cap
+dtox = 3.2E-10                xj = 8.1E-8                   ndep = 1E17
+ngate = 1.6E20                nsd = 1E20                    rsh = 17.5
+rshg = 15.5
//*** dw and dl parameter ***
+wint = 2E-9                   wl = 0                        wln = 1
+ww = 0                        wwn = 1                       wwl = 0
+lint = 1E-9                   ll = 0                        lln = 1
+lw = 0                        lwn = 1                       lwl = 0
+llc = 0                       lwc = 0                       lwlc = 0
+wlc = 0                       wwc = 0                       wwlc = 0
+dwg = 0                       dwb = 0                       xl = 0+dxl_n_18_cap
+xw = 0+dxw_n_18_cap
//*** flicker noise model parameter ***
+noia = 3.1E42                 noib = 1.81E21                noic = 3E8
+em = 1E6                      ef = 0.86                     lintnoi = -5E-9
//***layout-dependent parasitics model parameter ***
+dmcg = 4E-8                   dmci = 4E-8                   dmdg = 0
+dmcgt = 0                     dwj = 0                       xgw = 0
+xgl = 0                       ngcon = 1
//*** vth related  parameter ***
+vth0 = 0.4207+dvth0_n_18_cap      lvth0 = 0+dlvth0_n_18_cap         wvth0 = 0+dwvth0_n_18_cap
+pvth0 = 0+dpvth0_n_18_cap         phin = 0                      k1 = 0.30264
+k2 = -0.012135                k3 = -5.68454                 k3b = 2.454986
+w0 = 8.190018E-8              lpe0 = 6.610138E-8            lpeb = 2.000404E-8
+dvtp0 = 2.36094E-6            dvtp1 = 4.5                   dvt0 = 0.236381
+dvt1 = 0.537442               dvt2 = 5.56679E-2             dvt0w = 0
+dvt1w = 0                     dvt2w = 0                     vfbsdoff = 0.02
//*** mobility related parameter ***
+u0 = 2.98009E-2+du0_n_18_cap      lu0 = 0+dlu0_n_18_cap             wu0 = 0+dwu0_n_18_cap
+pu0 = 0+dpu0_n_18_cap             ua = -9.49994E-10             ub = 2.091579E-18
+uc = 7.758295E-11             ud = 0                        vsat = 1.15107E5+dvsat_n_18_cap
+wvsat = -2.49993E-3           a0 = 1.08155                  ags = 1.051675
+wags = -5.000059E-8           b0 = 0                        b1 = 0
+keta = -5.19382E-2            a1 = 0                        a2 = 1
+rdsw = 100.002354             prwb = 0                      prwg = 0
+wr = 1
//*** subthreshold related parameter ***
+voff = -0.155578              voffl = -3.595178E-9          minv = -0.15
+nfactor = 1.621754            eta0 = 1.804707E-3            etab = -1.26845E-2
+dsub = 0.422235               cit = 7.212E-4                cdsc = 0
+cdscb = 0                     cdscd = 0
//*** output resistance related parameter ***
+pclm = 1.239489               pdiblc1 = 4.53031E-4          pdiblc2 = 7.801573E-3
+pdiblcb = 1                   drout = 0.56                  pscbe1 = 1E9
+pscbe2 = 1E-20                pvag = 0.9                    delta = 7.595625E-3
+fprout = 300                  pdits = 0                     pditsl = 0
+pditsd = 0                    alpha0 = 2E-10                alpha1 = 0.01
+beta0 = 6.4                   agidl = 1.1505E-7             bgidl = 2.692E9
+cgidl = 0.24                  egidl = 0.24
//*** gate dielectric tunneling current ***
+aigbacc = 0.0211              bigbacc = 2.44E-3             cigbacc = 0.312
+nigbacc = 6                   aigbinv = 0.017               bigbinv = 4.3E-3
+cigbinv = 5.7E-3              eigbinv = 1.04                nigbinv = 6
+aigc = 0.012                  bigc = 1.41E-3                cigc = 5.72E-4
+aigsd = 0.0116                bigsd = 1.3E-3                cigsd = 0.073
+dlcig = 2.43E-9               nigc = 2.97                   poxedge = 1
+pigcd = 2.4                   ntox = 1                      toxref = 3E-9
//*** capacitance parameter ***
+xpart = 1                     cgso = 3.13E-11+dcgso_n_18_cap    cgdo = 3.13E-11+dcgdo_n_18_cap
+cgbo = 0                      ckappas = 0.6                 ckappad = 0.6
+cf = 6.13E-11                 clc = 1.04E-7                 cle = 0.6
+dlc = 0                 dwc = 0                       noff = 1.6
+voffcv = -0.097               acde = 1                      moin = 5.67
+cgsl = 2.71E-11+dcgsl_n_18_cap    cgdl = 2.71E-11+dcgdl_n_18_cap
//*** souce/drain junction diode model parameter **
+ijthsrev = 0.01               ijthsfwd = 0.01               xjbvs = 1
+bvs = 10                      jss = 4.14E-7                 jsws = 9.7E-13
+jswgs = 1.4E-12               cjs = 8.41E-4+dcj_n_18_cap        mjs = 0.31
+mjsws = 0.081                 cjsws = 1.02E-10+dcjsw_n_18_cap   cjswgs = 1.2E-10+dcjswg_n_18_cap
+mjswgs = 0.511                pbs = 0.511                   pbsws = 0.786
+pbswgs = 0.7
//** rf model related parameter ***
+xrcrg1 = 12                   xrcrg2 = 1                    rbpb = 50
+rbpd = 50                     rbps = 50                     rbdb = 50
+rbsb = 50                     gbmin = 1E-12
//*** stress effect related parameter ***
+saref = 6.1E-7                sbref = 6.1E-7                wlod = 1.37E-7
+ku0 = -2.471E-8               kvsat = 0.3                   kvth0 = 2.1E-9
+tku0 = 0.097                  llodku0 = 1                   wlodku0 = 1
+llodvth = 1                   wlodvth = 1                   lku0 = 1.23E-8
+wku0 = 9.96E-8                pku0 = 4.6E-14                lkvth0 = -2.421E-11
+wkvth0 = 0                    pkvth0 = 0                    stk2 = 3.87E-10
+lodk2 = 0.5                   steta0 = 0                    lodeta0 = 1
//*** temperature coefficient ***
+tnom = 25                     ute = -0.9                    kt1 = -0.235274
+kt1l = 0                      kt2 = -0.036                  ua1 = 8.32E-10
+ub1 = 0                       uc1 = 4.355E-11               at = 7E4
+prt = 0                       njs = 1                       njd = 1
+xtis = 3                      xtid = 3                      tpb = 1.1E-3
+tpbsw = 1.9E-3                tpbswg = 1E-3                 tcj = 6.52E-4
+tcjsw = 3.57E-4               tcjswg = 1.5E-3               tvoff = 2.2428E-3
+tvfbsdoff = 0.022
//*** well proximity effect model parameters ***
+web = 0                       wec = 0                       kvth0we = 2.1E-3
+k2we = 0                      ku0we = -4.21E-3              scref = 1E-6
7:type=n  minr=1e-60
//*** flag parameter ***
+version = 4.3                 binunit = 2                   mobmod = 0
+capmod = 2                    rdsmod = 0                    igcmod = 1
+igbmod = 1                    rbodymod = 0                  trnqsmod = 0
+acnqsmod = 0                  fnoimod = 1                   tnoimod = 0
+diomod = 1                    tempmod = 0                   permod = 1
+rgatemod = 0                  wpemod = 1
//*** geometry range parameter ***
+lmin = 2E-6                   lmax = 1E-5                   wmin = 5E-7
+wmax = 1E-6
//*** process parameter ***
+epsrox = 3.9                  toxe = tox_n_18_cap               toxm = tox_n_18_cap
+dtox = 3.2E-10                xj = 8.1E-8                   ndep = 1E17
+ngate = 1.6E20                nsd = 1E20                    rsh = 17.5
+rshg = 15.5
//*** dw and dl parameter ***
+wint = 2E-9                   wl = 0                        wln = 1
+ww = 0                        wwn = 1                       wwl = 0
+lint = 1E-9                   ll = 0                        lln = 1
+lw = 0                        lwn = 1                       lwl = 0
+llc = 0                       lwc = 0                       lwlc = 0
+wlc = 0                       wwc = 0                       wwlc = 0
+dwg = 0                       dwb = 0                       xl = 0+dxl_n_18_cap
+xw = 0+dxw_n_18_cap
//*** flicker noise model parameter ***
+noia = 3.1E42                 noib = 1.81E21                noic = 3E8
+em = 1E6                      ef = 0.86                     lintnoi = -5E-9
//***layout-dependent parasitics model parameter ***
+dmcg = 4E-8                   dmci = 4E-8                   dmdg = 0
+dmcgt = 0                     dwj = 0                       xgw = 0
+xgl = 0                       ngcon = 1
//*** vth related  parameter ***
+vth0 = 0.4207+dvth0_n_18_cap      lvth0 = 0+dlvth0_n_18_cap         wvth0 = 0+dwvth0_n_18_cap
+pvth0 = 0+dpvth0_n_18_cap         phin = 0                      k1 = 0.30264
+k2 = -0.012135                k3 = -5.68454                 k3b = 2.454986
+w0 = 8.190018E-8              lpe0 = 6.610138E-8            lpeb = 2.000404E-8
+dvtp0 = 2.36094E-6            dvtp1 = 4.5                   dvt0 = 0.236381
+dvt1 = 0.537442               dvt2 = 5.56679E-2             dvt0w = 0
+dvt1w = 0                     dvt2w = 0                     vfbsdoff = 0.02
//*** mobility related parameter ***
+u0 = 2.98009E-2+du0_n_18_cap      lu0 = 0+dlu0_n_18_cap             wu0 = 0+dwu0_n_18_cap
+pu0 = 0+dpu0_n_18_cap             ua = -9.49994E-10             ub = 2.091579E-18
+uc = 7.758295E-11             ud = 0                        vsat = 1.151071E5+dvsat_n_18_cap
+wvsat = -2.500017E-3          a0 = 1.08155                  ags = 1.051674
+wags = -4.999936E-8           b0 = 0                        b1 = 0
+keta = -5.19382E-2            a1 = 0                        a2 = 1
+rdsw = 100.002354             prwb = 0                      prwg = 0
+wr = 1
//*** subthreshold related parameter ***
+voff = -0.155578              voffl = -3.595178E-9          minv = -0.15
+nfactor = 1.621754            eta0 = 1.804707E-3            etab = -1.26845E-2
+dsub = 0.422235               cit = 7.212E-4                cdsc = 0
+cdscb = 0                     cdscd = 0
//*** output resistance related parameter ***
+pclm = 1.239489               pdiblc1 = 4.53031E-4          pdiblc2 = 7.801573E-3
+pdiblcb = 1                   drout = 0.56                  pscbe1 = 1E9
+pscbe2 = 1E-20                pvag = 0.9                    delta = 7.595625E-3
+fprout = 300                  pdits = 0                     pditsl = 0
+pditsd = 0                    alpha0 = 2E-10                alpha1 = 0.01
+beta0 = 6.4                   agidl = 1.1505E-7             bgidl = 2.692E9
+cgidl = 0.24                  egidl = 0.24
//*** gate dielectric tunneling current ***
+aigbacc = 0.0211              bigbacc = 2.44E-3             cigbacc = 0.312
+nigbacc = 6                   aigbinv = 0.017               bigbinv = 4.3E-3
+cigbinv = 5.7E-3              eigbinv = 1.04                nigbinv = 6
+aigc = 0.012                  bigc = 1.41E-3                cigc = 5.72E-4
+aigsd = 0.0116                bigsd = 1.3E-3                cigsd = 0.073
+dlcig = 2.43E-9               nigc = 2.97                   poxedge = 1
+pigcd = 2.4                   ntox = 1                      toxref = 3E-9
//*** capacitance parameter ***
+xpart = 1                     cgso = 3.13E-11+dcgso_n_18_cap    cgdo = 3.13E-11+dcgdo_n_18_cap
+cgbo = 0                      ckappas = 0.6                 ckappad = 0.6
+cf = 6.13E-11                 clc = 1.04E-7                 cle = 0.6
+dlc = 0                 dwc = 0                       noff = 1.6
+voffcv = -0.097               acde = 1                      moin = 5.67
+cgsl = 2.71E-11+dcgsl_n_18_cap    cgdl = 2.71E-11+dcgdl_n_18_cap
//*** souce/drain junction diode model parameter **
+ijthsrev = 0.01               ijthsfwd = 0.01               xjbvs = 1
+bvs = 10                      jss = 4.14E-7                 jsws = 9.7E-13
+jswgs = 1.4E-12               cjs = 8.41E-4+dcj_n_18_cap        mjs = 0.31
+mjsws = 0.081                 cjsws = 1.02E-10+dcjsw_n_18_cap   cjswgs = 1.2E-10+dcjswg_n_18_cap
+mjswgs = 0.511                pbs = 0.511                   pbsws = 0.786
+pbswgs = 0.7
//** rf model related parameter ***
+xrcrg1 = 12                   xrcrg2 = 1                    rbpb = 50
+rbpd = 50                     rbps = 50                     rbdb = 50
+rbsb = 50                     gbmin = 1E-12
//*** stress effect related parameter ***
+saref = 6.1E-7                sbref = 6.1E-7                wlod = 1.37E-7
+ku0 = -2.471E-8               kvsat = 0.3                   kvth0 = 2.1E-9
+tku0 = 0.097                  llodku0 = 1                   wlodku0 = 1
+llodvth = 1                   wlodvth = 1                   lku0 = 1.23E-8
+wku0 = 9.96E-8                pku0 = 4.6E-14                lkvth0 = -2.421E-11
+wkvth0 = 0                    pkvth0 = 0                    stk2 = 3.87E-10
+lodk2 = 0.5                   steta0 = 0                    lodeta0 = 1
//*** temperature coefficient ***
+tnom = 25                     ute = -0.9                    kt1 = -0.235274
+kt1l = 0                      kt2 = -0.036                  ua1 = 8.32E-10
+ub1 = 0                       uc1 = 4.355E-11               at = 7E4
+prt = 0                       njs = 1                       njd = 1
+xtis = 3                      xtid = 3                      tpb = 1.1E-3
+tpbsw = 1.9E-3                tpbswg = 1E-3                 tcj = 6.52E-4
+tcjsw = 3.57E-4               tcjswg = 1.5E-3               tvoff = 2.2428E-3
+tvfbsdoff = 0.022
//*** well proximity effect model parameters ***
+web = 0                       wec = 0                       kvth0we = 2.1E-3
+k2we = 0                      ku0we = -4.21E-3              scref = 1E-6
8:type=n  minr=1e-60
//*** flag parameter ***
+version = 4.3                 binunit = 2                   mobmod = 0
+capmod = 2                    rdsmod = 0                    igcmod = 1
+igbmod = 1                    rbodymod = 0                  trnqsmod = 0
+acnqsmod = 0                  fnoimod = 1                   tnoimod = 0
+diomod = 1                    tempmod = 0                   permod = 1
+rgatemod = 0                  wpemod = 1
//*** geometry range parameter ***
+lmin = 1E-6                   lmax = 2E-6                   wmin = 5E-7
+wmax = 1E-6
//*** process parameter ***
+epsrox = 3.9                  toxe = tox_n_18_cap               toxm = tox_n_18_cap
+dtox = 3.2E-10                xj = 8.1E-8                   ndep = 1E17
+ngate = 1.6E20                nsd = 1E20                    rsh = 17.5
+rshg = 15.5
//*** dw and dl parameter ***
+wint = 2E-9                   wl = 0                        wln = 1
+ww = 0                        wwn = 1                       wwl = 0
+lint = 1E-9                   ll = 0                        lln = 1
+lw = 0                        lwn = 1                       lwl = 0
+llc = 0                       lwc = 0                       lwlc = 0
+wlc = 0                       wwc = 0                       wwlc = 0
+dwg = 0                       dwb = 0                       xl = 0+dxl_n_18_cap
+xw = 0+dxw_n_18_cap
//*** flicker noise model parameter ***
+noia = 3.1E42                 noib = 1.81E21                noic = 3E8
+em = 1E6                      ef = 0.86                     lintnoi = -5E-9
//***layout-dependent parasitics model parameter ***
+dmcg = 4E-8                   dmci = 4E-8                   dmdg = 0
+dmcgt = 0                     dwj = 0                       xgw = 0
+xgl = 0                       ngcon = 1
//*** vth related  parameter ***
+vth0 = 0.4207+dvth0_n_18_cap      lvth0 = 0+dlvth0_n_18_cap         wvth0 = 0+dwvth0_n_18_cap
+pvth0 = 0+dpvth0_n_18_cap         phin = 0                      k1 = 0.30264
+k2 = -0.012135                k3 = -5.68454                 k3b = 2.454986
+w0 = 8.190018E-8              lpe0 = 6.610138E-8            lpeb = 2.000404E-8
+dvtp0 = 2.36094E-6            dvtp1 = 4.5                   dvt0 = 0.236381
+dvt1 = 0.537442               dvt2 = 5.56679E-2             dvt0w = 0
+dvt1w = 0                     dvt2w = 0                     vfbsdoff = 0.02
//*** mobility related parameter ***
+u0 = 2.98009E-2+du0_n_18_cap      lu0 = 0+dlu0_n_18_cap             wu0 = 0+dwu0_n_18_cap
+pu0 = 0+dpu0_n_18_cap             ua = -9.49994E-10             ub = 2.091579E-18
+uc = 7.758295E-11             ud = 0                        vsat = 1.151071E5+dvsat_n_18_cap
+wvsat = -2.500017E-3          a0 = 1.08155                  ags = 1.051674
+wags = -4.999936E-8           b0 = 0                        b1 = 0
+keta = -5.19382E-2            a1 = 0                        a2 = 1
+rdsw = 100.002354             prwb = 0                      prwg = 0
+wr = 1
//*** subthreshold related parameter ***
+voff = -0.155578              voffl = -3.595178E-9          minv = -0.15
+nfactor = 1.621754            eta0 = 1.804707E-3            etab = -1.26845E-2
+dsub = 0.422235               cit = 7.212E-4                cdsc = 0
+cdscb = 0                     cdscd = 0
//*** output resistance related parameter ***
+pclm = 1.239489               pdiblc1 = 4.53031E-4          pdiblc2 = 7.801573E-3
+pdiblcb = 1                   drout = 0.56                  pscbe1 = 1E9
+pscbe2 = 1E-20                pvag = 0.9                    delta = 7.595625E-3
+fprout = 300                  pdits = 0                     pditsl = 0
+pditsd = 0                    alpha0 = 2E-10                alpha1 = 0.01
+beta0 = 6.4                   agidl = 1.1505E-7             bgidl = 2.692E9
+cgidl = 0.24                  egidl = 0.24
//*** gate dielectric tunneling current ***
+aigbacc = 0.0211              bigbacc = 2.44E-3             cigbacc = 0.312
+nigbacc = 6                   aigbinv = 0.017               bigbinv = 4.3E-3
+cigbinv = 5.7E-3              eigbinv = 1.04                nigbinv = 6
+aigc = 0.012                  bigc = 1.41E-3                cigc = 5.72E-4
+aigsd = 0.0116                bigsd = 1.3E-3                cigsd = 0.073
+dlcig = 2.43E-9               nigc = 2.97                   poxedge = 1
+pigcd = 2.4                   ntox = 1                      toxref = 3E-9
//*** capacitance parameter ***
+xpart = 1                     cgso = 3.13E-11+dcgso_n_18_cap    cgdo = 3.13E-11+dcgdo_n_18_cap
+cgbo = 0                      ckappas = 0.6                 ckappad = 0.6
+cf = 6.13E-11                 clc = 1.04E-7                 cle = 0.6
+dlc = 0                 dwc = 0                       noff = 1.6
+voffcv = -0.097               acde = 1                      moin = 5.67
+cgsl = 2.71E-11+dcgsl_n_18_cap    cgdl = 2.71E-11+dcgdl_n_18_cap
//*** souce/drain junction diode model parameter **
+ijthsrev = 0.01               ijthsfwd = 0.01               xjbvs = 1
+bvs = 10                      jss = 4.14E-7                 jsws = 9.7E-13
+jswgs = 1.4E-12               cjs = 8.41E-4+dcj_n_18_cap        mjs = 0.31
+mjsws = 0.081                 cjsws = 1.02E-10+dcjsw_n_18_cap   cjswgs = 1.2E-10+dcjswg_n_18_cap
+mjswgs = 0.511                pbs = 0.511                   pbsws = 0.786
+pbswgs = 0.7
//** rf model related parameter ***
+xrcrg1 = 12                   xrcrg2 = 1                    rbpb = 50
+rbpd = 50                     rbps = 50                     rbdb = 50
+rbsb = 50                     gbmin = 1E-12
//*** stress effect related parameter ***
+saref = 6.1E-7                sbref = 6.1E-7                wlod = 1.37E-7
+ku0 = -2.471E-8               kvsat = 0.3                   kvth0 = 2.1E-9
+tku0 = 0.097                  llodku0 = 1                   wlodku0 = 1
+llodvth = 1                   wlodvth = 1                   lku0 = 1.23E-8
+wku0 = 9.96E-8                pku0 = 4.6E-14                lkvth0 = -2.421E-11
+wkvth0 = 0                    pkvth0 = 0                    stk2 = 3.87E-10
+lodk2 = 0.5                   steta0 = 0                    lodeta0 = 1
//*** temperature coefficient ***
+tnom = 25                     ute = -0.9                    kt1 = -0.235274
+kt1l = 0                      kt2 = -0.036                  ua1 = 8.32E-10
+ub1 = 0                       uc1 = 4.355E-11               at = 7E4
+prt = 0                       njs = 1                       njd = 1
+xtis = 3                      xtid = 3                      tpb = 1.1E-3
+tpbsw = 1.9E-3                tpbswg = 1E-3                 tcj = 6.52E-4
+tcjsw = 3.57E-4               tcjswg = 1.5E-3               tvoff = 2.2428E-3
+tvfbsdoff = 0.022
//*** well proximity effect model parameters ***
+web = 0                       wec = 0                       kvth0we = 2.1E-3
+k2we = 0                      ku0we = -4.21E-3              scref = 1E-6
9:type=n  minr=1e-60
//*** flag parameter ***
+version = 4.3                 binunit = 2                   mobmod = 0
+capmod = 2                    rdsmod = 0                    igcmod = 1
+igbmod = 1                    rbodymod = 0                  trnqsmod = 0
+acnqsmod = 0                  fnoimod = 1                   tnoimod = 0
+diomod = 1                    tempmod = 0                   permod = 1
+rgatemod = 0                  wpemod = 1
//*** geometry range parameter ***
+lmin = 1.5E-7                 lmax = 1E-6                   wmin = 5E-7
+wmax = 1E-6
//*** process parameter ***
+epsrox = 3.9                  toxe = tox_n_18_cap               toxm = tox_n_18_cap
+dtox = 3.2E-10                xj = 8.1E-8                   ndep = 1E17
+ngate = 1.6E20                nsd = 1E20                    rsh = 17.5
+rshg = 15.5
//*** dw and dl parameter ***
+wint = 2E-9                   wl = 0                        wln = 1
+ww = 0                        wwn = 1                       wwl = 0
+lint = 1E-9                   ll = 0                        lln = 1
+lw = 0                        lwn = 1                       lwl = 0
+llc = 0                       lwc = 0                       lwlc = 0
+wlc = 0                       wwc = 0                       wwlc = 0
+dwg = 0                       dwb = 0                       xl = 0+dxl_n_18_cap
+xw = 0+dxw_n_18_cap
//*** flicker noise model parameter ***
+noia = 3.1E42                 noib = 1.81E21                noic = 3E8
+em = 1E6                      ef = 0.86                     lintnoi = -5E-9
//***layout-dependent parasitics model parameter ***
+dmcg = 4E-8                   dmci = 4E-8                   dmdg = 0
+dmcgt = 0                     dwj = 0                       xgw = 0
+xgl = 0                       ngcon = 1
//*** vth related  parameter ***
+vth0 = 0.4207+dvth0_n_18_cap      lvth0 = 0+dlvth0_n_18_cap         wvth0 = 0+dwvth0_n_18_cap
+pvth0 = 0+dpvth0_n_18_cap         phin = 0                      k1 = 0.30264
+k2 = -0.012135                k3 = -5.68454                 k3b = 2.454986
+w0 = 8.190018E-8              lpe0 = 6.610138E-8            lpeb = 2.000404E-8
+dvtp0 = 2.36094E-6            dvtp1 = 4.5                   dvt0 = 0.236381
+dvt1 = 0.537442               dvt2 = 5.56679E-2             dvt0w = 0
+dvt1w = 0                     dvt2w = 0                     vfbsdoff = 0.02
//*** mobility related parameter ***
+u0 = 2.98009E-2+du0_n_18_cap      lu0 = 0+dlu0_n_18_cap             wu0 = 0+dwu0_n_18_cap
+pu0 = 0+dpu0_n_18_cap             ua = -9.49994E-10             ub = 2.091579E-18
+uc = 7.758295E-11             ud = 0                        vsat = 1.151071E5+dvsat_n_18_cap
+wvsat = -2.500017E-3          a0 = 1.08155                  ags = 1.051674
+wags = -4.999936E-8           b0 = 0                        b1 = 0
+keta = -5.19382E-2            a1 = 0                        a2 = 1
+rdsw = 100.002354             prwb = 0                      prwg = 0
+wr = 1
//*** subthreshold related parameter ***
+voff = -0.155578              voffl = -3.595178E-9          minv = -0.15
+nfactor = 1.621754            eta0 = 1.804707E-3            etab = -1.26845E-2
+dsub = 0.422235               cit = 7.212E-4                cdsc = 0
+cdscb = 0                     cdscd = 0
//*** output resistance related parameter ***
+pclm = 1.239489               pdiblc1 = 4.53031E-4          pdiblc2 = 7.801573E-3
+pdiblcb = 1                   drout = 0.56                  pscbe1 = 1E9
+pscbe2 = 1E-20                pvag = 0.9                    delta = 7.595625E-3
+fprout = 300                  pdits = 0                     pditsl = 0
+pditsd = 0                    alpha0 = 2E-10                alpha1 = 0.01
+beta0 = 6.4                   agidl = 1.1505E-7             bgidl = 2.692E9
+cgidl = 0.24                  egidl = 0.24
//*** gate dielectric tunneling current ***
+aigbacc = 0.0211              bigbacc = 2.44E-3             cigbacc = 0.312
+nigbacc = 6                   aigbinv = 0.017               bigbinv = 4.3E-3
+cigbinv = 5.7E-3              eigbinv = 1.04                nigbinv = 6
+aigc = 0.012                  bigc = 1.41E-3                cigc = 5.72E-4
+aigsd = 0.0116                bigsd = 1.3E-3                cigsd = 0.073
+dlcig = 2.43E-9               nigc = 2.97                   poxedge = 1
+pigcd = 2.4                   ntox = 1                      toxref = 3E-9
//*** capacitance parameter ***
+xpart = 1                     cgso = 3.13E-11+dcgso_n_18_cap    cgdo = 3.13E-11+dcgdo_n_18_cap
+cgbo = 0                      ckappas = 0.6                 ckappad = 0.6
+cf = 6.13E-11                 clc = 1.04E-7                 cle = 0.6
+dlc = 0                 dwc = 0                       noff = 1.6
+voffcv = -0.097               acde = 1                      moin = 5.67
+cgsl = 2.71E-11+dcgsl_n_18_cap    cgdl = 2.71E-11+dcgdl_n_18_cap
//*** souce/drain junction diode model parameter **
+ijthsrev = 0.01               ijthsfwd = 0.01               xjbvs = 1
+bvs = 10                      jss = 4.14E-7                 jsws = 9.7E-13
+jswgs = 1.4E-12               cjs = 8.41E-4+dcj_n_18_cap        mjs = 0.31
+mjsws = 0.081                 cjsws = 1.02E-10+dcjsw_n_18_cap   cjswgs = 1.2E-10+dcjswg_n_18_cap
+mjswgs = 0.511                pbs = 0.511                   pbsws = 0.786
+pbswgs = 0.7
//** rf model related parameter ***
+xrcrg1 = 12                   xrcrg2 = 1                    rbpb = 50
+rbpd = 50                     rbps = 50                     rbdb = 50
+rbsb = 50                     gbmin = 1E-12
//*** stress effect related parameter ***
+saref = 6.1E-7                sbref = 6.1E-7                wlod = 1.37E-7
+ku0 = -2.471E-8               kvsat = 0.3                   kvth0 = 2.1E-9
+tku0 = 0.097                  llodku0 = 1                   wlodku0 = 1
+llodvth = 1                   wlodvth = 1                   lku0 = 1.23E-8
+wku0 = 9.96E-8                pku0 = 4.6E-14                lkvth0 = -2.421E-11
+wkvth0 = 0                    pkvth0 = 0                    stk2 = 3.87E-10
+lodk2 = 0.5                   steta0 = 0                    lodeta0 = 1
//*** temperature coefficient ***
+tnom = 25                     ute = -0.9                    kt1 = -0.235274
+kt1l = 0                      kt2 = -0.036                  ua1 = 8.32E-10
+ub1 = 0                       uc1 = 4.355E-11               at = 7E4
+prt = 0                       njs = 1                       njd = 1
+xtis = 3                      xtid = 3                      tpb = 1.1E-3
+tpbsw = 1.9E-3                tpbswg = 1E-3                 tcj = 6.52E-4
+tcjsw = 3.57E-4               tcjswg = 1.5E-3               tvoff = 2.2428E-3
+tvfbsdoff = 0.022
//*** well proximity effect model parameters ***
+web = 0                       wec = 0                       kvth0we = 2.1E-3
+k2we = 0                      ku0we = -4.21E-3              scref = 1E-6
10:type=n  minr=1e-60
//*** flag parameter ***
+version = 4.3                 binunit = 2                   mobmod = 0
+capmod = 2                    rdsmod = 0                    igcmod = 1
+igbmod = 1                    rbodymod = 0                  trnqsmod = 0
+acnqsmod = 0                  fnoimod = 1                   tnoimod = 0
+diomod = 1                    tempmod = 0                   permod = 1
+rgatemod = 0                  wpemod = 1
//*** geometry range parameter ***
+lmin = 2E-6                   lmax = 1E-5                   wmin = 3.2E-7
+wmax = 5E-7
//*** process parameter ***
+epsrox = 3.9                  toxe = tox_n_18_cap               toxm = tox_n_18_cap
+dtox = 3.2E-10                xj = 8.1E-8                   ndep = 1E17
+ngate = 1.6E20                nsd = 1E20                    rsh = 17.5
+rshg = 15.5
//*** dw and dl parameter ***
+wint = 2E-9                   wl = 0                        wln = 1
+ww = 0                        wwn = 1                       wwl = 0
+lint = 1E-9                   ll = 0                        lln = 1
+lw = 0                        lwn = 1                       lwl = 0
+llc = 0                       lwc = 0                       lwlc = 0
+wlc = 0                       wwc = 0                       wwlc = 0
+dwg = 0                       dwb = 0                       xl = 0+dxl_n_18_cap
+xw = 0+dxw_n_18_cap
//*** flicker noise model parameter ***
+noia = 3.1E42                 noib = 1.81E21                noic = 3E8
+em = 1E6                      ef = 0.86                     lintnoi = -5E-9
//***layout-dependent parasitics model parameter ***
+dmcg = 4E-8                   dmci = 4E-8                   dmdg = 0
+dmcgt = 0                     dwj = 0                       xgw = 0
+xgl = 0                       ngcon = 1
//*** vth related  parameter ***
+vth0 = 0.4207+dvth0_n_18_cap      lvth0 = 0+dlvth0_n_18_cap         wvth0 = 0+dwvth0_n_18_cap
+pvth0 = 0+dpvth0_n_18_cap         phin = 0                      k1 = 0.30264
+k2 = -0.012135                k3 = -5.68454                 k3b = 2.454986
+w0 = 8.190018E-8              lpe0 = 6.610138E-8            lpeb = 2.000404E-8
+dvtp0 = 2.36094E-6            dvtp1 = 4.5                   dvt0 = 0.236381
+dvt1 = 0.537442               dvt2 = 5.56679E-2             dvt0w = 0
+dvt1w = 0                     dvt2w = 0                     vfbsdoff = 0.02
//*** mobility related parameter ***
+u0 = 2.98009E-2+du0_n_18_cap      lu0 = 0+dlu0_n_18_cap             wu0 = 0+dwu0_n_18_cap
+pu0 = 0+dpu0_n_18_cap             ua = -9.49994E-10             ub = 2.091579E-18
+uc = 7.758295E-11             ud = 0                        vsat = 1.151071E5+dvsat_n_18_cap
+wvsat = -2.500026E-3          a0 = 1.08155                  ags = 1.051677
+wags = -5.000053E-8           b0 = 0                        b1 = 0
+keta = -5.19382E-2            a1 = 0                        a2 = 1
+rdsw = 100.002354             prwb = 0                      prwg = 0
+wr = 1
//*** subthreshold related parameter ***
+voff = -0.155578              voffl = -3.595178E-9          minv = -0.15
+nfactor = 1.621754            eta0 = 1.804707E-3            etab = -1.26845E-2
+dsub = 0.422235               cit = 7.212E-4                cdsc = 0
+cdscb = 0                     cdscd = 0
//*** output resistance related parameter ***
+pclm = 1.239489               pdiblc1 = 4.53031E-4          pdiblc2 = 7.801573E-3
+pdiblcb = 1                   drout = 0.56                  pscbe1 = 1E9
+pscbe2 = 1E-20                pvag = 0.9                    delta = 7.595625E-3
+fprout = 300                  pdits = 0                     pditsl = 0
+pditsd = 0                    alpha0 = 2E-10                alpha1 = 0.01
+beta0 = 6.4                   agidl = 1.1505E-7             bgidl = 2.692E9
+cgidl = 0.24                  egidl = 0.24
//*** gate dielectric tunneling current ***
+aigbacc = 0.0211              bigbacc = 2.44E-3             cigbacc = 0.312
+nigbacc = 6                   aigbinv = 0.017               bigbinv = 4.3E-3
+cigbinv = 5.7E-3              eigbinv = 1.04                nigbinv = 6
+aigc = 0.012                  bigc = 1.41E-3                cigc = 5.72E-4
+aigsd = 0.0116                bigsd = 1.3E-3                cigsd = 0.073
+dlcig = 2.43E-9               nigc = 2.97                   poxedge = 1
+pigcd = 2.4                   ntox = 1                      toxref = 3E-9
//*** capacitance parameter ***
+xpart = 1                     cgso = 3.13E-11+dcgso_n_18_cap    cgdo = 3.13E-11+dcgdo_n_18_cap
+cgbo = 0                      ckappas = 0.6                 ckappad = 0.6
+cf = 6.13E-11                 clc = 1.04E-7                 cle = 0.6
+dlc = 0                 dwc = 0                       noff = 1.6
+voffcv = -0.097               acde = 1                      moin = 5.67
+cgsl = 2.71E-11+dcgsl_n_18_cap    cgdl = 2.71E-11+dcgdl_n_18_cap
//*** souce/drain junction diode model parameter **
+ijthsrev = 0.01               ijthsfwd = 0.01               xjbvs = 1
+bvs = 10                      jss = 4.14E-7                 jsws = 9.7E-13
+jswgs = 1.4E-12               cjs = 8.41E-4+dcj_n_18_cap        mjs = 0.31
+mjsws = 0.081                 cjsws = 1.02E-10+dcjsw_n_18_cap   cjswgs = 1.2E-10+dcjswg_n_18_cap
+mjswgs = 0.511                pbs = 0.511                   pbsws = 0.786
+pbswgs = 0.7
//** rf model related parameter ***
+xrcrg1 = 12                   xrcrg2 = 1                    rbpb = 50
+rbpd = 50                     rbps = 50                     rbdb = 50
+rbsb = 50                     gbmin = 1E-12
//*** stress effect related parameter ***
+saref = 6.1E-7                sbref = 6.1E-7                wlod = 1.37E-7
+ku0 = -2.471E-8               kvsat = 0.3                   kvth0 = 2.1E-9
+tku0 = 0.097                  llodku0 = 1                   wlodku0 = 1
+llodvth = 1                   wlodvth = 1                   lku0 = 1.23E-8
+wku0 = 9.96E-8                pku0 = 4.6E-14                lkvth0 = -2.421E-11
+wkvth0 = 0                    pkvth0 = 0                    stk2 = 3.87E-10
+lodk2 = 0.5                   steta0 = 0                    lodeta0 = 1
//*** temperature coefficient ***
+tnom = 25                     ute = -0.9                    kt1 = -0.235274
+kt1l = 0                      kt2 = -0.036                  ua1 = 8.32E-10
+ub1 = 0                       uc1 = 4.355E-11               at = 7E4
+prt = 0                       njs = 1                       njd = 1
+xtis = 3                      xtid = 3                      tpb = 1.1E-3
+tpbsw = 1.9E-3                tpbswg = 1E-3                 tcj = 6.52E-4
+tcjsw = 3.57E-4               tcjswg = 1.5E-3               tvoff = 2.2428E-3
+tvfbsdoff = 0.022
//*** well proximity effect model parameters ***
+web = 0                       wec = 0                       kvth0we = 2.1E-3
+k2we = 0                      ku0we = -4.21E-3              scref = 1E-6
11:type=n  minr=1e-60
//*** flag parameter ***
+version = 4.3                 binunit = 2                   mobmod = 0
+capmod = 2                    rdsmod = 0                    igcmod = 1
+igbmod = 1                    rbodymod = 0                  trnqsmod = 0
+acnqsmod = 0                  fnoimod = 1                   tnoimod = 0
+diomod = 1                    tempmod = 0                   permod = 1
+rgatemod = 0                  wpemod = 1
//*** geometry range parameter ***
+lmin = 1E-6                   lmax = 2E-6                   wmin = 3.2E-7
+wmax = 5E-7
//*** process parameter ***
+epsrox = 3.9                  toxe = tox_n_18_cap               toxm = tox_n_18_cap
+dtox = 3.2E-10                xj = 8.1E-8                   ndep = 1E17
+ngate = 1.6E20                nsd = 1E20                    rsh = 17.5
+rshg = 15.5
//*** dw and dl parameter ***
+wint = 2E-9                   wl = 0                        wln = 1
+ww = 0                        wwn = 1                       wwl = 0
+lint = 1E-9                   ll = 0                        lln = 1
+lw = 0                        lwn = 1                       lwl = 0
+llc = 0                       lwc = 0                       lwlc = 0
+wlc = 0                       wwc = 0                       wwlc = 0
+dwg = 0                       dwb = 0                       xl = 0+dxl_n_18_cap
+xw = 0+dxw_n_18_cap
//*** flicker noise model parameter ***
+noia = 3.1E42                 noib = 1.81E21                noic = 3E8
+em = 1E6                      ef = 0.86                     lintnoi = -5E-9
//***layout-dependent parasitics model parameter ***
+dmcg = 4E-8                   dmci = 4E-8                   dmdg = 0
+dmcgt = 0                     dwj = 0                       xgw = 0
+xgl = 0                       ngcon = 1
//*** vth related  parameter ***
+vth0 = 0.4207+dvth0_n_18_cap      lvth0 = 0+dlvth0_n_18_cap         wvth0 = 0+dwvth0_n_18_cap
+pvth0 = 0+dpvth0_n_18_cap         phin = 0                      k1 = 0.30264
+k2 = -0.012135                k3 = -5.68454                 k3b = 2.454986
+w0 = 8.190018E-8              lpe0 = 6.610138E-8            lpeb = 2.000404E-8
+dvtp0 = 2.36094E-6            dvtp1 = 4.5                   dvt0 = 0.236381
+dvt1 = 0.537442               dvt2 = 5.56679E-2             dvt0w = 0
+dvt1w = 0                     dvt2w = 0                     vfbsdoff = 0.02
//*** mobility related parameter ***
+u0 = 2.98009E-2+du0_n_18_cap      lu0 = 0+dlu0_n_18_cap             wu0 = 0+dwu0_n_18_cap
+pu0 = 0+dpu0_n_18_cap             ua = -9.49994E-10             ub = 2.091579E-18
+uc = 7.758295E-11             ud = 0                        vsat = 1.151071E5+dvsat_n_18_cap
+wvsat = -2.500026E-3          a0 = 1.08155                  ags = 1.051677
+wags = -5.000053E-8           b0 = 0                        b1 = 0
+keta = -5.19382E-2            a1 = 0                        a2 = 1
+rdsw = 100.002354             prwb = 0                      prwg = 0
+wr = 1
//*** subthreshold related parameter ***
+voff = -0.155578              voffl = -3.595178E-9          minv = -0.15
+nfactor = 1.621754            eta0 = 1.804707E-3            etab = -1.26845E-2
+dsub = 0.422235               cit = 7.212E-4                cdsc = 0
+cdscb = 0                     cdscd = 0
//*** output resistance related parameter ***
+pclm = 1.239489               pdiblc1 = 4.53031E-4          pdiblc2 = 7.801573E-3
+pdiblcb = 1                   drout = 0.56                  pscbe1 = 1E9
+pscbe2 = 1E-20                pvag = 0.9                    delta = 7.595625E-3
+fprout = 300                  pdits = 0                     pditsl = 0
+pditsd = 0                    alpha0 = 2E-10                alpha1 = 0.01
+beta0 = 6.4                   agidl = 1.1505E-7             bgidl = 2.692E9
+cgidl = 0.24                  egidl = 0.24
//*** gate dielectric tunneling current ***
+aigbacc = 0.0211              bigbacc = 2.44E-3             cigbacc = 0.312
+nigbacc = 6                   aigbinv = 0.017               bigbinv = 4.3E-3
+cigbinv = 5.7E-3              eigbinv = 1.04                nigbinv = 6
+aigc = 0.012                  bigc = 1.41E-3                cigc = 5.72E-4
+aigsd = 0.0116                bigsd = 1.3E-3                cigsd = 0.073
+dlcig = 2.43E-9               nigc = 2.97                   poxedge = 1
+pigcd = 2.4                   ntox = 1                      toxref = 3E-9
//*** capacitance parameter ***
+xpart = 1                     cgso = 3.13E-11+dcgso_n_18_cap    cgdo = 3.13E-11+dcgdo_n_18_cap
+cgbo = 0                      ckappas = 0.6                 ckappad = 0.6
+cf = 6.13E-11                 clc = 1.04E-7                 cle = 0.6
+dlc = 0                 dwc = 0                       noff = 1.6
+voffcv = -0.097               acde = 1                      moin = 5.67
+cgsl = 2.71E-11+dcgsl_n_18_cap    cgdl = 2.71E-11+dcgdl_n_18_cap
//*** souce/drain junction diode model parameter **
+ijthsrev = 0.01               ijthsfwd = 0.01               xjbvs = 1
+bvs = 10                      jss = 4.14E-7                 jsws = 9.7E-13
+jswgs = 1.4E-12               cjs = 8.41E-4+dcj_n_18_cap        mjs = 0.31
+mjsws = 0.081                 cjsws = 1.02E-10+dcjsw_n_18_cap   cjswgs = 1.2E-10+dcjswg_n_18_cap
+mjswgs = 0.511                pbs = 0.511                   pbsws = 0.786
+pbswgs = 0.7
//** rf model related parameter ***
+xrcrg1 = 12                   xrcrg2 = 1                    rbpb = 50
+rbpd = 50                     rbps = 50                     rbdb = 50
+rbsb = 50                     gbmin = 1E-12
//*** stress effect related parameter ***
+saref = 6.1E-7                sbref = 6.1E-7                wlod = 1.37E-7
+ku0 = -2.471E-8               kvsat = 0.3                   kvth0 = 2.1E-9
+tku0 = 0.097                  llodku0 = 1                   wlodku0 = 1
+llodvth = 1                   wlodvth = 1                   lku0 = 1.23E-8
+wku0 = 9.96E-8                pku0 = 4.6E-14                lkvth0 = -2.421E-11
+wkvth0 = 0                    pkvth0 = 0                    stk2 = 3.87E-10
+lodk2 = 0.5                   steta0 = 0                    lodeta0 = 1
//*** temperature coefficient ***
+tnom = 25                     ute = -0.9                    kt1 = -0.235274
+kt1l = 0                      kt2 = -0.036                  ua1 = 8.32E-10
+ub1 = 0                       uc1 = 4.355E-11               at = 7E4
+prt = 0                       njs = 1                       njd = 1
+xtis = 3                      xtid = 3                      tpb = 1.1E-3
+tpbsw = 1.9E-3                tpbswg = 1E-3                 tcj = 6.52E-4
+tcjsw = 3.57E-4               tcjswg = 1.5E-3               tvoff = 2.2428E-3
+tvfbsdoff = 0.022
//*** well proximity effect model parameters ***
+web = 0                       wec = 0                       kvth0we = 2.1E-3
+k2we = 0                      ku0we = -4.21E-3              scref = 1E-6
12:type=n  minr=1e-60
//*** flag parameter ***
+version = 4.3                 binunit = 2                   mobmod = 0
+capmod = 2                    rdsmod = 0                    igcmod = 1
+igbmod = 1                    rbodymod = 0                  trnqsmod = 0
+acnqsmod = 0                  fnoimod = 1                   tnoimod = 0
+diomod = 1                    tempmod = 0                   permod = 1
+rgatemod = 0                  wpemod = 1
//*** geometry range parameter ***
+lmin = 1.5E-7                 lmax = 1E-6                   wmin = 3.2E-7
+wmax = 5E-7
//*** process parameter ***
+epsrox = 3.9                  toxe = tox_n_18_cap               toxm = tox_n_18_cap
+dtox = 3.2E-10                xj = 8.1E-8                   ndep = 1E17
+ngate = 1.6E20                nsd = 1E20                    rsh = 17.5
+rshg = 15.5
//*** dw and dl parameter ***
+wint = 2E-9                   wl = 0                        wln = 1
+ww = 0                        wwn = 1                       wwl = 0
+lint = 1E-9                   ll = 0                        lln = 1
+lw = 0                        lwn = 1                       lwl = 0
+llc = 0                       lwc = 0                       lwlc = 0
+wlc = 0                       wwc = 0                       wwlc = 0
+dwg = 0                       dwb = 0                       xl = 0+dxl_n_18_cap
+xw = 0+dxw_n_18_cap
//*** flicker noise model parameter ***
+noia = 3.1E42                 noib = 1.81E21                noic = 3E8
+em = 1E6                      ef = 0.86                     lintnoi = -5E-9
//***layout-dependent parasitics model parameter ***
+dmcg = 4E-8                   dmci = 4E-8                   dmdg = 0
+dmcgt = 0                     dwj = 0                       xgw = 0
+xgl = 0                       ngcon = 1
//*** vth related  parameter ***
+vth0 = 0.4207+dvth0_n_18_cap      lvth0 = 0+dlvth0_n_18_cap         wvth0 = 0+dwvth0_n_18_cap
+pvth0 = 0+dpvth0_n_18_cap         phin = 0                      k1 = 0.30264
+k2 = -0.012135                k3 = -5.68454                 k3b = 2.454986
+w0 = 8.190018E-8              lpe0 = 6.610138E-8            lpeb = 2.000404E-8
+dvtp0 = 2.36094E-6            dvtp1 = 4.5                   dvt0 = 0.236381
+dvt1 = 0.537442               dvt2 = 5.56679E-2             dvt0w = 0
+dvt1w = 0                     dvt2w = 0                     vfbsdoff = 0.02
//*** mobility related parameter ***
+u0 = 2.98009E-2+du0_n_18_cap      lu0 = 0+dlu0_n_18_cap             wu0 = 0+dwu0_n_18_cap
+pu0 = 0+dpu0_n_18_cap             ua = -9.49994E-10             ub = 2.091579E-18
+uc = 7.758295E-11             ud = 0                        vsat = 1.151071E5+dvsat_n_18_cap
+wvsat = -2.500026E-3          a0 = 1.08155                  ags = 1.051677
+wags = -5.000053E-8           b0 = 0                        b1 = 0
+keta = -5.19382E-2            a1 = 0                        a2 = 1
+rdsw = 100.002354             prwb = 0                      prwg = 0
+wr = 1
//*** subthreshold related parameter ***
+voff = -0.155578              voffl = -3.595178E-9          minv = -0.15
+nfactor = 1.621754            eta0 = 1.804707E-3            etab = -1.26845E-2
+dsub = 0.422235               cit = 7.212E-4                cdsc = 0
+cdscb = 0                     cdscd = 0
//*** output resistance related parameter ***
+pclm = 1.239489               pdiblc1 = 4.53031E-4          pdiblc2 = 7.801573E-3
+pdiblcb = 1                   drout = 0.56                  pscbe1 = 1E9
+pscbe2 = 1E-20                pvag = 0.9                    delta = 7.595625E-3
+fprout = 300                  pdits = 0                     pditsl = 0
+pditsd = 0                    alpha0 = 2E-10                alpha1 = 0.01
+beta0 = 6.4                   agidl = 1.1505E-7             bgidl = 2.692E9
+cgidl = 0.24                  egidl = 0.24
//*** gate dielectric tunneling current ***
+aigbacc = 0.0211              bigbacc = 2.44E-3             cigbacc = 0.312
+nigbacc = 6                   aigbinv = 0.017               bigbinv = 4.3E-3
+cigbinv = 5.7E-3              eigbinv = 1.04                nigbinv = 6
+aigc = 0.012                  bigc = 1.41E-3                cigc = 5.72E-4
+aigsd = 0.0116                bigsd = 1.3E-3                cigsd = 0.073
+dlcig = 2.43E-9               nigc = 2.97                   poxedge = 1
+pigcd = 2.4                   ntox = 1                      toxref = 3E-9
//*** capacitance parameter ***
+xpart = 1                     cgso = 3.13E-11+dcgso_n_18_cap    cgdo = 3.13E-11+dcgdo_n_18_cap
+cgbo = 0                      ckappas = 0.6                 ckappad = 0.6
+cf = 6.13E-11                 clc = 1.04E-7                 cle = 0.6
+dlc = 0                 dwc = 0                       noff = 1.6
+voffcv = -0.097               acde = 1                      moin = 5.67
+cgsl = 2.71E-11+dcgsl_n_18_cap    cgdl = 2.71E-11+dcgdl_n_18_cap
//*** souce/drain junction diode model parameter **
+ijthsrev = 0.01               ijthsfwd = 0.01               xjbvs = 1
+bvs = 10                      jss = 4.14E-7                 jsws = 9.7E-13
+jswgs = 1.4E-12               cjs = 8.41E-4+dcj_n_18_cap        mjs = 0.31
+mjsws = 0.081                 cjsws = 1.02E-10+dcjsw_n_18_cap   cjswgs = 1.2E-10+dcjswg_n_18_cap
+mjswgs = 0.511                pbs = 0.511                   pbsws = 0.786
+pbswgs = 0.7
//** rf model related parameter ***
+xrcrg1 = 12                   xrcrg2 = 1                    rbpb = 50
+rbpd = 50                     rbps = 50                     rbdb = 50
+rbsb = 50                     gbmin = 1E-12
//*** stress effect related parameter ***
+saref = 6.1E-7                sbref = 6.1E-7                wlod = 1.37E-7
+ku0 = -2.471E-8               kvsat = 0.3                   kvth0 = 2.1E-9
+tku0 = 0.097                  llodku0 = 1                   wlodku0 = 1
+llodvth = 1                   wlodvth = 1                   lku0 = 1.23E-8
+wku0 = 9.96E-8                pku0 = 4.6E-14                lkvth0 = -2.421E-11
+wkvth0 = 0                    pkvth0 = 0                    stk2 = 3.87E-10
+lodk2 = 0.5                   steta0 = 0                    lodeta0 = 1
//*** temperature coefficient ***
+tnom = 25                     ute = -0.9                    kt1 = -0.235274
+kt1l = 0                      kt2 = -0.036                  ua1 = 8.32E-10
+ub1 = 0                       uc1 = 4.355E-11               at = 7E4
+prt = 0                       njs = 1                       njd = 1
+xtis = 3                      xtid = 3                      tpb = 1.1E-3
+tpbsw = 1.9E-3                tpbswg = 1E-3                 tcj = 6.52E-4
+tcjsw = 3.57E-4               tcjswg = 1.5E-3               tvoff = 2.2428E-3
+tvfbsdoff = 0.022
//*** well proximity effect model parameters ***
+web = 0                       wec = 0                       kvth0we = 2.1E-3
+k2we = 0                      ku0we = -4.21E-3              scref = 1E-6
13:type=n  minr=1e-60
//*** flag parameter ***
+version = 4.3                 binunit = 2                   mobmod = 0
+capmod = 2                    rdsmod = 0                    igcmod = 1
+igbmod = 1                    rbodymod = 0                  trnqsmod = 0
+acnqsmod = 0                  fnoimod = 1                   tnoimod = 0
+diomod = 1                    tempmod = 0                   permod = 1
+rgatemod = 0                  wpemod = 1
//*** geometry range parameter ***
+lmin = 1E-5                   lmax = 9E-4                   wmin = 3.2E-7
+wmax = 5E-7
//*** process parameter ***
+epsrox = 3.9                  toxe = tox_n_18_cap               toxm = tox_n_18_cap
+dtox = 3.2E-10                xj = 8.1E-8                   ndep = 1E17
+ngate = 1.6E20                nsd = 1E20                    rsh = 17.5
+rshg = 15.5
//*** dw and dl parameter ***
+wint = 2E-9                   wl = 0                        wln = 1
+ww = 0                        wwn = 1                       wwl = 0
+lint = 1E-9                   ll = 0                        lln = 1
+lw = 0                        lwn = 1                       lwl = 0
+lwc = 0                       lwlc = 0                      wwc = 0
+wwlc = 0                      dwg = 0                       dwb = 0
+xl = 0.0+dxl_n_18_cap             xw = 0.0+dxw_n_18_cap
//*** flicker noise model parameter ***
+noia = 3.1E42                 noib = 1.81E21                noic = 3E8
+em = 1E6                      ef = 0.86                     lintnoi = -5E-9
//***layout-dependent parasitics model parameter ***
+dmcg = 4E-8                   dmci = 4E-8                   dmdg = 0
+dmcgt = 0                     dwj = 0                       xgw = 0
+xgl = 0                       ngcon = 1
//*** vth related  parameter ***
+vth0 = 0.4207+dvth0_n_18_cap      lvth0 = 0.0+dlvth0_n_18_cap       wvth0 = 0.0+dwvth0_n_18_cap
+pvth0 = 0.0+dpvth0_n_18_cap       phin = 0                      k1 = 0.30264
+k2 = -0.012135                k3 = -5.68454                 k3b = 2.454986
+w0 = 8.190018E-8              lpe0 = 6.610138E-8            lpeb = 2.000404E-8
+dvtp0 = 2.36094E-6            dvtp1 = 4.5                   dvt0 = 0.236381
+dvt1 = 0.537442               dvt2 = 5.56679E-2             dvt0w = 0
+dvt1w = 0                     dvt2w = 0                     vfbsdoff = 0.02
//*** mobility related parameter ***
+u0 = 0.0298009+du0_n_18_cap       lu0 = 0.0+dlu0_n_18_cap           wu0 = 0.0+dwu0_n_18_cap
+pu0 = 0.0+dpu0_n_18_cap           ua = -9.49994E-10             ub = 2.091579E-18
+uc = 7.758295E-11             ud = 0                        vsat = ( 115107.0+dvsat_n_18_cap)  + 0.15
+wvsat = -2.500042E-3          a0 = 1.08155                  ags = 1.051675
+wags = -4.999997E-8           b0 = 0                        b1 = 0
+keta = -5.19382E-2            a1 = 0                        a2 = 1
+rdsw = 100.002354             prwb = 0                      prwg = 0
+wr = 1
//*** subthreshold related parameter ***
+voff = -0.155578              voffl = -3.595178E-9          minv = -0.15
+nfactor = 1.621754            eta0 = 1.804707E-3            etab = -1.26845E-2
+dsub = 0.422235               cit = 7.212E-4                cdsc = 0
+cdscb = 0                     cdscd = 0
//*** output resistance related parameter ***
+pclm = 1.239489               pdiblc1 = 4.53031E-4          pdiblc2 = 7.801573E-3
+pdiblcb = 1                   drout = 0.56                  pscbe1 = 1E9
+pscbe2 = 1E-20                pvag = 0.9                    delta = 7.595625E-3
+fprout = 300                  pdits = 0                     pditsl = 0
+pditsd = 0                    lc = 0                        alpha0 = 2E-10
+alpha1 = 0.01                 beta0 = 6.4                   agidl = 1.1505E-7
+bgidl = 2.692E9               cgidl = 0.24                  egidl = 0.24
//*** gate dielectric tunneling current ***
+aigbacc = 0.0211              bigbacc = 2.44E-3             cigbacc = 0.312
+nigbacc = 6                   aigbinv = 0.017               bigbinv = 4.3E-3
+cigbinv = 5.7E-3              eigbinv = 1.04                nigbinv = 6
+aigc = 0.012                  bigc = 1.41E-3                cigc = 5.72E-4
+aigsd = 0.0116                bigsd = 1.3E-3                cigsd = 0.073
+dlcig = 2.43E-9               nigc = 2.97                   poxedge = 1
+pigcd = 2.4                   ntox = 1                      toxref = 3E-9
//*** capacitance parameter ***
+xpart = 1                     cgso = 3.13E-11+dcgso_n_18_cap    cgdo = 3.13E-11+dcgdo_n_18_cap
+cgbo = 0                      ckappas = 0.6                 ckappad = 0.6
+cf = 6.13E-11                 clc = 1.04E-7                 cle = 0.6
+dlc = 0                 dwc = 0                       noff = 1.6
+voffcv = -0.097               acde = 1                      moin = 5.67
+cgsl = 2.71E-11+dcgsl_n_18_cap    cgdl = 2.71E-11+dcgdl_n_18_cap
//*** souce/drain junction diode model parameter **
+ijthsrev = 0.01               ijthsfwd = 0.01               xjbvs = 1
+bvs = 10                      jss = 4.14E-7                 jsws = 9.7E-13
+jswgs = 1.4E-12               cjs = 8.41E-4+dcj_n_18_cap        mjs = 0.31
+mjsws = 0.081                 cjsws = 1.02E-10+dcjsw_n_18_cap   cjswgs = 1.2E-10+dcjswg_n_18_cap
+mjswgs = 0.511                pbs = 0.511                   pbsws = 0.786
+pbswgs = 0.7
//** rf model related parameter ***
+xrcrg1 = 12                   xrcrg2 = 1                    rbpb = 50
+rbpd = 50                     rbps = 50                     rbdb = 50
+rbsb = 50                     gbmin = 1E-12
//*** stress effect related parameter ***
+saref = 6.1E-7                sbref = 6.1E-7                wlod = 1.37E-7
+ku0 = -2.471E-8               kvsat = 0.3                   kvth0 = 2.1E-9
+tku0 = 0.097                  llodku0 = 1                   wlodku0 = 1
+llodvth = 1                   wlodvth = 1                   lku0 = 1.23E-8
+wku0 = 9.96E-8                pku0 = 4.6E-14                lkvth0 = -2.421E-11
+wkvth0 = 0                    pkvth0 = 0                    stk2 = 3.87E-10
+lodk2 = 0.5                   steta0 = 0                    lodeta0 = 1
//*** temperature coefficient ***
+tnom = 25                     ute = -0.9                    kt1 = -0.235274
+kt1l = 0                      kt2 = -0.036                  ua1 = 8.32E-10
+ub1 = 0                       uc1 = 4.355E-11               at = 7E4
+prt = 0                       njs = 1                       njd = 1
+xtis = 3                      xtid = 3                      tpb = 1.1E-3
+tpbsw = 1.9E-3                tpbswg = 1E-3                 tcj = 6.52E-4
+tcjsw = 3.57E-4               tcjswg = 1.5E-3               tvoff = 2.2428E-3
+tvfbsdoff = 0.022
//*** well proximity effect model parameters ***
+web = 0                       wec = 0                       kvth0we = 2.1E-3
+k2we = 0                      ku0we = -4.21E-3              scref = 1E-6
14:type=n  minr=1e-60
//*** flag parameter ***
+version = 4.3                 binunit = 2                   mobmod = 0
+capmod = 2                    rdsmod = 0                    igcmod = 1
+igbmod = 1                    rbodymod = 0                  trnqsmod = 0
+acnqsmod = 0                  fnoimod = 1                   tnoimod = 0
+diomod = 1                    tempmod = 0                   permod = 1
+rgatemod = 0                  wpemod = 1
//*** geometry range parameter ***
+lmin = 1E-5                   lmax = 9E-4                   wmin = 5E-7
+wmax = 1E-6
//*** process parameter ***
+epsrox = 3.9                  toxe = tox_n_18_cap               toxm = tox_n_18_cap
+dtox = 3.2E-10                xj = 8.1E-8                   ndep = 1E17
+ngate = 1.6E20                nsd = 1E20                    rsh = 17.5
+rshg = 15.5
//*** dw and dl parameter ***
+wint = 2E-9                   wl = 0                        wln = 1
+ww = 0                        wwn = 1                       wwl = 0
+lint = 1E-9                   ll = 0                        lln = 1
+lw = 0                        lwn = 1                       lwl = 0
+lwc = 0                       lwlc = 0                      wwc = 0
+wwlc = 0                      dwg = 0                       dwb = 0
+xl = 0.0+dxl_n_18_cap             xw = 0.0+dxw_n_18_cap
//*** flicker noise model parameter ***
+noia = 3.1E42                 noib = 1.81E21                noic = 3E8
+em = 1E6                      ef = 0.86                     lintnoi = -5E-9
//***layout-dependent parasitics model parameter ***
+dmcg = 4E-8                   dmci = 4E-8                   dmdg = 0
+dmcgt = 0                     dwj = 0                       xgw = 0
+xgl = 0                       ngcon = 1
//*** vth related  parameter ***
+vth0 = 0.4207+dvth0_n_18_cap      lvth0 = 0.0+dlvth0_n_18_cap       wvth0 = 0.0+dwvth0_n_18_cap
+pvth0 = 0.0+dpvth0_n_18_cap       phin = 0                      k1 = 0.30264
+k2 = -0.012135                k3 = -5.68454                 k3b = 2.454986
+w0 = 8.190018E-8              lpe0 = 6.610138E-8            lpeb = 2.000404E-8
+dvtp0 = 2.36094E-6            dvtp1 = 4.5                   dvt0 = 0.236381
+dvt1 = 0.537442               dvt2 = 5.56679E-2             dvt0w = 0
+dvt1w = 0                     dvt2w = 0                     vfbsdoff = 0.02
//*** mobility related parameter ***
+u0 = 0.0298009+du0_n_18_cap       lu0 = 0.0+dlu0_n_18_cap           wu0 = 0.0+dwu0_n_18_cap
+pu0 = 0.0+dpu0_n_18_cap           ua = -9.49994E-10             ub = 2.091579E-18
+uc = 7.758295E-11             ud = 0                        vsat = ( 115107.0+dvsat_n_18_cap)  + 0.0748
+wvsat = -2.500005E-3          a0 = 1.08155                  ags = 1.051674
+wags = -4.999913E-8           b0 = 0                        b1 = 0
+keta = -5.19382E-2            a1 = 0                        a2 = 1
+rdsw = 100.002354             prwb = 0                      prwg = 0
+wr = 1
//*** subthreshold related parameter ***
+voff = -0.155578              voffl = -3.595178E-9          minv = -0.15
+nfactor = 1.621754            eta0 = 1.804707E-3            etab = -1.26845E-2
+dsub = 0.422235               cit = 7.212E-4                cdsc = 0
+cdscb = 0                     cdscd = 0
//*** output resistance related parameter ***
+pclm = 1.239489               pdiblc1 = 4.53031E-4          pdiblc2 = 7.801573E-3
+pdiblcb = 1                   drout = 0.56                  pscbe1 = 1E9
+pscbe2 = 1E-20                pvag = 0.9                    delta = 7.595625E-3
+fprout = 300                  pdits = 0                     pditsl = 0
+pditsd = 0                    lc = 0                        alpha0 = 2E-10
+alpha1 = 0.01                 beta0 = 6.4                   agidl = 1.1505E-7
+bgidl = 2.692E9               cgidl = 0.24                  egidl = 0.24
//*** gate dielectric tunneling current ***
+aigbacc = 0.0211              bigbacc = 2.44E-3             cigbacc = 0.312
+nigbacc = 6                   aigbinv = 0.017               bigbinv = 4.3E-3
+cigbinv = 5.7E-3              eigbinv = 1.04                nigbinv = 6
+aigc = 0.012                  bigc = 1.41E-3                cigc = 5.72E-4
+aigsd = 0.0116                bigsd = 1.3E-3                cigsd = 0.073
+dlcig = 2.43E-9               nigc = 2.97                   poxedge = 1
+pigcd = 2.4                   ntox = 1                      toxref = 3E-9
//*** capacitance parameter ***
+xpart = 1                     cgso = 3.13E-11+dcgso_n_18_cap    cgdo = 3.13E-11+dcgdo_n_18_cap
+cgbo = 0                      ckappas = 0.6                 ckappad = 0.6
+cf = 6.13E-11                 clc = 1.04E-7                 cle = 0.6
+dlc = 0                 dwc = 0                       noff = 1.6
+voffcv = -0.097               acde = 1                      moin = 5.67
+cgsl = 2.71E-11+dcgsl_n_18_cap    cgdl = 2.71E-11+dcgdl_n_18_cap
//*** souce/drain junction diode model parameter **
+ijthsrev = 0.01               ijthsfwd = 0.01               xjbvs = 1
+bvs = 10                      jss = 4.14E-7                 jsws = 9.7E-13
+jswgs = 1.4E-12               cjs = 8.41E-4+dcj_n_18_cap        mjs = 0.31
+mjsws = 0.081                 cjsws = 1.02E-10+dcjsw_n_18_cap   cjswgs = 1.2E-10+dcjswg_n_18_cap
+mjswgs = 0.511                pbs = 0.511                   pbsws = 0.786
+pbswgs = 0.7
//** rf model related parameter ***
+xrcrg1 = 12                   xrcrg2 = 1                    rbpb = 50
+rbpd = 50                     rbps = 50                     rbdb = 50
+rbsb = 50                     gbmin = 1E-12
//*** stress effect related parameter ***
+saref = 6.1E-7                sbref = 6.1E-7                wlod = 1.37E-7
+ku0 = -2.471E-8               kvsat = 0.3                   kvth0 = 2.1E-9
+tku0 = 0.097                  llodku0 = 1                   wlodku0 = 1
+llodvth = 1                   wlodvth = 1                   lku0 = 1.23E-8
+wku0 = 9.96E-8                pku0 = 4.6E-14                lkvth0 = -2.421E-11
+wkvth0 = 0                    pkvth0 = 0                    stk2 = 3.87E-10
+lodk2 = 0.5                   steta0 = 0                    lodeta0 = 1
//*** temperature coefficient ***
+tnom = 25                     ute = -0.9                    kt1 = -0.235274
+kt1l = 0                      kt2 = -0.036                  ua1 = 8.32E-10
+ub1 = 0                       uc1 = 4.355E-11               at = 7E4
+prt = 0                       njs = 1                       njd = 1
+xtis = 3                      xtid = 3                      tpb = 1.1E-3
+tpbsw = 1.9E-3                tpbswg = 1E-3                 tcj = 6.52E-4
+tcjsw = 3.57E-4               tcjswg = 1.5E-3               tvoff = 2.2428E-3
+tvfbsdoff = 0.022
//*** well proximity effect model parameters ***
+web = 0                       wec = 0                       kvth0we = 2.1E-3
+k2we = 0                      ku0we = -4.21E-3              scref = 1E-6
15:type=n  minr=1e-60
//*** flag parameter ***
+version = 4.3                 binunit = 2                   mobmod = 0
+capmod = 2                    rdsmod = 0                    igcmod = 1
+igbmod = 1                    rbodymod = 0                  trnqsmod = 0
+acnqsmod = 0                  fnoimod = 1                   tnoimod = 0
+diomod = 1                    tempmod = 0                   permod = 1
+rgatemod = 0                  wpemod = 1
//*** geometry range parameter ***
+lmin = 1E-5                   lmax = 9E-4                   wmin = 1E-6
+wmax = 2E-6
//*** process parameter ***
+epsrox = 3.9                  toxe = tox_n_18_cap               toxm = tox_n_18_cap
+dtox = 3.2E-10                xj = 8.1E-8                   ndep = 1E17
+ngate = 1.6E20                nsd = 1E20                    rsh = 17.5
+rshg = 15.5
//*** dw and dl parameter ***
+wint = 2E-9                   wl = 0                        wln = 1
+ww = 0                        wwn = 1                       wwl = 0
+lint = 1E-9                   ll = 0                        lln = 1
+lw = 0                        lwn = 1                       lwl = 0
+lwc = 0                       lwlc = 0                      wwc = 0
+wwlc = 0                      dwg = 0                       dwb = 0
+xl = 0.0+dxl_n_18_cap             xw = 0.0+dxw_n_18_cap
//*** flicker noise model parameter ***
+noia = 3.1E42                 noib = 1.81E21                noic = 3E8
+em = 1E6                      ef = 0.86                     lintnoi = -5E-9
//***layout-dependent parasitics model parameter ***
+dmcg = 4E-8                   dmci = 4E-8                   dmdg = 0
+dmcgt = 0                     dwj = 0                       xgw = 0
+xgl = 0                       ngcon = 1
//*** vth related  parameter ***
+vth0 = 0.4207+dvth0_n_18_cap      lvth0 = 0.0+dlvth0_n_18_cap       wvth0 = 0.0+dwvth0_n_18_cap
+pvth0 = 0.0+dpvth0_n_18_cap       phin = 0                      k1 = 0.30264
+k2 = -0.012135                k3 = -5.68454                 k3b = 2.454986
+w0 = 8.190018E-8              lpe0 = 6.610138E-8            lpeb = 2.000404E-8
+dvtp0 = 2.36094E-6            dvtp1 = 4.5                   dvt0 = 0.236381
+dvt1 = 0.537442               dvt2 = 5.56679E-2             dvt0w = 0
+dvt1w = 0                     dvt2w = 0                     vfbsdoff = 0.02
//*** mobility related parameter ***
+u0 = 0.0298009+du0_n_18_cap       lu0 = 0.0+dlu0_n_18_cap           wu0 = 0.0+dwu0_n_18_cap
+pu0 = 0.0+dpu0_n_18_cap           ua = -9.49994E-10             ub = 2.091579E-18
+uc = 7.758295E-11             ud = 0                        vsat = ( 115107.0+dvsat_n_18_cap)  -0.058
+wvsat = -2.499872E-3          a0 = 1.08155                  ags = 1.051676
+wags = -5.000143E-8           b0 = 0                        b1 = 0
+keta = -5.19382E-2            a1 = 0                        a2 = 1
+rdsw = 100.002354             prwb = 0                      prwg = 0
+wr = 1
//*** subthreshold related parameter ***
+voff = -0.155578              voffl = -3.595178E-9          minv = -0.15
+nfactor = 1.621754            eta0 = 1.804707E-3            etab = -1.26845E-2
+dsub = 0.422235               cit = 7.212E-4                cdsc = 0
+cdscb = 0                     cdscd = 0
//*** output resistance related parameter ***
+pclm = 1.239489               pdiblc1 = 4.53031E-4          pdiblc2 = 7.801573E-3
+pdiblcb = 1                   drout = 0.56                  pscbe1 = 1E9
+pscbe2 = 1E-20                pvag = 0.9                    delta = 7.595625E-3
+fprout = 300                  pdits = 0                     pditsl = 0
+pditsd = 0                    lc = 0                        alpha0 = 2E-10
+alpha1 = 0.01                 beta0 = 6.4                   agidl = 1.1505E-7
+bgidl = 2.692E9               cgidl = 0.24                  egidl = 0.24
//*** gate dielectric tunneling current ***
+aigbacc = 0.0211              bigbacc = 2.44E-3             cigbacc = 0.312
+nigbacc = 6                   aigbinv = 0.017               bigbinv = 4.3E-3
+cigbinv = 5.7E-3              eigbinv = 1.04                nigbinv = 6
+aigc = 0.012                  bigc = 1.41E-3                cigc = 5.72E-4
+aigsd = 0.0116                bigsd = 1.3E-3                cigsd = 0.073
+dlcig = 2.43E-9               nigc = 2.97                   poxedge = 1
+pigcd = 2.4                   ntox = 1                      toxref = 3E-9
//*** capacitance parameter ***
+xpart = 1                     cgso = 3.13E-11+dcgso_n_18_cap    cgdo = 3.13E-11+dcgdo_n_18_cap
+cgbo = 0                      ckappas = 0.6                 ckappad = 0.6
+cf = 6.13E-11                 clc = 1.04E-7                 cle = 0.6
+dlc = 0                 dwc = 0                       noff = 1.6
+voffcv = -0.097               acde = 1                      moin = 5.67
+cgsl = 2.71E-11+dcgsl_n_18_cap    cgdl = 2.71E-11+dcgdl_n_18_cap
//*** souce/drain junction diode model parameter **
+ijthsrev = 0.01               ijthsfwd = 0.01               xjbvs = 1
+bvs = 10                      jss = 4.14E-7                 jsws = 9.7E-13
+jswgs = 1.4E-12               cjs = 8.41E-4+dcj_n_18_cap        mjs = 0.31
+mjsws = 0.081                 cjsws = 1.02E-10+dcjsw_n_18_cap   cjswgs = 1.2E-10+dcjswg_n_18_cap
+mjswgs = 0.511                pbs = 0.511                   pbsws = 0.786
+pbswgs = 0.7
//** rf model related parameter ***
+xrcrg1 = 12                   xrcrg2 = 1                    rbpb = 50
+rbpd = 50                     rbps = 50                     rbdb = 50
+rbsb = 50                     gbmin = 1E-12
//*** stress effect related parameter ***
+saref = 6.1E-7                sbref = 6.1E-7                wlod = 1.37E-7
+ku0 = -2.471E-8               kvsat = 0.3                   kvth0 = 2.1E-9
+tku0 = 0.097                  llodku0 = 1                   wlodku0 = 1
+llodvth = 1                   wlodvth = 1                   lku0 = 1.23E-8
+wku0 = 9.96E-8                pku0 = 4.6E-14                lkvth0 = -2.421E-11
+wkvth0 = 0                    pkvth0 = 0                    stk2 = 3.87E-10
+lodk2 = 0.5                   steta0 = 0                    lodeta0 = 1
//*** temperature coefficient ***
+tnom = 25                     ute = -0.9                    kt1 = -0.235274
+kt1l = 0                      kt2 = -0.036                  ua1 = 8.32E-10
+ub1 = 0                       uc1 = 4.355E-11               at = 7E4
+prt = 0                       njs = 1                       njd = 1
+xtis = 3                      xtid = 3                      tpb = 1.1E-3
+tpbsw = 1.9E-3                tpbswg = 1E-3                 tcj = 6.52E-4
+tcjsw = 3.57E-4               tcjswg = 1.5E-3               tvoff = 2.2428E-3
+tvfbsdoff = 0.022
//*** well proximity effect model parameters ***
+web = 0                       wec = 0                       kvth0we = 2.1E-3
+k2we = 0                      ku0we = -4.21E-3              scref = 1E-6
16:type=n  minr=1e-60
//*** flag parameter ***
+version = 4.3                 binunit = 2                   mobmod = 0
+capmod = 2                    rdsmod = 0                    igcmod = 1
+igbmod = 1                    rbodymod = 0                  trnqsmod = 0
+acnqsmod = 0                  fnoimod = 1                   tnoimod = 0
+diomod = 1                    tempmod = 0                   permod = 1
+rgatemod = 0                  wpemod = 1
//*** geometry range parameter ***
+lmin = 1E-5                   lmax = 9E-4                   wmin = 2E-6
+wmax = 1E-5
//*** process parameter ***
+epsrox = 3.9                  toxe = tox_n_18_cap               toxm = tox_n_18_cap
+dtox = 3.2E-10                xj = 8.1E-8                   ndep = 1E17
+ngate = 1.6E20                nsd = 1E20                    rsh = 17.5
+rshg = 15.5
//*** dw and dl parameter ***
+wint = 2E-9                   wl = 0                        wln = 1
+ww = 0                        wwn = 1                       wwl = 0
+lint = 1E-9                   ll = 0                        lln = 1
+lw = 0                        lwn = 1                       lwl = 0
+lwc = 0                       lwlc = 0                      wwc = 0
+wwlc = 0                      dwg = 0                       dwb = 0
+xl = 0.0+dxl_n_18_cap             xw = 0.0+dxw_n_18_cap
//*** flicker noise model parameter ***
+noia = 3.1E42                 noib = 1.81E21                noic = 3E8
+em = 1E6                      ef = 0.86                     lintnoi = -5E-9
//***layout-dependent parasitics model parameter ***
+dmcg = 4E-8                   dmci = 4E-8                   dmdg = 0
+dmcgt = 0                     dwj = 0                       xgw = 0
+xgl = 0                       ngcon = 1
//*** vth related  parameter ***
+vth0 = 0.4207+dvth0_n_18_cap      lvth0 = 0.0+dlvth0_n_18_cap       wvth0 = 0.0+dwvth0_n_18_cap
+pvth0 = 0.0+dpvth0_n_18_cap       phin = 0                      k1 = 0.30264
+k2 = -0.012135                k3 = -5.68454                 k3b = 2.454986
+w0 = 8.190018E-8              lpe0 = 6.610138E-8            lpeb = 2.000404E-8
+dvtp0 = 2.36094E-6            dvtp1 = 4.5                   dvt0 = 0.236381
+dvt1 = 0.537442               dvt2 = 5.56679E-2             dvt0w = 0
+dvt1w = 0                     dvt2w = 0                     vfbsdoff = 0.02
//*** mobility related parameter ***
+u0 = 0.0298009+du0_n_18_cap       lu0 = 0.0+dlu0_n_18_cap           wu0 = 0.0+dwu0_n_18_cap
+pu0 = 0.0+dpu0_n_18_cap           ua = -9.49994E-10             ub = 2.091579E-18
+uc = 7.758295E-11             ud = 0                        vsat = 115107.0+dvsat_n_18_cap
+wvsat = -2.499988E-3          a0 = 1.08155                  ags = 1.051675
+wags = -4.999975E-8           b0 = 0                        b1 = 0
+keta = -5.19382E-2            a1 = 0                        a2 = 1
+rdsw = 100.002354             prwb = 0                      prwg = 0
+wr = 1
//*** subthreshold related parameter ***
+voff = -0.155578              voffl = -3.595178E-9          minv = -0.15
+nfactor = 1.621754            eta0 = 1.804707E-3            etab = -1.26845E-2
+dsub = 0.422235               cit = 7.212E-4                cdsc = 0
+cdscb = 0                     cdscd = 0
//*** output resistance related parameter ***
+pclm = 1.239489               pdiblc1 = 4.53031E-4          pdiblc2 = 7.801573E-3
+pdiblcb = 1                   drout = 0.56                  pscbe1 = 1E9
+pscbe2 = 1E-20                pvag = 0.9                    delta = 7.595625E-3
+fprout = 300                  pdits = 0                     pditsl = 0
+pditsd = 0                    lc = 0                        alpha0 = 2E-10
+alpha1 = 0.01                 beta0 = 6.4                   agidl = 1.1505E-7
+bgidl = 2.692E9               cgidl = 0.24                  egidl = 0.24
//*** gate dielectric tunneling current ***
+aigbacc = 0.0211              bigbacc = 2.44E-3             cigbacc = 0.312
+nigbacc = 6                   aigbinv = 0.017               bigbinv = 4.3E-3
+cigbinv = 5.7E-3              eigbinv = 1.04                nigbinv = 6
+aigc = 0.012                  bigc = 1.41E-3                cigc = 5.72E-4
+aigsd = 0.0116                bigsd = 1.3E-3                cigsd = 0.073
+dlcig = 2.43E-9               nigc = 2.97                   poxedge = 1
+pigcd = 2.4                   ntox = 1                      toxref = 3E-9
//*** capacitance parameter ***
+xpart = 1                     cgso = 3.13E-11+dcgso_n_18_cap    cgdo = 3.13E-11+dcgdo_n_18_cap
+cgbo = 0                      ckappas = 0.6                 ckappad = 0.6
+cf = 6.13E-11                 clc = 1.04E-7                 cle = 0.6
+dlc = 0                 dwc = 0                       noff = 1.6
+voffcv = -0.097               acde = 1                      moin = 5.67
+cgsl = 2.71E-11+dcgsl_n_18_cap    cgdl = 2.71E-11+dcgdl_n_18_cap
//*** souce/drain junction diode model parameter **
+ijthsrev = 0.01               ijthsfwd = 0.01               xjbvs = 1
+bvs = 10                      jss = 4.14E-7                 jsws = 9.7E-13
+jswgs = 1.4E-12               cjs = 8.41E-4+dcj_n_18_cap        mjs = 0.31
+mjsws = 0.081                 cjsws = 1.02E-10+dcjsw_n_18_cap   cjswgs = 1.2E-10+dcjswg_n_18_cap
+mjswgs = 0.511                pbs = 0.511                   pbsws = 0.786
+pbswgs = 0.7
//** rf model related parameter ***
+xrcrg1 = 12                   xrcrg2 = 1                    rbpb = 50
+rbpd = 50                     rbps = 50                     rbdb = 50
+rbsb = 50                     gbmin = 1E-12
//*** stress effect related parameter ***
+saref = 6.1E-7                sbref = 6.1E-7                wlod = 1.37E-7
+ku0 = -2.471E-8               kvsat = 0.3                   kvth0 = 2.1E-9
+tku0 = 0.097                  llodku0 = 1                   wlodku0 = 1
+llodvth = 1                   wlodvth = 1                   lku0 = 1.23E-8
+wku0 = 9.96E-8                pku0 = 4.6E-14                lkvth0 = -2.421E-11
+wkvth0 = 0                    pkvth0 = 0                    stk2 = 3.87E-10
+lodk2 = 0.5                   steta0 = 0                    lodeta0 = 1
//*** temperature coefficient ***
+tnom = 25                     ute = -0.9                    kt1 = -0.235274
+kt1l = 0                      kt2 = -0.036                  ua1 = 8.32E-10
+ub1 = 0                       uc1 = 4.355E-11               at = 7E4
+prt = 0                       njs = 1                       njd = 1
+xtis = 3                      xtid = 3                      tpb = 1.1E-3
+tpbsw = 1.9E-3                tpbswg = 1E-3                 tcj = 6.52E-4
+tcjsw = 3.57E-4               tcjswg = 1.5E-3               tvoff = 2.2428E-3
+tvfbsdoff = 0.022
//*** well proximity effect model parameters ***
+web = 0                       wec = 0                       kvth0we = 2.1E-3
+k2we = 0                      ku0we = -4.21E-3              scref = 1E-6
17:type=n  minr=1e-60
//*** flag parameter ***
+version = 4.3                 binunit = 2                   mobmod = 0
+capmod = 2                    rdsmod = 0                    igcmod = 1
+igbmod = 1                    rbodymod = 0                  trnqsmod = 0
+acnqsmod = 0                  fnoimod = 1                   tnoimod = 0
+diomod = 1                    tempmod = 0                   permod = 1
+rgatemod = 0                  wpemod = 1
//*** geometry range parameter ***
+lmin = 1.5E-7                 lmax = 1E-6                   wmin = 1E-5
+wmax = 9E-4
//*** process parameter ***
+epsrox = 3.9                  toxe = tox_n_18_cap               toxm = tox_n_18_cap
+dtox = 3.2E-10                xj = 8.1E-8                   ndep = 1E17
+ngate = 1.6E20                nsd = 1E20                    rsh = 17.5
+rshg = 15.5
//*** dw and dl parameter ***
+wint = 2E-9                   wl = 0                        wln = 1
+ww = 0                        wwn = 1                       wwl = 0
+lint = 1E-9                   ll = 0                        lln = 1
+lw = 0                        lwn = 1                       lwl = 0
+lwc = 0                       lwlc = 0                      wwc = 0
+wwlc = 0                      dwg = 0                       dwb = 0
+xl = 0.0+dxl_n_18_cap             xw = 0.0+dxw_n_18_cap
//*** flicker noise model parameter ***
+noia = 3.1E42                 noib = 1.81E21                noic = 3E8
+em = 1E6                      ef = 0.86                     lintnoi = -5E-9
//***layout-dependent parasitics model parameter ***
+dmcg = 4E-8                   dmci = 4E-8                   dmdg = 0
+dmcgt = 0                     dwj = 0                       xgw = 0
+xgl = 0                       ngcon = 1
//*** vth related  parameter ***
+vth0 = 0.4207+dvth0_n_18_cap      lvth0 = 0.0+dlvth0_n_18_cap       wvth0 = 0.0+dwvth0_n_18_cap
+pvth0 = 0.0+dpvth0_n_18_cap       phin = 0                      k1 = 0.30264
+k2 = -0.012135                k3 = -5.68454                 k3b = 2.454986
+w0 = 8.190018E-8              lpe0 = 6.610138E-8            lpeb = 2.000404E-8
+dvtp0 = 2.36094E-6            dvtp1 = 4.5                   dvt0 = 0.236381
+dvt1 = 0.537442               dvt2 = 5.56679E-2             dvt0w = 0
+dvt1w = 0                     dvt2w = 0                     vfbsdoff = 0.02
//*** mobility related parameter ***
+u0 = 0.0298009+du0_n_18_cap       lu0 = 0.0+dlu0_n_18_cap           wu0 = 0.0+dwu0_n_18_cap
+pu0 = 0.0+dpu0_n_18_cap           ua = -9.49994E-10             ub = 2.091579E-18
+uc = 7.758295E-11             ud = 0                        vsat = ( 115107.0+dvsat_n_18_cap)  -250.09884
+a0 = 1.08155                  ags = 1.046673                b0 = 0
+b1 = 0                        keta = -5.19382E-2            a1 = 0
+a2 = 1                        rdsw = 100.002354             prwb = 0
+prwg = 0                      wr = 1
//*** subthreshold related parameter ***
+voff = -0.155578              voffl = -3.595178E-9          minv = -0.15
+nfactor = 1.621754            eta0 = 1.804707E-3            etab = -1.26845E-2
+dsub = 0.422235               cit = 7.212E-4                cdsc = 0
+cdscb = 0                     cdscd = 0
//*** output resistance related parameter ***
+pclm = 1.239489               pdiblc1 = 4.53031E-4          pdiblc2 = 7.801573E-3
+pdiblcb = 1                   drout = 0.56                  pscbe1 = 1E9
+pscbe2 = 1E-20                pvag = 0.9                    delta = 7.595625E-3
+fprout = 300                  pdits = 0                     pditsl = 0
+pditsd = 0                    lc = 0                        alpha0 = 2E-10
+alpha1 = 0.01                 beta0 = 6.4                   agidl = 1.1505E-7
+bgidl = 2.692E9               cgidl = 0.24                  egidl = 0.24
//*** gate dielectric tunneling current ***
+aigbacc = 0.0211              bigbacc = 2.44E-3             cigbacc = 0.312
+nigbacc = 6                   aigbinv = 0.017               bigbinv = 4.3E-3
+cigbinv = 5.7E-3              eigbinv = 1.04                nigbinv = 6
+aigc = 0.012                  bigc = 1.41E-3                cigc = 5.72E-4
+aigsd = 0.0116                bigsd = 1.3E-3                cigsd = 0.073
+dlcig = 2.43E-9               nigc = 2.97                   poxedge = 1
+pigcd = 2.4                   ntox = 1                      toxref = 3E-9
//*** capacitance parameter ***
+xpart = 1                     cgso = 3.13E-11+dcgso_n_18_cap    cgdo = 3.13E-11+dcgdo_n_18_cap
+cgbo = 0                      ckappas = 0.6                 ckappad = 0.6
+cf = 6.13E-11                 clc = 1.04E-7                 cle = 0.6
+dlc = 0                dwc = 0                       noff = 1.6
+voffcv = -0.097               acde = 1                      moin = 5.67
+cgsl = 2.71E-11+dcgsl_n_18_cap    cgdl = 2.71E-11+dcgdl_n_18_cap
//*** souce/drain junction diode model parameter **
+ijthsrev = 0.01               ijthsfwd = 0.01               xjbvs = 1
+bvs = 10                      jss = 4.14E-7                 jsws = 9.7E-13
+jswgs = 1.4E-12               cjs = 8.41E-4+dcj_n_18_cap        mjs = 0.31
+mjsws = 0.081                 cjsws = 1.02E-10+dcjsw_n_18_cap   cjswgs = 1.2E-10+dcjswg_n_18_cap
+mjswgs = 0.511                pbs = 0.511                   pbsws = 0.786
+pbswgs = 0.7
//** rf model related parameter ***
+xrcrg1 = 12                   xrcrg2 = 1                    rbpb = 50
+rbpd = 50                     rbps = 50                     rbdb = 50
+rbsb = 50                     gbmin = 1E-12
//*** stress effect related parameter ***
+saref = 6.1E-7                sbref = 6.1E-7                wlod = 1.37E-7
+ku0 = -2.471E-8               kvsat = 0.3                   kvth0 = 2.1E-9
+tku0 = 0.097                  llodku0 = 1                   wlodku0 = 1
+llodvth = 1                   wlodvth = 1                   lku0 = 1.23E-8
+wku0 = 9.96E-8                pku0 = 4.6E-14                lkvth0 = -2.421E-11
+wkvth0 = 0                    pkvth0 = 0                    stk2 = 3.87E-10
+lodk2 = 0.5                   steta0 = 0                    lodeta0 = 1
//*** temperature coefficient ***
+tnom = 25                     ute = -0.9                    kt1 = -0.235274
+kt1l = 0                      kt2 = -0.036                  ua1 = 8.32E-10
+ub1 = 0                       uc1 = 4.355E-11               at = 7E4
+prt = 0                       njs = 1                       njd = 1
+xtis = 3                      xtid = 3                      tpb = 1.1E-3
+tpbsw = 1.9E-3                tpbswg = 1E-3                 tcj = 6.52E-4
+tcjsw = 3.57E-4               tcjswg = 1.5E-3               tvoff = 2.2428E-3
+tvfbsdoff = 0.022
//*** well proximity effect model parameters ***
+web = 0                       wec = 0                       kvth0we = 2.1E-3
+k2we = 0                      ku0we = -4.21E-3              scref = 1E-6
18:type=n  minr=1e-60
//*** flag parameter ***
+version = 4.3                 binunit = 2                   mobmod = 0
+capmod = 2                    rdsmod = 0                    igcmod = 1
+igbmod = 1                    rbodymod = 0                  trnqsmod = 0
+acnqsmod = 0                  fnoimod = 1                   tnoimod = 0
+diomod = 1                    tempmod = 0                   permod = 1
+rgatemod = 0                  wpemod = 1
//*** geometry range parameter ***
+lmin = 1E-6                   lmax = 2E-6                   wmin = 1E-5
+wmax = 9E-4
//*** process parameter ***
+epsrox = 3.9                  toxe = tox_n_18_cap               toxm = tox_n_18_cap
+dtox = 3.2E-10                xj = 8.1E-8                   ndep = 1E17
+ngate = 1.6E20                nsd = 1E20                    rsh = 17.5
+rshg = 15.5
//*** dw and dl parameter ***
+wint = 2E-9                   wl = 0                        wln = 1
+ww = 0                        wwn = 1                       wwl = 0
+lint = 1E-9                   ll = 0                        lln = 1
+lw = 0                        lwn = 1                       lwl = 0
+lwc = 0                       lwlc = 0                      wwc = 0
+wwlc = 0                      dwg = 0                       dwb = 0
+xl = 0.0+dxl_n_18_cap             xw = 0.0+dxw_n_18_cap
//*** flicker noise model parameter ***
+noia = 3.1E42                 noib = 1.81E21                noic = 3E8
+em = 1E6                      ef = 0.86                     lintnoi = -5E-9
//***layout-dependent parasitics model parameter ***
+dmcg = 4E-8                   dmci = 4E-8                   dmdg = 0
+dmcgt = 0                     dwj = 0                       xgw = 0
+xgl = 0                       ngcon = 1
//*** vth related  parameter ***
+vth0 = 0.4207+dvth0_n_18_cap      lvth0 = 0.0+dlvth0_n_18_cap       wvth0 = 0.0+dwvth0_n_18_cap
+pvth0 = 0.0+dpvth0_n_18_cap       phin = 0                      k1 = 0.30264
+k2 = -0.012135                k3 = -5.68454                 k3b = 2.454986
+w0 = 8.190018E-8              lpe0 = 6.610138E-8            lpeb = 2.000404E-8
+dvtp0 = 2.36094E-6            dvtp1 = 4.5                   dvt0 = 0.236381
+dvt1 = 0.537442               dvt2 = 5.56679E-2             dvt0w = 0
+dvt1w = 0                     dvt2w = 0                     vfbsdoff = 0.02
//*** mobility related parameter ***
+u0 = 0.0298009+du0_n_18_cap       lu0 = 0.0+dlu0_n_18_cap           wu0 = 0.0+dwu0_n_18_cap
+pu0 = 0.0+dpu0_n_18_cap           ua = -9.49994E-10             ub = 2.091579E-18
+uc = 7.758295E-11             ud = 0                        vsat = ( 115107.0+dvsat_n_18_cap)  -250.09884
+a0 = 1.08155                  ags = 1.046673                b0 = 0
+b1 = 0                        keta = -5.19382E-2            a1 = 0
+a2 = 1                        rdsw = 100.002354             prwb = 0
+prwg = 0                      wr = 1
//*** subthreshold related parameter ***
+voff = -0.155578              voffl = -3.595178E-9          minv = -0.15
+nfactor = 1.621754            eta0 = 1.804707E-3            etab = -1.26845E-2
+dsub = 0.422235               cit = 7.212E-4                cdsc = 0
+cdscb = 0                     cdscd = 0
//*** output resistance related parameter ***
+pclm = 1.239489               pdiblc1 = 4.53031E-4          pdiblc2 = 7.801573E-3
+pdiblcb = 1                   drout = 0.56                  pscbe1 = 1E9
+pscbe2 = 1E-20                pvag = 0.9                    delta = 7.595625E-3
+fprout = 300                  pdits = 0                     pditsl = 0
+pditsd = 0                    lc = 0                        alpha0 = 2E-10
+alpha1 = 0.01                 beta0 = 6.4                   agidl = 1.1505E-7
+bgidl = 2.692E9               cgidl = 0.24                  egidl = 0.24
//*** gate dielectric tunneling current ***
+aigbacc = 0.0211              bigbacc = 2.44E-3             cigbacc = 0.312
+nigbacc = 6                   aigbinv = 0.017               bigbinv = 4.3E-3
+cigbinv = 5.7E-3              eigbinv = 1.04                nigbinv = 6
+aigc = 0.012                  bigc = 1.41E-3                cigc = 5.72E-4
+aigsd = 0.0116                bigsd = 1.3E-3                cigsd = 0.073
+dlcig = 2.43E-9               nigc = 2.97                   poxedge = 1
+pigcd = 2.4                   ntox = 1                      toxref = 3E-9
//*** capacitance parameter ***
+xpart = 1                     cgso = 3.13E-11+dcgso_n_18_cap    cgdo = 3.13E-11+dcgdo_n_18_cap
+cgbo = 0                      ckappas = 0.6                 ckappad = 0.6
+cf = 6.13E-11                 clc = 1.04E-7                 cle = 0.6
+dlc = 0                dwc = 0                       noff = 1.6
+voffcv = -0.097               acde = 1                      moin = 5.67
+cgsl = 2.71E-11+dcgsl_n_18_cap    cgdl = 2.71E-11+dcgdl_n_18_cap
//*** souce/drain junction diode model parameter **
+ijthsrev = 0.01               ijthsfwd = 0.01               xjbvs = 1
+bvs = 10                      jss = 4.14E-7                 jsws = 9.7E-13
+jswgs = 1.4E-12               cjs = 8.41E-4+dcj_n_18_cap        mjs = 0.31
+mjsws = 0.081                 cjsws = 1.02E-10+dcjsw_n_18_cap   cjswgs = 1.2E-10+dcjswg_n_18_cap
+mjswgs = 0.511                pbs = 0.511                   pbsws = 0.786
+pbswgs = 0.7
//** rf model related parameter ***
+xrcrg1 = 12                   xrcrg2 = 1                    rbpb = 50
+rbpd = 50                     rbps = 50                     rbdb = 50
+rbsb = 50                     gbmin = 1E-12
//*** stress effect related parameter ***
+saref = 6.1E-7                sbref = 6.1E-7                wlod = 1.37E-7
+ku0 = -2.471E-8               kvsat = 0.3                   kvth0 = 2.1E-9
+tku0 = 0.097                  llodku0 = 1                   wlodku0 = 1
+llodvth = 1                   wlodvth = 1                   lku0 = 1.23E-8
+wku0 = 9.96E-8                pku0 = 4.6E-14                lkvth0 = -2.421E-11
+wkvth0 = 0                    pkvth0 = 0                    stk2 = 3.87E-10
+lodk2 = 0.5                   steta0 = 0                    lodeta0 = 1
//*** temperature coefficient ***
+tnom = 25                     ute = -0.9                    kt1 = -0.235274
+kt1l = 0                      kt2 = -0.036                  ua1 = 8.32E-10
+ub1 = 0                       uc1 = 4.355E-11               at = 7E4
+prt = 0                       njs = 1                       njd = 1
+xtis = 3                      xtid = 3                      tpb = 1.1E-3
+tpbsw = 1.9E-3                tpbswg = 1E-3                 tcj = 6.52E-4
+tcjsw = 3.57E-4               tcjswg = 1.5E-3               tvoff = 2.2428E-3
+tvfbsdoff = 0.022
//*** well proximity effect model parameters ***
+web = 0                       wec = 0                       kvth0we = 2.1E-3
+k2we = 0                      ku0we = -4.21E-3              scref = 1E-6
19:type=n  minr=1e-60
//*** flag parameter ***
+version = 4.3                 binunit = 2                   mobmod = 0
+capmod = 2                    rdsmod = 0                    igcmod = 1
+igbmod = 1                    rbodymod = 0                  trnqsmod = 0
+acnqsmod = 0                  fnoimod = 1                   tnoimod = 0
+diomod = 1                    tempmod = 0                   permod = 1
+rgatemod = 0                  wpemod = 1
//*** geometry range parameter ***
+lmin = 2E-6                   lmax = 1E-5                   wmin = 1E-5
+wmax = 9E-4
//*** process parameter ***
+epsrox = 3.9                  toxe = tox_n_18_cap               toxm = tox_n_18_cap
+dtox = 3.2E-10                xj = 8.1E-8                   ndep = 1E17
+ngate = 1.6E20                nsd = 1E20                    rsh = 17.5
+rshg = 15.5
//*** dw and dl parameter ***
+wint = 2E-9                   wl = 0                        wln = 1
+ww = 0                        wwn = 1                       wwl = 0
+lint = 1E-9                   ll = 0                        lln = 1
+lw = 0                        lwn = 1                       lwl = 0
+lwc = 0                       lwlc = 0                      wwc = 0
+wwlc = 0                      dwg = 0                       dwb = 0
+xl = 0.0+dxl_n_18_cap             xw = 0.0+dxw_n_18_cap
//*** flicker noise model parameter ***
+noia = 3.1E42                 noib = 1.81E21                noic = 3E8
+em = 1E6                      ef = 0.86                     lintnoi = -5E-9
//***layout-dependent parasitics model parameter ***
+dmcg = 4E-8                   dmci = 4E-8                   dmdg = 0
+dmcgt = 0                     dwj = 0                       xgw = 0
+xgl = 0                       ngcon = 1
//*** vth related  parameter ***
+vth0 = 0.4207+dvth0_n_18_cap      lvth0 = 0.0+dlvth0_n_18_cap       wvth0 = 0.0+dwvth0_n_18_cap
+pvth0 = 0.0+dpvth0_n_18_cap       phin = 0                      k1 = 0.30264
+k2 = -0.012135                k3 = -5.68454                 k3b = 2.454986
+w0 = 8.190018E-8              lpe0 = 6.610138E-8            lpeb = 2.000404E-8
+dvtp0 = 2.36094E-6            dvtp1 = 4.5                   dvt0 = 0.236381
+dvt1 = 0.537442               dvt2 = 5.56679E-2             dvt0w = 0
+dvt1w = 0                     dvt2w = 0                     vfbsdoff = 0.02
//*** mobility related parameter ***
+u0 = 0.0298009+du0_n_18_cap       lu0 = 0.0+dlu0_n_18_cap           wu0 = 0.0+dwu0_n_18_cap
+pu0 = 0.0+dpu0_n_18_cap           ua = -9.49994E-10             ub = 2.091579E-18
+uc = 7.758295E-11             ud = 0                        vsat = ( 115107.0+dvsat_n_18_cap)  -250.09884
+a0 = 1.08155                  ags = 1.046673                b0 = 0
+b1 = 0                        keta = -5.19382E-2            a1 = 0
+a2 = 1                        rdsw = 100.002354             prwb = 0
+prwg = 0                      wr = 1
//*** subthreshold related parameter ***
+voff = -0.155578              voffl = -3.595178E-9          minv = -0.15
+nfactor = 1.621754            eta0 = 1.804707E-3            etab = -1.26845E-2
+dsub = 0.422235               cit = 7.212E-4                cdsc = 0
+cdscb = 0                     cdscd = 0
//*** output resistance related parameter ***
+pclm = 1.239489               pdiblc1 = 4.53031E-4          pdiblc2 = 7.801573E-3
+pdiblcb = 1                   drout = 0.56                  pscbe1 = 1E9
+pscbe2 = 1E-20                pvag = 0.9                    delta = 7.595625E-3
+fprout = 300                  pdits = 0                     pditsl = 0
+pditsd = 0                    lc = 0                        alpha0 = 2E-10
+alpha1 = 0.01                 beta0 = 6.4                   agidl = 1.1505E-7
+bgidl = 2.692E9               cgidl = 0.24                  egidl = 0.24
//*** gate dielectric tunneling current ***
+aigbacc = 0.0211              bigbacc = 2.44E-3             cigbacc = 0.312
+nigbacc = 6                   aigbinv = 0.017               bigbinv = 4.3E-3
+cigbinv = 5.7E-3              eigbinv = 1.04                nigbinv = 6
+aigc = 0.012                  bigc = 1.41E-3                cigc = 5.72E-4
+aigsd = 0.0116                bigsd = 1.3E-3                cigsd = 0.073
+dlcig = 2.43E-9               nigc = 2.97                   poxedge = 1
+pigcd = 2.4                   ntox = 1                      toxref = 3E-9
//*** capacitance parameter ***
+xpart = 1                     cgso = 3.13E-11+dcgso_n_18_cap    cgdo = 3.13E-11+dcgdo_n_18_cap
+cgbo = 0                      ckappas = 0.6                 ckappad = 0.6
+cf = 6.13E-11                 clc = 1.04E-7                 cle = 0.6
+dlc = 0                dwc = 0                       noff = 1.6
+voffcv = -0.097               acde = 1                      moin = 5.67
+cgsl = 2.71E-11+dcgsl_n_18_cap    cgdl = 2.71E-11+dcgdl_n_18_cap
//*** souce/drain junction diode model parameter **
+ijthsrev = 0.01               ijthsfwd = 0.01               xjbvs = 1
+bvs = 10                      jss = 4.14E-7                 jsws = 9.7E-13
+jswgs = 1.4E-12               cjs = 8.41E-4+dcj_n_18_cap        mjs = 0.31
+mjsws = 0.081                 cjsws = 1.02E-10+dcjsw_n_18_cap   cjswgs = 1.2E-10+dcjswg_n_18_cap
+mjswgs = 0.511                pbs = 0.511                   pbsws = 0.786
+pbswgs = 0.7
//** rf model related parameter ***
+xrcrg1 = 12                   xrcrg2 = 1                    rbpb = 50
+rbpd = 50                     rbps = 50                     rbdb = 50
+rbsb = 50                     gbmin = 1E-12
//*** stress effect related parameter ***
+saref = 6.1E-7                sbref = 6.1E-7                wlod = 1.37E-7
+ku0 = -2.471E-8               kvsat = 0.3                   kvth0 = 2.1E-9
+tku0 = 0.097                  llodku0 = 1                   wlodku0 = 1
+llodvth = 1                   wlodvth = 1                   lku0 = 1.23E-8
+wku0 = 9.96E-8                pku0 = 4.6E-14                lkvth0 = -2.421E-11
+wkvth0 = 0                    pkvth0 = 0                    stk2 = 3.87E-10
+lodk2 = 0.5                   steta0 = 0                    lodeta0 = 1
//*** temperature coefficient ***
+tnom = 25                     ute = -0.9                    kt1 = -0.235274
+kt1l = 0                      kt2 = -0.036                  ua1 = 8.32E-10
+ub1 = 0                       uc1 = 4.355E-11               at = 7E4
+prt = 0                       njs = 1                       njd = 1
+xtis = 3                      xtid = 3                      tpb = 1.1E-3
+tpbsw = 1.9E-3                tpbswg = 1E-3                 tcj = 6.52E-4
+tcjsw = 3.57E-4               tcjswg = 1.5E-3               tvoff = 2.2428E-3
+tvfbsdoff = 0.022
//*** well proximity effect model parameters ***
+web = 0                       wec = 0                       kvth0we = 2.1E-3
+k2we = 0                      ku0we = -4.21E-3              scref = 1E-6
20:type=n  minr=1e-60
//*** flag parameter ***
+version = 4.3                 binunit = 2                   mobmod = 0
+capmod = 2                    rdsmod = 0                    igcmod = 1
+igbmod = 1                    rbodymod = 0                  trnqsmod = 0
+acnqsmod = 0                  fnoimod = 1                   tnoimod = 0
+diomod = 1                    tempmod = 0                   permod = 1
+rgatemod = 0                  wpemod = 1
//*** geometry range parameter ***
+lmin = 1E-5                   lmax = 9E-4                   wmin = 1E-5
+wmax = 9E-4
//*** process parameter ***
+epsrox = 3.9                  toxe = tox_n_18_cap               toxm = tox_n_18_cap
+dtox = 3.2E-10                xj = 8.1E-8                   ndep = 1E17
+ngate = 1.6E20                nsd = 1E20                    rsh = 17.5
+rshg = 15.5
//*** dw and dl parameter ***
+wint = 2E-9                   wl = 0                        wln = 1
+ww = 0                        wwn = 1                       wwl = 0
+lint = 1E-9                   ll = 0                        lln = 1
+lw = 0                        lwn = 1                       lwl = 0
+lwc = 0                       lwlc = 0                      wwc = 0
+wwlc = 0                      dwg = 0                       dwb = 0
+xl = 0.0+dxl_n_18_cap             xw = 0.0+dxw_n_18_cap
//*** flicker noise model parameter ***
+noia = 3.1E42                 noib = 1.81E21                noic = 3E8
+em = 1E6                      ef = 0.86                     lintnoi = -5E-9
//***layout-dependent parasitics model parameter ***
+dmcg = 4E-8                   dmci = 4E-8                   dmdg = 0
+dmcgt = 0                     dwj = 0                       xgw = 0
+xgl = 0                       ngcon = 1
//*** vth related  parameter ***
+vth0 = 0.4207+dvth0_n_18_cap      lvth0 = 0.0+dlvth0_n_18_cap       wvth0 = 0.0+dwvth0_n_18_cap
+pvth0 = 0.0+dpvth0_n_18_cap       phin = 0                      k1 = 0.30264
+k2 = -0.012135                k3 = -5.68454                 k3b = 2.454986
+w0 = 8.190018E-8              lpe0 = 6.610138E-8            lpeb = 2.000404E-8
+dvtp0 = 2.36094E-6            dvtp1 = 4.5                   dvt0 = 0.236381
+dvt1 = 0.537442               dvt2 = 5.56679E-2             dvt0w = 0
+dvt1w = 0                     dvt2w = 0                     vfbsdoff = 0.02
//*** mobility related parameter ***
+u0 = 0.0298009+du0_n_18_cap       lu0 = 0.0+dlu0_n_18_cap           wu0 = 0.0+dwu0_n_18_cap
+pu0 = 0.0+dpu0_n_18_cap           ua = -9.49994E-10             ub = 2.091579E-18
+uc = 7.758295E-11             ud = 0                        vsat = ( 115107.0+dvsat_n_18_cap)  -250.09884
+a0 = 1.08155                  ags = 1.046673                b0 = 0
+b1 = 0                        keta = -5.19382E-2            a1 = 0
+a2 = 1                        rdsw = 100.002354             prwb = 0
+prwg = 0                      wr = 1
//*** subthreshold related parameter ***
+voff = -0.155578              voffl = -3.595178E-9          minv = -0.15
+nfactor = 1.621754            eta0 = 1.804707E-3            etab = -1.26845E-2
+dsub = 0.422235               cit = 7.212E-4                cdsc = 0
+cdscb = 0                     cdscd = 0
//*** output resistance related parameter ***
+pclm = 1.239489               pdiblc1 = 4.53031E-4          pdiblc2 = 7.801573E-3
+pdiblcb = 1                   drout = 0.56                  pscbe1 = 1E9
+pscbe2 = 1E-20                pvag = 0.9                    delta = 7.595625E-3
+fprout = 300                  pdits = 0                     pditsl = 0
+pditsd = 0                    lc = 0                        alpha0 = 2E-10
+alpha1 = 0.01                 beta0 = 6.4                   agidl = 1.1505E-7
+bgidl = 2.692E9               cgidl = 0.24                  egidl = 0.24
//*** gate dielectric tunneling current ***
+aigbacc = 0.0211              bigbacc = 2.44E-3             cigbacc = 0.312
+nigbacc = 6                   aigbinv = 0.017               bigbinv = 4.3E-3
+cigbinv = 5.7E-3              eigbinv = 1.04                nigbinv = 6
+aigc = 0.012                  bigc = 1.41E-3                cigc = 5.72E-4
+aigsd = 0.0116                bigsd = 1.3E-3                cigsd = 0.073
+dlcig = 2.43E-9               nigc = 2.97                   poxedge = 1
+pigcd = 2.4                   ntox = 1                      toxref = 3E-9
//*** capacitance parameter ***
+xpart = 1                     cgso = 3.13E-11+dcgso_n_18_cap    cgdo = 3.13E-11+dcgdo_n_18_cap
+cgbo = 0                      ckappas = 0.6                 ckappad = 0.6
+cf = 6.13E-11                 clc = 1.04E-7                 cle = 0.6
+dlc = 0                dwc = 0                       noff = 1.6
+voffcv = -0.097               acde = 1                      moin = 5.67
+cgsl = 2.71E-11+dcgsl_n_18_cap    cgdl = 2.71E-11+dcgdl_n_18_cap
//*** souce/drain junction diode model parameter **
+ijthsrev = 0.01               ijthsfwd = 0.01               xjbvs = 1
+bvs = 10                      jss = 4.14E-7                 jsws = 9.7E-13
+jswgs = 1.4E-12               cjs = 8.41E-4+dcj_n_18_cap        mjs = 0.31
+mjsws = 0.081                 cjsws = 1.02E-10+dcjsw_n_18_cap   cjswgs = 1.2E-10+dcjswg_n_18_cap
+mjswgs = 0.511                pbs = 0.511                   pbsws = 0.786
+pbswgs = 0.7
//** rf model related parameter ***
+xrcrg1 = 12                   xrcrg2 = 1                    rbpb = 50
+rbpd = 50                     rbps = 50                     rbdb = 50
+rbsb = 50                     gbmin = 1E-12
//*** stress effect related parameter ***
+saref = 6.1E-7                sbref = 6.1E-7                wlod = 1.37E-7
+ku0 = -2.471E-8               kvsat = 0.3                   kvth0 = 2.1E-9
+tku0 = 0.097                  llodku0 = 1                   wlodku0 = 1
+llodvth = 1                   wlodvth = 1                   lku0 = 1.23E-8
+wku0 = 9.96E-8                pku0 = 4.6E-14                lkvth0 = -2.421E-11
+wkvth0 = 0                    pkvth0 = 0                    stk2 = 3.87E-10
+lodk2 = 0.5                   steta0 = 0                    lodeta0 = 1
//*** temperature coefficient ***
+tnom = 25                     ute = -0.9                    kt1 = -0.235274
+kt1l = 0                      kt2 = -0.036                  ua1 = 8.32E-10
+ub1 = 0                       uc1 = 4.355E-11               at = 7E4
+prt = 0                       njs = 1                       njd = 1
+xtis = 3                      xtid = 3                      tpb = 1.1E-3
+tpbsw = 1.9E-3                tpbswg = 1E-3                 tcj = 6.52E-4
+tcjsw = 3.57E-4               tcjswg = 1.5E-3               tvoff = 2.2428E-3
+tvfbsdoff = 0.022
//*** well proximity effect model parameters ***
+web = 0                       wec = 0                       kvth0we = 2.1E-3
+k2we = 0                      ku0we = -4.21E-3              scref = 1E-6
}

model pch18_mac bsim4 {
1:type=p  minr=1e-60
//*** flag parameter ***
+version = 4.3                 binunit = 2                   mobmod = 0
+capmod = 2                    rdsmod = 0                    igcmod = 1
+igbmod = 1                    rbodymod = 0                  trnqsmod = 0
+acnqsmod = 0                  fnoimod = 1                   tnoimod = 0
+diomod = 1                    permod = 1                    rgatemod = 0
+wpemod = 0
//*** geometry range parameter ***
+lmin = 2E-6                   lmax = 1E-5                   wmin = 2E-6
+wmax = 1E-5
//*** process parameter ***
+epsrox = 3.9                  toxe = tox_p_18_cap               toxm = tox_p_18_cap
+dtox = 3.1E-10                xj = 1.7E-7                   ndep = 8.5E17
+ngate = 8E19                  nsd = 1E20                    rsh = 9.68
+rshg = 0.1
//*** dw and dl parameter ***
+wint = 1.389287E-8            wl = 0                        wln = 1
+ww = 0                        wwn = 1                       wwl = 0
+lint = 0                      ll = 0                        lln = 1
+lw = 0                        lwn = 1                       lwl = 0
+llc = 0                       lwc = 0                       lwlc = 0
+wlc = 0                       wwc = 0                       wwlc = 0
+dwg = 0                       dwb = 0                       xl = 0.0+dxl_p_18_cap
+xw = 0.0+dxw_p_18_cap
//*** flicker noise model parameter ***
+noia = 7.45E41                noib = 1.57E26                noic = 2E10
+em = 2.1E7                    ef = 1.3
//***layout-dependent parasitics model parameter ***
+dmcg = 8.5E-8                 dmci = 8.5E-8                 dmdg = 0
+dmcgt = 0                     dwj = 0                       xgw = 0
+xgl = 0                       ngcon = 1
//*** vth related  parameter ***
+vth0 = -0.35906+dvth0_p_18_cap    lvth0 = 0.0+dlvth0_p_18_cap       wvth0 = 0.0+dwvth0_p_18_cap
+pvth0 = 0.0+dpvth0_p_18_cap       phin = 0                      k1 = 0.25
+k2 = -1.21927E-2              k3 = -3.3                     k3b = 1.200306
+w0 = 1.585076E-7              lpe0 = 7.519925E-8            lpeb = 5.608072E-8
+dvtp0 = 2.2E-6                dvtp1 = 0.2                   dvt0 = 0.20341
+dvt1 = 0.95146                dvt2 = 0.01                   dvt0w = 0
+dvt1w = 5.366499E6            dvt2w = 0
//*** mobility related parameter ***
+u0 = 0.0196662+du0_p_18_cap       lu0 = 0.0+dlu0_p_18_cap           wu0 = 0.0+dwu0_p_18_cap
+pu0 = 0.0+dpu0_p_18_cap           ua = 2.455E-10                ub = 2.569851E-18
+wub = -3.000007E-25           uc = 4.336286E-11             ud = 0
+vsat = 65731.5+dvsat_p_18_cap     a0 = 0.693823                 ags = 1.93352
+b0 = 0                        b1 = 0                        keta = -6.14042E-2
+a1 = 0                        a2 = 1                        rdsw = 327.6
+prwb = -0.249981              prwg = 0.25                   wr = 1
//*** subthreshold related parameter ***
+voff = -0.05137               voffl = -6.036214E-9          minv = 0
+nfactor = 0.627693            eta0 = 3.11538E-2             etab = -2.38505E-2
+dsub = 1.2725                 cit = 1E-4                    cdsc = 0
+cdscb = 0                     cdscd = 0
//*** output resistance related parameter ***
+pclm = 0.627258               pdiblc1 = 0                   pdiblc2 = 9.579679E-3
+pdiblcb = 0                   drout = 1.132692              pscbe1 = 9.264E8
+pscbe2 = 1E-20                pvag = 1.425                  delta = 0.02
+fprout = 390.234144           pdits = 5.042617E-3           pditsl = 100
+pditsd = 0                    alpha0 = 0                    alpha1 = 0.06
+beta0 = 13.5                  agidl = 7.8E-8                bgidl = 2.404E9
+cgidl = 0.47                  egidl = 0.14
//*** gate dielectric tunneling current ***
+aigbacc = 0.014               bigbacc = 2.7E-3              cigbacc = 0.121
+nigbacc = 4.8                 aigbinv = 0.37                bigbinv = 0.028
+cigbinv = 6.4E-3              eigbinv = 1.2                 nigbinv = 1.5
+aigc = 6.8E-3                 bigc = 5.91E-4                cigc = 0
+aigsd = 6.1E-3                bigsd = 2.14E-4               cigsd = 0.037
+dlcig = 2.21E-9               nigc = 2.31                   poxedge = 1
+pigcd = 2.25                  ntox = 1                      toxref = 3E-9
//*** capacitance parameter ***
+xpart = 1                     cgso = 2.2E-11+dcgso_p_18_cap     cgdo = 2.2E-11+dcgdo_p_18_cap
+cgbo = 0                      ckappas = 0.6                 ckappad = 0.6
+cf = 1.08E-10                 clc = 1E-7                    cle = 0.6
+dlc =0                 dwc = 0                       noff = 2
+voffcv = -0.084               acde = 1.2                    moin = 6.4
+cgsl = 1E-10+dcgsl_p_18_cap    cgdl = 1E-10+dcgdl_p_18_cap
//*** souce/drain junction diode model parameter **
+ijthsrev = 0.01               ijthsfwd = 0.01               xjbvs = 1
+bvs = 10                      jss = 3.1E-7                  jsws = 1E-12
+jswgs = 2.87E-12              cjs = 9.7E-4+dcj_p_18_cap         mjs = 0.41
+mjsws = 0.097                 cjsws = 1.1E-10+dcjsw_p_18_cap    cjswgs = 2.3E-10+dcjswg_p_18_cap
+mjswgs = 0.88                 pbs = 0.75                    pbsws = 0.49
+pbswgs = 0.8
//** rf model related parameter ***
+xrcrg1 = 12                   xrcrg2 = 1                    rbpb = 50
+rbpd = 50                     rbps = 50                     rbdb = 50
+rbsb = 50                     gbmin = 1E-12
//*** stress effect related parameter ***
+saref = 6.1E-7                sbref = 6.1E-7                wlod = 2.86E-7
+ku0 = 1.2E-7                  kvsat = -0.34                 kvth0 = 1.7E-10
+tku0 = 0.24                   llodku0 = 1                   wlodku0 = 1
+llodvth = 1.8                 wlodvth = 1                   lku0 = 1.871E-7
+wku0 = 2.4E-7                 pku0 = -3.24E-14              lkvth0 = 2.4E-10
+wkvth0 = 1.8E-10              pkvth0 = 0                    stk2 = 0
+lodk2 = 1.9                   steta0 = 0                    lodeta0 = 1
//*** temperature coefficient ***
+tnom = 25                     ute = -1.2192                 kt1 = -0.2061
+kt1l = 0                      kt2 = -0.01232                ua1 = 4.0941E-9
+ub1 = -4.8969E-18             uc1 = -5.5E-11                at = 4.00001E4
+prt = 0                       njs = 1                       xtis = 3
+tpb = 1.9E-3                  tpbsw = 1.9E-3                tpbswg = 1.9E-3
+tcj = 7.98E-4                 tcjsw = 2.4E-4                tcjswg = 4.77E-3
//*** well proximity effect model parameters ***
+web = 0                       wec = 0                       kvth0we = -2E-3
+k2we = 0                      ku0we = -4.1E-3               scref = 1E-6
2:type=p  minr=1e-60
//*** flag parameter ***
+version = 4.3                 binunit = 2                   mobmod = 0
+capmod = 2                    rdsmod = 0                    igcmod = 1
+igbmod = 1                    rbodymod = 0                  trnqsmod = 0
+acnqsmod = 0                  fnoimod = 1                   tnoimod = 0
+diomod = 1                    permod = 1                    rgatemod = 0
+wpemod = 0
//*** geometry range parameter ***
+lmin = 1E-6                   lmax = 2E-6                   wmin = 2E-6
+wmax = 1E-5
//*** process parameter ***
+epsrox = 3.9                  toxe = tox_p_18_cap               toxm = tox_p_18_cap
+dtox = 3.1E-10                xj = 1.7E-7                   ndep = 8.5E17
+ngate = 8E19                  nsd = 1E20                    rsh = 9.68
+rshg = 0.1
//*** dw and dl parameter ***
+wint = 1.389287E-8            wl = 0                        wln = 1
+ww = 0                        wwn = 1                       wwl = 0
+lint = 0                      ll = 0                        lln = 1
+lw = 0                        lwn = 1                       lwl = 0
+llc = 0                       lwc = 0                       lwlc = 0
+wlc = 0                       wwc = 0                       wwlc = 0
+dwg = 0                       dwb = 0                       xl = 0+dxl_p_18_cap
+xw = 0+dxw_p_18_cap
//*** flicker noise model parameter ***
+noia = 7.45E41                noib = 1.57E26                noic = 2E10
+em = 2.1E7                    ef = 1.3
//***layout-dependent parasitics model parameter ***
+dmcg = 8.5E-8                 dmci = 8.5E-8                 dmdg = 0
+dmcgt = 0                     dwj = 0                       xgw = 0
+xgl = 0                       ngcon = 1
//*** vth related  parameter ***
+vth0 = -0.35906+dvth0_p_18_cap    lvth0 = 0+dlvth0_p_18_cap         wvth0 = 0+dwvth0_p_18_cap
+pvth0 = 0+dpvth0_p_18_cap         phin = 0                      k1 = 0.25
+k2 = -1.21927E-2              k3 = -3.3                     k3b = 1.200306
+w0 = 1.585076E-7              lpe0 = 7.519925E-8            lpeb = 5.608072E-8
+dvtp0 = 2.2E-6                dvtp1 = 0.2                   dvt0 = 0.20341
+dvt1 = 0.95146                dvt2 = 0.01                   dvt0w = 0
+dvt1w = 5.366499E6            dvt2w = 0
//*** mobility related parameter ***
+u0 = 1.96662E-2+du0_p_18_cap      lu0 = 0+dlu0_p_18_cap             wu0 = 0+dwu0_p_18_cap
+pu0 = 0+dpu0_p_18_cap             ua = 2.455E-10                ub = 2.569851E-18
+wub = -3.000007E-25           uc = 4.336286E-11             ud = 0
+vsat = 6.57315E4+dvsat_p_18_cap   a0 = 0.693823                 ags = 1.93352
+b0 = 0                        b1 = 0                        keta = -6.14042E-2
+a1 = 0                        a2 = 1                        rdsw = 327.6
+prwb = -0.249981              prwg = 0.25                   wr = 1
//*** subthreshold related parameter ***
+voff = -0.05137               voffl = -6.036214E-9          minv = 0
+nfactor = 0.627693            eta0 = 3.11538E-2             etab = -2.38505E-2
+dsub = 1.2725                 cit = 1E-4                    cdsc = 0
+cdscb = 0                     cdscd = 0
//*** output resistance related parameter ***
+pclm = 0.627258               pdiblc1 = 0                   pdiblc2 = 9.579679E-3
+pdiblcb = 0                   drout = 1.132692              pscbe1 = 9.264E8
+pscbe2 = 1E-20                pvag = 1.425                  delta = 0.02
+fprout = 390.234144           pdits = 5.042617E-3           pditsl = 100
+pditsd = 0                    alpha0 = 0                    alpha1 = 0.06
+beta0 = 13.5                  agidl = 7.8E-8                bgidl = 2.404E9
+cgidl = 0.47                  egidl = 0.14
//*** gate dielectric tunneling current ***
+aigbacc = 0.014               bigbacc = 2.7E-3              cigbacc = 0.121
+nigbacc = 4.8                 aigbinv = 0.37                bigbinv = 0.028
+cigbinv = 6.4E-3              eigbinv = 1.2                 nigbinv = 1.5
+aigc = 6.8E-3                 bigc = 5.91E-4                cigc = 0
+aigsd = 6.1E-3                bigsd = 2.14E-4               cigsd = 0.037
+dlcig = 2.21E-9               nigc = 2.31                   poxedge = 1
+pigcd = 2.25                  ntox = 1                      toxref = 3E-9
//*** capacitance parameter ***
+xpart = 1                     cgso = 2.2E-11+dcgso_p_18_cap     cgdo = 2.2E-11+dcgdo_p_18_cap
+cgbo = 0                      ckappas = 0.6                 ckappad = 0.6
+cf = 1.08E-10                 clc = 1E-7                    cle = 0.6
+dlc = 0                dwc = 0                       noff = 2
+voffcv = -0.084               acde = 1.2                    moin = 6.4
+cgsl = 1E-10+dcgsl_p_18_cap    cgdl = 1E-10+dcgdl_p_18_cap
//*** souce/drain junction diode model parameter **
+ijthsrev = 0.01               ijthsfwd = 0.01               xjbvs = 1
+bvs = 10                      jss = 3.1E-7                  jsws = 1E-12
+jswgs = 2.87E-12              cjs = 9.7E-4+dcj_p_18_cap         mjs = 0.41
+mjsws = 0.097                 cjsws = 1.1E-10+dcjsw_p_18_cap    cjswgs = 2.3E-10+dcjswg_p_18_cap
+mjswgs = 0.88                 pbs = 0.75                    pbsws = 0.49
+pbswgs = 0.8
//** rf model related parameter ***
+xrcrg1 = 12                   xrcrg2 = 1                    rbpb = 50
+rbpd = 50                     rbps = 50                     rbdb = 50
+rbsb = 50                     gbmin = 1E-12
//*** stress effect related parameter ***
+saref = 6.1E-7                sbref = 6.1E-7                wlod = 2.86E-7
+ku0 = 1.2E-7                  kvsat = -0.34                 kvth0 = 1.7E-10
+tku0 = 0.24                   llodku0 = 1                   wlodku0 = 1
+llodvth = 1.8                 wlodvth = 1                   lku0 = 1.871E-7
+wku0 = 2.4E-7                 pku0 = -3.24E-14              lkvth0 = 2.4E-10
+wkvth0 = 1.8E-10              pkvth0 = 0                    stk2 = 0
+lodk2 = 1.9                   steta0 = 0                    lodeta0 = 1
//*** temperature coefficient ***
+tnom = 25                     ute = -1.2192                 kt1 = -0.2061
+kt1l = 0                      kt2 = -0.01232                ua1 = 4.0941E-9
+ub1 = -4.8969E-18             uc1 = -5.5E-11                at = 4.00001E4
+prt = 0                       njs = 1                       xtis = 3
+tpb = 1.9E-3                  tpbsw = 1.9E-3                tpbswg = 1.9E-3
+tcj = 7.98E-4                 tcjsw = 2.4E-4                tcjswg = 4.77E-3
//*** well proximity effect model parameters ***
+web = 0                       wec = 0                       kvth0we = -2E-3
+k2we = 0                      ku0we = -4.1E-3               scref = 1E-6
3:type=p  minr=1e-60
//*** flag parameter ***
+version = 4.3                 binunit = 2                   mobmod = 0
+capmod = 2                    rdsmod = 0                    igcmod = 1
+igbmod = 1                    rbodymod = 0                  trnqsmod = 0
+acnqsmod = 0                  fnoimod = 1                   tnoimod = 0
+diomod = 1                    permod = 1                    rgatemod = 0
+wpemod = 0
//*** geometry range parameter ***
+lmin = 1.5E-7                 lmax = 1E-6                   wmin = 2E-6
+wmax = 1E-5
//*** process parameter ***
+epsrox = 3.9                  toxe = tox_p_18_cap               toxm = tox_p_18_cap
+dtox = 3.1E-10                xj = 1.7E-7                   ndep = 8.5E17
+ngate = 8E19                  nsd = 1E20                    rsh = 9.68
+rshg = 0.1
//*** dw and dl parameter ***
+wint = 1.389287E-8            wl = 0                        wln = 1
+ww = 0                        wwn = 1                       wwl = 0
+lint = 0                      ll = 0                        lln = 1
+lw = 0                        lwn = 1                       lwl = 0
+llc = 0                       lwc = 0                       lwlc = 0
+wlc = 0                       wwc = 0                       wwlc = 0
+dwg = 0                       dwb = 0                       xl = 0+dxl_p_18_cap
+xw = 0+dxw_p_18_cap
//*** flicker noise model parameter ***
+noia = 7.45E41                noib = 1.57E26                noic = 2E10
+em = 2.1E7                    ef = 1.3
//***layout-dependent parasitics model parameter ***
+dmcg = 8.5E-8                 dmci = 8.5E-8                 dmdg = 0
+dmcgt = 0                     dwj = 0                       xgw = 0
+xgl = 0                       ngcon = 1
//*** vth related  parameter ***
+vth0 = -0.35906+dvth0_p_18_cap    lvth0 = 0+dlvth0_p_18_cap         wvth0 = 0+dwvth0_p_18_cap
+pvth0 = 0+dpvth0_p_18_cap         phin = 0                      k1 = 0.25
+k2 = -1.21927E-2              k3 = -3.3                     k3b = 1.200306
+w0 = 1.585076E-7              lpe0 = 7.519925E-8            lpeb = 5.608072E-8
+dvtp0 = 2.2E-6                dvtp1 = 0.2                   dvt0 = 0.20341
+dvt1 = 0.95146                dvt2 = 0.01                   dvt0w = 0
+dvt1w = 5.366499E6            dvt2w = 0
//*** mobility related parameter ***
+u0 = 1.96662E-2+du0_p_18_cap      lu0 = 0+dlu0_p_18_cap             wu0 = 0+dwu0_p_18_cap
+pu0 = 0+dpu0_p_18_cap             ua = 2.455E-10                ub = 2.569851E-18
+wub = -3.000007E-25           uc = 4.336286E-11             ud = 0
+vsat = 6.57315E4+dvsat_p_18_cap   a0 = 0.693823                 ags = 1.93352
+b0 = 0                        b1 = 0                        keta = -6.14042E-2
+a1 = 0                        a2 = 1                        rdsw = 327.6
+prwb = -0.249981              prwg = 0.25                   wr = 1
//*** subthreshold related parameter ***
+voff = -0.05137               voffl = -6.036214E-9          minv = 0
+nfactor = 0.627693            eta0 = 3.11538E-2             etab = -2.38505E-2
+dsub = 1.2725                 cit = 1E-4                    cdsc = 0
+cdscb = 0                     cdscd = 0
//*** output resistance related parameter ***
+pclm = 0.627258               pdiblc1 = 0                   pdiblc2 = 9.579679E-3
+pdiblcb = 0                   drout = 1.132692              pscbe1 = 9.264E8
+pscbe2 = 1E-20                pvag = 1.425                  delta = 0.02
+fprout = 390.234144           pdits = 5.042617E-3           pditsl = 100
+pditsd = 0                    alpha0 = 0                    alpha1 = 0.06
+beta0 = 13.5                  agidl = 7.8E-8                bgidl = 2.404E9
+cgidl = 0.47                  egidl = 0.14
//*** gate dielectric tunneling current ***
+aigbacc = 0.014               bigbacc = 2.7E-3              cigbacc = 0.121
+nigbacc = 4.8                 aigbinv = 0.37                bigbinv = 0.028
+cigbinv = 6.4E-3              eigbinv = 1.2                 nigbinv = 1.5
+aigc = 6.8E-3                 bigc = 5.91E-4                cigc = 0
+aigsd = 6.1E-3                bigsd = 2.14E-4               cigsd = 0.037
+dlcig = 2.21E-9               nigc = 2.31                   poxedge = 1
+pigcd = 2.25                  ntox = 1                      toxref = 3E-9
//*** capacitance parameter ***
+xpart = 1                     cgso = 2.2E-11+dcgso_p_18_cap     cgdo = 2.2E-11+dcgdo_p_18_cap
+cgbo = 0                      ckappas = 0.6                 ckappad = 0.6
+cf = 1.08E-10                 clc = 1E-7                    cle = 0.6
+dlc = 0                 dwc = 0                       noff = 2
+voffcv = -0.084               acde = 1.2                    moin = 6.4
+cgsl = 1E-10+dcgsl_p_18_cap    cgdl = 1E-10+dcgdl_p_18_cap
//*** souce/drain junction diode model parameter **
+ijthsrev = 0.01               ijthsfwd = 0.01               xjbvs = 1
+bvs = 10                      jss = 3.1E-7                  jsws = 1E-12
+jswgs = 2.87E-12              cjs = 9.7E-4+dcj_p_18_cap         mjs = 0.41
+mjsws = 0.097                 cjsws = 1.1E-10+dcjsw_p_18_cap    cjswgs = 2.3E-10+dcjswg_p_18_cap
+mjswgs = 0.88                 pbs = 0.75                    pbsws = 0.49
+pbswgs = 0.8
//** rf model related parameter ***
+xrcrg1 = 12                   xrcrg2 = 1                    rbpb = 50
+rbpd = 50                     rbps = 50                     rbdb = 50
+rbsb = 50                     gbmin = 1E-12
//*** stress effect related parameter ***
+saref = 6.1E-7                sbref = 6.1E-7                wlod = 2.86E-7
+ku0 = 1.2E-7                  kvsat = -0.34                 kvth0 = 1.7E-10
+tku0 = 0.24                   llodku0 = 1                   wlodku0 = 1
+llodvth = 1.8                 wlodvth = 1                   lku0 = 1.871E-7
+wku0 = 2.4E-7                 pku0 = -3.24E-14              lkvth0 = 2.4E-10
+wkvth0 = 1.8E-10              pkvth0 = 0                    stk2 = 0
+lodk2 = 1.9                   steta0 = 0                    lodeta0 = 1
//*** temperature coefficient ***
+tnom = 25                     ute = -1.2192                 kt1 = -0.2061
+kt1l = 0                      kt2 = -0.01232                ua1 = 4.0941E-9
+ub1 = -4.8969E-18             uc1 = -5.5E-11                at = 4.00001E4
+prt = 0                       njs = 1                       xtis = 3
+tpb = 1.9E-3                  tpbsw = 1.9E-3                tpbswg = 1.9E-3
+tcj = 7.98E-4                 tcjsw = 2.4E-4                tcjswg = 4.77E-3
//*** well proximity effect model parameters ***
+web = 0                       wec = 0                       kvth0we = -2E-3
+k2we = 0                      ku0we = -4.1E-3               scref = 1E-6
4:type=p  minr=1e-60
//*** flag parameter ***
+version = 4.3                 binunit = 2                   mobmod = 0
+capmod = 2                    rdsmod = 0                    igcmod = 1
+igbmod = 1                    rbodymod = 0                  trnqsmod = 0
+acnqsmod = 0                  fnoimod = 1                   tnoimod = 0
+diomod = 1                    permod = 1                    rgatemod = 0
+wpemod = 0
//*** geometry range parameter ***
+lmin = 2E-6                   lmax = 1E-5                   wmin = 1E-6
+wmax = 2E-6
//*** process parameter ***
+epsrox = 3.9                  toxe = tox_p_18_cap               toxm = tox_p_18_cap
+dtox = 3.1E-10                xj = 1.7E-7                   ndep = 8.5E17
+ngate = 8E19                  nsd = 1E20                    rsh = 9.68
+rshg = 0.1
//*** dw and dl parameter ***
+wint = 1.389287E-8            wl = 0                        wln = 1
+ww = 0                        wwn = 1                       wwl = 0
+lint = 0                      ll = 0                        lln = 1
+lw = 0                        lwn = 1                       lwl = 0
+llc = 0                       lwc = 0                       lwlc = 0
+wlc = 0                       wwc = 0                       wwlc = 0
+dwg = 0                       dwb = 0                       xl = 0+dxl_p_18_cap
+xw = 0+dxw_p_18_cap
//*** flicker noise model parameter ***
+noia = 7.45E41                noib = 1.57E26                noic = 2E10
+em = 2.1E7                    ef = 1.3
//***layout-dependent parasitics model parameter ***
+dmcg = 8.5E-8                 dmci = 8.5E-8                 dmdg = 0
+dmcgt = 0                     dwj = 0                       xgw = 0
+xgl = 0                       ngcon = 1
//*** vth related  parameter ***
+vth0 = -0.35906+dvth0_p_18_cap    lvth0 = 0+dlvth0_p_18_cap         wvth0 = 0+dwvth0_p_18_cap
+pvth0 = 0+dpvth0_p_18_cap         phin = 0                      k1 = 0.25
+k2 = -1.21927E-2              k3 = -3.3                     k3b = 1.200306
+w0 = 1.585076E-7              lpe0 = 7.519925E-8            lpeb = 5.608072E-8
+dvtp0 = 2.2E-6                dvtp1 = 0.2                   dvt0 = 0.20341
+dvt1 = 0.95146                dvt2 = 0.01                   dvt0w = 0
+dvt1w = 5.366499E6            dvt2w = 0
//*** mobility related parameter ***
+u0 = 1.96662E-2+du0_p_18_cap      lu0 = 0+dlu0_p_18_cap             wu0 = 0+dwu0_p_18_cap
+pu0 = 0+dpu0_p_18_cap             ua = 2.455E-10                ub = 2.56985E-18
+wub = -2.999987E-25           uc = 4.336286E-11             ud = 0
+vsat = 6.57315E4+dvsat_p_18_cap   a0 = 0.693823                 ags = 1.93352
+b0 = 0                        b1 = 0                        keta = -6.14042E-2
+a1 = 0                        a2 = 1                        rdsw = 327.6
+prwb = -0.249981              prwg = 0.25                   wr = 1
//*** subthreshold related parameter ***
+voff = -0.05137               voffl = -6.036214E-9          minv = 0
+nfactor = 0.627693            eta0 = 3.11538E-2             etab = -2.38505E-2
+dsub = 1.2725                 cit = 1E-4                    cdsc = 0
+cdscb = 0                     cdscd = 0
//*** output resistance related parameter ***
+pclm = 0.627258               pdiblc1 = 0                   pdiblc2 = 9.579679E-3
+pdiblcb = 0                   drout = 1.132692              pscbe1 = 9.264E8
+pscbe2 = 1E-20                pvag = 1.425                  delta = 0.02
+fprout = 390.234144           pdits = 5.042617E-3           pditsl = 100
+pditsd = 0                    alpha0 = 0                    alpha1 = 0.06
+beta0 = 13.5                  agidl = 7.8E-8                bgidl = 2.404E9
+cgidl = 0.47                  egidl = 0.14
//*** gate dielectric tunneling current ***
+aigbacc = 0.014               bigbacc = 2.7E-3              cigbacc = 0.121
+nigbacc = 4.8                 aigbinv = 0.37                bigbinv = 0.028
+cigbinv = 6.4E-3              eigbinv = 1.2                 nigbinv = 1.5
+aigc = 6.8E-3                 bigc = 5.91E-4                cigc = 0
+aigsd = 6.1E-3                bigsd = 2.14E-4               cigsd = 0.037
+dlcig = 2.21E-9               nigc = 2.31                   poxedge = 1
+pigcd = 2.25                  ntox = 1                      toxref = 3E-9
//*** capacitance parameter ***
+xpart = 1                     cgso = 2.2E-11+dcgso_p_18_cap     cgdo = 2.2E-11+dcgdo_p_18_cap
+cgbo = 0                      ckappas = 0.6                 ckappad = 0.6
+cf = 1.08E-10                 clc = 1E-7                    cle = 0.6
+dlc = 0                 dwc = 0                       noff = 2
+voffcv = -0.084               acde = 1.2                    moin = 6.4
+cgsl = 1E-10+dcgsl_p_18_cap    cgdl = 1E-10+dcgdl_p_18_cap
//*** souce/drain junction diode model parameter **
+ijthsrev = 0.01               ijthsfwd = 0.01               xjbvs = 1
+bvs = 10                      jss = 3.1E-7                  jsws = 1E-12
+jswgs = 2.87E-12              cjs = 9.7E-4+dcj_p_18_cap         mjs = 0.41
+mjsws = 0.097                 cjsws = 1.1E-10+dcjsw_p_18_cap    cjswgs = 2.3E-10+dcjswg_p_18_cap
+mjswgs = 0.88                 pbs = 0.75                    pbsws = 0.49
+pbswgs = 0.8
//** rf model related parameter ***
+xrcrg1 = 12                   xrcrg2 = 1                    rbpb = 50
+rbpd = 50                     rbps = 50                     rbdb = 50
+rbsb = 50                     gbmin = 1E-12
//*** stress effect related parameter ***
+saref = 6.1E-7                sbref = 6.1E-7                wlod = 2.86E-7
+ku0 = 1.2E-7                  kvsat = -0.34                 kvth0 = 1.7E-10
+tku0 = 0.24                   llodku0 = 1                   wlodku0 = 1
+llodvth = 1.8                 wlodvth = 1                   lku0 = 1.871E-7
+wku0 = 2.4E-7                 pku0 = -3.24E-14              lkvth0 = 2.4E-10
+wkvth0 = 1.8E-10              pkvth0 = 0                    stk2 = 0
+lodk2 = 1.9                   steta0 = 0                    lodeta0 = 1
//*** temperature coefficient ***
+tnom = 25                     ute = -1.2192                 kt1 = -0.2061
+kt1l = 0                      kt2 = -0.01232                ua1 = 4.0941E-9
+ub1 = -4.8969E-18             uc1 = -5.5E-11                at = 4.00001E4
+prt = 0                       njs = 1                       xtis = 3
+tpb = 1.9E-3                  tpbsw = 1.9E-3                tpbswg = 1.9E-3
+tcj = 7.98E-4                 tcjsw = 2.4E-4                tcjswg = 4.77E-3
//*** well proximity effect model parameters ***
+web = 0                       wec = 0                       kvth0we = -2E-3
+k2we = 0                      ku0we = -4.1E-3               scref = 1E-6
5:type=p  minr=1e-60
//*** flag parameter ***
+version = 4.3                 binunit = 2                   mobmod = 0
+capmod = 2                    rdsmod = 0                    igcmod = 1
+igbmod = 1                    rbodymod = 0                  trnqsmod = 0
+acnqsmod = 0                  fnoimod = 1                   tnoimod = 0
+diomod = 1                    permod = 1                    rgatemod = 0
+wpemod = 0
//*** geometry range parameter ***
+lmin = 1E-6                   lmax = 2E-6                   wmin = 1E-6
+wmax = 2E-6
//*** process parameter ***
+epsrox = 3.9                  toxe = tox_p_18_cap               toxm = tox_p_18_cap
+dtox = 3.1E-10                xj = 1.7E-7                   ndep = 8.5E17
+ngate = 8E19                  nsd = 1E20                    rsh = 9.68
+rshg = 0.1
//*** dw and dl parameter ***
+wint = 1.389287E-8            wl = 0                        wln = 1
+ww = 0                        wwn = 1                       wwl = 0
+lint = 0                      ll = 0                        lln = 1
+lw = 0                        lwn = 1                       lwl = 0
+llc = 0                       lwc = 0                       lwlc = 0
+wlc = 0                       wwc = 0                       wwlc = 0
+dwg = 0                       dwb = 0                       xl = 0+dxl_p_18_cap
+xw = 0+dxw_p_18_cap
//*** flicker noise model parameter ***
+noia = 7.45E41                noib = 1.57E26                noic = 2E10
+em = 2.1E7                    ef = 1.3
//***layout-dependent parasitics model parameter ***
+dmcg = 8.5E-8                 dmci = 8.5E-8                 dmdg = 0
+dmcgt = 0                     dwj = 0                       xgw = 0
+xgl = 0                       ngcon = 1
//*** vth related  parameter ***
+vth0 = -0.35906+dvth0_p_18_cap    lvth0 = 0+dlvth0_p_18_cap         wvth0 = 0+dwvth0_p_18_cap
+pvth0 = 0+dpvth0_p_18_cap         phin = 0                      k1 = 0.25
+k2 = -1.21927E-2              k3 = -3.3                     k3b = 1.200306
+w0 = 1.585076E-7              lpe0 = 7.519925E-8            lpeb = 5.608072E-8
+dvtp0 = 2.2E-6                dvtp1 = 0.2                   dvt0 = 0.20341
+dvt1 = 0.95146                dvt2 = 0.01                   dvt0w = 0
+dvt1w = 5.366499E6            dvt2w = 0
//*** mobility related parameter ***
+u0 = 1.96662E-2+du0_p_18_cap      lu0 = 0+dlu0_p_18_cap             wu0 = 0+dwu0_p_18_cap
+pu0 = 0+dpu0_p_18_cap             ua = 2.455E-10                ub = 2.56985E-18
+wub = -2.999987E-25           uc = 4.336286E-11             ud = 0
+vsat = 6.57315E4+dvsat_p_18_cap   a0 = 0.693823                 ags = 1.93352
+b0 = 0                        b1 = 0                        keta = -6.14042E-2
+a1 = 0                        a2 = 1                        rdsw = 327.6
+prwb = -0.249981              prwg = 0.25                   wr = 1
//*** subthreshold related parameter ***
+voff = -0.05137               voffl = -6.036214E-9          minv = 0
+nfactor = 0.627693            eta0 = 3.11538E-2             etab = -2.38505E-2
+dsub = 1.2725                 cit = 1E-4                    cdsc = 0
+cdscb = 0                     cdscd = 0
//*** output resistance related parameter ***
+pclm = 0.627258               pdiblc1 = 0                   pdiblc2 = 9.579679E-3
+pdiblcb = 0                   drout = 1.132692              pscbe1 = 9.264E8
+pscbe2 = 1E-20                pvag = 1.425                  delta = 0.02
+fprout = 390.234144           pdits = 5.042617E-3           pditsl = 100
+pditsd = 0                    alpha0 = 0                    alpha1 = 0.06
+beta0 = 13.5                  agidl = 7.8E-8                bgidl = 2.404E9
+cgidl = 0.47                  egidl = 0.14
//*** gate dielectric tunneling current ***
+aigbacc = 0.014               bigbacc = 2.7E-3              cigbacc = 0.121
+nigbacc = 4.8                 aigbinv = 0.37                bigbinv = 0.028
+cigbinv = 6.4E-3              eigbinv = 1.2                 nigbinv = 1.5
+aigc = 6.8E-3                 bigc = 5.91E-4                cigc = 0
+aigsd = 6.1E-3                bigsd = 2.14E-4               cigsd = 0.037
+dlcig = 2.21E-9               nigc = 2.31                   poxedge = 1
+pigcd = 2.25                  ntox = 1                      toxref = 3E-9
//*** capacitance parameter ***
+xpart = 1                     cgso = 2.2E-11+dcgso_p_18_cap     cgdo = 2.2E-11+dcgdo_p_18_cap
+cgbo = 0                      ckappas = 0.6                 ckappad = 0.6
+cf = 1.08E-10                 clc = 1E-7                    cle = 0.6
+dlc = 0                 dwc = 0                       noff = 2
+voffcv = -0.084               acde = 1.2                    moin = 6.4
+cgsl = 1E-10+dcgsl_p_18_cap    cgdl = 1E-10+dcgdl_p_18_cap
//*** souce/drain junction diode model parameter **
+ijthsrev = 0.01               ijthsfwd = 0.01               xjbvs = 1
+bvs = 10                      jss = 3.1E-7                  jsws = 1E-12
+jswgs = 2.87E-12              cjs = 9.7E-4+dcj_p_18_cap         mjs = 0.41
+mjsws = 0.097                 cjsws = 1.1E-10+dcjsw_p_18_cap    cjswgs = 2.3E-10+dcjswg_p_18_cap
+mjswgs = 0.88                 pbs = 0.75                    pbsws = 0.49
+pbswgs = 0.8
//** rf model related parameter ***
+xrcrg1 = 12                   xrcrg2 = 1                    rbpb = 50
+rbpd = 50                     rbps = 50                     rbdb = 50
+rbsb = 50                     gbmin = 1E-12
//*** stress effect related parameter ***
+saref = 6.1E-7                sbref = 6.1E-7                wlod = 2.86E-7
+ku0 = 1.2E-7                  kvsat = -0.34                 kvth0 = 1.7E-10
+tku0 = 0.24                   llodku0 = 1                   wlodku0 = 1
+llodvth = 1.8                 wlodvth = 1                   lku0 = 1.871E-7
+wku0 = 2.4E-7                 pku0 = -3.24E-14              lkvth0 = 2.4E-10
+wkvth0 = 1.8E-10              pkvth0 = 0                    stk2 = 0
+lodk2 = 1.9                   steta0 = 0                    lodeta0 = 1
//*** temperature coefficient ***
+tnom = 25                     ute = -1.2192                 kt1 = -0.2061
+kt1l = 0                      kt2 = -0.01232                ua1 = 4.0941E-9
+ub1 = -4.8969E-18             uc1 = -5.5E-11                at = 4.00001E4
+prt = 0                       njs = 1                       xtis = 3
+tpb = 1.9E-3                  tpbsw = 1.9E-3                tpbswg = 1.9E-3
+tcj = 7.98E-4                 tcjsw = 2.4E-4                tcjswg = 4.77E-3
//*** well proximity effect model parameters ***
+web = 0                       wec = 0                       kvth0we = -2E-3
+k2we = 0                      ku0we = -4.1E-3               scref = 1E-6
6:type=p  minr=1e-60
//*** flag parameter ***
+version = 4.3                 binunit = 2                   mobmod = 0
+capmod = 2                    rdsmod = 0                    igcmod = 1
+igbmod = 1                    rbodymod = 0                  trnqsmod = 0
+acnqsmod = 0                  fnoimod = 1                   tnoimod = 0
+diomod = 1                    permod = 1                    rgatemod = 0
+wpemod = 0
//*** geometry range parameter ***
+lmin = 1.5E-7                 lmax = 1E-6                   wmin = 1E-6
+wmax = 2E-6
//*** process parameter ***
+epsrox = 3.9                  toxe = tox_p_18_cap               toxm = tox_p_18_cap
+dtox = 3.1E-10                xj = 1.7E-7                   ndep = 8.5E17
+ngate = 8E19                  nsd = 1E20                    rsh = 9.68
+rshg = 0.1
//*** dw and dl parameter ***
+wint = 1.389287E-8            wl = 0                        wln = 1
+ww = 0                        wwn = 1                       wwl = 0
+lint = 0                      ll = 0                        lln = 1
+lw = 0                        lwn = 1                       lwl = 0
+llc = 0                       lwc = 0                       lwlc = 0
+wlc = 0                       wwc = 0                       wwlc = 0
+dwg = 0                       dwb = 0                       xl = 0+dxl_p_18_cap
+xw = 0+dxw_p_18_cap
//*** flicker noise model parameter ***
+noia = 7.45E41                noib = 1.57E26                noic = 2E10
+em = 2.1E7                    ef = 1.3
//***layout-dependent parasitics model parameter ***
+dmcg = 8.5E-8                 dmci = 8.5E-8                 dmdg = 0
+dmcgt = 0                     dwj = 0                       xgw = 0
+xgl = 0                       ngcon = 1
//*** vth related  parameter ***
+vth0 = -0.35906+dvth0_p_18_cap    lvth0 = 0+dlvth0_p_18_cap         wvth0 = 0+dwvth0_p_18_cap
+pvth0 = 0+dpvth0_p_18_cap         phin = 0                      k1 = 0.25
+k2 = -1.21927E-2              k3 = -3.3                     k3b = 1.200306
+w0 = 1.585076E-7              lpe0 = 7.519925E-8            lpeb = 5.608072E-8
+dvtp0 = 2.2E-6                dvtp1 = 0.2                   dvt0 = 0.20341
+dvt1 = 0.95146                dvt2 = 0.01                   dvt0w = 0
+dvt1w = 5.366499E6            dvt2w = 0
//*** mobility related parameter ***
+u0 = 1.96662E-2+du0_p_18_cap      lu0 = 0+dlu0_p_18_cap             wu0 = 0+dwu0_p_18_cap
+pu0 = 0+dpu0_p_18_cap             ua = 2.455E-10                ub = 2.56985E-18
+wub = -2.999987E-25           uc = 4.336286E-11             ud = 0
+vsat = 6.57315E4+dvsat_p_18_cap   a0 = 0.693823                 ags = 1.93352
+b0 = 0                        b1 = 0                        keta = -6.14042E-2
+a1 = 0                        a2 = 1                        rdsw = 327.6
+prwb = -0.249981              prwg = 0.25                   wr = 1
//*** subthreshold related parameter ***
+voff = -0.05137               voffl = -6.036214E-9          minv = 0
+nfactor = 0.627693            eta0 = 3.11538E-2             etab = -2.38505E-2
+dsub = 1.2725                 cit = 1E-4                    cdsc = 0
+cdscb = 0                     cdscd = 0
//*** output resistance related parameter ***
+pclm = 0.627258               pdiblc1 = 0                   pdiblc2 = 9.579679E-3
+pdiblcb = 0                   drout = 1.132692              pscbe1 = 9.264E8
+pscbe2 = 1E-20                pvag = 1.425                  delta = 0.02
+fprout = 390.234144           pdits = 5.042617E-3           pditsl = 100
+pditsd = 0                    alpha0 = 0                    alpha1 = 0.06
+beta0 = 13.5                  agidl = 7.8E-8                bgidl = 2.404E9
+cgidl = 0.47                  egidl = 0.14
//*** gate dielectric tunneling current ***
+aigbacc = 0.014               bigbacc = 2.7E-3              cigbacc = 0.121
+nigbacc = 4.8                 aigbinv = 0.37                bigbinv = 0.028
+cigbinv = 6.4E-3              eigbinv = 1.2                 nigbinv = 1.5
+aigc = 6.8E-3                 bigc = 5.91E-4                cigc = 0
+aigsd = 6.1E-3                bigsd = 2.14E-4               cigsd = 0.037
+dlcig = 2.21E-9               nigc = 2.31                   poxedge = 1
+pigcd = 2.25                  ntox = 1                      toxref = 3E-9
//*** capacitance parameter ***
+xpart = 1                     cgso = 2.2E-11+dcgso_p_18_cap     cgdo = 2.2E-11+dcgdo_p_18_cap
+cgbo = 0                      ckappas = 0.6                 ckappad = 0.6
+cf = 1.08E-10                 clc = 1E-7                    cle = 0.6
+dlc = 0                 dwc = 0                       noff = 2
+voffcv = -0.084               acde = 1.2                    moin = 6.4
+cgsl = 1E-10+dcgsl_p_18_cap    cgdl = 1E-10+dcgdl_p_18_cap
//*** souce/drain junction diode model parameter **
+ijthsrev = 0.01               ijthsfwd = 0.01               xjbvs = 1
+bvs = 10                      jss = 3.1E-7                  jsws = 1E-12
+jswgs = 2.87E-12              cjs = 9.7E-4+dcj_p_18_cap         mjs = 0.41
+mjsws = 0.097                 cjsws = 1.1E-10+dcjsw_p_18_cap    cjswgs = 2.3E-10+dcjswg_p_18_cap
+mjswgs = 0.88                 pbs = 0.75                    pbsws = 0.49
+pbswgs = 0.8
//** rf model related parameter ***
+xrcrg1 = 12                   xrcrg2 = 1                    rbpb = 50
+rbpd = 50                     rbps = 50                     rbdb = 50
+rbsb = 50                     gbmin = 1E-12
//*** stress effect related parameter ***
+saref = 6.1E-7                sbref = 6.1E-7                wlod = 2.86E-7
+ku0 = 1.2E-7                  kvsat = -0.34                 kvth0 = 1.7E-10
+tku0 = 0.24                   llodku0 = 1                   wlodku0 = 1
+llodvth = 1.8                 wlodvth = 1                   lku0 = 1.871E-7
+wku0 = 2.4E-7                 pku0 = -3.24E-14              lkvth0 = 2.4E-10
+wkvth0 = 1.8E-10              pkvth0 = 0                    stk2 = 0
+lodk2 = 1.9                   steta0 = 0                    lodeta0 = 1
//*** temperature coefficient ***
+tnom = 25                     ute = -1.2192                 kt1 = -0.2061
+kt1l = 0                      kt2 = -0.01232                ua1 = 4.0941E-9
+ub1 = -4.8969E-18             uc1 = -5.5E-11                at = 4.00001E4
+prt = 0                       njs = 1                       xtis = 3
+tpb = 1.9E-3                  tpbsw = 1.9E-3                tpbswg = 1.9E-3
+tcj = 7.98E-4                 tcjsw = 2.4E-4                tcjswg = 4.77E-3
//*** well proximity effect model parameters ***
+web = 0                       wec = 0                       kvth0we = -2E-3
+k2we = 0                      ku0we = -4.1E-3               scref = 1E-6
7:type=p  minr=1e-60
//*** flag parameter ***
+version = 4.3                 binunit = 2                   mobmod = 0
+capmod = 2                    rdsmod = 0                    igcmod = 1
+igbmod = 1                    rbodymod = 0                  trnqsmod = 0
+acnqsmod = 0                  fnoimod = 1                   tnoimod = 0
+diomod = 1                    permod = 1                    rgatemod = 0
+wpemod = 0
//*** geometry range parameter ***
+lmin = 2E-6                   lmax = 1E-5                   wmin = 5E-7
+wmax = 1E-6
//*** process parameter ***
+epsrox = 3.9                  toxe = tox_p_18_cap               toxm = tox_p_18_cap
+dtox = 3.1E-10                xj = 1.7E-7                   ndep = 8.5E17
+ngate = 8E19                  nsd = 1E20                    rsh = 9.68
+rshg = 0.1
//*** dw and dl parameter ***
+wint = 1.389287E-8            wl = 0                        wln = 1
+ww = 0                        wwn = 1                       wwl = 0
+lint = 0                      ll = 0                        lln = 1
+lw = 0                        lwn = 1                       lwl = 0
+llc = 0                       lwc = 0                       lwlc = 0
+wlc = 0                       wwc = 0                       wwlc = 0
+dwg = 0                       dwb = 0                       xl = 0+dxl_p_18_cap
+xw = 0+dxw_p_18_cap
//*** flicker noise model parameter ***
+noia = 7.45E41                noib = 1.57E26                noic = 2E10
+em = 2.1E7                    ef = 1.3
//***layout-dependent parasitics model parameter ***
+dmcg = 8.5E-8                 dmci = 8.5E-8                 dmdg = 0
+dmcgt = 0                     dwj = 0                       xgw = 0
+xgl = 0                       ngcon = 1
//*** vth related  parameter ***
+vth0 = -0.35906+dvth0_p_18_cap    lvth0 = 0+dlvth0_p_18_cap         wvth0 = 0+dwvth0_p_18_cap
+pvth0 = 0+dpvth0_p_18_cap         phin = 0                      k1 = 0.25
+k2 = -1.21927E-2              k3 = -3.3                     k3b = 1.200306
+w0 = 1.585076E-7              lpe0 = 7.519925E-8            lpeb = 5.608072E-8
+dvtp0 = 2.2E-6                dvtp1 = 0.2                   dvt0 = 0.20341
+dvt1 = 0.95146                dvt2 = 0.01                   dvt0w = 0
+dvt1w = 5.366499E6            dvt2w = 0
//*** mobility related parameter ***
+u0 = 1.96662E-2+du0_p_18_cap      lu0 = 0+dlu0_p_18_cap             wu0 = 0+dwu0_p_18_cap
+pu0 = 0+dpu0_p_18_cap             ua = 2.455E-10                ub = 2.569851E-18
+wub = -3.000001E-25           uc = 4.336286E-11             ud = 0
+vsat = 6.57315E4+dvsat_p_18_cap   a0 = 0.693823                 ags = 1.93352
+b0 = 0                        b1 = 0                        keta = -6.14042E-2
+a1 = 0                        a2 = 1                        rdsw = 327.6
+prwb = -0.249981              prwg = 0.25                   wr = 1
//*** subthreshold related parameter ***
+voff = -0.05137               voffl = -6.036214E-9          minv = 0
+nfactor = 0.627693            eta0 = 3.11538E-2             etab = -2.38505E-2
+dsub = 1.2725                 cit = 1E-4                    cdsc = 0
+cdscb = 0                     cdscd = 0
//*** output resistance related parameter ***
+pclm = 0.627258               pdiblc1 = 0                   pdiblc2 = 9.579679E-3
+pdiblcb = 0                   drout = 1.132692              pscbe1 = 9.264E8
+pscbe2 = 1E-20                pvag = 1.425                  delta = 0.02
+fprout = 390.234144           pdits = 5.042617E-3           pditsl = 100
+pditsd = 0                    alpha0 = 0                    alpha1 = 0.06
+beta0 = 13.5                  agidl = 7.8E-8                bgidl = 2.404E9
+cgidl = 0.47                  egidl = 0.14
//*** gate dielectric tunneling current ***
+aigbacc = 0.014               bigbacc = 2.7E-3              cigbacc = 0.121
+nigbacc = 4.8                 aigbinv = 0.37                bigbinv = 0.028
+cigbinv = 6.4E-3              eigbinv = 1.2                 nigbinv = 1.5
+aigc = 6.8E-3                 bigc = 5.91E-4                cigc = 0
+aigsd = 6.1E-3                bigsd = 2.14E-4               cigsd = 0.037
+dlcig = 2.21E-9               nigc = 2.31                   poxedge = 1
+pigcd = 2.25                  ntox = 1                      toxref = 3E-9
//*** capacitance parameter ***
+xpart = 1                     cgso = 2.2E-11+dcgso_p_18_cap     cgdo = 2.2E-11+dcgdo_p_18_cap
+cgbo = 0                      ckappas = 0.6                 ckappad = 0.6
+cf = 1.08E-10                 clc = 1E-7                    cle = 0.6
+dlc = 0                 dwc = 0                       noff = 2
+voffcv = -0.084               acde = 1.2                    moin = 6.4
+cgsl = 1E-10+dcgsl_p_18_cap    cgdl = 1E-10+dcgdl_p_18_cap
//*** souce/drain junction diode model parameter **
+ijthsrev = 0.01               ijthsfwd = 0.01               xjbvs = 1
+bvs = 10                      jss = 3.1E-7                  jsws = 1E-12
+jswgs = 2.87E-12              cjs = 9.7E-4+dcj_p_18_cap         mjs = 0.41
+mjsws = 0.097                 cjsws = 1.1E-10+dcjsw_p_18_cap    cjswgs = 2.3E-10+dcjswg_p_18_cap
+mjswgs = 0.88                 pbs = 0.75                    pbsws = 0.49
+pbswgs = 0.8
//** rf model related parameter ***
+xrcrg1 = 12                   xrcrg2 = 1                    rbpb = 50
+rbpd = 50                     rbps = 50                     rbdb = 50
+rbsb = 50                     gbmin = 1E-12
//*** stress effect related parameter ***
+saref = 6.1E-7                sbref = 6.1E-7                wlod = 2.86E-7
+ku0 = 1.2E-7                  kvsat = -0.34                 kvth0 = 1.7E-10
+tku0 = 0.24                   llodku0 = 1                   wlodku0 = 1
+llodvth = 1.8                 wlodvth = 1                   lku0 = 1.871E-7
+wku0 = 2.4E-7                 pku0 = -3.24E-14              lkvth0 = 2.4E-10
+wkvth0 = 1.8E-10              pkvth0 = 0                    stk2 = 0
+lodk2 = 1.9                   steta0 = 0                    lodeta0 = 1
//*** temperature coefficient ***
+tnom = 25                     ute = -1.2192                 kt1 = -0.2061
+kt1l = 0                      kt2 = -0.01232                ua1 = 4.0941E-9
+ub1 = -4.8969E-18             uc1 = -5.5E-11                at = 4.00001E4
+prt = 0                       njs = 1                       xtis = 3
+tpb = 1.9E-3                  tpbsw = 1.9E-3                tpbswg = 1.9E-3
+tcj = 7.98E-4                 tcjsw = 2.4E-4                tcjswg = 4.77E-3
//*** well proximity effect model parameters ***
+web = 0                       wec = 0                       kvth0we = -2E-3
+k2we = 0                      ku0we = -4.1E-3               scref = 1E-6
8:type=p  minr=1e-60
//*** flag parameter ***
+version = 4.3                 binunit = 2                   mobmod = 0
+capmod = 2                    rdsmod = 0                    igcmod = 1
+igbmod = 1                    rbodymod = 0                  trnqsmod = 0
+acnqsmod = 0                  fnoimod = 1                   tnoimod = 0
+diomod = 1                    permod = 1                    rgatemod = 0
+wpemod = 0
//*** geometry range parameter ***
+lmin = 1E-6                   lmax = 2E-6                   wmin = 5E-7
+wmax = 1E-6
//*** process parameter ***
+epsrox = 3.9                  toxe = tox_p_18_cap               toxm = tox_p_18_cap
+dtox = 3.1E-10                xj = 1.7E-7                   ndep = 8.5E17
+ngate = 8E19                  nsd = 1E20                    rsh = 9.68
+rshg = 0.1
//*** dw and dl parameter ***
+wint = 1.389287E-8            wl = 0                        wln = 1
+ww = 0                        wwn = 1                       wwl = 0
+lint = 0                      ll = 0                        lln = 1
+lw = 0                        lwn = 1                       lwl = 0
+llc = 0                       lwc = 0                       lwlc = 0
+wlc = 0                       wwc = 0                       wwlc = 0
+dwg = 0                       dwb = 0                       xl = 0+dxl_p_18_cap
+xw = 0+dxw_p_18_cap
//*** flicker noise model parameter ***
+noia = 7.45E41                noib = 1.57E26                noic = 2E10
+em = 2.1E7                    ef = 1.3
//***layout-dependent parasitics model parameter ***
+dmcg = 8.5E-8                 dmci = 8.5E-8                 dmdg = 0
+dmcgt = 0                     dwj = 0                       xgw = 0
+xgl = 0                       ngcon = 1
//*** vth related  parameter ***
+vth0 = -0.35906+dvth0_p_18_cap    lvth0 = 0+dlvth0_p_18_cap         wvth0 = 0+dwvth0_p_18_cap
+pvth0 = 0+dpvth0_p_18_cap         phin = 0                      k1 = 0.25
+k2 = -1.21927E-2              k3 = -3.3                     k3b = 1.200306
+w0 = 1.585076E-7              lpe0 = 7.519925E-8            lpeb = 5.608072E-8
+dvtp0 = 2.2E-6                dvtp1 = 0.2                   dvt0 = 0.20341
+dvt1 = 0.95146                dvt2 = 0.01                   dvt0w = 0
+dvt1w = 5.366499E6            dvt2w = 0
//*** mobility related parameter ***
+u0 = 1.96662E-2+du0_p_18_cap      lu0 = 0+dlu0_p_18_cap             wu0 = 0+dwu0_p_18_cap
+pu0 = 0+dpu0_p_18_cap             ua = 2.455E-10                ub = 2.569851E-18
+wub = -3.000001E-25           uc = 4.336286E-11             ud = 0
+vsat = 6.57315E4+dvsat_p_18_cap   a0 = 0.693823                 ags = 1.93352
+b0 = 0                        b1 = 0                        keta = -6.14042E-2
+a1 = 0                        a2 = 1                        rdsw = 327.6
+prwb = -0.249981              prwg = 0.25                   wr = 1
//*** subthreshold related parameter ***
+voff = -0.05137               voffl = -6.036214E-9          minv = 0
+nfactor = 0.627693            eta0 = 3.11538E-2             etab = -2.38505E-2
+dsub = 1.2725                 cit = 1E-4                    cdsc = 0
+cdscb = 0                     cdscd = 0
//*** output resistance related parameter ***
+pclm = 0.627258               pdiblc1 = 0                   pdiblc2 = 9.579679E-3
+pdiblcb = 0                   drout = 1.132692              pscbe1 = 9.264E8
+pscbe2 = 1E-20                pvag = 1.425                  delta = 0.02
+fprout = 390.234144           pdits = 5.042617E-3           pditsl = 100
+pditsd = 0                    alpha0 = 0                    alpha1 = 0.06
+beta0 = 13.5                  agidl = 7.8E-8                bgidl = 2.404E9
+cgidl = 0.47                  egidl = 0.14
//*** gate dielectric tunneling current ***
+aigbacc = 0.014               bigbacc = 2.7E-3              cigbacc = 0.121
+nigbacc = 4.8                 aigbinv = 0.37                bigbinv = 0.028
+cigbinv = 6.4E-3              eigbinv = 1.2                 nigbinv = 1.5
+aigc = 6.8E-3                 bigc = 5.91E-4                cigc = 0
+aigsd = 6.1E-3                bigsd = 2.14E-4               cigsd = 0.037
+dlcig = 2.21E-9               nigc = 2.31                   poxedge = 1
+pigcd = 2.25                  ntox = 1                      toxref = 3E-9
//*** capacitance parameter ***
+xpart = 1                     cgso = 2.2E-11+dcgso_p_18_cap     cgdo = 2.2E-11+dcgdo_p_18_cap
+cgbo = 0                      ckappas = 0.6                 ckappad = 0.6
+cf = 1.08E-10                 clc = 1E-7                    cle = 0.6
+dlc = 0                 dwc = 0                       noff = 2
+voffcv = -0.084               acde = 1.2                    moin = 6.4
+cgsl = 1E-10+dcgsl_p_18_cap    cgdl = 1E-10+dcgdl_p_18_cap
//*** souce/drain junction diode model parameter **
+ijthsrev = 0.01               ijthsfwd = 0.01               xjbvs = 1
+bvs = 10                      jss = 3.1E-7                  jsws = 1E-12
+jswgs = 2.87E-12              cjs = 9.7E-4+dcj_p_18_cap         mjs = 0.41
+mjsws = 0.097                 cjsws = 1.1E-10+dcjsw_p_18_cap    cjswgs = 2.3E-10+dcjswg_p_18_cap
+mjswgs = 0.88                 pbs = 0.75                    pbsws = 0.49
+pbswgs = 0.8
//** rf model related parameter ***
+xrcrg1 = 12                   xrcrg2 = 1                    rbpb = 50
+rbpd = 50                     rbps = 50                     rbdb = 50
+rbsb = 50                     gbmin = 1E-12
//*** stress effect related parameter ***
+saref = 6.1E-7                sbref = 6.1E-7                wlod = 2.86E-7
+ku0 = 1.2E-7                  kvsat = -0.34                 kvth0 = 1.7E-10
+tku0 = 0.24                   llodku0 = 1                   wlodku0 = 1
+llodvth = 1.8                 wlodvth = 1                   lku0 = 1.871E-7
+wku0 = 2.4E-7                 pku0 = -3.24E-14              lkvth0 = 2.4E-10
+wkvth0 = 1.8E-10              pkvth0 = 0                    stk2 = 0
+lodk2 = 1.9                   steta0 = 0                    lodeta0 = 1
//*** temperature coefficient ***
+tnom = 25                     ute = -1.2192                 kt1 = -0.2061
+kt1l = 0                      kt2 = -0.01232                ua1 = 4.0941E-9
+ub1 = -4.8969E-18             uc1 = -5.5E-11                at = 4.00001E4
+prt = 0                       njs = 1                       xtis = 3
+tpb = 1.9E-3                  tpbsw = 1.9E-3                tpbswg = 1.9E-3
+tcj = 7.98E-4                 tcjsw = 2.4E-4                tcjswg = 4.77E-3
//*** well proximity effect model parameters ***
+web = 0                       wec = 0                       kvth0we = -2E-3
+k2we = 0                      ku0we = -4.1E-3               scref = 1E-6
9:type=p  minr=1e-60
//*** flag parameter ***
+version = 4.3                 binunit = 2                   mobmod = 0
+capmod = 2                    rdsmod = 0                    igcmod = 1
+igbmod = 1                    rbodymod = 0                  trnqsmod = 0
+acnqsmod = 0                  fnoimod = 1                   tnoimod = 0
+diomod = 1                    permod = 1                    rgatemod = 0
+wpemod = 0
//*** geometry range parameter ***
+lmin = 1.5E-7                 lmax = 1E-6                   wmin = 5E-7
+wmax = 1E-6
//*** process parameter ***
+epsrox = 3.9                  toxe = tox_p_18_cap               toxm = tox_p_18_cap
+dtox = 3.1E-10                xj = 1.7E-7                   ndep = 8.5E17
+ngate = 8E19                  nsd = 1E20                    rsh = 9.68
+rshg = 0.1
//*** dw and dl parameter ***
+wint = 1.389287E-8            wl = 0                        wln = 1
+ww = 0                        wwn = 1                       wwl = 0
+lint = 0                      ll = 0                        lln = 1
+lw = 0                        lwn = 1                       lwl = 0
+llc = 0                       lwc = 0                       lwlc = 0
+wlc = 0                       wwc = 0                       wwlc = 0
+dwg = 0                       dwb = 0                       xl = 0+dxl_p_18_cap
+xw = 0+dxw_p_18_cap
//*** flicker noise model parameter ***
+noia = 7.45E41                noib = 1.57E26                noic = 2E10
+em = 2.1E7                    ef = 1.3
//***layout-dependent parasitics model parameter ***
+dmcg = 8.5E-8                 dmci = 8.5E-8                 dmdg = 0
+dmcgt = 0                     dwj = 0                       xgw = 0
+xgl = 0                       ngcon = 1
//*** vth related  parameter ***
+vth0 = -0.35906+dvth0_p_18_cap    lvth0 = 0+dlvth0_p_18_cap         wvth0 = 0+dwvth0_p_18_cap
+pvth0 = 0+dpvth0_p_18_cap         phin = 0                      k1 = 0.25
+k2 = -1.21927E-2              k3 = -3.3                     k3b = 1.200306
+w0 = 1.585076E-7              lpe0 = 7.519925E-8            lpeb = 5.608072E-8
+dvtp0 = 2.2E-6                dvtp1 = 0.2                   dvt0 = 0.20341
+dvt1 = 0.95146                dvt2 = 0.01                   dvt0w = 0
+dvt1w = 5.366499E6            dvt2w = 0
//*** mobility related parameter ***
+u0 = 1.96662E-2+du0_p_18_cap      lu0 = 0+dlu0_p_18_cap             wu0 = 0+dwu0_p_18_cap
+pu0 = 0+dpu0_p_18_cap             ua = 2.455E-10                ub = 2.569851E-18
+wub = -3.000001E-25           uc = 4.336286E-11             ud = 0
+vsat = 6.57315E4+dvsat_p_18_cap   a0 = 0.693823                 ags = 1.93352
+b0 = 0                        b1 = 0                        keta = -6.14042E-2
+a1 = 0                        a2 = 1                        rdsw = 327.6
+prwb = -0.249981              prwg = 0.25                   wr = 1
//*** subthreshold related parameter ***
+voff = -0.05137               voffl = -6.036214E-9          minv = 0
+nfactor = 0.627693            eta0 = 3.11538E-2             etab = -2.38505E-2
+dsub = 1.2725                 cit = 1E-4                    cdsc = 0
+cdscb = 0                     cdscd = 0
//*** output resistance related parameter ***
+pclm = 0.627258               pdiblc1 = 0                   pdiblc2 = 9.579679E-3
+pdiblcb = 0                   drout = 1.132692              pscbe1 = 9.264E8
+pscbe2 = 1E-20                pvag = 1.425                  delta = 0.02
+fprout = 390.234144           pdits = 5.042617E-3           pditsl = 100
+pditsd = 0                    alpha0 = 0                    alpha1 = 0.06
+beta0 = 13.5                  agidl = 7.8E-8                bgidl = 2.404E9
+cgidl = 0.47                  egidl = 0.14
//*** gate dielectric tunneling current ***
+aigbacc = 0.014               bigbacc = 2.7E-3              cigbacc = 0.121
+nigbacc = 4.8                 aigbinv = 0.37                bigbinv = 0.028
+cigbinv = 6.4E-3              eigbinv = 1.2                 nigbinv = 1.5
+aigc = 6.8E-3                 bigc = 5.91E-4                cigc = 0
+aigsd = 6.1E-3                bigsd = 2.14E-4               cigsd = 0.037
+dlcig = 2.21E-9               nigc = 2.31                   poxedge = 1
+pigcd = 2.25                  ntox = 1                      toxref = 3E-9
//*** capacitance parameter ***
+xpart = 1                     cgso = 2.2E-11+dcgso_p_18_cap     cgdo = 2.2E-11+dcgdo_p_18_cap
+cgbo = 0                      ckappas = 0.6                 ckappad = 0.6
+cf = 1.08E-10                 clc = 1E-7                    cle = 0.6
+dlc = 0                 dwc = 0                       noff = 2
+voffcv = -0.084               acde = 1.2                    moin = 6.4
+cgsl = 1E-10+dcgsl_p_18_cap    cgdl = 1E-10+dcgdl_p_18_cap
//*** souce/drain junction diode model parameter **
+ijthsrev = 0.01               ijthsfwd = 0.01               xjbvs = 1
+bvs = 10                      jss = 3.1E-7                  jsws = 1E-12
+jswgs = 2.87E-12              cjs = 9.7E-4+dcj_p_18_cap         mjs = 0.41
+mjsws = 0.097                 cjsws = 1.1E-10+dcjsw_p_18_cap    cjswgs = 2.3E-10+dcjswg_p_18_cap
+mjswgs = 0.88                 pbs = 0.75                    pbsws = 0.49
+pbswgs = 0.8
//** rf model related parameter ***
+xrcrg1 = 12                   xrcrg2 = 1                    rbpb = 50
+rbpd = 50                     rbps = 50                     rbdb = 50
+rbsb = 50                     gbmin = 1E-12
//*** stress effect related parameter ***
+saref = 6.1E-7                sbref = 6.1E-7                wlod = 2.86E-7
+ku0 = 1.2E-7                  kvsat = -0.34                 kvth0 = 1.7E-10
+tku0 = 0.24                   llodku0 = 1                   wlodku0 = 1
+llodvth = 1.8                 wlodvth = 1                   lku0 = 1.871E-7
+wku0 = 2.4E-7                 pku0 = -3.24E-14              lkvth0 = 2.4E-10
+wkvth0 = 1.8E-10              pkvth0 = 0                    stk2 = 0
+lodk2 = 1.9                   steta0 = 0                    lodeta0 = 1
//*** temperature coefficient ***
+tnom = 25                     ute = -1.2192                 kt1 = -0.2061
+kt1l = 0                      kt2 = -0.01232                ua1 = 4.0941E-9
+ub1 = -4.8969E-18             uc1 = -5.5E-11                at = 4.00001E4
+prt = 0                       njs = 1                       xtis = 3
+tpb = 1.9E-3                  tpbsw = 1.9E-3                tpbswg = 1.9E-3
+tcj = 7.98E-4                 tcjsw = 2.4E-4                tcjswg = 4.77E-3
//*** well proximity effect model parameters ***
+web = 0                       wec = 0                       kvth0we = -2E-3
+k2we = 0                      ku0we = -4.1E-3               scref = 1E-6
10:type=p  minr=1e-60
//*** flag parameter ***
+version = 4.3                 binunit = 2                   mobmod = 0
+capmod = 2                    rdsmod = 0                    igcmod = 1
+igbmod = 1                    rbodymod = 0                  trnqsmod = 0
+acnqsmod = 0                  fnoimod = 1                   tnoimod = 0
+diomod = 1                    permod = 1                    rgatemod = 0
+wpemod = 0
//*** geometry range parameter ***
+lmin = 2E-6                   lmax = 1E-5                   wmin = 3.2E-7
+wmax = 5E-7
//*** process parameter ***
+epsrox = 3.9                  toxe = tox_p_18_cap               toxm = tox_p_18_cap
+dtox = 3.1E-10                xj = 1.7E-7                   ndep = 8.5E17
+ngate = 8E19                  nsd = 1E20                    rsh = 9.68
+rshg = 0.1
//*** dw and dl parameter ***
+wint = 1.389287E-8            wl = 0                        wln = 1
+ww = 0                        wwn = 1                       wwl = 0
+lint = 0                      ll = 0                        lln = 1
+lw = 0                        lwn = 1                       lwl = 0
+llc = 0                       lwc = 0                       lwlc = 0
+wlc = 0                       wwc = 0                       wwlc = 0
+dwg = 0                       dwb = 0                       xl = 0+dxl_p_18_cap
+xw = 0+dxw_p_18_cap
//*** flicker noise model parameter ***
+noia = 7.45E41                noib = 1.57E26                noic = 2E10
+em = 2.1E7                    ef = 1.3
//***layout-dependent parasitics model parameter ***
+dmcg = 8.5E-8                 dmci = 8.5E-8                 dmdg = 0
+dmcgt = 0                     dwj = 0                       xgw = 0
+xgl = 0                       ngcon = 1
//*** vth related  parameter ***
+vth0 = -0.35906+dvth0_p_18_cap    lvth0 = 0+dlvth0_p_18_cap         wvth0 = 0+dwvth0_p_18_cap
+pvth0 = 0+dpvth0_p_18_cap         phin = 0                      k1 = 0.25
+k2 = -1.21927E-2              k3 = -3.3                     k3b = 1.200306
+w0 = 1.585076E-7              lpe0 = 7.519925E-8            lpeb = 5.608072E-8
+dvtp0 = 2.2E-6                dvtp1 = 0.2                   dvt0 = 0.20341
+dvt1 = 0.95146                dvt2 = 0.01                   dvt0w = 0
+dvt1w = 5.366499E6            dvt2w = 0
//*** mobility related parameter ***
+u0 = 1.96662E-2+du0_p_18_cap      lu0 = 0+dlu0_p_18_cap             wu0 = 0+dwu0_p_18_cap
+pu0 = 0+dpu0_p_18_cap             ua = 2.455E-10                ub = 2.569851E-18
+wub = -2.999999E-25           uc = 4.336286E-11             ud = 0
+vsat = 6.57315E4+dvsat_p_18_cap   a0 = 0.693823                 ags = 1.93352
+b0 = 0                        b1 = 0                        keta = -6.14042E-2
+a1 = 0                        a2 = 1                        rdsw = 327.6
+prwb = -0.249981              prwg = 0.25                   wr = 1
//*** subthreshold related parameter ***
+voff = -0.05137               voffl = -6.036214E-9          minv = 0
+nfactor = 0.627693            eta0 = 3.11538E-2             etab = -2.38505E-2
+dsub = 1.2725                 cit = 1E-4                    cdsc = 0
+cdscb = 0                     cdscd = 0
//*** output resistance related parameter ***
+pclm = 0.627258               pdiblc1 = 0                   pdiblc2 = 9.579679E-3
+pdiblcb = 0                   drout = 1.132692              pscbe1 = 9.264E8
+pscbe2 = 1E-20                pvag = 1.425                  delta = 0.02
+fprout = 390.234144           pdits = 5.042617E-3           pditsl = 100
+pditsd = 0                    alpha0 = 0                    alpha1 = 0.06
+beta0 = 13.5                  agidl = 7.8E-8                bgidl = 2.404E9
+cgidl = 0.47                  egidl = 0.14
//*** gate dielectric tunneling current ***
+aigbacc = 0.014               bigbacc = 2.7E-3              cigbacc = 0.121
+nigbacc = 4.8                 aigbinv = 0.37                bigbinv = 0.028
+cigbinv = 6.4E-3              eigbinv = 1.2                 nigbinv = 1.5
+aigc = 6.8E-3                 bigc = 5.91E-4                cigc = 0
+aigsd = 6.1E-3                bigsd = 2.14E-4               cigsd = 0.037
+dlcig = 2.21E-9               nigc = 2.31                   poxedge = 1
+pigcd = 2.25                  ntox = 1                      toxref = 3E-9
//*** capacitance parameter ***
+xpart = 1                     cgso = 2.2E-11+dcgso_p_18_cap     cgdo = 2.2E-11+dcgdo_p_18_cap
+cgbo = 0                      ckappas = 0.6                 ckappad = 0.6
+cf = 1.08E-10                 clc = 1E-7                    cle = 0.6
+dlc = 0                 dwc = 0                       noff = 2
+voffcv = -0.084               acde = 1.2                    moin = 6.4
+cgsl = 1E-10+dcgsl_p_18_cap    cgdl = 1E-10+dcgdl_p_18_cap
//*** souce/drain junction diode model parameter **
+ijthsrev = 0.01               ijthsfwd = 0.01               xjbvs = 1
+bvs = 10                      jss = 3.1E-7                  jsws = 1E-12
+jswgs = 2.87E-12              cjs = 9.7E-4+dcj_p_18_cap         mjs = 0.41
+mjsws = 0.097                 cjsws = 1.1E-10+dcjsw_p_18_cap    cjswgs = 2.3E-10+dcjswg_p_18_cap
+mjswgs = 0.88                 pbs = 0.75                    pbsws = 0.49
+pbswgs = 0.8
//** rf model related parameter ***
+xrcrg1 = 12                   xrcrg2 = 1                    rbpb = 50
+rbpd = 50                     rbps = 50                     rbdb = 50
+rbsb = 50                     gbmin = 1E-12
//*** stress effect related parameter ***
+saref = 6.1E-7                sbref = 6.1E-7                wlod = 2.86E-7
+ku0 = 1.2E-7                  kvsat = -0.34                 kvth0 = 1.7E-10
+tku0 = 0.24                   llodku0 = 1                   wlodku0 = 1
+llodvth = 1.8                 wlodvth = 1                   lku0 = 1.871E-7
+wku0 = 2.4E-7                 pku0 = -3.24E-14              lkvth0 = 2.4E-10
+wkvth0 = 1.8E-10              pkvth0 = 0                    stk2 = 0
+lodk2 = 1.9                   steta0 = 0                    lodeta0 = 1
//*** temperature coefficient ***
+tnom = 25                     ute = -1.2192                 kt1 = -0.2061
+kt1l = 0                      kt2 = -0.01232                ua1 = 4.0941E-9
+ub1 = -4.8969E-18             uc1 = -5.5E-11                at = 4.00001E4
+prt = 0                       njs = 1                       xtis = 3
+tpb = 1.9E-3                  tpbsw = 1.9E-3                tpbswg = 1.9E-3
+tcj = 7.98E-4                 tcjsw = 2.4E-4                tcjswg = 4.77E-3
//*** well proximity effect model parameters ***
+web = 0                       wec = 0                       kvth0we = -2E-3
+k2we = 0                      ku0we = -4.1E-3               scref = 1E-6
11:type=p  minr=1e-60
//*** flag parameter ***
+version = 4.3                 binunit = 2                   mobmod = 0
+capmod = 2                    rdsmod = 0                    igcmod = 1
+igbmod = 1                    rbodymod = 0                  trnqsmod = 0
+acnqsmod = 0                  fnoimod = 1                   tnoimod = 0
+diomod = 1                    permod = 1                    rgatemod = 0
+wpemod = 0
//*** geometry range parameter ***
+lmin = 1E-6                   lmax = 2E-6                   wmin = 3.2E-7
+wmax = 5E-7
//*** process parameter ***
+epsrox = 3.9                  toxe = tox_p_18_cap               toxm = tox_p_18_cap
+dtox = 3.1E-10                xj = 1.7E-7                   ndep = 8.5E17
+ngate = 8E19                  nsd = 1E20                    rsh = 9.68
+rshg = 0.1
//*** dw and dl parameter ***
+wint = 1.389287E-8            wl = 0                        wln = 1
+ww = 0                        wwn = 1                       wwl = 0
+lint = 0                      ll = 0                        lln = 1
+lw = 0                        lwn = 1                       lwl = 0
+llc = 0                       lwc = 0                       lwlc = 0
+wlc = 0                       wwc = 0                       wwlc = 0
+dwg = 0                       dwb = 0                       xl = 0+dxl_p_18_cap
+xw = 0+dxw_p_18_cap
//*** flicker noise model parameter ***
+noia = 7.45E41                noib = 1.57E26                noic = 2E10
+em = 2.1E7                    ef = 1.3
//***layout-dependent parasitics model parameter ***
+dmcg = 8.5E-8                 dmci = 8.5E-8                 dmdg = 0
+dmcgt = 0                     dwj = 0                       xgw = 0
+xgl = 0                       ngcon = 1
//*** vth related  parameter ***
+vth0 = -0.35906+dvth0_p_18_cap    lvth0 = 0+dlvth0_p_18_cap         wvth0 = 0+dwvth0_p_18_cap
+pvth0 = 0+dpvth0_p_18_cap         phin = 0                      k1 = 0.25
+k2 = -1.21927E-2              k3 = -3.3                     k3b = 1.200306
+w0 = 1.585076E-7              lpe0 = 7.519925E-8            lpeb = 5.608072E-8
+dvtp0 = 2.2E-6                dvtp1 = 0.2                   dvt0 = 0.20341
+dvt1 = 0.95146                dvt2 = 0.01                   dvt0w = 0
+dvt1w = 5.366499E6            dvt2w = 0
//*** mobility related parameter ***
+u0 = 1.96662E-2+du0_p_18_cap      lu0 = 0+dlu0_p_18_cap             wu0 = 0+dwu0_p_18_cap
+pu0 = 0+dpu0_p_18_cap             ua = 2.455E-10                ub = 2.569851E-18
+wub = -2.999999E-25           uc = 4.336286E-11             ud = 0
+vsat = 6.57315E4+dvsat_p_18_cap   a0 = 0.693823                 ags = 1.93352
+b0 = 0                        b1 = 0                        keta = -6.14042E-2
+a1 = 0                        a2 = 1                        rdsw = 327.6
+prwb = -0.249981              prwg = 0.25                   wr = 1
//*** subthreshold related parameter ***
+voff = -0.05137               voffl = -6.036214E-9          minv = 0
+nfactor = 0.627693            eta0 = 3.11538E-2             etab = -2.38505E-2
+dsub = 1.2725                 cit = 1E-4                    cdsc = 0
+cdscb = 0                     cdscd = 0
//*** output resistance related parameter ***
+pclm = 0.627258               pdiblc1 = 0                   pdiblc2 = 9.579679E-3
+pdiblcb = 0                   drout = 1.132692              pscbe1 = 9.264E8
+pscbe2 = 1E-20                pvag = 1.425                  delta = 0.02
+fprout = 390.234144           pdits = 5.042617E-3           pditsl = 100
+pditsd = 0                    alpha0 = 0                    alpha1 = 0.06
+beta0 = 13.5                  agidl = 7.8E-8                bgidl = 2.404E9
+cgidl = 0.47                  egidl = 0.14
//*** gate dielectric tunneling current ***
+aigbacc = 0.014               bigbacc = 2.7E-3              cigbacc = 0.121
+nigbacc = 4.8                 aigbinv = 0.37                bigbinv = 0.028
+cigbinv = 6.4E-3              eigbinv = 1.2                 nigbinv = 1.5
+aigc = 6.8E-3                 bigc = 5.91E-4                cigc = 0
+aigsd = 6.1E-3                bigsd = 2.14E-4               cigsd = 0.037
+dlcig = 2.21E-9               nigc = 2.31                   poxedge = 1
+pigcd = 2.25                  ntox = 1                      toxref = 3E-9
//*** capacitance parameter ***
+xpart = 1                     cgso = 2.2E-11+dcgso_p_18_cap     cgdo = 2.2E-11+dcgdo_p_18_cap
+cgbo = 0                      ckappas = 0.6                 ckappad = 0.6
+cf = 1.08E-10                 clc = 1E-7                    cle = 0.6
+dlc = 0                 dwc = 0                       noff = 2
+voffcv = -0.084               acde = 1.2                    moin = 6.4
+cgsl = 1E-10+dcgsl_p_18_cap    cgdl = 1E-10+dcgdl_p_18_cap
//*** souce/drain junction diode model parameter **
+ijthsrev = 0.01               ijthsfwd = 0.01               xjbvs = 1
+bvs = 10                      jss = 3.1E-7                  jsws = 1E-12
+jswgs = 2.87E-12              cjs = 9.7E-4+dcj_p_18_cap         mjs = 0.41
+mjsws = 0.097                 cjsws = 1.1E-10+dcjsw_p_18_cap    cjswgs = 2.3E-10+dcjswg_p_18_cap
+mjswgs = 0.88                 pbs = 0.75                    pbsws = 0.49
+pbswgs = 0.8
//** rf model related parameter ***
+xrcrg1 = 12                   xrcrg2 = 1                    rbpb = 50
+rbpd = 50                     rbps = 50                     rbdb = 50
+rbsb = 50                     gbmin = 1E-12
//*** stress effect related parameter ***
+saref = 6.1E-7                sbref = 6.1E-7                wlod = 2.86E-7
+ku0 = 1.2E-7                  kvsat = -0.34                 kvth0 = 1.7E-10
+tku0 = 0.24                   llodku0 = 1                   wlodku0 = 1
+llodvth = 1.8                 wlodvth = 1                   lku0 = 1.871E-7
+wku0 = 2.4E-7                 pku0 = -3.24E-14              lkvth0 = 2.4E-10
+wkvth0 = 1.8E-10              pkvth0 = 0                    stk2 = 0
+lodk2 = 1.9                   steta0 = 0                    lodeta0 = 1
//*** temperature coefficient ***
+tnom = 25                     ute = -1.2192                 kt1 = -0.2061
+kt1l = 0                      kt2 = -0.01232                ua1 = 4.0941E-9
+ub1 = -4.8969E-18             uc1 = -5.5E-11                at = 4.00001E4
+prt = 0                       njs = 1                       xtis = 3
+tpb = 1.9E-3                  tpbsw = 1.9E-3                tpbswg = 1.9E-3
+tcj = 7.98E-4                 tcjsw = 2.4E-4                tcjswg = 4.77E-3
//*** well proximity effect model parameters ***
+web = 0                       wec = 0                       kvth0we = -2E-3
+k2we = 0                      ku0we = -4.1E-3               scref = 1E-6
12:type=p  minr=1e-60
//*** flag parameter ***
+version = 4.3                 binunit = 2                   mobmod = 0
+capmod = 2                    rdsmod = 0                    igcmod = 1
+igbmod = 1                    rbodymod = 0                  trnqsmod = 0
+acnqsmod = 0                  fnoimod = 1                   tnoimod = 0
+diomod = 1                    permod = 1                    rgatemod = 0
+wpemod = 0
//*** geometry range parameter ***
+lmin = 1.5E-7                 lmax = 1E-6                   wmin = 3.2E-7
+wmax = 5E-7
//*** process parameter ***
+epsrox = 3.9                  toxe = tox_p_18_cap               toxm = tox_p_18_cap
+dtox = 3.1E-10                xj = 1.7E-7                   ndep = 8.5E17
+ngate = 8E19                  nsd = 1E20                    rsh = 9.68
+rshg = 0.1
//*** dw and dl parameter ***
+wint = 1.389287E-8            wl = 0                        wln = 1
+ww = 0                        wwn = 1                       wwl = 0
+lint = 0                      ll = 0                        lln = 1
+lw = 0                        lwn = 1                       lwl = 0
+llc = 0                       lwc = 0                       lwlc = 0
+wlc = 0                       wwc = 0                       wwlc = 0
+dwg = 0                       dwb = 0                       xl = 0+dxl_p_18_cap
+xw = 0+dxw_p_18_cap
//*** flicker noise model parameter ***
+noia = 7.45E41                noib = 1.57E26                noic = 2E10
+em = 2.1E7                    ef = 1.3
//***layout-dependent parasitics model parameter ***
+dmcg = 8.5E-8                 dmci = 8.5E-8                 dmdg = 0
+dmcgt = 0                     dwj = 0                       xgw = 0
+xgl = 0                       ngcon = 1
//*** vth related  parameter ***
+vth0 = -0.35906+dvth0_p_18_cap    lvth0 = 0+dlvth0_p_18_cap         wvth0 = 0+dwvth0_p_18_cap
+pvth0 = 0+dpvth0_p_18_cap         phin = 0                      k1 = 0.25
+k2 = -1.21927E-2              k3 = -3.3                     k3b = 1.200306
+w0 = 1.585076E-7              lpe0 = 7.519925E-8            lpeb = 5.608072E-8
+dvtp0 = 2.2E-6                dvtp1 = 0.2                   dvt0 = 0.20341
+dvt1 = 0.95146                dvt2 = 0.01                   dvt0w = 0
+dvt1w = 5.366499E6            dvt2w = 0
//*** mobility related parameter ***
+u0 = 1.96662E-2+du0_p_18_cap      lu0 = 0+dlu0_p_18_cap             wu0 = 0+dwu0_p_18_cap
+pu0 = 0+dpu0_p_18_cap             ua = 2.455E-10                ub = 2.569851E-18
+wub = -2.999999E-25           uc = 4.336286E-11             ud = 0
+vsat = 6.57315E4+dvsat_p_18_cap   a0 = 0.693823                 ags = 1.93352
+b0 = 0                        b1 = 0                        keta = -6.14042E-2
+a1 = 0                        a2 = 1                        rdsw = 327.6
+prwb = -0.249981              prwg = 0.25                   wr = 1
//*** subthreshold related parameter ***
+voff = -0.05137               voffl = -6.036214E-9          minv = 0
+nfactor = 0.627693            eta0 = 3.11538E-2             etab = -2.38505E-2
+dsub = 1.2725                 cit = 1E-4                    cdsc = 0
+cdscb = 0                     cdscd = 0
//*** output resistance related parameter ***
+pclm = 0.627258               pdiblc1 = 0                   pdiblc2 = 9.579679E-3
+pdiblcb = 0                   drout = 1.132692              pscbe1 = 9.264E8
+pscbe2 = 1E-20                pvag = 1.425                  delta = 0.02
+fprout = 390.234144           pdits = 5.042617E-3           pditsl = 100
+pditsd = 0                    alpha0 = 0                    alpha1 = 0.06
+beta0 = 13.5                  agidl = 7.8E-8                bgidl = 2.404E9
+cgidl = 0.47                  egidl = 0.14
//*** gate dielectric tunneling current ***
+aigbacc = 0.014               bigbacc = 2.7E-3              cigbacc = 0.121
+nigbacc = 4.8                 aigbinv = 0.37                bigbinv = 0.028
+cigbinv = 6.4E-3              eigbinv = 1.2                 nigbinv = 1.5
+aigc = 6.8E-3                 bigc = 5.91E-4                cigc = 0
+aigsd = 6.1E-3                bigsd = 2.14E-4               cigsd = 0.037
+dlcig = 2.21E-9               nigc = 2.31                   poxedge = 1
+pigcd = 2.25                  ntox = 1                      toxref = 3E-9
//*** capacitance parameter ***
+xpart = 1                     cgso = 2.2E-11+dcgso_p_18_cap     cgdo = 2.2E-11+dcgdo_p_18_cap
+cgbo = 0                      ckappas = 0.6                 ckappad = 0.6
+cf = 1.08E-10                 clc = 1E-7                    cle = 0.6
+dlc = 0                 dwc = 0                       noff = 2
+voffcv = -0.084               acde = 1.2                    moin = 6.4
+cgsl = 1E-10+dcgsl_p_18_cap    cgdl = 1E-10+dcgdl_p_18_cap
//*** souce/drain junction diode model parameter **
+ijthsrev = 0.01               ijthsfwd = 0.01               xjbvs = 1
+bvs = 10                      jss = 3.1E-7                  jsws = 1E-12
+jswgs = 2.87E-12              cjs = 9.7E-4+dcj_p_18_cap         mjs = 0.41
+mjsws = 0.097                 cjsws = 1.1E-10+dcjsw_p_18_cap    cjswgs = 2.3E-10+dcjswg_p_18_cap
+mjswgs = 0.88                 pbs = 0.75                    pbsws = 0.49
+pbswgs = 0.8
//** rf model related parameter ***
+xrcrg1 = 12                   xrcrg2 = 1                    rbpb = 50
+rbpd = 50                     rbps = 50                     rbdb = 50
+rbsb = 50                     gbmin = 1E-12
//*** stress effect related parameter ***
+saref = 6.1E-7                sbref = 6.1E-7                wlod = 2.86E-7
+ku0 = 1.2E-7                  kvsat = -0.34                 kvth0 = 1.7E-10
+tku0 = 0.24                   llodku0 = 1                   wlodku0 = 1
+llodvth = 1.8                 wlodvth = 1                   lku0 = 1.871E-7
+wku0 = 2.4E-7                 pku0 = -3.24E-14              lkvth0 = 2.4E-10
+wkvth0 = 1.8E-10              pkvth0 = 0                    stk2 = 0
+lodk2 = 1.9                   steta0 = 0                    lodeta0 = 1
//*** temperature coefficient ***
+tnom = 25                     ute = -1.2192                 kt1 = -0.2061
+kt1l = 0                      kt2 = -0.01232                ua1 = 4.0941E-9
+ub1 = -4.8969E-18             uc1 = -5.5E-11                at = 4.00001E4
+prt = 0                       njs = 1                       xtis = 3
+tpb = 1.9E-3                  tpbsw = 1.9E-3                tpbswg = 1.9E-3
+tcj = 7.98E-4                 tcjsw = 2.4E-4                tcjswg = 4.77E-3
//*** well proximity effect model parameters ***
+web = 0                       wec = 0                       kvth0we = -2E-3
+k2we = 0                      ku0we = -4.1E-3               scref = 1E-6
13:type=p  minr=1e-60
//*** flag parameter ***
+version = 4.3                 binunit = 2                   mobmod = 0
+capmod = 2                    rdsmod = 0                    igcmod = 1
+igbmod = 1                    rbodymod = 0                  trnqsmod = 0
+acnqsmod = 0                  fnoimod = 1                   tnoimod = 0
+diomod = 1                    permod = 1                    rgatemod = 0
+wpemod = 0
//*** geometry range parameter ***
+lmin = 1E-5                   lmax = 9E-4                   wmin = 3.2E-7
+wmax = 5E-7
//*** process parameter ***
+epsrox = 3.9                  toxe = tox_p_18_cap               toxm = tox_p_18_cap
+dtox = 3.1E-10                xj = 1.7E-7                   ndep = 8.5E17
+ngate = 8E19                  nsd = 1E20                    rsh = 9.68
+rshg = 0.1
//*** dw and dl parameter ***
+wint = 1.389287E-8            wl = 0                        wln = 1
+ww = 0                        wwn = 1                       wwl = 0
+lint = 0                      ll = 0                        lln = 1
+lw = 0                        lwn = 1                       lwl = 0
+lwc = 0                       lwlc = 0                      wwc = 0
+wwlc = 0                      dwg = 0                       dwb = 0
+xl = 0.0+dxl_p_18_cap             xw = 0.0+dxw_p_18_cap
//*** flicker noise model parameter ***
+noia = 7.45E41                noib = 1.57E26                noic = 2E10
+em = 2.1E7                    ef = 1.3
//***layout-dependent parasitics model parameter ***
+dmcg = 8.5E-8                 dmci = 8.5E-8                 dmdg = 0
+dmcgt = 0                     dwj = 0                       xgw = 0
+xgl = 0                       ngcon = 1
//*** vth related  parameter ***
+vth0 = -0.35906+dvth0_p_18_cap    lvth0 = 0.0+dlvth0_p_18_cap       wvth0 = 0.0+dwvth0_p_18_cap
+pvth0 = 0.0+dpvth0_p_18_cap       phin = 0                      k1 = 0.25
+k2 = -1.21927E-2              k3 = -3.3                     k3b = 1.200306
+w0 = 1.585076E-7              lpe0 = 7.519925E-8            lpeb = 5.608072E-8
+dvtp0 = 2.2E-6                dvtp1 = 0.2                   dvt0 = 0.20341
+dvt1 = 0.95146                dvt2 = 0.01                   dvt0w = 0
+dvt1w = 5.366499E6            dvt2w = 0
//*** mobility related parameter ***
+u0 = 0.0196662+du0_p_18_cap       lu0 = 0.0+dlu0_p_18_cap           wu0 = 0.0+dwu0_p_18_cap
+pu0 = 0.0+dpu0_p_18_cap           ua = 2.455E-10                ub = 2.56985E-18
+wub = -2.999996E-25           uc = 4.336286E-11             ud = 0
+vsat = 65731.5+dvsat_p_18_cap     a0 = 0.693823                 ags = 1.93352
+b0 = 0                        b1 = 0                        keta = -6.14042E-2
+a1 = 0                        a2 = 1                        rdsw = 327.6
+prwb = -0.249981              prwg = 0.25                   wr = 1
//*** subthreshold related parameter ***
+voff = -0.05137               voffl = -6.036214E-9          minv = 0
+nfactor = 0.627693            eta0 = 3.11538E-2             etab = -2.38505E-2
+dsub = 1.2725                 cit = 1E-4                    cdsc = 0
+cdscb = 0                     cdscd = 0
//*** output resistance related parameter ***
+pclm = 0.627258               pdiblc1 = 0                   pdiblc2 = 9.579679E-3
+pdiblcb = 0                   drout = 1.132692              pscbe1 = 9.264E8
+pscbe2 = 1E-20                pvag = 1.425                  delta = 0.02
+fprout = 390.234144           pdits = 5.042617E-3           pditsl = 100
+pditsd = 0                    lc = 0                        alpha0 = 0
+alpha1 = 0.06                 beta0 = 13.5                  agidl = 7.8E-8
+bgidl = 2.404E9               cgidl = 0.47                  egidl = 0.14
//*** gate dielectric tunneling current ***
+aigbacc = 0.014               bigbacc = 2.7E-3              cigbacc = 0.121
+nigbacc = 4.8                 aigbinv = 0.37                bigbinv = 0.028
+cigbinv = 6.4E-3              eigbinv = 1.2                 nigbinv = 1.5
+aigc = 6.8E-3                 bigc = 5.91E-4                cigc = 0
+aigsd = 6.1E-3                bigsd = 2.14E-4               cigsd = 0.037
+dlcig = 2.21E-9               nigc = 2.31                   poxedge = 1
+pigcd = 2.25                  ntox = 1                      toxref = 3E-9
//*** capacitance parameter ***
+xpart = 1                     cgso = 2.2E-11+dcgso_p_18_cap     cgdo = 2.2E-11+dcgdo_p_18_cap
+cgbo = 0                      ckappas = 0.6                 ckappad = 0.6
+cf = 1.08E-10                 clc = 1E-7                    cle = 0.6
+dlc = 0                 dwc = 0                       noff = 2
+voffcv = -0.084               acde = 1.2                    moin = 6.4
+cgsl = 1E-10+dcgsl_p_18_cap    cgdl = 1E-10+dcgdl_p_18_cap
//*** souce/drain junction diode model parameter **
+ijthsrev = 0.01               ijthsfwd = 0.01               xjbvs = 1
+bvs = 10                      jss = 3.1E-7                  jsws = 1E-12
+jswgs = 2.87E-12              cjs = 9.7E-4+dcj_p_18_cap         mjs = 0.41
+mjsws = 0.097                 cjsws = 1.1E-10+dcjsw_p_18_cap    cjswgs = 2.3E-10+dcjswg_p_18_cap
+mjswgs = 0.88                 pbs = 0.75                    pbsws = 0.49
+pbswgs = 0.8
//** rf model related parameter ***
+xrcrg1 = 12                   xrcrg2 = 1                    rbpb = 50
+rbpd = 50                     rbps = 50                     rbdb = 50
+rbsb = 50                     gbmin = 1E-12
//*** stress effect related parameter ***
+saref = 6.1E-7                sbref = 6.1E-7                wlod = 2.86E-7
+ku0 = 1.2E-7                  kvsat = -0.34                 kvth0 = 1.7E-10
+tku0 = 0.24                   llodku0 = 1                   wlodku0 = 1
+llodvth = 1.8                 wlodvth = 1                   lku0 = 1.871E-7
+wku0 = 2.4E-7                 pku0 = -3.24E-14              lkvth0 = 2.4E-10
+wkvth0 = 1.8E-10              pkvth0 = 0                    stk2 = 0
+lodk2 = 1.9                   steta0 = 0                    lodeta0 = 1
//*** temperature coefficient ***
+tnom = 25                     ute = -1.2192                 kt1 = -0.2061
+kt1l = 0                      kt2 = -0.01232                ua1 = 4.0941E-9
+ub1 = -4.8969E-18             uc1 = -5.5E-11                at = 4.00001E4
+prt = 0                       njs = 1                       xtis = 3
+tpb = 1.9E-3                  tpbsw = 1.9E-3                tpbswg = 1.9E-3
+tcj = 7.98E-4                 tcjsw = 2.4E-4                tcjswg = 4.77E-3
//*** well proximity effect model parameters ***
+web = 0                       wec = 0                       kvth0we = -2E-3
+k2we = 0                      ku0we = -4.1E-3               scref = 1E-6
14:type=p  minr=1e-60
//*** flag parameter ***
+version = 4.3                 binunit = 2                   mobmod = 0
+capmod = 2                    rdsmod = 0                    igcmod = 1
+igbmod = 1                    rbodymod = 0                  trnqsmod = 0
+acnqsmod = 0                  fnoimod = 1                   tnoimod = 0
+diomod = 1                    permod = 1                    rgatemod = 0
+wpemod = 0
//*** geometry range parameter ***
+lmin = 1E-5                   lmax = 9E-4                   wmin = 5E-7
+wmax = 1E-6
//*** process parameter ***
+epsrox = 3.9                  toxe = tox_p_18_cap               toxm = tox_p_18_cap
+dtox = 3.1E-10                xj = 1.7E-7                   ndep = 8.5E17
+ngate = 8E19                  nsd = 1E20                    rsh = 9.68
+rshg = 0.1
//*** dw and dl parameter ***
+wint = 1.389287E-8            wl = 0                        wln = 1
+ww = 0                        wwn = 1                       wwl = 0
+lint = 0                      ll = 0                        lln = 1
+lw = 0                        lwn = 1                       lwl = 0
+lwc = 0                       lwlc = 0                      wwc = 0
+wwlc = 0                      dwg = 0                       dwb = 0
+xl = 0.0+dxl_p_18_cap             xw = 0.0+dxw_p_18_cap
//*** flicker noise model parameter ***
+noia = 7.45E41                noib = 1.57E26                noic = 2E10
+em = 2.1E7                    ef = 1.3
//***layout-dependent parasitics model parameter ***
+dmcg = 8.5E-8                 dmci = 8.5E-8                 dmdg = 0
+dmcgt = 0                     dwj = 0                       xgw = 0
+xgl = 0                       ngcon = 1
//*** vth related  parameter ***
+vth0 = -0.35906+dvth0_p_18_cap    lvth0 = 0.0+dlvth0_p_18_cap       wvth0 = 0.0+dwvth0_p_18_cap
+pvth0 = 0.0+dpvth0_p_18_cap       phin = 0                      k1 = 0.25
+k2 = -1.21927E-2              k3 = -3.3                     k3b = 1.200306
+w0 = 1.585076E-7              lpe0 = 7.519925E-8            lpeb = 5.608072E-8
+dvtp0 = 2.2E-6                dvtp1 = 0.2                   dvt0 = 0.20341
+dvt1 = 0.95146                dvt2 = 0.01                   dvt0w = 0
+dvt1w = 5.366499E6            dvt2w = 0
//*** mobility related parameter ***
+u0 = 0.0196662+du0_p_18_cap       lu0 = 0.0+dlu0_p_18_cap           wu0 = 0.0+dwu0_p_18_cap
+pu0 = 0.0+dpu0_p_18_cap           ua = 2.455E-10                ub = 2.569852E-18
+wub = -3.000005E-25           uc = 4.336286E-11             ud = 0
+vsat = 65731.5+dvsat_p_18_cap     a0 = 0.693823                 ags = 1.93352
+b0 = 0                        b1 = 0                        keta = -6.14042E-2
+a1 = 0                        a2 = 1                        rdsw = 327.6
+prwb = -0.249981              prwg = 0.25                   wr = 1
//*** subthreshold related parameter ***
+voff = -0.05137               voffl = -6.036214E-9          minv = 0
+nfactor = 0.627693            eta0 = 3.11538E-2             etab = -2.38505E-2
+dsub = 1.2725                 cit = 1E-4                    cdsc = 0
+cdscb = 0                     cdscd = 0
//*** output resistance related parameter ***
+pclm = 0.627258               pdiblc1 = 0                   pdiblc2 = 9.579679E-3
+pdiblcb = 0                   drout = 1.132692              pscbe1 = 9.264E8
+pscbe2 = 1E-20                pvag = 1.425                  delta = 0.02
+fprout = 390.234144           pdits = 5.042617E-3           pditsl = 100
+pditsd = 0                    lc = 0                        alpha0 = 0
+alpha1 = 0.06                 beta0 = 13.5                  agidl = 7.8E-8
+bgidl = 2.404E9               cgidl = 0.47                  egidl = 0.14
//*** gate dielectric tunneling current ***
+aigbacc = 0.014               bigbacc = 2.7E-3              cigbacc = 0.121
+nigbacc = 4.8                 aigbinv = 0.37                bigbinv = 0.028
+cigbinv = 6.4E-3              eigbinv = 1.2                 nigbinv = 1.5
+aigc = 6.8E-3                 bigc = 5.91E-4                cigc = 0
+aigsd = 6.1E-3                bigsd = 2.14E-4               cigsd = 0.037
+dlcig = 2.21E-9               nigc = 2.31                   poxedge = 1
+pigcd = 2.25                  ntox = 1                      toxref = 3E-9
//*** capacitance parameter ***
+xpart = 1                     cgso = 2.2E-11+dcgso_p_18_cap     cgdo = 2.2E-11+dcgdo_p_18_cap
+cgbo = 0                      ckappas = 0.6                 ckappad = 0.6
+cf = 1.08E-10                 clc = 1E-7                    cle = 0.6
+dlc = 0                 dwc = 0                       noff = 2
+voffcv = -0.084               acde = 1.2                    moin = 6.4
+cgsl = 1E-10+dcgsl_p_18_cap    cgdl = 1E-10+dcgdl_p_18_cap
//*** souce/drain junction diode model parameter **
+ijthsrev = 0.01               ijthsfwd = 0.01               xjbvs = 1
+bvs = 10                      jss = 3.1E-7                  jsws = 1E-12
+jswgs = 2.87E-12              cjs = 9.7E-4+dcj_p_18_cap         mjs = 0.41
+mjsws = 0.097                 cjsws = 1.1E-10+dcjsw_p_18_cap    cjswgs = 2.3E-10+dcjswg_p_18_cap
+mjswgs = 0.88                 pbs = 0.75                    pbsws = 0.49
+pbswgs = 0.8
//** rf model related parameter ***
+xrcrg1 = 12                   xrcrg2 = 1                    rbpb = 50
+rbpd = 50                     rbps = 50                     rbdb = 50
+rbsb = 50                     gbmin = 1E-12
//*** stress effect related parameter ***
+saref = 6.1E-7                sbref = 6.1E-7                wlod = 2.86E-7
+ku0 = 1.2E-7                  kvsat = -0.34                 kvth0 = 1.7E-10
+tku0 = 0.24                   llodku0 = 1                   wlodku0 = 1
+llodvth = 1.8                 wlodvth = 1                   lku0 = 1.871E-7
+wku0 = 2.4E-7                 pku0 = -3.24E-14              lkvth0 = 2.4E-10
+wkvth0 = 1.8E-10              pkvth0 = 0                    stk2 = 0
+lodk2 = 1.9                   steta0 = 0                    lodeta0 = 1
//*** temperature coefficient ***
+tnom = 25                     ute = -1.2192                 kt1 = -0.2061
+kt1l = 0                      kt2 = -0.01232                ua1 = 4.0941E-9
+ub1 = -4.8969E-18             uc1 = -5.5E-11                at = 4.00001E4
+prt = 0                       njs = 1                       xtis = 3
+tpb = 1.9E-3                  tpbsw = 1.9E-3                tpbswg = 1.9E-3
+tcj = 7.98E-4                 tcjsw = 2.4E-4                tcjswg = 4.77E-3
//*** well proximity effect model parameters ***
+web = 0                       wec = 0                       kvth0we = -2E-3
+k2we = 0                      ku0we = -4.1E-3               scref = 1E-6
15:type=p  minr=1e-60
//*** flag parameter ***
+version = 4.3                 binunit = 2                   mobmod = 0
+capmod = 2                    rdsmod = 0                    igcmod = 1
+igbmod = 1                    rbodymod = 0                  trnqsmod = 0
+acnqsmod = 0                  fnoimod = 1                   tnoimod = 0
+diomod = 1                    permod = 1                    rgatemod = 0
+wpemod = 0
//*** geometry range parameter ***
+lmin = 1E-5                   lmax = 9E-4                   wmin = 1E-6
+wmax = 2E-6
//*** process parameter ***
+epsrox = 3.9                  toxe = tox_p_18_cap               toxm = tox_p_18_cap
+dtox = 3.1E-10                xj = 1.7E-7                   ndep = 8.5E17
+ngate = 8E19                  nsd = 1E20                    rsh = 9.68
+rshg = 0.1
//*** dw and dl parameter ***
+wint = 1.389287E-8            wl = 0                        wln = 1
+ww = 0                        wwn = 1                       wwl = 0
+lint = 0                      ll = 0                        lln = 1
+lw = 0                        lwn = 1                       lwl = 0
+lwc = 0                       lwlc = 0                      wwc = 0
+wwlc = 0                      dwg = 0                       dwb = 0
+xl = 0.0+dxl_p_18_cap             xw = 0.0+dxw_p_18_cap
//*** flicker noise model parameter ***
+noia = 7.45E41                noib = 1.57E26                noic = 2E10
+em = 2.1E7                    ef = 1.3
//***layout-dependent parasitics model parameter ***
+dmcg = 8.5E-8                 dmci = 8.5E-8                 dmdg = 0
+dmcgt = 0                     dwj = 0                       xgw = 0
+xgl = 0                       ngcon = 1
//*** vth related  parameter ***
+vth0 = -0.35906+dvth0_p_18_cap    lvth0 = 0.0+dlvth0_p_18_cap       wvth0 = 0.0+dwvth0_p_18_cap
+pvth0 = 0.0+dpvth0_p_18_cap       phin = 0                      k1 = 0.25
+k2 = -1.21927E-2              k3 = -3.3                     k3b = 1.200306
+w0 = 1.585076E-7              lpe0 = 7.519925E-8            lpeb = 5.608072E-8
+dvtp0 = 2.2E-6                dvtp1 = 0.2                   dvt0 = 0.20341
+dvt1 = 0.95146                dvt2 = 0.01                   dvt0w = 0
+dvt1w = 5.366499E6            dvt2w = 0
//*** mobility related parameter ***
+u0 = 0.0196662+du0_p_18_cap       lu0 = 0.0+dlu0_p_18_cap           wu0 = 0.0+dwu0_p_18_cap
+pu0 = 0.0+dpu0_p_18_cap           ua = 2.455E-10                ub = 2.56985E-18
+wub = -2.999987E-25           uc = 4.336286E-11             ud = 0
+vsat = 65731.5+dvsat_p_18_cap     a0 = 0.693823                 ags = 1.93352
+b0 = 0                        b1 = 0                        keta = -6.14042E-2
+a1 = 0                        a2 = 1                        rdsw = 327.6
+prwb = -0.249981              prwg = 0.25                   wr = 1
//*** subthreshold related parameter ***
+voff = -0.05137               voffl = -6.036214E-9          minv = 0
+nfactor = 0.627693            eta0 = 3.11538E-2             etab = -2.38505E-2
+dsub = 1.2725                 cit = 1E-4                    cdsc = 0
+cdscb = 0                     cdscd = 0
//*** output resistance related parameter ***
+pclm = 0.627258               pdiblc1 = 0                   pdiblc2 = 9.579679E-3
+pdiblcb = 0                   drout = 1.132692              pscbe1 = 9.264E8
+pscbe2 = 1E-20                pvag = 1.425                  delta = 0.02
+fprout = 390.234144           pdits = 5.042617E-3           pditsl = 100
+pditsd = 0                    lc = 0                        alpha0 = 0
+alpha1 = 0.06                 beta0 = 13.5                  agidl = 7.8E-8
+bgidl = 2.404E9               cgidl = 0.47                  egidl = 0.14
//*** gate dielectric tunneling current ***
+aigbacc = 0.014               bigbacc = 2.7E-3              cigbacc = 0.121
+nigbacc = 4.8                 aigbinv = 0.37                bigbinv = 0.028
+cigbinv = 6.4E-3              eigbinv = 1.2                 nigbinv = 1.5
+aigc = 6.8E-3                 bigc = 5.91E-4                cigc = 0
+aigsd = 6.1E-3                bigsd = 2.14E-4               cigsd = 0.037
+dlcig = 2.21E-9               nigc = 2.31                   poxedge = 1
+pigcd = 2.25                  ntox = 1                      toxref = 3E-9
//*** capacitance parameter ***
+xpart = 1                     cgso = 2.2E-11+dcgso_p_18_cap     cgdo = 2.2E-11+dcgdo_p_18_cap
+cgbo = 0                      ckappas = 0.6                 ckappad = 0.6
+cf = 1.08E-10                 clc = 1E-7                    cle = 0.6
+dlc = 0                 dwc = 0                       noff = 2
+voffcv = -0.084               acde = 1.2                    moin = 6.4
+cgsl = 1E-10+dcgsl_p_18_cap    cgdl = 1E-10+dcgdl_p_18_cap
//*** souce/drain junction diode model parameter **
+ijthsrev = 0.01               ijthsfwd = 0.01               xjbvs = 1
+bvs = 10                      jss = 3.1E-7                  jsws = 1E-12
+jswgs = 2.87E-12              cjs = 9.7E-4+dcj_p_18_cap         mjs = 0.41
+mjsws = 0.097                 cjsws = 1.1E-10+dcjsw_p_18_cap    cjswgs = 2.3E-10+dcjswg_p_18_cap
+mjswgs = 0.88                 pbs = 0.75                    pbsws = 0.49
+pbswgs = 0.8
//** rf model related parameter ***
+xrcrg1 = 12                   xrcrg2 = 1                    rbpb = 50
+rbpd = 50                     rbps = 50                     rbdb = 50
+rbsb = 50                     gbmin = 1E-12
//*** stress effect related parameter ***
+saref = 6.1E-7                sbref = 6.1E-7                wlod = 2.86E-7
+ku0 = 1.2E-7                  kvsat = -0.34                 kvth0 = 1.7E-10
+tku0 = 0.24                   llodku0 = 1                   wlodku0 = 1
+llodvth = 1.8                 wlodvth = 1                   lku0 = 1.871E-7
+wku0 = 2.4E-7                 pku0 = -3.24E-14              lkvth0 = 2.4E-10
+wkvth0 = 1.8E-10              pkvth0 = 0                    stk2 = 0
+lodk2 = 1.9                   steta0 = 0                    lodeta0 = 1
//*** temperature coefficient ***
+tnom = 25                     ute = -1.2192                 kt1 = -0.2061
+kt1l = 0                      kt2 = -0.01232                ua1 = 4.0941E-9
+ub1 = -4.8969E-18             uc1 = -5.5E-11                at = 4.00001E4
+prt = 0                       njs = 1                       xtis = 3
+tpb = 1.9E-3                  tpbsw = 1.9E-3                tpbswg = 1.9E-3
+tcj = 7.98E-4                 tcjsw = 2.4E-4                tcjswg = 4.77E-3
//*** well proximity effect model parameters ***
+web = 0                       wec = 0                       kvth0we = -2E-3
+k2we = 0                      ku0we = -4.1E-3               scref = 1E-6
16:type=p  minr=1e-60
//*** flag parameter ***
+version = 4.3                 binunit = 2                   mobmod = 0
+capmod = 2                    rdsmod = 0                    igcmod = 1
+igbmod = 1                    rbodymod = 0                  trnqsmod = 0
+acnqsmod = 0                  fnoimod = 1                   tnoimod = 0
+diomod = 1                    permod = 1                    rgatemod = 0
+wpemod = 0
//*** geometry range parameter ***
+lmin = 1E-5                   lmax = 9E-4                   wmin = 2E-6
+wmax = 1E-5
//*** process parameter ***
+epsrox = 3.9                  toxe = tox_p_18_cap               toxm = tox_p_18_cap
+dtox = 3.1E-10                xj = 1.7E-7                   ndep = 8.5E17
+ngate = 8E19                  nsd = 1E20                    rsh = 9.68
+rshg = 0.1
//*** dw and dl parameter ***
+wint = 1.389287E-8            wl = 0                        wln = 1
+ww = 0                        wwn = 1                       wwl = 0
+lint = 0                      ll = 0                        lln = 1
+lw = 0                        lwn = 1                       lwl = 0
+lwc = 0                       lwlc = 0                      wwc = 0
+wwlc = 0                      dwg = 0                       dwb = 0
+xl = 0.0+dxl_p_18_cap             xw = 0.0+dxw_p_18_cap
//*** flicker noise model parameter ***
+noia = 7.45E41                noib = 1.57E26                noic = 2E10
+em = 2.1E7                    ef = 1.3
//***layout-dependent parasitics model parameter ***
+dmcg = 8.5E-8                 dmci = 8.5E-8                 dmdg = 0
+dmcgt = 0                     dwj = 0                       xgw = 0
+xgl = 0                       ngcon = 1
//*** vth related  parameter ***
+vth0 = -0.35906+dvth0_p_18_cap    lvth0 = 0.0+dlvth0_p_18_cap       wvth0 = 0.0+dwvth0_p_18_cap
+pvth0 = 0.0+dpvth0_p_18_cap       phin = 0                      k1 = 0.25
+k2 = -1.21927E-2              k3 = -3.3                     k3b = 1.200306
+w0 = 1.585076E-7              lpe0 = 7.519925E-8            lpeb = 5.608072E-8
+dvtp0 = 2.2E-6                dvtp1 = 0.2                   dvt0 = 0.20341
+dvt1 = 0.95146                dvt2 = 0.01                   dvt0w = 0
+dvt1w = 5.366499E6            dvt2w = 0
//*** mobility related parameter ***
+u0 = 0.0196662+du0_p_18_cap       lu0 = 0.0+dlu0_p_18_cap           wu0 = 0.0+dwu0_p_18_cap
+pu0 = 0.0+dpu0_p_18_cap           ua = 2.455E-10                ub = 2.569851E-18
+wub = -3.000007E-25           uc = 4.336286E-11             ud = 0
+vsat = 65731.5+dvsat_p_18_cap     a0 = 0.693823                 ags = 1.93352
+b0 = 0                        b1 = 0                        keta = -6.14042E-2
+a1 = 0                        a2 = 1                        rdsw = 327.6
+prwb = -0.249981              prwg = 0.25                   wr = 1
//*** subthreshold related parameter ***
+voff = -0.05137               voffl = -6.036214E-9          minv = 0
+nfactor = 0.627693            eta0 = 3.11538E-2             etab = -2.38505E-2
+dsub = 1.2725                 cit = 1E-4                    cdsc = 0
+cdscb = 0                     cdscd = 0
//*** output resistance related parameter ***
+pclm = 0.627258               pdiblc1 = 0                   pdiblc2 = 9.579679E-3
+pdiblcb = 0                   drout = 1.132692              pscbe1 = 9.264E8
+pscbe2 = 1E-20                pvag = 1.425                  delta = 0.02
+fprout = 390.234144           pdits = 5.042617E-3           pditsl = 100
+pditsd = 0                    lc = 0                        alpha0 = 0
+alpha1 = 0.06                 beta0 = 13.5                  agidl = 7.8E-8
+bgidl = 2.404E9               cgidl = 0.47                  egidl = 0.14
//*** gate dielectric tunneling current ***
+aigbacc = 0.014               bigbacc = 2.7E-3              cigbacc = 0.121
+nigbacc = 4.8                 aigbinv = 0.37                bigbinv = 0.028
+cigbinv = 6.4E-3              eigbinv = 1.2                 nigbinv = 1.5
+aigc = 6.8E-3                 bigc = 5.91E-4                cigc = 0
+aigsd = 6.1E-3                bigsd = 2.14E-4               cigsd = 0.037
+dlcig = 2.21E-9               nigc = 2.31                   poxedge = 1
+pigcd = 2.25                  ntox = 1                      toxref = 3E-9
//*** capacitance parameter ***
+xpart = 1                     cgso = 2.2E-11+dcgso_p_18_cap     cgdo = 2.2E-11+dcgdo_p_18_cap
+cgbo = 0                      ckappas = 0.6                 ckappad = 0.6
+cf = 1.08E-10                 clc = 1E-7                    cle = 0.6
+dlc = 0                 dwc = 0                       noff = 2
+voffcv = -0.084               acde = 1.2                    moin = 6.4
+cgsl = 1E-10+dcgsl_p_18_cap    cgdl = 1E-10+dcgdl_p_18_cap
//*** souce/drain junction diode model parameter **
+ijthsrev = 0.01               ijthsfwd = 0.01               xjbvs = 1
+bvs = 10                      jss = 3.1E-7                  jsws = 1E-12
+jswgs = 2.87E-12              cjs = 9.7E-4+dcj_p_18_cap         mjs = 0.41
+mjsws = 0.097                 cjsws = 1.1E-10+dcjsw_p_18_cap    cjswgs = 2.3E-10+dcjswg_p_18_cap
+mjswgs = 0.88                 pbs = 0.75                    pbsws = 0.49
+pbswgs = 0.8
//** rf model related parameter ***
+xrcrg1 = 12                   xrcrg2 = 1                    rbpb = 50
+rbpd = 50                     rbps = 50                     rbdb = 50
+rbsb = 50                     gbmin = 1E-12
//*** stress effect related parameter ***
+saref = 6.1E-7                sbref = 6.1E-7                wlod = 2.86E-7
+ku0 = 1.2E-7                  kvsat = -0.34                 kvth0 = 1.7E-10
+tku0 = 0.24                   llodku0 = 1                   wlodku0 = 1
+llodvth = 1.8                 wlodvth = 1                   lku0 = 1.871E-7
+wku0 = 2.4E-7                 pku0 = -3.24E-14              lkvth0 = 2.4E-10
+wkvth0 = 1.8E-10              pkvth0 = 0                    stk2 = 0
+lodk2 = 1.9                   steta0 = 0                    lodeta0 = 1
//*** temperature coefficient ***
+tnom = 25                     ute = -1.2192                 kt1 = -0.2061
+kt1l = 0                      kt2 = -0.01232                ua1 = 4.0941E-9
+ub1 = -4.8969E-18             uc1 = -5.5E-11                at = 4.00001E4
+prt = 0                       njs = 1                       xtis = 3
+tpb = 1.9E-3                  tpbsw = 1.9E-3                tpbswg = 1.9E-3
+tcj = 7.98E-4                 tcjsw = 2.4E-4                tcjswg = 4.77E-3
//*** well proximity effect model parameters ***
+web = 0                       wec = 0                       kvth0we = -2E-3
+k2we = 0                      ku0we = -4.1E-3               scref = 1E-6
17:type=p  minr=1e-60
//*** flag parameter ***
+version = 4.3                 binunit = 2                   mobmod = 0
+capmod = 2                    rdsmod = 0                    igcmod = 1
+igbmod = 1                    rbodymod = 0                  trnqsmod = 0
+acnqsmod = 0                  fnoimod = 1                   tnoimod = 0
+diomod = 1                    permod = 1                    rgatemod = 0
+wpemod = 0
//*** geometry range parameter ***
+lmin = 1.5E-7                 lmax = 1E-6                   wmin = 1E-5
+wmax = 9E-4
//*** process parameter ***
+epsrox = 3.9                  toxe = tox_p_18_cap               toxm = tox_p_18_cap
+dtox = 3.1E-10                xj = 1.7E-7                   ndep = 8.5E17
+ngate = 8E19                  nsd = 1E20                    rsh = 9.68
+rshg = 0.1
//*** dw and dl parameter ***
+wint = 1.389287E-8            wl = 0                        wln = 1
+ww = 0                        wwn = 1                       wwl = 0
+lint = 0                      ll = 0                        lln = 1
+lw = 0                        lwn = 1                       lwl = 0
+lwc = 0                       lwlc = 0                      wwc = 0
+wwlc = 0                      dwg = 0                       dwb = 0
+xl = 0.0+dxl_p_18_cap             xw = 0.0+dxw_p_18_cap
//*** flicker noise model parameter ***
+noia = 7.45E41                noib = 1.57E26                noic = 2E10
+em = 2.1E7                    ef = 1.3
//***layout-dependent parasitics model parameter ***
+dmcg = 8.5E-8                 dmci = 8.5E-8                 dmdg = 0
+dmcgt = 0                     dwj = 0                       xgw = 0
+xgl = 0                       ngcon = 1
//*** vth related  parameter ***
+vth0 = -0.35906+dvth0_p_18_cap    lvth0 = 0.0+dlvth0_p_18_cap       wvth0 = 0.0+dwvth0_p_18_cap
+pvth0 = 0.0+dpvth0_p_18_cap       phin = 0                      k1 = 0.25
+k2 = -1.21927E-2              k3 = -3.3                     k3b = 1.200306
+w0 = 1.585076E-7              lpe0 = 7.519925E-8            lpeb = 5.608072E-8
+dvtp0 = 2.2E-6                dvtp1 = 0.2                   dvt0 = 0.20341
+dvt1 = 0.95146                dvt2 = 0.01                   dvt0w = 0
+dvt1w = 5.366499E6            dvt2w = 0
//*** mobility related parameter ***
+u0 = 0.0196662+du0_p_18_cap       lu0 = 0.0+dlu0_p_18_cap           wu0 = 0.0+dwu0_p_18_cap
+pu0 = 0.0+dpu0_p_18_cap           ua = 2.455E-10                ub = 2.539767E-18
+uc = 4.336286E-11             ud = 0                        vsat = 65731.5+dvsat_p_18_cap
+a0 = 0.693823                 ags = 1.93352                 b0 = 0
+b1 = 0                        keta = -6.14042E-2            a1 = 0
+a2 = 1                        rdsw = 327.6                  prwb = -0.249981
+prwg = 0.25                   wr = 1
//*** subthreshold related parameter ***
+voff = -0.05137               voffl = -6.036214E-9          minv = 0
+nfactor = 0.627693            eta0 = 3.11538E-2             etab = -2.38505E-2
+dsub = 1.2725                 cit = 1E-4                    cdsc = 0
+cdscb = 0                     cdscd = 0
//*** output resistance related parameter ***
+pclm = 0.627258               pdiblc1 = 0                   pdiblc2 = 9.579679E-3
+pdiblcb = 0                   drout = 1.132692              pscbe1 = 9.264E8
+pscbe2 = 1E-20                pvag = 1.425                  delta = 0.02
+fprout = 390.234144           pdits = 5.042617E-3           pditsl = 100
+pditsd = 0                    lc = 0                        alpha0 = 0
+alpha1 = 0.06                 beta0 = 13.5                  agidl = 7.8E-8
+bgidl = 2.404E9               cgidl = 0.47                  egidl = 0.14
//*** gate dielectric tunneling current ***
+aigbacc = 0.014               bigbacc = 2.7E-3              cigbacc = 0.121
+nigbacc = 4.8                 aigbinv = 0.37                bigbinv = 0.028
+cigbinv = 6.4E-3              eigbinv = 1.2                 nigbinv = 1.5
+aigc = 6.8E-3                 bigc = 5.91E-4                cigc = 0
+aigsd = 6.1E-3                bigsd = 2.14E-4               cigsd = 0.037
+dlcig = 2.21E-9               nigc = 2.31                   poxedge = 1
+pigcd = 2.25                  ntox = 1                      toxref = 3E-9
//*** capacitance parameter ***
+xpart = 1                     cgso = 2.2E-11+dcgso_p_18_cap     cgdo = 2.2E-11+dcgdo_p_18_cap
+cgbo = 0                      ckappas = 0.6                 ckappad = 0.6
+cf = 1.08E-10                 clc = 1E-7                    cle = 0.6
+dlc = 0                 dwc = 0                       noff = 2
+voffcv = -0.084               acde = 1.2                    moin = 6.4
+cgsl = 1E-10+dcgsl_p_18_cap    cgdl = 1E-10+dcgdl_p_18_cap
//*** souce/drain junction diode model parameter **
+ijthsrev = 0.01               ijthsfwd = 0.01               xjbvs = 1
+bvs = 10                      jss = 3.1E-7                  jsws = 1E-12
+jswgs = 2.87E-12              cjs = 9.7E-4+dcj_p_18_cap         mjs = 0.41
+mjsws = 0.097                 cjsws = 1.1E-10+dcjsw_p_18_cap    cjswgs = 2.3E-10+dcjswg_p_18_cap
+mjswgs = 0.88                 pbs = 0.75                    pbsws = 0.49
+pbswgs = 0.8
//** rf model related parameter ***
+xrcrg1 = 12                   xrcrg2 = 1                    rbpb = 50
+rbpd = 50                     rbps = 50                     rbdb = 50
+rbsb = 50                     gbmin = 1E-12
//*** stress effect related parameter ***
+saref = 6.1E-7                sbref = 6.1E-7                wlod = 2.86E-7
+ku0 = 1.2E-7                  kvsat = -0.34                 kvth0 = 1.7E-10
+tku0 = 0.24                   llodku0 = 1                   wlodku0 = 1
+llodvth = 1.8                 wlodvth = 1                   lku0 = 1.871E-7
+wku0 = 2.4E-7                 pku0 = -3.24E-14              lkvth0 = 2.4E-10
+wkvth0 = 1.8E-10              pkvth0 = 0                    stk2 = 0
+lodk2 = 1.9                   steta0 = 0                    lodeta0 = 1
//*** temperature coefficient ***
+tnom = 25                     ute = -1.2192                 kt1 = -0.2061
+kt1l = 0                      kt2 = -0.01232                ua1 = 4.0941E-9
+ub1 = -4.8969E-18             uc1 = -5.5E-11                at = 4.00001E4
+prt = 0                       njs = 1                       xtis = 3
+tpb = 1.9E-3                  tpbsw = 1.9E-3                tpbswg = 1.9E-3
+tcj = 7.98E-4                 tcjsw = 2.4E-4                tcjswg = 4.77E-3
//*** well proximity effect model parameters ***
+web = 0                       wec = 0                       kvth0we = -2E-3
+k2we = 0                      ku0we = -4.1E-3               scref = 1E-6
18:type=p  minr=1e-60
//*** flag parameter ***
+version = 4.3                 binunit = 2                   mobmod = 0
+capmod = 2                    rdsmod = 0                    igcmod = 1
+igbmod = 1                    rbodymod = 0                  trnqsmod = 0
+acnqsmod = 0                  fnoimod = 1                   tnoimod = 0
+diomod = 1                    permod = 1                    rgatemod = 0
+wpemod = 0
//*** geometry range parameter ***
+lmin = 1E-6                   lmax = 2E-6                   wmin = 1E-5
+wmax = 9E-4
//*** process parameter ***
+epsrox = 3.9                  toxe = tox_p_18_cap               toxm = tox_p_18_cap
+dtox = 3.1E-10                xj = 1.7E-7                   ndep = 8.5E17
+ngate = 8E19                  nsd = 1E20                    rsh = 9.68
+rshg = 0.1
//*** dw and dl parameter ***
+wint = 1.389287E-8            wl = 0                        wln = 1
+ww = 0                        wwn = 1                       wwl = 0
+lint = 0                      ll = 0                        lln = 1
+lw = 0                        lwn = 1                       lwl = 0
+lwc = 0                       lwlc = 0                      wwc = 0
+wwlc = 0                      dwg = 0                       dwb = 0
+xl = 0.0+dxl_p_18_cap             xw = 0.0+dxw_p_18_cap
//*** flicker noise model parameter ***
+noia = 7.45E41                noib = 1.57E26                noic = 2E10
+em = 2.1E7                    ef = 1.3
//***layout-dependent parasitics model parameter ***
+dmcg = 8.5E-8                 dmci = 8.5E-8                 dmdg = 0
+dmcgt = 0                     dwj = 0                       xgw = 0
+xgl = 0                       ngcon = 1
//*** vth related  parameter ***
+vth0 = -0.35906+dvth0_p_18_cap    lvth0 = 0.0+dlvth0_p_18_cap       wvth0 = 0.0+dwvth0_p_18_cap
+pvth0 = 0.0+dpvth0_p_18_cap       phin = 0                      k1 = 0.25
+k2 = -1.21927E-2              k3 = -3.3                     k3b = 1.200306
+w0 = 1.585076E-7              lpe0 = 7.519925E-8            lpeb = 5.608072E-8
+dvtp0 = 2.2E-6                dvtp1 = 0.2                   dvt0 = 0.20341
+dvt1 = 0.95146                dvt2 = 0.01                   dvt0w = 0
+dvt1w = 5.366499E6            dvt2w = 0
//*** mobility related parameter ***
+u0 = 0.0196662+du0_p_18_cap       lu0 = 0.0+dlu0_p_18_cap           wu0 = 0.0+dwu0_p_18_cap
+pu0 = 0.0+dpu0_p_18_cap           ua = 2.455E-10                ub = 2.539767E-18
+uc = 4.336286E-11             ud = 0                        vsat = 65731.5+dvsat_p_18_cap
+a0 = 0.693823                 ags = 1.93352                 b0 = 0
+b1 = 0                        keta = -6.14042E-2            a1 = 0
+a2 = 1                        rdsw = 327.6                  prwb = -0.249981
+prwg = 0.25                   wr = 1
//*** subthreshold related parameter ***
+voff = -0.05137               voffl = -6.036214E-9          minv = 0
+nfactor = 0.627693            eta0 = 3.11538E-2             etab = -2.38505E-2
+dsub = 1.2725                 cit = 1E-4                    cdsc = 0
+cdscb = 0                     cdscd = 0
//*** output resistance related parameter ***
+pclm = 0.627258               pdiblc1 = 0                   pdiblc2 = 9.579679E-3
+pdiblcb = 0                   drout = 1.132692              pscbe1 = 9.264E8
+pscbe2 = 1E-20                pvag = 1.425                  delta = 0.02
+fprout = 390.234144           pdits = 5.042617E-3           pditsl = 100
+pditsd = 0                    lc = 0                        alpha0 = 0
+alpha1 = 0.06                 beta0 = 13.5                  agidl = 7.8E-8
+bgidl = 2.404E9               cgidl = 0.47                  egidl = 0.14
//*** gate dielectric tunneling current ***
+aigbacc = 0.014               bigbacc = 2.7E-3              cigbacc = 0.121
+nigbacc = 4.8                 aigbinv = 0.37                bigbinv = 0.028
+cigbinv = 6.4E-3              eigbinv = 1.2                 nigbinv = 1.5
+aigc = 6.8E-3                 bigc = 5.91E-4                cigc = 0
+aigsd = 6.1E-3                bigsd = 2.14E-4               cigsd = 0.037
+dlcig = 2.21E-9               nigc = 2.31                   poxedge = 1
+pigcd = 2.25                  ntox = 1                      toxref = 3E-9
//*** capacitance parameter ***
+xpart = 1                     cgso = 2.2E-11+dcgso_p_18_cap     cgdo = 2.2E-11+dcgdo_p_18_cap
+cgbo = 0                      ckappas = 0.6                 ckappad = 0.6
+cf = 1.08E-10                 clc = 1E-7                    cle = 0.6
+dlc = 0                 dwc = 0                       noff = 2
+voffcv = -0.084               acde = 1.2                    moin = 6.4
+cgsl = 1E-10+dcgsl_p_18_cap    cgdl = 1E-10+dcgdl_p_18_cap
//*** souce/drain junction diode model parameter **
+ijthsrev = 0.01               ijthsfwd = 0.01               xjbvs = 1
+bvs = 10                      jss = 3.1E-7                  jsws = 1E-12
+jswgs = 2.87E-12              cjs = 9.7E-4+dcj_p_18_cap         mjs = 0.41
+mjsws = 0.097                 cjsws = 1.1E-10+dcjsw_p_18_cap    cjswgs = 2.3E-10+dcjswg_p_18_cap
+mjswgs = 0.88                 pbs = 0.75                    pbsws = 0.49
+pbswgs = 0.8
//** rf model related parameter ***
+xrcrg1 = 12                   xrcrg2 = 1                    rbpb = 50
+rbpd = 50                     rbps = 50                     rbdb = 50
+rbsb = 50                     gbmin = 1E-12
//*** stress effect related parameter ***
+saref = 6.1E-7                sbref = 6.1E-7                wlod = 2.86E-7
+ku0 = 1.2E-7                  kvsat = -0.34                 kvth0 = 1.7E-10
+tku0 = 0.24                   llodku0 = 1                   wlodku0 = 1
+llodvth = 1.8                 wlodvth = 1                   lku0 = 1.871E-7
+wku0 = 2.4E-7                 pku0 = -3.24E-14              lkvth0 = 2.4E-10
+wkvth0 = 1.8E-10              pkvth0 = 0                    stk2 = 0
+lodk2 = 1.9                   steta0 = 0                    lodeta0 = 1
//*** temperature coefficient ***
+tnom = 25                     ute = -1.2192                 kt1 = -0.2061
+kt1l = 0                      kt2 = -0.01232                ua1 = 4.0941E-9
+ub1 = -4.8969E-18             uc1 = -5.5E-11                at = 4.00001E4
+prt = 0                       njs = 1                       xtis = 3
+tpb = 1.9E-3                  tpbsw = 1.9E-3                tpbswg = 1.9E-3
+tcj = 7.98E-4                 tcjsw = 2.4E-4                tcjswg = 4.77E-3
//*** well proximity effect model parameters ***
+web = 0                       wec = 0                       kvth0we = -2E-3
+k2we = 0                      ku0we = -4.1E-3               scref = 1E-6
19:type=p  minr=1e-60
//*** flag parameter ***
+version = 4.3                 binunit = 2                   mobmod = 0
+capmod = 2                    rdsmod = 0                    igcmod = 1
+igbmod = 1                    rbodymod = 0                  trnqsmod = 0
+acnqsmod = 0                  fnoimod = 1                   tnoimod = 0
+diomod = 1                    permod = 1                    rgatemod = 0
+wpemod = 0
//*** geometry range parameter ***
+lmin = 2E-6                   lmax = 1E-5                   wmin = 1E-5
+wmax = 9E-4
//*** process parameter ***
+epsrox = 3.9                  toxe = tox_p_18_cap               toxm = tox_p_18_cap
+dtox = 3.1E-10                xj = 1.7E-7                   ndep = 8.5E17
+ngate = 8E19                  nsd = 1E20                    rsh = 9.68
+rshg = 0.1
//*** dw and dl parameter ***
+wint = 1.389287E-8            wl = 0                        wln = 1
+ww = 0                        wwn = 1                       wwl = 0
+lint = 0                      ll = 0                        lln = 1
+lw = 0                        lwn = 1                       lwl = 0
+lwc = 0                       lwlc = 0                      wwc = 0
+wwlc = 0                      dwg = 0                       dwb = 0
+xl = 0.0+dxl_p_18_cap             xw = 0.0+dxw_p_18_cap
//*** flicker noise model parameter ***
+noia = 7.45E41                noib = 1.57E26                noic = 2E10
+em = 2.1E7                    ef = 1.3
//***layout-dependent parasitics model parameter ***
+dmcg = 8.5E-8                 dmci = 8.5E-8                 dmdg = 0
+dmcgt = 0                     dwj = 0                       xgw = 0
+xgl = 0                       ngcon = 1
//*** vth related  parameter ***
+vth0 = -0.35906+dvth0_p_18_cap    lvth0 = 0.0+dlvth0_p_18_cap       wvth0 = 0.0+dwvth0_p_18_cap
+pvth0 = 0.0+dpvth0_p_18_cap       phin = 0                      k1 = 0.25
+k2 = -1.21927E-2              k3 = -3.3                     k3b = 1.200306
+w0 = 1.585076E-7              lpe0 = 7.519925E-8            lpeb = 5.608072E-8
+dvtp0 = 2.2E-6                dvtp1 = 0.2                   dvt0 = 0.20341
+dvt1 = 0.95146                dvt2 = 0.01                   dvt0w = 0
+dvt1w = 5.366499E6            dvt2w = 0
//*** mobility related parameter ***
+u0 = 0.0196662+du0_p_18_cap       lu0 = 0.0+dlu0_p_18_cap           wu0 = 0.0+dwu0_p_18_cap
+pu0 = 0.0+dpu0_p_18_cap           ua = 2.455E-10                ub = 2.539767E-18
+uc = 4.336286E-11             ud = 0                        vsat = 65731.5+dvsat_p_18_cap
+a0 = 0.693823                 ags = 1.93352                 b0 = 0
+b1 = 0                        keta = -6.14042E-2            a1 = 0
+a2 = 1                        rdsw = 327.6                  prwb = -0.249981
+prwg = 0.25                   wr = 1
//*** subthreshold related parameter ***
+voff = -0.05137               voffl = -6.036214E-9          minv = 0
+nfactor = 0.627693            eta0 = 3.11538E-2             etab = -2.38505E-2
+dsub = 1.2725                 cit = 1E-4                    cdsc = 0
+cdscb = 0                     cdscd = 0
//*** output resistance related parameter ***
+pclm = 0.627258               pdiblc1 = 0                   pdiblc2 = 9.579679E-3
+pdiblcb = 0                   drout = 1.132692              pscbe1 = 9.264E8
+pscbe2 = 1E-20                pvag = 1.425                  delta = 0.02
+fprout = 390.234144           pdits = 5.042617E-3           pditsl = 100
+pditsd = 0                    lc = 0                        alpha0 = 0
+alpha1 = 0.06                 beta0 = 13.5                  agidl = 7.8E-8
+bgidl = 2.404E9               cgidl = 0.47                  egidl = 0.14
//*** gate dielectric tunneling current ***
+aigbacc = 0.014               bigbacc = 2.7E-3              cigbacc = 0.121
+nigbacc = 4.8                 aigbinv = 0.37                bigbinv = 0.028
+cigbinv = 6.4E-3              eigbinv = 1.2                 nigbinv = 1.5
+aigc = 6.8E-3                 bigc = 5.91E-4                cigc = 0
+aigsd = 6.1E-3                bigsd = 2.14E-4               cigsd = 0.037
+dlcig = 2.21E-9               nigc = 2.31                   poxedge = 1
+pigcd = 2.25                  ntox = 1                      toxref = 3E-9
//*** capacitance parameter ***
+xpart = 1                     cgso = 2.2E-11+dcgso_p_18_cap     cgdo = 2.2E-11+dcgdo_p_18_cap
+cgbo = 0                      ckappas = 0.6                 ckappad = 0.6
+cf = 1.08E-10                 clc = 1E-7                    cle = 0.6
+dlc = 0                 dwc = 0                       noff = 2
+voffcv = -0.084               acde = 1.2                    moin = 6.4
+cgsl = 1E-10+dcgsl_p_18_cap    cgdl = 1E-10+dcgdl_p_18_cap
//*** souce/drain junction diode model parameter **
+ijthsrev = 0.01               ijthsfwd = 0.01               xjbvs = 1
+bvs = 10                      jss = 3.1E-7                  jsws = 1E-12
+jswgs = 2.87E-12              cjs = 9.7E-4+dcj_p_18_cap         mjs = 0.41
+mjsws = 0.097                 cjsws = 1.1E-10+dcjsw_p_18_cap    cjswgs = 2.3E-10+dcjswg_p_18_cap
+mjswgs = 0.88                 pbs = 0.75                    pbsws = 0.49
+pbswgs = 0.8
//** rf model related parameter ***
+xrcrg1 = 12                   xrcrg2 = 1                    rbpb = 50
+rbpd = 50                     rbps = 50                     rbdb = 50
+rbsb = 50                     gbmin = 1E-12
//*** stress effect related parameter ***
+saref = 6.1E-7                sbref = 6.1E-7                wlod = 2.86E-7
+ku0 = 1.2E-7                  kvsat = -0.34                 kvth0 = 1.7E-10
+tku0 = 0.24                   llodku0 = 1                   wlodku0 = 1
+llodvth = 1.8                 wlodvth = 1                   lku0 = 1.871E-7
+wku0 = 2.4E-7                 pku0 = -3.24E-14              lkvth0 = 2.4E-10
+wkvth0 = 1.8E-10              pkvth0 = 0                    stk2 = 0
+lodk2 = 1.9                   steta0 = 0                    lodeta0 = 1
//*** temperature coefficient ***
+tnom = 25                     ute = -1.2192                 kt1 = -0.2061
+kt1l = 0                      kt2 = -0.01232                ua1 = 4.0941E-9
+ub1 = -4.8969E-18             uc1 = -5.5E-11                at = 4.00001E4
+prt = 0                       njs = 1                       xtis = 3
+tpb = 1.9E-3                  tpbsw = 1.9E-3                tpbswg = 1.9E-3
+tcj = 7.98E-4                 tcjsw = 2.4E-4                tcjswg = 4.77E-3
//*** well proximity effect model parameters ***
+web = 0                       wec = 0                       kvth0we = -2E-3
+k2we = 0                      ku0we = -4.1E-3               scref = 1E-6
20:type=p  minr=1e-60
//*** flag parameter ***
+version = 4.3                 binunit = 2                   mobmod = 0
+capmod = 2                    rdsmod = 0                    igcmod = 1
+igbmod = 1                    rbodymod = 0                  trnqsmod = 0
+acnqsmod = 0                  fnoimod = 1                   tnoimod = 0
+diomod = 1                    permod = 1                    rgatemod = 0
+wpemod = 0
//*** geometry range parameter ***
+lmin = 1E-5                   lmax = 9E-4                   wmin = 1E-5
+wmax = 9E-4
//*** process parameter ***
+epsrox = 3.9                  toxe = tox_p_18_cap               toxm = tox_p_18_cap
+dtox = 3.1E-10                xj = 1.7E-7                   ndep = 8.5E17
+ngate = 8E19                  nsd = 1E20                    rsh = 9.68
+rshg = 0.1
//*** dw and dl parameter ***
+wint = 1.389287E-8            wl = 0                        wln = 1
+ww = 0                        wwn = 1                       wwl = 0
+lint = 0                      ll = 0                        lln = 1
+lw = 0                        lwn = 1                       lwl = 0
+lwc = 0                       lwlc = 0                      wwc = 0
+wwlc = 0                      dwg = 0                       dwb = 0
+xl = 0.0+dxl_p_18_cap             xw = 0.0+dxw_p_18_cap
//*** flicker noise model parameter ***
+noia = 7.45E41                noib = 1.57E26                noic = 2E10
+em = 2.1E7                    ef = 1.3
//***layout-dependent parasitics model parameter ***
+dmcg = 8.5E-8                 dmci = 8.5E-8                 dmdg = 0
+dmcgt = 0                     dwj = 0                       xgw = 0
+xgl = 0                       ngcon = 1
//*** vth related  parameter ***
+vth0 = -0.35906+dvth0_p_18_cap    lvth0 = 0.0+dlvth0_p_18_cap       wvth0 = 0.0+dwvth0_p_18_cap
+pvth0 = 0.0+dpvth0_p_18_cap       phin = 0                      k1 = 0.25
+k2 = -1.21927E-2              k3 = -3.3                     k3b = 1.200306
+w0 = 1.585076E-7              lpe0 = 7.519925E-8            lpeb = 5.608072E-8
+dvtp0 = 2.2E-6                dvtp1 = 0.2                   dvt0 = 0.20341
+dvt1 = 0.95146                dvt2 = 0.01                   dvt0w = 0
+dvt1w = 5.366499E6            dvt2w = 0
//*** mobility related parameter ***
+u0 = 0.0196662+du0_p_18_cap       lu0 = 0.0+dlu0_p_18_cap           wu0 = 0.0+dwu0_p_18_cap
+pu0 = 0.0+dpu0_p_18_cap           ua = 2.455E-10                ub = 2.539767E-18
+uc = 4.336286E-11             ud = 0                        vsat = 65731.5+dvsat_p_18_cap
+a0 = 0.693823                 ags = 1.93352                 b0 = 0
+b1 = 0                        keta = -6.14042E-2            a1 = 0
+a2 = 1                        rdsw = 327.6                  prwb = -0.249981
+prwg = 0.25                   wr = 1
//*** subthreshold related parameter ***
+voff = -0.05137               voffl = -6.036214E-9          minv = 0
+nfactor = 0.627693            eta0 = 3.11538E-2             etab = -2.38505E-2
+dsub = 1.2725                 cit = 1E-4                    cdsc = 0
+cdscb = 0                     cdscd = 0
//*** output resistance related parameter ***
+pclm = 0.627258               pdiblc1 = 0                   pdiblc2 = 9.579679E-3
+pdiblcb = 0                   drout = 1.132692              pscbe1 = 9.264E8
+pscbe2 = 1E-20                pvag = 1.425                  delta = 0.02
+fprout = 390.234144           pdits = 5.042617E-3           pditsl = 100
+pditsd = 0                    lc = 0                        alpha0 = 0
+alpha1 = 0.06                 beta0 = 13.5                  agidl = 7.8E-8
+bgidl = 2.404E9               cgidl = 0.47                  egidl = 0.14
//*** gate dielectric tunneling current ***
+aigbacc = 0.014               bigbacc = 2.7E-3              cigbacc = 0.121
+nigbacc = 4.8                 aigbinv = 0.37                bigbinv = 0.028
+cigbinv = 6.4E-3              eigbinv = 1.2                 nigbinv = 1.5
+aigc = 6.8E-3                 bigc = 5.91E-4                cigc = 0
+aigsd = 6.1E-3                bigsd = 2.14E-4               cigsd = 0.037
+dlcig = 2.21E-9               nigc = 2.31                   poxedge = 1
+pigcd = 2.25                  ntox = 1                      toxref = 3E-9
//*** capacitance parameter ***
+xpart = 1                     cgso = 2.2E-11+dcgso_p_18_cap     cgdo = 2.2E-11+dcgdo_p_18_cap
+cgbo = 0                      ckappas = 0.6                 ckappad = 0.6
+cf = 1.08E-10                 clc = 1E-7                    cle = 0.6
+dlc = 0                 dwc = 0                       noff = 2
+voffcv = -0.084               acde = 1.2                    moin = 6.4
+cgsl = 1E-10+dcgsl_p_18_cap    cgdl = 1E-10+dcgdl_p_18_cap
//*** souce/drain junction diode model parameter **
+ijthsrev = 0.01               ijthsfwd = 0.01               xjbvs = 1
+bvs = 10                      jss = 3.1E-7                  jsws = 1E-12
+jswgs = 2.87E-12              cjs = 9.7E-4+dcj_p_18_cap         mjs = 0.41
+mjsws = 0.097                 cjsws = 1.1E-10+dcjsw_p_18_cap    cjswgs = 2.3E-10+dcjswg_p_18_cap
+mjswgs = 0.88                 pbs = 0.75                    pbsws = 0.49
+pbswgs = 0.8
//** rf model related parameter ***
+xrcrg1 = 12                   xrcrg2 = 1                    rbpb = 50
+rbpd = 50                     rbps = 50                     rbdb = 50
+rbsb = 50                     gbmin = 1E-12
//*** stress effect related parameter ***
+saref = 6.1E-7                sbref = 6.1E-7                wlod = 2.86E-7
+ku0 = 1.2E-7                  kvsat = -0.34                 kvth0 = 1.7E-10
+tku0 = 0.24                   llodku0 = 1                   wlodku0 = 1
+llodvth = 1.8                 wlodvth = 1                   lku0 = 1.871E-7
+wku0 = 2.4E-7                 pku0 = -3.24E-14              lkvth0 = 2.4E-10
+wkvth0 = 1.8E-10              pkvth0 = 0                    stk2 = 0
+lodk2 = 1.9                   steta0 = 0                    lodeta0 = 1
//*** temperature coefficient ***
+tnom = 25                     ute = -1.2192                 kt1 = -0.2061
+kt1l = 0                      kt2 = -0.01232                ua1 = 4.0941E-9
+ub1 = -4.8969E-18             uc1 = -5.5E-11                at = 4.00001E4
+prt = 0                       njs = 1                       xtis = 3
+tpb = 1.9E-3                  tpbsw = 1.9E-3                tpbswg = 1.9E-3
+tcj = 7.98E-4                 tcjsw = 2.4E-4                tcjswg = 4.77E-3
//*** well proximity effect model parameters ***
+web = 0                       wec = 0                       kvth0we = -2E-3
+k2we = 0                      ku0we = -4.1E-3               scref = 1E-6
}

endsection moscap18

section s1v_mac
subckt g45ncap1 (d g s b)
parameters l=0.1u w=10u multi=1 factor=1 nrd=0 nrs=0 trise=0
mcore (d g s b) nch_mac  w=w l=l nrd=nrd nrs=nrs trise=trise
ends g45ncap1

subckt g45pcap1 (d g s b)
parameters l=0.1u w=10u multi=1 factor=1 nrd=0 nrs=0 trise=0
mcore (d g s b) pch_mac  w=w l=l nrd=nrd nrs=nrs trise=trise
ends g45pcap1

endsection s1v_mac

section s1p8v_mac

subckt g45ncap2 (d g s b)
parameters l=0.1u w=10u multi=1 factor=1 nrd=0 nrs=0 trise=0
mcore (d g s b) nch18_mac  w=w l=l nrd=nrd nrs=nrs trise=trise
ends g45ncap2

subckt g45pcap2 (d g s b)
parameters l=0.1u w=10u multi=1 factor=1 nrd=0 nrs=0 trise=0
mcore (d g s b) pch18_mac  w=w l=l nrd=nrd nrs=nrs trise=trise
ends g45pcap2
endsection s1p8v_mac

endlibrary  gpdk045
