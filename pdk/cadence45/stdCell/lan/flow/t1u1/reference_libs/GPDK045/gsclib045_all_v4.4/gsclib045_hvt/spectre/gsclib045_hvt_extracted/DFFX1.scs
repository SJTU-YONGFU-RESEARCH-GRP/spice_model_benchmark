// Generated for: spectre (May  1 09:15:01 2013 )
// Library name: gsclib045_hvt
// Cell name: DFFX1
// View name: extracted

simulator lang=spectre

subckt DFFX1 CK D Q QN VDD VSS
mp57 (\1\:QN \4\:qint \15\:VDD VDD) g45p1hvt w=(3.9e-07) l=4.5e-08 nf=1 \
        as=7.142e-14 ad=5.46e-14 ps=1.52e-06 pd=1.06e-06 nrd=1.16667 \
        nrs=1.16667 sa=1.4e-07 sb=2.49744e-07 sd=160n sca=35.2977 \
        scb=0.0266107 scc=0.00346222 m=(1)
mp55 (\1\:Q qbint \12\:VDD VDD) g45p1hvt w=(3.9e-07) l=4.5e-08 nf=1 \
        as=8.555e-14 ad=5.46e-14 ps=1.92e-06 pd=1.06e-06 nrd=1.16667 \
        nrs=1.16667 sa=1.4e-07 sb=2.87436e-07 sd=160n sca=19.0259 \
        scb=0.0163587 scc=0.00171562 m=(1)
C1 (D VSS) capacitor c=8.25216e-17
C2 (QN VSS) capacitor c=2.1175e-17
C3 (Q VSS) capacitor c=4.07219e-17
C4 (VDD VSS) capacitor c=2.47524e-16
C5 (CK VSS) capacitor c=4.06489e-17
C6 (qint VSS) capacitor c=2.13586e-17
C7 (qbint VSS) capacitor c=4.56704e-17
C8 (CKb VSS) capacitor c=2.26755e-17
C9 (n30 VSS) capacitor c=4.02362e-17
C10 (n35 VSS) capacitor c=2.55819e-18
C11 (mout VSS) capacitor c=5.06335e-17
C12 (CKbb VSS) capacitor c=5.1112e-17
C13 (n20 VSS) capacitor c=3.2118e-17
C14 (n25 VSS) capacitor c=1.73661e-18
C15 (n21 VSS) capacitor c=7.01524e-19
C16 (n36 VSS) capacitor c=1.1262e-18
C17 (n26 VSS) capacitor c=8.70796e-19
C18 (n22 VSS) capacitor c=7.32139e-19
C19 (\10\:CKb VSS) capacitor c=4.66928e-17
C20 (\1\:D VSS) capacitor c=3.15347e-17
C21 (\5\:CKbb VSS) capacitor c=6.9781e-17
C22 (\5\:CKb VSS) capacitor c=5.14322e-17
C23 (\4\:mout VSS) capacitor c=7.89007e-17
C24 (\4\:n20 VSS) capacitor c=3.56696e-17
C25 (\2\:CKbb VSS) capacitor c=4.83774e-17
C26 (\8\:qbint VSS) capacitor c=6.78558e-17
C27 (\3\:n30 VSS) capacitor c=4.02986e-17
C28 (\1\:CK VSS) capacitor c=3.19565e-17
C29 (\7\:qbint VSS) capacitor c=3.31148e-17
C30 (\4\:qint VSS) capacitor c=4.52163e-17
C31 (\8\:CKb VSS) capacitor c=2.88626e-17
C32 (\3\:D VSS) capacitor c=8.07237e-17
C33 (\6\:CKb VSS) capacitor c=7.19358e-17
C34 (\6\:CKbb VSS) capacitor c=6.43098e-17
C35 (\3\:n20 VSS) capacitor c=4.9931e-17
C36 (\3\:CKbb VSS) capacitor c=4.02968e-17
C37 (\3\:CKb VSS) capacitor c=6.0241e-17
C38 (\11\:qbint VSS) capacitor c=3.56819e-17
C39 (\3\:CK VSS) capacitor c=3.50065e-17
C40 (\5\:qbint VSS) capacitor c=3.11695e-17
C41 (\4\:qbint VSS) capacitor c=2.72438e-17
C42 (\3\:qint VSS) capacitor c=3.64658e-17
C43 (\9\:CKb VSS) capacitor c=3.88397e-17
C44 (\2\:D VSS) capacitor c=6.04176e-17
C45 (\7\:CKb VSS) capacitor c=5.25326e-17
C46 (\7\:CKbb VSS) capacitor c=3.00387e-17
C47 (\4\:CKb VSS) capacitor c=5.00172e-17
C48 (\3\:mout VSS) capacitor c=3.41489e-17
C49 (\4\:CKbb VSS) capacitor c=3.94816e-17
C50 (\2\:CKb VSS) capacitor c=6.85356e-17
C51 (\10\:qbint VSS) capacitor c=2.68585e-17
C52 (\2\:n30 VSS) capacitor c=4.42892e-17
C53 (\2\:CK VSS) capacitor c=2.83132e-17
C54 (\13\:CKbb VSS) capacitor c=4.46506e-17
C55 (\1\:VDD VSS) capacitor c=3.62135e-17
C56 (\9\:n20 VSS) capacitor c=6.3773e-17
C57 (\8\:VDD VSS) capacitor c=1.41398e-17
C58 (\9\:mout VSS) capacitor c=6.09022e-17
C59 (\8\:n30 VSS) capacitor c=6.12715e-17
C60 (\10\:VDD VSS) capacitor c=1.49885e-17
C61 (\16\:qbint VSS) capacitor c=6.60424e-17
C62 (\15\:CKb VSS) capacitor c=1.46037e-16
C63 (\12\:VDD VSS) capacitor c=1.2322e-17
C64 (\1\:Q VSS) capacitor c=6.97323e-17
C65 (\5\:qint VSS) capacitor c=2.37998e-17
C66 (\15\:VDD VSS) capacitor c=1.96133e-17
C67 (\1\:QN VSS) capacitor c=3.58613e-17
C68 (\3\:VDD VSS) capacitor c=6.41271e-17
C69 (\8\:CKbb VSS) capacitor c=1.28346e-16
C70 (\5\:n20 VSS) capacitor c=8.67881e-17
C71 (\7\:mout VSS) capacitor c=4.48265e-17
C72 (\4\:n30 VSS) capacitor c=5.74075e-17
C73 (\13\:qbint VSS) capacitor c=7.39829e-17
C74 (\17\:CKb VSS) capacitor c=8.40801e-17
C75 (\3\:Q VSS) capacitor c=2.50746e-17
C76 (\9\:qint VSS) capacitor c=2.21292e-17
C77 (\3\:QN VSS) capacitor c=2.63069e-17
C78 (\2\:qint VSS) capacitor c=7.12383e-18
C79 (\2\:qbint VSS) capacitor c=4.03e-17
C80 (\3\:qbint VSS) capacitor c=3.27443e-17
C81 (\9\:qbint VSS) capacitor c=3.12381e-17
C82 (\2\:n20 VSS) capacitor c=3.31176e-17
C83 (\2\:mout VSS) capacitor c=4.12411e-17
C84 (\7\:qint VSS) capacitor c=2.28364e-17
C85 (\8\:qint VSS) capacitor c=1.98953e-17
C86 (\4\:CK VSS) capacitor c=7.3454e-17
C87 (\12\:qbint VSS) capacitor c=1.33302e-16
C88 (\15\:qbint VSS) capacitor c=6.08538e-17
C89 (\18\:qbint VSS) capacitor c=5.79106e-17
C90 (\6\:n30 VSS) capacitor c=7.1627e-17
C91 (\7\:n30 VSS) capacitor c=4.9543e-17
C92 (\5\:mout VSS) capacitor c=3.03714e-17
C93 (\6\:mout VSS) capacitor c=5.23718e-17
C94 (\7\:n20 VSS) capacitor c=5.73044e-17
C95 (\8\:n20 VSS) capacitor c=4.07e-17
C96 (\4\:D VSS) capacitor c=2.34028e-17
C97 (\11\:CKb VSS) capacitor c=6.47786e-17
C98 (\12\:CKb VSS) capacitor c=7.28769e-17
C99 (\13\:CKb VSS) capacitor c=1.02218e-16
C100 (\14\:CKb VSS) capacitor c=1.74037e-16
C101 (\19\:CKb VSS) capacitor c=4.05011e-17
C102 (\20\:CKb VSS) capacitor c=5.03118e-17
C103 (\10\:CKbb VSS) capacitor c=1.50485e-16
C104 (\11\:CKbb VSS) capacitor c=1.03566e-16
C105 (\12\:CKbb VSS) capacitor c=5.96848e-17
C106 (\15\:CKbb VSS) capacitor c=2.40635e-17
C107 (\5\:VDD VSS) capacitor c=2.96932e-17
C108 (\6\:VDD VSS) capacitor c=3.31046e-17
C109 (\14\:VDD VSS) capacitor c=1.18323e-17
Rk22 (\4\:D D) resistor r=0.03661 c=0
Rk2 (\4\:QN QN) resistor r=0.07346 c=0
Rk1 (\2\:QN \4\:QN) resistor r=0.3051 c=0
Rk6 (\2\:Q Q) resistor r=0.3648 c=0
Rk7 (Q \4\:Q) resistor r=0.04326 c=0
Rk35 (\2\:VDD \4\:VDD) resistor r=0.4886 c=0
Rk36 (\4\:VDD \5\:VDD) resistor r=0.2344 c=0
Rk37 (\5\:VDD \6\:VDD) resistor r=0.4889 c=0
Rk38 (\6\:VDD \7\:VDD) resistor r=0.3247 c=0
Rk39 (\5\:VDD \9\:VDD) resistor r=0.04327 c=0
Rk40 (\6\:VDD \11\:VDD) resistor r=0.04327 c=0
Rk41 (\7\:VDD \13\:VDD) resistor r=0.1196 c=0
Rk44 (\14\:VDD VDD) resistor r=0.195 c=0
Rk42 (\7\:VDD \14\:VDD) resistor r=0.3563 c=0
Rk43 (\14\:VDD \16\:VDD) resistor r=0.223 c=0
Rk8 (CK \4\:CK) resistor r=0.1611 c=0
Rk45 (\2\:VSS \4\:VSS) resistor r=0.4471 c=0
Rk46 (\4\:VSS \5\:VSS) resistor r=0.1928 c=0
Rk47 (\5\:VSS \6\:VSS) resistor r=0.5209 c=0
Rk48 (\6\:VSS \7\:VSS) resistor r=0.3381 c=0
Rk49 (\7\:VSS \8\:VSS) resistor r=0.05243 c=0
Rk51 (\9\:VSS VSS) resistor r=0.195 c=0
Rk50 (\8\:VSS \9\:VSS) resistor r=0.3029 c=0
Rk52 (\5\:VSS \11\:VSS) resistor r=0.1021 c=0
Rk53 (\6\:VSS \13\:VSS) resistor r=0.3552 c=0
Rk54 (\8\:VSS \15\:VSS) resistor r=0.292 c=0
Rk55 (\9\:VSS \17\:VSS) resistor r=0.07346 c=0
Rk3 (\6\:qint \7\:qint) resistor r=0.1175 c=0
Rk4 (\7\:qint \8\:qint) resistor r=0.1191 c=0
Rk5 (\7\:qint \10\:qint) resistor r=0.1055 c=0
Rk9 (\12\:qbint \14\:qbint) resistor r=0.7584 c=0
Rk10 (\14\:qbint \15\:qbint) resistor r=0.2002 c=0
Rk11 (\15\:qbint \17\:qbint) resistor r=0.3184 c=0
Rk12 (\15\:qbint \18\:qbint) resistor r=0.2298 c=0
Rk23 (\11\:CKb \12\:CKb) resistor r=0.2903 c=0
Rk24 (\12\:CKb \13\:CKb) resistor r=0.1037 c=0
Rk25 (\13\:CKb \14\:CKb) resistor r=0.9093 c=0
Rk26 (\14\:CKb \16\:CKb) resistor r=0.8361 c=0
Rk27 (\16\:CKb \18\:CKb) resistor r=0.3728 c=0
Rk28 (\13\:CKb \19\:CKb) resistor r=0.09725 c=0
Rk29 (\14\:CKb \20\:CKb) resistor r=0.2089 c=0
Rk13 (\5\:n30 \6\:n30) resistor r=0.3928 c=0
Rk14 (\6\:n30 \7\:n30) resistor r=0.2191 c=0
Rk15 (\6\:n30 \9\:n30) resistor r=0.2438 c=0
Rk16 (\5\:mout \6\:mout) resistor r=0.1078 c=0
Rk17 (\6\:mout \8\:mout) resistor r=0.1663 c=0
Rk18 (\6\:mout \10\:mout) resistor r=0.3304 c=0
Rk30 (\9\:CKbb \10\:CKbb) resistor r=0.6479 c=0
Rk31 (\10\:CKbb \11\:CKbb) resistor r=0.817 c=0
Rk32 (\11\:CKbb \12\:CKbb) resistor r=0.2641 c=0
Rk33 (\9\:CKbb \14\:CKbb) resistor r=0.4353 c=0
Rk34 (\11\:CKbb \15\:CKbb) resistor r=0.03523 c=0
Rk19 (\6\:n20 \7\:n20) resistor r=0.4354 c=0
Rk20 (\7\:n20 \8\:n20) resistor r=0.1231 c=0
Rk21 (\7\:n20 \10\:n20) resistor r=0.2779 c=0
Rl31 (\1\:D \2\:D) resistor r=42.2849 c=0
Rl32 (\2\:D \3\:D) resistor r=126.284 c=0
Rl10 (\1\:CK \2\:CK) resistor r=29.5379 c=0
Rl11 (\2\:CK \3\:CK) resistor r=56.461 c=0
Rl3 (\2\:qint \4\:qint) resistor r=49.7141 c=0
Rl2 (\2\:qint \3\:qint) resistor r=34.3295 c=0
Rl1 (qint \2\:qint) resistor r=5.915 c=0
Rl4 (qbint \2\:qbint) resistor r=74.7185 c=0
Rl7 (\2\:qbint \5\:qbint) resistor r=40.1031 c=0
Rl8 (\2\:qbint \6\:qbint) resistor r=6.4781 c=0
Rl9 (\3\:qbint \7\:qbint) resistor r=60.772 c=0
Rl6 (\3\:qbint \4\:qbint) resistor r=28.0797 c=0
Rl5 (\2\:qbint \3\:qbint) resistor r=153.345 c=0
Rl14 (\8\:qbint \9\:qbint) resistor r=120.868 c=0
Rl16 (\9\:qbint \11\:qbint) resistor r=47.791 c=0
Rl15 (\9\:qbint \10\:qbint) resistor r=2.7666 c=0
Rl34 (\9\:CKb \10\:CKb) resistor r=110.713 c=0
Rl33 (\8\:CKb \9\:CKb) resistor r=33.7903 c=0
Rl30 (\6\:CKb \7\:CKb) resistor r=74.2328 c=0
Rl27 (\4\:CKb \5\:CKb) resistor r=52.0674 c=0
Rl18 (CKb \2\:CKb) resistor r=24.2328 c=0
Rl19 (\2\:CKb \3\:CKb) resistor r=193.029 c=0
Rl13 (\2\:n30 \3\:n30) resistor r=50.7948 c=0
Rl12 (n30 \2\:n30) resistor r=101.923 c=0
Rl26 (\2\:mout \4\:mout) resistor r=114.125 c=0
Rl24 (mout \2\:mout) resistor r=73.3853 c=0
Rl25 (\2\:mout \3\:mout) resistor r=15.3298 c=0
Rl28 (\5\:CKbb \6\:CKbb) resistor r=197.643 c=0
Rl29 (\6\:CKbb \7\:CKbb) resistor r=26.1559 c=0
Rl20 (\3\:CKbb \4\:CKbb) resistor r=41.0764 c=0
Rl17 (CKbb \2\:CKbb) resistor r=61.5157 c=0
Rl23 (\2\:n20 \4\:n20) resistor r=51.6372 c=0
Rl22 (\2\:n20 \3\:n20) resistor r=117.022 c=0
Rl21 (n20 \2\:n20) resistor r=11.5001 c=0
Rz1 (\3\:QN \4\:QN) resistor r=75 c=0
Rz3 (\3\:Q \4\:Q) resistor r=75 c=0
Rz10 (\3\:VDD \4\:VDD) resistor r=8.3333 c=0
Rz11 (\3\:VDD \7\:VDD) resistor r=6.25 c=0
Rz12 (\1\:VSS \2\:VSS) resistor r=75 c=0
Rz13 (\10\:VSS \11\:VSS) resistor r=75 c=0
Rz14 (\12\:VSS \13\:VSS) resistor r=75 c=0
Rz15 (\14\:VSS \15\:VSS) resistor r=75 c=0
Rz16 (\16\:VSS \17\:VSS) resistor r=75 c=0
Rz2 (\9\:qint \10\:qint) resistor r=75 c=0
Rz4 (\13\:qbint \14\:qbint) resistor r=75 c=0
Rz8 (\17\:CKb \18\:CKb) resistor r=75 c=0
Rz5 (\4\:n30 \5\:n30) resistor r=75 c=0
Rz6 (\7\:mout \8\:mout) resistor r=75 c=0
Rz9 (\8\:CKbb \9\:CKbb) resistor r=75 c=0
Rz7 (\5\:n20 \6\:n20) resistor r=75 c=0
Ry1 (\1\:QN \2\:QN) resistor r=20.6667 c=0
Ry3 (\1\:Q \2\:Q) resistor r=20.6667 c=0
Ry10 (\1\:VDD \2\:VDD) resistor r=62 c=0
Ry11 (\8\:VDD \9\:VDD) resistor r=62 c=0
Ry12 (\10\:VDD \11\:VDD) resistor r=62 c=0
Ry13 (\12\:VDD \13\:VDD) resistor r=62 c=0
Ry14 (\15\:VDD \16\:VDD) resistor r=62 c=0
Ry15 (\3\:VSS \4\:VSS) resistor r=6.8889 c=0
Ry16 (\3\:VSS \7\:VSS) resistor r=5.1667 c=0
Ry2 (\5\:qint \6\:qint) resistor r=62 c=0
Ry4 (\16\:qbint \17\:qbint) resistor r=62 c=0
Ry8 (\15\:CKb \16\:CKb) resistor r=62 c=0
Ry5 (\8\:n30 \9\:n30) resistor r=62 c=0
Ry6 (\9\:mout \10\:mout) resistor r=62 c=0
Ry9 (\13\:CKbb \14\:CKbb) resistor r=62 c=0
Ry7 (\9\:n20 \10\:n20) resistor r=62 c=0
Rx8 (\2\:D \4\:D) resistor r=45 c=0
Rx2 (\2\:CK \4\:CK) resistor r=45 c=0
Rx1 (qint \8\:qint) resistor r=45 c=0
Rx3 (\6\:qbint \12\:qbint) resistor r=45 c=0
Rx4 (\10\:qbint \18\:qbint) resistor r=45 c=0
Rx9 (\9\:CKb \11\:CKb) resistor r=45 c=0
Rx10 (\7\:CKb \12\:CKb) resistor r=45 c=0
Rx11 (\4\:CKb \19\:CKb) resistor r=45 c=0
Rx12 (\2\:CKb \20\:CKb) resistor r=45 c=0
Rx5 (\2\:n30 \7\:n30) resistor r=45 c=0
Rx6 (\3\:mout \5\:mout) resistor r=45 c=0
Rx13 (\7\:CKbb \10\:CKbb) resistor r=45 c=0
Rx14 (CKbb \12\:CKbb) resistor r=45 c=0
Rx15 (\4\:CKbb \15\:CKbb) resistor r=45 c=0
Rx7 (n20 \8\:n20) resistor r=45 c=0
mn57 (\3\:QN \3\:qint \16\:VSS VSS) g45n1hvt w=(2.6e-07) l=4.5e-08 nf=1 \
        as=6.273e-14 ad=3.64e-14 ps=1.67e-06 pd=8e-07 nrd=1.16667 \
        nrs=1.16667 sa=1.4e-07 sb=2.50577e-07 sd=160n sca=17.5885 \
        scb=0.0172826 scc=0.00162584 m=(1)
mn55 (\3\:Q \5\:qbint \14\:VSS VSS) g45n1hvt w=(2.6e-07) l=4.5e-08 nf=1 \
        as=4.945e-14 ad=3.64e-14 ps=9.8e-07 pd=8e-07 nrd=1.16667 \
        nrs=1.16667 sa=1.4e-07 sb=3.18462e-07 sd=160n sca=17.5885 \
        scb=0.0172826 scc=0.00162584 m=(1)
mn56 (\9\:qint \4\:qbint \16\:VSS VSS) g45n1hvt w=(1.45e-07) l=4.5e-08 \
        nf=1 as=6.273e-14 ad=2.03e-14 ps=1.67e-06 pd=5.7e-07 nrd=1.16667 \
        nrs=1.16667 sa=3.7e-07 sb=1.4e-07 sd=160n sca=23.279 scb=0.0230742 \
        scc=0.00267719 m=(1)
mn20 (\17\:CKb \3\:CK \14\:VSS VSS) g45n1hvt w=(1.45e-07) l=4.5e-08 nf=1 \
        as=4.945e-14 ad=2.682e-14 ps=9.8e-07 pd=6.6e-07 nrd=1.16667 \
        nrs=1.16667 sa=4.15e-07 sb=1.85e-07 sd=160n sca=23.279 \
        scb=0.0230742 scc=0.00267719 m=(1)
mn45 (\13\:qbint n30 \12\:VSS VSS) g45n1hvt w=(1.45e-07) l=4.5e-08 nf=1 \
        as=2.392e-14 ad=2.03e-14 ps=6.2e-07 pd=5.7e-07 nrd=1.16667 \
        nrs=1.16667 sa=1.4e-07 sb=2e-06 sd=160n sca=18.4982 scb=0.0194884 \
        scc=0.00168796 m=(1)
mn50 (n35 \11\:qbint \12\:VSS VSS) g45n1hvt w=(1.45e-07) l=4.5e-08 nf=1 \
        as=2.392e-14 ad=1.667e-14 ps=6.2e-07 pd=5.2e-07 nrd=1.16667 \
        nrs=1.16667 sa=3.5e-07 sb=1.965e-06 sd=160n sca=18.4982 \
        scb=0.0194884 scc=0.00168796 m=(1)
mn51 (\4\:n30 \3\:CKb n35 VSS) g45n1hvt w=(1.45e-07) l=4.5e-08 nf=1 \
        as=1.667e-14 ad=4.132e-14 ps=5.2e-07 pd=8.6e-07 nrd=1.16667 \
        nrs=1.16667 sa=5.1e-07 sb=1.805e-06 sd=160n sca=18.4982 \
        scb=0.0194884 scc=0.00168796 m=(1)
mn40 (\4\:n30 \3\:CKbb \7\:mout VSS) g45n1hvt w=(1.45e-07) l=4.5e-08 nf=1 \
        as=2.61e-14 ad=4.132e-14 ps=6.5e-07 pd=8.6e-07 nrd=1.16667 \
        nrs=1.16667 sa=8.4e-07 sb=1.475e-06 sd=160n sca=18.4982 \
        scb=0.0194884 scc=0.00168796 m=(1)
mn30 (\7\:mout \3\:n20 \10\:VSS VSS) g45n1hvt w=(1.45e-07) l=4.5e-08 \
        nf=1 as=9.718e-14 ad=2.61e-14 ps=1.77e-06 pd=6.5e-07 nrd=1.16667 \
        nrs=1.16667 sa=1.065e-06 sb=1.25e-06 sd=160n sca=18.4982 \
        scb=0.0194884 scc=0.00168796 m=(1)
mn35 (n25 mout \10\:VSS VSS) g45n1hvt w=(1.45e-07) l=4.5e-08 nf=1 \
        as=9.718e-14 ad=1.595e-14 ps=1.77e-06 pd=5.1e-07 nrd=1.16667 \
        nrs=1.16667 sa=1.445e-06 sb=8.7e-07 sd=160n sca=18.4982 \
        scb=0.0194884 scc=0.00168796 m=(1)
mn36 (\5\:n20 \6\:CKbb n25 VSS) g45n1hvt w=(1.45e-07) l=4.5e-08 nf=1 \
        as=1.595e-14 ad=2.32e-14 ps=5.1e-07 pd=6.1e-07 nrd=1.16667 \
        nrs=1.16667 sa=1.6e-06 sb=7.15e-07 sd=160n sca=18.4982 \
        scb=0.0194884 scc=0.00168796 m=(1)
mn26 (\5\:n20 \6\:CKb n21 VSS) g45n1hvt w=(1.45e-07) l=4.5e-08 nf=1 \
        as=8.7e-15 ad=2.32e-14 ps=4.1e-07 pd=6.1e-07 nrd=1.16667 \
        nrs=1.16667 sa=1.805e-06 sb=5.1e-07 sd=160n sca=18.4982 \
        scb=0.0194884 scc=0.00168796 m=(1)
mn25 (n21 \3\:D \1\:VSS VSS) g45n1hvt w=(1.45e-07) l=4.5e-08 nf=1 \
        as=4.81e-14 ad=8.7e-15 ps=1e-06 pd=4.1e-07 nrd=1.16667 nrs=1.16667 \
        sa=1.91e-06 sb=4.05e-07 sd=160n sca=18.4982 scb=0.0194884 \
        scc=0.00168796 m=(1)
mn21 (\8\:CKbb \8\:CKb \1\:VSS VSS) g45n1hvt w=(1.45e-07) l=4.5e-08 nf=1 \
        as=4.81e-14 ad=2.03e-14 ps=1e-06 pd=5.7e-07 nrd=1.16667 \
        nrs=1.16667 sa=2e-06 sb=1.4e-07 sd=160n sca=18.4982 scb=0.0194884 \
        scc=0.00168796 m=(1)
mp56 (\5\:qint \7\:qbint \15\:VDD VDD) g45p1hvt w=(2.15e-07) l=4.5e-08 \
        nf=1 as=7.142e-14 ad=3.01e-14 ps=1.52e-06 pd=7.1e-07 nrd=1.16667 \
        nrs=1.16667 sa=3.7e-07 sb=1.4e-07 sd=160n sca=47.2218 \
        scb=0.0292973 scc=0.00588575 m=(1)
mp20 (\15\:CKb \1\:CK \12\:VDD VDD) g45p1hvt w=(2.15e-07) l=4.5e-08 nf=1 \
        as=8.555e-14 ad=3.977e-14 ps=1.92e-06 pd=8e-07 nrd=1.16667 \
        nrs=1.16667 sa=3.95e-07 sb=1.85e-07 sd=160n sca=25.9192 \
        scb=0.0230503 scc=0.00301683 m=(1)
mp45 (\16\:qbint \3\:n30 \10\:VDD VDD) g45p1hvt w=(2.15e-07) l=4.5e-08 \
        nf=1 as=8.63e-14 ad=3.01e-14 ps=1.52e-06 pd=7.1e-07 nrd=1.16667 \
        nrs=1.16667 sa=1.4e-07 sb=2e-06 sd=160n sca=12.1244 scb=0.0107968 \
        scc=0.000332109 m=(1)
mp50 (n36 \8\:qbint \10\:VDD VDD) g45p1hvt w=(2.15e-07) l=4.5e-08 nf=1 \
        as=8.63e-14 ad=1.827e-14 ps=1.52e-06 pd=6e-07 nrd=1.16667 \
        nrs=1.16667 sa=4.05e-07 sb=2e-06 sd=160n sca=12.1244 scb=0.0107968 \
        scc=0.000332109 m=(1)
mp51 (\8\:n30 \2\:CKbb n36 VDD) g45p1hvt w=(2.15e-07) l=4.5e-08 nf=1 \
        as=1.827e-14 ad=4.515e-14 ps=6e-07 pd=8.5e-07 nrd=1.16667 \
        nrs=1.16667 sa=5.35e-07 sb=1.935e-06 sd=160n sca=12.1244 \
        scb=0.0107968 scc=0.000332109 m=(1)
mp40 (\8\:n30 CKb \9\:mout VDD) g45p1hvt w=(2.15e-07) l=4.5e-08 nf=1 \
        as=6.127e-14 ad=4.515e-14 ps=1e-06 pd=8.5e-07 nrd=1.16667 \
        nrs=1.16667 sa=7.9e-07 sb=1.68e-06 sd=160n sca=12.1244 \
        scb=0.0107968 scc=0.000332109 m=(1)
mp30 (\9\:mout \4\:n20 \8\:VDD VDD) g45p1hvt w=(2.15e-07) l=4.5e-08 nf=1 \
        as=8.63e-14 ad=6.127e-14 ps=1.52e-06 pd=1e-06 nrd=1.16667 \
        nrs=1.16667 sa=1.12e-06 sb=1.35e-06 sd=160n sca=12.1244 \
        scb=0.0107968 scc=0.000332109 m=(1)
mp35 (n26 \4\:mout \8\:VDD VDD) g45p1hvt w=(2.15e-07) l=4.5e-08 nf=1 \
        as=8.63e-14 ad=1.397e-14 ps=1.52e-06 pd=5.6e-07 nrd=1.16667 \
        nrs=1.16667 sa=1.385e-06 sb=1.085e-06 sd=160n sca=12.1244 \
        scb=0.0107968 scc=0.000332109 m=(1)
mp36 (\9\:n20 \5\:CKb n26 VDD) g45p1hvt w=(2.15e-07) l=4.5e-08 nf=1 \
        as=1.397e-14 ad=4.622e-14 ps=5.6e-07 pd=8.6e-07 nrd=1.16667 \
        nrs=1.16667 sa=1.495e-06 sb=9.75e-07 sd=160n sca=12.1244 \
        scb=0.0107968 scc=0.000332109 m=(1)
mp26 (\9\:n20 \5\:CKbb n22 VDD) g45p1hvt w=(2.15e-07) l=4.5e-08 nf=1 \
        as=4.622e-14 ad=4.622e-14 ps=8.6e-07 pd=8.6e-07 nrd=1.16667 \
        nrs=1.16667 sa=1.755e-06 sb=7.15e-07 sd=160n sca=12.3306 \
        scb=0.010847 scc=0.000332116 m=(1)
mp25 (n22 \1\:D \1\:VDD VDD) g45p1hvt w=(2.15e-07) l=4.5e-08 nf=1 \
        as=3.44e-14 ad=4.622e-14 ps=7.5e-07 pd=8.6e-07 nrd=1.16667 \
        nrs=1.16667 sa=2e-06 sb=4.55e-07 sd=160n sca=13.4144 scb=0.0116069 \
        scc=0.000333202 m=(1)
mp21 (\13\:CKbb \10\:CKb \1\:VDD VDD) g45p1hvt w=(2.15e-07) l=4.5e-08 \
        nf=1 as=3.44e-14 ad=5.375e-14 ps=7.5e-07 pd=9.3e-07 nrd=1.16667 \
        nrs=1.16667 sa=2e-06 sb=2.5e-07 sd=160n sca=15.8535 scb=0.0153154 \
        scc=0.000377744 m=(1)
ends DFFX1
// End of subcircuit definition.
