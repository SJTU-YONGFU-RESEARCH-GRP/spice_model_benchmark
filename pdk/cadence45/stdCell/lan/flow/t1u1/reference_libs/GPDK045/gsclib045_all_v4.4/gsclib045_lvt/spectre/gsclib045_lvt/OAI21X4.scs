// gsclib045_lvt/OAI21X4/schematic

simulator lang=spectre

subckt OAI21X4 A0 A1 B0 Y VDD VSS
mp0 (n1 A0 VDD VDD) g45p1lvt w=(1.56u) l=45n nf=1 m=(1)
mp2 (Y B0 VDD VDD) g45p1lvt w=(1.56u) l=45n nf=1 m=(1)
mp1 (Y A1 n1 VDD) g45p1lvt w=(1.56u) l=45n nf=1 m=(1)
mn2 (Y B0 n0 VSS) g45n1lvt w=(1.04u) l=45n nf=1 m=(1)
mn1 (n0 A1 VSS VSS) g45n1lvt w=(1.04u) l=45n nf=1 m=(1)
mn0 (n0 A0 VSS VSS) g45n1lvt w=(1.04u) l=45n nf=1 m=(1)
ends OAI21X4
