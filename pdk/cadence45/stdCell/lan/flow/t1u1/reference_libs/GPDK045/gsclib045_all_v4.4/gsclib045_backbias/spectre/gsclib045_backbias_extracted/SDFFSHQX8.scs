// Generated for: spectre (May  1 11:32:28 2013 )
// Library name: gsclib045_backbias
// Cell name: SDFFSHQX8
// View name: extracted

simulator lang=spectre

subckt SDFFSHQX8 CK D NW Q SE SI SN VDD VSS
mp55_1__rcx (Q qbint VDD NW) g45p1svt w=(4.45e-07) l=4.5e-08 nf=1 \
        as=6.993e-14 ad=6.824e-14 ps=1.20429e-06 pd=1.20429e-06 \
        nrd=1.16667 nrs=1.16667 sa=1.4e-07 sb=1.34348e-06 sd=160n \
        sca=41.6034 scb=0.0375368 scc=0.00435732 m=(7)
C1 (NW VSS) capacitor c=1.00272e-15
C2 (D VSS) capacitor c=6.35623e-17
C3 (VDD VSS) capacitor c=4.81175e-16
C4 (CK VSS) capacitor c=5.71324e-17
C5 (SN VSS) capacitor c=2.14185e-17
C6 (Q VSS) capacitor c=5.55829e-16
C7 (SI VSS) capacitor c=7.63414e-17
C8 (qbint VSS) capacitor c=3.31671e-16
C9 (n30 VSS) capacitor c=1.9978e-16
C10 (net459 VSS) capacitor c=3.48373e-18
C11 (net467 VSS) capacitor c=1.98903e-18
C12 (CKb VSS) capacitor c=4.13913e-17
C13 (mout VSS) capacitor c=3.88092e-17
C14 (CKbb VSS) capacitor c=4.96061e-17
C15 (net435 VSS) capacitor c=3.71162e-19
C16 (n20 VSS) capacitor c=4.70181e-17
C17 (net427 VSS) capacitor c=1.83791e-18
C18 (Db VSS) capacitor c=5.05057e-17
C19 (net443 VSS) capacitor c=9.05262e-18
C20 (SEb VSS) capacitor c=4.06983e-17
C21 (net455 VSS) capacitor c=1.40273e-18
C22 (net355 VSS) capacitor c=9.4347e-17
C23 (net378 VSS) capacitor c=5.94322e-18
C24 (net390 VSS) capacitor c=9.80049e-18
C25 (net398 VSS) capacitor c=1.63377e-18
C26 (\7\:SE VSS) capacitor c=3.54477e-17
C27 (\1\:SI VSS) capacitor c=7.56977e-17
C28 (\3\:SEb VSS) capacitor c=7.2098e-17
C29 (\3\:SE VSS) capacitor c=5.80891e-17
C30 (\1\:D VSS) capacitor c=4.09371e-17
C31 (\1\:CK VSS) capacitor c=2.58688e-17
C32 (\7\:CKb VSS) capacitor c=2.60056e-17
C33 (\4\:CKbb VSS) capacitor c=3.18187e-17
C34 (\5\:CKb VSS) capacitor c=4.79038e-17
C35 (\4\:mout VSS) capacitor c=6.64914e-17
C36 (\4\:SN VSS) capacitor c=5.26958e-17
C37 (\3\:CKb VSS) capacitor c=5.5355e-17
C38 (\2\:CKbb VSS) capacitor c=4.69167e-17
C39 (\23\:qbint VSS) capacitor c=5.41907e-17
C40 (\3\:SN VSS) capacitor c=3.75954e-17
C41 (\6\:SE VSS) capacitor c=2.30831e-17
C42 (\3\:SI VSS) capacitor c=8.02899e-17
C43 (\1\:SE VSS) capacitor c=6.48037e-17
C44 (\4\:D VSS) capacitor c=3.71515e-17
C45 (\4\:CK VSS) capacitor c=2.36134e-17
C46 (\12\:CKb VSS) capacitor c=2.31665e-17
C47 (\10\:CKb VSS) capacitor c=2.14769e-17
C48 (\6\:CKbb VSS) capacitor c=7.17127e-17
C49 (\3\:n20 VSS) capacitor c=9.44449e-17
C50 (\6\:SN VSS) capacitor c=6.88904e-17
C51 (\25\:qbint VSS) capacitor c=3.85372e-17
C52 (\1\:SN VSS) capacitor c=5.93024e-17
C53 (\4\:SE VSS) capacitor c=1.42752e-17
C54 (\2\:SI VSS) capacitor c=6.23989e-17
C55 (\4\:SEb VSS) capacitor c=5.06315e-17
C56 (\2\:SE VSS) capacitor c=7.30555e-17
C57 (\2\:SEb VSS) capacitor c=5.09358e-17
C58 (\3\:D VSS) capacitor c=1.18832e-17
C59 (\3\:CK VSS) capacitor c=1.56651e-17
C60 (\11\:CKb VSS) capacitor c=2.5342e-17
C61 (\5\:CKbb VSS) capacitor c=5.28806e-17
C62 (\9\:CKb VSS) capacitor c=3.26343e-17
C63 (\6\:CKb VSS) capacitor c=4.68092e-17
C64 (\3\:mout VSS) capacitor c=5.42523e-17
C65 (\2\:n20 VSS) capacitor c=5.86116e-17
C66 (\5\:SN VSS) capacitor c=4.94778e-17
C67 (\4\:CKb VSS) capacitor c=3.50837e-17
C68 (\3\:CKbb VSS) capacitor c=2.74656e-17
C69 (\2\:CKb VSS) capacitor c=4.42949e-17
C70 (\24\:qbint VSS) capacitor c=5.16477e-17
C71 (\2\:SN VSS) capacitor c=4.48147e-17
C72 (\1\:VDD VSS) capacitor c=4.56325e-17
C73 (\5\:SEb VSS) capacitor c=7.76266e-17
C74 (\16\:VDD VSS) capacitor c=2.98063e-17
C75 (\6\:Db VSS) capacitor c=1.18474e-16
C76 (\18\:VDD VSS) capacitor c=4.64903e-17
C77 (\22\:CKb VSS) capacitor c=7.07519e-17
C78 (\20\:VDD VSS) capacitor c=6.52822e-17
C79 (\9\:CKbb VSS) capacitor c=1.08698e-16
C80 (\8\:Db VSS) capacitor c=1.05691e-16
C81 (\6\:n20 VSS) capacitor c=1.17393e-16
C82 (\22\:VDD VSS) capacitor c=2.0838e-17
C83 (\12\:mout VSS) capacitor c=5.63276e-17
C84 (\24\:VDD VSS) capacitor c=2.48758e-17
C85 (\14\:mout VSS) capacitor c=2.61445e-17
C86 (\15\:n30 VSS) capacitor c=4.22565e-17
C87 (\26\:VDD VSS) capacitor c=3.29752e-17
C88 (\3\:net355 VSS) capacitor c=9.95318e-17
C89 (\9\:SEb VSS) capacitor c=1.00052e-16
C90 (\18\:CKb VSS) capacitor c=5.26915e-17
C91 (\12\:CKbb VSS) capacitor c=7.98463e-17
C92 (\4\:Db VSS) capacitor c=2.89127e-16
C93 (\4\:n20 VSS) capacitor c=1.00254e-16
C94 (\10\:mout VSS) capacitor c=5.54414e-17
C95 (\8\:mout VSS) capacitor c=6.73586e-17
C96 (\13\:n30 VSS) capacitor c=7.43521e-17
C97 (\27\:qbint VSS) capacitor c=3.7657e-16
C98 (\2\:CK VSS) capacitor c=1.70737e-17
C99 (\2\:D VSS) capacitor c=2.4594e-17
C100 (\26\:qbint VSS) capacitor c=7.60937e-17
C101 (\33\:qbint VSS) capacitor c=6.84945e-17
C102 (\5\:SE VSS) capacitor c=1.60122e-17
C103 (\11\:n30 VSS) capacitor c=1.27991e-16
C104 (\12\:n30 VSS) capacitor c=1.26841e-16
C105 (\7\:SN VSS) capacitor c=2.09935e-16
C106 (\8\:SN VSS) capacitor c=1.7936e-16
C107 (\5\:mout VSS) capacitor c=5.479e-17
C108 (\6\:mout VSS) capacitor c=6.79847e-17
C109 (\7\:mout VSS) capacitor c=5.8701e-17
C110 (\8\:n20 VSS) capacitor c=8.01737e-17
C111 (\13\:CKb VSS) capacitor c=1.22949e-16
C112 (\14\:CKb VSS) capacitor c=2.2544e-16
C113 (\15\:CKb VSS) capacitor c=2.23044e-16
C114 (\16\:CKb VSS) capacitor c=1.2445e-16
C115 (\17\:CKb VSS) capacitor c=4.43457e-17
C116 (\7\:CKbb VSS) capacitor c=6.4839e-17
C117 (\8\:CKbb VSS) capacitor c=1.52287e-16
C118 (\11\:CKbb VSS) capacitor c=2.0474e-16
C119 (\20\:CKb VSS) capacitor c=8.29846e-17
C120 (\21\:CKb VSS) capacitor c=5.38537e-17
C121 (\5\:CK VSS) capacitor c=5.63638e-17
C122 (\5\:D VSS) capacitor c=2.81155e-17
C123 (\3\:Db VSS) capacitor c=2.54579e-16
C124 (\7\:SEb VSS) capacitor c=1.01336e-16
C125 (\8\:SEb VSS) capacitor c=1.45979e-16
C126 (\5\:SI VSS) capacitor c=4.1217e-17
C127 (\8\:SE VSS) capacitor c=1.1082e-16
C128 (\9\:SE VSS) capacitor c=7.95483e-17
C129 (\3\:VDD VSS) capacitor c=8.56065e-17
C130 (\4\:VDD VSS) capacitor c=9.23518e-17
C131 (\5\:VDD VSS) capacitor c=1.19485e-16
C132 (\6\:VDD VSS) capacitor c=8.45051e-17
C133 (\7\:VDD VSS) capacitor c=8.38251e-17
C134 (\8\:VDD VSS) capacitor c=7.92889e-17
C135 (\9\:VDD VSS) capacitor c=2.05767e-16
Rk43 (\5\:D D) resistor r=0.1389 c=0
Rk80 (\2\:VSS \4\:VSS) resistor r=0.1897 c=0
Rk81 (\4\:VSS \5\:VSS) resistor r=0.1252 c=0
Rk82 (\5\:VSS \6\:VSS) resistor r=0.3784 c=0
Rk83 (\6\:VSS \7\:VSS) resistor r=0.2983 c=0
Rk84 (\7\:VSS \8\:VSS) resistor r=0.1403 c=0
Rk85 (\8\:VSS \9\:VSS) resistor r=0.6569 c=0
Rk86 (\9\:VSS \10\:VSS) resistor r=0.3508 c=0
Rk87 (\10\:VSS \11\:VSS) resistor r=0.05499 c=0
Rk90 (\12\:VSS VSS) resistor r=0.3784 c=0
Rk88 (\11\:VSS \12\:VSS) resistor r=0.5592 c=0
Rk96 (\5\:VSS \21\:VSS) resistor r=0.2551 c=0
Rk97 (\6\:VSS \23\:VSS) resistor r=0.2519 c=0
Rk98 (\8\:VSS \25\:VSS) resistor r=0.18 c=0
Rk99 (\9\:VSS \27\:VSS) resistor r=0.3145 c=0
Rk100 (\10\:VSS \29\:VSS) resistor r=0.2723 c=0
Rk56 (\2\:VDD \3\:VDD) resistor r=0.4077 c=0
Rk57 (\3\:VDD \4\:VDD) resistor r=0.4462 c=0
Rk58 (\4\:VDD \5\:VDD) resistor r=0.5214 c=0
Rk59 (\5\:VDD \6\:VDD) resistor r=0.5807 c=0
Rk60 (\6\:VDD \7\:VDD) resistor r=0.2335 c=0
Rk61 (\7\:VDD \8\:VDD) resistor r=0.4828 c=0
Rk64 (\9\:VDD VDD) resistor r=0.3257 c=0
Rk62 (\8\:VDD \9\:VDD) resistor r=0.2705 c=0
Rk69 (\3\:VDD \17\:VDD) resistor r=0.178 c=0
Rk70 (\4\:VDD \19\:VDD) resistor r=0.2685 c=0
Rk71 (\5\:VDD \21\:VDD) resistor r=0.442 c=0
Rk72 (\6\:VDD \23\:VDD) resistor r=0.04333 c=0
Rk73 (\7\:VDD \25\:VDD) resistor r=0.04333 c=0
Rk74 (\8\:VDD \27\:VDD) resistor r=0.1297 c=0
Rk42 (CK \5\:CK) resistor r=0.1283 c=0
Rk55 (\9\:SE SE) resistor r=0.003494 c=0
Rk54 (\8\:SE \9\:SE) resistor r=0.6233 c=0
Rk22 (\8\:SN SN) resistor r=0.01161 c=0
Rk21 (\7\:SN \8\:SN) resistor r=1.4486 c=0
Rk51 (\4\:SI \5\:SI) resistor r=0.00514 c=0
Rk52 (\6\:SI SI) resistor r=0.00514 c=0
Rk53 (\5\:SI \6\:SI) resistor r=0.05165 c=0
Rk10 (\26\:qbint \27\:qbint) resistor r=0.5082 c=0
Rk14 (\27\:qbint \33\:qbint) resistor r=0.5317 c=0
Rk18 (\11\:n30 \12\:n30) resistor r=0.755 c=0
Rk19 (\12\:n30 \14\:n30) resistor r=0.3055 c=0
Rk20 (\12\:n30 \16\:n30) resistor r=0.1792 c=0
Rk31 (\13\:CKb \14\:CKb) resistor r=0.7837 c=0
Rk32 (\14\:CKb \15\:CKb) resistor r=1.1282 c=0
Rk33 (\15\:CKb \16\:CKb) resistor r=0.8407 c=0
Rk34 (\14\:CKb \17\:CKb) resistor r=0.2527 c=0
Rk39 (\19\:CKb \20\:CKb) resistor r=0.1609 c=0
Rk40 (\20\:CKb \21\:CKb) resistor r=0.3243 c=0
Rk41 (\20\:CKb \23\:CKb) resistor r=0.5233 c=0
Rk23 (\5\:mout \6\:mout) resistor r=0.3103 c=0
Rk24 (\6\:mout \7\:mout) resistor r=0.3325 c=0
Rk25 (\7\:mout \9\:mout) resistor r=0.3617 c=0
Rk26 (\6\:mout \11\:mout) resistor r=0.2149 c=0
Rk27 (\6\:mout \13\:mout) resistor r=0.2613 c=0
Rk28 (\7\:mout \15\:mout) resistor r=0.07997 c=0
Rk35 (\7\:CKbb \8\:CKbb) resistor r=0.2559 c=0
Rk36 (\8\:CKbb \10\:CKbb) resistor r=0.5548 c=0
Rk37 (\8\:CKbb \11\:CKbb) resistor r=1.2865 c=0
Rk38 (\10\:CKbb \13\:CKbb) resistor r=0.3613 c=0
Rk29 (\5\:n20 \7\:n20) resistor r=0.501 c=0
Rk30 (\7\:n20 \8\:n20) resistor r=0.4791 c=0
Rk44 (\2\:Db \3\:Db) resistor r=0.3024 c=0
Rk45 (\3\:Db \5\:Db) resistor r=1.5361 c=0
Rk46 (\3\:Db \7\:Db) resistor r=0.8675 c=0
Rk47 (\5\:Db \9\:Db) resistor r=0.5347 c=0
Rk48 (\6\:SEb \7\:SEb) resistor r=0.5201 c=0
Rk49 (\7\:SEb \8\:SEb) resistor r=0.2961 c=0
Rk50 (\8\:SEb \10\:SEb) resistor r=0.7424 c=0
Rk17 (\2\:net355 \4\:net355) resistor r=0.3066 c=0
Rl57 (\1\:D \2\:D) resistor r=90.0987 c=0
Rl59 (\2\:D \4\:D) resistor r=84.3295 c=0
Rl58 (\2\:D \3\:D) resistor r=10.6974 c=0
Rl54 (\1\:CK \2\:CK) resistor r=113.176 c=0
Rl56 (\2\:CK \4\:CK) resistor r=63.1757 c=0
Rl55 (\2\:CK \3\:CK) resistor r=7.5059 c=0
Rl62 (\2\:SE \3\:SE) resistor r=135.031 c=0
Rl61 (\1\:SE \2\:SE) resistor r=43.4636 c=0
Rl68 (\5\:SE \7\:SE) resistor r=99.7141 c=0
Rl67 (\5\:SE \6\:SE) resistor r=45.868 c=0
Rl66 (\4\:SE \5\:SE) resistor r=11.5001 c=0
Rl39 (\4\:SN \5\:SN) resistor r=48.3726 c=0
Rl40 (\5\:SN \6\:SN) resistor r=147.31 c=0
Rl32 (\2\:SN \3\:SN) resistor r=24.7951 c=0
Rl31 (\1\:SN \2\:SN) resistor r=128.823 c=0
Rl64 (\1\:SI \2\:SI) resistor r=29.5379 c=0
Rl65 (\2\:SI \3\:SI) resistor r=150.257 c=0
Rl33 (\24\:qbint \23\:qbint) resistor r=116.54 c=0
Rl34 (\24\:qbint \25\:qbint) resistor r=24.2328 c=0
Rl53 (\11\:CKb \12\:CKb) resistor r=24.848 c=0
Rl51 (\9\:CKb \10\:CKb) resistor r=24.2328 c=0
Rl46 (\5\:CKb \6\:CKb) resistor r=48.7687 c=0
Rl38 (\3\:CKb \4\:CKb) resistor r=78.079 c=0
Rl35 (CKb \2\:CKb) resistor r=37.2302 c=0
Rl49 (\7\:CKb \8\:CKb) resistor r=80.8559 c=0
Rl52 (\8\:CKb \11\:CKb) resistor r=14.0381 c=0
Rl50 (\8\:CKb \9\:CKb) resistor r=162.618 c=0
Rl45 (\2\:mout \4\:mout) resistor r=102.375 c=0
Rl43 (mout \2\:mout) resistor r=77.3751 c=0
Rl44 (\2\:mout \3\:mout) resistor r=5.376 c=0
Rl36 (CKbb \2\:CKbb) resistor r=93.7964 c=0
Rl47 (\4\:CKbb \5\:CKbb) resistor r=24.2328 c=0
Rl48 (\5\:CKbb \6\:CKbb) resistor r=202.966 c=0
Rl37 (\2\:CKbb \3\:CKbb) resistor r=91.0764 c=0
Rl41 (n20 \2\:n20) resistor r=29.5379 c=0
Rl42 (\2\:n20 \3\:n20) resistor r=232.95 c=0
Rl63 (\3\:SEb \4\:SEb) resistor r=30.2349 c=0
Rl60 (SEb \2\:SEb) resistor r=74.2328 c=0
Rz16 (\2\:VSS \1\:VSS) resistor r=75 c=0
Rz18 (\21\:VSS \20\:VSS) resistor r=75 c=0
Rz19 (\23\:VSS \22\:VSS) resistor r=75 c=0
Rz20 (\25\:VSS \24\:VSS) resistor r=75 c=0
Rz21 (\27\:VSS \26\:VSS) resistor r=75 c=0
Rz22 (\29\:VSS \28\:VSS) resistor r=75 c=0
Rz7 (\14\:n30 \13\:n30) resistor r=75 c=0
Rz12 (\18\:CKb \19\:CKb) resistor r=75 c=0
Rz8 (\8\:mout \9\:mout) resistor r=75 c=0
Rz9 (\10\:mout \11\:mout) resistor r=75 c=0
Rz11 (\12\:CKbb \13\:CKbb) resistor r=75 c=0
Rz10 (\4\:n20 \5\:n20) resistor r=75 c=0
Rz13 (Db \2\:Db) resistor r=75 c=0
Rz14 (\4\:Db \5\:Db) resistor r=75 c=0
Rz15 (\9\:SEb \10\:SEb) resistor r=75 c=0
Ry34 (VSS \3\:VSS) resistor r=5.1667 c=0
Ry31 (\4\:VSS \3\:VSS) resistor r=15.5 c=0
Ry32 (\7\:VSS \3\:VSS) resistor r=5.1667 c=0
Ry33 (\11\:VSS \3\:VSS) resistor r=5.1667 c=0
Ry18 (\2\:VDD \1\:VDD) resistor r=62 c=0
Ry20 (\17\:VDD \16\:VDD) resistor r=62 c=0
Ry21 (\19\:VDD \18\:VDD) resistor r=20.6667 c=0
Ry22 (\21\:VDD \20\:VDD) resistor r=62 c=0
Ry23 (\23\:VDD \22\:VDD) resistor r=62 c=0
Ry24 (\25\:VDD \24\:VDD) resistor r=62 c=0
Ry25 (\27\:VDD \26\:VDD) resistor r=62 c=0
Ry9 (\16\:n30 \15\:n30) resistor r=62 c=0
Ry14 (\22\:CKb \23\:CKb) resistor r=62 c=0
Ry10 (\12\:mout \13\:mout) resistor r=62 c=0
Ry11 (\14\:mout \15\:mout) resistor r=62 c=0
Ry13 (\9\:CKbb \10\:CKbb) resistor r=62 c=0
Ry12 (\6\:n20 \7\:n20) resistor r=62 c=0
Ry15 (\6\:Db \7\:Db) resistor r=62 c=0
Ry16 (\8\:Db \9\:Db) resistor r=62 c=0
Ry17 (\5\:SEb \6\:SEb) resistor r=62 c=0
Ry7 (net355 \2\:net355) resistor r=62 c=0
Ry8 (\3\:net355 \4\:net355) resistor r=62 c=0
Rx16 (\3\:D \5\:D) resistor r=45 c=0
Rx15 (\3\:CK \5\:CK) resistor r=45 c=0
Rx20 (\2\:SE \8\:SE) resistor r=45 c=0
Rx21 (\4\:SE \9\:SE) resistor r=45 c=0
Rx4 (\5\:SN \7\:SN) resistor r=45 c=0
Rx5 (\2\:SN \8\:SN) resistor r=45 c=0
Rx19 (\2\:SI \4\:SI) resistor r=45 c=0
Rx1 (\26\:qbint \24\:qbint) resistor r=45 c=0
Rx2 (\33\:qbint qbint) resistor r=45 c=0
Rx3 (\11\:n30 n30) resistor r=45 c=0
Rx8 (\9\:CKb \13\:CKb) resistor r=45 c=0
Rx9 (\4\:CKb \15\:CKb) resistor r=45 c=0
Rx10 (\2\:CKb \16\:CKb) resistor r=45 c=0
Rx11 (\6\:CKb \17\:CKb) resistor r=45 c=0
Rx14 (\11\:CKb \21\:CKb) resistor r=45 c=0
Rx6 (\3\:mout \5\:mout) resistor r=45 c=0
Rx12 (\5\:CKbb \7\:CKbb) resistor r=45 c=0
Rx13 (\3\:CKbb \11\:CKbb) resistor r=45 c=0
Rx7 (\2\:n20 \8\:n20) resistor r=45 c=0
Rx17 (\4\:SEb \7\:SEb) resistor r=45 c=0
Rx18 (\2\:SEb \8\:SEb) resistor r=45 c=0
mn55_1__rcx (Q qbint VSS VSS) g45n1svt w=(2.95e-07) l=4.5e-08 nf=1 \
        as=4.889e-14 ad=4.994e-14 ps=9.2143e-07 pd=9.2857e-07 nrd=1.16667 \
        nrs=1.16667 sa=1.4e-07 sb=1.485e-06 sd=160n sca=16.4223 \
        scb=0.0158966 scc=0.0014413 m=(7)
mn11 (net443 \4\:D \22\:VSS VSS) g45n1svt w=(2.6e-07) l=4.5e-08 nf=1 \
        as=8.135e-14 ad=5.85e-14 ps=1.42e-06 pd=9.7e-07 nrd=1.16667 \
        nrs=1.16667 sa=4.16058e-07 sb=7.2e-07 sd=160n sca=12.8392 \
        scb=0.0126987 scc=0.00074151 m=(1)
mn12 (Db SEb net443 VSS) g45n1svt w=(2.6e-07) l=4.5e-08 nf=1 as=5.85e-14 \
        ad=4.16e-14 ps=9.7e-07 pd=8.4e-07 nrd=1.16667 nrs=1.16667 \
        sa=6.86058e-07 sb=4.5e-07 sd=160n sca=12.8392 scb=0.0126987 \
        scc=0.00074151 m=(1)
mn14 (Db \1\:SE net455 VSS) g45n1svt w=(2.6e-07) l=4.5e-08 nf=1 \
        as=1.56e-14 ad=4.16e-14 ps=6.4e-07 pd=8.4e-07 nrd=1.16667 \
        nrs=1.16667 sa=8.91058e-07 sb=2.45e-07 sd=160n sca=12.8392 \
        scb=0.0126987 scc=0.00074151 m=(1)
mn13 (net455 \3\:SI \20\:VSS VSS) g45n1svt w=(2.6e-07) l=4.5e-08 nf=1 \
        as=3.64e-14 ad=1.56e-14 ps=8e-07 pd=6.4e-07 nrd=1.16667 \
        nrs=1.16667 sa=9.96058e-07 sb=1.4e-07 sd=160n sca=12.8392 \
        scb=0.0126987 scc=0.00074151 m=(1)
mn45_1__rcx (\27\:qbint n30 \12\:VSS VSS) g45n1svt w=(2.6e-07) l=4.5e-08 \
        nf=1 as=4.328e-14 ad=4.333e-14 ps=8.6e-07 pd=8.5333e-07 \
        nrd=1.16667 nrs=1.16667 sa=1.4e-07 sb=1.2599e-06 sd=160n \
        sca=17.5885 scb=0.0172826 scc=0.00162584 m=(3)
mn50 (net459 \1\:SN \12\:VSS VSS) g45n1svt w=(2.05e-07) l=4.5e-08 nf=1 \
        as=4.665e-14 ad=2.768e-14 ps=9e-07 pd=6.8e-07 nrd=1.16667 \
        nrs=1.16667 sa=8.05e-07 sb=7.8e-07 sd=160n sca=19.867 \
        scb=0.0198061 scc=0.00201945 m=(1)
mn51 (net467 \25\:qbint net459 VSS) g45n1svt w=(2.05e-07) l=4.5e-08 nf=1 \
        as=2.768e-14 ad=2.768e-14 ps=6.8e-07 pd=6.8e-07 nrd=1.16667 \
        nrs=1.16667 sa=9.85e-07 sb=6e-07 sd=160n sca=19.867 scb=0.0198061 \
        scc=0.00201945 m=(1)
mn52 (\13\:n30 CKb net467 VSS) g45n1svt w=(2.05e-07) l=4.5e-08 nf=1 \
        as=2.768e-14 ad=4.818e-14 ps=6.8e-07 pd=8.8e-07 nrd=1.16667 \
        nrs=1.16667 sa=1.165e-06 sb=4.2e-07 sd=160n sca=19.867 \
        scb=0.0198061 scc=0.00201945 m=(1)
mn40 (\13\:n30 CKbb \8\:mout VSS) g45n1svt w=(2.05e-07) l=4.5e-08 nf=1 \
        as=2.87e-14 ad=4.818e-14 ps=6.9e-07 pd=8.8e-07 nrd=1.16667 \
        nrs=1.16667 sa=1.445e-06 sb=1.4e-07 sd=160n sca=19.867 \
        scb=0.0198061 scc=0.00201945 m=(1)
mn30 (net435 \6\:SN \28\:VSS VSS) g45n1svt w=(2.05e-07) l=4.5e-08 nf=1 \
        as=3.485e-14 ad=1.435e-14 ps=7.5e-07 pd=5.5e-07 nrd=1.16667 \
        nrs=1.16667 sa=1.7e-07 sb=2.55e-07 sd=160n sca=11.015 \
        scb=0.0105032 scc=0.000405626 m=(1)
mn31 (\10\:mout \3\:n20 net435 VSS) g45n1svt w=(2.05e-07) l=4.5e-08 nf=1 \
        as=1.435e-14 ad=2.87e-14 ps=5.5e-07 pd=6.9e-07 nrd=1.16667 \
        nrs=1.16667 sa=2.85e-07 sb=1.4e-07 sd=160n sca=11.015 \
        scb=0.0105032 scc=0.000405626 m=(1)
mn35 (net427 mout \26\:VSS VSS) g45n1svt w=(2.05e-07) l=4.5e-08 nf=1 \
        as=2.87e-14 ad=2.05e-14 ps=6.9e-07 pd=6.1e-07 nrd=1.16667 \
        nrs=1.16667 sa=1.4e-07 sb=6.35e-07 sd=160n sca=13.8179 \
        scb=0.0141903 scc=0.000851218 m=(1)
mn36 (\4\:n20 \6\:CKbb net427 VSS) g45n1svt w=(2.05e-07) l=4.5e-08 nf=1 \
        as=2.05e-14 ad=4.305e-14 ps=6.1e-07 pd=8.3e-07 nrd=1.16667 \
        nrs=1.16667 sa=2.85e-07 sb=4.9e-07 sd=160n sca=13.8179 \
        scb=0.0141903 scc=0.000851218 m=(1)
mn25 (\4\:n20 \10\:CKb \4\:Db VSS) g45n1svt w=(2.05e-07) l=4.5e-08 nf=1 \
        as=4.818e-14 ad=4.305e-14 ps=8.8e-07 pd=8.3e-07 nrd=1.16667 \
        nrs=1.16667 sa=5.4e-07 sb=2.35e-07 sd=160n sca=13.8179 \
        scb=0.0141903 scc=0.000851218 m=(1)
mn21 (\12\:CKbb \12\:CKb \24\:VSS VSS) g45n1svt w=(1.45e-07) l=4.5e-08 \
        nf=1 as=6.043e-14 ad=2.175e-14 ps=1.17e-06 pd=5.9e-07 nrd=1.16667 \
        nrs=1.16667 sa=1.5e-07 sb=3.05e-07 sd=160n sca=10.4914 \
        scb=0.00978575 scc=0.000300434 m=(1)
mn20 (\18\:CKb \4\:CK \22\:VSS VSS) g45n1svt w=(1.45e-07) l=4.5e-08 nf=1 \
        as=8.135e-14 ad=2.03e-14 ps=1.42e-06 pd=5.7e-07 nrd=1.16667 \
        nrs=1.16667 sa=1.4e-07 sb=1.215e-06 sd=160n sca=16.2011 \
        scb=0.0172667 scc=0.0012292 m=(1)
mn10 (\9\:SEb \6\:SE \1\:VSS VSS) g45n1svt w=(1.45e-07) l=4.5e-08 nf=1 \
        as=4.465e-14 ad=2.03e-14 ps=1.5e-06 pd=5.7e-07 nrd=1.16667 \
        nrs=1.16667 sa=1.4e-07 sb=1e-07 sd=160n sca=23.279 scb=0.0230742 \
        scc=0.00267719 m=(1)
mp11 (net390 \1\:D \18\:VDD NW) g45p1svt w=(3.9e-07) l=4.5e-08 nf=1 \
        as=1.2125e-13 ad=1.287e-13 ps=1.68e-06 pd=1.44e-06 nrd=1.16667 \
        nrs=1.16667 sa=4.12885e-07 sb=7.97308e-07 sd=160n sca=11.4561 \
        scb=0.00963524 scc=0.000244209 m=(1)
mp12 (\6\:Db \3\:SE net390 NW) g45p1svt w=(3.9e-07) l=4.5e-08 nf=1 \
        as=1.287e-13 ad=6.24e-14 ps=1.44e-06 pd=1.1e-06 nrd=1.16667 \
        nrs=1.16667 sa=7.87885e-07 sb=4.22308e-07 sd=160n sca=11.4656 \
        scb=0.00963696 scc=0.000244209 m=(1)
mp14 (\6\:Db \3\:SEb net398 NW) g45p1svt w=(3.9e-07) l=4.5e-08 nf=1 \
        as=2.34e-14 ad=6.24e-14 ps=9e-07 pd=1.1e-06 nrd=1.16667 \
        nrs=1.16667 sa=9.92885e-07 sb=2.17308e-07 sd=160n sca=12.0152 \
        scb=0.00983999 scc=0.000244281 m=(1)
mp13 (net398 \1\:SI \16\:VDD NW) g45p1svt w=(3.9e-07) l=4.5e-08 nf=1 \
        as=4.38e-14 ad=2.34e-14 ps=1.06e-06 pd=9e-07 nrd=1.16667 \
        nrs=1.16667 sa=1.09788e-06 sb=1.12308e-07 sd=160n sca=12.499 \
        scb=0.0102001 scc=0.000244729 m=(1)
mp45_1__rcx (\27\:qbint n30 \9\:VDD NW) g45p1svt w=(3.9e-07) l=4.5e-08 \
        nf=1 as=7.627e-14 ad=5.747e-14 ps=1.32e-06 pd=1.08667e-06 \
        nrd=1.16667 nrs=1.16667 sa=1.22051e-07 sb=7.73077e-07 sd=160n \
        sca=30.5009 scb=0.0202006 scc=0.00336097 m=(3)
mp50 (\3\:net355 \3\:SN \9\:VDD NW) g45p1svt w=(3.1e-07) l=4.5e-08 nf=1 \
        as=1.04e-13 ad=6.51e-14 ps=1.76e-06 pd=1.04e-06 nrd=1.16667 \
        nrs=1.16667 sa=5.85323e-07 sb=3.55e-07 sd=160n sca=11.2287 \
        scb=0.00925355 scc=0.000213039 m=(1)
mp51 (\3\:net355 \23\:qbint \26\:VDD NW) g45p1svt w=(3.1e-07) l=4.5e-08 \
        nf=1 as=4.59e-14 ad=6.51e-14 ps=1.22e-06 pd=1.04e-06 nrd=1.16667 \
        nrs=1.16667 sa=8.40323e-07 sb=1e-07 sd=160n sca=11.2287 \
        scb=0.00925355 scc=0.000213039 m=(1)
mp52 (\15\:n30 \2\:CKbb net355 NW) g45p1svt w=(3.1e-07) l=4.5e-08 nf=1 \
        as=4.3e-14 ad=4.96e-14 ps=9e-07 pd=9.4e-07 nrd=1.16667 nrs=1.16667 \
        sa=1.3871e-07 sb=3.20484e-07 sd=160n sca=35.6995 scb=0.0234062 \
        scc=0.00420468 m=(1)
mp40 (\15\:n30 \3\:CKb \14\:mout NW) g45p1svt w=(3.1e-07) l=4.5e-08 nf=1 \
        as=3.58e-14 ad=4.96e-14 ps=9e-07 pd=9.4e-07 nrd=1.16667 \
        nrs=1.16667 sa=3.4371e-07 sb=1.15484e-07 sd=160n sca=35.6995 \
        scb=0.0234062 scc=0.00420468 m=(1)
mp30 (\12\:mout \4\:SN \24\:VDD NW) g45p1svt w=(3.1e-07) l=4.5e-08 nf=1 \
        as=5.14e-14 ad=4.96e-14 ps=1.44e-06 pd=9.4e-07 nrd=1.16667 \
        nrs=1.16667 sa=1e-07 sb=1.12e-06 sd=160n sca=11.6918 \
        scb=0.00996378 scc=0.000286585 m=(1)
mp31 (\12\:mout n20 \22\:VDD NW) g45p1svt w=(3.1e-07) l=4.5e-08 nf=1 \
        as=9.7e-14 ad=4.96e-14 ps=1.54e-06 pd=9.4e-07 nrd=1.16667 \
        nrs=1.16667 sa=3.05e-07 sb=9.15e-07 sd=160n sca=11.6918 \
        scb=0.00996378 scc=0.000286585 m=(1)
mp35 (net378 \4\:mout \22\:VDD NW) g45p1svt w=(3.1e-07) l=4.5e-08 nf=1 \
        as=9.7e-14 ad=3.565e-14 ps=1.54e-06 pd=8.5e-07 nrd=1.16667 \
        nrs=1.16667 sa=5.7e-07 sb=6.5e-07 sd=160n sca=11.6918 \
        scb=0.00996378 scc=0.000286585 m=(1)
mp36 (\6\:n20 \5\:CKb net378 NW) g45p1svt w=(3.1e-07) l=4.5e-08 nf=1 \
        as=3.565e-14 ad=6.51e-14 ps=8.5e-07 pd=1.04e-06 nrd=1.16667 \
        nrs=1.16667 sa=7.3e-07 sb=4.9e-07 sd=160n sca=11.6918 \
        scb=0.00996378 scc=0.000286585 m=(1)
mp25 (\6\:n20 \4\:CKbb \8\:Db NW) g45p1svt w=(3.1e-07) l=4.5e-08 nf=1 \
        as=7.285e-14 ad=6.51e-14 ps=1.09e-06 pd=1.04e-06 nrd=1.16667 \
        nrs=1.16667 sa=9.85e-07 sb=2.35e-07 sd=160n sca=11.6918 \
        scb=0.00996378 scc=0.000286585 m=(1)
mp21 (\9\:CKbb \7\:CKb \20\:VDD NW) g45p1svt w=(2.15e-07) l=4.5e-08 nf=1 \
        as=3.01e-14 ad=3.01e-14 ps=7.1e-07 pd=7.1e-07 nrd=1.16667 \
        nrs=1.16667 sa=1.4e-07 sb=1.4e-07 sd=160n sca=45.7906 \
        scb=0.0283307 scc=0.00588417 m=(1)
mp20 (\22\:CKb \1\:CK \18\:VDD NW) g45p1svt w=(2.15e-07) l=4.5e-08 nf=1 \
        as=1.2125e-13 ad=3.01e-14 ps=1.68e-06 pd=7.1e-07 nrd=1.16667 \
        nrs=1.16667 sa=1.4e-07 sb=1.28e-06 sd=160n sca=12.1244 \
        scb=0.0107968 scc=0.000332109 m=(1)
mp10 (\5\:SEb \7\:SE \1\:VDD NW) g45p1svt w=(2.15e-07) l=4.5e-08 nf=1 \
        as=3.94e-14 ad=3.01e-14 ps=1.15e-06 pd=7.1e-07 nrd=1.16667 \
        nrs=1.16667 sa=1.4e-07 sb=1e-07 sd=160n sca=24.2122 scb=0.0283954 \
        scc=0.00140518 m=(1)
ends SDFFSHQX8
// End of subcircuit definition.
