// gsclib045_backbias/BUFX20/schematic

simulator lang=spectre

subckt BUFX20 A Y NW VDD VSS
mn1 (VSS n0 Y VSS) g45n1svt w=(5.185u) l=45n nf=1 m=(1)
mn0 (VSS A n0 VSS) g45n1svt w=(1.3u) l=45n nf=1 m=(1)
mp1 (Y n0 VDD NW) g45p1svt w=(7.82u) l=45n nf=1 m=(1)
mp0 (n0 A VDD NW) g45p1svt w=(1.95u) l=45n nf=1 m=(1)
ends BUFX20
