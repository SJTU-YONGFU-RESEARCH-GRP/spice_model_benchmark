// Generated for: spectre (May  1 08:11:54 2013 )
// Library name: gsclib045
// Cell name: LSLH_ISOH_X1_FROM_OFF
// View name: extracted

simulator lang=spectre

subckt LSLH_ISOH_X1_FROM_OFF A ExtVDD ISO VDD VSS Y
PM2 (\9\:Ab \9\:A \3\:VDD VDD) g45p1svt w=(2.15e-07) l=4.5e-08 nf=1 \
        as=3.01e-14 ad=3.01e-14 ps=7.1e-07 pd=7.1e-07 nrd=1.16667 \
        nrs=1.16667 sa=1.4e-07 sb=1.4e-07 sd=160n sca=24.0639 \
        scb=0.0290523 scc=0.00100369 m=(1)
PM0 (\12\:Ybint \4\:Yint \14\:ExtVDD ExtVDD) g45p1svt w=(2.15e-07) \
        l=4.5e-08 nf=1 as=3.01e-14 ad=3.01e-14 ps=7.1e-07 pd=7.1e-07 \
        nrd=1.16667 nrs=1.16667 sa=1.4e-07 sb=1.4e-07 sd=160n sca=25.7248 \
        scb=0.0268097 scc=0.00266528 m=(1)
PM5 (\17\:ison \1\:ISO \6\:ExtVDD ExtVDD) g45p1svt w=(2.15e-07) \
        l=4.5e-08 nf=1 as=3.01e-14 ad=3.01e-14 ps=7.1e-07 pd=7.1e-07 \
        nrd=1.16667 nrs=1.16667 sa=1.4e-07 sb=1.4e-07 sd=160n sca=21.4837 \
        scb=0.0250239 scc=0.00136209 m=(1)
PM1 (\11\:Yint Ybint \12\:ExtVDD ExtVDD) g45p1svt w=(2.15e-07) l=4.5e-08 \
        nf=1 as=3.01e-14 ad=3.01e-14 ps=7.1e-07 pd=7.1e-07 nrd=1.16667 \
        nrs=1.16667 sa=1.4e-07 sb=1.4e-07 sd=160n sca=6.55891 \
        scb=0.00285886 scc=1.84381e-05 m=(1)
C1 (Y VSS) capacitor c=3.56015e-17
C2 (ISO VSS) capacitor c=3.84152e-17
C3 (VDD VSS) capacitor c=1.03304e-16
C4 (A VSS) capacitor c=4.10655e-17
C5 (ExtVDD VSS) capacitor c=2.9805e-16
C6 (Yint VSS) capacitor c=3.4573e-17
C7 (Ab VSS) capacitor c=1.68214e-16
C8 (Ybint VSS) capacitor c=3.13144e-17
C9 (GatedVSS VSS) capacitor c=3.68864e-17
C10 (ison VSS) capacitor c=1.2322e-16
C11 (\6\:Ybint VSS) capacitor c=3.75717e-17
C12 (\8\:ison VSS) capacitor c=4.0956e-17
C13 (\1\:ISO VSS) capacitor c=4.40767e-17
C14 (\4\:Yint VSS) capacitor c=2.45492e-17
C15 (\9\:A VSS) capacitor c=3.93413e-17
C16 (\3\:Ybint VSS) capacitor c=2.95632e-17
C17 (\1\:A VSS) capacitor c=2.32894e-16
C18 (\4\:ISO VSS) capacitor c=2.63678e-17
C19 (\10\:A VSS) capacitor c=2.89179e-17
C20 (\5\:Ybint VSS) capacitor c=1.16933e-17
C21 (\1\:Y VSS) capacitor c=3.52208e-17
C22 (\2\:Y VSS) capacitor c=3.56882e-17
C23 (\2\:ExtVDD VSS) capacitor c=1.85472e-17
C24 (\1\:ExtVDD VSS) capacitor c=2.0122e-17
C25 (\2\:Ybint VSS) capacitor c=2.27297e-17
C26 (\12\:ison VSS) capacitor c=3.01685e-17
C27 (\7\:ison VSS) capacitor c=2.14062e-17
C28 (\3\:ISO VSS) capacitor c=1.56073e-17
C29 (\3\:Yint VSS) capacitor c=2.39197e-17
C30 (\2\:GatedVSS VSS) capacitor c=3.24504e-17
C31 (\4\:Ab VSS) capacitor c=7.74959e-17
C32 (\6\:A VSS) capacitor c=1.72561e-17
C33 (\8\:Y VSS) capacitor c=8.84136e-17
C34 (\10\:ExtVDD VSS) capacitor c=7.1384e-17
C35 (\4\:Y VSS) capacitor c=5.8122e-17
C36 (\3\:ExtVDD VSS) capacitor c=6.57561e-17
C37 (\12\:ExtVDD VSS) capacitor c=1.18991e-16
C38 (\11\:Yint VSS) capacitor c=6.32084e-17
C39 (\17\:ison VSS) capacitor c=7.04278e-17
C40 (\12\:Ybint VSS) capacitor c=9.07361e-17
C41 (\6\:ExtVDD VSS) capacitor c=1.17099e-16
C42 (\14\:ExtVDD VSS) capacitor c=1.30279e-16
C43 (\9\:Ab VSS) capacitor c=6.06619e-17
C44 (\3\:VDD VSS) capacitor c=3.74066e-17
C45 (\6\:Y VSS) capacitor c=7.44287e-17
C46 (\9\:GatedVSS VSS) capacitor c=9.91972e-17
C47 (\3\:GatedVSS VSS) capacitor c=3.67685e-16
C48 (\7\:Ybint VSS) capacitor c=2.16786e-16
C49 (\5\:Yint VSS) capacitor c=1.97969e-16
C50 (\14\:ison VSS) capacitor c=3.52152e-17
C51 (\11\:Ab VSS) capacitor c=3.97669e-17
C52 (\15\:GatedVSS VSS) capacitor c=9.99477e-17
C53 (\2\:ISO VSS) capacitor c=3.85488e-17
C54 (\2\:Yint VSS) capacitor c=1.98518e-17
C55 (VDD VSS) capacitor c=4.51655e-16
C56 (\4\:A VSS) capacitor c=1.29827e-16
C57 (\5\:A VSS) capacitor c=2.03189e-17
C58 (\6\:ison VSS) capacitor c=1.76237e-17
C59 (\4\:Ybint VSS) capacitor c=1.54443e-17
C60 (\12\:A VSS) capacitor c=1.99708e-17
C61 (\7\:Ab VSS) capacitor c=1.00026e-17
C62 (\8\:Ab VSS) capacitor c=6.19461e-17
C63 (\5\:ISO VSS) capacitor c=3.76396e-17
C64 (\8\:Yint VSS) capacitor c=3.95713e-17
C65 (\13\:ison VSS) capacitor c=4.30018e-17
C66 (\16\:ison VSS) capacitor c=7.06258e-17
C67 (\13\:Yint VSS) capacitor c=5.47857e-17
C68 (\5\:ExtVDD VSS) capacitor c=1.04541e-16
C69 (\6\:GatedVSS VSS) capacitor c=1.12437e-16
C70 (\3\:Y VSS) capacitor c=5.35004e-17
C71 (\11\:GatedVSS VSS) capacitor c=4.34313e-16
C72 (\14\:GatedVSS VSS) capacitor c=1.65079e-16
C73 (\23\:GatedVSS VSS) capacitor c=7.78528e-17
C74 (\8\:ExtVDD VSS) capacitor c=8.82547e-18
C75 (\9\:ExtVDD VSS) capacitor c=1.43957e-17
C76 (\17\:ExtVDD VSS) capacitor c=7.13237e-17
C77 (\11\:Ybint VSS) capacitor c=9.75892e-17
C78 (\14\:Ybint VSS) capacitor c=5.40885e-17
C79 (\10\:Y VSS) capacitor c=4.62444e-17
C80 (\2\:VDD VSS) capacitor c=1.5324e-17
Rk21 (\3\:Y \5\:Y) resistor r=0.3227 c=0
Rk46 (\9\:Y Y) resistor r=0.01673 c=0
Rk44 (\7\:Y \9\:Y) resistor r=0.5262 c=0
Rk45 (\9\:Y \10\:Y) resistor r=0.2619 c=0
Rk9 (\5\:ISO ISO) resistor r=0.04036 c=0
Rk59 (VDD VDD) resistor r=0.6016 c=0
Rk60 (VDD \2\:VDD) resistor r=0.2049 c=0
Rk61 (\2\:VDD \4\:VDD) resistor r=0.3311 c=0
Rk1 (A \11\:A) resistor r=0.008212 c=0
Rk3 (\12\:A A) resistor r=0.005208 c=0
Rk2 (\11\:A \12\:A) resistor r=0.004045 c=0
Rk37 (ExtVDD ExtVDD) resistor r=0.002861 c=0
Rk16 (\4\:ExtVDD \5\:ExtVDD) resistor r=0.3119 c=0
Rk17 (\5\:ExtVDD \7\:ExtVDD) resistor r=0.9376 c=0
Rk31 (\8\:ExtVDD \9\:ExtVDD) resistor r=0.1174 c=0
Rk32 (\9\:ExtVDD \11\:ExtVDD) resistor r=0.3119 c=0
Rk33 (\9\:ExtVDD \13\:ExtVDD) resistor r=0.2247 c=0
Rk34 (\13\:ExtVDD \15\:ExtVDD) resistor r=0.9909 c=0
Rk36 (\17\:ExtVDD ExtVDD) resistor r=0.002861 c=0
Rk35 (\9\:ExtVDD \17\:ExtVDD) resistor r=0.1819 c=0
Rk51 (VSS VSS) resistor r=0.1479 c=0
Rk50 (\3\:VSS VSS) resistor r=0.08092 c=0
Rk47 (\2\:VSS \3\:VSS) resistor r=0.1058 c=0
Rk52 (VSS \6\:VSS) resistor r=0.1135 c=0
Rk54 (\7\:VSS VSS) resistor r=0.2192 c=0
Rk53 (\6\:VSS \7\:VSS) resistor r=0.1329 c=0
Rk58 (\6\:VSS \15\:VSS) resistor r=0.2098 c=0
Rk62 (\17\:VSS VSS) resistor r=0.5915 c=0
Rk64 (\18\:VSS VSS) resistor r=0.1797 c=0
Rk63 (VSS \18\:VSS) resistor r=0.3947 c=0
Rk11 (\5\:Yint \8\:Yint) resistor r=0.2147 c=0
Rk15 (\12\:Yint \13\:Yint) resistor r=0.2964 c=0
Rk6 (\7\:Ab \8\:Ab) resistor r=0.04277 c=0
Rk7 (\8\:Ab \10\:Ab) resistor r=0.4592 c=0
Rk8 (\8\:Ab \12\:Ab) resistor r=0.1596 c=0
Rk40 (\7\:Ybint \11\:Ybint) resistor r=0.1765 c=0
Rk41 (\11\:Ybint \13\:Ybint) resistor r=0.6333 c=0
Rk42 (\7\:Ybint \14\:Ybint) resistor r=0.2894 c=0
Rk19 (\3\:GatedVSS \6\:GatedVSS) resistor r=1.4219 c=0
Rk22 (\10\:GatedVSS \11\:GatedVSS) resistor r=0.5676 c=0
Rk25 (\11\:GatedVSS \14\:GatedVSS) resistor r=0.4737 c=0
Rk26 (\14\:GatedVSS \16\:GatedVSS) resistor r=0.6286 c=0
Rk30 (\14\:GatedVSS \23\:GatedVSS) resistor r=0.7591 c=0
Rk13 (\13\:ison \15\:ison) resistor r=0.2856 c=0
Rk14 (\16\:ison \18\:ison) resistor r=0.4254 c=0
Rl35 (\1\:Y \2\:Y) resistor r=107.339 c=0
Rl2 (\1\:ISO \2\:ISO) resistor r=159.681 c=0
Rl4 (\2\:ISO \4\:ISO) resistor r=86.3858 c=0
Rl3 (\2\:ISO \3\:ISO) resistor r=5.1123 c=0
Rl21 (\4\:A \9\:A) resistor r=132.549 c=0
Rl16 (\4\:A \1\:A) resistor r=624.028 c=0
Rl22 (\5\:A \10\:A) resistor r=84.6812 c=0
Rl18 (\5\:A \6\:A) resistor r=5.1123 c=0
Rl17 (\5\:A \4\:A) resistor r=29.0517 c=0
Rl23 (\1\:ExtVDD \2\:ExtVDD) resistor r=166.126 c=0
Rl12 (\2\:Yint \4\:Yint) resistor r=41.7694 c=0
Rl10 (\2\:Yint Yint) resistor r=105.33 c=0
Rl11 (\2\:Yint \3\:Yint) resistor r=34.5546 c=0
Rl7 (Ab \4\:Ab) resistor r=297.11 c=0
Rl13 (\2\:Ybint Ybint) resistor r=72.3229 c=0
Rl38 (\4\:Ybint \6\:Ybint) resistor r=93.2039 c=0
Rl36 (\4\:Ybint \3\:Ybint) resistor r=67.6128 c=0
Rl37 (\4\:Ybint \5\:Ybint) resistor r=3.5166 c=0
Rl1 (\2\:GatedVSS GatedVSS) resistor r=169.462 c=0
Rl30 (ison \8\:ison) resistor r=115.053 c=0
Rl28 (\6\:ison ison) resistor r=72.842 c=0
Rl34 (\6\:ison \12\:ison) resistor r=116.573 c=0
Rl29 (\6\:ison \7\:ison) resistor r=51.6001 c=0
Rz15 (\6\:Y \7\:Y) resistor r=37.5 c=0
Rz19 (\15\:VSS \14\:VSS) resistor r=75 c=0
Rz1 (\12\:Ab \11\:Ab) resistor r=75 c=0
Rz7 (\10\:GatedVSS \9\:GatedVSS) resistor r=37.5 c=0
Rz8 (\16\:GatedVSS \15\:GatedVSS) resistor r=75 c=0
Rz4 (\15\:ison \14\:ison) resistor r=75 c=0
Ry6 (\4\:Y \5\:Y) resistor r=20.6667 c=0
Ry11 (\8\:Y \9\:Y) resistor r=20.6667 c=0
Ry14 (\3\:VDD \4\:VDD) resistor r=62 c=0
Ry4 (\3\:ExtVDD \4\:ExtVDD) resistor r=20.6667 c=0
Ry5 (\6\:ExtVDD \7\:ExtVDD) resistor r=62 c=0
Ry7 (\10\:ExtVDD \11\:ExtVDD) resistor r=20.6667 c=0
Ry8 (\12\:ExtVDD \13\:ExtVDD) resistor r=62 c=0
Ry9 (\14\:ExtVDD \15\:ExtVDD) resistor r=62 c=0
Ry12 (\2\:VSS \1\:VSS) resistor r=7.75 c=0
Ry13 (\7\:VSS \1\:VSS) resistor r=5.1667 c=0
Ry15 (\17\:VSS \16\:VSS) resistor r=7.75 c=0
Ry16 (\18\:VSS \16\:VSS) resistor r=5.1667 c=0
Ry3 (\12\:Yint \11\:Yint) resistor r=62 c=0
Ry1 (\10\:Ab \9\:Ab) resistor r=62 c=0
Ry10 (\13\:Ybint \12\:Ybint) resistor r=62 c=0
Ry2 (\18\:ison \17\:ison) resistor r=62 c=0
Rx10 (\2\:Y \3\:Y) resistor r=45 c=0
Rx15 (\1\:Y \10\:Y) resistor r=45 c=0
Rx3 (\3\:ISO \5\:ISO) resistor r=45 c=0
Rx1 (\11\:A \6\:A) resistor r=45 c=0
Rx8 (\1\:ExtVDD \5\:ExtVDD) resistor r=45 c=0
Rx12 (\2\:ExtVDD \8\:ExtVDD) resistor r=45 c=0
Rx4 (\8\:Yint \3\:Yint) resistor r=45 c=0
Rx7 (\13\:Yint Yint) resistor r=45 c=0
Rx2 (\7\:Ab \4\:Ab) resistor r=45 c=0
Rx13 (\11\:Ybint \2\:Ybint) resistor r=45 c=0
Rx14 (\14\:Ybint \5\:Ybint) resistor r=45 c=0
Rx9 (\6\:GatedVSS \2\:GatedVSS) resistor r=45 c=0
Rx11 (\23\:GatedVSS GatedVSS) resistor r=45 c=0
Rx5 (\13\:ison \7\:ison) resistor r=45 c=0
Rx6 (\16\:ison \12\:ison) resistor r=45 c=0
NM2 (\15\:GatedVSS \10\:A \11\:Ab VSS) g45n1svt w=(1.45e-07) l=4.5e-08 \
        nf=1 as=2.03e-14 ad=2.03e-14 ps=5.7e-07 pd=5.7e-07 nrd=1.16667 \
        nrs=1.16667 sa=1.4e-07 sb=1.4e-07 sd=160n sca=7.79977 \
        scb=0.00524357 scc=6.87485e-05 m=(1)
NM4 (\14\:VSS \4\:ISO \14\:ison VSS) g45n1svt w=(1.45e-07) l=4.5e-08 \
        nf=1 as=2.03e-14 ad=2.03e-14 ps=5.7e-07 pd=5.7e-07 nrd=1.16667 \
        nrs=1.16667 sa=1.4e-07 sb=1.4e-07 sd=160n sca=7.27658 \
        scb=0.00433573 scc=4.41722e-05 m=(1)
mn0 (\6\:Y \3\:Ybint \9\:GatedVSS VSS) g45n1svt w=(2.6e-07) l=4.5e-08 \
        nf=1 as=3.64e-14 ad=3.64e-14 ps=8e-07 pd=8e-07 nrd=1.16667 \
        nrs=1.16667 sa=1.4e-07 sb=1.4e-07 sd=160n sca=11.8713 \
        scb=0.0115056 scc=0.000581193 m=(1)
NM0 (\7\:Ybint \1\:A \11\:GatedVSS VSS) g45n1svt w=(2.6e-07) l=4.5e-08 \
        nf=1 as=3.987e-14 ad=4.16e-14 ps=8.2667e-07 pd=8.4e-07 nrd=1.16667 \
        nrs=1.16667 sa=7.55e-07 sb=5.5e-07 sd=160n sca=16.3874 \
        scb=0.0162972 scc=0.00139495 m=(3)
NM1_1__rcx (\5\:Yint Ab \11\:GatedVSS VSS) g45n1svt w=(2.6e-07) l=4.5e-08 \
        nf=1 as=4.16e-14 ad=3.987e-14 ps=8.4e-07 pd=8.2667e-07 nrd=1.16667 \
        nrs=1.16667 sa=5.5e-07 sb=7.55e-07 sd=160n sca=16.3874 \
        scb=0.0162972 scc=0.00139495 m=(3)
NM3_1__rcx (\3\:GatedVSS ison \3\:VSS VSS) g45n1svt w=(2.6e-07) \
        l=4.5e-08 nf=1 as=4.16e-14 ad=3.9e-14 ps=8.4e-07 pd=8.2e-07 \
        nrd=1.16667 nrs=1.16667 sa=1.4e-07 sb=7.55e-07 sd=160n sca=8.36684 \
        scb=0.00633377 scc=0.000139167 m=(4)
PM4 (\4\:Y \8\:ison \3\:ExtVDD ExtVDD) g45p1svt w=(3.9e-07) l=4.5e-08 \
        nf=1 as=5.46e-14 ad=5.46e-14 ps=1.06e-06 pd=1.06e-06 nrd=1.16667 \
        nrs=1.16667 sa=1.4e-07 sb=1.4e-07 sd=160n sca=18.499 scb=0.0162347 \
        scc=0.00159525 m=(1)
mp0 (\8\:Y \6\:Ybint \10\:ExtVDD ExtVDD) g45p1svt w=(3.9e-07) l=4.5e-08 \
        nf=1 as=5.46e-14 ad=5.46e-14 ps=1.06e-06 pd=1.06e-06 nrd=1.16667 \
        nrs=1.16667 sa=1.4e-07 sb=1.4e-07 sd=160n sca=28.6983 \
        scb=0.0316799 scc=0.00295254 m=(1)
ends LSLH_ISOH_X1_FROM_OFF
// End of subcircuit definition.
