// Generated for: spectre (May  1 11:27:18 2013 )
// Library name: gsclib045_backbias
// Cell name: AO21X4
// View name: extracted

simulator lang=spectre

subckt AO21X4 A0 A1 B0 NW VDD VSS Y
mp0 (\3\:net88 \1\:A0 \10\:VDD NW) g45p1svt w=(3.9e-07) l=4.5e-08 nf=1 \
        as=6.24e-14 ad=5.46e-14 ps=1.1e-06 pd=1.06e-06 nrd=1.16667 \
        nrs=1.16667 sa=1.4e-07 sb=5.3e-07 sd=160n sca=16.4723 \
        scb=0.0164029 scc=0.000368802 m=(1)
mp1 (net88 \1\:A1 \10\:VDD NW) g45p1svt w=(3.9e-07) l=4.5e-08 nf=1 \
        as=6.24e-14 ad=6.24e-14 ps=1.1e-06 pd=1.1e-06 nrd=1.16667 \
        nrs=1.16667 sa=3.45e-07 sb=3.25e-07 sd=160n sca=13.2039 \
        scb=0.0109987 scc=0.000261009 m=(1)
mp2 (\20\:net100 \1\:B0 net88 NW) g45p1svt w=(3.9e-07) l=4.5e-08 nf=1 \
        as=6.24e-14 ad=4.68e-14 ps=1.1e-06 pd=1.11e-06 nrd=1.16667 \
        nrs=1.16667 sa=5.5e-07 sb=1.2e-07 sd=160n sca=12.0571 \
        scb=0.00992821 scc=0.00025832 m=(1)
mp3 (\6\:Y net100 \1\:VDD NW) g45p1svt w=(3.9e-07) l=4.5e-08 nf=1 \
        as=5.58e-14 ad=6.24e-14 ps=1.08e-06 pd=1.1e-06 nrd=1.16667 \
        nrs=1.16667 sa=1.12308e-07 sb=7.55e-07 sd=160n sca=14.0824 \
        scb=0.0125149 scc=0.000698926 m=(4)
C1 (NW VSS) capacitor c=2.72455e-16
C2 (Y VSS) capacitor c=2.66989e-17
C3 (A0 VSS) capacitor c=6.81715e-17
C4 (VDD VSS) capacitor c=4.18084e-17
C5 (net100 VSS) capacitor c=3.65988e-16
C6 (net88 VSS) capacitor c=7.76511e-17
C7 (\1\:B0 VSS) capacitor c=5.09434e-17
C8 (\1\:A1 VSS) capacitor c=5.44342e-17
C9 (\1\:A0 VSS) capacitor c=5.45985e-17
C10 (\3\:B0 VSS) capacitor c=5.2714e-17
C11 (\3\:A1 VSS) capacitor c=6.10218e-17
C12 (\3\:A0 VSS) capacitor c=4.09915e-17
C13 (\2\:B0 VSS) capacitor c=4.04526e-17
C14 (\2\:A1 VSS) capacitor c=5.456e-17
C15 (\2\:A0 VSS) capacitor c=4.45578e-17
C16 (\1\:VDD VSS) capacitor c=3.19839e-16
C17 (\20\:net100 VSS) capacitor c=5.0494e-17
C18 (\10\:VDD VSS) capacitor c=4.19217e-17
C19 (\3\:net88 VSS) capacitor c=5.05879e-17
C20 (\2\:Y VSS) capacitor c=1.25616e-16
C21 (\18\:net100 VSS) capacitor c=3.80712e-17
C22 (\4\:A0 VSS) capacitor c=1.88755e-17
C23 (\4\:A1 VSS) capacitor c=1.25828e-16
C24 (\4\:B0 VSS) capacitor c=1.3967e-16
C25 (\17\:net100 VSS) capacitor c=7.36463e-17
C26 (\1\:Y VSS) capacitor c=4.58727e-17
C27 (\6\:Y VSS) capacitor c=2.34281e-16
C28 (\5\:VDD VSS) capacitor c=5.25911e-17
Rk6 (\4\:B0 B0) resistor r=0.003683 c=0
Rk4 (\4\:A1 A1) resistor r=0.003683 c=0
Rk11 (Y \1\:Y) resistor r=0.1369 c=0
Rk12 (\1\:Y \2\:Y) resistor r=0.2642 c=0
Rk14 (\1\:Y \6\:Y) resistor r=0.194 c=0
Rk3 (\4\:A0 A0) resistor r=0.00899 c=0
Rk28 (\7\:VSS VSS) resistor r=0.07475 c=0
Rk27 (\1\:VSS \7\:VSS) resistor r=0.2979 c=0
Rk31 (\7\:VSS \13\:VSS) resistor r=0.1734 c=0
Rk20 (\5\:VDD VDD) resistor r=0.1775 c=0
Rk19 (\1\:VDD \5\:VDD) resistor r=0.2979 c=0
Rk23 (\5\:VDD \11\:VDD) resistor r=0.19 c=0
Rk8 (net100 \17\:net100) resistor r=0.1486 c=0
Rk9 (\17\:net100 \19\:net100) resistor r=0.2864 c=0
Rk10 (\17\:net100 \21\:net100) resistor r=0.3745 c=0
Rk5 (\2\:net88 \4\:net88) resistor r=0.4345 c=0
Rl5 (\1\:B0 \2\:B0) resistor r=72.2449 c=0
Rl6 (\2\:B0 \3\:B0) resistor r=120.685 c=0
Rl3 (\1\:A1 \2\:A1) resistor r=76.9231 c=0
Rl4 (\2\:A1 \3\:A1) resistor r=126.099 c=0
Rl1 (\1\:A0 \2\:A0) resistor r=149.175 c=0
Rl2 (\2\:A0 \3\:A0) resistor r=45.3288 c=0
Rz7 (\13\:VSS \12\:VSS) resistor r=75 c=0
Rz1 (\19\:net100 \18\:net100) resistor r=75 c=0
Ry9 (\11\:VDD \10\:VDD) resistor r=62 c=0
Ry3 (\21\:net100 \20\:net100) resistor r=62 c=0
Ry1 (net88 \2\:net88) resistor r=31 c=0
Ry2 (\3\:net88 \4\:net88) resistor r=31 c=0
Rx3 (\2\:B0 \4\:B0) resistor r=45 c=0
Rx2 (\2\:A1 \4\:A1) resistor r=45 c=0
Rx1 (\2\:A0 \4\:A0) resistor r=45 c=0
mn0 (net104 \3\:A0 \12\:VSS VSS) g45n1svt w=(2.6e-07) l=4.5e-08 nf=1 \
        as=3.64e-14 ad=2.73e-14 ps=8e-07 pd=7.3e-07 nrd=1.16667 \
        nrs=1.16667 sa=1.4e-07 sb=1.35e-06 sd=160n sca=7.84363 \
        scb=0.00546499 scc=9.84911e-05 m=(1)
mn1 (\18\:net100 \3\:A1 net104 VSS) g45n1svt w=(2.6e-07) l=4.5e-08 nf=1 \
        as=2.73e-14 ad=5.07e-14 ps=7.3e-07 pd=9.1e-07 nrd=1.16667 \
        nrs=1.16667 sa=2.9e-07 sb=1.2e-06 sd=160n sca=7.84363 \
        scb=0.00546499 scc=9.84911e-05 m=(1)
mn2 (\18\:net100 \3\:B0 \1\:VSS VSS) g45n1svt w=(2.6e-07) l=4.5e-08 nf=1 \
        as=4.16e-14 ad=5.07e-14 ps=8.4e-07 pd=9.1e-07 nrd=1.16667 \
        nrs=1.16667 sa=5.3e-07 sb=9.6e-07 sd=160n sca=7.84363 \
        scb=0.00546499 scc=9.84911e-05 m=(1)
mn3 (\2\:Y net100 \1\:VSS VSS) g45n1svt w=(2.6e-07) l=4.5e-08 nf=1 \
        as=4.03e-14 ad=4.16e-14 ps=8.3e-07 pd=8.4e-07 nrd=1.16667 \
        nrs=1.16667 sa=7.35e-07 sb=7.55e-07 sd=160n sca=7.84363 \
        scb=0.00546499 scc=9.84911e-05 m=(4)
ends AO21X4
// End of subcircuit definition.
