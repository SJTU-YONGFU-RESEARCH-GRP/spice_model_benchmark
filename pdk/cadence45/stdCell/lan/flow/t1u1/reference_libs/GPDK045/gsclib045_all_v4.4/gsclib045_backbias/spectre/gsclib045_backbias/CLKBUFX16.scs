// gsclib045_backbias/CLKBUFX16/schematic

simulator lang=spectre

subckt CLKBUFX16 A Y VSS NW VDD
mn1 (Y net44 VSS VSS) g45n1svt w=(4.13u) l=45n nf=1 m=(1)
mn0 (net44 A VSS VSS) g45n1svt w=(1.04u) l=45n nf=1 m=(1)
mp1 (Y net44 VDD NW) g45p1svt w=(6.23u) l=45n nf=1 m=(1)
mp0 (net44 A VDD NW) g45p1svt w=(1.56u) l=45n nf=1 m=(1)
ends CLKBUFX16
