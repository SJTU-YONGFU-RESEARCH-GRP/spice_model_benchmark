// Generated for: spectre (May  1 09:14:15 2013 )
// Library name: gsclib045_lvt
// Cell name: DFFX4
// View name: extracted

simulator lang=spectre

subckt DFFX4 CK D Q QN VDD VSS
mp20 (\21\:CKb \1\:CK \13\:VDD VDD) g45p1lvt w=(2.15e-07) l=4.5e-08 nf=1 \
        as=3.01e-14 ad=5.15e-14 ps=7.1e-07 pd=1.13e-06 nrd=1.16667 \
        nrs=1.16667 sa=1.4e-07 sb=2.39535e-07 sd=160n sca=35.6444 \
        scb=0.0398802 scc=0.00365724 m=(1)
mp21 (\13\:CKbb CKb \30\:VDD VDD) g45p1lvt w=(2.15e-07) l=4.5e-08 nf=1 \
        as=3.44e-14 ad=3.01e-14 ps=7.5e-07 pd=7.1e-07 nrd=1.16667 \
        nrs=1.16667 sa=1.4e-07 sb=2e-06 sd=160n sca=10.8469 scb=0.00772406 \
        scc=8.06202e-05 m=(1)
mp25 (n22 \1\:D \30\:VDD VDD) g45p1lvt w=(2.15e-07) l=4.5e-08 nf=1 \
        as=3.44e-14 ad=2.472e-14 ps=7.5e-07 pd=6.6e-07 nrd=1.16667 \
        nrs=1.16667 sa=3.45e-07 sb=2e-06 sd=160n sca=10.2589 \
        scb=0.00748244 scc=8.05157e-05 m=(1)
mp26 (\5\:n20 \3\:CKbb n22 VDD) g45p1lvt w=(2.15e-07) l=4.5e-08 nf=1 \
        as=2.472e-14 ad=4.73e-14 ps=6.6e-07 pd=8.7e-07 nrd=1.16667 \
        nrs=1.16667 sa=5.05e-07 sb=2e-06 sd=160n sca=10.2104 \
        scb=0.00747301 scc=8.05149e-05 m=(1)
mp36 (\5\:n20 \6\:CKb n26 VDD) g45p1lvt w=(2.15e-07) l=4.5e-08 nf=1 \
        as=2.472e-14 ad=4.73e-14 ps=6.6e-07 pd=8.7e-07 nrd=1.16667 \
        nrs=1.16667 sa=7.7e-07 sb=2e-06 sd=160n sca=10.2104 scb=0.00747301 \
        scc=8.05149e-05 m=(1)
mp35 (n26 mout \28\:VDD VDD) g45p1lvt w=(2.15e-07) l=4.5e-08 nf=1 \
        as=7.43e-14 ad=2.472e-14 ps=1.32e-06 pd=6.6e-07 nrd=1.16667 \
        nrs=1.16667 sa=9.3e-07 sb=2e-06 sd=160n sca=10.2104 scb=0.00747301 \
        scc=8.05149e-05 m=(1)
mp30 (\7\:mout n20 \28\:VDD VDD) g45p1lvt w=(2.15e-07) l=4.5e-08 nf=1 \
        as=7.43e-14 ad=6.558e-14 ps=1.32e-06 pd=1.04e-06 nrd=1.16667 \
        nrs=1.16667 sa=1.195e-06 sb=2e-06 sd=160n sca=10.2104 \
        scb=0.00747301 scc=8.05149e-05 m=(1)
mp40 (\12\:n30 \8\:CKb \7\:mout VDD) g45p1lvt w=(2.15e-07) l=4.5e-08 nf=1 \
        as=6.558e-14 ad=4.945e-14 ps=1.04e-06 pd=8.9e-07 nrd=1.16667 \
        nrs=1.16667 sa=1.545e-06 sb=2e-06 sd=160n sca=10.2104 \
        scb=0.00747301 scc=8.05149e-05 m=(1)
mp51 (\12\:n30 \4\:CKbb n36 VDD) g45p1lvt w=(2.15e-07) l=4.5e-08 nf=1 \
        as=1.29e-14 ad=4.945e-14 ps=5.5e-07 pd=8.9e-07 nrd=1.16667 \
        nrs=1.16667 sa=1.82e-06 sb=2e-06 sd=160n sca=10.2104 \
        scb=0.00747301 scc=8.05149e-05 m=(1)
mp50 (n36 qbint \3\:VDD VDD) g45p1lvt w=(2.15e-07) l=4.5e-08 nf=1 \
        as=5.415e-14 ad=1.29e-14 ps=1e-06 pd=5.5e-07 nrd=1.16667 \
        nrs=1.16667 sa=1.925e-06 sb=2e-06 sd=160n sca=10.2104 \
        scb=0.00747301 scc=8.05149e-05 m=(1)
C1 (D VSS) capacitor c=3.48266e-17
C2 (Q VSS) capacitor c=3.6664e-17
C3 (QN VSS) capacitor c=1.78845e-17
C4 (CK VSS) capacitor c=9.58303e-17
C5 (VDD VSS) capacitor c=3.17892e-16
C6 (CKb VSS) capacitor c=5.69226e-17
C7 (CKbb VSS) capacitor c=8.16834e-17
C8 (n20 VSS) capacitor c=3.42846e-17
C9 (n25 VSS) capacitor c=1.45671e-19
C10 (mout VSS) capacitor c=8.23341e-17
C11 (n30 VSS) capacitor c=2.11642e-16
C12 (qbint VSS) capacitor c=6.77096e-17
C13 (qint VSS) capacitor c=2.87511e-16
C14 (n22 VSS) capacitor c=2.69352e-19
C15 (n26 VSS) capacitor c=2.60756e-18
C16 (n36 VSS) capacitor c=4.50931e-21
C17 (\22\:qbint VSS) capacitor c=5.0465e-17
C18 (\5\:qbint VSS) capacitor c=2.69978e-16
C19 (\4\:CKbb VSS) capacitor c=4.81861e-17
C20 (\8\:CKb VSS) capacitor c=2.94243e-17
C21 (\6\:CKb VSS) capacitor c=5.02936e-17
C22 (\3\:CKbb VSS) capacitor c=3.50587e-17
C23 (\1\:D VSS) capacitor c=7.18806e-17
C24 (\1\:CK VSS) capacitor c=2.89244e-17
C25 (\20\:qbint VSS) capacitor c=3.21089e-17
C26 (\3\:qbint VSS) capacitor c=7.29841e-17
C27 (\10\:CKb VSS) capacitor c=7.32451e-17
C28 (\6\:CKbb VSS) capacitor c=6.02006e-17
C29 (\3\:n20 VSS) capacitor c=5.3617e-17
C30 (\3\:mout VSS) capacitor c=5.14167e-17
C31 (\5\:CKb VSS) capacitor c=5.21019e-17
C32 (\3\:D VSS) capacitor c=4.63968e-17
C33 (\2\:CKb VSS) capacitor c=4.82382e-17
C34 (\3\:CK VSS) capacitor c=2.30212e-17
C35 (\21\:qbint VSS) capacitor c=4.26311e-17
C36 (\4\:qbint VSS) capacitor c=2.20754e-17
C37 (\5\:CKbb VSS) capacitor c=7.22504e-17
C38 (\11\:CKb VSS) capacitor c=2.95592e-17
C39 (\9\:CKb VSS) capacitor c=3.63327e-17
C40 (\2\:n20 VSS) capacitor c=5.52422e-17
C41 (\2\:mout VSS) capacitor c=6.75528e-17
C42 (\7\:CKb VSS) capacitor c=3.90864e-17
C43 (\4\:CKb VSS) capacitor c=2.15682e-17
C44 (\2\:CKbb VSS) capacitor c=6.27814e-17
C45 (\2\:D VSS) capacitor c=5.05125e-17
C46 (\3\:CKb VSS) capacitor c=2.22178e-17
C47 (\2\:CK VSS) capacitor c=2.64482e-17
C48 (\19\:qint VSS) capacitor c=3.93485e-17
C49 (\1\:Q VSS) capacitor c=1.78415e-16
C50 (\31\:qbint VSS) capacitor c=5.94928e-17
C51 (\12\:n30 VSS) capacitor c=8.01197e-17
C52 (\7\:mout VSS) capacitor c=8.03439e-17
C53 (\28\:VDD VSS) capacitor c=2.68694e-17
C54 (\5\:n20 VSS) capacitor c=1.17514e-16
C55 (\30\:VDD VSS) capacitor c=3.55176e-17
C56 (\13\:CKbb VSS) capacitor c=1.77288e-17
C57 (\21\:CKb VSS) capacitor c=6.02436e-17
C58 (\13\:VDD VSS) capacitor c=3.00898e-17
C59 (\1\:VDD VSS) capacitor c=5.64578e-17
C60 (\15\:qint VSS) capacitor c=4.89053e-17
C61 (\1\:QN VSS) capacitor c=7.34137e-17
C62 (\28\:qbint VSS) capacitor c=1.98498e-17
C63 (\10\:n30 VSS) capacitor c=3.17678e-17
C64 (\4\:mout VSS) capacitor c=3.66209e-17
C65 (\7\:n20 VSS) capacitor c=7.94743e-17
C66 (\10\:CKbb VSS) capacitor c=9.72892e-17
C67 (\17\:CKb VSS) capacitor c=9.56238e-17
C68 (\2\:qbint VSS) capacitor c=5.55739e-17
C69 (\4\:D VSS) capacitor c=5.19669e-17
C70 (\4\:n20 VSS) capacitor c=6.64545e-17
C71 (\6\:mout VSS) capacitor c=6.83922e-17
C72 (\9\:mout VSS) capacitor c=4.19983e-17
C73 (\12\:CKb VSS) capacitor c=9.45312e-17
C74 (\13\:CKb VSS) capacitor c=9.45085e-17
C75 (\14\:CKb VSS) capacitor c=8.74542e-17
C76 (\15\:CKb VSS) capacitor c=5.43095e-17
C77 (\16\:CKb VSS) capacitor c=7.63246e-17
C78 (\19\:CKb VSS) capacitor c=4.28577e-17
C79 (\20\:CKb VSS) capacitor c=9.43854e-17
C80 (\7\:CKbb VSS) capacitor c=1.91504e-16
C81 (\8\:CKbb VSS) capacitor c=1.86366e-16
C82 (\9\:CKbb VSS) capacitor c=5.34074e-17
C83 (\12\:CKbb VSS) capacitor c=2.4517e-17
C84 (\8\:n30 VSS) capacitor c=5.14137e-17
C85 (\9\:n30 VSS) capacitor c=5.69607e-17
C86 (\4\:Q VSS) capacitor c=9.97708e-17
C87 (\5\:QN VSS) capacitor c=1.7638e-16
C88 (\23\:qbint VSS) capacitor c=2.33815e-16
C89 (\24\:qbint VSS) capacitor c=2.09971e-16
C90 (\26\:qbint VSS) capacitor c=3.93037e-17
C91 (\27\:qbint VSS) capacitor c=4.12581e-17
C92 (\30\:qbint VSS) capacitor c=3.97896e-17
C93 (\17\:qint VSS) capacitor c=4.33346e-17
C94 (\18\:qint VSS) capacitor c=3.05313e-17
C95 (\3\:VDD VSS) capacitor c=5.3063e-16
C96 (\10\:VDD VSS) capacitor c=3.94915e-17
C97 (\12\:VDD VSS) capacitor c=2.00191e-17
Rk2 (D \4\:D) resistor r=0.06305 c=0
Rk25 (\1\:Q Q) resistor r=0.2391 c=0
Rk26 (Q \4\:Q) resistor r=0.1104 c=0
Rk45 (\2\:VSS \3\:VSS) resistor r=0.07253 c=0
Rk52 (\3\:VSS \10\:VSS) resistor r=0.4711 c=0
Rk53 (\10\:VSS \11\:VSS) resistor r=0.1754 c=0
Rk55 (\12\:VSS VSS) resistor r=0.4337 c=0
Rk54 (\11\:VSS \12\:VSS) resistor r=0.1177 c=0
Rk56 (VSS \14\:VSS) resistor r=0.2596 c=0
Rk63 (\10\:VSS \28\:VSS) resistor r=0.07393 c=0
Rk64 (\12\:VSS \30\:VSS) resistor r=0.07393 c=0
Rk31 (\1\:QN QN) resistor r=0.1689 c=0
Rk32 (QN \5\:QN) resistor r=0.1167 c=0
Rk1 (CK \4\:CK) resistor r=0.02238 c=0
Rk65 (\2\:VDD \3\:VDD) resistor r=0.1854 c=0
Rk72 (\3\:VDD \10\:VDD) resistor r=0.4977 c=0
Rk73 (\10\:VDD \11\:VDD) resistor r=0.2271 c=0
Rk75 (\12\:VDD VDD) resistor r=0.3685 c=0
Rk74 (\11\:VDD \12\:VDD) resistor r=0.1829 c=0
Rk76 (VDD \14\:VDD) resistor r=0.3799 c=0
Rk84 (\10\:VDD \29\:VDD) resistor r=0.04331 c=0
Rk85 (\12\:VDD \31\:VDD) resistor r=0.2276 c=0
Rk8 (\12\:CKb \13\:CKb) resistor r=0.548 c=0
Rk9 (\13\:CKb \14\:CKb) resistor r=0.4552 c=0
Rk10 (\14\:CKb \15\:CKb) resistor r=0.1638 c=0
Rk11 (\15\:CKb \16\:CKb) resistor r=0.3716 c=0
Rk12 (\16\:CKb \18\:CKb) resistor r=0.3725 c=0
Rk13 (\13\:CKb \19\:CKb) resistor r=0.2036 c=0
Rk14 (\14\:CKb \20\:CKb) resistor r=0.5096 c=0
Rk15 (\18\:CKb \22\:CKb) resistor r=0.4523 c=0
Rk16 (\7\:CKbb \8\:CKbb) resistor r=1.4506 c=0
Rk17 (\8\:CKbb \9\:CKbb) resistor r=0.2802 c=0
Rk18 (\9\:CKbb \11\:CKbb) resistor r=0.3846 c=0
Rk19 (\8\:CKbb \12\:CKbb) resistor r=0.06427 c=0
Rk20 (\9\:CKbb \14\:CKbb) resistor r=0.05841 c=0
Rk3 (\4\:n20 \6\:n20) resistor r=0.4128 c=0
Rk4 (\6\:n20 \8\:n20) resistor r=0.4737 c=0
Rk5 (\5\:mout \6\:mout) resistor r=0.1682 c=0
Rk6 (\6\:mout \8\:mout) resistor r=0.432 c=0
Rk7 (\6\:mout \9\:mout) resistor r=0.1869 c=0
Rk21 (\8\:n30 \9\:n30) resistor r=0.275 c=0
Rk22 (\9\:n30 \11\:n30) resistor r=0.0958 c=0
Rk23 (\9\:n30 \13\:n30) resistor r=0.3467 c=0
Rk35 (\23\:qbint \24\:qbint) resistor r=1.8995 c=0
Rk36 (\24\:qbint \25\:qbint) resistor r=0.2576 c=0
Rk37 (\25\:qbint \26\:qbint) resistor r=0.04668 c=0
Rk38 (\26\:qbint \27\:qbint) resistor r=0.1992 c=0
Rk39 (\24\:qbint \29\:qbint) resistor r=0.08669 c=0
Rk40 (\25\:qbint \30\:qbint) resistor r=0.1728 c=0
Rk41 (\26\:qbint \32\:qbint) resistor r=0.2428 c=0
Rk42 (\16\:qint \17\:qint) resistor r=0.3721 c=0
Rk43 (\17\:qint \18\:qint) resistor r=0.225 c=0
Rk44 (\17\:qint \20\:qint) resistor r=0.1493 c=0
Rl5 (\1\:D \2\:D) resistor r=148.769 c=0
Rl6 (\2\:D \3\:D) resistor r=29.5379 c=0
Rl1 (\1\:CK \2\:CK) resistor r=118.464 c=0
Rl2 (\2\:CK \3\:CK) resistor r=37.6944 c=0
Rl3 (CKb \2\:CKb) resistor r=203.846 c=0
Rl16 (\10\:CKb \11\:CKb) resistor r=81.461 c=0
Rl15 (\8\:CKb \9\:CKb) resistor r=57.6695 c=0
Rl10 (\6\:CKb \7\:CKb) resistor r=42.9995 c=0
Rl7 (\4\:CKb \5\:CKb) resistor r=74.2923 c=0
Rl4 (\2\:CKb \3\:CKb) resistor r=94.9225 c=0
Rl17 (\4\:CKbb \5\:CKbb) resistor r=35.6627 c=0
Rl18 (\5\:CKbb \6\:CKbb) resistor r=199.169 c=0
Rl9 (\2\:CKbb \3\:CKbb) resistor r=29.5379 c=0
Rl8 (CKbb \2\:CKbb) resistor r=209.873 c=0
Rl13 (n20 \2\:n20) resistor r=53.4003 c=0
Rl14 (\2\:n20 \3\:n20) resistor r=141.541 c=0
Rl11 (mout \2\:mout) resistor r=141.541 c=0
Rl12 (\2\:mout \3\:mout) resistor r=66.8618 c=0
Rl56 (\21\:qbint \22\:qbint) resistor r=74.2328 c=0
Rl55 (\21\:qbint \20\:qbint) resistor r=83.2317 c=0
Rl19 (\2\:qbint qbint) resistor r=82.1542 c=0
Rl20 (\2\:qbint \3\:qbint) resistor r=116.817 c=0
Rl21 (\2\:qbint \4\:qbint) resistor r=4.5402 c=0
Rz12 (\14\:VSS \13\:VSS) resistor r=75 c=0
Rz19 (\28\:VSS \27\:VSS) resistor r=75 c=0
Rz20 (\30\:VSS \29\:VSS) resistor r=75 c=0
Rz21 (\2\:VDD \1\:VDD) resistor r=25 c=0
Rz22 (\3\:VDD \1\:VDD) resistor r=6.25 c=0
Rz23 (\11\:VDD \1\:VDD) resistor r=6.25 c=0
Rz3 (\17\:CKb \18\:CKb) resistor r=75 c=0
Rz4 (\10\:CKbb \11\:CKbb) resistor r=75 c=0
Rz1 (\7\:n20 \8\:n20) resistor r=75 c=0
Rz2 (\4\:mout \5\:mout) resistor r=75 c=0
Rz5 (\11\:n30 \10\:n30) resistor r=75 c=0
Rz10 (\29\:qbint \28\:qbint) resistor r=75 c=0
Rz11 (\16\:qint \15\:qint) resistor r=75 c=0
Ry12 (\2\:VSS \1\:VSS) resistor r=20.6667 c=0
Ry13 (\3\:VSS \1\:VSS) resistor r=5.1667 c=0
Ry14 (\11\:VSS \1\:VSS) resistor r=5.1667 c=0
Ry15 (\14\:VDD \13\:VDD) resistor r=62 c=0
Ry23 (\29\:VDD \28\:VDD) resistor r=62 c=0
Ry24 (\31\:VDD \30\:VDD) resistor r=62 c=0
Ry3 (\21\:CKb \22\:CKb) resistor r=62 c=0
Ry4 (\13\:CKbb \14\:CKbb) resistor r=62 c=0
Ry1 (\5\:n20 \6\:n20) resistor r=62 c=0
Ry2 (\7\:mout \8\:mout) resistor r=62 c=0
Ry5 (\13\:n30 \12\:n30) resistor r=62 c=0
Ry10 (\32\:qbint \31\:qbint) resistor r=31 c=0
Ry11 (\20\:qint \19\:qint) resistor r=20.6667 c=0
Rx2 (\2\:D \4\:D) resistor r=45 c=0
Rx1 (\2\:CK \4\:CK) resistor r=45 c=0
Rx5 (\9\:CKb \12\:CKb) resistor r=45 c=0
Rx6 (\4\:CKb \15\:CKb) resistor r=45 c=0
Rx7 (\3\:CKb \16\:CKb) resistor r=45 c=0
Rx8 (\11\:CKb \19\:CKb) resistor r=45 c=0
Rx9 (\7\:CKb \20\:CKb) resistor r=45 c=0
Rx10 (\5\:CKbb \7\:CKbb) resistor r=45 c=0
Rx11 (\2\:CKbb \12\:CKbb) resistor r=45 c=0
Rx3 (\2\:n20 \4\:n20) resistor r=45 c=0
Rx4 (\2\:mout \9\:mout) resistor r=45 c=0
Rx12 (\8\:n30 n30) resistor r=45 c=0
Rx13 (\23\:qbint \21\:qbint) resistor r=45 c=0
Rx14 (\27\:qbint \4\:qbint) resistor r=45 c=0
Rx15 (\30\:qbint \5\:qbint) resistor r=45 c=0
Rx16 (\18\:qint qint) resistor r=45 c=0
mn20 (\17\:CKb \3\:CK \13\:VSS VSS) g45n1lvt w=(1.45e-07) l=4.5e-08 nf=1 \
        as=2.03e-14 ad=2.973e-14 ps=5.7e-07 pd=7e-07 nrd=1.16667 \
        nrs=1.16667 sa=1.4e-07 sb=2.05e-07 sd=160n sca=9.16682 \
        scb=0.00760686 scc=0.000164708 m=(1)
mn21 (\10\:CKbb \2\:CKb \29\:VSS VSS) g45n1lvt w=(1.45e-07) l=4.5e-08 \
        nf=1 as=6.415e-14 ad=2.9e-14 ps=1.8e-06 pd=6.9e-07 nrd=1.16667 \
        nrs=1.16667 sa=2e-07 sb=2e-06 sd=160n sca=23.279 scb=0.0230742 \
        scc=0.00267719 m=(1)
mn25 (n21 \3\:D \29\:VSS VSS) g45n1lvt w=(1.45e-07) l=4.5e-08 nf=1 \
        as=6.415e-14 ad=1.667e-14 ps=1.8e-06 pd=5.2e-07 nrd=1.16667 \
        nrs=1.16667 sa=4.05e-07 sb=2e-06 sd=160n sca=23.279 scb=0.0230742 \
        scc=0.00267719 m=(1)
mn26 (\7\:n20 \5\:CKb n21 VSS) g45n1lvt w=(1.45e-07) l=4.5e-08 nf=1 \
        as=1.667e-14 ad=2.32e-14 ps=5.2e-07 pd=6.1e-07 nrd=1.16667 \
        nrs=1.16667 sa=5.65e-07 sb=2e-06 sd=160n sca=23.279 scb=0.0230742 \
        scc=0.00267719 m=(1)
mn36 (\7\:n20 CKbb n25 VSS) g45n1lvt w=(1.45e-07) l=4.5e-08 nf=1 \
        as=1.015e-14 ad=2.32e-14 ps=4.3e-07 pd=6.1e-07 nrd=1.16667 \
        nrs=1.16667 sa=7.7e-07 sb=2e-06 sd=160n sca=23.279 scb=0.0230742 \
        scc=0.00267719 m=(1)
mn35 (n25 \3\:mout \27\:VSS VSS) g45n1lvt w=(1.45e-07) l=4.5e-08 nf=1 \
        as=8.918e-14 ad=1.015e-14 ps=1.67e-06 pd=4.3e-07 nrd=1.16667 \
        nrs=1.16667 sa=8.85e-07 sb=2e-06 sd=160n sca=23.279 scb=0.0230742 \
        scc=0.00267719 m=(1)
mn30 (\4\:mout \3\:n20 \27\:VSS VSS) g45n1lvt w=(1.45e-07) l=4.5e-08 \
        nf=1 as=8.918e-14 ad=5.147e-14 ps=1.67e-06 pd=1e-06 nrd=1.16667 \
        nrs=1.16667 sa=1.185e-06 sb=2e-06 sd=160n sca=23.279 scb=0.0230742 \
        scc=0.00267719 m=(1)
mn40 (\10\:n30 \6\:CKbb \4\:mout VSS) g45n1lvt w=(1.45e-07) l=4.5e-08 \
        nf=1 as=5.148e-14 ad=2.32e-14 ps=1e-06 pd=6.1e-07 nrd=1.16667 \
        nrs=1.16667 sa=1.585e-06 sb=2e-06 sd=160n sca=23.279 scb=0.0230742 \
        scc=0.00267719 m=(1)
mn51 (\10\:n30 \10\:CKb n35 VSS) g45n1lvt w=(1.45e-07) l=4.5e-08 nf=1 \
        as=8.7e-15 ad=2.32e-14 ps=4.1e-07 pd=6.1e-07 nrd=1.16667 \
        nrs=1.16667 sa=1.79e-06 sb=2e-06 sd=160n sca=23.279 scb=0.0230742 \
        scc=0.00267719 m=(1)
mn50 (n35 \3\:qbint \3\:VSS VSS) g45n1lvt w=(1.45e-07) l=4.5e-08 nf=1 \
        as=5.49e-14 ad=8.7e-15 ps=1.6e-06 pd=4.1e-07 nrd=1.16667 \
        nrs=1.16667 sa=1.895e-06 sb=2e-06 sd=160n sca=23.279 scb=0.0230742 \
        scc=0.00267719 m=(1)
mn45_1__rcx (\28\:qbint n30 \3\:VSS VSS) g45n1lvt w=(2.05e-07) l=4.5e-08 \
        nf=1 as=7.388e-14 ad=3.28e-14 ps=1.6e-06 pd=7.3e-07 nrd=1.16667 \
        nrs=1.16667 sa=1.4439e-06 sb=2e-06 sd=160n sca=19.867 \
        scb=0.0198061 scc=0.00201945 m=(2)
mn56 (\15\:qint \20\:qbint \3\:VSS VSS) g45n1lvt w=(2.6e-07) l=4.5e-08 \
        nf=1 as=7.54e-14 ad=3.64e-14 ps=1.1e-06 pd=8e-07 nrd=1.16667 \
        nrs=1.16667 sa=2e-06 sb=1.4e-07 sd=160n sca=17.5885 scb=0.0172826 \
        scc=0.00162584 m=(1)
mn55_1__rcx (\4\:Q \5\:qbint \3\:VSS VSS) g45n1lvt w=(2.6e-07) l=4.5e-08 \
        nf=1 as=9.491e-14 ad=4.16e-14 ps=1.6e-06 pd=8.4e-07 nrd=1.16667 \
        nrs=1.16667 sa=1.28288e-06 sb=2e-06 sd=160n sca=17.5885 \
        scb=0.0172826 scc=0.00162584 m=(4)
mn57_1__rcx (\1\:QN qint \3\:VSS VSS) g45n1lvt w=(2.6e-07) l=4.5e-08 \
        nf=1 as=9.055e-14 ad=4.355e-14 ps=1.475e-06 pd=8.55e-07 \
        nrd=1.16667 nrs=1.16667 sa=1.69865e-06 sb=1.165e-06 sd=160n \
        sca=17.5885 scb=0.0172826 scc=0.00162584 m=(4)
mp45 (\31\:qbint n30 \3\:VDD VDD) g45p1lvt w=(3.1e-07) l=4.5e-08 nf=1 \
        as=6.213e-14 ad=4.96e-14 ps=1.08e-06 pd=9.4e-07 nrd=1.16667 \
        nrs=1.16667 sa=1.43e-06 sb=2e-06 sd=160n sca=11.3312 \
        scb=0.00941412 scc=0.000228915 m=(2)
mp56 (\19\:qint \22\:qbint \3\:VDD VDD) g45p1lvt w=(3.9e-07) l=4.5e-08 \
        nf=1 as=6.24e-14 ad=5.46e-14 ps=1.1e-06 pd=1.06e-06 nrd=1.16667 \
        nrs=1.16667 sa=1.95487e-06 sb=1.4e-07 sd=160n sca=15.1531 \
        scb=0.0133339 scc=0.000649799 m=(1)
mp57 (\5\:QN qint \3\:VDD VDD) g45p1lvt w=(3.9e-07) l=4.5e-08 nf=1 \
        as=6.24e-14 ad=6.24e-14 ps=1.1e-06 pd=1.1e-06 nrd=1.16667 \
        nrs=1.16667 sa=1.64051e-06 sb=9.6e-07 sd=160n sca=13.5671 \
        scb=0.012183 scc=0.000647513 m=(4)
mp55_1__rcx (\1\:Q \5\:qbint \3\:VDD VDD) g45p1lvt w=(3.9e-07) l=4.5e-08 \
        nf=1 as=6.433e-14 ad=6.24e-14 ps=1.115e-06 pd=1.1e-06 nrd=1.16667 \
        nrs=1.16667 sa=1.27256e-06 sb=1.78e-06 sd=160n sca=13.5671 \
        scb=0.012183 scc=0.000647513 m=(4)
ends DFFX4
// End of subcircuit definition.
