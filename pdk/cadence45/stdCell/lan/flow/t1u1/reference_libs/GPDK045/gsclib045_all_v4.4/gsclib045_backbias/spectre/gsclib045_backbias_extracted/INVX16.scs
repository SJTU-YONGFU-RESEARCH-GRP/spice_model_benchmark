// Generated for: spectre (May  1 11:29:36 2013 )
// Library name: gsclib045_backbias
// Cell name: INVX16
// View name: extracted

simulator lang=spectre

subckt INVX16 A NW VDD VSS Y
mp0 (\1\:Y \1\:A VDD NW) g45p1svt w=(4.45e-07) l=4.5e-08 nf=1 \
        as=6.993e-14 ad=7.12e-14 ps=1.20429e-06 pd=1.21e-06 nrd=1.16667 \
        nrs=1.16667 sa=1.4e-07 sb=2e-06 sd=160n sca=41.6034 scb=0.0375368 \
        scc=0.00435732 m=(14)
C1 (A VSS) capacitor c=2.14865e-17
C2 (VDD VSS) capacitor c=8.78975e-16
C3 (NW VSS) capacitor c=3.50224e-16
C4 (Y VSS) capacitor c=3.21758e-17
C5 (\1\:A VSS) capacitor c=1.24325e-15
C6 (\22\:A VSS) capacitor c=2.29307e-17
C7 (\1\:Y VSS) capacitor c=9.08505e-16
C8 (\56\:A VSS) capacitor c=4.26718e-17
C9 (\4\:Y VSS) capacitor c=1.30412e-17
C10 (\5\:Y VSS) capacitor c=7.24622e-16
Rk7 (\56\:A A) resistor r=0.01623 c=0
Rk6 (\1\:A \56\:A) resistor r=0.29 c=0
Rk23 (\4\:Y Y) resistor r=0.1123 c=0
Rk9 (\1\:Y \4\:Y) resistor r=0.1594 c=0
Rk10 (\4\:Y \5\:Y) resistor r=0.07507 c=0
Rl21 (\1\:A \22\:A) resistor r=3.1164 c=0
Rx7 (\56\:A \22\:A) resistor r=45 c=0
mn0 (\5\:Y \1\:A VSS VSS) g45n1svt w=(2.95e-07) l=4.5e-08 nf=1 \
        as=4.636e-14 ad=4.72e-14 ps=9.0429e-07 pd=9.1e-07 nrd=1.16667 \
        nrs=1.16667 sa=1.4e-07 sb=2e-06 sd=160n sca=16.4223 scb=0.0158966 \
        scc=0.0014413 m=(14)
ends INVX16
// End of subcircuit definition.
