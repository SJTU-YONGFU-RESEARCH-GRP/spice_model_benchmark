// Generated for: spectre (May  1 08:13:10 2013 )
// Library name: gsclib045
// Cell name: SDFF4RX1
// View name: extracted

simulator lang=spectre

subckt SDFF4RX1 CK D1 D2 D3 D4 Q1 Q1N Q2 Q2N Q3 Q3N Q4 Q4N RN SE SI VDD \
        VSS
mp57 (\3\:Q1N \4\:qint \93\:VDD VDD) g45p1svt w=(3.9e-07) l=4.5e-08 nf=1 \
        as=9.842e-14 ad=5.46e-14 ps=1.97e-06 pd=1.06e-06 nrd=1.16667 \
        nrs=1.16667 sa=1.4e-07 sb=2.49744e-07 sd=160n sca=41.7168 \
        scb=0.0364245 scc=0.00429626 m=(1)
mp55 (\7\:Q1 qbint \90\:VDD VDD) g45p1svt w=(3.9e-07) l=4.5e-08 nf=1 \
        as=1.4115e-13 ad=8.385e-14 ps=2.12e-06 pd=1.59e-06 nrd=1.16667 \
        nrs=1.16667 sa=1.4e-07 sb=1.17795e-06 sd=160n sca=30.6824 \
        scb=0.0202434 scc=0.00336098 m=(1)
PM17 (\5\:Q2 \10\:qbint_2 \54\:VDD VDD) g45p1svt w=(3.9e-07) l=4.5e-08 \
        nf=1 as=1.4115e-13 ad=8.385e-14 ps=2.12e-06 pd=1.59e-06 \
        nrd=1.16667 nrs=1.16667 sa=1.17795e-06 sb=1.4e-07 sd=160n \
        sca=30.5009 scb=0.0202006 scc=0.00336097 m=(1)
PM19 (\3\:Q2N qint_2 \51\:VDD VDD) g45p1svt w=(3.9e-07) l=4.5e-08 nf=1 \
        as=9.843e-14 ad=5.46e-14 ps=1.97e-06 pd=1.06e-06 nrd=1.16667 \
        nrs=1.16667 sa=2.49744e-07 sb=1.4e-07 sd=160n sca=30.5009 \
        scb=0.0202006 scc=0.00336097 m=(1)
PM35 (\5\:Q3 \10\:qbint_3 \28\:VDD VDD) g45p1svt w=(3.9e-07) l=4.5e-08 \
        nf=1 as=1.4115e-13 ad=8.385e-14 ps=2.12e-06 pd=1.59e-06 \
        nrd=1.16667 nrs=1.16667 sa=1.17795e-06 sb=1.4e-07 sd=160n \
        sca=30.5009 scb=0.0202006 scc=0.00336097 m=(1)
PM37 (\3\:Q3N qint_3 \25\:VDD VDD) g45p1svt w=(3.9e-07) l=4.5e-08 nf=1 \
        as=9.843e-14 ad=5.46e-14 ps=1.97e-06 pd=1.06e-06 nrd=1.16667 \
        nrs=1.16667 sa=2.49744e-07 sb=1.4e-07 sd=160n sca=30.5009 \
        scb=0.0202006 scc=0.00336097 m=(1)
PM40 (\1\:Q4 \10\:qbint_4 \9\:VDD VDD) g45p1svt w=(3.9e-07) l=4.5e-08 \
        nf=1 as=1.4115e-13 ad=8.385e-14 ps=2.12e-06 pd=1.59e-06 \
        nrd=1.16667 nrs=1.16667 sa=1.17795e-06 sb=1.4e-07 sd=160n \
        sca=30.6824 scb=0.0202434 scc=0.00336098 m=(1)
PM38 (\3\:Q4N qint_4 \1\:VDD VDD) g45p1svt w=(3.9e-07) l=4.5e-08 nf=1 \
        as=9.843e-14 ad=5.46e-14 ps=1.97e-06 pd=1.06e-06 nrd=1.16667 \
        nrs=1.16667 sa=2.49744e-07 sb=1.4e-07 sd=160n sca=41.7168 \
        scb=0.0364245 scc=0.00429626 m=(1)
C1 (CK VSS) capacitor c=4.61857e-17
C2 (VDD VSS) capacitor c=1.79367e-15
C3 (SE VSS) capacitor c=2.71219e-17
C4 (RN VSS) capacitor c=2.69774e-17
C5 (Q1 VSS) capacitor c=5.49206e-17
C6 (Q1N VSS) capacitor c=1.93086e-17
C7 (D1 VSS) capacitor c=2.01013e-17
C8 (Q2 VSS) capacitor c=5.51178e-17
C9 (Q2N VSS) capacitor c=2.46099e-17
C10 (D2 VSS) capacitor c=2.06955e-17
C11 (Q3 VSS) capacitor c=5.44739e-17
C12 (Q3N VSS) capacitor c=2.56487e-17
C13 (D3 VSS) capacitor c=2.06955e-17
C14 (Q4N VSS) capacitor c=1.93507e-17
C15 (Q4 VSS) capacitor c=5.44007e-17
C16 (D4 VSS) capacitor c=2.06955e-17
C17 (CKb VSS) capacitor c=3.43291e-17
C18 (Ckbb VSS) capacitor c=2.20379e-17
C19 (Db VSS) capacitor c=4.99688e-17
C20 (qint VSS) capacitor c=2.28111e-17
C21 (n8 VSS) capacitor c=1.80574e-18
C22 (n6 VSS) capacitor c=6.69321e-17
C23 (SEb VSS) capacitor c=4.41333e-17
C24 (qbint VSS) capacitor c=4.50804e-17
C25 (n20 VSS) capacitor c=2.55525e-17
C26 (n30 VSS) capacitor c=3.62459e-17
C27 (mout VSS) capacitor c=5.23033e-17
C28 (n2 VSS) capacitor c=3.96884e-18
C29 (n4 VSS) capacitor c=1.50247e-18
C30 (n9 VSS) capacitor c=5.88253e-19
C31 (n11 VSS) capacitor c=3.08479e-18
C32 (n5 VSS) capacitor c=2.3104e-19
C33 (n1 VSS) capacitor c=2.88673e-18
C34 (Db_2 VSS) capacitor c=1.0205e-16
C35 (qint_2 VSS) capacitor c=5.99788e-17
C36 (n8_2 VSS) capacitor c=1.80578e-18
C37 (n6_2 VSS) capacitor c=7.45521e-17
C38 (SEb_2 VSS) capacitor c=5.67986e-17
C39 (qbint_2 VSS) capacitor c=4.73296e-17
C40 (n20_2 VSS) capacitor c=4.67252e-17
C41 (n30_2 VSS) capacitor c=4.67921e-17
C42 (mout_2 VSS) capacitor c=5.25831e-17
C43 (n2_2 VSS) capacitor c=3.95036e-18
C44 (n4_2 VSS) capacitor c=1.50247e-18
C45 (n9_2 VSS) capacitor c=5.52712e-19
C46 (n11_2 VSS) capacitor c=3.08479e-18
C47 (n5_2 VSS) capacitor c=2.3104e-19
C48 (n1_2 VSS) capacitor c=2.88673e-18
C49 (Db_3 VSS) capacitor c=1.0205e-16
C50 (qint_3 VSS) capacitor c=5.91883e-17
C51 (n8_3 VSS) capacitor c=1.80578e-18
C52 (n6_3 VSS) capacitor c=7.45521e-17
C53 (SEb_3 VSS) capacitor c=5.68111e-17
C54 (qbint_3 VSS) capacitor c=4.73296e-17
C55 (n20_3 VSS) capacitor c=4.67252e-17
C56 (n30_3 VSS) capacitor c=4.67921e-17
C57 (mout_3 VSS) capacitor c=5.25831e-17
C58 (n2_3 VSS) capacitor c=3.95036e-18
C59 (n4_3 VSS) capacitor c=1.50783e-18
C60 (n9_3 VSS) capacitor c=5.52712e-19
C61 (n11_3 VSS) capacitor c=3.08479e-18
C62 (n5_3 VSS) capacitor c=2.3104e-19
C63 (n1_3 VSS) capacitor c=2.88673e-18
C64 (Db_4 VSS) capacitor c=1.02018e-16
C65 (qint_4 VSS) capacitor c=5.13236e-17
C66 (n8_4 VSS) capacitor c=1.80578e-18
C67 (n6_4 VSS) capacitor c=7.45521e-17
C68 (SEb_4 VSS) capacitor c=5.68047e-17
C69 (qbint_4 VSS) capacitor c=4.73255e-17
C70 (n20_4 VSS) capacitor c=4.67239e-17
C71 (n30_4 VSS) capacitor c=4.67906e-17
C72 (mout_4 VSS) capacitor c=5.25818e-17
C73 (n2_4 VSS) capacitor c=3.95036e-18
C74 (n4_4 VSS) capacitor c=1.50247e-18
C75 (n9_4 VSS) capacitor c=5.52712e-19
C76 (n11_4 VSS) capacitor c=3.08479e-18
C77 (n5_4 VSS) capacitor c=2.3104e-19
C78 (n1_4 VSS) capacitor c=2.88673e-18
C79 (\4\:qbint_4 VSS) capacitor c=3.79729e-17
C80 (\10\:qbint_4 VSS) capacitor c=4.54503e-17
C81 (\27\:RN VSS) capacitor c=3.04484e-17
C82 (\30\:Ckbb VSS) capacitor c=7.65216e-17
C83 (\29\:CKb VSS) capacitor c=2.87167e-17
C84 (\23\:RN VSS) capacitor c=6.5104e-17
C85 (\27\:CKb VSS) capacitor c=3.75016e-17
C86 (\26\:Ckbb VSS) capacitor c=9.09094e-17
C87 (\1\:D4 VSS) capacitor c=4.76465e-17
C88 (\27\:SE VSS) capacitor c=4.14954e-17
C89 (\3\:SEb_4 VSS) capacitor c=4.28165e-17
C90 (\3\:Q3 VSS) capacitor c=4.93823e-17
C91 (\22\:SE VSS) capacitor c=4.63196e-17
C92 (\4\:qbint_3 VSS) capacitor c=3.75963e-17
C93 (\10\:qbint_3 VSS) capacitor c=4.52809e-17
C94 (\20\:RN VSS) capacitor c=3.04484e-17
C95 (\19\:Ckbb VSS) capacitor c=7.49483e-17
C96 (\22\:CKb VSS) capacitor c=2.87259e-17
C97 (\16\:RN VSS) capacitor c=6.5104e-17
C98 (\20\:CKb VSS) capacitor c=3.75016e-17
C99 (\15\:Ckbb VSS) capacitor c=9.09164e-17
C100 (\1\:D3 VSS) capacitor c=4.76487e-17
C101 (\20\:SE VSS) capacitor c=4.14555e-17
C102 (\3\:SEb_3 VSS) capacitor c=4.28533e-17
C103 (\3\:Q2 VSS) capacitor c=4.94017e-17
C104 (\15\:SE VSS) capacitor c=4.46444e-17
C105 (\15\:CKb VSS) capacitor c=3.57999e-17
C106 (\1\:CK VSS) capacitor c=4.10322e-17
C107 (\4\:qbint_2 VSS) capacitor c=3.77252e-17
C108 (\10\:qbint_2 VSS) capacitor c=4.53909e-17
C109 (\13\:RN VSS) capacitor c=3.04484e-17
C110 (\12\:Ckbb VSS) capacitor c=7.49483e-17
C111 (\11\:CKb VSS) capacitor c=2.87259e-17
C112 (\9\:RN VSS) capacitor c=6.5104e-17
C113 (\9\:CKb VSS) capacitor c=3.75016e-17
C114 (\8\:Ckbb VSS) capacitor c=9.09133e-17
C115 (\1\:D2 VSS) capacitor c=4.76367e-17
C116 (\13\:SE VSS) capacitor c=4.07216e-17
C117 (\3\:SEb_2 VSS) capacitor c=4.27191e-17
C118 (\3\:Q1 VSS) capacitor c=4.92079e-17
C119 (\8\:SE VSS) capacitor c=4.11974e-17
C120 (\5\:SE VSS) capacitor c=3.94154e-17
C121 (\3\:SI VSS) capacitor c=8.22013e-17
C122 (\1\:SE VSS) capacitor c=4.2271e-17
C123 (\1\:D1 VSS) capacitor c=4.67535e-17
C124 (\6\:Ckbb VSS) capacitor c=9.02335e-17
C125 (\6\:CKb VSS) capacitor c=3.66746e-17
C126 (\6\:RN VSS) capacitor c=6.54428e-17
C127 (\4\:n20 VSS) capacitor c=4.61513e-17
C128 (\3\:CKb VSS) capacitor c=2.85099e-17
C129 (\3\:Ckbb VSS) capacitor c=7.66837e-17
C130 (\8\:qbint VSS) capacitor c=4.83027e-17
C131 (\3\:RN VSS) capacitor c=3.05845e-17
C132 (\3\:n30 VSS) capacitor c=4.5414e-17
C133 (\7\:qbint VSS) capacitor c=3.74527e-17
C134 (\4\:qint VSS) capacitor c=5.02807e-17
C135 (\4\:qint_4 VSS) capacitor c=3.98003e-17
C136 (\8\:qbint_4 VSS) capacitor c=3.52813e-17
C137 (\9\:qbint_4 VSS) capacitor c=3.13044e-17
C138 (\3\:n30_4 VSS) capacitor c=3.69005e-17
C139 (\25\:RN VSS) capacitor c=4.43685e-17
C140 (\3\:qbint_4 VSS) capacitor c=3.89788e-17
C141 (\31\:CKb VSS) capacitor c=3.408e-17
C142 (\31\:Ckbb VSS) capacitor c=6.02149e-17
C143 (\4\:n20_4 VSS) capacitor c=4.02749e-17
C144 (\24\:RN VSS) capacitor c=8.26834e-17
C145 (\3\:mout_4 VSS) capacitor c=4.93331e-17
C146 (\28\:Ckbb VSS) capacitor c=5.79095e-17
C147 (\26\:CKb VSS) capacitor c=5.7991e-17
C148 (\3\:D4 VSS) capacitor c=4.06457e-17
C149 (\25\:SE VSS) capacitor c=4.33001e-17
C150 (\1\:Q3 VSS) capacitor c=5.63886e-17
C151 (\24\:SE VSS) capacitor c=4.0499e-17
C152 (\4\:qint_3 VSS) capacitor c=4.57569e-17
C153 (\8\:qbint_3 VSS) capacitor c=3.51275e-17
C154 (\9\:qbint_3 VSS) capacitor c=3.13391e-17
C155 (\3\:n30_3 VSS) capacitor c=3.69005e-17
C156 (\18\:RN VSS) capacitor c=4.43684e-17
C157 (\3\:qbint_3 VSS) capacitor c=3.89788e-17
C158 (\24\:CKb VSS) capacitor c=3.408e-17
C159 (\20\:Ckbb VSS) capacitor c=6.02151e-17
C160 (\4\:n20_3 VSS) capacitor c=4.02749e-17
C161 (\17\:RN VSS) capacitor c=8.28546e-17
C162 (\3\:mout_3 VSS) capacitor c=4.93331e-17
C163 (\17\:Ckbb VSS) capacitor c=5.79106e-17
C164 (\19\:CKb VSS) capacitor c=5.7991e-17
C165 (\3\:D3 VSS) capacitor c=4.06457e-17
C166 (\18\:SE VSS) capacitor c=4.345e-17
C167 (\1\:Q2 VSS) capacitor c=5.68693e-17
C168 (\17\:SE VSS) capacitor c=4.05079e-17
C169 (\18\:CKb VSS) capacitor c=3.11795e-17
C170 (\3\:CK VSS) capacitor c=4.31576e-17
C171 (\4\:qint_2 VSS) capacitor c=4.63791e-17
C172 (\8\:qbint_2 VSS) capacitor c=3.51589e-17
C173 (\9\:qbint_2 VSS) capacitor c=3.12922e-17
C174 (\3\:n30_2 VSS) capacitor c=3.69005e-17
C175 (\11\:RN VSS) capacitor c=4.43685e-17
C176 (\3\:qbint_2 VSS) capacitor c=3.89788e-17
C177 (\13\:CKb VSS) capacitor c=3.408e-17
C178 (\13\:Ckbb VSS) capacitor c=6.02151e-17
C179 (\4\:n20_2 VSS) capacitor c=4.02749e-17
C180 (\10\:RN VSS) capacitor c=8.28571e-17
C181 (\3\:mout_2 VSS) capacitor c=4.93331e-17
C182 (\10\:Ckbb VSS) capacitor c=5.79106e-17
C183 (\8\:CKb VSS) capacitor c=5.7991e-17
C184 (\3\:D2 VSS) capacitor c=4.06457e-17
C185 (\11\:SE VSS) capacitor c=4.345e-17
C186 (\1\:Q1 VSS) capacitor c=5.54607e-17
C187 (\10\:SE VSS) capacitor c=3.60258e-17
C188 (\7\:SE VSS) capacitor c=3.58217e-17
C189 (\1\:SI VSS) capacitor c=5.53716e-17
C190 (\3\:SE VSS) capacitor c=4.33001e-17
C191 (\3\:SEb VSS) capacitor c=5.72182e-17
C192 (\3\:D1 VSS) capacitor c=4.06724e-17
C193 (\7\:CKb VSS) capacitor c=5.81133e-17
C194 (\4\:Ckbb VSS) capacitor c=5.79348e-17
C195 (\3\:mout VSS) capacitor c=4.93391e-17
C196 (\5\:RN VSS) capacitor c=8.27341e-17
C197 (\3\:n20 VSS) capacitor c=3.9835e-17
C198 (\2\:Ckbb VSS) capacitor c=6.03049e-17
C199 (\10\:qbint VSS) capacitor c=3.89788e-17
C200 (\1\:RN VSS) capacitor c=4.41774e-17
C201 (\5\:qbint VSS) capacitor c=3.10294e-17
C202 (\4\:qbint VSS) capacitor c=3.52782e-17
C203 (\3\:qint VSS) capacitor c=3.97302e-17
C204 (\3\:qint_4 VSS) capacitor c=2.26454e-17
C205 (\7\:qbint_4 VSS) capacitor c=2.50167e-17
C206 (\2\:n30_4 VSS) capacitor c=4.35846e-17
C207 (\28\:RN VSS) capacitor c=3.13513e-17
C208 (\26\:RN VSS) capacitor c=1.37805e-16
C209 (\2\:qbint_4 VSS) capacitor c=4.34768e-17
C210 (\32\:CKb VSS) capacitor c=5.05401e-17
C211 (\32\:Ckbb VSS) capacitor c=2.20733e-17
C212 (\30\:CKb VSS) capacitor c=3.93207e-17
C213 (\3\:n20_4 VSS) capacitor c=2.51719e-17
C214 (\22\:RN VSS) capacitor c=2.95242e-17
C215 (\2\:mout_4 VSS) capacitor c=4.88217e-17
C216 (\29\:Ckbb VSS) capacitor c=2.1772e-17
C217 (\28\:CKb VSS) capacitor c=4.08666e-17
C218 (\27\:Ckbb VSS) capacitor c=4.46129e-17
C219 (\2\:D4 VSS) capacitor c=3.65531e-17
C220 (\28\:SE VSS) capacitor c=5.0578e-17
C221 (\2\:SEb_4 VSS) capacitor c=7.66707e-17
C222 (\26\:SE VSS) capacitor c=5.01802e-17
C223 (\4\:Q3 VSS) capacitor c=3.08853e-17
C224 (\2\:Q3 VSS) capacitor c=1.21707e-16
C225 (\23\:SE VSS) capacitor c=2.71076e-17
C226 (\3\:qint_3 VSS) capacitor c=2.26253e-17
C227 (\7\:qbint_3 VSS) capacitor c=2.49926e-17
C228 (\2\:n30_3 VSS) capacitor c=4.3585e-17
C229 (\21\:RN VSS) capacitor c=3.29225e-17
C230 (\19\:RN VSS) capacitor c=1.37851e-16
C231 (\2\:qbint_3 VSS) capacitor c=4.34772e-17
C232 (\25\:CKb VSS) capacitor c=5.04884e-17
C233 (\21\:Ckbb VSS) capacitor c=2.20733e-17
C234 (\23\:CKb VSS) capacitor c=3.9321e-17
C235 (\3\:n20_3 VSS) capacitor c=2.5172e-17
C236 (\15\:RN VSS) capacitor c=3.10721e-17
C237 (\2\:mout_3 VSS) capacitor c=4.88218e-17
C238 (\18\:Ckbb VSS) capacitor c=2.17721e-17
C239 (\21\:CKb VSS) capacitor c=4.08722e-17
C240 (\16\:Ckbb VSS) capacitor c=4.46196e-17
C241 (\2\:D3 VSS) capacitor c=3.65598e-17
C242 (\21\:SE VSS) capacitor c=5.05859e-17
C243 (\2\:SEb_3 VSS) capacitor c=7.66847e-17
C244 (\19\:SE VSS) capacitor c=5.01973e-17
C245 (\4\:Q2 VSS) capacitor c=3.02519e-17
C246 (\2\:Q2 VSS) capacitor c=1.21272e-16
C247 (\16\:SE VSS) capacitor c=2.69171e-17
C248 (\17\:CKb VSS) capacitor c=1.98856e-17
C249 (\2\:CK VSS) capacitor c=3.27848e-17
C250 (\3\:qint_2 VSS) capacitor c=2.26128e-17
C251 (\7\:qbint_2 VSS) capacitor c=2.50833e-17
C252 (\2\:n30_2 VSS) capacitor c=4.3585e-17
C253 (\14\:RN VSS) capacitor c=3.29225e-17
C254 (\12\:RN VSS) capacitor c=1.37851e-16
C255 (\2\:qbint_2 VSS) capacitor c=4.34772e-17
C256 (\14\:CKb VSS) capacitor c=5.04884e-17
C257 (\14\:Ckbb VSS) capacitor c=2.19942e-17
C258 (\12\:CKb VSS) capacitor c=3.92475e-17
C259 (\3\:n20_2 VSS) capacitor c=2.5172e-17
C260 (\8\:RN VSS) capacitor c=3.04136e-17
C261 (\2\:mout_2 VSS) capacitor c=4.88218e-17
C262 (\11\:Ckbb VSS) capacitor c=2.17721e-17
C263 (\10\:CKb VSS) capacitor c=4.08722e-17
C264 (\9\:Ckbb VSS) capacitor c=4.46131e-17
C265 (\2\:D2 VSS) capacitor c=3.65532e-17
C266 (\14\:SE VSS) capacitor c=5.0578e-17
C267 (\2\:SEb_2 VSS) capacitor c=7.65422e-17
C268 (\12\:SE VSS) capacitor c=5.02053e-17
C269 (\4\:Q1 VSS) capacitor c=3.0692e-17
C270 (\2\:Q1 VSS) capacitor c=1.21383e-16
C271 (\9\:SE VSS) capacitor c=2.31299e-17
C272 (\6\:SE VSS) capacitor c=2.31176e-17
C273 (\2\:SI VSS) capacitor c=4.8943e-17
C274 (\4\:SE VSS) capacitor c=5.02421e-17
C275 (\2\:SEb VSS) capacitor c=7.61091e-17
C276 (\2\:SE VSS) capacitor c=5.06267e-17
C277 (\2\:D1 VSS) capacitor c=3.65363e-17
C278 (\7\:Ckbb VSS) capacitor c=4.45382e-17
C279 (\5\:CKb VSS) capacitor c=4.08331e-17
C280 (\5\:Ckbb VSS) capacitor c=2.17721e-17
C281 (\2\:mout VSS) capacitor c=4.88186e-17
C282 (\7\:RN VSS) capacitor c=3.11841e-17
C283 (\4\:CKb VSS) capacitor c=3.98237e-17
C284 (\2\:CKb VSS) capacitor c=5.05461e-17
C285 (\9\:qbint VSS) capacitor c=4.34931e-17
C286 (\2\:RN VSS) capacitor c=1.37921e-16
C287 (\4\:RN VSS) capacitor c=3.28818e-17
C288 (\2\:n30 VSS) capacitor c=4.36333e-17
C289 (\3\:Q4N VSS) capacitor c=6.9034e-17
C290 (\1\:VDD VSS) capacitor c=3.96886e-17
C291 (\9\:qint_4 VSS) capacitor c=3.17617e-17
C292 (\1\:Q4 VSS) capacitor c=6.1597e-17
C293 (\9\:VDD VSS) capacitor c=2.46881e-17
C294 (\13\:qbint_4 VSS) capacitor c=1.24252e-16
C295 (\11\:VDD VSS) capacitor c=2.60762e-17
C296 (\4\:n30_4 VSS) capacitor c=8.5557e-17
C297 (\4\:mout_4 VSS) capacitor c=5.58256e-17
C298 (\13\:VDD VSS) capacitor c=1.95144e-17
C299 (\15\:VDD VSS) capacitor c=2.16059e-17
C300 (\3\:n6_4 VSS) capacitor c=6.71637e-17
C301 (\7\:n20_4 VSS) capacitor c=6.84192e-17
C302 (\4\:Db_4 VSS) capacitor c=8.95927e-17
C303 (\18\:VDD VSS) capacitor c=1.93155e-17
C304 (\6\:Db_4 VSS) capacitor c=5.04213e-17
C305 (\21\:VDD VSS) capacitor c=3.73311e-17
C306 (\5\:SEb_4 VSS) capacitor c=1.09118e-16
C307 (\3\:Q3N VSS) capacitor c=6.69327e-17
C308 (\25\:VDD VSS) capacitor c=3.34191e-17
C309 (\9\:qint_3 VSS) capacitor c=3.18868e-17
C310 (\5\:Q3 VSS) capacitor c=1.01829e-15
C311 (\28\:VDD VSS) capacitor c=3.77162e-17
C312 (\13\:qbint_3 VSS) capacitor c=1.24252e-16
C313 (\31\:VDD VSS) capacitor c=3.91044e-17
C314 (\4\:n30_3 VSS) capacitor c=8.53581e-17
C315 (\4\:mout_3 VSS) capacitor c=5.58256e-17
C316 (\34\:VDD VSS) capacitor c=3.25426e-17
C317 (\38\:VDD VSS) capacitor c=3.46259e-17
C318 (\3\:n6_3 VSS) capacitor c=6.71637e-17
C319 (\7\:n20_3 VSS) capacitor c=6.84192e-17
C320 (\4\:Db_3 VSS) capacitor c=8.95927e-17
C321 (\41\:VDD VSS) capacitor c=3.03372e-17
C322 (\6\:Db_3 VSS) capacitor c=5.04003e-17
C323 (\44\:VDD VSS) capacitor c=3.73606e-17
C324 (\5\:SEb_3 VSS) capacitor c=1.08476e-16
C325 (\24\:Ckbb VSS) capacitor c=1.19543e-16
C326 (\48\:VDD VSS) capacitor c=3.60854e-17
C327 (\56\:CKb VSS) capacitor c=3.44359e-17
C328 (\3\:Q2N VSS) capacitor c=6.47398e-17
C329 (\51\:VDD VSS) capacitor c=3.34215e-17
C330 (\9\:qint_2 VSS) capacitor c=3.18809e-17
C331 (\5\:Q2 VSS) capacitor c=1.10274e-15
C332 (\54\:VDD VSS) capacitor c=3.77162e-17
C333 (\13\:qbint_2 VSS) capacitor c=1.24252e-16
C334 (\57\:VDD VSS) capacitor c=3.91044e-17
C335 (\4\:n30_2 VSS) capacitor c=8.53581e-17
C336 (\4\:mout_2 VSS) capacitor c=5.58256e-17
C337 (\60\:VDD VSS) capacitor c=3.25426e-17
C338 (\63\:VDD VSS) capacitor c=3.46259e-17
C339 (\3\:n6_2 VSS) capacitor c=6.71637e-17
C340 (\7\:n20_2 VSS) capacitor c=6.84192e-17
C341 (\4\:Db_2 VSS) capacitor c=8.95927e-17
C342 (\66\:VDD VSS) capacitor c=3.03902e-17
C343 (\6\:Db_2 VSS) capacitor c=5.02026e-17
C344 (\70\:VDD VSS) capacitor c=3.73606e-17
C345 (\5\:SEb_2 VSS) capacitor c=1.08564e-16
C346 (\6\:SEb VSS) capacitor c=1.07812e-16
C347 (\73\:VDD VSS) capacitor c=3.73606e-17
C348 (\76\:VDD VSS) capacitor c=3.52036e-17
C349 (\4\:Db VSS) capacitor c=8.90383e-17
C350 (\5\:n20 VSS) capacitor c=6.85912e-17
C351 (\80\:VDD VSS) capacitor c=3.45501e-17
C352 (\3\:n6 VSS) capacitor c=7.53324e-17
C353 (\83\:VDD VSS) capacitor c=3.25329e-17
C354 (\8\:mout VSS) capacitor c=5.57457e-17
C355 (\4\:n30 VSS) capacitor c=8.5642e-17
C356 (\86\:VDD VSS) capacitor c=3.91119e-17
C357 (\12\:qbint VSS) capacitor c=1.23899e-16
C358 (\90\:VDD VSS) capacitor c=3.7707e-17
C359 (\7\:Q1 VSS) capacitor c=8.61568e-16
C360 (\5\:qint VSS) capacitor c=3.27792e-17
C361 (\93\:VDD VSS) capacitor c=3.34145e-17
C362 (\3\:Q1N VSS) capacitor c=6.90288e-17
C363 (\3\:VDD VSS) capacitor c=2.24488e-16
C364 (\1\:Q4N VSS) capacitor c=3.11786e-17
C365 (\7\:qint_4 VSS) capacitor c=3.33266e-17
C366 (\3\:Q4 VSS) capacitor c=3.66766e-17
C367 (\16\:qbint_4 VSS) capacitor c=4.64187e-17
C368 (\6\:n30_4 VSS) capacitor c=1.40764e-16
C369 (\8\:mout_4 VSS) capacitor c=2.98993e-17
C370 (\9\:n20_4 VSS) capacitor c=4.63252e-17
C371 (\8\:Db_4 VSS) capacitor c=7.29954e-17
C372 (\7\:SEb_4 VSS) capacitor c=8.42679e-17
C373 (\1\:Q3N VSS) capacitor c=2.74737e-17
C374 (\7\:qint_3 VSS) capacitor c=3.34671e-17
C375 (\7\:Q3 VSS) capacitor c=3.66766e-17
C376 (\16\:qbint_3 VSS) capacitor c=4.63356e-17
C377 (\6\:n30_3 VSS) capacitor c=1.40636e-16
C378 (\8\:mout_3 VSS) capacitor c=2.98993e-17
C379 (\9\:n20_3 VSS) capacitor c=4.63252e-17
C380 (\8\:Db_3 VSS) capacitor c=7.29954e-17
C381 (\7\:SEb_3 VSS) capacitor c=7.93915e-17
C382 (\22\:Ckbb VSS) capacitor c=6.14112e-16
C383 (\51\:CKb VSS) capacitor c=5.92461e-17
C384 (\1\:Q2N VSS) capacitor c=3.04712e-17
C385 (\7\:qint_2 VSS) capacitor c=3.34703e-17
C386 (\7\:Q2 VSS) capacitor c=3.71702e-17
C387 (\16\:qbint_2 VSS) capacitor c=4.63535e-17
C388 (\6\:n30_2 VSS) capacitor c=1.40764e-16
C389 (\8\:mout_2 VSS) capacitor c=2.98993e-17
C390 (\9\:n20_2 VSS) capacitor c=4.63252e-17
C391 (\8\:Db_2 VSS) capacitor c=7.29954e-17
C392 (\7\:SEb_2 VSS) capacitor c=7.60513e-17
C393 (\4\:SEb VSS) capacitor c=7.59193e-17
C394 (\6\:Db VSS) capacitor c=1.02253e-16
C395 (\8\:Db VSS) capacitor c=7.32531e-17
C396 (\9\:n20 VSS) capacitor c=4.63434e-17
C397 (\6\:mout VSS) capacitor c=2.99257e-17
C398 (\6\:n30 VSS) capacitor c=1.42261e-16
C399 (\16\:qbint VSS) capacitor c=4.63395e-17
C400 (\5\:Q1 VSS) capacitor c=3.61217e-17
C401 (\9\:qint VSS) capacitor c=3.33285e-17
C402 (\1\:Q1N VSS) capacitor c=3.11786e-17
C403 (\2\:qint VSS) capacitor c=7.48686e-18
C404 (\2\:qbint VSS) capacitor c=2.51493e-17
C405 (\3\:qbint VSS) capacitor c=3.8211e-17
C406 (\2\:n20 VSS) capacitor c=2.37037e-17
C407 (\7\:qint VSS) capacitor c=3.65951e-17
C408 (\8\:qint VSS) capacitor c=2.41624e-17
C409 (\11\:qbint VSS) capacitor c=9.55968e-17
C410 (\14\:qbint VSS) capacitor c=4.86677e-17
C411 (\15\:qbint VSS) capacitor c=2.06459e-17
C412 (\8\:n30 VSS) capacitor c=1.32574e-16
C413 (\2\:n20_2 VSS) capacitor c=2.31147e-17
C414 (\4\:mout VSS) capacitor c=7.80696e-17
C415 (\5\:mout VSS) capacitor c=7.28305e-17
C416 (\7\:n20 VSS) capacitor c=9.92707e-17
C417 (\8\:n20 VSS) capacitor c=1.02547e-16
C418 (\4\:D1 VSS) capacitor c=5.2223e-17
C419 (\3\:Db VSS) capacitor c=1.03757e-16
C420 (\4\:SI VSS) capacitor c=3.03371e-17
C421 (\6\:SI VSS) capacitor c=4.21993e-17
C422 (\5\:qbint_2 VSS) capacitor c=3.74778e-17
C423 (\8\:SEb VSS) capacitor c=9.2279e-17
C424 (\2\:qint_2 VSS) capacitor c=8.12457e-18
C425 (\9\:Q1 VSS) capacitor c=6.27936e-16
C426 (\4\:SEb_2 VSS) capacitor c=9.21525e-17
C427 (\16\:CKb VSS) capacitor c=1.3143e-17
C428 (\4\:D2 VSS) capacitor c=5.2233e-17
C429 (\3\:Db_2 VSS) capacitor c=1.04549e-16
C430 (\5\:n20_2 VSS) capacitor c=1.02518e-16
C431 (\6\:n20_2 VSS) capacitor c=9.98576e-17
C432 (\6\:mout_2 VSS) capacitor c=7.29271e-17
C433 (\7\:mout_2 VSS) capacitor c=7.81848e-17
C434 (\2\:n20_3 VSS) capacitor c=2.31147e-17
C435 (\8\:n30_2 VSS) capacitor c=1.32748e-16
C436 (\11\:qbint_2 VSS) capacitor c=2.06767e-17
C437 (\12\:qbint_2 VSS) capacitor c=4.8695e-17
C438 (\15\:qbint_2 VSS) capacitor c=9.56116e-17
C439 (\5\:qint_2 VSS) capacitor c=2.43198e-17
C440 (\6\:qint_2 VSS) capacitor c=3.64365e-17
C441 (\5\:CK VSS) capacitor c=4.64252e-17
C442 (\5\:qbint_3 VSS) capacitor c=3.74778e-17
C443 (\2\:qint_3 VSS) capacitor c=8.04361e-18
C444 (\9\:Q2 VSS) capacitor c=2.96382e-16
C445 (\4\:SEb_3 VSS) capacitor c=9.20317e-17
C446 (\4\:D3 VSS) capacitor c=5.2233e-17
C447 (\3\:Db_3 VSS) capacitor c=1.04549e-16
C448 (\5\:n20_3 VSS) capacitor c=1.02518e-16
C449 (\6\:n20_3 VSS) capacitor c=9.98576e-17
C450 (\2\:n20_4 VSS) capacitor c=2.31147e-17
C451 (\6\:mout_3 VSS) capacitor c=7.29271e-17
C452 (\7\:mout_3 VSS) capacitor c=7.81848e-17
C453 (\8\:n30_3 VSS) capacitor c=1.32888e-16
C454 (\11\:qbint_3 VSS) capacitor c=2.06767e-17
C455 (\12\:qbint_3 VSS) capacitor c=4.8695e-17
C456 (\15\:qbint_3 VSS) capacitor c=9.56116e-17
C457 (\5\:qbint_4 VSS) capacitor c=3.74874e-17
C458 (\5\:qint_3 VSS) capacitor c=2.41525e-17
C459 (\6\:qint_3 VSS) capacitor c=3.63946e-17
C460 (\2\:qint_4 VSS) capacitor c=7.57237e-18
C461 (\9\:Q3 VSS) capacitor c=1.89817e-16
C462 (\4\:SEb_4 VSS) capacitor c=9.20413e-17
C463 (\4\:D4 VSS) capacitor c=5.2233e-17
C464 (\3\:Db_4 VSS) capacitor c=1.04526e-16
C465 (\5\:n20_4 VSS) capacitor c=1.02518e-16
C466 (\6\:n20_4 VSS) capacitor c=9.98576e-17
C467 (\6\:mout_4 VSS) capacitor c=7.29271e-17
C468 (\7\:mout_4 VSS) capacitor c=7.81848e-17
C469 (\8\:n30_4 VSS) capacitor c=1.32888e-16
C470 (\11\:qbint_4 VSS) capacitor c=2.06767e-17
C471 (\12\:qbint_4 VSS) capacitor c=4.8695e-17
C472 (\15\:qbint_4 VSS) capacitor c=9.57009e-17
C473 (\5\:qint_4 VSS) capacitor c=2.41121e-17
C474 (\6\:qint_4 VSS) capacitor c=3.63665e-17
C475 (\33\:CKb VSS) capacitor c=1.11882e-16
C476 (\34\:CKb VSS) capacitor c=6.54868e-16
C477 (\35\:CKb VSS) capacitor c=5.69959e-16
C478 (\36\:CKb VSS) capacitor c=5.10272e-16
C479 (\37\:CKb VSS) capacitor c=1.55994e-16
C480 (\38\:CKb VSS) capacitor c=3.81692e-16
C481 (\39\:CKb VSS) capacitor c=4.85834e-16
C482 (\40\:CKb VSS) capacitor c=3.67427e-16
C483 (\41\:CKb VSS) capacitor c=1.55994e-16
C484 (\42\:CKb VSS) capacitor c=5.54587e-16
C485 (\43\:CKb VSS) capacitor c=5.5281e-16
C486 (\44\:CKb VSS) capacitor c=6.5508e-16
C487 (\45\:CKb VSS) capacitor c=1.12024e-16
C488 (\46\:CKb VSS) capacitor c=7.14576e-17
C489 (\47\:CKb VSS) capacitor c=8.38823e-17
C490 (\48\:CKb VSS) capacitor c=7.14576e-17
C491 (\49\:CKb VSS) capacitor c=3.86659e-17
C492 (\50\:CKb VSS) capacitor c=1.07791e-16
C493 (\53\:CKb VSS) capacitor c=8.38823e-17
C494 (\54\:CKb VSS) capacitor c=7.14576e-17
C495 (\55\:CKb VSS) capacitor c=7.23853e-17
C496 (\29\:RN VSS) capacitor c=4.40201e-16
C497 (\30\:RN VSS) capacitor c=5.70716e-16
C498 (\31\:RN VSS) capacitor c=7.21878e-16
C499 (\32\:RN VSS) capacitor c=8.22799e-16
C500 (\33\:RN VSS) capacitor c=8.3852e-16
C501 (\34\:RN VSS) capacitor c=3.93307e-16
C502 (\35\:RN VSS) capacitor c=6.40124e-16
C503 (\36\:RN VSS) capacitor c=6.63826e-16
C504 (\37\:RN VSS) capacitor c=5.86955e-16
C505 (\29\:SE VSS) capacitor c=5.50878e-17
C506 (\30\:SE VSS) capacitor c=1.09809e-15
C507 (\31\:SE VSS) capacitor c=6.29563e-16
C508 (\32\:SE VSS) capacitor c=5.87613e-16
C509 (\33\:SE VSS) capacitor c=6.80639e-16
C510 (\34\:SE VSS) capacitor c=7.02954e-16
C511 (\35\:SE VSS) capacitor c=1.16306e-16
C512 (\36\:SE VSS) capacitor c=1.418e-16
C513 (\37\:SE VSS) capacitor c=1.09887e-15
C514 (\38\:SE VSS) capacitor c=5.50069e-17
C515 (\39\:SE VSS) capacitor c=8.53356e-17
C516 (\40\:SE VSS) capacitor c=5.27528e-17
C517 (\41\:SE VSS) capacitor c=5.52328e-17
C518 (\42\:SE VSS) capacitor c=8.53197e-17
C519 (\43\:SE VSS) capacitor c=5.27528e-17
C520 (\44\:SE VSS) capacitor c=5.52328e-17
C521 (\45\:SE VSS) capacitor c=8.50644e-17
C522 (\46\:SE VSS) capacitor c=5.75694e-17
C523 (\33\:Ckbb VSS) capacitor c=6.08948e-16
C524 (\34\:Ckbb VSS) capacitor c=1.57822e-16
C525 (\35\:Ckbb VSS) capacitor c=5.03241e-16
C526 (\36\:Ckbb VSS) capacitor c=5.36394e-16
C527 (\37\:Ckbb VSS) capacitor c=1.57821e-16
C528 (\38\:Ckbb VSS) capacitor c=2.3307e-16
C529 (\40\:Ckbb VSS) capacitor c=4.36284e-16
C530 (\41\:Ckbb VSS) capacitor c=1.57821e-16
C531 (\42\:Ckbb VSS) capacitor c=4.25626e-16
C532 (\43\:Ckbb VSS) capacitor c=4.25007e-16
C533 (\44\:Ckbb VSS) capacitor c=1.57759e-16
C534 (\45\:Ckbb VSS) capacitor c=6.08887e-16
C535 (\5\:VDD VSS) capacitor c=9.17579e-18
C536 (\6\:VDD VSS) capacitor c=2.53622e-17
C537 (\7\:VDD VSS) capacitor c=1.90075e-17
C538 (\17\:VDD VSS) capacitor c=3.02187e-17
C539 (\20\:VDD VSS) capacitor c=4.06048e-17
C540 (\24\:VDD VSS) capacitor c=1.67798e-17
C541 (\27\:VDD VSS) capacitor c=3.16514e-17
C542 (\30\:VDD VSS) capacitor c=4.18436e-17
C543 (\33\:VDD VSS) capacitor c=2.58579e-17
C544 (\37\:VDD VSS) capacitor c=3.09204e-17
C545 (\40\:VDD VSS) capacitor c=4.16943e-17
C546 (\43\:VDD VSS) capacitor c=3.39786e-17
C547 (\47\:VDD VSS) capacitor c=3.00689e-17
C548 (\50\:VDD VSS) capacitor c=3.8774e-17
C549 (\53\:VDD VSS) capacitor c=3.16514e-17
C550 (\59\:VDD VSS) capacitor c=3.33155e-17
C551 (\62\:VDD VSS) capacitor c=3.47098e-17
C552 (\65\:VDD VSS) capacitor c=2.99548e-17
C553 (\69\:VDD VSS) capacitor c=4.30678e-17
C554 (\72\:VDD VSS) capacitor c=5.09544e-17
C555 (\75\:VDD VSS) capacitor c=2.17944e-17
C556 (\79\:VDD VSS) capacitor c=2.94638e-17
C557 (\82\:VDD VSS) capacitor c=3.32821e-17
C558 (\85\:VDD VSS) capacitor c=3.52613e-17
C559 (\89\:VDD VSS) capacitor c=1.80989e-17
C560 (\92\:VDD VSS) capacitor c=2.3255e-17
Rk60 (\5\:CK CK) resistor r=0.01231 c=0
Rk59 (\4\:CK \5\:CK) resistor r=0.004286 c=0
Rk276 (VSS VSS) resistor r=1e-06 c=0
Rk244 (\2\:VSS \4\:VSS) resistor r=0.2713 c=0
Rk245 (\4\:VSS \5\:VSS) resistor r=0.08298 c=0
Rk246 (\5\:VSS \6\:VSS) resistor r=0.3164 c=0
Rk247 (\6\:VSS \7\:VSS) resistor r=0.5153 c=0
Rk248 (\7\:VSS \8\:VSS) resistor r=0.09828 c=0
Rk249 (\8\:VSS \9\:VSS) resistor r=0.4629 c=0
Rk250 (\9\:VSS \10\:VSS) resistor r=0.4133 c=0
Rk251 (\10\:VSS \11\:VSS) resistor r=0.3431 c=0
Rk252 (\11\:VSS \12\:VSS) resistor r=0.08043 c=0
Rk253 (\12\:VSS \13\:VSS) resistor r=0.3062 c=0
Rk254 (\13\:VSS \14\:VSS) resistor r=0.3164 c=0
Rk255 (\14\:VSS \15\:VSS) resistor r=0.5145 c=0
Rk256 (\15\:VSS \16\:VSS) resistor r=0.5656 c=0
Rk257 (\16\:VSS \17\:VSS) resistor r=0.4133 c=0
Rk258 (\17\:VSS \18\:VSS) resistor r=0.2411 c=0
Rk259 (\18\:VSS \19\:VSS) resistor r=0.1964 c=0
Rk260 (\19\:VSS \20\:VSS) resistor r=0.3916 c=0
Rk261 (\20\:VSS \21\:VSS) resistor r=0.3062 c=0
Rk262 (\21\:VSS \22\:VSS) resistor r=0.3234 c=0
Rk263 (\22\:VSS \23\:VSS) resistor r=0.5119 c=0
Rk264 (\23\:VSS \24\:VSS) resistor r=0.5612 c=0
Rk265 (\24\:VSS \25\:VSS) resistor r=0.1467 c=0
Rk266 (\25\:VSS \26\:VSS) resistor r=0.2666 c=0
Rk267 (\26\:VSS \27\:VSS) resistor r=0.4822 c=0
Rk268 (\27\:VSS \28\:VSS) resistor r=0.4133 c=0
Rk269 (\28\:VSS \29\:VSS) resistor r=0.05493 c=0
Rk270 (\29\:VSS \30\:VSS) resistor r=0.5063 c=0
Rk271 (\30\:VSS \31\:VSS) resistor r=0.5153 c=0
Rk272 (\31\:VSS \32\:VSS) resistor r=0.1977 c=0
Rk273 (\32\:VSS \33\:VSS) resistor r=0.1187 c=0
Rk275 (\34\:VSS VSS) resistor r=0.1312 c=0
Rk274 (\33\:VSS \34\:VSS) resistor r=0.3062 c=0
Rk277 (\5\:VSS \36\:VSS) resistor r=0.04432 c=0
Rk278 (\6\:VSS \38\:VSS) resistor r=0.04432 c=0
Rk279 (\7\:VSS \40\:VSS) resistor r=0.04432 c=0
Rk280 (\9\:VSS \42\:VSS) resistor r=0.04432 c=0
Rk281 (\10\:VSS \44\:VSS) resistor r=0.04432 c=0
Rk282 (\12\:VSS \46\:VSS) resistor r=0.04432 c=0
Rk283 (\13\:VSS \48\:VSS) resistor r=0.04432 c=0
Rk284 (\14\:VSS \50\:VSS) resistor r=0.04432 c=0
Rk285 (\15\:VSS \52\:VSS) resistor r=0.07268 c=0
Rk286 (\16\:VSS \54\:VSS) resistor r=0.04432 c=0
Rk287 (\17\:VSS \56\:VSS) resistor r=0.04432 c=0
Rk288 (\19\:VSS \58\:VSS) resistor r=0.04238 c=0
Rk289 (\20\:VSS \60\:VSS) resistor r=0.04432 c=0
Rk290 (\21\:VSS \62\:VSS) resistor r=0.04432 c=0
Rk291 (\22\:VSS \64\:VSS) resistor r=0.07268 c=0
Rk292 (\23\:VSS \66\:VSS) resistor r=0.04432 c=0
Rk293 (\24\:VSS \68\:VSS) resistor r=0.04432 c=0
Rk294 (\26\:VSS \70\:VSS) resistor r=0.04432 c=0
Rk295 (\27\:VSS \72\:VSS) resistor r=0.04432 c=0
Rk296 (\28\:VSS \74\:VSS) resistor r=0.04432 c=0
Rk297 (\30\:VSS \76\:VSS) resistor r=0.04432 c=0
Rk298 (\31\:VSS \78\:VSS) resistor r=0.04432 c=0
Rk299 (\33\:VSS \80\:VSS) resistor r=0.04432 c=0
Rk300 (\34\:VSS \82\:VSS) resistor r=0.04432 c=0
Rk243 (VDD VDD) resistor r=1e-06 c=0
Rk179 (\2\:VDD \4\:VDD) resistor r=0.2713 c=0
Rk180 (\4\:VDD \5\:VDD) resistor r=0.1085 c=0
Rk181 (\5\:VDD \6\:VDD) resistor r=0.2909 c=0
Rk182 (\6\:VDD \7\:VDD) resistor r=0.4643 c=0
Rk183 (\7\:VDD \8\:VDD) resistor r=0.1493 c=0
Rk184 (\5\:VDD \10\:VDD) resistor r=0.04432 c=0
Rk185 (\6\:VDD \12\:VDD) resistor r=0.04432 c=0
Rk186 (\7\:VDD \14\:VDD) resistor r=0.04432 c=0
Rk187 (\8\:VDD \16\:VDD) resistor r=0.07268 c=0
Rk188 (\8\:VDD \17\:VDD) resistor r=0.4769 c=0
Rk189 (\17\:VDD \19\:VDD) resistor r=0.04432 c=0
Rk190 (\17\:VDD \20\:VDD) resistor r=0.4006 c=0
Rk191 (\20\:VDD \22\:VDD) resistor r=0.04432 c=0
Rk192 (\20\:VDD \23\:VDD) resistor r=0.3431 c=0
Rk193 (\23\:VDD \24\:VDD) resistor r=0.08043 c=0
Rk194 (\24\:VDD \26\:VDD) resistor r=0.04432 c=0
Rk195 (\24\:VDD \27\:VDD) resistor r=0.3317 c=0
Rk196 (\27\:VDD \29\:VDD) resistor r=0.04432 c=0
Rk197 (\27\:VDD \30\:VDD) resistor r=0.2909 c=0
Rk198 (\30\:VDD \32\:VDD) resistor r=0.04432 c=0
Rk199 (\30\:VDD \33\:VDD) resistor r=0.4643 c=0
Rk200 (\33\:VDD \35\:VDD) resistor r=0.04432 c=0
Rk201 (\33\:VDD \36\:VDD) resistor r=0.04728 c=0
Rk202 (\36\:VDD \37\:VDD) resistor r=0.1289 c=0
Rk203 (\37\:VDD \39\:VDD) resistor r=0.04432 c=0
Rk204 (\37\:VDD \40\:VDD) resistor r=0.4465 c=0
Rk205 (\40\:VDD \42\:VDD) resistor r=0.04432 c=0
Rk206 (\40\:VDD \43\:VDD) resistor r=0.4006 c=0
Rk207 (\43\:VDD \45\:VDD) resistor r=0.04432 c=0
Rk208 (\43\:VDD \46\:VDD) resistor r=0.2411 c=0
Rk209 (\46\:VDD \47\:VDD) resistor r=0.1977 c=0
Rk210 (\47\:VDD \49\:VDD) resistor r=0.04432 c=0
Rk211 (\47\:VDD \50\:VDD) resistor r=0.3904 c=0
Rk212 (\50\:VDD \52\:VDD) resistor r=0.04432 c=0
Rk213 (\50\:VDD \53\:VDD) resistor r=0.3317 c=0
Rk214 (\53\:VDD \55\:VDD) resistor r=0.04432 c=0
Rk215 (\53\:VDD \56\:VDD) resistor r=0.2979 c=0
Rk216 (\56\:VDD \58\:VDD) resistor r=0.07268 c=0
Rk217 (\56\:VDD \59\:VDD) resistor r=0.4609 c=0
Rk218 (\59\:VDD \61\:VDD) resistor r=0.04432 c=0
Rk219 (\59\:VDD \62\:VDD) resistor r=0.1762 c=0
Rk220 (\62\:VDD \64\:VDD) resistor r=0.04432 c=0
Rk221 (\62\:VDD \65\:VDD) resistor r=0.4465 c=0
Rk222 (\65\:VDD \67\:VDD) resistor r=0.04432 c=0
Rk223 (\65\:VDD \68\:VDD) resistor r=0.134 c=0
Rk224 (\68\:VDD \69\:VDD) resistor r=0.2666 c=0
Rk225 (\69\:VDD \71\:VDD) resistor r=0.04432 c=0
Rk226 (\69\:VDD \72\:VDD) resistor r=0.4822 c=0
Rk227 (\72\:VDD \74\:VDD) resistor r=0.04432 c=0
Rk228 (\72\:VDD \75\:VDD) resistor r=0.4006 c=0
Rk229 (\75\:VDD \77\:VDD) resistor r=0.04432 c=0
Rk230 (\75\:VDD \78\:VDD) resistor r=0.06768 c=0
Rk231 (\78\:VDD \79\:VDD) resistor r=0.3788 c=0
Rk232 (\79\:VDD \81\:VDD) resistor r=0.04432 c=0
Rk233 (\79\:VDD \82\:VDD) resistor r=0.1762 c=0
Rk234 (\82\:VDD \84\:VDD) resistor r=0.04432 c=0
Rk235 (\82\:VDD \85\:VDD) resistor r=0.4643 c=0
Rk236 (\85\:VDD \87\:VDD) resistor r=0.04432 c=0
Rk237 (\85\:VDD \88\:VDD) resistor r=0.1977 c=0
Rk238 (\88\:VDD \89\:VDD) resistor r=0.09318 c=0
Rk239 (\89\:VDD \91\:VDD) resistor r=0.04432 c=0
Rk242 (\92\:VDD VDD) resistor r=0.1312 c=0
Rk240 (\89\:VDD \92\:VDD) resistor r=0.3317 c=0
Rk241 (\92\:VDD \94\:VDD) resistor r=0.04432 c=0
Rk147 (\29\:SE \30\:SE) resistor r=0.2699 c=0
Rk148 (\30\:SE \31\:SE) resistor r=0.6117 c=0
Rk149 (\31\:SE \32\:SE) resistor r=4.2469 c=0
Rk150 (\32\:SE \33\:SE) resistor r=0.3962 c=0
Rk151 (\33\:SE \34\:SE) resistor r=4.973 c=0
Rk152 (\34\:SE \35\:SE) resistor r=0.3962 c=0
Rk153 (\35\:SE \36\:SE) resistor r=0.5594 c=0
Rk154 (\36\:SE \37\:SE) resistor r=0.7298 c=0
Rk155 (\37\:SE \38\:SE) resistor r=0.2699 c=0
Rk156 (\31\:SE \39\:SE) resistor r=0.2358 c=0
Rk157 (\32\:SE \40\:SE) resistor r=0.2108 c=0
Rk158 (\40\:SE \41\:SE) resistor r=0.2699 c=0
Rk159 (\33\:SE \42\:SE) resistor r=0.2358 c=0
Rk160 (\34\:SE \43\:SE) resistor r=0.2108 c=0
Rk161 (\43\:SE \44\:SE) resistor r=0.2699 c=0
Rk162 (\35\:SE \45\:SE) resistor r=0.2358 c=0
Rk164 (\46\:SE SE) resistor r=0.0334 c=0
Rk163 (\36\:SE \46\:SE) resistor r=0.2358 c=0
Rk138 (\29\:RN \30\:RN) resistor r=1.3273 c=0
Rk139 (\30\:RN \31\:RN) resistor r=3.9268 c=0
Rk140 (\31\:RN \32\:RN) resistor r=1.3273 c=0
Rk141 (\32\:RN \33\:RN) resistor r=4.7866 c=0
Rk142 (\33\:RN \34\:RN) resistor r=1.3273 c=0
Rk146 (\35\:RN RN) resistor r=0.04189 c=0
Rk143 (\34\:RN \35\:RN) resistor r=1.4645 c=0
Rk144 (\35\:RN \36\:RN) resistor r=3.4367 c=0
Rk145 (\36\:RN \37\:RN) resistor r=1.3273 c=0
Rk7 (\8\:Q1 Q1) resistor r=0.0157 c=0
Rk6 (\6\:Q1 \8\:Q1) resistor r=0.2754 c=0
Rk31 (\9\:Q1 \10\:Q1) resistor r=4.5396 c=0
Rk1 (Q1N \2\:Q1N) resistor r=0.037 c=0
Rk2 (Q1N \4\:Q1N) resistor r=0.2021 c=0
Rk21 (\4\:D1 D1) resistor r=0.01785 c=0
Rk26 (\4\:SI \5\:SI) resistor r=0.007787 c=0
Rk27 (SI \6\:SI) resistor r=0.007787 c=0
Rk28 (\4\:SI \6\:SI) resistor r=0.03343 c=0
Rk52 (Q2 \6\:Q2) resistor r=0.01602 c=0
Rk53 (\6\:Q2 \8\:Q2) resistor r=0.2754 c=0
Rk62 (\9\:Q2 \10\:Q2) resistor r=2.0022 c=0
Rk57 (Q2N \2\:Q2N) resistor r=0.037 c=0
Rk58 (Q2N \4\:Q2N) resistor r=0.2021 c=0
Rk34 (\4\:D2 D2) resistor r=0.01764 c=0
Rk83 (Q3 \6\:Q3) resistor r=0.01602 c=0
Rk84 (\6\:Q3 \8\:Q3) resistor r=0.2754 c=0
Rk90 (\9\:Q3 \10\:Q3) resistor r=1.268 c=0
Rk88 (Q3N \2\:Q3N) resistor r=0.037 c=0
Rk89 (Q3N \4\:Q3N) resistor r=0.2021 c=0
Rk65 (\4\:D3 D3) resistor r=0.01764 c=0
Rk177 (Q4N \2\:Q4N) resistor r=0.037 c=0
Rk178 (Q4N \4\:Q4N) resistor r=0.2021 c=0
Rk111 (Q4 \2\:Q4) resistor r=0.01602 c=0
Rk112 (\2\:Q4 \4\:Q4) resistor r=0.2754 c=0
Rk93 (\4\:D4 D4) resistor r=0.01764 c=0
Rk116 (\33\:CKb \34\:CKb) resistor r=0.6868 c=0
Rk117 (\34\:CKb \35\:CKb) resistor r=1.0086 c=0
Rk118 (\35\:CKb \36\:CKb) resistor r=3.4257 c=0
Rk119 (\36\:CKb \37\:CKb) resistor r=0.3078 c=0
Rk120 (\37\:CKb \38\:CKb) resistor r=1.0086 c=0
Rk121 (\38\:CKb \39\:CKb) resistor r=1.9112 c=0
Rk122 (\39\:CKb \40\:CKb) resistor r=2.2911 c=0
Rk123 (\40\:CKb \41\:CKb) resistor r=0.3078 c=0
Rk124 (\41\:CKb \42\:CKb) resistor r=1.0086 c=0
Rk125 (\42\:CKb \43\:CKb) resistor r=3.1811 c=0
Rk126 (\43\:CKb \44\:CKb) resistor r=1.0086 c=0
Rk127 (\44\:CKb \45\:CKb) resistor r=0.7781 c=0
Rk128 (\34\:CKb \46\:CKb) resistor r=0.2848 c=0
Rk129 (\36\:CKb \47\:CKb) resistor r=0.3775 c=0
Rk130 (\37\:CKb \48\:CKb) resistor r=0.2848 c=0
Rk131 (\39\:CKb \49\:CKb) resistor r=0.1041 c=0
Rk132 (\49\:CKb \50\:CKb) resistor r=0.2043 c=0
Rk133 (\50\:CKb \52\:CKb) resistor r=0.2759 c=0
Rk134 (\40\:CKb \53\:CKb) resistor r=0.3775 c=0
Rk135 (\41\:CKb \54\:CKb) resistor r=0.2848 c=0
Rk136 (\44\:CKb \55\:CKb) resistor r=0.2848 c=0
Rk137 (\49\:CKb \57\:CKb) resistor r=0.2044 c=0
Rk61 (\23\:Ckbb \25\:Ckbb) resistor r=0.3121 c=0
Rk165 (\33\:Ckbb \34\:Ckbb) resistor r=0.8193 c=0
Rk166 (\34\:Ckbb \35\:Ckbb) resistor r=0.4943 c=0
Rk167 (\35\:Ckbb \36\:Ckbb) resistor r=3.5624 c=0
Rk168 (\36\:Ckbb \37\:Ckbb) resistor r=0.8193 c=0
Rk169 (\37\:Ckbb \38\:Ckbb) resistor r=0.4943 c=0
Rk170 (\38\:Ckbb \39\:Ckbb) resistor r=1.5037 c=0
Rk171 (\39\:Ckbb \40\:Ckbb) resistor r=2.8459 c=0
Rk172 (\40\:Ckbb \41\:Ckbb) resistor r=0.8193 c=0
Rk173 (\41\:Ckbb \42\:Ckbb) resistor r=0.4943 c=0
Rk174 (\42\:Ckbb \43\:Ckbb) resistor r=2.8838 c=0
Rk175 (\43\:Ckbb \44\:Ckbb) resistor r=0.4943 c=0
Rk176 (\44\:Ckbb \45\:Ckbb) resistor r=0.8193 c=0
Rk22 (\2\:Db \3\:Db) resistor r=0.2088 c=0
Rk23 (\3\:Db \5\:Db) resistor r=0.3028 c=0
Rk24 (\3\:Db \7\:Db) resistor r=0.5603 c=0
Rk25 (\5\:Db \9\:Db) resistor r=0.4437 c=0
Rk3 (\6\:qint \7\:qint) resistor r=0.1049 c=0
Rk4 (\7\:qint \8\:qint) resistor r=0.1212 c=0
Rk5 (\7\:qint \10\:qint) resistor r=0.1254 c=0
Rk17 (\2\:n6 \4\:n6) resistor r=0.222 c=0
Rk29 (\5\:SEb \7\:SEb) resistor r=0.4159 c=0
Rk30 (\7\:SEb \8\:SEb) resistor r=0.5485 c=0
Rk8 (\11\:qbint \13\:qbint) resistor r=0.5666 c=0
Rk9 (\13\:qbint \14\:qbint) resistor r=0.3422 c=0
Rk10 (\14\:qbint \15\:qbint) resistor r=0.1592 c=0
Rk11 (\14\:qbint \17\:qbint) resistor r=0.2065 c=0
Rk18 (\6\:n20 \7\:n20) resistor r=0.2696 c=0
Rk19 (\7\:n20 \8\:n20) resistor r=0.581 c=0
Rk20 (\7\:n20 \10\:n20) resistor r=0.195 c=0
Rk12 (\5\:n30 \7\:n30) resistor r=0.3726 c=0
Rk13 (\7\:n30 \8\:n30) resistor r=0.5772 c=0
Rk14 (\4\:mout \5\:mout) resistor r=0.4567 c=0
Rk15 (\5\:mout \7\:mout) resistor r=0.1209 c=0
Rk16 (\5\:mout \9\:mout) resistor r=0.2151 c=0
Rk35 (\2\:Db_2 \3\:Db_2) resistor r=0.6077 c=0
Rk36 (\3\:Db_2 \5\:Db_2) resistor r=0.3028 c=0
Rk37 (\3\:Db_2 \7\:Db_2) resistor r=0.2088 c=0
Rk38 (\5\:Db_2 \9\:Db_2) resistor r=0.4437 c=0
Rk54 (\5\:qint_2 \6\:qint_2) resistor r=0.1212 c=0
Rk55 (\6\:qint_2 \8\:qint_2) resistor r=0.1254 c=0
Rk56 (\6\:qint_2 \10\:qint_2) resistor r=0.1049 c=0
Rk39 (\2\:n6_2 \4\:n6_2) resistor r=0.222 c=0
Rk32 (\4\:SEb_2 \6\:SEb_2) resistor r=0.55 c=0
Rk33 (\6\:SEb_2 \8\:SEb_2) resistor r=0.4161 c=0
Rk48 (\11\:qbint_2 \12\:qbint_2) resistor r=0.1592 c=0
Rk49 (\12\:qbint_2 \14\:qbint_2) resistor r=0.3422 c=0
Rk50 (\14\:qbint_2 \15\:qbint_2) resistor r=0.5662 c=0
Rk51 (\12\:qbint_2 \17\:qbint_2) resistor r=0.2022 c=0
Rk40 (\5\:n20_2 \6\:n20_2) resistor r=0.581 c=0
Rk41 (\6\:n20_2 \8\:n20_2) resistor r=0.2672 c=0
Rk42 (\6\:n20_2 \10\:n20_2) resistor r=0.195 c=0
Rk46 (\5\:n30_2 \7\:n30_2) resistor r=0.3733 c=0
Rk47 (\7\:n30_2 \8\:n30_2) resistor r=0.5802 c=0
Rk43 (\5\:mout_2 \6\:mout_2) resistor r=0.2454 c=0
Rk44 (\6\:mout_2 \7\:mout_2) resistor r=0.4567 c=0
Rk45 (\6\:mout_2 \9\:mout_2) resistor r=0.1209 c=0
Rk66 (\2\:Db_3 \3\:Db_3) resistor r=0.6077 c=0
Rk67 (\3\:Db_3 \5\:Db_3) resistor r=0.3028 c=0
Rk68 (\3\:Db_3 \7\:Db_3) resistor r=0.2088 c=0
Rk69 (\5\:Db_3 \9\:Db_3) resistor r=0.4437 c=0
Rk85 (\5\:qint_3 \6\:qint_3) resistor r=0.1212 c=0
Rk86 (\6\:qint_3 \8\:qint_3) resistor r=0.1254 c=0
Rk87 (\6\:qint_3 \10\:qint_3) resistor r=0.1049 c=0
Rk70 (\2\:n6_3 \4\:n6_3) resistor r=0.222 c=0
Rk63 (\4\:SEb_3 \6\:SEb_3) resistor r=0.55 c=0
Rk64 (\6\:SEb_3 \8\:SEb_3) resistor r=0.419 c=0
Rk79 (\11\:qbint_3 \12\:qbint_3) resistor r=0.1592 c=0
Rk80 (\12\:qbint_3 \14\:qbint_3) resistor r=0.3422 c=0
Rk81 (\14\:qbint_3 \15\:qbint_3) resistor r=0.5662 c=0
Rk82 (\12\:qbint_3 \17\:qbint_3) resistor r=0.2022 c=0
Rk71 (\5\:n20_3 \6\:n20_3) resistor r=0.581 c=0
Rk72 (\6\:n20_3 \8\:n20_3) resistor r=0.2672 c=0
Rk73 (\6\:n20_3 \10\:n20_3) resistor r=0.195 c=0
Rk77 (\5\:n30_3 \7\:n30_3) resistor r=0.3733 c=0
Rk78 (\7\:n30_3 \8\:n30_3) resistor r=0.5802 c=0
Rk74 (\5\:mout_3 \6\:mout_3) resistor r=0.2454 c=0
Rk75 (\6\:mout_3 \7\:mout_3) resistor r=0.4567 c=0
Rk76 (\6\:mout_3 \9\:mout_3) resistor r=0.1209 c=0
Rk94 (\2\:Db_4 \3\:Db_4) resistor r=0.6077 c=0
Rk95 (\3\:Db_4 \5\:Db_4) resistor r=0.3028 c=0
Rk96 (\3\:Db_4 \7\:Db_4) resistor r=0.2088 c=0
Rk97 (\5\:Db_4 \9\:Db_4) resistor r=0.4437 c=0
Rk113 (\5\:qint_4 \6\:qint_4) resistor r=0.1212 c=0
Rk114 (\6\:qint_4 \8\:qint_4) resistor r=0.1254 c=0
Rk115 (\6\:qint_4 \10\:qint_4) resistor r=0.1049 c=0
Rk98 (\2\:n6_4 \4\:n6_4) resistor r=0.222 c=0
Rk91 (\4\:SEb_4 \6\:SEb_4) resistor r=0.55 c=0
Rk92 (\6\:SEb_4 \8\:SEb_4) resistor r=0.4218 c=0
Rk107 (\11\:qbint_4 \12\:qbint_4) resistor r=0.1592 c=0
Rk108 (\12\:qbint_4 \14\:qbint_4) resistor r=0.3422 c=0
Rk109 (\14\:qbint_4 \15\:qbint_4) resistor r=0.5662 c=0
Rk110 (\12\:qbint_4 \17\:qbint_4) resistor r=0.2022 c=0
Rk99 (\5\:n20_4 \6\:n20_4) resistor r=0.581 c=0
Rk100 (\6\:n20_4 \8\:n20_4) resistor r=0.2672 c=0
Rk101 (\6\:n20_4 \10\:n20_4) resistor r=0.195 c=0
Rk105 (\5\:n30_4 \7\:n30_4) resistor r=0.3733 c=0
Rk106 (\7\:n30_4 \8\:n30_4) resistor r=0.5802 c=0
Rk102 (\5\:mout_4 \6\:mout_4) resistor r=0.2454 c=0
Rk103 (\6\:mout_4 \7\:mout_4) resistor r=0.4567 c=0
Rk104 (\6\:mout_4 \9\:mout_4) resistor r=0.1209 c=0
Rl84 (\1\:CK \2\:CK) resistor r=24.2328 c=0
Rl85 (\2\:CK \3\:CK) resistor r=58.8482 c=0
Rl139 (\27\:SE \28\:SE) resistor r=52.6149 c=0
Rl136 (\25\:SE \26\:SE) resistor r=33.3841 c=0
Rl131 (\22\:SE \23\:SE) resistor r=54.5379 c=0
Rl132 (\23\:SE \24\:SE) resistor r=41.0764 c=0
Rl97 (\20\:SE \21\:SE) resistor r=52.6149 c=0
Rl94 (\18\:SE \19\:SE) resistor r=33.3841 c=0
Rl89 (\15\:SE \16\:SE) resistor r=54.5379 c=0
Rl90 (\16\:SE \17\:SE) resistor r=41.0764 c=0
Rl50 (\13\:SE \14\:SE) resistor r=52.6149 c=0
Rl47 (\11\:SE \12\:SE) resistor r=33.3841 c=0
Rl42 (\8\:SE \9\:SE) resistor r=54.5379 c=0
Rl43 (\9\:SE \10\:SE) resistor r=41.0764 c=0
Rl40 (\5\:SE \6\:SE) resistor r=54.5379 c=0
Rl41 (\6\:SE \7\:SE) resistor r=41.0764 c=0
Rl37 (\3\:SE \4\:SE) resistor r=33.3841 c=0
Rl34 (\1\:SE \2\:SE) resistor r=52.6149 c=0
Rl149 (\23\:RN \24\:RN) resistor r=147.643 c=0
Rl107 (\16\:RN \17\:RN) resistor r=147.643 c=0
Rl60 (\9\:RN \10\:RN) resistor r=147.643 c=0
Rl24 (\5\:RN \6\:RN) resistor r=147.643 c=0
Rl161 (\27\:RN \28\:RN) resistor r=52.6149 c=0
Rl160 (\26\:RN \27\:RN) resistor r=51.1559 c=0
Rl159 (\25\:RN \26\:RN) resistor r=47.3097 c=0
Rl148 (\22\:RN \23\:RN) resistor r=52.6149 c=0
Rl119 (\20\:RN \21\:RN) resistor r=52.6149 c=0
Rl118 (\19\:RN \20\:RN) resistor r=51.1559 c=0
Rl117 (\18\:RN \19\:RN) resistor r=47.3097 c=0
Rl106 (\15\:RN \16\:RN) resistor r=52.6149 c=0
Rl72 (\13\:RN \14\:RN) resistor r=52.6149 c=0
Rl71 (\12\:RN \13\:RN) resistor r=51.1559 c=0
Rl70 (\11\:RN \12\:RN) resistor r=47.3097 c=0
Rl59 (\8\:RN \9\:RN) resistor r=52.6149 c=0
Rl25 (\6\:RN \7\:RN) resistor r=52.6149 c=0
Rl13 (\2\:RN \3\:RN) resistor r=51.1559 c=0
Rl12 (\1\:RN \2\:RN) resistor r=47.3097 c=0
Rl14 (\3\:RN \4\:RN) resistor r=52.6149 c=0
Rl46 (\3\:Q1 \4\:Q1) resistor r=87.2302 c=0
Rl45 (\2\:Q1 \3\:Q1) resistor r=89.1533 c=0
Rl44 (\1\:Q1 \2\:Q1) resistor r=41.0764 c=0
Rl32 (\1\:D1 \2\:D1) resistor r=91.5405 c=0
Rl33 (\2\:D1 \3\:D1) resistor r=35.7713 c=0
Rl39 (\2\:SI \3\:SI) resistor r=89.1533 c=0
Rl38 (\1\:SI \2\:SI) resistor r=41.0764 c=0
Rl93 (\3\:Q2 \4\:Q2) resistor r=87.2302 c=0
Rl92 (\2\:Q2 \3\:Q2) resistor r=89.1533 c=0
Rl91 (\1\:Q2 \2\:Q2) resistor r=41.0764 c=0
Rl51 (\1\:D2 \2\:D2) resistor r=91.5405 c=0
Rl52 (\2\:D2 \3\:D2) resistor r=35.7713 c=0
Rl135 (\3\:Q3 \4\:Q3) resistor r=87.2302 c=0
Rl134 (\2\:Q3 \3\:Q3) resistor r=89.1533 c=0
Rl133 (\1\:Q3 \2\:Q3) resistor r=41.0764 c=0
Rl98 (\1\:D3 \2\:D3) resistor r=91.5405 c=0
Rl99 (\2\:D3 \3\:D3) resistor r=35.7713 c=0
Rl140 (\1\:D4 \2\:D4) resistor r=91.5405 c=0
Rl141 (\2\:D4 \3\:D4) resistor r=35.7713 c=0
Rl143 (\26\:CKb \27\:CKb) resistor r=109.983 c=0
Rl101 (\19\:CKb \20\:CKb) resistor r=109.983 c=0
Rl54 (\8\:CKb \9\:CKb) resistor r=109.983 c=0
Rl30 (\6\:CKb \7\:CKb) resistor r=109.983 c=0
Rl156 (\31\:CKb \32\:CKb) resistor r=31.9251 c=0
Rl153 (\29\:CKb \30\:CKb) resistor r=24.2328 c=0
Rl144 (\27\:CKb \28\:CKb) resistor r=32.9066 c=0
Rl114 (\24\:CKb \25\:CKb) resistor r=31.9251 c=0
Rl111 (\22\:CKb \23\:CKb) resistor r=24.2328 c=0
Rl102 (\20\:CKb \21\:CKb) resistor r=32.9066 c=0
Rl67 (\13\:CKb \14\:CKb) resistor r=31.9251 c=0
Rl64 (\11\:CKb \12\:CKb) resistor r=24.2328 c=0
Rl55 (\9\:CKb \10\:CKb) resistor r=32.9066 c=0
Rl29 (\5\:CKb \6\:CKb) resistor r=33.8727 c=0
Rl20 (\3\:CKb \4\:CKb) resistor r=24.2328 c=0
Rl17 (CKb \2\:CKb) resistor r=31.9251 c=0
Rl86 (\15\:CKb \16\:CKb) resistor r=64.2642 c=0
Rl88 (\16\:CKb \18\:CKb) resistor r=37.3411 c=0
Rl87 (\16\:CKb \17\:CKb) resistor r=1.2301 c=0
Rl154 (\30\:Ckbb \31\:Ckbb) resistor r=183.747 c=0
Rl112 (\19\:Ckbb \20\:Ckbb) resistor r=183.747 c=0
Rl65 (\12\:Ckbb \13\:Ckbb) resistor r=183.747 c=0
Rl19 (\2\:Ckbb \3\:Ckbb) resistor r=183.747 c=0
Rl155 (\31\:Ckbb \32\:Ckbb) resistor r=62.6944 c=0
Rl145 (\28\:Ckbb \29\:Ckbb) resistor r=62.6944 c=0
Rl142 (\26\:Ckbb \27\:Ckbb) resistor r=230.67 c=0
Rl113 (\20\:Ckbb \21\:Ckbb) resistor r=62.6944 c=0
Rl103 (\17\:Ckbb \18\:Ckbb) resistor r=62.6944 c=0
Rl100 (\15\:Ckbb \16\:Ckbb) resistor r=230.67 c=0
Rl66 (\13\:Ckbb \14\:Ckbb) resistor r=62.6944 c=0
Rl56 (\10\:Ckbb \11\:Ckbb) resistor r=62.6944 c=0
Rl53 (\8\:Ckbb \9\:Ckbb) resistor r=230.67 c=0
Rl31 (\6\:Ckbb \7\:Ckbb) resistor r=230.67 c=0
Rl28 (\4\:Ckbb \5\:Ckbb) resistor r=62.6944 c=0
Rl18 (Ckbb \2\:Ckbb) resistor r=62.6944 c=0
Rl3 (\2\:qint \4\:qint) resistor r=38.1757 c=0
Rl2 (\2\:qint \3\:qint) resistor r=45.868 c=0
Rl1 (qint \2\:qint) resistor r=5.915 c=0
Rl35 (SEb \2\:SEb) resistor r=26.9231 c=0
Rl36 (\2\:SEb \3\:SEb) resistor r=148.376 c=0
Rl15 (\8\:qbint \9\:qbint) resistor r=62.2302 c=0
Rl16 (\9\:qbint \10\:qbint) resistor r=39.1533 c=0
Rl4 (qbint \2\:qbint) resistor r=41.3231 c=0
Rl7 (\2\:qbint \5\:qbint) resistor r=49.0154 c=0
Rl8 (\2\:qbint \6\:qbint) resistor r=5.6723 c=0
Rl9 (\3\:qbint \7\:qbint) resistor r=30.0028 c=0
Rl6 (\3\:qbint \4\:qbint) resistor r=58.8489 c=0
Rl5 (\2\:qbint \3\:qbint) resistor r=145.337 c=0
Rl23 (\2\:n20 \4\:n20) resistor r=36.2526 c=0
Rl22 (\2\:n20 \3\:n20) resistor r=82.4064 c=0
Rl21 (n20 \2\:n20) resistor r=2.7713 c=0
Rl11 (\2\:n30 \3\:n30) resistor r=58.4254 c=0
Rl10 (n30 \2\:n30) resistor r=49.9532 c=0
Rl26 (mout \2\:mout) resistor r=72.3097 c=0
Rl27 (\2\:mout \3\:mout) resistor r=26.1559 c=0
Rl81 (qint_2 \2\:qint_2) resistor r=38.1757 c=0
Rl83 (\2\:qint_2 \4\:qint_2) resistor r=45.868 c=0
Rl82 (\2\:qint_2 \3\:qint_2) resistor r=5.9102 c=0
Rl49 (\2\:SEb_2 \3\:SEb_2) resistor r=26.3736 c=0
Rl48 (SEb_2 \2\:SEb_2) resistor r=147.512 c=0
Rl68 (qbint_2 \2\:qbint_2) resistor r=62.2302 c=0
Rl69 (\2\:qbint_2 \3\:qbint_2) resistor r=39.1533 c=0
Rl75 (\4\:qbint_2 \5\:qbint_2) resistor r=30.0028 c=0
Rl78 (\5\:qbint_2 \8\:qbint_2) resistor r=58.8489 c=0
Rl80 (\6\:qbint_2 \10\:qbint_2) resistor r=41.3231 c=0
Rl79 (\6\:qbint_2 \9\:qbint_2) resistor r=49.0154 c=0
Rl77 (\6\:qbint_2 \7\:qbint_2) resistor r=5.6723 c=0
Rl76 (\5\:qbint_2 \6\:qbint_2) resistor r=145.337 c=0
Rl61 (n20_2 \2\:n20_2) resistor r=36.2526 c=0
Rl63 (\2\:n20_2 \4\:n20_2) resistor r=82.4064 c=0
Rl62 (\2\:n20_2 \3\:n20_2) resistor r=2.7666 c=0
Rl73 (n30_2 \2\:n30_2) resistor r=57.5621 c=0
Rl74 (\2\:n30_2 \3\:n30_2) resistor r=49.8142 c=0
Rl57 (mout_2 \2\:mout_2) resistor r=72.3097 c=0
Rl58 (\2\:mout_2 \3\:mout_2) resistor r=26.1559 c=0
Rl128 (qint_3 \2\:qint_3) resistor r=38.1757 c=0
Rl130 (\2\:qint_3 \4\:qint_3) resistor r=45.868 c=0
Rl129 (\2\:qint_3 \3\:qint_3) resistor r=5.9102 c=0
Rl96 (\2\:SEb_3 \3\:SEb_3) resistor r=26.3736 c=0
Rl95 (SEb_3 \2\:SEb_3) resistor r=147.512 c=0
Rl115 (qbint_3 \2\:qbint_3) resistor r=62.2302 c=0
Rl116 (\2\:qbint_3 \3\:qbint_3) resistor r=39.1533 c=0
Rl122 (\4\:qbint_3 \5\:qbint_3) resistor r=30.0028 c=0
Rl125 (\5\:qbint_3 \8\:qbint_3) resistor r=58.8489 c=0
Rl127 (\6\:qbint_3 \10\:qbint_3) resistor r=41.3231 c=0
Rl126 (\6\:qbint_3 \9\:qbint_3) resistor r=49.0154 c=0
Rl124 (\6\:qbint_3 \7\:qbint_3) resistor r=5.6723 c=0
Rl123 (\5\:qbint_3 \6\:qbint_3) resistor r=145.337 c=0
Rl108 (n20_3 \2\:n20_3) resistor r=36.2526 c=0
Rl110 (\2\:n20_3 \4\:n20_3) resistor r=82.4064 c=0
Rl109 (\2\:n20_3 \3\:n20_3) resistor r=2.7666 c=0
Rl120 (n30_3 \2\:n30_3) resistor r=57.5621 c=0
Rl121 (\2\:n30_3 \3\:n30_3) resistor r=49.8142 c=0
Rl104 (mout_3 \2\:mout_3) resistor r=72.3097 c=0
Rl105 (\2\:mout_3 \3\:mout_3) resistor r=26.1559 c=0
Rl170 (qint_4 \2\:qint_4) resistor r=38.1757 c=0
Rl172 (\2\:qint_4 \4\:qint_4) resistor r=45.868 c=0
Rl171 (\2\:qint_4 \3\:qint_4) resistor r=5.9102 c=0
Rl138 (\2\:SEb_4 \3\:SEb_4) resistor r=26.3736 c=0
Rl137 (SEb_4 \2\:SEb_4) resistor r=147.512 c=0
Rl157 (qbint_4 \2\:qbint_4) resistor r=62.2302 c=0
Rl158 (\2\:qbint_4 \3\:qbint_4) resistor r=39.1533 c=0
Rl164 (\4\:qbint_4 \5\:qbint_4) resistor r=30.0028 c=0
Rl167 (\5\:qbint_4 \8\:qbint_4) resistor r=58.8489 c=0
Rl169 (\6\:qbint_4 \10\:qbint_4) resistor r=41.3231 c=0
Rl168 (\6\:qbint_4 \9\:qbint_4) resistor r=49.0154 c=0
Rl166 (\6\:qbint_4 \7\:qbint_4) resistor r=5.6723 c=0
Rl165 (\5\:qbint_4 \6\:qbint_4) resistor r=145.337 c=0
Rl150 (n20_4 \2\:n20_4) resistor r=36.2526 c=0
Rl152 (\2\:n20_4 \4\:n20_4) resistor r=82.4064 c=0
Rl151 (\2\:n20_4 \3\:n20_4) resistor r=2.7666 c=0
Rl162 (n30_4 \2\:n30_4) resistor r=57.5621 c=0
Rl163 (\2\:n30_4 \3\:n30_4) resistor r=49.8142 c=0
Rl146 (mout_4 \2\:mout_4) resistor r=72.3097 c=0
Rl147 (\2\:mout_4 \3\:mout_4) resistor r=26.1559 c=0
Rz53 (\1\:VSS \2\:VSS) resistor r=75 c=0
Rz54 (\35\:VSS \36\:VSS) resistor r=75 c=0
Rz55 (\37\:VSS \38\:VSS) resistor r=75 c=0
Rz56 (\39\:VSS \40\:VSS) resistor r=75 c=0
Rz57 (\41\:VSS \42\:VSS) resistor r=75 c=0
Rz58 (\43\:VSS \44\:VSS) resistor r=75 c=0
Rz59 (\45\:VSS \46\:VSS) resistor r=75 c=0
Rz60 (\47\:VSS \48\:VSS) resistor r=75 c=0
Rz61 (\49\:VSS \50\:VSS) resistor r=75 c=0
Rz62 (\51\:VSS \52\:VSS) resistor r=75 c=0
Rz63 (\53\:VSS \54\:VSS) resistor r=75 c=0
Rz64 (\55\:VSS \56\:VSS) resistor r=75 c=0
Rz65 (\57\:VSS \58\:VSS) resistor r=75 c=0
Rz66 (\59\:VSS \60\:VSS) resistor r=75 c=0
Rz67 (\61\:VSS \62\:VSS) resistor r=75 c=0
Rz68 (\63\:VSS \64\:VSS) resistor r=75 c=0
Rz69 (\65\:VSS \66\:VSS) resistor r=75 c=0
Rz70 (\67\:VSS \68\:VSS) resistor r=75 c=0
Rz71 (\69\:VSS \70\:VSS) resistor r=75 c=0
Rz72 (\71\:VSS \72\:VSS) resistor r=75 c=0
Rz73 (\73\:VSS \74\:VSS) resistor r=75 c=0
Rz74 (\75\:VSS \76\:VSS) resistor r=75 c=0
Rz75 (\77\:VSS \78\:VSS) resistor r=75 c=0
Rz76 (\79\:VSS \80\:VSS) resistor r=75 c=0
Rz77 (\81\:VSS \82\:VSS) resistor r=75 c=0
Rz44 (\3\:VDD \4\:VDD) resistor r=9.375 c=0
Rz45 (\3\:VDD \8\:VDD) resistor r=6.25 c=0
Rz46 (\3\:VDD \23\:VDD) resistor r=6.25 c=0
Rz47 (\3\:VDD \36\:VDD) resistor r=6.25 c=0
Rz48 (\3\:VDD \46\:VDD) resistor r=6.25 c=0
Rz49 (\3\:VDD \56\:VDD) resistor r=6.25 c=0
Rz50 (\3\:VDD \68\:VDD) resistor r=6.25 c=0
Rz51 (\3\:VDD \78\:VDD) resistor r=6.25 c=0
Rz52 (\3\:VDD \88\:VDD) resistor r=6.25 c=0
Rz3 (\5\:Q1 \6\:Q1) resistor r=75 c=0
Rz1 (\1\:Q1N \2\:Q1N) resistor r=75 c=0
Rz18 (\7\:Q2 \8\:Q2) resistor r=75 c=0
Rz20 (\1\:Q2N \2\:Q2N) resistor r=75 c=0
Rz29 (\7\:Q3 \8\:Q3) resistor r=75 c=0
Rz31 (\1\:Q3N \2\:Q3N) resistor r=75 c=0
Rz43 (\1\:Q4N \2\:Q4N) resistor r=75 c=0
Rz39 (\3\:Q4 \4\:Q4) resistor r=75 c=0
Rz41 (\51\:CKb \52\:CKb) resistor r=75 c=0
Rz21 (\22\:Ckbb \23\:Ckbb) resistor r=75 c=0
Rz42 (\22\:Ckbb \39\:Ckbb) resistor r=37.5 c=0
Rz8 (\6\:Db \7\:Db) resistor r=75 c=0
Rz9 (\8\:Db \9\:Db) resistor r=75 c=0
Rz2 (\9\:qint \10\:qint) resistor r=75 c=0
Rz10 (\4\:SEb \5\:SEb) resistor r=75 c=0
Rz4 (\16\:qbint \17\:qbint) resistor r=75 c=0
Rz7 (\9\:n20 \10\:n20) resistor r=75 c=0
Rz5 (\6\:n30 \7\:n30) resistor r=75 c=0
Rz6 (\6\:mout \7\:mout) resistor r=75 c=0
Rz12 (Db_2 \2\:Db_2) resistor r=75 c=0
Rz13 (\8\:Db_2 \9\:Db_2) resistor r=75 c=0
Rz19 (\7\:qint_2 \8\:qint_2) resistor r=75 c=0
Rz11 (\7\:SEb_2 \8\:SEb_2) resistor r=75 c=0
Rz17 (\16\:qbint_2 \17\:qbint_2) resistor r=75 c=0
Rz14 (\9\:n20_2 \10\:n20_2) resistor r=75 c=0
Rz16 (\6\:n30_2 \7\:n30_2) resistor r=75 c=0
Rz15 (\8\:mout_2 \9\:mout_2) resistor r=75 c=0
Rz23 (Db_3 \2\:Db_3) resistor r=75 c=0
Rz24 (\8\:Db_3 \9\:Db_3) resistor r=75 c=0
Rz30 (\7\:qint_3 \8\:qint_3) resistor r=75 c=0
Rz22 (\7\:SEb_3 \8\:SEb_3) resistor r=75 c=0
Rz28 (\16\:qbint_3 \17\:qbint_3) resistor r=75 c=0
Rz25 (\9\:n20_3 \10\:n20_3) resistor r=75 c=0
Rz27 (\6\:n30_3 \7\:n30_3) resistor r=75 c=0
Rz26 (\8\:mout_3 \9\:mout_3) resistor r=75 c=0
Rz33 (Db_4 \2\:Db_4) resistor r=75 c=0
Rz34 (\8\:Db_4 \9\:Db_4) resistor r=75 c=0
Rz40 (\7\:qint_4 \8\:qint_4) resistor r=75 c=0
Rz32 (\7\:SEb_4 \8\:SEb_4) resistor r=75 c=0
Rz38 (\16\:qbint_4 \17\:qbint_4) resistor r=75 c=0
Rz35 (\9\:n20_4 \10\:n20_4) resistor r=75 c=0
Rz37 (\6\:n30_4 \7\:n30_4) resistor r=75 c=0
Rz36 (\8\:mout_4 \9\:mout_4) resistor r=75 c=0
Ry83 (\3\:VSS \4\:VSS) resistor r=7.75 c=0
Ry84 (\3\:VSS \8\:VSS) resistor r=5.1667 c=0
Ry85 (\3\:VSS \11\:VSS) resistor r=5.1667 c=0
Ry86 (\3\:VSS \15\:VSS) resistor r=5.1667 c=0
Ry87 (\3\:VSS \18\:VSS) resistor r=5.1667 c=0
Ry88 (\3\:VSS \22\:VSS) resistor r=5.1667 c=0
Ry89 (\3\:VSS \25\:VSS) resistor r=5.1667 c=0
Ry90 (\3\:VSS \29\:VSS) resistor r=5.1667 c=0
Ry91 (\3\:VSS \32\:VSS) resistor r=5.1667 c=0
Ry54 (\1\:VDD \2\:VDD) resistor r=62 c=0
Ry55 (\9\:VDD \10\:VDD) resistor r=62 c=0
Ry56 (\11\:VDD \12\:VDD) resistor r=62 c=0
Ry57 (\13\:VDD \14\:VDD) resistor r=62 c=0
Ry58 (\15\:VDD \16\:VDD) resistor r=62 c=0
Ry59 (\18\:VDD \19\:VDD) resistor r=62 c=0
Ry60 (\21\:VDD \22\:VDD) resistor r=62 c=0
Ry61 (\25\:VDD \26\:VDD) resistor r=62 c=0
Ry62 (\28\:VDD \29\:VDD) resistor r=62 c=0
Ry63 (\31\:VDD \32\:VDD) resistor r=62 c=0
Ry64 (\34\:VDD \35\:VDD) resistor r=62 c=0
Ry65 (\38\:VDD \39\:VDD) resistor r=62 c=0
Ry66 (\41\:VDD \42\:VDD) resistor r=62 c=0
Ry67 (\44\:VDD \45\:VDD) resistor r=62 c=0
Ry68 (\48\:VDD \49\:VDD) resistor r=62 c=0
Ry69 (\51\:VDD \52\:VDD) resistor r=62 c=0
Ry70 (\54\:VDD \55\:VDD) resistor r=62 c=0
Ry71 (\57\:VDD \58\:VDD) resistor r=62 c=0
Ry72 (\60\:VDD \61\:VDD) resistor r=62 c=0
Ry73 (\63\:VDD \64\:VDD) resistor r=62 c=0
Ry74 (\66\:VDD \67\:VDD) resistor r=62 c=0
Ry75 (\70\:VDD \71\:VDD) resistor r=62 c=0
Ry76 (\73\:VDD \74\:VDD) resistor r=62 c=0
Ry77 (\76\:VDD \77\:VDD) resistor r=62 c=0
Ry78 (\80\:VDD \81\:VDD) resistor r=62 c=0
Ry79 (\83\:VDD \84\:VDD) resistor r=62 c=0
Ry80 (\86\:VDD \87\:VDD) resistor r=62 c=0
Ry81 (\90\:VDD \91\:VDD) resistor r=62 c=0
Ry82 (\93\:VDD \94\:VDD) resistor r=62 c=0
Ry3 (\7\:Q1 \8\:Q1) resistor r=31 c=0
Ry13 (\7\:Q1 \10\:Q1) resistor r=62 c=0
Ry1 (\3\:Q1N \4\:Q1N) resistor r=31 c=0
Ry23 (\5\:Q2 \6\:Q2) resistor r=31 c=0
Ry27 (\5\:Q2 \10\:Q2) resistor r=62 c=0
Ry25 (\3\:Q2N \4\:Q2N) resistor r=31 c=0
Ry37 (\5\:Q3 \6\:Q3) resistor r=31 c=0
Ry40 (\5\:Q3 \10\:Q3) resistor r=62 c=0
Ry39 (\3\:Q3N \4\:Q3N) resistor r=31 c=0
Ry53 (\3\:Q4N \4\:Q4N) resistor r=31 c=0
Ry50 (\1\:Q4 \2\:Q4) resistor r=31 c=0
Ry52 (\56\:CKb \57\:CKb) resistor r=62 c=0
Ry26 (\24\:Ckbb \25\:Ckbb) resistor r=62 c=0
Ry10 (Db \2\:Db) resistor r=62 c=0
Ry11 (\4\:Db \5\:Db) resistor r=62 c=0
Ry2 (\5\:qint \6\:qint) resistor r=62 c=0
Ry7 (n6 \2\:n6) resistor r=62 c=0
Ry8 (\3\:n6 \4\:n6) resistor r=62 c=0
Ry12 (\6\:SEb \7\:SEb) resistor r=62 c=0
Ry4 (\12\:qbint \13\:qbint) resistor r=62 c=0
Ry9 (\5\:n20 \6\:n20) resistor r=62 c=0
Ry5 (\4\:n30 \5\:n30) resistor r=62 c=0
Ry6 (\8\:mout \9\:mout) resistor r=62 c=0
Ry15 (\4\:Db_2 \5\:Db_2) resistor r=62 c=0
Ry16 (\6\:Db_2 \7\:Db_2) resistor r=62 c=0
Ry24 (\9\:qint_2 \10\:qint_2) resistor r=62 c=0
Ry17 (n6_2 \2\:n6_2) resistor r=62 c=0
Ry18 (\3\:n6_2 \4\:n6_2) resistor r=62 c=0
Ry14 (\5\:SEb_2 \6\:SEb_2) resistor r=62 c=0
Ry22 (\13\:qbint_2 \14\:qbint_2) resistor r=62 c=0
Ry19 (\7\:n20_2 \8\:n20_2) resistor r=62 c=0
Ry21 (\4\:n30_2 \5\:n30_2) resistor r=62 c=0
Ry20 (\4\:mout_2 \5\:mout_2) resistor r=62 c=0
Ry29 (\4\:Db_3 \5\:Db_3) resistor r=62 c=0
Ry30 (\6\:Db_3 \7\:Db_3) resistor r=62 c=0
Ry38 (\9\:qint_3 \10\:qint_3) resistor r=62 c=0
Ry31 (n6_3 \2\:n6_3) resistor r=62 c=0
Ry32 (\3\:n6_3 \4\:n6_3) resistor r=62 c=0
Ry28 (\5\:SEb_3 \6\:SEb_3) resistor r=62 c=0
Ry36 (\13\:qbint_3 \14\:qbint_3) resistor r=62 c=0
Ry33 (\7\:n20_3 \8\:n20_3) resistor r=62 c=0
Ry35 (\4\:n30_3 \5\:n30_3) resistor r=62 c=0
Ry34 (\4\:mout_3 \5\:mout_3) resistor r=62 c=0
Ry42 (\4\:Db_4 \5\:Db_4) resistor r=62 c=0
Ry43 (\6\:Db_4 \7\:Db_4) resistor r=62 c=0
Ry51 (\9\:qint_4 \10\:qint_4) resistor r=62 c=0
Ry44 (n6_4 \2\:n6_4) resistor r=62 c=0
Ry45 (\3\:n6_4 \4\:n6_4) resistor r=62 c=0
Ry41 (\5\:SEb_4 \6\:SEb_4) resistor r=62 c=0
Ry49 (\13\:qbint_4 \14\:qbint_4) resistor r=62 c=0
Ry46 (\7\:n20_4 \8\:n20_4) resistor r=62 c=0
Ry48 (\4\:n30_4 \5\:n30_4) resistor r=62 c=0
Ry47 (\4\:mout_4 \5\:mout_4) resistor r=62 c=0
Rx19 (\2\:CK \4\:CK) resistor r=45 c=0
Rx59 (\28\:SE \29\:SE) resistor r=45 c=0
Rx60 (\26\:SE \30\:SE) resistor r=45 c=0
Rx61 (\4\:SE \37\:SE) resistor r=45 c=0
Rx62 (\2\:SE \38\:SE) resistor r=45 c=0
Rx63 (\23\:SE \39\:SE) resistor r=45 c=0
Rx64 (\19\:SE \40\:SE) resistor r=45 c=0
Rx65 (\21\:SE \41\:SE) resistor r=45 c=0
Rx66 (\16\:SE \42\:SE) resistor r=45 c=0
Rx67 (\12\:SE \43\:SE) resistor r=45 c=0
Rx68 (\14\:SE \44\:SE) resistor r=45 c=0
Rx69 (\9\:SE \45\:SE) resistor r=45 c=0
Rx70 (\6\:SE \46\:SE) resistor r=45 c=0
Rx51 (\28\:RN \29\:RN) resistor r=45 c=0
Rx52 (\22\:RN \30\:RN) resistor r=45 c=0
Rx53 (\21\:RN \31\:RN) resistor r=45 c=0
Rx54 (\15\:RN \32\:RN) resistor r=45 c=0
Rx55 (\14\:RN \33\:RN) resistor r=45 c=0
Rx56 (\8\:RN \34\:RN) resistor r=45 c=0
Rx57 (\7\:RN \36\:RN) resistor r=45 c=0
Rx58 (\4\:RN \37\:RN) resistor r=45 c=0
Rx10 (\4\:Q1 \9\:Q1) resistor r=45 c=0
Rx7 (\2\:D1 \4\:D1) resistor r=45 c=0
Rx8 (\2\:SI \5\:SI) resistor r=45 c=0
Rx20 (\4\:Q2 \9\:Q2) resistor r=45 c=0
Rx12 (\2\:D2 \4\:D2) resistor r=45 c=0
Rx29 (\4\:Q3 \9\:Q3) resistor r=45 c=0
Rx22 (\2\:D3 \4\:D3) resistor r=45 c=0
Rx31 (\2\:D4 \4\:D4) resistor r=45 c=0
Rx38 (\32\:CKb \33\:CKb) resistor r=45 c=0
Rx39 (\28\:CKb \35\:CKb) resistor r=45 c=0
Rx40 (\21\:CKb \38\:CKb) resistor r=45 c=0
Rx41 (\10\:CKb \42\:CKb) resistor r=45 c=0
Rx42 (\5\:CKb \43\:CKb) resistor r=45 c=0
Rx43 (\2\:CKb \45\:CKb) resistor r=45 c=0
Rx44 (\30\:CKb \46\:CKb) resistor r=45 c=0
Rx45 (\25\:CKb \47\:CKb) resistor r=45 c=0
Rx46 (\23\:CKb \48\:CKb) resistor r=45 c=0
Rx47 (\17\:CKb \50\:CKb) resistor r=45 c=0
Rx48 (\14\:CKb \53\:CKb) resistor r=45 c=0
Rx49 (\12\:CKb \54\:CKb) resistor r=45 c=0
Rx50 (\4\:CKb \55\:CKb) resistor r=45 c=0
Rx71 (\32\:Ckbb \33\:Ckbb) resistor r=45 c=0
Rx72 (\29\:Ckbb \34\:Ckbb) resistor r=45 c=0
Rx73 (\27\:Ckbb \35\:Ckbb) resistor r=45 c=0
Rx74 (\21\:Ckbb \36\:Ckbb) resistor r=45 c=0
Rx75 (\18\:Ckbb \37\:Ckbb) resistor r=45 c=0
Rx76 (\16\:Ckbb \38\:Ckbb) resistor r=45 c=0
Rx77 (\14\:Ckbb \40\:Ckbb) resistor r=45 c=0
Rx78 (\11\:Ckbb \41\:Ckbb) resistor r=45 c=0
Rx79 (\9\:Ckbb \42\:Ckbb) resistor r=45 c=0
Rx80 (\7\:Ckbb \43\:Ckbb) resistor r=45 c=0
Rx81 (\5\:Ckbb \44\:Ckbb) resistor r=45 c=0
Rx82 (Ckbb \45\:Ckbb) resistor r=45 c=0
Rx1 (qint \8\:qint) resistor r=45 c=0
Rx9 (\2\:SEb \8\:SEb) resistor r=45 c=0
Rx2 (\9\:qbint \11\:qbint) resistor r=45 c=0
Rx3 (\6\:qbint \15\:qbint) resistor r=45 c=0
Rx6 (n20 \8\:n20) resistor r=45 c=0
Rx4 (\2\:n30 \8\:n30) resistor r=45 c=0
Rx5 (\2\:mout \4\:mout) resistor r=45 c=0
Rx18 (\3\:qint_2 \5\:qint_2) resistor r=45 c=0
Rx11 (\2\:SEb_2 \4\:SEb_2) resistor r=45 c=0
Rx16 (\7\:qbint_2 \11\:qbint_2) resistor r=45 c=0
Rx17 (\2\:qbint_2 \15\:qbint_2) resistor r=45 c=0
Rx13 (\3\:n20_2 \5\:n20_2) resistor r=45 c=0
Rx15 (\2\:n30_2 \8\:n30_2) resistor r=45 c=0
Rx14 (\2\:mout_2 \7\:mout_2) resistor r=45 c=0
Rx28 (\3\:qint_3 \5\:qint_3) resistor r=45 c=0
Rx21 (\2\:SEb_3 \4\:SEb_3) resistor r=45 c=0
Rx26 (\7\:qbint_3 \11\:qbint_3) resistor r=45 c=0
Rx27 (\2\:qbint_3 \15\:qbint_3) resistor r=45 c=0
Rx23 (\3\:n20_3 \5\:n20_3) resistor r=45 c=0
Rx25 (\2\:n30_3 \8\:n30_3) resistor r=45 c=0
Rx24 (\2\:mout_3 \7\:mout_3) resistor r=45 c=0
Rx37 (\3\:qint_4 \5\:qint_4) resistor r=45 c=0
Rx30 (\2\:SEb_4 \4\:SEb_4) resistor r=45 c=0
Rx35 (\7\:qbint_4 \11\:qbint_4) resistor r=45 c=0
Rx36 (\2\:qbint_4 \15\:qbint_4) resistor r=45 c=0
Rx32 (\3\:n20_4 \5\:n20_4) resistor r=45 c=0
Rx34 (\2\:n30_4 \8\:n30_4) resistor r=45 c=0
Rx33 (\2\:mout_4 \7\:mout_4) resistor r=45 c=0
NM38 (\1\:Q4N \4\:qint_4 \1\:VSS VSS) g45n1svt w=(2.6e-07) l=4.5e-08 \
        nf=1 as=7.48e-14 ad=3.64e-14 ps=1.6e-06 pd=8e-07 nrd=1.16667 \
        nrs=1.16667 sa=2.66058e-07 sb=1.4e-07 sd=160n sca=17.5885 \
        scb=0.0172826 scc=0.00162584 m=(1)
NM40 (\3\:Q4 \9\:qbint_4 \35\:VSS VSS) g45n1svt w=(2.6e-07) l=4.5e-08 \
        nf=1 as=6.97e-14 ad=3.64e-14 ps=1.5e-06 pd=8e-07 nrd=1.16667 \
        nrs=1.16667 sa=1.4e-07 sb=1.4e-07 sd=160n sca=17.5885 \
        scb=0.0172826 scc=0.00162584 m=(1)
NM37 (\1\:Q3N \4\:qint_3 \45\:VSS VSS) g45n1svt w=(2.6e-07) l=4.5e-08 \
        nf=1 as=7.48e-14 ad=3.64e-14 ps=1.6e-06 pd=8e-07 nrd=1.16667 \
        nrs=1.16667 sa=2.66058e-07 sb=1.4e-07 sd=160n sca=17.5885 \
        scb=0.0172826 scc=0.00162584 m=(1)
NM35 (\7\:Q3 \9\:qbint_3 \47\:VSS VSS) g45n1svt w=(2.6e-07) l=4.5e-08 \
        nf=1 as=6.97e-14 ad=3.64e-14 ps=1.5e-06 pd=8e-07 nrd=1.16667 \
        nrs=1.16667 sa=1.4e-07 sb=1.4e-07 sd=160n sca=17.5885 \
        scb=0.0172826 scc=0.00162584 m=(1)
NM19 (\1\:Q2N \4\:qint_2 \59\:VSS VSS) g45n1svt w=(2.6e-07) l=4.5e-08 \
        nf=1 as=7.48e-14 ad=3.64e-14 ps=1.6e-06 pd=8e-07 nrd=1.16667 \
        nrs=1.16667 sa=2.66058e-07 sb=1.4e-07 sd=160n sca=17.5885 \
        scb=0.0172826 scc=0.00162584 m=(1)
NM17 (\7\:Q2 \9\:qbint_2 \61\:VSS VSS) g45n1svt w=(2.6e-07) l=4.5e-08 \
        nf=1 as=6.97e-14 ad=3.64e-14 ps=1.5e-06 pd=8e-07 nrd=1.16667 \
        nrs=1.16667 sa=1.4e-07 sb=1.4e-07 sd=160n sca=17.5885 \
        scb=0.0172826 scc=0.00162584 m=(1)
mn57 (\1\:Q1N \3\:qint \81\:VSS VSS) g45n1svt w=(2.6e-07) l=4.5e-08 nf=1 \
        as=7.48e-14 ad=3.64e-14 ps=1.6e-06 pd=8e-07 nrd=1.16667 \
        nrs=1.16667 sa=2.66058e-07 sb=1.4e-07 sd=160n sca=17.5885 \
        scb=0.0172826 scc=0.00162584 m=(1)
mn55 (\5\:Q1 \5\:qbint \79\:VSS VSS) g45n1svt w=(2.6e-07) l=4.5e-08 nf=1 \
        as=6.97e-14 ad=3.64e-14 ps=1.5e-06 pd=8e-07 nrd=1.16667 \
        nrs=1.16667 sa=1.4e-07 sb=1.4e-07 sd=160n sca=17.5885 \
        scb=0.0172826 scc=0.00162584 m=(1)
NM39 (\7\:qint_4 \8\:qbint_4 \1\:VSS VSS) g45n1svt w=(1.45e-07) \
        l=4.5e-08 nf=1 as=2.03e-14 ad=7.48e-14 ps=5.7e-07 pd=1.6e-06 \
        nrd=1.16667 nrs=1.16667 sa=3.7e-07 sb=1.4e-07 sd=160n sca=23.279 \
        scb=0.0230742 scc=0.00267719 m=(1)
NM44 (\16\:qbint_4 \3\:n30_4 n9_4 VSS) g45n1svt w=(1.45e-07) l=4.5e-08 \
        nf=1 as=1.45e-14 ad=2.392e-14 ps=4.9e-07 pd=6.2e-07 nrd=1.16667 \
        nrs=1.16667 sa=2e-06 sb=1.65e-07 sd=160n sca=15.7071 scb=0.0167369 \
        scc=0.00113434 m=(1)
NM43 (n9_4 \25\:RN \37\:VSS VSS) g45n1svt w=(1.45e-07) l=4.5e-08 nf=1 \
        as=7.75e-14 ad=1.45e-14 ps=1.49e-06 pd=4.9e-07 nrd=1.16667 \
        nrs=1.16667 sa=1.91e-06 sb=3.1e-07 sd=160n sca=15.7071 \
        scb=0.0167369 scc=0.00113434 m=(1)
NM42 (n11_4 \3\:qbint_4 \37\:VSS VSS) g45n1svt w=(1.45e-07) l=4.5e-08 \
        nf=1 as=7.75e-14 ad=1.957e-14 ps=1.49e-06 pd=5.6e-07 nrd=1.16667 \
        nrs=1.16667 sa=1.645e-06 sb=5.75e-07 sd=160n sca=15.7071 \
        scb=0.0167369 scc=0.00113434 m=(1)
NM41 (\6\:n30_4 \31\:CKb n11_4 VSS) g45n1svt w=(1.45e-07) l=4.5e-08 nf=1 \
        as=1.957e-14 ad=2.9e-14 ps=5.6e-07 pd=6.9e-07 nrd=1.16667 \
        nrs=1.16667 sa=1.465e-06 sb=7.55e-07 sd=160n sca=15.7071 \
        scb=0.0167369 scc=0.00113434 m=(1)
NM45 (\8\:mout_4 \31\:Ckbb \6\:n30_4 VSS) g45n1svt w=(1.45e-07) l=4.5e-08 \
        nf=1 as=2.9e-14 ad=3.335e-14 ps=6.9e-07 pd=7.5e-07 nrd=1.16667 \
        nrs=1.16667 sa=1.22e-06 sb=1e-06 sd=160n sca=15.7071 scb=0.0167369 \
        scc=0.00113434 m=(1)
NM49 (\8\:mout_4 \4\:n20_4 \39\:VSS VSS) g45n1svt w=(1.45e-07) l=4.5e-08 \
        nf=1 as=8.475e-14 ad=3.335e-14 ps=1.59e-06 pd=7.5e-07 nrd=1.16667 \
        nrs=1.16667 sa=9.45e-07 sb=1.275e-06 sd=160n sca=15.7071 \
        scb=0.0167369 scc=0.00113434 m=(1)
NM47 (n7_4 \24\:RN \39\:VSS VSS) g45n1svt w=(1.45e-07) l=4.5e-08 nf=1 \
        as=8.475e-14 ad=8.7e-15 ps=1.59e-06 pd=4.1e-07 nrd=1.16667 \
        nrs=1.16667 sa=6.3e-07 sb=1.59e-06 sd=160n sca=15.7071 \
        scb=0.0167369 scc=0.00113434 m=(1)
NM46 (n5_4 \3\:mout_4 n7_4 VSS) g45n1svt w=(1.45e-07) l=4.5e-08 nf=1 \
        as=8.7e-15 ad=1.957e-14 ps=4.1e-07 pd=5.6e-07 nrd=1.16667 \
        nrs=1.16667 sa=5.25e-07 sb=1.695e-06 sd=160n sca=15.7071 \
        scb=0.0167369 scc=0.00113434 m=(1)
NM48 (\9\:n20_4 \28\:Ckbb n5_4 VSS) g45n1svt w=(1.45e-07) l=4.5e-08 nf=1 \
        as=2.32e-14 ad=1.957e-14 ps=6.1e-07 pd=5.6e-07 nrd=1.16667 \
        nrs=1.16667 sa=1.875e-06 sb=3.45e-07 sd=160n sca=15.7071 \
        scb=0.0167369 scc=0.00113434 m=(1)
NM50 (\8\:Db_4 \26\:CKb \9\:n20_4 VSS) g45n1svt w=(1.45e-07) l=4.5e-08 \
        nf=1 as=2.32e-14 ad=2.03e-14 ps=6.1e-07 pd=5.7e-07 nrd=1.16667 \
        nrs=1.16667 sa=1.4e-07 sb=2e-06 sd=160n sca=15.7071 scb=0.0167369 \
        scc=0.00113434 m=(1)
NM54 (n1_4 \3\:D4 \41\:VSS VSS) g45n1svt w=(1.45e-07) l=4.5e-08 nf=1 \
        as=5.027e-14 ad=2.03e-14 ps=1.33e-06 pd=5.7e-07 nrd=1.16667 \
        nrs=1.16667 sa=8.86379e-07 sb=1.25e-07 sd=160n sca=12.9138 \
        scb=0.0133404 scc=0.000640143 m=(1)
NM53 (Db_4 SEb_4 n1_4 VSS) g45n1svt w=(1.45e-07) l=4.5e-08 nf=1 \
        as=2.03e-14 ad=3.77e-14 ps=5.7e-07 pd=8.1e-07 nrd=1.16667 \
        nrs=1.16667 sa=7.01379e-07 sb=3.1e-07 sd=160n sca=12.9138 \
        scb=0.0133404 scc=0.000640143 m=(1)
NM52 (Db_4 \25\:SE n3_4 VSS) g45n1svt w=(1.45e-07) l=4.5e-08 nf=1 \
        as=8.7e-15 ad=3.77e-14 ps=4.1e-07 pd=8.1e-07 nrd=1.16667 \
        nrs=1.16667 sa=3.96379e-07 sb=6.15e-07 sd=160n sca=12.9138 \
        scb=0.0133404 scc=0.000640143 m=(1)
NM51 (n3_4 \1\:Q3 \43\:VSS VSS) g45n1svt w=(1.45e-07) l=4.5e-08 nf=1 \
        as=7.87e-14 ad=8.7e-15 ps=1.6e-06 pd=4.1e-07 nrd=1.16667 \
        nrs=1.16667 sa=2.91379e-07 sb=7.2e-07 sd=160n sca=12.9138 \
        scb=0.0133404 scc=0.000640143 m=(1)
NM55 (\7\:SEb_4 \24\:SE \43\:VSS VSS) g45n1svt w=(1.45e-07) l=4.5e-08 \
        nf=1 as=7.87e-14 ad=3.262e-14 ps=1.6e-06 pd=7.4e-07 nrd=1.16667 \
        nrs=1.16667 sa=2.25e-07 sb=4.41897e-07 sd=160n sca=23.279 \
        scb=0.0230742 scc=0.00267719 m=(1)
NM36 (\7\:qint_3 \8\:qbint_3 \45\:VSS VSS) g45n1svt w=(1.45e-07) \
        l=4.5e-08 nf=1 as=2.03e-14 ad=7.48e-14 ps=5.7e-07 pd=1.6e-06 \
        nrd=1.16667 nrs=1.16667 sa=3.7e-07 sb=1.4e-07 sd=160n sca=23.279 \
        scb=0.0230742 scc=0.00267719 m=(1)
NM31 (\16\:qbint_3 \3\:n30_3 n9_3 VSS) g45n1svt w=(1.45e-07) l=4.5e-08 \
        nf=1 as=1.45e-14 ad=2.392e-14 ps=4.9e-07 pd=6.2e-07 nrd=1.16667 \
        nrs=1.16667 sa=2e-06 sb=1.65e-07 sd=160n sca=15.7071 scb=0.0167369 \
        scc=0.00113434 m=(1)
NM32 (n9_3 \18\:RN \49\:VSS VSS) g45n1svt w=(1.45e-07) l=4.5e-08 nf=1 \
        as=7.75e-14 ad=1.45e-14 ps=1.49e-06 pd=4.9e-07 nrd=1.16667 \
        nrs=1.16667 sa=1.91e-06 sb=3.1e-07 sd=160n sca=15.7071 \
        scb=0.0167369 scc=0.00113434 m=(1)
NM33 (n11_3 \3\:qbint_3 \49\:VSS VSS) g45n1svt w=(1.45e-07) l=4.5e-08 \
        nf=1 as=7.75e-14 ad=1.957e-14 ps=1.49e-06 pd=5.6e-07 nrd=1.16667 \
        nrs=1.16667 sa=1.645e-06 sb=5.75e-07 sd=160n sca=15.7071 \
        scb=0.0167369 scc=0.00113434 m=(1)
NM34 (\6\:n30_3 \24\:CKb n11_3 VSS) g45n1svt w=(1.45e-07) l=4.5e-08 nf=1 \
        as=1.957e-14 ad=2.9e-14 ps=5.6e-07 pd=6.9e-07 nrd=1.16667 \
        nrs=1.16667 sa=1.465e-06 sb=7.55e-07 sd=160n sca=15.7071 \
        scb=0.0167369 scc=0.00113434 m=(1)
NM30 (\8\:mout_3 \20\:Ckbb \6\:n30_3 VSS) g45n1svt w=(1.45e-07) l=4.5e-08 \
        nf=1 as=2.9e-14 ad=3.335e-14 ps=6.9e-07 pd=7.5e-07 nrd=1.16667 \
        nrs=1.16667 sa=1.22e-06 sb=1e-06 sd=160n sca=15.7071 scb=0.0167369 \
        scc=0.00113434 m=(1)
NM26 (\8\:mout_3 \4\:n20_3 \51\:VSS VSS) g45n1svt w=(1.45e-07) l=4.5e-08 \
        nf=1 as=8.475e-14 ad=3.335e-14 ps=1.59e-06 pd=7.5e-07 nrd=1.16667 \
        nrs=1.16667 sa=9.45e-07 sb=1.275e-06 sd=160n sca=15.7071 \
        scb=0.0167369 scc=0.00113434 m=(1)
NM28 (n7_3 \17\:RN \51\:VSS VSS) g45n1svt w=(1.45e-07) l=4.5e-08 nf=1 \
        as=8.475e-14 ad=8.7e-15 ps=1.59e-06 pd=4.1e-07 nrd=1.16667 \
        nrs=1.16667 sa=6.3e-07 sb=1.59e-06 sd=160n sca=15.7071 \
        scb=0.0167369 scc=0.00113434 m=(1)
NM29 (n5_3 \3\:mout_3 n7_3 VSS) g45n1svt w=(1.45e-07) l=4.5e-08 nf=1 \
        as=8.7e-15 ad=1.957e-14 ps=4.1e-07 pd=5.6e-07 nrd=1.16667 \
        nrs=1.16667 sa=5.25e-07 sb=1.695e-06 sd=160n sca=15.7071 \
        scb=0.0167369 scc=0.00113434 m=(1)
NM27 (\9\:n20_3 \17\:Ckbb n5_3 VSS) g45n1svt w=(1.45e-07) l=4.5e-08 nf=1 \
        as=2.32e-14 ad=1.957e-14 ps=6.1e-07 pd=5.6e-07 nrd=1.16667 \
        nrs=1.16667 sa=1.875e-06 sb=3.45e-07 sd=160n sca=15.7071 \
        scb=0.0167369 scc=0.00113434 m=(1)
NM25 (\8\:Db_3 \19\:CKb \9\:n20_3 VSS) g45n1svt w=(1.45e-07) l=4.5e-08 \
        nf=1 as=2.32e-14 ad=2.03e-14 ps=6.1e-07 pd=5.7e-07 nrd=1.16667 \
        nrs=1.16667 sa=1.4e-07 sb=2e-06 sd=160n sca=15.7071 scb=0.0167369 \
        scc=0.00113434 m=(1)
NM21 (n1_3 \3\:D3 \53\:VSS VSS) g45n1svt w=(1.45e-07) l=4.5e-08 nf=1 \
        as=5.027e-14 ad=2.03e-14 ps=1.33e-06 pd=5.7e-07 nrd=1.16667 \
        nrs=1.16667 sa=8.86379e-07 sb=1.25e-07 sd=160n sca=12.9138 \
        scb=0.0133404 scc=0.000640143 m=(1)
NM22 (Db_3 SEb_3 n1_3 VSS) g45n1svt w=(1.45e-07) l=4.5e-08 nf=1 \
        as=2.03e-14 ad=3.77e-14 ps=5.7e-07 pd=8.1e-07 nrd=1.16667 \
        nrs=1.16667 sa=7.01379e-07 sb=3.1e-07 sd=160n sca=12.9138 \
        scb=0.0133404 scc=0.000640143 m=(1)
NM23 (Db_3 \18\:SE n3_3 VSS) g45n1svt w=(1.45e-07) l=4.5e-08 nf=1 \
        as=8.7e-15 ad=3.77e-14 ps=4.1e-07 pd=8.1e-07 nrd=1.16667 \
        nrs=1.16667 sa=3.96379e-07 sb=6.15e-07 sd=160n sca=12.9138 \
        scb=0.0133404 scc=0.000640143 m=(1)
NM24 (n3_3 \1\:Q2 \55\:VSS VSS) g45n1svt w=(1.45e-07) l=4.5e-08 nf=1 \
        as=7.87e-14 ad=8.7e-15 ps=1.6e-06 pd=4.1e-07 nrd=1.16667 \
        nrs=1.16667 sa=2.91379e-07 sb=7.2e-07 sd=160n sca=12.9138 \
        scb=0.0133404 scc=0.000640143 m=(1)
NM20 (\7\:SEb_3 \17\:SE \55\:VSS VSS) g45n1svt w=(1.45e-07) l=4.5e-08 \
        nf=1 as=7.87e-14 ad=3.262e-14 ps=1.6e-06 pd=7.4e-07 nrd=1.16667 \
        nrs=1.16667 sa=2.25e-07 sb=4.41897e-07 sd=160n sca=23.279 \
        scb=0.0230742 scc=0.00267719 m=(1)
NM18 (\7\:qint_2 \8\:qbint_2 \59\:VSS VSS) g45n1svt w=(1.45e-07) \
        l=4.5e-08 nf=1 as=2.03e-14 ad=7.48e-14 ps=5.7e-07 pd=1.6e-06 \
        nrd=1.16667 nrs=1.16667 sa=3.7e-07 sb=1.4e-07 sd=160n sca=23.279 \
        scb=0.0230742 scc=0.00267719 m=(1)
NM13 (\16\:qbint_2 \3\:n30_2 n9_2 VSS) g45n1svt w=(1.45e-07) l=4.5e-08 \
        nf=1 as=1.45e-14 ad=2.392e-14 ps=4.9e-07 pd=6.2e-07 nrd=1.16667 \
        nrs=1.16667 sa=2e-06 sb=1.65e-07 sd=160n sca=15.7071 scb=0.0167369 \
        scc=0.00113434 m=(1)
NM14 (n9_2 \11\:RN \63\:VSS VSS) g45n1svt w=(1.45e-07) l=4.5e-08 nf=1 \
        as=7.75e-14 ad=1.45e-14 ps=1.49e-06 pd=4.9e-07 nrd=1.16667 \
        nrs=1.16667 sa=1.91e-06 sb=3.1e-07 sd=160n sca=15.7071 \
        scb=0.0167369 scc=0.00113434 m=(1)
NM15 (n11_2 \3\:qbint_2 \63\:VSS VSS) g45n1svt w=(1.45e-07) l=4.5e-08 \
        nf=1 as=7.75e-14 ad=1.957e-14 ps=1.49e-06 pd=5.6e-07 nrd=1.16667 \
        nrs=1.16667 sa=1.645e-06 sb=5.75e-07 sd=160n sca=15.7071 \
        scb=0.0167369 scc=0.00113434 m=(1)
NM16 (\6\:n30_2 \13\:CKb n11_2 VSS) g45n1svt w=(1.45e-07) l=4.5e-08 nf=1 \
        as=1.957e-14 ad=2.9e-14 ps=5.6e-07 pd=6.9e-07 nrd=1.16667 \
        nrs=1.16667 sa=1.465e-06 sb=7.55e-07 sd=160n sca=15.7071 \
        scb=0.0167369 scc=0.00113434 m=(1)
NM12 (\8\:mout_2 \13\:Ckbb \6\:n30_2 VSS) g45n1svt w=(1.45e-07) l=4.5e-08 \
        nf=1 as=2.9e-14 ad=3.335e-14 ps=6.9e-07 pd=7.5e-07 nrd=1.16667 \
        nrs=1.16667 sa=1.22e-06 sb=1e-06 sd=160n sca=15.7071 scb=0.0167369 \
        scc=0.00113434 m=(1)
NM8 (\8\:mout_2 \4\:n20_2 \65\:VSS VSS) g45n1svt w=(1.45e-07) l=4.5e-08 \
        nf=1 as=8.475e-14 ad=3.335e-14 ps=1.59e-06 pd=7.5e-07 nrd=1.16667 \
        nrs=1.16667 sa=9.45e-07 sb=1.275e-06 sd=160n sca=15.7071 \
        scb=0.0167369 scc=0.00113434 m=(1)
NM10 (n7_2 \10\:RN \65\:VSS VSS) g45n1svt w=(1.45e-07) l=4.5e-08 nf=1 \
        as=8.475e-14 ad=8.7e-15 ps=1.59e-06 pd=4.1e-07 nrd=1.16667 \
        nrs=1.16667 sa=6.3e-07 sb=1.59e-06 sd=160n sca=15.7071 \
        scb=0.0167369 scc=0.00113434 m=(1)
NM11 (n5_2 \3\:mout_2 n7_2 VSS) g45n1svt w=(1.45e-07) l=4.5e-08 nf=1 \
        as=8.7e-15 ad=1.957e-14 ps=4.1e-07 pd=5.6e-07 nrd=1.16667 \
        nrs=1.16667 sa=5.25e-07 sb=1.695e-06 sd=160n sca=15.7071 \
        scb=0.0167369 scc=0.00113434 m=(1)
NM9 (\9\:n20_2 \10\:Ckbb n5_2 VSS) g45n1svt w=(1.45e-07) l=4.5e-08 nf=1 \
        as=2.32e-14 ad=1.957e-14 ps=6.1e-07 pd=5.6e-07 nrd=1.16667 \
        nrs=1.16667 sa=1.875e-06 sb=3.45e-07 sd=160n sca=15.7071 \
        scb=0.0167369 scc=0.00113434 m=(1)
NM7 (\8\:Db_2 \8\:CKb \9\:n20_2 VSS) g45n1svt w=(1.45e-07) l=4.5e-08 nf=1 \
        as=2.32e-14 ad=2.03e-14 ps=6.1e-07 pd=5.7e-07 nrd=1.16667 \
        nrs=1.16667 sa=1.4e-07 sb=2e-06 sd=160n sca=15.7071 scb=0.0167369 \
        scc=0.00113434 m=(1)
NM1 (n1_2 \3\:D2 \67\:VSS VSS) g45n1svt w=(1.45e-07) l=4.5e-08 nf=1 \
        as=5.027e-14 ad=2.03e-14 ps=1.33e-06 pd=5.7e-07 nrd=1.16667 \
        nrs=1.16667 sa=8.86379e-07 sb=1.25e-07 sd=160n sca=12.9138 \
        scb=0.0133404 scc=0.000640143 m=(1)
NM2 (Db_2 SEb_2 n1_2 VSS) g45n1svt w=(1.45e-07) l=4.5e-08 nf=1 \
        as=2.03e-14 ad=3.77e-14 ps=5.7e-07 pd=8.1e-07 nrd=1.16667 \
        nrs=1.16667 sa=7.01379e-07 sb=3.1e-07 sd=160n sca=12.9138 \
        scb=0.0133404 scc=0.000640143 m=(1)
NM3 (Db_2 \11\:SE n3_2 VSS) g45n1svt w=(1.45e-07) l=4.5e-08 nf=1 \
        as=8.7e-15 ad=3.77e-14 ps=4.1e-07 pd=8.1e-07 nrd=1.16667 \
        nrs=1.16667 sa=3.96379e-07 sb=6.15e-07 sd=160n sca=12.9138 \
        scb=0.0133404 scc=0.000640143 m=(1)
NM4 (n3_2 \1\:Q1 \69\:VSS VSS) g45n1svt w=(1.45e-07) l=4.5e-08 nf=1 \
        as=7.87e-14 ad=8.7e-15 ps=1.6e-06 pd=4.1e-07 nrd=1.16667 \
        nrs=1.16667 sa=2.91379e-07 sb=7.2e-07 sd=160n sca=12.9138 \
        scb=0.0133404 scc=0.000640143 m=(1)
NM0 (\7\:SEb_2 \10\:SE \69\:VSS VSS) g45n1svt w=(1.45e-07) l=4.5e-08 \
        nf=1 as=7.87e-14 ad=3.262e-14 ps=1.6e-06 pd=7.4e-07 nrd=1.16667 \
        nrs=1.16667 sa=2.25e-07 sb=4.41897e-07 sd=160n sca=23.279 \
        scb=0.0230742 scc=0.00267719 m=(1)
mn56 (\9\:qint \4\:qbint \81\:VSS VSS) g45n1svt w=(1.45e-07) l=4.5e-08 \
        nf=1 as=2.03e-14 ad=7.48e-14 ps=5.7e-07 pd=1.6e-06 nrd=1.16667 \
        nrs=1.16667 sa=3.7e-07 sb=1.4e-07 sd=160n sca=23.279 scb=0.0230742 \
        scc=0.00267719 m=(1)
mn46 (\16\:qbint n30 n9 VSS) g45n1svt w=(1.45e-07) l=4.5e-08 nf=1 \
        as=1.45e-14 ad=2.392e-14 ps=4.9e-07 pd=6.2e-07 nrd=1.16667 \
        nrs=1.16667 sa=2e-06 sb=1.65e-07 sd=160n sca=15.7071 scb=0.0167369 \
        scc=0.00113434 m=(1)
mn45 (n9 \1\:RN \77\:VSS VSS) g45n1svt w=(1.45e-07) l=4.5e-08 nf=1 \
        as=7.75e-14 ad=1.45e-14 ps=1.49e-06 pd=4.9e-07 nrd=1.16667 \
        nrs=1.16667 sa=1.91e-06 sb=3.1e-07 sd=160n sca=15.7071 \
        scb=0.0167369 scc=0.00113434 m=(1)
mn50 (n11 \10\:qbint \77\:VSS VSS) g45n1svt w=(1.45e-07) l=4.5e-08 nf=1 \
        as=7.75e-14 ad=1.957e-14 ps=1.49e-06 pd=5.6e-07 nrd=1.16667 \
        nrs=1.16667 sa=1.645e-06 sb=5.75e-07 sd=160n sca=15.7071 \
        scb=0.0167369 scc=0.00113434 m=(1)
mn51 (\6\:n30 CKb n11 VSS) g45n1svt w=(1.45e-07) l=4.5e-08 nf=1 \
        as=1.957e-14 ad=2.9e-14 ps=5.6e-07 pd=6.9e-07 nrd=1.16667 \
        nrs=1.16667 sa=1.465e-06 sb=7.55e-07 sd=160n sca=15.7071 \
        scb=0.0167369 scc=0.00113434 m=(1)
mn40 (\6\:mout \2\:Ckbb \6\:n30 VSS) g45n1svt w=(1.45e-07) l=4.5e-08 nf=1 \
        as=2.9e-14 ad=3.335e-14 ps=6.9e-07 pd=7.5e-07 nrd=1.16667 \
        nrs=1.16667 sa=1.22e-06 sb=1e-06 sd=160n sca=15.7071 scb=0.0167369 \
        scc=0.00113434 m=(1)
mn30 (\6\:mout \3\:n20 \75\:VSS VSS) g45n1svt w=(1.45e-07) l=4.5e-08 \
        nf=1 as=8.475e-14 ad=3.335e-14 ps=1.59e-06 pd=7.5e-07 nrd=1.16667 \
        nrs=1.16667 sa=9.45e-07 sb=1.275e-06 sd=160n sca=15.7071 \
        scb=0.0167369 scc=0.00113434 m=(1)
mn35 (n7 \5\:RN \75\:VSS VSS) g45n1svt w=(1.45e-07) l=4.5e-08 nf=1 \
        as=8.475e-14 ad=8.7e-15 ps=1.59e-06 pd=4.1e-07 nrd=1.16667 \
        nrs=1.16667 sa=6.3e-07 sb=1.59e-06 sd=160n sca=15.7071 \
        scb=0.0167369 scc=0.00113434 m=(1)
mn36 (n5 \3\:mout n7 VSS) g45n1svt w=(1.45e-07) l=4.5e-08 nf=1 as=8.7e-15 \
        ad=1.957e-14 ps=4.1e-07 pd=5.6e-07 nrd=1.16667 nrs=1.16667 \
        sa=5.25e-07 sb=1.695e-06 sd=160n sca=15.7071 scb=0.0167369 \
        scc=0.00113434 m=(1)
mn37 (\9\:n20 \4\:Ckbb n5 VSS) g45n1svt w=(1.45e-07) l=4.5e-08 nf=1 \
        as=2.32e-14 ad=1.957e-14 ps=6.1e-07 pd=5.6e-07 nrd=1.16667 \
        nrs=1.16667 sa=1.875e-06 sb=3.45e-07 sd=160n sca=15.7071 \
        scb=0.0167369 scc=0.00113434 m=(1)
mn25 (\8\:Db \7\:CKb \9\:n20 VSS) g45n1svt w=(1.45e-07) l=4.5e-08 nf=1 \
        as=2.32e-14 ad=2.03e-14 ps=6.1e-07 pd=5.7e-07 nrd=1.16667 \
        nrs=1.16667 sa=1.4e-07 sb=2e-06 sd=160n sca=15.7071 scb=0.0167369 \
        scc=0.00113434 m=(1)
mn11 (n1 \3\:D1 \73\:VSS VSS) g45n1svt w=(1.45e-07) l=4.5e-08 nf=1 \
        as=5.027e-14 ad=2.03e-14 ps=1.33e-06 pd=5.7e-07 nrd=1.16667 \
        nrs=1.16667 sa=8.86379e-07 sb=1.25e-07 sd=160n sca=12.9138 \
        scb=0.0133404 scc=0.000640143 m=(1)
mn12 (\6\:Db \3\:SEb n1 VSS) g45n1svt w=(1.45e-07) l=4.5e-08 nf=1 \
        as=2.03e-14 ad=3.77e-14 ps=5.7e-07 pd=8.1e-07 nrd=1.16667 \
        nrs=1.16667 sa=7.01379e-07 sb=3.1e-07 sd=160n sca=12.9138 \
        scb=0.0133404 scc=0.000640143 m=(1)
mn14 (\6\:Db \3\:SE n3 VSS) g45n1svt w=(1.45e-07) l=4.5e-08 nf=1 \
        as=8.7e-15 ad=3.77e-14 ps=4.1e-07 pd=8.1e-07 nrd=1.16667 \
        nrs=1.16667 sa=3.96379e-07 sb=6.15e-07 sd=160n sca=12.9138 \
        scb=0.0133404 scc=0.000640143 m=(1)
mn13 (n3 \1\:SI \71\:VSS VSS) g45n1svt w=(1.45e-07) l=4.5e-08 nf=1 \
        as=7.87e-14 ad=8.7e-15 ps=1.6e-06 pd=4.1e-07 nrd=1.16667 \
        nrs=1.16667 sa=2.91379e-07 sb=7.2e-07 sd=160n sca=12.9138 \
        scb=0.0133404 scc=0.000640143 m=(1)
mn10 (\4\:SEb \7\:SE \71\:VSS VSS) g45n1svt w=(1.45e-07) l=4.5e-08 nf=1 \
        as=7.87e-14 ad=3.262e-14 ps=1.6e-06 pd=7.4e-07 nrd=1.16667 \
        nrs=1.16667 sa=2.25e-07 sb=4.41897e-07 sd=160n sca=23.279 \
        scb=0.0230742 scc=0.00267719 m=(1)
mn21 (\22\:Ckbb \18\:CKb \57\:VSS VSS) g45n1svt w=(1.45e-07) l=4.5e-08 \
        nf=1 as=6.752e-14 ad=9.332e-14 ps=1.56e-06 pd=1.56e-06 nrd=1.16667 \
        nrs=1.16667 sa=3.6e-07 sb=1.95e-07 sd=160n sca=19.8813 \
        scb=0.0206549 scc=0.00197265 m=(1)
mn20 (\51\:CKb \3\:CK \57\:VSS VSS) g45n1svt w=(1.45e-07) l=4.5e-08 nf=1 \
        as=6.752e-14 ad=2.03e-14 ps=1.56e-06 pd=5.7e-07 nrd=1.16667 \
        nrs=1.16667 sa=1.4e-07 sb=4.15e-07 sd=160n sca=19.8813 \
        scb=0.0206549 scc=0.00197265 m=(1)
PM43 (\13\:qbint_4 n30_4 \9\:VDD VDD) g45p1svt w=(2.15e-07) l=4.5e-08 \
        nf=1 as=1.4115e-13 ad=3.44e-14 ps=2.12e-06 pd=7.5e-07 nrd=1.16667 \
        nrs=1.16667 sa=1.69e-06 sb=5.15e-07 sd=160n sca=29.9075 \
        scb=0.0247057 scc=0.00372713 m=(1)
PM44 (\13\:qbint_4 \27\:RN \11\:VDD VDD) g45p1svt w=(2.15e-07) l=4.5e-08 \
        nf=1 as=1.049e-13 ad=3.44e-14 ps=1.83e-06 pd=7.5e-07 nrd=1.16667 \
        nrs=1.16667 sa=1.485e-06 sb=7.2e-07 sd=160n sca=29.9075 \
        scb=0.0247057 scc=0.00372713 m=(1)
PM42 (n8_4 qbint_4 \11\:VDD VDD) g45p1svt w=(2.15e-07) l=4.5e-08 nf=1 \
        as=3.01e-14 ad=1.049e-13 ps=7.1e-07 pd=1.83e-06 nrd=1.16667 \
        nrs=1.16667 sa=9.85e-07 sb=1.22e-06 sd=160n sca=29.9075 \
        scb=0.0247057 scc=0.00372713 m=(1)
PM41 (\4\:n30_4 \30\:Ckbb n8_4 VDD) g45p1svt w=(2.15e-07) l=4.5e-08 nf=1 \
        as=3.01e-14 ad=5.375e-14 ps=7.1e-07 pd=9.3e-07 nrd=1.16667 \
        nrs=1.16667 sa=1.035e-06 sb=1.17e-06 sd=160n sca=29.9075 \
        scb=0.0247057 scc=0.00372713 m=(1)
PM45 (\4\:n30_4 \29\:CKb \4\:mout_4 VDD) g45p1svt w=(2.15e-07) l=4.5e-08 \
        nf=1 as=5.375e-14 ad=3.762e-14 ps=9.3e-07 pd=7.8e-07 nrd=1.16667 \
        nrs=1.16667 sa=1.465e-06 sb=7.4e-07 sd=160n sca=29.9075 \
        scb=0.0247057 scc=0.00372713 m=(1)
PM49 (\4\:mout_4 n20_4 \13\:VDD VDD) g45p1svt w=(2.15e-07) l=4.5e-08 \
        nf=1 as=8.415e-14 ad=3.762e-14 ps=1.83e-06 pd=7.8e-07 nrd=1.16667 \
        nrs=1.16667 sa=5.2e-07 sb=1.685e-06 sd=160n sca=29.9075 \
        scb=0.0247057 scc=0.00372713 m=(1)
PM48 (n6_4 \23\:RN \13\:VDD VDD) g45p1svt w=(2.15e-07) l=4.5e-08 nf=1 \
        as=8.415e-14 ad=3.44e-14 ps=1.83e-06 pd=7.5e-07 nrd=1.16667 \
        nrs=1.16667 sa=3.05e-07 sb=1.9e-06 sd=160n sca=29.9075 \
        scb=0.0247057 scc=0.00372713 m=(1)
PM46 (n6_4 mout_4 \15\:VDD VDD) g45p1svt w=(2.15e-07) l=4.5e-08 nf=1 \
        as=6.29e-14 ad=3.44e-14 ps=1.83e-06 pd=7.5e-07 nrd=1.16667 \
        nrs=1.16667 sa=1e-07 sb=2e-06 sd=160n sca=29.9075 scb=0.0247057 \
        scc=0.00372713 m=(1)
PM47 (\7\:n20_4 \27\:CKb \3\:n6_4 VDD) g45p1svt w=(2.15e-07) l=4.5e-08 \
        nf=1 as=3.44e-14 ad=3.01e-14 ps=7.5e-07 pd=7.1e-07 nrd=1.16667 \
        nrs=1.16667 sa=1.4e-07 sb=3.31977e-07 sd=160n sca=45.7906 \
        scb=0.0283307 scc=0.00588417 m=(1)
PM50 (\7\:n20_4 \26\:Ckbb \4\:Db_4 VDD) g45p1svt w=(2.15e-07) l=4.5e-08 \
        nf=1 as=3.44e-14 ad=2.73e-14 ps=7.5e-07 pd=7.1e-07 nrd=1.16667 \
        nrs=1.16667 sa=3.45e-07 sb=1.26977e-07 sd=160n sca=45.7906 \
        scb=0.0283307 scc=0.00588417 m=(1)
PM54 (n2_4 \1\:D4 \18\:VDD VDD) g45p1svt w=(2.15e-07) l=4.5e-08 nf=1 \
        as=7.005e-14 ad=3.87e-14 ps=1.71e-06 pd=7.9e-07 nrd=1.16667 \
        nrs=1.16667 sa=1e-06 sb=1.10465e-07 sd=160n sca=21.1782 \
        scb=0.0203295 scc=0.00208843 m=(1)
PM53 (\6\:Db_4 \27\:SE n2_4 VDD) g45p1svt w=(2.15e-07) l=4.5e-08 nf=1 \
        as=3.87e-14 ad=3.44e-14 ps=7.9e-07 pd=7.5e-07 nrd=1.16667 \
        nrs=1.16667 sa=7.75e-07 sb=3.35465e-07 sd=160n sca=21.1782 \
        scb=0.0203295 scc=0.00208843 m=(1)
PM51 (\6\:Db_4 \3\:SEb_4 n4_4 VDD) g45p1svt w=(2.15e-07) l=4.5e-08 nf=1 \
        as=2.58e-14 ad=3.44e-14 ps=6.7e-07 pd=7.5e-07 nrd=1.16667 \
        nrs=1.16667 sa=5.7e-07 sb=5.40465e-07 sd=160n sca=21.1782 \
        scb=0.0203295 scc=0.00208843 m=(1)
PM52 (n4_4 \3\:Q3 \21\:VDD VDD) g45p1svt w=(2.15e-07) l=4.5e-08 nf=1 \
        as=1.001e-13 ad=2.58e-14 ps=1.75e-06 pd=6.7e-07 nrd=1.16667 \
        nrs=1.16667 sa=4.05e-07 sb=7.05465e-07 sd=160n sca=21.1782 \
        scb=0.0203295 scc=0.00208843 m=(1)
PM55 (\5\:SEb_4 \22\:SE \21\:VDD VDD) g45p1svt w=(2.15e-07) l=4.5e-08 \
        nf=1 as=3.01e-14 ad=1.001e-13 ps=7.1e-07 pd=1.75e-06 nrd=1.16667 \
        nrs=1.16667 sa=9.70465e-07 sb=1.4e-07 sd=160n sca=21.1782 \
        scb=0.0203295 scc=0.00208843 m=(1)
PM32 (\13\:qbint_3 n30_3 \28\:VDD VDD) g45p1svt w=(2.15e-07) l=4.5e-08 \
        nf=1 as=1.4115e-13 ad=3.44e-14 ps=2.12e-06 pd=7.5e-07 nrd=1.16667 \
        nrs=1.16667 sa=1.69e-06 sb=5.15e-07 sd=160n sca=29.9075 \
        scb=0.0247057 scc=0.00372713 m=(1)
PM31 (\13\:qbint_3 \20\:RN \31\:VDD VDD) g45p1svt w=(2.15e-07) l=4.5e-08 \
        nf=1 as=1.049e-13 ad=3.44e-14 ps=1.83e-06 pd=7.5e-07 nrd=1.16667 \
        nrs=1.16667 sa=1.485e-06 sb=7.2e-07 sd=160n sca=29.9075 \
        scb=0.0247057 scc=0.00372713 m=(1)
PM33 (n8_3 qbint_3 \31\:VDD VDD) g45p1svt w=(2.15e-07) l=4.5e-08 nf=1 \
        as=3.01e-14 ad=1.049e-13 ps=7.1e-07 pd=1.83e-06 nrd=1.16667 \
        nrs=1.16667 sa=9.85e-07 sb=1.22e-06 sd=160n sca=29.9075 \
        scb=0.0247057 scc=0.00372713 m=(1)
PM34 (\4\:n30_3 \19\:Ckbb n8_3 VDD) g45p1svt w=(2.15e-07) l=4.5e-08 nf=1 \
        as=3.01e-14 ad=5.375e-14 ps=7.1e-07 pd=9.3e-07 nrd=1.16667 \
        nrs=1.16667 sa=1.035e-06 sb=1.17e-06 sd=160n sca=29.9075 \
        scb=0.0247057 scc=0.00372713 m=(1)
PM30 (\4\:n30_3 \22\:CKb \4\:mout_3 VDD) g45p1svt w=(2.15e-07) l=4.5e-08 \
        nf=1 as=5.375e-14 ad=3.762e-14 ps=9.3e-07 pd=7.8e-07 nrd=1.16667 \
        nrs=1.16667 sa=1.465e-06 sb=7.4e-07 sd=160n sca=29.9075 \
        scb=0.0247057 scc=0.00372713 m=(1)
PM26 (\4\:mout_3 n20_3 \34\:VDD VDD) g45p1svt w=(2.15e-07) l=4.5e-08 \
        nf=1 as=8.415e-14 ad=3.762e-14 ps=1.83e-06 pd=7.8e-07 nrd=1.16667 \
        nrs=1.16667 sa=5.2e-07 sb=1.685e-06 sd=160n sca=29.9075 \
        scb=0.0247057 scc=0.00372713 m=(1)
PM27 (n6_3 \16\:RN \34\:VDD VDD) g45p1svt w=(2.15e-07) l=4.5e-08 nf=1 \
        as=8.415e-14 ad=3.44e-14 ps=1.83e-06 pd=7.5e-07 nrd=1.16667 \
        nrs=1.16667 sa=3.05e-07 sb=1.9e-06 sd=160n sca=29.9075 \
        scb=0.0247057 scc=0.00372713 m=(1)
PM29 (n6_3 mout_3 \38\:VDD VDD) g45p1svt w=(2.15e-07) l=4.5e-08 nf=1 \
        as=6.29e-14 ad=3.44e-14 ps=1.83e-06 pd=7.5e-07 nrd=1.16667 \
        nrs=1.16667 sa=1e-07 sb=2e-06 sd=160n sca=29.9075 scb=0.0247057 \
        scc=0.00372713 m=(1)
PM28 (\7\:n20_3 \20\:CKb \3\:n6_3 VDD) g45p1svt w=(2.15e-07) l=4.5e-08 \
        nf=1 as=3.44e-14 ad=3.01e-14 ps=7.5e-07 pd=7.1e-07 nrd=1.16667 \
        nrs=1.16667 sa=1.4e-07 sb=3.31977e-07 sd=160n sca=45.7906 \
        scb=0.0283307 scc=0.00588417 m=(1)
PM25 (\7\:n20_3 \15\:Ckbb \4\:Db_3 VDD) g45p1svt w=(2.15e-07) l=4.5e-08 \
        nf=1 as=3.44e-14 ad=2.73e-14 ps=7.5e-07 pd=7.1e-07 nrd=1.16667 \
        nrs=1.16667 sa=3.45e-07 sb=1.26977e-07 sd=160n sca=45.7906 \
        scb=0.0283307 scc=0.00588417 m=(1)
PM21 (n2_3 \1\:D3 \41\:VDD VDD) g45p1svt w=(2.15e-07) l=4.5e-08 nf=1 \
        as=7.005e-14 ad=3.87e-14 ps=1.71e-06 pd=7.9e-07 nrd=1.16667 \
        nrs=1.16667 sa=1e-06 sb=1.10465e-07 sd=160n sca=21.1782 \
        scb=0.0203295 scc=0.00208843 m=(1)
PM22 (\6\:Db_3 \20\:SE n2_3 VDD) g45p1svt w=(2.15e-07) l=4.5e-08 nf=1 \
        as=3.87e-14 ad=3.44e-14 ps=7.9e-07 pd=7.5e-07 nrd=1.16667 \
        nrs=1.16667 sa=7.75e-07 sb=3.35465e-07 sd=160n sca=21.1782 \
        scb=0.0203295 scc=0.00208843 m=(1)
PM24 (\6\:Db_3 \3\:SEb_3 n4_3 VDD) g45p1svt w=(2.15e-07) l=4.5e-08 nf=1 \
        as=2.58e-14 ad=3.44e-14 ps=6.7e-07 pd=7.5e-07 nrd=1.16667 \
        nrs=1.16667 sa=5.7e-07 sb=5.40465e-07 sd=160n sca=21.1782 \
        scb=0.0203295 scc=0.00208843 m=(1)
PM23 (n4_3 \3\:Q2 \44\:VDD VDD) g45p1svt w=(2.15e-07) l=4.5e-08 nf=1 \
        as=1.001e-13 ad=2.58e-14 ps=1.75e-06 pd=6.7e-07 nrd=1.16667 \
        nrs=1.16667 sa=4.05e-07 sb=7.05465e-07 sd=160n sca=21.1782 \
        scb=0.0203295 scc=0.00208843 m=(1)
PM20 (\5\:SEb_3 \15\:SE \44\:VDD VDD) g45p1svt w=(2.15e-07) l=4.5e-08 \
        nf=1 as=3.01e-14 ad=1.001e-13 ps=7.1e-07 pd=1.75e-06 nrd=1.16667 \
        nrs=1.16667 sa=9.70465e-07 sb=1.4e-07 sd=160n sca=21.1782 \
        scb=0.0203295 scc=0.00208843 m=(1)
PM14 (\13\:qbint_2 n30_2 \54\:VDD VDD) g45p1svt w=(2.15e-07) l=4.5e-08 \
        nf=1 as=1.4115e-13 ad=3.44e-14 ps=2.12e-06 pd=7.5e-07 nrd=1.16667 \
        nrs=1.16667 sa=1.69e-06 sb=5.15e-07 sd=160n sca=29.9075 \
        scb=0.0247057 scc=0.00372713 m=(1)
PM13 (\13\:qbint_2 \13\:RN \57\:VDD VDD) g45p1svt w=(2.15e-07) l=4.5e-08 \
        nf=1 as=1.049e-13 ad=3.44e-14 ps=1.83e-06 pd=7.5e-07 nrd=1.16667 \
        nrs=1.16667 sa=1.485e-06 sb=7.2e-07 sd=160n sca=29.9075 \
        scb=0.0247057 scc=0.00372713 m=(1)
PM15 (n8_2 qbint_2 \57\:VDD VDD) g45p1svt w=(2.15e-07) l=4.5e-08 nf=1 \
        as=3.01e-14 ad=1.049e-13 ps=7.1e-07 pd=1.83e-06 nrd=1.16667 \
        nrs=1.16667 sa=9.85e-07 sb=1.22e-06 sd=160n sca=29.9075 \
        scb=0.0247057 scc=0.00372713 m=(1)
PM16 (\4\:n30_2 \12\:Ckbb n8_2 VDD) g45p1svt w=(2.15e-07) l=4.5e-08 nf=1 \
        as=3.01e-14 ad=5.375e-14 ps=7.1e-07 pd=9.3e-07 nrd=1.16667 \
        nrs=1.16667 sa=1.035e-06 sb=1.17e-06 sd=160n sca=29.9075 \
        scb=0.0247057 scc=0.00372713 m=(1)
PM12 (\4\:n30_2 \11\:CKb \4\:mout_2 VDD) g45p1svt w=(2.15e-07) l=4.5e-08 \
        nf=1 as=5.375e-14 ad=3.762e-14 ps=9.3e-07 pd=7.8e-07 nrd=1.16667 \
        nrs=1.16667 sa=1.465e-06 sb=7.4e-07 sd=160n sca=29.9075 \
        scb=0.0247057 scc=0.00372713 m=(1)
PM8 (\4\:mout_2 n20_2 \60\:VDD VDD) g45p1svt w=(2.15e-07) l=4.5e-08 nf=1 \
        as=8.415e-14 ad=3.762e-14 ps=1.83e-06 pd=7.8e-07 nrd=1.16667 \
        nrs=1.16667 sa=5.2e-07 sb=1.685e-06 sd=160n sca=29.9075 \
        scb=0.0247057 scc=0.00372713 m=(1)
PM9 (n6_2 \9\:RN \60\:VDD VDD) g45p1svt w=(2.15e-07) l=4.5e-08 nf=1 \
        as=8.415e-14 ad=3.44e-14 ps=1.83e-06 pd=7.5e-07 nrd=1.16667 \
        nrs=1.16667 sa=3.05e-07 sb=1.9e-06 sd=160n sca=29.9075 \
        scb=0.0247057 scc=0.00372713 m=(1)
PM11 (n6_2 mout_2 \63\:VDD VDD) g45p1svt w=(2.15e-07) l=4.5e-08 nf=1 \
        as=6.29e-14 ad=3.44e-14 ps=1.83e-06 pd=7.5e-07 nrd=1.16667 \
        nrs=1.16667 sa=1e-07 sb=2e-06 sd=160n sca=29.9075 scb=0.0247057 \
        scc=0.00372713 m=(1)
PM10 (\7\:n20_2 \9\:CKb \3\:n6_2 VDD) g45p1svt w=(2.15e-07) l=4.5e-08 \
        nf=1 as=3.44e-14 ad=3.01e-14 ps=7.5e-07 pd=7.1e-07 nrd=1.16667 \
        nrs=1.16667 sa=1.4e-07 sb=3.31977e-07 sd=160n sca=45.7906 \
        scb=0.0283307 scc=0.00588417 m=(1)
PM7 (\7\:n20_2 \8\:Ckbb \4\:Db_2 VDD) g45p1svt w=(2.15e-07) l=4.5e-08 \
        nf=1 as=3.44e-14 ad=2.73e-14 ps=7.5e-07 pd=7.1e-07 nrd=1.16667 \
        nrs=1.16667 sa=3.45e-07 sb=1.26977e-07 sd=160n sca=45.7906 \
        scb=0.0283307 scc=0.00588417 m=(1)
PM1 (n2_2 \1\:D2 \66\:VDD VDD) g45p1svt w=(2.15e-07) l=4.5e-08 nf=1 \
        as=7.005e-14 ad=3.87e-14 ps=1.71e-06 pd=7.9e-07 nrd=1.16667 \
        nrs=1.16667 sa=1e-06 sb=1.10465e-07 sd=160n sca=21.1782 \
        scb=0.0203295 scc=0.00208843 m=(1)
PM2 (\6\:Db_2 \13\:SE n2_2 VDD) g45p1svt w=(2.15e-07) l=4.5e-08 nf=1 \
        as=3.87e-14 ad=3.44e-14 ps=7.9e-07 pd=7.5e-07 nrd=1.16667 \
        nrs=1.16667 sa=7.75e-07 sb=3.35465e-07 sd=160n sca=21.1782 \
        scb=0.0203295 scc=0.00208843 m=(1)
PM4 (\6\:Db_2 \3\:SEb_2 n4_2 VDD) g45p1svt w=(2.15e-07) l=4.5e-08 nf=1 \
        as=2.58e-14 ad=3.44e-14 ps=6.7e-07 pd=7.5e-07 nrd=1.16667 \
        nrs=1.16667 sa=5.7e-07 sb=5.40465e-07 sd=160n sca=21.1782 \
        scb=0.0203295 scc=0.00208843 m=(1)
PM3 (n4_2 \3\:Q1 \70\:VDD VDD) g45p1svt w=(2.15e-07) l=4.5e-08 nf=1 \
        as=1.001e-13 ad=2.58e-14 ps=1.75e-06 pd=6.7e-07 nrd=1.16667 \
        nrs=1.16667 sa=4.05e-07 sb=7.05465e-07 sd=160n sca=21.1782 \
        scb=0.0203295 scc=0.00208843 m=(1)
PM0 (\5\:SEb_2 \8\:SE \70\:VDD VDD) g45p1svt w=(2.15e-07) l=4.5e-08 nf=1 \
        as=3.01e-14 ad=1.001e-13 ps=7.1e-07 pd=1.75e-06 nrd=1.16667 \
        nrs=1.16667 sa=9.70465e-07 sb=1.4e-07 sd=160n sca=21.1782 \
        scb=0.0203295 scc=0.00208843 m=(1)
mp46 (\12\:qbint \3\:n30 \90\:VDD VDD) g45p1svt w=(2.15e-07) l=4.5e-08 \
        nf=1 as=1.4115e-13 ad=3.44e-14 ps=2.12e-06 pd=7.5e-07 nrd=1.16667 \
        nrs=1.16667 sa=1.69e-06 sb=5.15e-07 sd=160n sca=29.9075 \
        scb=0.0247057 scc=0.00372713 m=(1)
mp45 (\12\:qbint \3\:RN \86\:VDD VDD) g45p1svt w=(2.15e-07) l=4.5e-08 \
        nf=1 as=1.049e-13 ad=3.44e-14 ps=1.83e-06 pd=7.5e-07 nrd=1.16667 \
        nrs=1.16667 sa=1.485e-06 sb=7.2e-07 sd=160n sca=29.9075 \
        scb=0.0247057 scc=0.00372713 m=(1)
mp50 (n8 \8\:qbint \86\:VDD VDD) g45p1svt w=(2.15e-07) l=4.5e-08 nf=1 \
        as=3.01e-14 ad=1.049e-13 ps=7.1e-07 pd=1.83e-06 nrd=1.16667 \
        nrs=1.16667 sa=9.85e-07 sb=1.22e-06 sd=160n sca=29.9075 \
        scb=0.0247057 scc=0.00372713 m=(1)
mp51 (\4\:n30 \3\:Ckbb n8 VDD) g45p1svt w=(2.15e-07) l=4.5e-08 nf=1 \
        as=3.01e-14 ad=5.375e-14 ps=7.1e-07 pd=9.3e-07 nrd=1.16667 \
        nrs=1.16667 sa=1.035e-06 sb=1.17e-06 sd=160n sca=29.9075 \
        scb=0.0247057 scc=0.00372713 m=(1)
mp40 (\4\:n30 \3\:CKb \8\:mout VDD) g45p1svt w=(2.15e-07) l=4.5e-08 nf=1 \
        as=5.375e-14 ad=3.762e-14 ps=9.3e-07 pd=7.8e-07 nrd=1.16667 \
        nrs=1.16667 sa=1.465e-06 sb=7.4e-07 sd=160n sca=29.9075 \
        scb=0.0247057 scc=0.00372713 m=(1)
mp30 (\8\:mout \4\:n20 \83\:VDD VDD) g45p1svt w=(2.15e-07) l=4.5e-08 \
        nf=1 as=8.415e-14 ad=3.762e-14 ps=1.83e-06 pd=7.8e-07 nrd=1.16667 \
        nrs=1.16667 sa=5.2e-07 sb=1.685e-06 sd=160n sca=29.9075 \
        scb=0.0247057 scc=0.00372713 m=(1)
mp35 (\3\:n6 \6\:RN \83\:VDD VDD) g45p1svt w=(2.15e-07) l=4.5e-08 nf=1 \
        as=8.415e-14 ad=3.44e-14 ps=1.83e-06 pd=7.5e-07 nrd=1.16667 \
        nrs=1.16667 sa=3.05e-07 sb=1.9e-06 sd=160n sca=29.9075 \
        scb=0.0247057 scc=0.00372713 m=(1)
mp36 (\3\:n6 mout \80\:VDD VDD) g45p1svt w=(2.15e-07) l=4.5e-08 nf=1 \
        as=6.29e-14 ad=3.44e-14 ps=1.83e-06 pd=7.5e-07 nrd=1.16667 \
        nrs=1.16667 sa=1e-07 sb=2e-06 sd=160n sca=29.9075 scb=0.0247057 \
        scc=0.00372713 m=(1)
mp37 (\5\:n20 \6\:CKb n6 VDD) g45p1svt w=(2.15e-07) l=4.5e-08 nf=1 \
        as=3.44e-14 ad=3.01e-14 ps=7.5e-07 pd=7.1e-07 nrd=1.16667 \
        nrs=1.16667 sa=1.4e-07 sb=3.31977e-07 sd=160n sca=45.7906 \
        scb=0.0283307 scc=0.00588417 m=(1)
mp25 (\5\:n20 \6\:Ckbb \4\:Db VDD) g45p1svt w=(2.15e-07) l=4.5e-08 nf=1 \
        as=3.44e-14 ad=2.73e-14 ps=7.5e-07 pd=7.1e-07 nrd=1.16667 \
        nrs=1.16667 sa=3.45e-07 sb=1.26977e-07 sd=160n sca=45.7906 \
        scb=0.0283307 scc=0.00588417 m=(1)
mp11 (n2 \1\:D1 \76\:VDD VDD) g45p1svt w=(2.15e-07) l=4.5e-08 nf=1 \
        as=7.005e-14 ad=3.87e-14 ps=1.71e-06 pd=7.9e-07 nrd=1.16667 \
        nrs=1.16667 sa=1e-06 sb=1.10465e-07 sd=160n sca=21.1782 \
        scb=0.0203295 scc=0.00208843 m=(1)
mp12 (Db \1\:SE n2 VDD) g45p1svt w=(2.15e-07) l=4.5e-08 nf=1 as=3.87e-14 \
        ad=3.44e-14 ps=7.9e-07 pd=7.5e-07 nrd=1.16667 nrs=1.16667 \
        sa=7.75e-07 sb=3.35465e-07 sd=160n sca=21.1782 scb=0.0203295 \
        scc=0.00208843 m=(1)
mp14 (Db SEb n4 VDD) g45p1svt w=(2.15e-07) l=4.5e-08 nf=1 as=2.58e-14 \
        ad=3.44e-14 ps=6.7e-07 pd=7.5e-07 nrd=1.16667 nrs=1.16667 \
        sa=5.7e-07 sb=5.40465e-07 sd=160n sca=21.1782 scb=0.0203295 \
        scc=0.00208843 m=(1)
mp13 (n4 \3\:SI \73\:VDD VDD) g45p1svt w=(2.15e-07) l=4.5e-08 nf=1 \
        as=1.001e-13 ad=2.58e-14 ps=1.75e-06 pd=6.7e-07 nrd=1.16667 \
        nrs=1.16667 sa=4.05e-07 sb=7.05465e-07 sd=160n sca=21.1782 \
        scb=0.0203295 scc=0.00208843 m=(1)
mp10 (\6\:SEb \5\:SE \73\:VDD VDD) g45p1svt w=(2.15e-07) l=4.5e-08 nf=1 \
        as=3.01e-14 ad=1.001e-13 ps=7.1e-07 pd=1.75e-06 nrd=1.16667 \
        nrs=1.16667 sa=9.70465e-07 sb=1.4e-07 sd=160n sca=21.1782 \
        scb=0.0203295 scc=0.00208843 m=(1)
mp21 (\24\:Ckbb \15\:CKb \48\:VDD VDD) g45p1svt w=(2.15e-07) l=4.5e-08 \
        nf=1 as=8.732e-14 ad=3.01e-14 ps=1.85e-06 pd=7.1e-07 nrd=1.16667 \
        nrs=1.16667 sa=3.6e-07 sb=1.4e-07 sd=160n sca=31.508 scb=0.0252524 \
        scc=0.00399199 m=(1)
mp20 (\56\:CKb \1\:CK \48\:VDD VDD) g45p1svt w=(2.15e-07) l=4.5e-08 nf=1 \
        as=8.732e-14 ad=3.01e-14 ps=1.85e-06 pd=7.1e-07 nrd=1.16667 \
        nrs=1.16667 sa=1.4e-07 sb=3.6e-07 sd=160n sca=31.508 scb=0.0252524 \
        scc=0.00399199 m=(1)
mp56 (\5\:qint \7\:qbint \93\:VDD VDD) g45p1svt w=(2.15e-07) l=4.5e-08 \
        nf=1 as=9.842e-14 ad=3.01e-14 ps=1.97e-06 pd=7.1e-07 nrd=1.16667 \
        nrs=1.16667 sa=3.7e-07 sb=1.4e-07 sd=160n sca=48.5748 \
        scb=0.0312356 scc=0.00590118 m=(1)
PM18 (\9\:qint_2 \4\:qbint_2 \51\:VDD VDD) g45p1svt w=(2.15e-07) \
        l=4.5e-08 nf=1 as=9.843e-14 ad=3.01e-14 ps=1.97e-06 pd=7.1e-07 \
        nrd=1.16667 nrs=1.16667 sa=1.4e-07 sb=3.7e-07 sd=160n sca=45.7906 \
        scb=0.0283307 scc=0.00588417 m=(1)
PM36 (\9\:qint_3 \4\:qbint_3 \25\:VDD VDD) g45p1svt w=(2.15e-07) \
        l=4.5e-08 nf=1 as=9.843e-14 ad=3.01e-14 ps=1.97e-06 pd=7.1e-07 \
        nrd=1.16667 nrs=1.16667 sa=1.4e-07 sb=3.7e-07 sd=160n sca=45.7906 \
        scb=0.0283307 scc=0.00588417 m=(1)
PM39 (\9\:qint_4 \4\:qbint_4 \1\:VDD VDD) g45p1svt w=(2.15e-07) \
        l=4.5e-08 nf=1 as=9.843e-14 ad=3.01e-14 ps=1.97e-06 pd=7.1e-07 \
        nrd=1.16667 nrs=1.16667 sa=1.4e-07 sb=3.7e-07 sd=160n sca=48.5748 \
        scb=0.0312356 scc=0.00590118 m=(1)
ends SDFF4RX1
// End of subcircuit definition.
