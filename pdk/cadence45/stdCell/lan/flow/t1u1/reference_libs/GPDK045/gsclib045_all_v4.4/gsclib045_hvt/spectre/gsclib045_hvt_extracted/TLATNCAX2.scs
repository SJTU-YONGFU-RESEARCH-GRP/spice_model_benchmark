// Generated for: spectre (May  1 09:19:52 2013 )
// Library name: gsclib045_hvt
// Cell name: TLATNCAX2
// View name: extracted

simulator lang=spectre

subckt TLATNCAX2 CK E ECK VDD VSS
mp0 (\9\:CKb \4\:CK \7\:VDD VDD) g45p1hvt w=(2.15e-07) l=4.5e-08 nf=1 \
        as=9.025e-14 ad=3.01e-14 ps=1.44e-06 pd=7.1e-07 nrd=1.16667 \
        nrs=1.16667 sa=1.4e-07 sb=8.88023e-07 sd=160n sca=50.7282 \
        scb=0.0349898 scc=0.00599471 m=(1)
mp1 (\15\:CKbb CKb \7\:VDD VDD) g45p1hvt w=(2.15e-07) l=4.5e-08 nf=1 \
        as=8.37e-14 ad=3.29e-14 ps=1.78e-06 pd=8.2e-07 nrd=1.16667 \
        nrs=1.16667 sa=8.75e-07 sb=1.53023e-07 sd=160n sca=45.7906 \
        scb=0.0283307 scc=0.00588417 m=(1)
mp21 (\9\:ECKb CKbb \13\:VDD VDD) g45p1hvt w=(2.15e-07) l=4.5e-08 nf=1 \
        as=4.765e-14 ad=3.44e-14 ps=1.48e-06 pd=7.5e-07 nrd=1.16667 \
        nrs=1.16667 sa=1e-07 sb=1.535e-06 sd=160n sca=13.4114 scb=0.012694 \
        scc=0.000544005 m=(1)
mp20 (\9\:ECKb \7\:Eint \11\:VDD VDD) g45p1hvt w=(2.15e-07) l=4.5e-08 \
        nf=1 as=8.99e-14 ad=3.44e-14 ps=1.58e-06 pd=7.5e-07 nrd=1.16667 \
        nrs=1.16667 sa=3.05e-07 sb=1.33e-06 sd=160n sca=13.4114 \
        scb=0.012694 scc=0.000544005 m=(1)
mp15 (net205 Eint \11\:VDD VDD) g45p1hvt w=(2.15e-07) l=4.5e-08 nf=1 \
        as=8.99e-14 ad=3.44e-14 ps=1.58e-06 pd=7.5e-07 nrd=1.16667 \
        nrs=1.16667 sa=5.7e-07 sb=1.065e-06 sd=160n sca=13.4114 \
        scb=0.012694 scc=0.000544005 m=(1)
mp16 (\8\:n0 \5\:CKb net205 VDD) g45p1hvt w=(2.15e-07) l=4.5e-08 nf=1 \
        as=3.44e-14 ad=4.3e-14 ps=7.5e-07 pd=8.3e-07 nrd=1.16667 \
        nrs=1.16667 sa=7.75e-07 sb=8.6e-07 sd=160n sca=13.4114 \
        scb=0.012694 scc=0.000544005 m=(1)
mp6 (\8\:n0 \6\:CKbb net217 VDD) g45p1hvt w=(2.15e-07) l=4.5e-08 nf=1 \
        as=2.688e-14 ad=4.3e-14 ps=6.8e-07 pd=8.3e-07 nrd=1.16667 \
        nrs=1.16667 sa=1.02e-06 sb=6.15e-07 sd=160n sca=13.9337 \
        scb=0.0128784 scc=0.000544065 m=(1)
mp5 (net217 \1\:E \9\:VDD VDD) g45p1hvt w=(2.15e-07) l=4.5e-08 nf=1 \
        as=5.59e-14 ad=2.688e-14 ps=9.5e-07 pd=6.8e-07 nrd=1.16667 \
        nrs=1.16667 sa=1.19e-06 sb=4.45e-07 sd=160n sca=14.806 \
        scb=0.0136191 scc=0.000545447 m=(1)
mp10 (\8\:Eint n0 \9\:VDD VDD) g45p1hvt w=(2.15e-07) l=4.5e-08 nf=1 \
        as=5.59e-14 ad=3.01e-14 ps=9.5e-07 pd=7.1e-07 nrd=1.16667 \
        nrs=1.16667 sa=1.495e-06 sb=1.4e-07 sd=160n sca=20.7705 \
        scb=0.0234544 scc=0.000885185 m=(1)
C1 (CK VSS) capacitor c=4.1231e-17
C2 (ECK VSS) capacitor c=2.76355e-17
C3 (VDD VSS) capacitor c=1.98753e-16
C4 (E VSS) capacitor c=2.97961e-17
C5 (CKb VSS) capacitor c=4.35263e-17
C6 (ECKb VSS) capacitor c=1.47557e-16
C7 (CKbb VSS) capacitor c=4.17392e-17
C8 (Eint VSS) capacitor c=4.7924e-17
C9 (n0 VSS) capacitor c=3.07181e-17
C10 (net254 VSS) capacitor c=4.88086e-18
C11 (net205 VSS) capacitor c=2.13272e-18
C12 (net217 VSS) capacitor c=2.16579e-18
C13 (\1\:E VSS) capacitor c=3.74391e-17
C14 (\6\:CKbb VSS) capacitor c=4.35356e-17
C15 (\5\:CKb VSS) capacitor c=5.64925e-17
C16 (\7\:Eint VSS) capacitor c=3.66724e-17
C17 (\4\:CK VSS) capacitor c=2.26475e-17
C18 (\3\:n0 VSS) capacitor c=2.68352e-17
C19 (\3\:E VSS) capacitor c=3.77578e-17
C20 (\4\:CKb VSS) capacitor c=7.48039e-17
C21 (\4\:CKbb VSS) capacitor c=5.77272e-17
C22 (\5\:Eint VSS) capacitor c=1.47193e-17
C23 (\4\:Eint VSS) capacitor c=4.13768e-17
C24 (\3\:CKbb VSS) capacitor c=5.02089e-17
C25 (\2\:CKb VSS) capacitor c=4.5777e-17
C26 (\3\:CK VSS) capacitor c=2.92416e-17
C27 (\2\:n0 VSS) capacitor c=2.79417e-17
C28 (\2\:E VSS) capacitor c=3.45416e-17
C29 (\7\:CKbb VSS) capacitor c=4.4889e-17
C30 (\6\:CKb VSS) capacitor c=3.02572e-17
C31 (\5\:CKbb VSS) capacitor c=4.95872e-17
C32 (\6\:Eint VSS) capacitor c=2.76882e-17
C33 (\2\:CKbb VSS) capacitor c=2.88189e-17
C34 (\3\:CKb VSS) capacitor c=2.50715e-17
C35 (\6\:ECKb VSS) capacitor c=1.69513e-17
C36 (\1\:CK VSS) capacitor c=1.99729e-17
C37 (\8\:Eint VSS) capacitor c=4.38486e-17
C38 (\9\:VDD VSS) capacitor c=3.19424e-17
C39 (\8\:n0 VSS) capacitor c=6.49888e-17
C40 (\11\:VDD VSS) capacitor c=1.23322e-17
C41 (\9\:ECKb VSS) capacitor c=1.15976e-16
C42 (\13\:VDD VSS) capacitor c=1.10385e-17
C43 (\15\:CKbb VSS) capacitor c=2.95679e-17
C44 (\3\:ECK VSS) capacitor c=5.30763e-17
C45 (\9\:CKb VSS) capacitor c=1.02476e-16
C46 (\1\:VDD VSS) capacitor c=2.16163e-17
C47 (\10\:Eint VSS) capacitor c=1.64122e-16
C48 (\6\:n0 VSS) capacitor c=4.56772e-17
C49 (\13\:ECKb VSS) capacitor c=7.22624e-17
C50 (\12\:CKbb VSS) capacitor c=5.00358e-17
C51 (\1\:ECK VSS) capacitor c=2.3226e-17
C52 (\11\:CKb VSS) capacitor c=4.67213e-17
C53 (\2\:CK VSS) capacitor c=1.36426e-17
C54 (\2\:Eint VSS) capacitor c=2.95151e-17
C55 (\3\:Eint VSS) capacitor c=3.20811e-17
C56 (\5\:CK VSS) capacitor c=8.29464e-17
C57 (\11\:ECKb VSS) capacitor c=1.59687e-16
C58 (\12\:ECKb VSS) capacitor c=2.26364e-17
C59 (\7\:CKb VSS) capacitor c=8.86423e-17
C60 (\8\:CKb VSS) capacitor c=1.78896e-16
C61 (\8\:CKbb VSS) capacitor c=1.01585e-17
C62 (\9\:CKbb VSS) capacitor c=3.91264e-17
C63 (\10\:CKbb VSS) capacitor c=4.84969e-17
C64 (\11\:CKbb VSS) capacitor c=3.67947e-17
C65 (\14\:CKbb VSS) capacitor c=4.12145e-17
C66 (\4\:E VSS) capacitor c=8.40022e-17
C67 (\4\:n0 VSS) capacitor c=8.66929e-17
C68 (\5\:n0 VSS) capacitor c=1.17827e-16
C69 (\12\:Eint VSS) capacitor c=1.07805e-16
C70 (\3\:VDD VSS) capacitor c=1.2627e-17
C71 (\4\:VDD VSS) capacitor c=3.18421e-17
C72 (\5\:VDD VSS) capacitor c=9.4061e-18
C73 (\7\:VDD VSS) capacitor c=7.74734e-17
Rk34 (\2\:VSS \3\:VSS) resistor r=0.04485 c=0
Rk35 (\3\:VSS \4\:VSS) resistor r=0.4776 c=0
Rk36 (\4\:VSS \5\:VSS) resistor r=0.2776 c=0
Rk39 (\6\:VSS VSS) resistor r=0.1922 c=0
Rk37 (\5\:VSS \6\:VSS) resistor r=0.1525 c=0
Rk40 (\3\:VSS \9\:VSS) resistor r=0.1215 c=0
Rk41 (\4\:VSS \11\:VSS) resistor r=0.07311 c=0
Rk1 (CK \5\:CK) resistor r=0.05279 c=0
Rk2 (ECK \2\:ECK) resistor r=0.05081 c=0
Rk3 (ECK \4\:ECK) resistor r=0.1755 c=0
Rk22 (\2\:VDD \3\:VDD) resistor r=0.04485 c=0
Rk23 (\3\:VDD \4\:VDD) resistor r=0.4275 c=0
Rk24 (\4\:VDD \5\:VDD) resistor r=0.2348 c=0
Rk25 (\5\:VDD \6\:VDD) resistor r=0.09239 c=0
Rk28 (\7\:VDD VDD) resistor r=0.1922 c=0
Rk26 (\6\:VDD \7\:VDD) resistor r=0.1374 c=0
Rk29 (\3\:VDD \10\:VDD) resistor r=0.308 c=0
Rk30 (\4\:VDD \12\:VDD) resistor r=0.07311 c=0
Rk31 (\5\:VDD \14\:VDD) resistor r=0.07311 c=0
Rk16 (E \4\:E) resistor r=0.01106 c=0
Rk7 (\7\:CKb \8\:CKb) resistor r=0.7929 c=0
Rk8 (\8\:CKb \10\:CKb) resistor r=0.7437 c=0
Rk9 (\10\:CKb \12\:CKb) resistor r=0.3427 c=0
Rk4 (\10\:ECKb \11\:ECKb) resistor r=0.6808 c=0
Rk5 (\11\:ECKb \12\:ECKb) resistor r=0.08039 c=0
Rk6 (\11\:ECKb \14\:ECKb) resistor r=0.6701 c=0
Rk10 (\8\:CKbb \9\:CKbb) resistor r=0.03407 c=0
Rk11 (\9\:CKbb \10\:CKbb) resistor r=0.3995 c=0
Rk12 (\10\:CKbb \11\:CKbb) resistor r=0.1499 c=0
Rk13 (\11\:CKbb \13\:CKbb) resistor r=0.2318 c=0
Rk14 (\9\:CKbb \14\:CKbb) resistor r=0.1827 c=0
Rk15 (\11\:CKbb \16\:CKbb) resistor r=0.03518 c=0
Rk20 (\9\:Eint \11\:Eint) resistor r=0.4393 c=0
Rk21 (\11\:Eint \12\:Eint) resistor r=0.9619 c=0
Rk17 (\4\:n0 \5\:n0) resistor r=0.5133 c=0
Rk18 (\5\:n0 \7\:n0) resistor r=0.1353 c=0
Rk19 (\5\:n0 \9\:n0) resistor r=0.4787 c=0
Rl3 (\2\:CK \4\:CK) resistor r=57.4064 c=0
Rl2 (\2\:CK \3\:CK) resistor r=34.3295 c=0
Rl1 (\1\:CK \2\:CK) resistor r=1.2713 c=0
Rl25 (\1\:E \2\:E) resistor r=56.9251 c=0
Rl26 (\2\:E \3\:E) resistor r=70.3867 c=0
Rl22 (\4\:CKb \5\:CKb) resistor r=188.027 c=0
Rl11 (CKb \2\:CKb) resistor r=100 c=0
Rl23 (\5\:CKb \6\:CKb) resistor r=24.2328 c=0
Rl12 (CKb \3\:CKb) resistor r=50.6918 c=0
Rl8 (ECKb \6\:ECKb) resistor r=9.0449 c=0
Rl24 (\6\:CKbb \7\:CKbb) resistor r=57.6695 c=0
Rl21 (\4\:CKbb \5\:CKbb) resistor r=50.6918 c=0
Rl13 (CKbb \2\:CKbb) resistor r=50.6918 c=0
Rl14 (\2\:CKbb \3\:CKbb) resistor r=79.5379 c=0
Rl19 (\5\:Eint \6\:Eint) resistor r=35.7713 c=0
Rl15 (Eint \2\:Eint) resistor r=129.568 c=0
Rl18 (\2\:Eint \5\:Eint) resistor r=35.772 c=0
Rl20 (\3\:Eint \7\:Eint) resistor r=111.22 c=0
Rl17 (\3\:Eint \4\:Eint) resistor r=65.3625 c=0
Rl16 (\2\:Eint \3\:Eint) resistor r=62.3766 c=0
Rl27 (n0 \2\:n0) resistor r=100.692 c=0
Rl28 (\2\:n0 \3\:n0) resistor r=29.5379 c=0
Rz9 (\9\:VSS \8\:VSS) resistor r=75 c=0
Rz10 (\11\:VSS \10\:VSS) resistor r=75 c=0
Rz1 (\2\:ECK \1\:ECK) resistor r=75 c=0
Rz7 (\2\:VDD \1\:VDD) resistor r=18.75 c=0
Rz8 (\6\:VDD \1\:VDD) resistor r=6.25 c=0
Rz3 (\11\:CKb \12\:CKb) resistor r=75 c=0
Rz2 (\14\:ECKb \13\:ECKb) resistor r=75 c=0
Rz4 (\12\:CKbb \13\:CKbb) resistor r=75 c=0
Rz6 (\10\:Eint \11\:Eint) resistor r=75 c=0
Rz5 (\6\:n0 \7\:n0) resistor r=75 c=0
Ry12 (\2\:VSS \1\:VSS) resistor r=15.5 c=0
Ry13 (\5\:VSS \1\:VSS) resistor r=5.1667 c=0
Ry1 (\4\:ECK \3\:ECK) resistor r=62 c=0
Ry7 (\10\:VDD \9\:VDD) resistor r=62 c=0
Ry8 (\12\:VDD \11\:VDD) resistor r=62 c=0
Ry9 (\14\:VDD \13\:VDD) resistor r=62 c=0
Ry3 (\9\:CKb \10\:CKb) resistor r=62 c=0
Ry2 (\10\:ECKb \9\:ECKb) resistor r=62 c=0
Ry4 (\15\:CKbb \16\:CKbb) resistor r=62 c=0
Ry6 (\8\:Eint \9\:Eint) resistor r=62 c=0
Ry5 (\8\:n0 \9\:n0) resistor r=62 c=0
Rx1 (\1\:CK \5\:CK) resistor r=45 c=0
Rx8 (\2\:E \4\:E) resistor r=45 c=0
Rx3 (\6\:CKb \7\:CKb) resistor r=45 c=0
Rx4 (\3\:CKb \8\:CKb) resistor r=45 c=0
Rx2 (\12\:ECKb \6\:ECKb) resistor r=45 c=0
Rx5 (\5\:CKbb \8\:CKbb) resistor r=45 c=0
Rx6 (\2\:CKbb \10\:CKbb) resistor r=45 c=0
Rx7 (\7\:CKbb \14\:CKbb) resistor r=45 c=0
Rx10 (\6\:Eint \12\:Eint) resistor r=45 c=0
Rx9 (\2\:n0 \4\:n0) resistor r=45 c=0
mn0 (\11\:CKb \3\:CK \6\:VSS VSS) g45n1hvt w=(1.45e-07) l=4.5e-08 nf=1 \
        as=4.365e-14 ad=2.03e-14 ps=9e-07 pd=5.7e-07 nrd=1.16667 \
        nrs=1.16667 sa=1.4e-07 sb=9e-07 sd=160n sca=19.8813 scb=0.0206549 \
        scc=0.00197265 m=(1)
mn1 (\12\:CKbb \2\:CKb \6\:VSS VSS) g45n1hvt w=(1.45e-07) l=4.5e-08 nf=1 \
        as=5.235e-14 ad=2.393e-14 ps=1.02e-06 pd=6.2e-07 nrd=1.16667 \
        nrs=1.16667 sa=8.75e-07 sb=1.65e-07 sd=160n sca=19.8813 \
        scb=0.0206549 scc=0.00197265 m=(1)
mn21 (\13\:ECKb \3\:CKbb net238 VSS) g45n1hvt w=(1.45e-07) l=4.5e-08 nf=1 \
        as=8.7e-15 ad=2.03e-14 ps=4.1e-07 pd=5.7e-07 nrd=1.16667 \
        nrs=1.16667 sa=1.4e-07 sb=1.62e-06 sd=160n sca=22.3376 \
        scb=0.0224607 scc=0.00248252 m=(1)
mn20 (net238 \4\:Eint \10\:VSS VSS) g45n1hvt w=(1.45e-07) l=4.5e-08 nf=1 \
        as=8.64e-14 ad=8.7e-15 ps=1.63e-06 pd=4.1e-07 nrd=1.16667 \
        nrs=1.16667 sa=2.45e-07 sb=1.515e-06 sd=160n sca=22.3376 \
        scb=0.0224607 scc=0.00248252 m=(1)
mn15 (net230 \5\:Eint \10\:VSS VSS) g45n1hvt w=(1.45e-07) l=4.5e-08 nf=1 \
        as=8.64e-14 ad=1.958e-14 ps=1.63e-06 pd=5.6e-07 nrd=1.16667 \
        nrs=1.16667 sa=5.3e-07 sb=1.23e-06 sd=160n sca=22.3376 \
        scb=0.0224607 scc=0.00248252 m=(1)
mn16 (\6\:n0 \4\:CKbb net230 VSS) g45n1hvt w=(1.45e-07) l=4.5e-08 nf=1 \
        as=1.958e-14 ad=2.755e-14 ps=5.6e-07 pd=6.7e-07 nrd=1.16667 \
        nrs=1.16667 sa=7.1e-07 sb=1.05e-06 sd=160n sca=22.3376 \
        scb=0.0224607 scc=0.00248252 m=(1)
mn6 (\6\:n0 \4\:CKb net254 VSS) g45n1hvt w=(1.45e-07) l=4.5e-08 nf=1 \
        as=3.48e-14 ad=2.755e-14 ps=7.7e-07 pd=6.7e-07 nrd=1.16667 \
        nrs=1.16667 sa=9.45e-07 sb=8.15e-07 sd=160n sca=22.3376 \
        scb=0.0224607 scc=0.00248252 m=(1)
mn5 (net254 \3\:E \8\:VSS VSS) g45n1hvt w=(1.45e-07) l=4.5e-08 nf=1 \
        as=7.97e-14 ad=3.48e-14 ps=1.51e-06 pd=7.7e-07 nrd=1.16667 \
        nrs=1.16667 sa=1.23e-06 sb=5.3e-07 sd=160n sca=22.3376 \
        scb=0.0224607 scc=0.00248252 m=(1)
mn10 (\10\:Eint \3\:n0 \8\:VSS VSS) g45n1hvt w=(1.45e-07) l=4.5e-08 nf=1 \
        as=7.97e-14 ad=3.263e-14 ps=1.51e-06 pd=7.4e-07 nrd=1.16667 \
        nrs=1.16667 sa=1.535e-06 sb=2.25e-07 sd=160n sca=22.3376 \
        scb=0.0224607 scc=0.00248252 m=(1)
mn22 (\1\:ECK ECKb \6\:VSS VSS) g45n1hvt w=(2.6e-07) l=4.5e-08 nf=1 \
        as=4.8e-14 ad=4.16e-14 ps=9.6e-07 pd=8.4e-07 nrd=1.16667 \
        nrs=1.16667 sa=2.71058e-07 sb=5.23462e-07 sd=160n sca=15.3338 \
        scb=0.0153436 scc=0.00119435 m=(2)
mp22_1__rcx (\3\:ECK ECKb \7\:VDD VDD) g45p1hvt w=(3.9e-07) l=4.5e-08 \
        nf=1 as=8.698e-14 ad=6.24e-14 ps=1.61e-06 pd=1.1e-06 nrd=1.16667 \
        nrs=1.16667 sa=2.99551e-07 sb=4.80321e-07 sd=160n sca=31.7249 \
        scb=0.0209416 scc=0.00336188 m=(2)
ends TLATNCAX2
// End of subcircuit definition.
