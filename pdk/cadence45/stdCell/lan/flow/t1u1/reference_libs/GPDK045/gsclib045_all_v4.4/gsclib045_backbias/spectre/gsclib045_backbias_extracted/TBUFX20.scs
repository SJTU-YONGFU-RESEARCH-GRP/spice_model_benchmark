// Generated for: spectre (May  1 11:33:07 2013 )
// Library name: gsclib045_backbias
// Cell name: TBUFX20
// View name: extracted

simulator lang=spectre

subckt TBUFX20 A NW OE VDD VSS Y
mp1_1__rcx (8 \19\:A VDD NW) g45p1svt w=(3.25e-07) l=4.5e-08 nf=1 \
        as=1.2318e-13 ad=6.012e-14 ps=1.66e-06 pd=1.02e-06 nrd=1.16667 \
        nrs=1.16667 sa=1.69262e-06 sb=1.79077e-06 sd=160n sca=17.5615 \
        scb=0.01617 scc=0.00141748 m=(1)
mp2_1__rcx (\55\:non \6\:OEb 8 NW) g45p1svt w=(3.25e-07) l=4.5e-08 nf=1 \
        as=6.012e-14 ad=5.2e-14 ps=1.02e-06 pd=9.7e-07 nrd=1.16667 \
        nrs=1.16667 sa=1.74569e-06 sb=1.75538e-06 sd=160n sca=17.5615 \
        scb=0.01617 scc=0.00141748 m=(1)
mp2_2__rcx (\55\:non OEb 11 NW) g45p1svt w=(3.25e-07) l=4.5e-08 nf=1 \
        as=1.95e-14 ad=5.2e-14 ps=7.7e-07 pd=9.7e-07 nrd=1.16667 \
        nrs=1.16667 sa=1.793e-06 sb=1.72385e-06 sd=160n sca=17.5615 \
        scb=0.01617 scc=0.00141748 m=(1)
mp1_2__rcx (11 \27\:A \46\:VDD NW) g45p1svt w=(3.25e-07) l=4.5e-08 nf=1 \
        as=8.18e-14 ad=1.95e-14 ps=1.32e-06 pd=7.7e-07 nrd=1.16667 \
        nrs=1.16667 sa=1.81723e-06 sb=1.70769e-06 sd=160n sca=17.5615 \
        scb=0.01617 scc=0.00141748 m=(1)
mp1_3__rcx (9 \22\:A \46\:VDD NW) g45p1svt w=(3.25e-07) l=4.5e-08 nf=1 \
        as=8.18e-14 ad=3.25e-14 ps=1.32e-06 pd=8.5e-07 nrd=1.16667 \
        nrs=1.16667 sa=1.59685e-06 sb=2e-06 sd=160n sca=13.7057 \
        scb=0.0125682 scc=0.000653447 m=(1)
mp2_3__rcx (\53\:non \12\:OEb 9 NW) g45p1svt w=(3.25e-07) l=4.5e-08 nf=1 \
        as=3.25e-14 ad=5.2e-14 ps=8.5e-07 pd=9.7e-07 nrd=1.16667 \
        nrs=1.16667 sa=1.65262e-06 sb=2e-06 sd=160n sca=13.7057 \
        scb=0.0125682 scc=0.000653447 m=(1)
mp2_4__rcx (\53\:non \7\:OEb 10 NW) g45p1svt w=(3.25e-07) l=4.5e-08 nf=1 \
        as=3.25e-14 ad=5.2e-14 ps=8.5e-07 pd=9.7e-07 nrd=1.16667 \
        nrs=1.16667 sa=1.73146e-06 sb=2e-06 sd=160n sca=13.7057 \
        scb=0.0125682 scc=0.000653447 m=(1)
mp1_4__rcx (10 \31\:A \44\:VDD NW) g45p1svt w=(3.25e-07) l=4.5e-08 nf=1 \
        as=1.051e-13 ad=3.25e-14 ps=1.65e-06 pd=8.5e-07 nrd=1.16667 \
        nrs=1.16667 sa=1.78123e-06 sb=2e-06 sd=160n sca=13.7057 \
        scb=0.0125682 scc=0.000653447 m=(1)
mp1_5__rcx (5 \28\:A \44\:VDD NW) g45p1svt w=(3.25e-07) l=4.5e-08 nf=1 \
        as=1.051e-13 ad=5.2e-14 ps=1.65e-06 pd=9.7e-07 nrd=1.16667 \
        nrs=1.16667 sa=1.83015e-06 sb=2e-06 sd=160n sca=13.7057 \
        scb=0.0125682 scc=0.000653447 m=(1)
mp2_5__rcx (\51\:non \19\:OEb 5 NW) g45p1svt w=(3.25e-07) l=4.5e-08 nf=1 \
        as=5.2e-14 ad=5.2e-14 ps=9.7e-07 pd=9.7e-07 nrd=1.16667 \
        nrs=1.16667 sa=1.86692e-06 sb=2e-06 sd=160n sca=13.7057 \
        scb=0.0125682 scc=0.000653447 m=(1)
mp2 (\51\:non \13\:OEb 6 NW) g45p1svt w=(3.25e-07) l=4.5e-08 nf=1 \
        as=5.2e-14 ad=5.2e-14 ps=9.7e-07 pd=9.7e-07 nrd=1.16667 \
        nrs=1.16667 sa=1.89846e-06 sb=2e-06 sd=160n sca=13.7057 \
        scb=0.0125682 scc=0.000653447 m=(1)
mp1 (6 \34\:A \1\:VDD NW) g45p1svt w=(3.25e-07) l=4.5e-08 nf=1 \
        as=1.0755e-13 ad=5.2e-14 ps=1.71e-06 pd=9.7e-07 nrd=1.16667 \
        nrs=1.16667 sa=1.93e-06 sb=2e-06 sd=160n sca=13.7057 scb=0.0125682 \
        scc=0.000653447 m=(1)
mp3_1__rcx (\40\:pon \2\:A VDD NW) g45p1svt w=(3.25e-07) l=4.5e-08 nf=1 \
        as=7.425e-14 ad=5.2e-14 ps=1.76667e-06 pd=9.7e-07 nrd=1.16667 \
        nrs=1.16667 sa=1e-07 sb=2e-06 sd=160n sca=49.4087 scb=0.0429485 \
        scc=0.0056687 m=(6)
mp4_1__rcx (\40\:pon OE VDD NW) g45p1svt w=(3.25e-07) l=4.5e-08 nf=1 \
        as=8.877e-14 ad=5.2e-14 ps=1.97e-06 pd=9.7e-07 nrd=1.16667 \
        nrs=1.16667 sa=3.05e-07 sb=2e-06 sd=160n sca=38.3877 scb=0.0274361 \
        scc=0.00406713 m=(6)
C1 (NW VSS) capacitor c=1.13529e-15
C2 (Y VSS) capacitor c=1.22443e-15
C3 (A VSS) capacitor c=2.35318e-17
C4 (VDD VSS) capacitor c=4.72864e-16
C5 (OE VSS) capacitor c=7.23719e-16
C6 (16 VSS) capacitor c=6.35687e-18
C7 (pon VSS) capacitor c=6.99545e-16
C8 (17 VSS) capacitor c=2.50553e-18
C9 (18 VSS) capacitor c=2.83825e-18
C10 (19 VSS) capacitor c=3.00585e-18
C11 (20 VSS) capacitor c=9.24291e-19
C12 (21 VSS) capacitor c=1.88768e-18
C13 (OEb VSS) capacitor c=5.84533e-17
C14 (non VSS) capacitor c=6.55144e-16
C15 (8 VSS) capacitor c=7.30544e-18
C16 (11 VSS) capacitor c=2.86247e-18
C17 (9 VSS) capacitor c=7.06791e-18
C18 (10 VSS) capacitor c=5.29684e-18
C19 (5 VSS) capacitor c=8.74805e-18
C20 (6 VSS) capacitor c=9.61153e-18
C21 (\34\:A VSS) capacitor c=5.62799e-17
C22 (\13\:OEb VSS) capacitor c=4.19726e-17
C23 (\19\:OEb VSS) capacitor c=3.15016e-17
C24 (\28\:A VSS) capacitor c=4.4897e-17
C25 (\31\:A VSS) capacitor c=5.49278e-17
C26 (\7\:OEb VSS) capacitor c=4.13583e-17
C27 (\12\:OEb VSS) capacitor c=4.08678e-17
C28 (\22\:A VSS) capacitor c=6.14257e-17
C29 (\27\:A VSS) capacitor c=6.77205e-17
C30 (\6\:OEb VSS) capacitor c=2.59973e-17
C31 (\19\:A VSS) capacitor c=5.45588e-17
C32 (\14\:OE VSS) capacitor c=1.93662e-16
C33 (\18\:A VSS) capacitor c=3.47092e-17
C34 (\24\:OE VSS) capacitor c=3.521e-17
C35 (\26\:OE VSS) capacitor c=5.27237e-17
C36 (\13\:A VSS) capacitor c=3.87096e-17
C37 (\14\:A VSS) capacitor c=1.66462e-17
C38 (\11\:OE VSS) capacitor c=2.68633e-17
C39 (\12\:OE VSS) capacitor c=3.25709e-17
C40 (\9\:A VSS) capacitor c=1.98515e-17
C41 (\6\:A VSS) capacitor c=2.16888e-17
C42 (\1\:OE VSS) capacitor c=2.56784e-17
C43 (\4\:OE VSS) capacitor c=3.1062e-17
C44 (\1\:A VSS) capacitor c=3.15073e-17
C45 (\21\:non VSS) capacitor c=2.35483e-17
C46 (\20\:A VSS) capacitor c=1.05089e-15
C47 (\2\:A VSS) capacitor c=1.13849e-15
C48 (\1\:VDD VSS) capacitor c=1.1428e-15
C49 (\51\:non VSS) capacitor c=1.4339e-16
C50 (\44\:VDD VSS) capacitor c=3.77303e-17
C51 (\53\:non VSS) capacitor c=1.7947e-16
C52 (\46\:VDD VSS) capacitor c=4.19717e-17
C53 (\55\:non VSS) capacitor c=1.18598e-16
C54 (\26\:OEb VSS) capacitor c=3.44081e-17
C55 (\40\:pon VSS) capacitor c=6.99193e-16
C56 (\41\:non VSS) capacitor c=4.76129e-16
C57 (\24\:OEb VSS) capacitor c=8.51532e-17
C58 (\45\:pon VSS) capacitor c=8.10816e-17
C59 (\52\:pon VSS) capacitor c=6.97608e-17
C60 (\59\:pon VSS) capacitor c=8.1502e-17
C61 (\2\:OEb VSS) capacitor c=8.2841e-16
C62 (\23\:OEb VSS) capacitor c=5.51057e-17
C63 (\50\:non VSS) capacitor c=1.15372e-16
C64 (\43\:pon VSS) capacitor c=4.01141e-16
C65 (\13\:VDD VSS) capacitor c=8.47564e-17
C66 (\14\:VDD VSS) capacitor c=8.49981e-17
Rk17 (\2\:A A) resistor r=0.07968 c=0
Rk12 (\20\:A \2\:A) resistor r=1.0099 c=0
Rk90 (\1\:VDD \13\:VDD) resistor r=0.471 c=0
Rk92 (\14\:VDD VDD) resistor r=0.4509 c=0
Rk91 (\13\:VDD \14\:VDD) resistor r=0.3807 c=0
Rk111 (\13\:VDD \45\:VDD) resistor r=0.1592 c=0
Rk112 (\14\:VDD \47\:VDD) resistor r=0.2126 c=0
Rk140 (\1\:VSS \24\:VSS) resistor r=0.3582 c=0
Rk141 (\24\:VSS \25\:VSS) resistor r=0.2982 c=0
Rk142 (\25\:VSS \26\:VSS) resistor r=0.1578 c=0
Rk144 (\27\:VSS VSS) resistor r=0.02212 c=0
Rk143 (\26\:VSS \27\:VSS) resistor r=0.3707 c=0
Rk162 (\24\:VSS \63\:VSS) resistor r=0.2598 c=0
Rk163 (\26\:VSS \65\:VSS) resistor r=0.2598 c=0
Rk164 (\27\:VSS \67\:VSS) resistor r=0.251 c=0
Rk35 (\40\:pon \43\:pon) resistor r=2.9728 c=0
Rk37 (\40\:pon \46\:pon) resistor r=0.3461 c=0
Rk41 (\40\:pon \53\:pon) resistor r=0.3509 c=0
Rk45 (\40\:pon \60\:pon) resistor r=0.3642 c=0
Rk6 (\2\:OEb \23\:OEb) resistor r=0.5161 c=0
Rk7 (\23\:OEb \25\:OEb) resistor r=0.1344 c=0
Rk8 (\23\:OEb \27\:OEb) resistor r=0.06751 c=0
Rk26 (\41\:non \50\:non) resistor r=0.261 c=0
Rk27 (\50\:non \52\:non) resistor r=0.5173 c=0
Rk28 (\52\:non \54\:non) resistor r=0.6086 c=0
Rk29 (\54\:non \56\:non) resistor r=0.5824 c=0
Rl65 (\20\:A \34\:A) resistor r=114.264 c=0
Rl54 (\20\:A \28\:A) resistor r=103.08 c=0
Rl56 (\20\:A \31\:A) resistor r=115.362 c=0
Rl44 (\20\:A \22\:A) resistor r=112.261 c=0
Rl48 (\20\:A \27\:A) resistor r=85.7713 c=0
Rl37 (\20\:A \19\:A) resistor r=88.4615 c=0
Rl24 (\2\:A \18\:A) resistor r=43.6813 c=0
Rl20 (\2\:A \13\:A) resistor r=28.0797 c=0
Rl21 (\2\:A \14\:A) resistor r=32.2092 c=0
Rl12 (\2\:A \9\:A) resistor r=26.098 c=0
Rl10 (\2\:A \6\:A) resistor r=26.098 c=0
Rl1 (\2\:A \1\:A) resistor r=36.5385 c=0
Rl28 (OE \14\:OE) resistor r=289.95 c=0
Rl34 (OE \24\:OE) resistor r=78.5277 c=0
Rl36 (OE \26\:OE) resistor r=79.9451 c=0
Rl15 (OE \11\:OE) resistor r=74.7951 c=0
Rl16 (OE \12\:OE) resistor r=81.9251 c=0
Rl3 (OE \1\:OE) resistor r=27.2353 c=0
Rl5 (OE \4\:OE) resistor r=28.0797 c=0
Rl59 (\2\:OEb \13\:OEb) resistor r=151.157 c=0
Rl64 (\2\:OEb \19\:OEb) resistor r=43.4636 c=0
Rl49 (\2\:OEb \7\:OEb) resistor r=45.3874 c=0
Rl53 (\2\:OEb \12\:OEb) resistor r=43.4636 c=0
Rl39 (\2\:OEb OEb) resistor r=74.6625 c=0
Rl43 (\2\:OEb \6\:OEb) resistor r=24.2328 c=0
Rl87 (non \21\:non) resistor r=11.3141 c=0
Rz39 (\63\:VSS \62\:VSS) resistor r=75 c=0
Rz40 (\65\:VSS \64\:VSS) resistor r=75 c=0
Rz41 (\67\:VSS \66\:VSS) resistor r=75 c=0
Rz8 (\46\:pon \45\:pon) resistor r=75 c=0
Rz9 (\53\:pon \52\:pon) resistor r=75 c=0
Rz10 (\60\:pon \59\:pon) resistor r=75 c=0
Rz1 (\25\:OEb \24\:OEb) resistor r=75 c=0
Ry33 (\45\:VDD \44\:VDD) resistor r=62 c=0
Ry34 (\47\:VDD \46\:VDD) resistor r=62 c=0
Ry46 (\25\:VSS \1\:VSS) resistor r=5.1667 c=0
Ry1 (\27\:OEb \26\:OEb) resistor r=62 c=0
Ry2 (\52\:non \51\:non) resistor r=62 c=0
Ry3 (\54\:non \53\:non) resistor r=62 c=0
Ry4 (\56\:non \55\:non) resistor r=62 c=0
Rx18 (\43\:pon pon) resistor r=45 c=0
Rx17 (\50\:non \21\:non) resistor r=45 c=0
mn3_1__rcx (16 \1\:A \66\:VSS VSS) g45n1svt w=(2.15e-07) l=4.5e-08 nf=1 \
        as=3.01e-14 ad=2.258e-14 ps=7.1e-07 pd=6.4e-07 nrd=1.16667 \
        nrs=1.16667 sa=1.4e-07 sb=2e-06 sd=160n sca=10.3734 scb=0.00953019 \
        scc=0.000328496 m=(1)
mn4_1__rcx (\59\:pon \4\:OE 16 VSS) g45n1svt w=(2.15e-07) l=4.5e-08 nf=1 \
        as=2.258e-14 ad=3.44e-14 ps=6.4e-07 pd=7.5e-07 nrd=1.16667 \
        nrs=1.16667 sa=2.9e-07 sb=2e-06 sd=160n sca=10.3734 scb=0.00953019 \
        scc=0.000328496 m=(1)
mn4_2__rcx (\59\:pon \1\:OE 17 VSS) g45n1svt w=(2.15e-07) l=4.5e-08 nf=1 \
        as=2.902e-14 ad=3.44e-14 ps=7e-07 pd=7.5e-07 nrd=1.16667 \
        nrs=1.16667 sa=4.95e-07 sb=2e-06 sd=160n sca=10.3734 \
        scb=0.00953019 scc=0.000328496 m=(1)
mn3_2__rcx (17 \6\:A \64\:VSS VSS) g45n1svt w=(2.15e-07) l=4.5e-08 nf=1 \
        as=3.44e-14 ad=2.903e-14 ps=7.5e-07 pd=7e-07 nrd=1.16667 \
        nrs=1.16667 sa=6.75e-07 sb=2e-06 sd=160n sca=10.3734 \
        scb=0.00953019 scc=0.000328496 m=(1)
mn3_3__rcx (18 \9\:A \64\:VSS VSS) g45n1svt w=(2.15e-07) l=4.5e-08 nf=1 \
        as=3.44e-14 ad=3.333e-14 ps=7.5e-07 pd=7.4e-07 nrd=1.16667 \
        nrs=1.16667 sa=8.8e-07 sb=2e-06 sd=160n sca=10.3734 scb=0.00953019 \
        scc=0.000328496 m=(1)
mn4_3__rcx (\52\:pon \12\:OE 18 VSS) g45n1svt w=(2.15e-07) l=4.5e-08 nf=1 \
        as=3.333e-14 ad=4.515e-14 ps=7.4e-07 pd=8.5e-07 nrd=1.16667 \
        nrs=1.16667 sa=1.08e-06 sb=2e-06 sd=160n sca=10.3734 \
        scb=0.00953019 scc=0.000328496 m=(1)
mn4_4__rcx (\52\:pon \11\:OE 19 VSS) g45n1svt w=(2.15e-07) l=4.5e-08 nf=1 \
        as=4.408e-14 ad=4.515e-14 ps=8.4e-07 pd=8.5e-07 nrd=1.16667 \
        nrs=1.16667 sa=1.335e-06 sb=2e-06 sd=160n sca=10.3734 \
        scb=0.00953019 scc=0.000328496 m=(1)
mn3_4__rcx (19 \14\:A \62\:VSS VSS) g45n1svt w=(2.15e-07) l=4.5e-08 nf=1 \
        as=3.44e-14 ad=4.408e-14 ps=7.5e-07 pd=8.4e-07 nrd=1.16667 \
        nrs=1.16667 sa=1.585e-06 sb=2e-06 sd=160n sca=10.3734 \
        scb=0.00953019 scc=0.000328496 m=(1)
mn3_5__rcx (20 \13\:A \62\:VSS VSS) g45n1svt w=(2.15e-07) l=4.5e-08 nf=1 \
        as=3.44e-14 ad=1.29e-14 ps=7.5e-07 pd=5.5e-07 nrd=1.16667 \
        nrs=1.16667 sa=1.79e-06 sb=2e-06 sd=160n sca=10.3734 \
        scb=0.00953019 scc=0.000328496 m=(1)
mn4_5__rcx (\45\:pon \26\:OE 20 VSS) g45n1svt w=(2.15e-07) l=4.5e-08 nf=1 \
        as=1.29e-14 ad=4.3e-14 ps=5.5e-07 pd=8.3e-07 nrd=1.16667 \
        nrs=1.16667 sa=1.895e-06 sb=2e-06 sd=160n sca=10.3734 \
        scb=0.00953019 scc=0.000328496 m=(1)
mn4 (\45\:pon \24\:OE 21 VSS) g45n1svt w=(2.15e-07) l=4.5e-08 nf=1 \
        as=2.473e-14 ad=4.3e-14 ps=6.6e-07 pd=8.3e-07 nrd=1.16667 \
        nrs=1.16667 sa=2e-06 sb=2e-06 sd=160n sca=10.3734 scb=0.00953019 \
        scc=0.000328496 m=(1)
mn3 (21 \18\:A \1\:VSS VSS) g45n1svt w=(2.15e-07) l=4.5e-08 nf=1 \
        as=7.007e-14 ad=2.472e-14 ps=1.13e-06 pd=6.6e-07 nrd=1.16667 \
        nrs=1.16667 sa=2e-06 sb=2e-06 sd=160n sca=10.3734 scb=0.00953019 \
        scc=0.000328496 m=(1)
mn1_1__rcx (\41\:non \20\:A \1\:VSS VSS) g45n1svt w=(2.15e-07) l=4.5e-08 \
        nf=1 as=4.253e-14 ad=3.44e-14 ps=8.4167e-07 pd=7.5e-07 nrd=1.16667 \
        nrs=1.16667 sa=2e-06 sb=2e-06 sd=160n sca=10.3734 scb=0.00953019 \
        scc=0.000328496 m=(6)
mn2_1__rcx (\41\:non \2\:OEb \1\:VSS VSS) g45n1svt w=(2.15e-07) \
        l=4.5e-08 nf=1 as=3.44e-14 ad=3.44e-14 ps=7.5e-07 pd=7.5e-07 \
        nrd=1.16667 nrs=1.16667 sa=2e-06 sb=2e-06 sd=160n sca=10.3734 \
        scb=0.00953019 scc=0.000328496 m=(6)
mn0_1__rcx (\24\:OEb \14\:OE \1\:VSS VSS) g45n1svt w=(2.6e-07) l=4.5e-08 \
        nf=1 as=7.007e-14 ad=4.16e-14 ps=1.13e-06 pd=8.4e-07 nrd=1.16667 \
        nrs=1.16667 sa=1.67115e-06 sb=1.70663e-06 sd=160n sca=11.8713 \
        scb=0.0115056 scc=0.000581193 m=(2)
mn5_1__rcx (Y non \1\:VSS VSS) g45n1svt w=(2.6e-07) l=4.5e-08 nf=1 \
        as=4.163e-14 ad=4.16e-14 ps=8.42e-07 pd=8.4e-07 nrd=1.16667 \
        nrs=1.16667 sa=1.67115e-06 sb=2e-06 sd=160n sca=11.8713 \
        scb=0.0115056 scc=0.000581193 m=(20)
mp5_1__rcx (Y pon \1\:VDD NW) g45p1svt w=(3.9e-07) l=4.5e-08 nf=1 \
        as=6.427e-14 ad=6.396e-14 ps=1.1285e-06 pd=1.108e-06 nrd=1.16667 \
        nrs=1.16667 sa=1.66949e-06 sb=2e-06 sd=160n sca=13.1056 \
        scb=0.0116857 scc=0.000556045 m=(20)
mp0 (\26\:OEb \14\:OE VDD NW) g45p1svt w=(3.9e-07) l=4.5e-08 nf=1 \
        as=9.896e-14 ad=8.775e-14 ps=1.43e-06 pd=1.23e-06 nrd=1.16667 \
        nrs=1.16667 sa=1.68333e-06 sb=1.59295e-06 sd=160n sca=30.5009 \
        scb=0.0202006 scc=0.00336097 m=(2)
ends TBUFX20
// End of subcircuit definition.
