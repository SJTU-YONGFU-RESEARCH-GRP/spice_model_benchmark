// Generated for: spectre (May  1 08:11:29 2013 )
// Library name: gsclib045
// Cell name: HSWNX1
// View name: extracted

simulator lang=spectre

subckt HSWNX1 ExtVDD PSOn PSOn_out VDD VSS
PM0_76__rcx (VDD n0 ExtVDD ExtVDD) g45p1hvt w=(4.5e-07) l=4.5e-08 nf=1 \
        as=7.125e-14 ad=7.125e-14 ps=1.21667e-06 pd=1.21667e-06 \
        nrd=1.16667 nrs=1.16667 sa=1.4e-07 sb=2e-06 sd=160n sca=3.86017 \
        scb=0.000251977 scc=7.90668e-08 m=(24)
PM0_73__rcx (VDD n0 ExtVDD ExtVDD) g45p1hvt w=(4.5e-07) l=4.5e-08 nf=1 \
        as=7.2e-14 ad=7.2e-14 ps=1.22e-06 pd=1.22e-06 nrd=1.16667 \
        nrs=1.16667 sa=3.45e-07 sb=2e-06 sd=160n sca=3.86017 \
        scb=0.000251977 scc=7.90668e-08 m=(20)
PM0_68__rcx (VDD n0 ExtVDD ExtVDD) g45p1hvt w=(4.5e-07) l=4.5e-08 nf=1 \
        as=7.2e-14 ad=7.1e-14 ps=1.22e-06 pd=1.21556e-06 nrd=1.16667 \
        nrs=1.16667 sa=2e-06 sb=7.55e-07 sd=160n sca=16.9864 scb=0.0140904 \
        scc=0.00159544 m=(36)
PM1 (\117\:n0 \1\:PSOn ExtVDD ExtVDD) g45p1svt w=(4.5e-07) l=4.5e-08 \
        nf=1 as=6.3e-14 ad=7.2e-14 ps=1.18e-06 pd=1.22e-06 nrd=1.16667 \
        nrs=1.16667 sa=1.4e-07 sb=3.45e-07 sd=160n sca=27.248 \
        scb=0.0274655 scc=0.00244831 m=(2)
PM6_3__rcx (PSOn_out \24\:n0 ExtVDD ExtVDD) g45p1svt w=(4.5e-07) \
        l=4.5e-08 nf=1 as=7.2e-14 ad=6.75e-14 ps=1.22e-06 pd=1.2e-06 \
        nrd=1.16667 nrs=1.16667 sa=5.5e-07 sb=3.45e-07 sd=160n sca=16.2559 \
        scb=0.0139194 scc=0.00128532 m=(4)
C1 (PSOn_out VSS) capacitor c=3.89294e-16
C2 (ExtVDD VSS) capacitor c=3.15002e-15
C3 (VDD VSS) capacitor c=2.46914e-16
C4 (PSOn VSS) capacitor c=4.24165e-17
C5 (n0 VSS) capacitor c=1.80956e-15
C6 (\1\:PSOn VSS) capacitor c=1.46658e-16
C7 (\107\:n0 VSS) capacitor c=3.79814e-17
C8 (\117\:n0 VSS) capacitor c=9.11909e-17
C9 (\119\:n0 VSS) capacitor c=7.02617e-17
C10 (VDD VSS) capacitor c=4.35397e-15
C11 (ExtVDD VSS) capacitor c=1.29743e-15
C12 (ExtVDD VSS) capacitor c=2.43861e-15
C13 (\7\:PSOn VSS) capacitor c=3.85856e-17
C14 (\23\:n0 VSS) capacitor c=7.10829e-17
C15 (\24\:n0 VSS) capacitor c=2.7736e-16
C16 (\115\:n0 VSS) capacitor c=7.95927e-17
C17 (\116\:n0 VSS) capacitor c=6.46441e-17
Rk138 (\2\:VSS VSS) resistor r=1.2043 c=0
Rk144 (\4\:VSS VSS) resistor r=0.02214 c=0
Rk140 (VSS \4\:VSS) resistor r=1.0036 c=0
Rk147 (\14\:VSS VSS) resistor r=1.2043 c=0
Rk152 (\16\:VSS VSS) resistor r=0.02214 c=0
Rk149 (VSS \16\:VSS) resistor r=1.1567 c=0
Rk22 (ExtVDD ExtVDD) resistor r=0.3403 c=0
Rk99 (VDD VDD) resistor r=0.9677 c=0
Rk1 (\7\:PSOn PSOn) resistor r=0.03995 c=0
Rk8 (\115\:n0 \116\:n0) resistor r=0.642 c=0
Rk9 (\116\:n0 \118\:n0) resistor r=0.2954 c=0
Rk10 (\116\:n0 \120\:n0) resistor r=0.236 c=0
Rl28 (\23\:n0 n0) resistor r=96.583 c=0
Rl112 (\23\:n0 \107\:n0) resistor r=64.081 c=0
Rl29 (\24\:n0 \23\:n0) resistor r=193.783 c=0
Rz3 (\120\:n0 \119\:n0) resistor r=37.5 c=0
Ry94 (VSS \1\:VSS) resistor r=5.1667 c=0
Ry97 (VSS \13\:VSS) resistor r=5.1667 c=0
Ry93 (\2\:VSS \1\:VSS) resistor r=5.1667 c=0
Ry95 (\4\:VSS \1\:VSS) resistor r=5.1667 c=0
Ry96 (\14\:VSS \13\:VSS) resistor r=5.1667 c=0
Ry98 (\16\:VSS \13\:VSS) resistor r=5.1667 c=0
Ry3 (\118\:n0 \117\:n0) resistor r=20.6667 c=0
Rx1 (\7\:PSOn \1\:PSOn) resistor r=15 c=0
Rx2 (\115\:n0 \107\:n0) resistor r=9 c=0
NM0_1__rcx (\16\:VSS \1\:PSOn \119\:n0 VSS) g45n1svt w=(3e-07) l=4.5e-08 \
        nf=1 as=4.5e-14 ad=4.5e-14 ps=9e-07 pd=9e-07 nrd=1.16667 \
        nrs=1.16667 sa=3.45e-07 sb=1.4e-07 sd=160n sca=11.3599 \
        scb=0.0104786 scc=0.000506541 m=(2)
NM4_1__rcx (PSOn_out \24\:n0 \4\:VSS VSS) g45n1svt w=(3e-07) l=4.5e-08 \
        nf=1 as=4.5e-14 ad=4.8e-14 ps=9e-07 pd=9.2e-07 nrd=1.16667 \
        nrs=1.16667 sa=1.4e-07 sb=7.55e-07 sd=160n sca=9.00722 \
        scb=0.00736509 scc=0.000220315 m=(4)
ends HSWNX1
// End of subcircuit definition.
