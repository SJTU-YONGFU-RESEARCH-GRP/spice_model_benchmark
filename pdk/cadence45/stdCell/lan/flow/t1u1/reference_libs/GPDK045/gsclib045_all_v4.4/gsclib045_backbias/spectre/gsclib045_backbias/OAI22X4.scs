// gsclib045_backbias/OAI22X4/schematic

simulator lang=spectre

subckt OAI22X4 A0 A1 B0 B1 Y NW VDD VSS
mn0 (net102 A0 VSS VSS) g45n1svt w=(1.04u) l=45n nf=1 m=(1)
mn3 (Y B1 net102 VSS) g45n1svt w=(1.04u) l=45n nf=1 m=(1)
mn1 (net102 A1 VSS VSS) g45n1svt w=(1.04u) l=45n nf=1 m=(1)
mn2 (Y B0 net102 VSS) g45n1svt w=(1.04u) l=45n nf=1 m=(1)
mp3 (Y B1 net85 NW) g45p1svt w=(1.56u) l=45n nf=1 m=(1)
mp1 (Y A1 net93 NW) g45p1svt w=(1.56u) l=45n nf=1 m=(1)
mp0 (net93 A0 VDD NW) g45p1svt w=(1.56u) l=45n nf=1 m=(1)
mp2 (net85 B0 VDD NW) g45p1svt w=(1.56u) l=45n nf=1 m=(1)
ends OAI22X4
