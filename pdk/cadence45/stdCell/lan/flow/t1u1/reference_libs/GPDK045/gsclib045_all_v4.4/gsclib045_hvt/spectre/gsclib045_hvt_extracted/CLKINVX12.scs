// Generated for: spectre (May  1 09:13:51 2013 )
// Library name: gsclib045_hvt
// Cell name: CLKINVX12
// View name: extracted

simulator lang=spectre

subckt CLKINVX12 A VDD VSS Y
mp0 (Y A VDD VDD) g45p1hvt w=(4.7e-07) l=4.5e-08 nf=1 as=8.554e-14 \
        ad=7.661e-14 ps=1.304e-06 pd=1.266e-06 nrd=1.16667 nrs=1.16667 \
        sa=1.4e-07 sb=2e-06 sd=160n sca=40.6416 scb=0.0369115 \
        scc=0.00420297 m=(10)
C1 (A VSS) capacitor c=7.83048e-16
C2 (Y VSS) capacitor c=4.76208e-16
C3 (VDD VSS) capacitor c=4.26972e-16
C4 (\9\:Y VSS) capacitor c=4.81282e-16
Rk12 (Y \9\:Y) resistor r=0.4398 c=0
mn0 (\9\:Y A VSS VSS) g45n1hvt w=(3.1e-07) l=4.5e-08 nf=1 as=4.836e-14 \
        ad=5.859e-14 ps=9.32e-07 pd=9.98e-07 nrd=1.16667 nrs=1.16667 \
        sa=1.4e-07 sb=2e-06 sd=160n sca=8.7305 scb=0.00693421 \
        scc=0.00019605 m=(10)
ends CLKINVX12
// End of subcircuit definition.
