// Verilog-AMS netlist generated by the AMS netlister, version  ICADV12.1-64b.341 .
// Cadence Design Systems, Inc.

`include "disciplines.vams"

(* cds_ams_schematic *)
module MDFFHQX8 ( D1,.VDD(\VDD! ),D0,CK,S0,.NW(
\NW! ),Q,.VSS(\VSS! ) );

input   D1;
input  (*
integer inh_conn_prop_name = "VDD";
integer
inh_conn_def_value = "cds_globals.\\VDD! ";
 *)
 \VDD! ;
input   D0;

input   CK;
input   S0;
input  (*
integer inh_conn_prop_name = "NW";

integer inh_conn_def_value = "cds_globals.\\NW! ";
integer
supplySensitivity = "VDD";
 *)
 \NW! ;
output   Q;
input  (*
integer
inh_conn_prop_name = "VSS";
integer inh_conn_def_value
 = "cds_globals.\\VSS! ";
 *)
 \VSS! ;

wire n12;
wire n10;
wire D1;
wire (*
integer inh_conn_prop_name = "VSS";
integer inh_conn_def_value
 = "cds_globals.\\VSS! ";
 *)
\VSS! ;
wire D0;
wire n30;
wire qbint;
wire CK;
wire CKb;
wire S0b;
wire S0;
wire n25;
wire D0b;
wire Q;
wire (*
integer inh_conn_prop_name = "VDD";
integer inh_conn_def_value
 = "cds_globals.\\VDD! ";
 *)
\VDD! ;

g45n1svt #(.ad(36.4f), .nrd(538.462m), .sca(144.98299), .pd(800n), .scc(0.01780),
 .scb(0.10251), .as(36.4f), .nrs(538.462m), .m(1), .ps(800n), .w(260n),
 .sa(140n), .nf(1), .sb(140n), .sd(160n), .l(45n)) (*
integer
library_binding = "gpdk045";
integer passed_mfactor = "m";
 *)
mn13 (
n12, D1, \VSS! , \VSS!  );
g45n1svt #(.ad(36.4f), .nrd(538.462m), .sca(144.98299), .pd(800n), .scc(0.01780),
 .scb(0.10251), .as(36.4f), .nrs(538.462m), .m(1), .ps(800n), .w(260n),
 .sa(140n), .nf(1), .sb(140n), .sd(160n), .l(45n)) (*
integer
library_binding = "gpdk045";
integer passed_mfactor = "m";
 *)
mn14 (
D0b, S0, n12, \VSS!  );
g45n1svt #(.ad(36.4f), .nrd(538.462m), .sca(144.98299), .pd(800n), .scc(0.01780),
 .scb(0.10251), .as(36.4f), .nrs(538.462m), .m(1), .ps(800n), .w(260n),
 .sa(140n), .nf(1), .sb(140n), .sd(160n), .l(45n)) (*
integer
library_binding = "gpdk045";
integer passed_mfactor = "m";
 *)
mn12 (
D0b, S0b, n10, \VSS!  );
g45n1svt #(.ad(36.4f), .nrd(538.462m), .sca(144.98299), .pd(800n), .scc(0.01780),
 .scb(0.10251), .as(36.4f), .nrs(538.462m), .m(1), .ps(800n), .w(260n),
 .sa(140n), .nf(1), .sb(140n), .sd(160n), .l(45n)) (*
integer
library_binding = "gpdk045";
integer passed_mfactor = "m";
 *)
mn11 (
n10, D0, \VSS! , \VSS!  );
g45n1svt #(.ad(289.1f), .nrd(67.7966m), .sca(56.50260), .pd(4.41u), .scc(0.00690),
 .scb(0.05663), .as(289.1f), .nrs(67.7966m), .m(1), .ps(4.41u), .w(2.065u),
 .sa(140n), .nf(1), .sb(140n), .sd(160n), .l(45n)) (*
integer
library_binding = "gpdk045";
integer passed_mfactor = "m";
 *)
mn55 (
Q, qbint, \VSS! , \VSS!  );
g45n1svt #(.ad(28.7f), .nrd(682.927m), .sca(166.60249), .pd(690n), .scc(0.02069),
 .scb(0.10864), .as(28.7f), .nrs(682.927m), .m(1), .ps(690n), .w(205n),
 .sa(140n), .nf(1), .sb(140n), .sd(160n), .l(45n)) (*
integer
library_binding = "gpdk045";
integer passed_mfactor = "m";
 *)
mn50 (
n35, qbint, \VSS! , \VSS!  );
g45n1svt #(.ad(28.7f), .nrd(682.927m), .sca(166.60249), .pd(690n), .scc(0.02069),
 .scb(0.10864), .as(28.7f), .nrs(682.927m), .m(1), .ps(690n), .w(205n),
 .sa(140n), .nf(1), .sb(140n), .sd(160n), .l(45n)) (*
integer
library_binding = "gpdk045";
integer passed_mfactor = "m";
 *)
mn51 (
n30, CKb, n35, \VSS!  );
g45n1svt #(.ad(20.3f), .nrd(965.517m), .sca(203.41795), .pd(570n), .scc(0.02523),
 .scb(0.11509), .as(20.3f), .nrs(965.517m), .m(1), .ps(570n), .w(145n),
 .sa(140n), .nf(1), .sb(140n), .sd(160n), .l(45n)) (*
integer
library_binding = "gpdk045";
integer passed_mfactor = "m";
 *)
mn10 (
S0b, S0, \VSS! , \VSS!  );
g45n1svt #(.ad(28.7f), .nrd(682.927m), .sca(166.60249), .pd(690n), .scc(0.02069),
 .scb(0.10864), .as(28.7f), .nrs(682.927m), .m(1), .ps(690n), .w(205n),
 .sa(140n), .nf(1), .sb(140n), .sd(160n), .l(45n)) (*
integer
library_binding = "gpdk045";
integer passed_mfactor = "m";
 *)
mn40 (
mout, CKbb, n30, \VSS!  );
g45n1svt #(.ad(28.7f), .nrd(682.927m), .sca(166.60249), .pd(690n), .scc(0.02069),
 .scb(0.10864), .as(28.7f), .nrs(682.927m), .m(1), .ps(690n), .w(205n),
 .sa(140n), .nf(1), .sb(140n), .sd(160n), .l(45n)) (*
integer
library_binding = "gpdk045";
integer passed_mfactor = "m";
 *)
mn35 (
n25, mout, \VSS! , \VSS!  );
g45n1svt #(.ad(28.7f), .nrd(682.927m), .sca(166.60249), .pd(690n), .scc(0.02069),
 .scb(0.10864), .as(28.7f), .nrs(682.927m), .m(1), .ps(690n), .w(205n),
 .sa(140n), .nf(1), .sb(140n), .sd(160n), .l(45n)) (*
integer
library_binding = "gpdk045";
integer passed_mfactor = "m";
 *)
mn36 (
n20, CKbb, n25, \VSS!  );
g45n1svt #(.ad(20.3f), .nrd(965.517m), .sca(203.41795), .pd(570n), .scc(0.02523),
 .scb(0.11509), .as(20.3f), .nrs(965.517m), .m(1), .ps(570n), .w(145n),
 .sa(140n), .nf(1), .sb(140n), .sd(160n), .l(45n)) (*
integer
library_binding = "gpdk045";
integer passed_mfactor = "m";
 *)
mn21 (
CKbb, CKb, \VSS! , \VSS!  );
g45n1svt #(.ad(109.2f), .nrd(179.487m), .sca(80.49887), .pd(1.84u), .scc(0.00954),
 .scb(0.07059), .as(109.2f), .nrs(179.487m), .m(1), .ps(1.84u), .w(780n),
 .sa(140n), .nf(1), .sb(140n), .sd(160n), .l(45n)) (*
integer
library_binding = "gpdk045";
integer passed_mfactor = "m";
 *)
mn45 (
qbint, n30, \VSS! , \VSS!  );
g45n1svt #(.ad(28.7f), .nrd(682.927m), .sca(166.60249), .pd(690n), .scc(0.02069),
 .scb(0.10864), .as(28.7f), .nrs(682.927m), .m(1), .ps(690n), .w(205n),
 .sa(140n), .nf(1), .sb(140n), .sd(160n), .l(45n)) (*
integer
library_binding = "gpdk045";
integer passed_mfactor = "m";
 *)
mn25 (
D0b, CKb, n20, \VSS!  );
g45n1svt #(.ad(28.7f), .nrd(682.927m), .sca(166.60249), .pd(690n), .scc(0.02069),
 .scb(0.10864), .as(28.7f), .nrs(682.927m), .m(1), .ps(690n), .w(205n),
 .sa(140n), .nf(1), .sb(140n), .sd(160n), .l(45n)) (*
integer
library_binding = "gpdk045";
integer passed_mfactor = "m";
 *)
mn30 (
mout, n20, \VSS! , \VSS!  );
g45n1svt #(.ad(20.3f), .nrd(965.517m), .sca(203.41795), .pd(570n), .scc(0.02523),
 .scb(0.11509), .as(20.3f), .nrs(965.517m), .m(1), .ps(570n), .w(145n),
 .sa(140n), .nf(1), .sb(140n), .sd(160n), .l(45n)) (*
integer
library_binding = "gpdk045";
integer passed_mfactor = "m";
 *)
mn20 (
CKb, CK, \VSS! , \VSS!  );

g45p1svt #(.ad(54.6f), .nrd(358.974m), .sca(114.89040), .pd(1.06u), .scc(0.01377),
 .scb(0.09003), .as(54.6f), .nrs(358.974m), .m(1), .ps(1.06u), .w(390n),
 .sa(140n), .nf(1), .sb(140n), .sd(160n), .l(45n)) (*
integer
library_binding = "gpdk045";
integer passed_mfactor = "m";
 *)
mp14 (
D0b, S0b, n13, \NW!  );
g45p1svt #(.ad(54.6f), .nrd(358.974m), .sca(114.89040), .pd(1.06u), .scc(0.01377),
 .scb(0.09003), .as(54.6f), .nrs(358.974m), .m(1), .ps(1.06u), .w(390n),
 .sa(140n), .nf(1), .sb(140n), .sd(160n), .l(45n)) (*
integer
library_binding = "gpdk045";
integer passed_mfactor = "m";
 *)
mp13 (
n13, D1, \VDD! , \NW!  );
g45p1svt #(.ad(54.6f), .nrd(358.974m), .sca(114.89040), .pd(1.06u), .scc(0.01377),
 .scb(0.09003), .as(54.6f), .nrs(358.974m), .m(1), .ps(1.06u), .w(390n),
 .sa(140n), .nf(1), .sb(140n), .sd(160n), .l(45n)) (*
integer
library_binding = "gpdk045";
integer passed_mfactor = "m";
 *)
mp12 (
D0b, S0, n11, \NW!  );
g45p1svt #(.ad(54.6f), .nrd(358.974m), .sca(114.89040), .pd(1.06u), .scc(0.01377),
 .scb(0.09003), .as(54.6f), .nrs(358.974m), .m(1), .ps(1.06u), .w(390n),
 .sa(140n), .nf(1), .sb(140n), .sd(160n), .l(45n)) (*
integer
library_binding = "gpdk045";
integer passed_mfactor = "m";
 *)
mp11 (
n11, D0, \VDD! , \NW!  );
g45p1svt #(.ad(43.4f), .nrd(451.613m), .sca(130.90642), .pd(900n), .scc(0.01590),
 .scb(0.09728), .as(43.4f), .nrs(451.613m), .m(1), .ps(900n), .w(310n),
 .sa(140n), .nf(1), .sb(140n), .sd(160n), .l(45n)) (*
integer
library_binding = "gpdk045";
integer passed_mfactor = "m";
 *)
mp51 (
n30, CKbb, n36, \NW!  );
g45p1svt #(.ad(43.4f), .nrd(451.613m), .sca(130.90642), .pd(900n), .scc(0.01590),
 .scb(0.09728), .as(43.4f), .nrs(451.613m), .m(1), .ps(900n), .w(310n),
 .sa(140n), .nf(1), .sb(140n), .sd(160n), .l(45n)) (*
integer
library_binding = "gpdk045";
integer passed_mfactor = "m";
 *)
mp50 (
n36, qbint, \VDD! , \NW!  );
g45p1svt #(.ad(436.1f), .nrd(44.9438m), .sca(51.31501), .pd(6.51u), .scc(0.00636),
 .scb(0.05377), .as(436.1f), .nrs(44.9438m), .m(1), .ps(6.51u), .w(3.115u),
 .sa(140n), .nf(1), .sb(140n), .sd(160n), .l(45n)) (*
integer
library_binding = "gpdk045";
integer passed_mfactor = "m";
 *)
mp55 (
Q, qbint, \VDD! , \NW!  );
g45p1svt #(.ad(43.4f), .nrd(451.613m), .sca(130.90642), .pd(900n), .scc(0.01590),
 .scb(0.09728), .as(43.4f), .nrs(451.613m), .m(1), .ps(900n), .w(310n),
 .sa(140n), .nf(1), .sb(140n), .sd(160n), .l(45n)) (*
integer
library_binding = "gpdk045";
integer passed_mfactor = "m";
 *)
mp35 (
n26, mout, \VDD! , \NW!  );
g45p1svt #(.ad(43.4f), .nrd(451.613m), .sca(130.90642), .pd(900n), .scc(0.01590),
 .scb(0.09728), .as(43.4f), .nrs(451.613m), .m(1), .ps(900n), .w(310n),
 .sa(140n), .nf(1), .sb(140n), .sd(160n), .l(45n)) (*
integer
library_binding = "gpdk045";
integer passed_mfactor = "m";
 *)
mp36 (
n20, CKb, n26, \NW!  );
g45p1svt #(.ad(43.4f), .nrd(451.613m), .sca(130.90642), .pd(900n), .scc(0.01590),
 .scb(0.09728), .as(43.4f), .nrs(451.613m), .m(1), .ps(900n), .w(310n),
 .sa(140n), .nf(1), .sb(140n), .sd(160n), .l(45n)) (*
integer
library_binding = "gpdk045";
integer passed_mfactor = "m";
 *)
mp25 (
n20, CKbb, D0b, \NW!  );
g45p1svt #(.ad(30.1f), .nrd(651.163m), .sca(162.02845), .pd(710n), .scc(0.02009),
 .scb(0.10751), .as(30.1f), .nrs(651.163m), .m(1), .ps(710n), .w(215n),
 .sa(140n), .nf(1), .sb(140n), .sd(160n), .l(45n)) (*
integer
library_binding = "gpdk045";
integer passed_mfactor = "m";
 *)
mp21 (
CKbb, CKb, \VDD! , \NW!  );
g45p1svt #(.ad(43.4f), .nrd(451.613m), .sca(130.90642), .pd(900n), .scc(0.01590),
 .scb(0.09728), .as(43.4f), .nrs(451.613m), .m(1), .ps(900n), .w(310n),
 .sa(140n), .nf(1), .sb(140n), .sd(160n), .l(45n)) (*
integer
library_binding = "gpdk045";
integer passed_mfactor = "m";
 *)
mp30 (
mout, n20, \VDD! , \NW!  );
g45p1svt #(.ad(43.4f), .nrd(451.613m), .sca(130.90642), .pd(900n), .scc(0.01590),
 .scb(0.09728), .as(43.4f), .nrs(451.613m), .m(1), .ps(900n), .w(310n),
 .sa(140n), .nf(1), .sb(140n), .sd(160n), .l(45n)) (*
integer
library_binding = "gpdk045";
integer passed_mfactor = "m";
 *)
mp40 (
n30, CKb, mout, \NW!  );
g45p1svt #(.ad(30.1f), .nrd(651.163m), .sca(162.02845), .pd(710n), .scc(0.02009),
 .scb(0.10751), .as(30.1f), .nrs(651.163m), .m(1), .ps(710n), .w(215n),
 .sa(140n), .nf(1), .sb(140n), .sd(160n), .l(45n)) (*
integer
library_binding = "gpdk045";
integer passed_mfactor = "m";
 *)
mp10 (
S0b, S0, \VDD! , \NW!  );
g45p1svt #(.ad(163.8f), .nrd(119.658m), .sca(67.91660), .pd(2.62u), .scc(0.00813),
 .scb(0.06314), .as(163.8f), .nrs(119.658m), .m(1), .ps(2.62u), .w(1.17u),
 .sa(140n), .nf(1), .sb(140n), .sd(160n), .l(45n)) (*
integer
library_binding = "gpdk045";
integer passed_mfactor = "m";
 *)
mp45 (
qbint, n30, \VDD! , \NW!  );
g45p1svt #(.ad(30.1f), .nrd(651.163m), .sca(162.02845), .pd(710n), .scc(0.02009),
 .scb(0.10751), .as(30.1f), .nrs(651.163m), .m(1), .ps(710n), .w(215n),
 .sa(140n), .nf(1), .sb(140n), .sd(160n), .l(45n)) (*
integer
library_binding = "gpdk045";
integer passed_mfactor = "m";
 *)
mp20 (
CKb, CK, \VDD! , \NW!  );

endmodule
