// Generated for: spectre (May  1 09:19:04 2013 )
// Library name: gsclib045_lvt
// Cell name: TLATNCAX16
// View name: extracted

simulator lang=spectre

subckt TLATNCAX16 CK E ECK VDD VSS
mp0 (\11\:CKb \3\:CK \3\:VDD VDD) g45p1lvt w=(2.15e-07) l=4.5e-08 nf=1 \
        as=7.305e-14 ad=3.01e-14 ps=1.27e-06 pd=7.1e-07 nrd=1.16667 \
        nrs=1.16667 sa=1.4e-07 sb=2e-06 sd=160n sca=27.1157 scb=0.029461 \
        scc=0.0022003 m=(1)
mp15 (net205 \13\:Eint \3\:VDD VDD) g45p1lvt w=(2.15e-07) l=4.5e-08 nf=1 \
        as=9.907e-14 ad=2.687e-14 ps=1.56e-06 pd=6.8e-07 nrd=1.16667 \
        nrs=1.16667 sa=2e-06 sb=1.245e-06 sd=160n sca=16.4667 \
        scb=0.0163489 scc=0.00112485 m=(1)
mp16 (\12\:n0 \2\:CKb net205 VDD) g45p1lvt w=(2.15e-07) l=4.5e-08 nf=1 \
        as=2.687e-14 ad=4.3e-14 ps=6.8e-07 pd=8.3e-07 nrd=1.16667 \
        nrs=1.16667 sa=2e-06 sb=1.075e-06 sd=160n sca=16.4667 \
        scb=0.0163489 scc=0.00112485 m=(1)
mp6 (\12\:n0 \13\:CKbb net217 VDD) g45p1lvt w=(2.15e-07) l=4.5e-08 nf=1 \
        as=8.6e-14 ad=4.3e-14 ps=1.23e-06 pd=8.3e-07 nrd=1.16667 \
        nrs=1.16667 sa=2e-06 sb=8.3e-07 sd=160n sca=16.4857 scb=0.0163525 \
        scc=0.00112485 m=(1)
mp5 (net217 \1\:E \1\:VDD VDD) g45p1lvt w=(2.15e-07) l=4.5e-08 nf=1 \
        as=4.3e-14 ad=8.6e-14 ps=8.3e-07 pd=1.23e-06 nrd=1.16667 \
        nrs=1.16667 sa=2e-06 sb=3.85e-07 sd=160n sca=18.6197 scb=0.0182692 \
        scc=0.00113172 m=(1)
mp1 (\22\:CKbb \7\:CKb \1\:VDD VDD) g45p1lvt w=(2.15e-07) l=4.5e-08 nf=1 \
        as=4.3e-14 ad=3.01e-14 ps=8.3e-07 pd=7.1e-07 nrd=1.16667 \
        nrs=1.16667 sa=2e-06 sb=1.4e-07 sd=160n sca=25.1716 scb=0.0291739 \
        scc=0.0016465 m=(1)
C1 (CK VSS) capacitor c=4.07155e-17
C2 (VDD VSS) capacitor c=3.79261e-16
C3 (ECK VSS) capacitor c=6.46337e-16
C4 (CKb VSS) capacitor c=3.64926e-17
C5 (ECKb VSS) capacitor c=7.03302e-16
C6 (Eint VSS) capacitor c=7.40842e-17
C7 (CKbb VSS) capacitor c=6.64598e-16
C8 (14 VSS) capacitor c=4.59195e-18
C9 (15 VSS) capacitor c=4.51456e-18
C10 (n0 VSS) capacitor c=1.7865e-16
C11 (net230 VSS) capacitor c=4.12072e-18
C12 (net254 VSS) capacitor c=5.19245e-18
C13 (net205 VSS) capacitor c=2.66516e-18
C14 (net217 VSS) capacitor c=6.0142e-18
C15 (\7\:CKb VSS) capacitor c=3.40188e-17
C16 (\1\:E VSS) capacitor c=3.33294e-17
C17 (\13\:CKbb VSS) capacitor c=5.33459e-17
C18 (\2\:CKb VSS) capacitor c=3.74952e-17
C19 (\13\:Eint VSS) capacitor c=5.41485e-17
C20 (\3\:CK VSS) capacitor c=3.98293e-17
C21 (\5\:CKb VSS) capacitor c=2.81456e-17
C22 (\3\:E VSS) capacitor c=4.0131e-17
C23 (\3\:CKb VSS) capacitor c=4.85613e-17
C24 (\14\:CKbb VSS) capacitor c=2.78379e-17
C25 (\15\:Eint VSS) capacitor c=3.12272e-17
C26 (\12\:Eint VSS) capacitor c=7.039e-17
C27 (\10\:CKbb VSS) capacitor c=4.45323e-17
C28 (\11\:CKbb VSS) capacitor c=2.40511e-17
C29 (\8\:Eint VSS) capacitor c=3.68512e-17
C30 (\7\:Eint VSS) capacitor c=3.6681e-17
C31 (\5\:CKbb VSS) capacitor c=2.53471e-17
C32 (\4\:CKbb VSS) capacitor c=4.65227e-17
C33 (\1\:CK VSS) capacitor c=2.71364e-17
C34 (\6\:CKb VSS) capacitor c=3.11994e-17
C35 (\2\:E VSS) capacitor c=4.05909e-17
C36 (\4\:CKb VSS) capacitor c=2.68845e-17
C37 (\15\:CKbb VSS) capacitor c=2.07149e-17
C38 (\14\:Eint VSS) capacitor c=3.25587e-17
C39 (\2\:Eint VSS) capacitor c=7.20916e-16
C40 (\2\:CK VSS) capacitor c=3.12924e-17
C41 (\22\:CKbb VSS) capacitor c=4.51383e-17
C42 (\1\:VDD VSS) capacitor c=4.56006e-17
C43 (\12\:n0 VSS) capacitor c=6.36928e-17
C44 (\16\:Eint VSS) capacitor c=3.11425e-17
C45 (\56\:ECKb VSS) capacitor c=4.35358e-16
C46 (\11\:CKb VSS) capacitor c=6.69082e-16
C47 (\3\:VDD VSS) capacitor c=6.33174e-16
C48 (\20\:CKbb VSS) capacitor c=1.2611e-16
C49 (\8\:n0 VSS) capacitor c=7.87869e-17
C50 (\23\:Eint VSS) capacitor c=3.04546e-17
C51 (\68\:ECKb VSS) capacitor c=1.09423e-16
C52 (\65\:ECKb VSS) capacitor c=1.16878e-16
C53 (\13\:CKb VSS) capacitor c=4.03931e-17
C54 (\4\:CK VSS) capacitor c=6.8276e-17
C55 (\64\:ECKb VSS) capacitor c=6.38678e-17
C56 (\67\:ECKb VSS) capacitor c=3.29204e-17
C57 (\18\:Eint VSS) capacitor c=3.7874e-17
C58 (\22\:Eint VSS) capacitor c=3.51436e-17
C59 (\25\:Eint VSS) capacitor c=5.48958e-17
C60 (\10\:n0 VSS) capacitor c=8.72018e-17
C61 (\11\:n0 VSS) capacitor c=5.84111e-17
C62 (\4\:E VSS) capacitor c=4.49062e-17
C63 (\6\:E VSS) capacitor c=5.00329e-17
C64 (\8\:CKb VSS) capacitor c=9.87113e-17
C65 (\9\:CKb VSS) capacitor c=8.09484e-17
C66 (\10\:CKb VSS) capacitor c=5.90765e-16
C67 (\15\:CKb VSS) capacitor c=4.57631e-17
C68 (\19\:CKbb VSS) capacitor c=2.03803e-16
Rk1 (\4\:CK CK) resistor r=0.1076 c=0
Rk100 (\3\:VDD VDD) resistor r=0.1525 c=0
Rk73 (\4\:VDD \3\:VDD) resistor r=0.2012 c=0
Rk72 (\2\:VDD \4\:VDD) resistor r=0.7393 c=0
Rk33 (\4\:E \5\:E) resistor r=0.00188 c=0
Rk34 (E \6\:E) resistor r=0.001786 c=0
Rk35 (\4\:E \6\:E) resistor r=0.06016 c=0
Rk60 (\3\:VSS VSS) resistor r=0.1951 c=0
Rk46 (\2\:VSS \4\:VSS) resistor r=0.5516 c=0
Rk47 (\4\:VSS \5\:VSS) resistor r=0.1502 c=0
Rk50 (\7\:VSS \3\:VSS) resistor r=0.3106 c=0
Rk49 (\5\:VSS \7\:VSS) resistor r=0.4207 c=0
Rk63 (\7\:VSS \23\:VSS) resistor r=0.2054 c=0
Rk36 (\8\:CKb \9\:CKb) resistor r=0.6063 c=0
Rk37 (\9\:CKb \10\:CKb) resistor r=0.1379 c=0
Rk38 (\10\:CKb \12\:CKb) resistor r=4.9485 c=0
Rk39 (\12\:CKb \14\:CKb) resistor r=0.3164 c=0
Rk40 (\10\:CKb \15\:CKb) resistor r=0.2442 c=0
Rk19 (\56\:ECKb \64\:ECKb) resistor r=0.3419 c=0
Rk20 (\64\:ECKb \66\:ECKb) resistor r=0.4673 c=0
Rk21 (\64\:ECKb \67\:ECKb) resistor r=0.1264 c=0
Rk22 (\66\:ECKb \69\:ECKb) resistor r=0.7007 c=0
Rk24 (\18\:Eint \2\:Eint) resistor r=0.2342 c=0
Rk23 (\17\:Eint \18\:Eint) resistor r=0.1161 c=0
Rk27 (\18\:Eint \22\:Eint) resistor r=0.1613 c=0
Rk28 (\22\:Eint \24\:Eint) resistor r=0.09357 c=0
Rk29 (\22\:Eint \25\:Eint) resistor r=0.2657 c=0
Rk43 (CKbb \19\:CKbb) resistor r=1.4213 c=0
Rk44 (\19\:CKbb \21\:CKbb) resistor r=0.7402 c=0
Rk45 (\21\:CKbb \23\:CKbb) resistor r=0.3798 c=0
Rk30 (\9\:n0 \10\:n0) resistor r=0.5107 c=0
Rk31 (\10\:n0 \11\:n0) resistor r=0.2657 c=0
Rk32 (\10\:n0 \13\:n0) resistor r=0.2281 c=0
Rl2 (\2\:CK \3\:CK) resistor r=74.3312 c=0
Rl1 (\1\:CK \2\:CK) resistor r=24.7951 c=0
Rl88 (\1\:E \2\:E) resistor r=94.9225 c=0
Rl89 (\2\:E \3\:E) resistor r=29.5379 c=0
Rl91 (\6\:CKb \7\:CKb) resistor r=80.5643 c=0
Rl90 (\5\:CKb \6\:CKb) resistor r=39.6664 c=0
Rl87 (\3\:CKb \4\:CKb) resistor r=29.5379 c=0
Rl84 (CKb \2\:CKb) resistor r=57.6695 c=0
Rl82 (\14\:Eint \13\:Eint) resistor r=97.3098 c=0
Rl83 (\14\:Eint \15\:Eint) resistor r=24.2328 c=0
Rl75 (\2\:Eint \12\:Eint) resistor r=98.4922 c=0
Rl67 (\2\:Eint \8\:Eint) resistor r=72.3105 c=0
Rl66 (\2\:Eint \7\:Eint) resistor r=71.8867 c=0
Rl57 (\2\:Eint Eint) resistor r=74.2328 c=0
Rl85 (\14\:CKbb \13\:CKbb) resistor r=150 c=0
Rl71 (CKbb \10\:CKbb) resistor r=28.0797 c=0
Rl72 (CKbb \11\:CKbb) resistor r=24.2328 c=0
Rl62 (CKbb \5\:CKbb) resistor r=22.5951 c=0
Rl61 (CKbb \4\:CKbb) resistor r=28.0797 c=0
Rl86 (\15\:CKbb \14\:CKbb) resistor r=26.1559 c=0
Rz14 (\2\:VSS \1\:VSS) resistor r=75 c=0
Rz17 (\23\:VSS \22\:VSS) resistor r=75 c=0
Rz12 (\13\:CKb \14\:CKb) resistor r=75 c=0
Rz8 (\66\:ECKb \65\:ECKb) resistor r=75 c=0
Rz9 (\69\:ECKb \68\:ECKb) resistor r=75 c=0
Rz10 (\24\:Eint \23\:Eint) resistor r=75 c=0
Rz13 (\21\:CKbb \20\:CKbb) resistor r=75 c=0
Rz11 (\9\:n0 \8\:n0) resistor r=75 c=0
Ry19 (\2\:VDD \1\:VDD) resistor r=62 c=0
Ry16 (\4\:VSS \3\:VSS) resistor r=5.1667 c=0
Ry14 (\11\:CKb \12\:CKb) resistor r=62 c=0
Ry12 (\17\:Eint \16\:Eint) resistor r=62 c=0
Ry15 (\23\:CKbb \22\:CKbb) resistor r=62 c=0
Ry13 (\13\:n0 \12\:n0) resistor r=62 c=0
Rx1 (\2\:CK \4\:CK) resistor r=45 c=0
Rx8 (\2\:E \5\:E) resistor r=45 c=0
Rx9 (\6\:CKb \8\:CKb) resistor r=45 c=0
Rx10 (\4\:CKb \9\:CKb) resistor r=45 c=0
Rx11 (CKb \15\:CKb) resistor r=45 c=0
Rx2 (\67\:ECKb ECKb) resistor r=45 c=0
Rx6 (\25\:Eint \14\:Eint) resistor r=45 c=0
Rx14 (\19\:CKbb \15\:CKbb) resistor r=45 c=0
Rx7 (\11\:n0 n0) resistor r=45 c=0
mn0 (\13\:CKb \1\:CK \3\:VSS VSS) g45n1lvt w=(1.45e-07) l=4.5e-08 nf=1 \
        as=5.218e-14 ad=2.465e-14 ps=1.02e-06 pd=6.3e-07 nrd=1.16667 \
        nrs=1.16667 sa=1.7e-07 sb=2e-06 sd=160n sca=23.279 scb=0.0230742 \
        scc=0.00267719 m=(1)
mn15 (net230 \15\:Eint \5\:VSS VSS) g45n1lvt w=(1.45e-07) l=4.5e-08 nf=1 \
        as=9.418e-14 ad=5.365e-14 ps=1.64e-06 pd=1.03e-06 nrd=1.16667 \
        nrs=1.16667 sa=2e-06 sb=1.275e-06 sd=160n sca=17.8702 \
        scb=0.0189183 scc=0.00156031 m=(1)
mn16 (\8\:n0 \14\:CKbb net230 VSS) g45n1lvt w=(1.45e-07) l=4.5e-08 nf=1 \
        as=5.365e-14 ad=3.553e-14 ps=1.03e-06 pd=7.8e-07 nrd=1.16667 \
        nrs=1.16667 sa=2e-06 sb=8.6e-07 sd=160n sca=17.8702 scb=0.0189183 \
        scc=0.00156031 m=(1)
mn6 (\8\:n0 \3\:CKb net254 VSS) g45n1lvt w=(1.45e-07) l=4.5e-08 nf=1 \
        as=1.595e-14 ad=3.553e-14 ps=5.1e-07 pd=7.8e-07 nrd=1.16667 \
        nrs=1.16667 sa=2e-06 sb=5.7e-07 sd=160n sca=17.8702 scb=0.0189183 \
        scc=0.00156031 m=(1)
mn5 (net254 \3\:E \1\:VSS VSS) g45n1lvt w=(1.45e-07) l=4.5e-08 nf=1 \
        as=7.03e-14 ad=1.595e-14 ps=1.37e-06 pd=5.1e-07 nrd=1.16667 \
        nrs=1.16667 sa=2e-06 sb=4.15e-07 sd=160n sca=17.8702 scb=0.0189183 \
        scc=0.00156031 m=(1)
mn1 (\20\:CKbb \5\:CKb \1\:VSS VSS) g45n1lvt w=(1.45e-07) l=4.5e-08 nf=1 \
        as=7.03e-14 ad=2.175e-14 ps=1.37e-06 pd=5.9e-07 nrd=1.16667 \
        nrs=1.16667 sa=2e-06 sb=1.5e-07 sd=160n sca=17.8702 scb=0.0189183 \
        scc=0.00156031 m=(1)
mn22_1__rcx (ECK ECKb \3\:VSS VSS) g45n1lvt w=(2.95e-07) l=4.5e-08 nf=1 \
        as=4.843e-14 ad=4.825e-14 ps=9.2571e-07 pd=9.1714e-07 nrd=1.16667 \
        nrs=1.16667 sa=2.82542e-07 sb=2e-06 sd=160n sca=16.4223 \
        scb=0.0158966 scc=0.0014413 m=(14)
mn20_1__rcx (13 Eint \3\:VSS VSS) g45n1lvt w=(2.6e-07) l=4.5e-08 nf=1 \
        as=5.94e-14 ad=1.56e-14 ps=1.02e-06 pd=6.4e-07 nrd=1.16667 \
        nrs=1.16667 sa=2e-06 sb=1.90587e-06 sd=160n sca=13.9783 \
        scb=0.013979 scc=0.000942864 m=(1)
mn21_1__rcx (\65\:ECKb \4\:CKbb 13 VSS) g45n1lvt w=(2.6e-07) l=4.5e-08 \
        nf=1 as=1.56e-14 ad=5.72e-14 ps=6.4e-07 pd=9.6e-07 nrd=1.16667 \
        nrs=1.16667 sa=2e-06 sb=1.88365e-06 sd=160n sca=13.9783 \
        scb=0.013979 scc=0.000942864 m=(1)
mn21_2__rcx (\65\:ECKb \5\:CKbb 14 VSS) g45n1lvt w=(2.6e-07) l=4.5e-08 \
        nf=1 as=4.16e-14 ad=5.72e-14 ps=8.4e-07 pd=9.6e-07 nrd=1.16667 \
        nrs=1.16667 sa=2e-06 sb=1.78721e-06 sd=160n sca=13.9783 \
        scb=0.013979 scc=0.000942864 m=(1)
mn20_2__rcx (14 \7\:Eint \22\:VSS VSS) g45n1lvt w=(2.6e-07) l=4.5e-08 \
        nf=1 as=6.68e-14 ad=4.16e-14 ps=1.12e-06 pd=8.4e-07 nrd=1.16667 \
        nrs=1.16667 sa=2e-06 sb=1.69654e-06 sd=160n sca=13.9783 \
        scb=0.013979 scc=0.000942864 m=(1)
mn20_3__rcx (15 \8\:Eint \22\:VSS VSS) g45n1lvt w=(2.6e-07) l=4.5e-08 \
        nf=1 as=6.68e-14 ad=4.16e-14 ps=1.12e-06 pd=8.4e-07 nrd=1.16667 \
        nrs=1.16667 sa=2e-06 sb=1.57933e-06 sd=160n sca=13.9783 \
        scb=0.013979 scc=0.000942864 m=(1)
mn21_3__rcx (\68\:ECKb \11\:CKbb 15 VSS) g45n1lvt w=(2.6e-07) l=4.5e-08 \
        nf=1 as=4.16e-14 ad=5.72e-14 ps=8.4e-07 pd=9.6e-07 nrd=1.16667 \
        nrs=1.16667 sa=2e-06 sb=1.48865e-06 sd=160n sca=13.9783 \
        scb=0.013979 scc=0.000942864 m=(1)
mn21 (\68\:ECKb \10\:CKbb 16 VSS) g45n1lvt w=(2.6e-07) l=4.5e-08 nf=1 \
        as=1.56e-14 ad=5.72e-14 ps=6.4e-07 pd=9.6e-07 nrd=1.16667 \
        nrs=1.16667 sa=2e-06 sb=1.37144e-06 sd=160n sca=13.9783 \
        scb=0.013979 scc=0.000942864 m=(1)
mn20 (16 \12\:Eint \5\:VSS VSS) g45n1lvt w=(2.6e-07) l=4.5e-08 nf=1 \
        as=6.408e-14 ad=1.56e-14 ps=1.07e-06 pd=6.4e-07 nrd=1.16667 \
        nrs=1.16667 sa=2e-06 sb=1.325e-06 sd=160n sca=13.9783 scb=0.013979 \
        scc=0.000942864 m=(1)
mn10_1__rcx (\23\:Eint n0 \5\:VSS VSS) g45n1lvt w=(2.05e-07) l=4.5e-08 \
        nf=1 as=7.913e-14 ad=3.895e-14 ps=1.355e-06 pd=7.9e-07 nrd=1.16667 \
        nrs=1.16667 sa=2e-06 sb=1.42902e-06 sd=160n sca=15.5643 \
        scb=0.0161016 scc=0.00117276 m=(2)
mp22_1__rcx (ECK ECKb \3\:VDD VDD) g45p1lvt w=(4.45e-07) l=4.5e-08 nf=1 \
        as=7.223e-14 ad=7.12e-14 ps=1.21929e-06 pd=1.21e-06 nrd=1.16667 \
        nrs=1.16667 sa=2.53539e-07 sb=2e-06 sd=160n sca=16.9974 \
        scb=0.0149208 scc=0.00098088 m=(14)
mp20_1__rcx (\56\:ECKb \2\:Eint \3\:VDD VDD) g45p1lvt w=(3.9e-07) \
        l=4.5e-08 nf=1 as=8.805e-14 ad=6.24e-14 ps=1.4325e-06 pd=1.1e-06 \
        nrd=1.16667 nrs=1.16667 sa=2e-06 sb=1.94154e-06 sd=160n \
        sca=15.8351 scb=0.0142471 scc=0.00110276 m=(4)
mp21_1__rcx (\56\:ECKb CKbb \3\:VDD VDD) g45p1lvt w=(3.9e-07) l=4.5e-08 \
        nf=1 as=9.24e-14 ad=6.24e-14 ps=1.33e-06 pd=1.1e-06 nrd=1.16667 \
        nrs=1.16667 sa=2e-06 sb=1.89365e-06 sd=160n sca=15.8351 \
        scb=0.0142471 scc=0.00110276 m=(4)
mp10 (\16\:Eint n0 \3\:VDD VDD) g45p1lvt w=(3.1e-07) l=4.5e-08 nf=1 \
        as=9.136e-14 ad=4.96e-14 ps=1.675e-06 pd=9.4e-07 nrd=1.16667 \
        nrs=1.16667 sa=2e-06 sb=1.3554e-06 sd=160n sca=17.3904 \
        scb=0.0162056 scc=0.00137566 m=(2)
ends TLATNCAX16
// End of subcircuit definition.
