// Generated for: spectre (May  1 09:10:53 2013 )
// Library name: gsclib045_lvt
// Cell name: ADDFHX1
// View name: extracted

simulator lang=spectre

subckt ADDFHX1 A B CI CO S VDD VSS
mp12 (\1\:CO COb \16\:VDD VDD) g45p1lvt w=(3.9e-07) l=4.5e-08 nf=1 \
        as=5.46e-14 ad=5.46e-14 ps=1.06e-06 pd=1.06e-06 nrd=1.16667 \
        nrs=1.16667 sa=1.4e-07 sb=1.4e-07 sd=160n sca=38.6307 \
        scb=0.0321643 scc=0.00380145 m=(1)
mp13 (\3\:S Sb \10\:VDD VDD) g45p1lvt w=(3.9e-07) l=4.5e-08 nf=1 \
        as=9.85e-14 ad=7.41e-14 ps=1.58e-06 pd=1.16e-06 nrd=1.16667 \
        nrs=1.16667 sa=5.0359e-07 sb=1.9e-07 sd=160n sca=33.8487 \
        scb=0.0240553 scc=0.00339289 m=(1)
C1 (A VSS) capacitor c=3.63893e-17
C2 (CO VSS) capacitor c=6.58826e-17
C3 (VDD VSS) capacitor c=2.39838e-16
C4 (B VSS) capacitor c=6.0703e-17
C5 (CI VSS) capacitor c=3.31085e-17
C6 (S VSS) capacitor c=2.26932e-17
C7 (COb VSS) capacitor c=3.15978e-17
C8 (n2 VSS) capacitor c=8.7605e-17
C9 (n4 VSS) capacitor c=7.20481e-17
C10 (Sb VSS) capacitor c=3.53114e-17
C11 (n7 VSS) capacitor c=2.00123e-18
C12 (n6 VSS) capacitor c=2.33477e-18
C13 (n3 VSS) capacitor c=6.6619e-17
C14 (n1 VSS) capacitor c=2.10879e-18
C15 (n5 VSS) capacitor c=8.22217e-17
C16 (n9 VSS) capacitor c=4.257e-18
C17 (n8 VSS) capacitor c=2.25667e-18
C18 (\10\:A VSS) capacitor c=7.32347e-17
C19 (\11\:B VSS) capacitor c=6.24937e-17
C20 (\11\:CI VSS) capacitor c=7.50071e-17
C21 (\6\:COb VSS) capacitor c=3.43086e-17
C22 (\9\:A VSS) capacitor c=6.34026e-17
C23 (\10\:B VSS) capacitor c=5.31937e-17
C24 (\7\:CI VSS) capacitor c=7.46988e-17
C25 (\6\:A VSS) capacitor c=8.50631e-17
C26 (\7\:B VSS) capacitor c=6.43972e-17
C27 (\1\:CI VSS) capacitor c=4.74443e-17
C28 (\1\:B VSS) capacitor c=4.42571e-17
C29 (\1\:A VSS) capacitor c=5.51681e-17
C30 (\3\:Sb VSS) capacitor c=2.67459e-17
C31 (\12\:A VSS) capacitor c=6.21258e-17
C32 (\13\:B VSS) capacitor c=1.0662e-16
C33 (\8\:CI VSS) capacitor c=5.80396e-17
C34 (\4\:COb VSS) capacitor c=5.74e-17
C35 (\7\:A VSS) capacitor c=5.14216e-17
C36 (\8\:B VSS) capacitor c=6.13665e-17
C37 (\5\:CI VSS) capacitor c=3.48525e-17
C38 (\4\:A VSS) capacitor c=7.4808e-17
C39 (\4\:B VSS) capacitor c=9.64273e-17
C40 (\3\:CI VSS) capacitor c=4.31738e-17
C41 (\3\:B VSS) capacitor c=5.13155e-17
C42 (\3\:A VSS) capacitor c=4.03116e-17
C43 (\3\:COb VSS) capacitor c=2.36981e-17
C44 (\2\:Sb VSS) capacitor c=2.14513e-17
C45 (\11\:A VSS) capacitor c=5.28196e-17
C46 (\12\:B VSS) capacitor c=7.40961e-17
C47 (\10\:CI VSS) capacitor c=6.05461e-17
C48 (\7\:COb VSS) capacitor c=2.17597e-17
C49 (\8\:A VSS) capacitor c=5.25819e-17
C50 (\9\:B VSS) capacitor c=5.53739e-17
C51 (\6\:CI VSS) capacitor c=5.77211e-17
C52 (\5\:A VSS) capacitor c=7.00569e-17
C53 (\6\:B VSS) capacitor c=1.53944e-17
C54 (\4\:CI VSS) capacitor c=3.65201e-17
C55 (\2\:B VSS) capacitor c=3.38688e-17
C56 (\2\:A VSS) capacitor c=2.33604e-17
C57 (\2\:COb VSS) capacitor c=1.51084e-17
C58 (\3\:S VSS) capacitor c=4.51829e-17
C59 (\10\:VDD VSS) capacitor c=5.23163e-17
C60 (\9\:Sb VSS) capacitor c=7.55176e-17
C61 (\11\:Sb VSS) capacitor c=4.75203e-17
C62 (\1\:VDD VSS) capacitor c=1.39726e-17
C63 (\3\:n5 VSS) capacitor c=7.21191e-17
C64 (\12\:VDD VSS) capacitor c=1.52904e-17
C65 (\9\:COb VSS) capacitor c=1.25819e-16
C66 (\12\:COb VSS) capacitor c=1.75956e-17
C67 (\3\:n3 VSS) capacitor c=9.51956e-17
C68 (\14\:VDD VSS) capacitor c=1.87241e-17
C69 (\1\:CO VSS) capacitor c=8.59855e-17
C70 (\16\:VDD VSS) capacitor c=4.11346e-17
C71 (\5\:VDD VSS) capacitor c=5.57341e-17
C72 (\1\:S VSS) capacitor c=4.00457e-17
C73 (\4\:Sb VSS) capacitor c=8.55668e-17
C74 (\6\:Sb VSS) capacitor c=5.29471e-17
C75 (\3\:n4 VSS) capacitor c=8.48154e-17
C76 (\16\:COb VSS) capacitor c=5.58905e-17
C77 (\19\:COb VSS) capacitor c=2.58285e-17
C78 (\3\:n2 VSS) capacitor c=7.90147e-17
C79 (\3\:CO VSS) capacitor c=4.27576e-17
C80 (\2\:CI VSS) capacitor c=2.67749e-17
C81 (\5\:B VSS) capacitor c=4.45459e-17
C82 (\5\:COb VSS) capacitor c=5.29551e-17
C83 (\8\:COb VSS) capacitor c=1.62865e-16
C84 (\11\:COb VSS) capacitor c=9.7195e-17
C85 (\14\:COb VSS) capacitor c=1.84611e-16
C86 (\15\:COb VSS) capacitor c=1.4463e-16
C87 (\18\:COb VSS) capacitor c=5.36275e-17
C88 (\12\:CI VSS) capacitor c=1.46338e-16
C89 (\13\:CI VSS) capacitor c=1.73872e-16
C90 (\14\:CI VSS) capacitor c=6.94829e-17
C91 (\14\:B VSS) capacitor c=8.74414e-17
C92 (\15\:B VSS) capacitor c=7.43439e-17
C93 (\16\:B VSS) capacitor c=1.85949e-16
C94 (\17\:B VSS) capacitor c=1.39712e-16
C95 (\13\:A VSS) capacitor c=1.16215e-16
C96 (\14\:A VSS) capacitor c=1.95134e-16
C97 (\15\:A VSS) capacitor c=2.06446e-16
C98 (\16\:A VSS) capacitor c=1.27683e-16
C99 (\8\:Sb VSS) capacitor c=1.72542e-16
C100 (\3\:VDD VSS) capacitor c=2.3361e-17
C101 (\4\:VDD VSS) capacitor c=2.65096e-17
C102 (\7\:VDD VSS) capacitor c=1.40667e-17
C103 (\8\:VDD VSS) capacitor c=1.20447e-17
Rk22 (A \13\:A) resistor r=0.05405 c=0
Rk23 (\13\:A \14\:A) resistor r=0.8074 c=0
Rk24 (\14\:A \15\:A) resistor r=0.5547 c=0
Rk25 (\15\:A \16\:A) resistor r=0.8886 c=0
Rk43 (\2\:VSS \3\:VSS) resistor r=0.1839 c=0
Rk44 (\3\:VSS \5\:VSS) resistor r=0.4887 c=0
Rk45 (\5\:VSS \6\:VSS) resistor r=0.0816 c=0
Rk47 (\7\:VSS VSS) resistor r=0.03466 c=0
Rk46 (\6\:VSS \7\:VSS) resistor r=0.4324 c=0
Rk48 (\3\:VSS \8\:VSS) resistor r=0.2052 c=0
Rk49 (\8\:VSS \10\:VSS) resistor r=0.1359 c=0
Rk50 (\6\:VSS \12\:VSS) resistor r=0.0433 c=0
Rk51 (\7\:VSS \14\:VSS) resistor r=0.274 c=0
Rk52 (\8\:VSS \15\:VSS) resistor r=0.4085 c=0
Rk53 (\15\:VSS \17\:VSS) resistor r=0.3685 c=0
Rk1 (\2\:CO CO) resistor r=0.4916 c=0
Rk2 (CO \4\:CO) resistor r=0.2015 c=0
Rk32 (\2\:VDD \3\:VDD) resistor r=0.07381 c=0
Rk33 (\3\:VDD \4\:VDD) resistor r=0.2344 c=0
Rk34 (\4\:VDD \6\:VDD) resistor r=0.4652 c=0
Rk35 (\6\:VDD \7\:VDD) resistor r=0.0816 c=0
Rk37 (\8\:VDD VDD) resistor r=0.03466 c=0
Rk36 (\7\:VDD \8\:VDD) resistor r=0.4324 c=0
Rk38 (\3\:VDD \9\:VDD) resistor r=0.401 c=0
Rk39 (\9\:VDD \11\:VDD) resistor r=0.4153 c=0
Rk40 (\4\:VDD \13\:VDD) resistor r=0.0433 c=0
Rk41 (\7\:VDD \15\:VDD) resistor r=0.0433 c=0
Rk42 (\8\:VDD \17\:VDD) resistor r=0.3385 c=0
Rk18 (\14\:B B) resistor r=0.3954 c=0
Rk19 (B \15\:B) resistor r=0.06271 c=0
Rk20 (\15\:B \16\:B) resistor r=0.5018 c=0
Rk21 (\16\:B \17\:B) resistor r=0.8662 c=0
Rk15 (\12\:CI \13\:CI) resistor r=0.8837 c=0
Rk17 (\14\:CI CI) resistor r=0.01639 c=0
Rk16 (\13\:CI \14\:CI) resistor r=0.4688 c=0
Rk30 (S \2\:S) resistor r=0.07795 c=0
Rk31 (\2\:S \4\:S) resistor r=0.3675 c=0
Rk7 (\8\:COb \10\:COb) resistor r=1.1562 c=0
Rk8 (\10\:COb \11\:COb) resistor r=0.1576 c=0
Rk9 (\11\:COb \13\:COb) resistor r=0.04526 c=0
Rk10 (\11\:COb \14\:COb) resistor r=1.0324 c=0
Rk11 (\14\:COb \15\:COb) resistor r=0.9294 c=0
Rk12 (\15\:COb \17\:COb) resistor r=0.337 c=0
Rk13 (\14\:COb \18\:COb) resistor r=0.2088 c=0
Rk14 (\15\:COb \20\:COb) resistor r=0.07456 c=0
Rk3 (\2\:n2 \4\:n2) resistor r=0.282 c=0
Rk6 (\2\:n4 \4\:n4) resistor r=0.2808 c=0
Rk26 (\5\:Sb \7\:Sb) resistor r=0.2103 c=0
Rk27 (\5\:Sb \8\:Sb) resistor r=0.6086 c=0
Rk28 (\8\:Sb \10\:Sb) resistor r=0.7525 c=0
Rk29 (\10\:Sb \12\:Sb) resistor r=0.1267 c=0
Rk4 (\2\:n3 \4\:n3) resistor r=0.4404 c=0
Rk5 (\2\:n5 \4\:n5) resistor r=0.2356 c=0
Rl29 (\10\:A \11\:A) resistor r=89.6174 c=0
Rl30 (\11\:A \12\:A) resistor r=93.4636 c=0
Rl20 (\8\:A \9\:A) resistor r=83.9406 c=0
Rl19 (\7\:A \8\:A) resistor r=99.2576 c=0
Rl14 (\5\:A \6\:A) resistor r=87.9121 c=0
Rl13 (\4\:A \5\:A) resistor r=100 c=0
Rl3 (\1\:A \2\:A) resistor r=68.4636 c=0
Rl4 (\2\:A \3\:A) resistor r=24.2328 c=0
Rl27 (\11\:B \12\:B) resistor r=24.2328 c=0
Rl28 (\12\:B \13\:B) resistor r=158.848 c=0
Rl18 (\9\:B \10\:B) resistor r=24.2328 c=0
Rl17 (\8\:B \9\:B) resistor r=155.814 c=0
Rl5 (\1\:B \2\:B) resistor r=29.5379 c=0
Rl6 (\2\:B \3\:B) resistor r=87.2302 c=0
Rl12 (\5\:B \7\:B) resistor r=34.3295 c=0
Rl10 (\4\:B \5\:B) resistor r=180.049 c=0
Rl11 (\5\:B \6\:B) resistor r=4.3144 c=0
Rl16 (\6\:CI \7\:CI) resistor r=155.814 c=0
Rl15 (\5\:CI \6\:CI) resistor r=24.2328 c=0
Rl7 (\1\:CI \2\:CI) resistor r=99.0311 c=0
Rl8 (\2\:CI \3\:CI) resistor r=53.4552 c=0
Rl9 (\2\:CI \4\:CI) resistor r=89.3546 c=0
Rl26 (\9\:CI \11\:CI) resistor r=158.774 c=0
Rl24 (\8\:CI \9\:CI) resistor r=65.0471 c=0
Rl25 (\9\:CI \10\:CI) resistor r=15.0424 c=0
Rl1 (COb \2\:COb) resistor r=29.5379 c=0
Rl2 (\2\:COb \3\:COb) resistor r=44.9225 c=0
Rl22 (\5\:COb \6\:COb) resistor r=59.5933 c=0
Rl21 (\4\:COb \5\:COb) resistor r=166.989 c=0
Rl23 (\5\:COb \7\:COb) resistor r=79.5158 c=0
Rl31 (Sb \2\:Sb) resistor r=39.6174 c=0
Rl32 (\2\:Sb \3\:Sb) resistor r=24.2328 c=0
Rz13 (\1\:VSS \2\:VSS) resistor r=75 c=0
Rz14 (\9\:VSS \10\:VSS) resistor r=75 c=0
Rz15 (\11\:VSS \12\:VSS) resistor r=75 c=0
Rz16 (\13\:VSS \14\:VSS) resistor r=75 c=0
Rz17 (\16\:VSS \17\:VSS) resistor r=75 c=0
Rz1 (\3\:CO \4\:CO) resistor r=75 c=0
Rz11 (\5\:VDD \6\:VDD) resistor r=6.25 c=0
Rz12 (\5\:VDD \9\:VDD) resistor r=7.5 c=0
Rz10 (\1\:S \2\:S) resistor r=75 c=0
Rz6 (\16\:COb \17\:COb) resistor r=75 c=0
Rz7 (\19\:COb \20\:COb) resistor r=75 c=0
Rz2 (n2 \2\:n2) resistor r=75 c=0
Rz3 (\3\:n2 \4\:n2) resistor r=75 c=0
Rz4 (n4 \2\:n4) resistor r=75 c=0
Rz5 (\3\:n4 \4\:n4) resistor r=75 c=0
Rz8 (\4\:Sb \5\:Sb) resistor r=75 c=0
Rz9 (\6\:Sb \7\:Sb) resistor r=75 c=0
Ry16 (\4\:VSS \5\:VSS) resistor r=5.1667 c=0
Ry17 (\4\:VSS \15\:VSS) resistor r=6.2 c=0
Ry1 (\1\:CO \2\:CO) resistor r=20.6667 c=0
Ry11 (\1\:VDD \2\:VDD) resistor r=62 c=0
Ry12 (\10\:VDD \11\:VDD) resistor r=62 c=0
Ry13 (\12\:VDD \13\:VDD) resistor r=62 c=0
Ry14 (\14\:VDD \15\:VDD) resistor r=62 c=0
Ry15 (\16\:VDD \17\:VDD) resistor r=62 c=0
Ry10 (\3\:S \4\:S) resistor r=20.6667 c=0
Ry6 (\9\:COb \10\:COb) resistor r=31 c=0
Ry7 (\12\:COb \13\:COb) resistor r=62 c=0
Ry8 (\9\:Sb \10\:Sb) resistor r=62 c=0
Ry9 (\11\:Sb \12\:Sb) resistor r=62 c=0
Ry2 (n3 \2\:n3) resistor r=62 c=0
Ry3 (\3\:n3 \4\:n3) resistor r=62 c=0
Ry4 (n5 \2\:n5) resistor r=62 c=0
Ry5 (\3\:n5 \4\:n5) resistor r=62 c=0
Rx10 (\11\:A \13\:A) resistor r=45 c=0
Rx11 (\8\:A \14\:A) resistor r=45 c=0
Rx12 (\5\:A \15\:A) resistor r=45 c=0
Rx13 (\2\:A \16\:A) resistor r=45 c=0
Rx6 (\2\:B \14\:B) resistor r=45 c=0
Rx7 (\6\:B \15\:B) resistor r=45 c=0
Rx8 (\9\:B \16\:B) resistor r=45 c=0
Rx9 (\12\:B \17\:B) resistor r=45 c=0
Rx3 (\10\:CI \12\:CI) resistor r=45 c=0
Rx4 (\6\:CI \13\:CI) resistor r=45 c=0
Rx5 (\4\:CI \14\:CI) resistor r=45 c=0
Rx1 (\7\:COb \8\:COb) resistor r=45 c=0
Rx2 (\2\:COb \18\:COb) resistor r=45 c=0
Rx14 (\2\:Sb \8\:Sb) resistor r=45 c=0
mn12 (\3\:CO \3\:COb \13\:VSS VSS) g45n1lvt w=(2.6e-07) l=4.5e-08 nf=1 \
        as=3.64e-14 ad=3.64e-14 ps=8e-07 pd=8e-07 nrd=1.16667 nrs=1.16667 \
        sa=1.4e-07 sb=1.4e-07 sd=160n sca=15.3338 scb=0.0153436 \
        scc=0.00119435 m=(1)
mn13 (\1\:S \3\:Sb \16\:VSS VSS) g45n1lvt w=(2.6e-07) l=4.5e-08 nf=1 \
        as=6.825e-14 ad=4.94e-14 ps=1.42e-06 pd=9e-07 nrd=1.16667 \
        nrs=1.16667 sa=2.70769e-07 sb=1.9e-07 sd=160n sca=17.5885 \
        scb=0.0172826 scc=0.00162584 m=(1)
mn2 (\3\:n2 \3\:A \11\:VSS VSS) g45n1lvt w=(2.05e-07) l=4.5e-08 nf=1 \
        as=8.11e-14 ad=2.87e-14 ps=1.45e-06 pd=6.9e-07 nrd=1.16667 \
        nrs=1.16667 sa=1.4e-07 sb=6.1e-07 sd=160n sca=12.4149 scb=0.012446 \
        scc=0.000614222 m=(1)
mn3 (n2 \3\:B \11\:VSS VSS) g45n1lvt w=(2.05e-07) l=4.5e-08 nf=1 \
        as=8.11e-14 ad=3.28e-14 ps=1.45e-06 pd=7.3e-07 nrd=1.16667 \
        nrs=1.16667 sa=4.05e-07 sb=3.45e-07 sd=160n sca=12.4149 \
        scb=0.012446 scc=0.000614222 m=(1)
mn4 (\19\:COb \3\:CI n2 VSS) g45n1lvt w=(2.05e-07) l=4.5e-08 nf=1 \
        as=3.28e-14 ad=2.87e-14 ps=7.3e-07 pd=6.9e-07 nrd=1.16667 \
        nrs=1.16667 sa=6.1e-07 sb=1.4e-07 sd=160n sca=12.4149 scb=0.012446 \
        scc=0.000614222 m=(1)
mn1 (\16\:COb \4\:B n0 VSS) g45n1lvt w=(2.05e-07) l=4.5e-08 nf=1 \
        as=1.23e-14 ad=2.87e-14 ps=5.3e-07 pd=6.9e-07 nrd=1.16667 \
        nrs=1.16667 sa=1.4e-07 sb=1.125e-06 sd=160n sca=7.4441 \
        scb=0.00471561 scc=6.10752e-05 m=(1)
mn0 (n0 \4\:A \1\:VSS VSS) g45n1lvt w=(2.05e-07) l=4.5e-08 nf=1 \
        as=3.28e-14 ad=1.23e-14 ps=7.3e-07 pd=5.3e-07 nrd=1.16667 \
        nrs=1.16667 sa=2.45e-07 sb=1.02e-06 sd=160n sca=7.4441 \
        scb=0.00471561 scc=6.10752e-05 m=(1)
mn7 (\3\:n4 \5\:CI \1\:VSS VSS) g45n1lvt w=(2.05e-07) l=4.5e-08 nf=1 \
        as=3.28e-14 ad=3.28e-14 ps=7.3e-07 pd=7.3e-07 nrd=1.16667 \
        nrs=1.16667 sa=4.5e-07 sb=8.15e-07 sd=160n sca=7.4441 \
        scb=0.00471561 scc=6.10752e-05 m=(1)
mn6 (\3\:n4 \8\:B \9\:VSS VSS) g45n1lvt w=(2.05e-07) l=4.5e-08 nf=1 \
        as=5.29e-14 ad=3.28e-14 ps=9.8e-07 pd=7.3e-07 nrd=1.16667 \
        nrs=1.16667 sa=6.55e-07 sb=6.1e-07 sd=160n sca=7.4441 \
        scb=0.00471561 scc=6.10752e-05 m=(1)
mn5 (n4 \7\:A \9\:VSS VSS) g45n1lvt w=(2.05e-07) l=4.5e-08 nf=1 \
        as=5.29e-14 ad=3.28e-14 ps=9.8e-07 pd=7.3e-07 nrd=1.16667 \
        nrs=1.16667 sa=9.2e-07 sb=3.45e-07 sd=160n sca=7.4441 \
        scb=0.00471561 scc=6.10752e-05 m=(1)
mn8 (\6\:Sb \4\:COb n4 VSS) g45n1lvt w=(2.05e-07) l=4.5e-08 nf=1 \
        as=3.28e-14 ad=2.87e-14 ps=7.3e-07 pd=6.9e-07 nrd=1.16667 \
        nrs=1.16667 sa=1.125e-06 sb=1.4e-07 sd=160n sca=7.4441 \
        scb=0.00471561 scc=6.10752e-05 m=(1)
mn11 (\4\:Sb \8\:CI n7 VSS) g45n1lvt w=(2.05e-07) l=4.5e-08 nf=1 \
        as=1.23e-14 ad=2.87e-14 ps=5.3e-07 pd=6.9e-07 nrd=1.16667 \
        nrs=1.16667 sa=1.4e-07 sb=5.12927e-07 sd=160n sca=8.14041 \
        scb=0.00590656 scc=0.000103269 m=(1)
mn10 (n7 \13\:B n6 VSS) g45n1lvt w=(2.05e-07) l=4.5e-08 nf=1 as=1.435e-14 \
        ad=1.23e-14 ps=5.5e-07 pd=5.3e-07 nrd=1.16667 nrs=1.16667 \
        sa=2.45e-07 sb=4.07927e-07 sd=160n sca=8.14041 scb=0.00590656 \
        scc=0.000103269 m=(1)
mn9 (n6 \12\:A \16\:VSS VSS) g45n1lvt w=(2.05e-07) l=4.5e-08 nf=1 \
        as=6.825e-14 ad=1.435e-14 ps=1.42e-06 pd=5.5e-07 nrd=1.16667 \
        nrs=1.16667 sa=3.6e-07 sb=2.92927e-07 sd=160n sca=8.14041 \
        scb=0.00590656 scc=0.000103269 m=(1)
mp2 (n3 \1\:A \14\:VDD VDD) g45p1lvt w=(3.1e-07) l=4.5e-08 nf=1 \
        as=1.1475e-13 ad=4.34e-14 ps=1.9e-06 pd=9e-07 nrd=1.16667 \
        nrs=1.16667 sa=1.4e-07 sb=6.14113e-07 sd=160n sca=35.8226 \
        scb=0.0234328 scc=0.00420469 m=(1)
mp3 (\3\:n3 \1\:B \14\:VDD VDD) g45p1lvt w=(3.1e-07) l=4.5e-08 nf=1 \
        as=1.1475e-13 ad=8.525e-14 ps=1.9e-06 pd=1.17e-06 nrd=1.16667 \
        nrs=1.16667 sa=3.63306e-07 sb=4.6e-07 sd=160n sca=20.5825 \
        scb=0.0183783 scc=0.00199566 m=(1)
mp4 (\12\:COb \1\:CI \3\:n3 VDD) g45p1lvt w=(3.1e-07) l=4.5e-08 nf=1 \
        as=8.525e-14 ad=4.34e-14 ps=1.17e-06 pd=9e-07 nrd=1.16667 \
        nrs=1.16667 sa=6.83306e-07 sb=1.4e-07 sd=160n sca=20.5825 \
        scb=0.0183783 scc=0.00199566 m=(1)
mp1 (\9\:COb \7\:B n1 VDD) g45p1lvt w=(3.1e-07) l=4.5e-08 nf=1 \
        as=1.86e-14 ad=4.34e-14 ps=7.4e-07 pd=9e-07 nrd=1.16667 \
        nrs=1.16667 sa=1.4e-07 sb=1.135e-06 sd=160n sca=15.5687 \
        scb=0.0146164 scc=0.00101158 m=(1)
mp0 (n1 \6\:A \12\:VDD VDD) g45p1lvt w=(3.1e-07) l=4.5e-08 nf=1 \
        as=1.066e-13 ad=1.86e-14 ps=1.7e-06 pd=7.4e-07 nrd=1.16667 \
        nrs=1.16667 sa=2.45e-07 sb=1.03e-06 sd=160n sca=15.5687 \
        scb=0.0146164 scc=0.00101158 m=(1)
mp7 (\3\:n5 \7\:CI \12\:VDD VDD) g45p1lvt w=(3.1e-07) l=4.5e-08 nf=1 \
        as=1.066e-13 ad=4.96e-14 ps=1.7e-06 pd=9.4e-07 nrd=1.16667 \
        nrs=1.16667 sa=5.1e-07 sb=7.65e-07 sd=160n sca=15.5687 \
        scb=0.0146164 scc=0.00101158 m=(1)
mp6 (\3\:n5 \10\:B \1\:VDD VDD) g45p1lvt w=(3.1e-07) l=4.5e-08 nf=1 \
        as=7.09e-14 ad=4.96e-14 ps=1.7e-06 pd=9.4e-07 nrd=1.16667 \
        nrs=1.16667 sa=7.15e-07 sb=5.6e-07 sd=160n sca=15.5687 \
        scb=0.0146164 scc=0.00101158 m=(1)
mp5 (n5 \9\:A \1\:VDD VDD) g45p1lvt w=(3.1e-07) l=4.5e-08 nf=1 \
        as=7.09e-14 ad=4.96e-14 ps=1.7e-06 pd=9.4e-07 nrd=1.16667 \
        nrs=1.16667 sa=9.1e-07 sb=3.65e-07 sd=160n sca=15.5687 \
        scb=0.0146164 scc=0.00101158 m=(1)
mp8 (\11\:Sb \6\:COb n5 VDD) g45p1lvt w=(3.1e-07) l=4.5e-08 nf=1 \
        as=4.96e-14 ad=4.96e-14 ps=9.4e-07 pd=1.13e-06 nrd=1.16667 \
        nrs=1.16667 sa=1.115e-06 sb=1.6e-07 sd=160n sca=15.5687 \
        scb=0.0146164 scc=0.00101158 m=(1)
mp11 (\9\:Sb \11\:CI n9 VDD) g45p1lvt w=(3.1e-07) l=4.5e-08 nf=1 \
        as=4.185e-14 ad=3.7e-14 ps=8.9e-07 pd=9e-07 nrd=1.16667 \
        nrs=1.16667 sa=1.19355e-07 sb=7.29194e-07 sd=160n sca=13.6224 \
        scb=0.0125368 scc=0.000630866 m=(1)
mp10 (n9 \11\:B n8 VDD) g45p1lvt w=(3.1e-07) l=4.5e-08 nf=1 as=2.17e-14 \
        ad=4.185e-14 ps=7.6e-07 pd=8.9e-07 nrd=1.16667 nrs=1.16667 \
        sa=2.99355e-07 sb=5.49194e-07 sd=160n sca=13.9217 scb=0.012619 \
        scc=0.000630881 m=(1)
mp9 (n8 \10\:A \10\:VDD VDD) g45p1lvt w=(3.1e-07) l=4.5e-08 nf=1 \
        as=9.85e-14 ad=2.17e-14 ps=1.58e-06 pd=7.6e-07 nrd=1.16667 \
        nrs=1.16667 sa=4.14355e-07 sb=4.34194e-07 sd=160n sca=14.3211 \
        scb=0.0128282 scc=0.000631006 m=(1)
ends ADDFHX1
// End of subcircuit definition.
