// gsclib045_backbias/NOR4BX4/schematic

simulator lang=spectre

subckt NOR4BX4 AN B C D Y NW VDD VSS
mn4 (Y D VSS VSS) g45n1svt w=(1.04u) l=45n nf=1 m=(1)
mn1 (Y n0 VSS VSS) g45n1svt w=(1.04u) l=45n nf=1 m=(1)
mn3 (Y C VSS VSS) g45n1svt w=(1.04u) l=45n nf=1 m=(1)
mn0 (n0 AN VSS VSS) g45n1svt w=(260n) l=45n nf=1 m=(1)
mn2 (Y B VSS VSS) g45n1svt w=(1.04u) l=45n nf=1 m=(1)
mp4 (Y D n3 NW) g45p1svt w=(1.56u) l=45n nf=1 m=(1)
mp0 (n0 AN VDD NW) g45p1svt w=(390n) l=45n nf=1 m=(1)
mp3 (n3 C n2 NW) g45p1svt w=(1.56u) l=45n nf=1 m=(1)
mp2 (n2 B n1 NW) g45p1svt w=(1.56u) l=45n nf=1 m=(1)
mp1 (n1 n0 VDD NW) g45p1svt w=(1.56u) l=45n nf=1 m=(1)
ends NOR4BX4
