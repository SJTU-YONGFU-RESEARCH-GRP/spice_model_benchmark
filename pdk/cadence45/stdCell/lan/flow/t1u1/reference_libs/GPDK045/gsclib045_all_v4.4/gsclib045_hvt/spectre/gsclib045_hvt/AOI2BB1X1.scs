// gsclib045_hvt/AOI2BB1X1/schematic

simulator lang=spectre

subckt AOI2BB1X1 A0N A1N B0 Y VSS VDD
mp3 (Y n0 n2 VDD) g45p1hvt w=(390n) l=45n nf=1 m=(1)
mp2 (n2 B0 VDD VDD) g45p1hvt w=(390n) l=45n nf=1 m=(1)
mp1 (n0 A1N n1 VDD) g45p1hvt w=(215n) l=45n nf=1 m=(1)
mp0 (n1 A0N VDD VDD) g45p1hvt w=(215n) l=45n nf=1 m=(1)
mn2 (Y B0 VSS VSS) g45n1hvt w=(260n) l=45n nf=1 m=(1)
mn1 (n0 A1N VSS VSS) g45n1hvt w=(145n) l=45n nf=1 m=(1)
mn3 (Y n0 VSS VSS) g45n1hvt w=(260n) l=45n nf=1 m=(1)
mn0 (n0 A0N VSS VSS) g45n1hvt w=(145n) l=45n nf=1 m=(1)
ends AOI2BB1X1
