// gsclib045_lvt/AO22X2/schematic

simulator lang=spectre

subckt AO22X2 A0 A1 B0 B1 Y VSS VDD
mp3 (net128 B1 net111 VDD) g45p1lvt w=(215n) l=45n nf=1 m=(1)
mp2 (net128 B0 net111 VDD) g45p1lvt w=(215n) l=45n nf=1 m=(1)
mp1 (net111 A1 VDD VDD) g45p1lvt w=(215n) l=45n nf=1 m=(1)
mp0 (net111 A0 VDD VDD) g45p1lvt w=(215n) l=45n nf=1 m=(1)
mp4 (Y net128 VDD VDD) g45p1lvt w=(780n) l=45n nf=1 m=(1)
mn3 (net128 B1 net132 VSS) g45n1lvt w=(145n) l=45n nf=1 m=(1)
mn2 (net132 B0 VSS VSS) g45n1lvt w=(145n) l=45n nf=1 m=(1)
mn1 (net128 A1 net124 VSS) g45n1lvt w=(145n) l=45n nf=1 m=(1)
mn0 (net124 A0 VSS VSS) g45n1lvt w=(145n) l=45n nf=1 m=(1)
mn4 (Y net128 VSS VSS) g45n1lvt w=(520n) l=45n nf=1 m=(1)
ends AO22X2
