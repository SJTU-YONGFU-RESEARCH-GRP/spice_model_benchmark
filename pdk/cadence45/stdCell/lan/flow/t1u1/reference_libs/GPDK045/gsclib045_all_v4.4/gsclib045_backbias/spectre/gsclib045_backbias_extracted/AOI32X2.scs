// Generated for: spectre (May  1 11:27:54 2013 )
// Library name: gsclib045_backbias
// Cell name: AOI32X2
// View name: extracted

simulator lang=spectre

subckt AOI32X2 A0 A1 A2 B0 B1 NW VDD VSS Y
mp2_1__rcx (net47 \3\:A2 \5\:VDD NW) g45p1svt w=(3.9e-07) l=4.5e-08 nf=1 \
        as=6.24e-14 ad=6.24e-14 ps=1.1e-06 pd=1.1e-06 nrd=1.16667 \
        nrs=1.16667 sa=5.5e-07 sb=1.75e-06 sd=160n sca=12.9062 \
        scb=0.0110166 scc=0.000412479 m=(2)
mp4 (\7\:Y \1\:B1 \4\:net47 NW) g45p1svt w=(3.9e-07) l=4.5e-08 nf=1 \
        as=6.24e-14 ad=8.093e-14 ps=1.1e-06 pd=1.195e-06 nrd=1.16667 \
        nrs=1.16667 sa=1.655e-06 sb=6.45e-07 sd=160n sca=12.9823 \
        scb=0.0110609 scc=0.000412509 m=(2)
mp3_1__rcx (\7\:Y B0 net47 NW) g45p1svt w=(3.9e-07) l=4.5e-08 nf=1 \
        as=7.41e-14 ad=8.093e-14 ps=1.16e-06 pd=1.195e-06 nrd=1.16667 \
        nrs=1.16667 sa=1.45e-06 sb=8.5e-07 sd=160n sca=12.4042 \
        scb=0.0108296 scc=0.000412414 m=(2)
mp0_1__rcx (net47 A0 \1\:VDD NW) g45p1svt w=(3.9e-07) l=4.5e-08 nf=1 \
        as=6.24e-14 ad=7.41e-14 ps=1.1e-06 pd=1.16e-06 nrd=1.16667 \
        nrs=1.16667 sa=1.4e-07 sb=2e-06 sd=160n sca=17.4492 scb=0.017739 \
        scc=0.000533089 m=(2)
mp1_1__rcx (net47 \1\:A1 \1\:VDD NW) g45p1svt w=(3.9e-07) l=4.5e-08 nf=1 \
        as=6.24e-14 ad=6.24e-14 ps=1.1e-06 pd=1.1e-06 nrd=1.16667 \
        nrs=1.16667 sa=3.45e-07 sb=1.955e-06 sd=160n sca=14.0779 \
        scb=0.0121323 scc=0.000415426 m=(2)
C1 (A2 VSS) capacitor c=7.42894e-17
C2 (B1 VSS) capacitor c=5.17925e-17
C3 (NW VSS) capacitor c=3.39156e-16
C4 (A0 VSS) capacitor c=4.40862e-16
C5 (Y VSS) capacitor c=2.17495e-17
C6 (B0 VSS) capacitor c=3.39883e-16
C7 (A1 VSS) capacitor c=1.9487e-17
C8 (VDD VSS) capacitor c=3.65416e-17
C9 (11 VSS) capacitor c=1.92813e-18
C10 (12 VSS) capacitor c=5.2414e-18
C11 (13 VSS) capacitor c=2.77956e-18
C12 (14 VSS) capacitor c=9.73428e-18
C13 (15 VSS) capacitor c=4.63479e-18
C14 (16 VSS) capacitor c=6.32374e-18
C15 (net47 VSS) capacitor c=3.5706e-16
C16 (\1\:B1 VSS) capacitor c=8.47854e-17
C17 (\1\:A1 VSS) capacitor c=3.63568e-16
C18 (\6\:B0 VSS) capacitor c=2.24976e-17
C19 (\4\:B1 VSS) capacitor c=2.12797e-17
C20 (\6\:B1 VSS) capacitor c=4.59199e-17
C21 (\1\:B0 VSS) capacitor c=4.1148e-17
C22 (\6\:A0 VSS) capacitor c=3.27122e-17
C23 (\6\:A1 VSS) capacitor c=5.82842e-17
C24 (\1\:A2 VSS) capacitor c=6.40117e-17
C25 (\5\:A2 VSS) capacitor c=2.40383e-17
C26 (\3\:A1 VSS) capacitor c=5.85565e-17
C27 (\1\:A0 VSS) capacitor c=4.88998e-17
C28 (\3\:A2 VSS) capacitor c=9.53118e-17
C29 (\4\:net47 VSS) capacitor c=8.99878e-17
C30 (\7\:Y VSS) capacitor c=1.46556e-16
C31 (\5\:VDD VSS) capacitor c=3.97405e-17
C32 (\1\:Y VSS) capacitor c=5.07591e-17
C33 (\4\:Y VSS) capacitor c=7.84232e-17
C34 (\2\:A2 VSS) capacitor c=1.86707e-17
C35 (\3\:B1 VSS) capacitor c=2.04803e-17
C36 (\7\:A2 VSS) capacitor c=3.83596e-17
C37 (\3\:Y VSS) capacitor c=9.88597e-17
C38 (\6\:Y VSS) capacitor c=4.88214e-17
C39 (\7\:B1 VSS) capacitor c=5.03619e-17
C40 (\1\:VDD VSS) capacitor c=3.5901e-16
Rk1 (\7\:A2 A2) resistor r=0.2025 c=0
Rk12 (B1 \7\:B1) resistor r=0.02928 c=0
Rk6 (\2\:Y \3\:Y) resistor r=0.3186 c=0
Rk7 (\3\:Y \5\:Y) resistor r=0.4836 c=0
Rk9 (\6\:Y Y) resistor r=0.02559 c=0
Rk10 (\6\:Y \7\:Y) resistor r=0.2431 c=0
Rk8 (\3\:Y \6\:Y) resistor r=0.3845 c=0
Rk21 (\2\:VSS \4\:VSS) resistor r=0.288 c=0
Rk22 (\4\:VSS \5\:VSS) resistor r=0.5261 c=0
Rk23 (\5\:VSS \6\:VSS) resistor r=0.1251 c=0
Rk25 (\7\:VSS VSS) resistor r=0.1073 c=0
Rk24 (\6\:VSS \7\:VSS) resistor r=0.4434 c=0
Rk26 (\5\:VSS \9\:VSS) resistor r=0.1021 c=0
Rk27 (\7\:VSS \11\:VSS) resistor r=0.2815 c=0
Rk2 (A1 \1\:A1) resistor r=0.02396 c=0
Rk28 (VDD \1\:VDD) resistor r=0.1599 c=0
Rk31 (\1\:VDD \6\:VDD) resistor r=0.1995 c=0
Rl5 (\2\:A2 \1\:A2) resistor r=82.6702 c=0
Rl8 (\2\:A2 \5\:A2) resistor r=49.9779 c=0
Rl6 (\2\:A2 \3\:A2) resistor r=49.0067 c=0
Rl17 (\3\:B1 \1\:B1) resistor r=23.8563 c=0
Rl18 (\3\:B1 \4\:B1) resistor r=32.7557 c=0
Rl20 (\3\:B1 \6\:B1) resistor r=82.1768 c=0
Rl13 (A0 \6\:A0) resistor r=28.1859 c=0
Rl1 (A0 \1\:A0) resistor r=29.8412 c=0
Rl22 (B0 \6\:B0) resistor r=37.3411 c=0
Rl14 (B0 \1\:B0) resistor r=24.7951 c=0
Rl11 (\1\:A1 \6\:A1) resistor r=47.2527 c=0
Rl4 (\1\:A1 \3\:A1) resistor r=35.3072 c=0
Rz1 (\2\:Y \1\:Y) resistor r=75 c=0
Rz2 (\5\:Y \4\:Y) resistor r=75 c=0
Rz3 (\1\:VSS \2\:VSS) resistor r=75 c=0
Rz4 (\8\:VSS \9\:VSS) resistor r=75 c=0
Rz5 (\10\:VSS \11\:VSS) resistor r=75 c=0
Ry10 (\3\:VSS \4\:VSS) resistor r=62 c=0
Ry11 (\3\:VSS \6\:VSS) resistor r=5.1667 c=0
Ry13 (\6\:VDD \5\:VDD) resistor r=62 c=0
Ry5 (net47 \4\:net47) resistor r=62 c=0
Rx1 (\7\:A2 \3\:A2) resistor r=45 c=0
Rx6 (\7\:B1 \1\:B1) resistor r=45 c=0
mn0_1__rcx (11 \1\:A0 \10\:VSS VSS) g45n1svt w=(2.6e-07) l=4.5e-08 nf=1 \
        as=3.64e-14 ad=1.56e-14 ps=8e-07 pd=6.4e-07 nrd=1.16667 \
        nrs=1.16667 sa=1.4e-07 sb=2e-06 sd=160n sca=17.5885 scb=0.0172826 \
        scc=0.00162584 m=(1)
mn1_1__rcx (11 \3\:A1 12 VSS) g45n1svt w=(2.6e-07) l=4.5e-08 nf=1 \
        as=4.55e-14 ad=1.56e-14 ps=8.7e-07 pd=6.4e-07 nrd=1.16667 \
        nrs=1.16667 sa=2.45e-07 sb=1.955e-06 sd=160n sca=17.5885 \
        scb=0.0172826 scc=0.00162584 m=(1)
mn2_1__rcx (\4\:Y \5\:A2 12 VSS) g45n1svt w=(2.6e-07) l=4.5e-08 nf=1 \
        as=4.55e-14 ad=4.16e-14 ps=8.7e-07 pd=8.4e-07 nrd=1.16667 \
        nrs=1.16667 sa=4.65e-07 sb=1.735e-06 sd=160n sca=17.5885 \
        scb=0.0172826 scc=0.00162584 m=(1)
mn2 (\4\:Y \1\:A2 13 VSS) g45n1svt w=(2.6e-07) l=4.5e-08 nf=1 as=1.56e-14 \
        ad=4.16e-14 ps=6.4e-07 pd=8.4e-07 nrd=1.16667 nrs=1.16667 \
        sa=6.7e-07 sb=1.53e-06 sd=160n sca=17.5885 scb=0.0172826 \
        scc=0.00162584 m=(1)
mn1 (13 \6\:A1 14 VSS) g45n1svt w=(2.6e-07) l=4.5e-08 nf=1 as=5.72e-14 \
        ad=1.56e-14 ps=9.6e-07 pd=6.4e-07 nrd=1.16667 nrs=1.16667 \
        sa=7.75e-07 sb=1.425e-06 sd=160n sca=17.5885 scb=0.0172826 \
        scc=0.00162584 m=(1)
mn0 (14 \6\:A0 \8\:VSS VSS) g45n1svt w=(2.6e-07) l=4.5e-08 nf=1 \
        as=1.177e-13 ad=5.72e-14 ps=1.77e-06 pd=9.6e-07 nrd=1.16667 \
        nrs=1.16667 sa=1.04e-06 sb=1.16e-06 sd=160n sca=17.5885 \
        scb=0.0172826 scc=0.00162584 m=(1)
mn3_1__rcx (15 \1\:B0 \8\:VSS VSS) g45n1svt w=(2.6e-07) l=4.5e-08 nf=1 \
        as=1.177e-13 ad=3.12e-14 ps=1.77e-06 pd=7.6e-07 nrd=1.16667 \
        nrs=1.16667 sa=1.39e-06 sb=8.1e-07 sd=160n sca=17.5885 \
        scb=0.0172826 scc=0.00162584 m=(1)
mn4_1__rcx (\1\:Y \6\:B1 15 VSS) g45n1svt w=(2.6e-07) l=4.5e-08 nf=1 \
        as=3.12e-14 ad=4.16e-14 ps=7.6e-07 pd=8.4e-07 nrd=1.16667 \
        nrs=1.16667 sa=1.555e-06 sb=6.45e-07 sd=160n sca=17.5885 \
        scb=0.0172826 scc=0.00162584 m=(1)
mn4 (\1\:Y \4\:B1 16 VSS) g45n1svt w=(2.6e-07) l=4.5e-08 nf=1 as=6.63e-14 \
        ad=4.16e-14 ps=1.03e-06 pd=8.4e-07 nrd=1.16667 nrs=1.16667 \
        sa=1.76e-06 sb=4.4e-07 sd=160n sca=17.5885 scb=0.0172826 \
        scc=0.00162584 m=(1)
mn3 (16 \6\:B0 \1\:VSS VSS) g45n1svt w=(2.6e-07) l=4.5e-08 nf=1 \
        as=3.64e-14 ad=6.63e-14 ps=8e-07 pd=1.03e-06 nrd=1.16667 \
        nrs=1.16667 sa=2e-06 sb=1.4e-07 sd=160n sca=17.5885 scb=0.0172826 \
        scc=0.00162584 m=(1)
ends AOI32X2
// End of subcircuit definition.
