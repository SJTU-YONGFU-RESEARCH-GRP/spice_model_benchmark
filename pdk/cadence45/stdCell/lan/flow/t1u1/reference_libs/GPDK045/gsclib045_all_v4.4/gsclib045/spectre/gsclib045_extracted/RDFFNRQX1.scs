// Generated for: spectre (May  1 08:12:07 2013 )
// Library name: gsclib045
// Cell name: RDFFNRQX1
// View name: extracted

simulator lang=spectre

subckt RDFFNRQX1 CKN D ExtVDD Q RN RT VDD VSS
mp20 (\21\:CKNb \4\:CKN \20\:VDD VDD) g45p1svt w=(2.15e-07) l=4.5e-08 \
        nf=1 as=3.01e-14 ad=3.44e-14 ps=7.1e-07 pd=7.5e-07 nrd=1.16667 \
        nrs=1.16667 sa=3.45e-07 sb=1.4e-07 sd=160n sca=15.0986 \
        scb=0.0152901 scc=0.00103801 m=(1)
mp21 (\13\:CKNbb \5\:CKNb \20\:VDD VDD) g45p1svt w=(2.15e-07) l=4.5e-08 \
        nf=1 as=3.44e-14 ad=3.01e-14 ps=7.5e-07 pd=7.1e-07 nrd=1.16667 \
        nrs=1.16667 sa=1.4e-07 sb=3.45e-07 sd=160n sca=14.7851 \
        scb=0.0152025 scc=0.00103799 m=(1)
mp25 (n22 \3\:D \12\:VDD VDD) g45p1svt w=(2.15e-07) l=4.5e-08 nf=1 \
        as=3.01e-14 ad=1.29e-14 ps=7.1e-07 pd=5.5e-07 nrd=1.16667 \
        nrs=1.16667 sa=1.4e-07 sb=2.45e-07 sd=160n sca=20.3407 \
        scb=0.022946 scc=0.00119484 m=(1)
mp26 (\15\:n20 \3\:CKNb n22 VDD) g45p1svt w=(2.15e-07) l=4.5e-08 nf=1 \
        as=1.29e-14 ad=3.01e-14 ps=5.5e-07 pd=7.1e-07 nrd=1.16667 \
        nrs=1.16667 sa=2.45e-07 sb=1.4e-07 sd=160n sca=17.8768 \
        scb=0.0186195 scc=0.00106238 m=(1)
mp36 (\7\:n20 \4\:CKNbb n31 VDD) g45p1svt w=(2.15e-07) l=4.5e-08 nf=1 \
        as=1.29e-14 ad=3.01e-14 ps=5.5e-07 pd=7.1e-07 nrd=1.16667 \
        nrs=1.16667 sa=1.4e-07 sb=2.45e-07 sd=160n sca=6.79882 \
        scb=0.00278203 scc=1.42286e-05 m=(1)
mp35 (n31 mout \22\:VDD VDD) g45p1svt w=(2.15e-07) l=4.5e-08 nf=1 \
        as=3.01e-14 ad=1.29e-14 ps=7.1e-07 pd=5.5e-07 nrd=1.16667 \
        nrs=1.16667 sa=2.45e-07 sb=1.4e-07 sd=160n sca=6.42122 \
        scb=0.00257522 scc=1.4095e-05 m=(1)
mp32 (\17\:mout \3\:n20 net402 VDD) g45p1svt w=(2.15e-07) l=4.5e-08 nf=1 \
        as=1.29e-14 ad=3.01e-14 ps=5.5e-07 pd=7.1e-07 nrd=1.16667 \
        nrs=1.16667 sa=1.4e-07 sb=2.45e-07 sd=160n sca=6.63763 \
        scb=0.00268079 scc=1.41468e-05 m=(1)
mp31 (net402 \5\:RNb \18\:VDD VDD) g45p1svt w=(2.15e-07) l=4.5e-08 nf=1 \
        as=3.01e-14 ad=1.29e-14 ps=7.1e-07 pd=5.5e-07 nrd=1.16667 \
        nrs=1.16667 sa=2.45e-07 sb=1.4e-07 sd=160n sca=7.12147 \
        scb=0.00304089 scc=1.45946e-05 m=(1)
mp22 (\11\:RNb \4\:RN \16\:VDD VDD) g45p1svt w=(2.15e-07) l=4.5e-08 nf=1 \
        as=3.01e-14 ad=3.01e-14 ps=7.1e-07 pd=7.1e-07 nrd=1.16667 \
        nrs=1.16667 sa=1.4e-07 sb=1.4e-07 sd=160n sca=17.717 scb=0.0191019 \
        scc=0.000880768 m=(1)
mp40 (\4\:n35 \5\:CKNbb \5\:mout VDD) g45p1svt w=(2.15e-07) l=4.5e-08 \
        nf=1 as=3.01e-14 ad=3.01e-14 ps=7.1e-07 pd=7.1e-07 nrd=1.16667 \
        nrs=1.16667 sa=1.4e-07 sb=1.4e-07 sd=160n sca=19.7416 \
        scb=0.0214921 scc=0.00142044 m=(1)
PM0 (\6\:n35g \5\:RT \9\:n35 ExtVDD) g45p1svt w=(2.15e-07) l=4.5e-08 nf=1 \
        as=3.01e-14 ad=3.01e-14 ps=7.1e-07 pd=7.1e-07 nrd=1.16667 \
        nrs=1.16667 sa=1.4e-07 sb=1.4e-07 sd=160n sca=26.0836 \
        scb=0.0271848 scc=0.00267095 m=(1)
PM1 (\14\:qbint \3\:n35g \1\:ExtVDD ExtVDD) g45p1svt w=(2.15e-07) \
        l=4.5e-08 nf=1 as=3.5882e-13 ad=3.01e-14 ps=3.6e-06 pd=7.1e-07 \
        nrd=1.16667 nrs=1.16667 sa=1.4e-07 sb=8.7e-07 sd=160n sca=25.2796 \
        scb=0.0259458 scc=0.00265434 m=(1)
PM2 (net205 \4\:qbint \1\:ExtVDD ExtVDD) g45p1svt w=(2.15e-07) l=4.5e-08 \
        nf=1 as=3.5882e-13 ad=1.29e-14 ps=3.6e-06 pd=5.5e-07 nrd=1.16667 \
        nrs=1.16667 sa=7.65e-07 sb=2.45e-07 sd=160n sca=14.5295 \
        scb=0.0144143 scc=0.000486924 m=(1)
mp45 (\6\:RTb \6\:RT \1\:ExtVDD ExtVDD) g45p1svt w=(2.15e-07) l=4.5e-08 \
        nf=1 as=3.5882e-13 ad=3.01e-14 ps=3.6e-06 pd=7.1e-07 nrd=1.16667 \
        nrs=1.16667 sa=3.3e-07 sb=1.4e-07 sd=160n sca=24.3731 \
        scb=0.0258873 scc=0.00229004 m=(1)
PM3 (\15\:n35g \4\:RTb net205 ExtVDD) g45p1svt w=(2.15e-07) l=4.5e-08 \
        nf=1 as=1.29e-14 ad=3.01e-14 ps=5.5e-07 pd=7.1e-07 nrd=1.16667 \
        nrs=1.16667 sa=8.7e-07 sb=1.4e-07 sd=160n sca=25.2796 \
        scb=0.0259458 scc=0.00265434 m=(1)
mp53 (\14\:n35 \13\:CKNb \3\:net098 VDD) g45p1svt w=(2.15e-07) l=4.5e-08 \
        nf=1 as=3.01e-14 ad=3.01e-14 ps=7.1e-07 pd=7.1e-07 nrd=1.16667 \
        nrs=1.16667 sa=1.4e-07 sb=1.4e-07 sd=160n sca=28.502 scb=0.031227 \
        scc=0.00281308 m=(1)
mp51 (n43 \2\:RNb \14\:VDD VDD) g45p1svt w=(2.15e-07) l=4.5e-08 nf=1 \
        as=3.01e-14 ad=1.29e-14 ps=7.1e-07 pd=5.5e-07 nrd=1.16667 \
        nrs=1.16667 sa=1.4e-07 sb=2.45e-07 sd=160n sca=13.263 \
        scb=0.0113871 scc=0.000191708 m=(1)
mp52 (net098 \7\:qbint n43 VDD) g45p1svt w=(2.15e-07) l=4.5e-08 nf=1 \
        as=1.29e-14 ad=3.01e-14 ps=5.5e-07 pd=7.1e-07 nrd=1.16667 \
        nrs=1.16667 sa=2.45e-07 sb=1.4e-07 sd=160n sca=15.1571 \
        scb=0.0152095 scc=0.00032323 m=(1)
C1 (RT VSS) capacitor c=2.16454e-17
C2 (RN VSS) capacitor c=4.55341e-17
C3 (D VSS) capacitor c=5.08282e-17
C4 (VDD VSS) capacitor c=6.32756e-16
C5 (CKN VSS) capacitor c=4.19498e-17
C6 (ExtVDD VSS) capacitor c=1.92414e-16
C7 (Q VSS) capacitor c=1.27804e-17
C8 (CKNb VSS) capacitor c=4.77795e-17
C9 (mout VSS) capacitor c=5.02221e-17
C10 (CKNbb VSS) capacitor c=5.23711e-17
C11 (n20 VSS) capacitor c=8.33177e-17
C12 (RNb VSS) capacitor c=5.65726e-17
C13 (n35g VSS) capacitor c=1.80972e-17
C14 (qbint VSS) capacitor c=4.50216e-17
C15 (RTb VSS) capacitor c=4.52604e-17
C16 (n35 VSS) capacitor c=1.82008e-16
C17 (net098 VSS) capacitor c=6.26829e-17
C18 (n40 VSS) capacitor c=7.49826e-17
C19 (\7\:qbint VSS) capacitor c=1.25832e-16
C20 (\2\:RNb VSS) capacitor c=2.99352e-16
C21 (\10\:qbint VSS) capacitor c=3.43512e-17
C22 (\13\:CKNb VSS) capacitor c=7.06929e-17
C23 (\4\:RTb VSS) capacitor c=9.89931e-17
C24 (\6\:RT VSS) capacitor c=2.33402e-17
C25 (\4\:qbint VSS) capacitor c=5.41658e-17
C26 (\3\:n35g VSS) capacitor c=6.37017e-17
C27 (\5\:RT VSS) capacitor c=8.6027e-17
C28 (\5\:CKNbb VSS) capacitor c=1.04467e-16
C29 (\4\:RN VSS) capacitor c=3.23183e-17
C30 (\5\:RNb VSS) capacitor c=6.43347e-17
C31 (\3\:n20 VSS) capacitor c=7.4544e-17
C32 (\4\:CKN VSS) capacitor c=5.55251e-17
C33 (\5\:CKNb VSS) capacitor c=3.12551e-17
C34 (\4\:CKNbb VSS) capacitor c=8.45259e-17
C35 (\3\:CKNb VSS) capacitor c=1.64419e-16
C36 (\3\:D VSS) capacitor c=5.64503e-17
C37 (\6\:qbint VSS) capacitor c=5.84087e-17
C38 (\11\:qbint VSS) capacitor c=4.09976e-17
C39 (\7\:CKNbb VSS) capacitor c=1.95834e-16
C40 (\8\:RT VSS) capacitor c=1.23572e-16
C41 (\2\:RT VSS) capacitor c=5.70341e-17
C42 (\5\:qbint VSS) capacitor c=3.87694e-17
C43 (\5\:n35g VSS) capacitor c=3.49043e-17
C44 (\2\:RTb VSS) capacitor c=5.13883e-17
C45 (\7\:CKNb VSS) capacitor c=3.43089e-17
C46 (\1\:RN VSS) capacitor c=3.43317e-17
C47 (\7\:RNb VSS) capacitor c=6.18372e-17
C48 (\1\:CKN VSS) capacitor c=2.85199e-17
C49 (\6\:n20 VSS) capacitor c=6.33352e-17
C50 (\3\:mout VSS) capacitor c=5.04497e-17
C51 (\12\:CKNb VSS) capacitor c=4.99683e-17
C52 (\2\:CKNbb VSS) capacitor c=8.21061e-17
C53 (\1\:D VSS) capacitor c=6.58183e-17
C54 (\9\:qbint VSS) capacitor c=8.35504e-17
C55 (\14\:CKNb VSS) capacitor c=7.1227e-17
C56 (\7\:RT VSS) capacitor c=1.55143e-16
C57 (\11\:CKNb VSS) capacitor c=1.43459e-16
C58 (\3\:RT VSS) capacitor c=5.76455e-17
C59 (\1\:RT VSS) capacitor c=4.86946e-17
C60 (\3\:RTb VSS) capacitor c=7.59547e-17
C61 (\3\:qbint VSS) capacitor c=4.45245e-17
C62 (\2\:n35 VSS) capacitor c=2.63587e-16
C63 (\4\:n35g VSS) capacitor c=7.15763e-17
C64 (\6\:CKNbb VSS) capacitor c=5.61759e-17
C65 (\8\:CKNbb VSS) capacitor c=2.31473e-16
C66 (\3\:n35 VSS) capacitor c=1.2108e-16
C67 (\6\:RNb VSS) capacitor c=8.08747e-17
C68 (\3\:RN VSS) capacitor c=5.05384e-17
C69 (\3\:CKN VSS) capacitor c=2.32839e-17
C70 (\6\:CKNb VSS) capacitor c=2.30249e-17
C71 (\3\:CKNbb VSS) capacitor c=1.07321e-16
C72 (\2\:mout VSS) capacitor c=4.00614e-17
C73 (\4\:mout VSS) capacitor c=3.90906e-17
C74 (\5\:n20 VSS) capacitor c=4.02502e-17
C75 (\2\:n20 VSS) capacitor c=7.16585e-17
C76 (\4\:CKNb VSS) capacitor c=8.29165e-17
C77 (\10\:CKNb VSS) capacitor c=3.21327e-17
C78 (\2\:D VSS) capacitor c=5.33006e-17
C79 (\1\:VDD VSS) capacitor c=4.7404e-17
C80 (\14\:VDD VSS) capacitor c=4.90906e-17
C81 (\4\:Q VSS) capacitor c=6.0197e-17
C82 (\3\:net098 VSS) capacitor c=9.8472e-17
C83 (\14\:n35 VSS) capacitor c=4.14095e-17
C84 (\15\:n35g VSS) capacitor c=5.86348e-17
C85 (\6\:RTb VSS) capacitor c=8.4484e-17
C86 (\1\:ExtVDD VSS) capacitor c=2.8122e-16
C87 (\9\:n35 VSS) capacitor c=5.48959e-17
C88 (\14\:qbint VSS) capacitor c=7.04216e-17
C89 (\6\:n35g VSS) capacitor c=9.19037e-17
C90 (\4\:n35 VSS) capacitor c=5.58548e-17
C91 (\11\:RNb VSS) capacitor c=2.80529e-17
C92 (\5\:mout VSS) capacitor c=7.05143e-17
C93 (\16\:VDD VSS) capacitor c=5.29937e-17
C94 (\18\:VDD VSS) capacitor c=4.39791e-17
C95 (\21\:CKNb VSS) capacitor c=4.74582e-17
C96 (\17\:mout VSS) capacitor c=3.49926e-17
C97 (\20\:VDD VSS) capacitor c=6.4399e-17
C98 (\22\:VDD VSS) capacitor c=4.60325e-17
C99 (\13\:CKNbb VSS) capacitor c=5.21157e-17
C100 (\7\:n20 VSS) capacitor c=4.10009e-17
C101 (\15\:n20 VSS) capacitor c=6.28553e-17
C102 (\12\:VDD VSS) capacitor c=4.84509e-17
C103 (\1\:Q VSS) capacitor c=4.01021e-17
C104 (\3\:n40 VSS) capacitor c=7.8616e-17
C105 (\17\:n35 VSS) capacitor c=4.88928e-17
C106 (\11\:n35g VSS) capacitor c=2.71897e-17
C107 (\10\:RTb VSS) capacitor c=4.83839e-17
C108 (\12\:n35 VSS) capacitor c=6.15551e-17
C109 (\16\:qbint VSS) capacitor c=2.31983e-17
C110 (\9\:n35g VSS) capacitor c=7.79787e-17
C111 (\7\:n35 VSS) capacitor c=4.56768e-17
C112 (\8\:RNb VSS) capacitor c=3.97934e-17
C113 (\13\:mout VSS) capacitor c=5.53341e-17
C114 (\17\:CKNb VSS) capacitor c=6.04611e-17
C115 (\15\:mout VSS) capacitor c=3.61893e-17
C116 (\9\:CKNbb VSS) capacitor c=3.47904e-17
C117 (\11\:n20 VSS) capacitor c=6.1652e-17
C118 (\13\:n20 VSS) capacitor c=5.87958e-17
C119 (\2\:CKNb VSS) capacitor c=7.23973e-17
C120 (\2\:CKN VSS) capacitor c=3.42585e-17
C121 (\4\:n20 VSS) capacitor c=6.75316e-17
C122 (VDD VSS) capacitor c=2.40252e-16
C123 (\2\:n35g VSS) capacitor c=3.33121e-17
C124 (ExtVDD VSS) capacitor c=3.93909e-17
C125 (\4\:RT VSS) capacitor c=7.53549e-17
C126 (\2\:qbint VSS) capacitor c=4.18376e-17
C127 (\8\:CKNb VSS) capacitor c=1.25277e-16
C128 (\9\:CKNb VSS) capacitor c=6.33461e-17
C129 (\3\:RNb VSS) capacitor c=4.97567e-16
C130 (\4\:RNb VSS) capacitor c=1.14107e-16
C131 (\15\:CKNb VSS) capacitor c=6.33403e-17
C132 (\16\:CKNb VSS) capacitor c=7.37081e-17
C133 (\8\:qbint VSS) capacitor c=9.78972e-17
C134 (\9\:n20 VSS) capacitor c=2.98874e-17
C135 (\10\:n20 VSS) capacitor c=4.95397e-17
C136 (\17\:n20 VSS) capacitor c=3.72061e-17
C137 (\12\:CKNbb VSS) capacitor c=7.90534e-17
C138 (\15\:CKNbb VSS) capacitor c=5.06473e-17
C139 (\5\:CKN VSS) capacitor c=4.75329e-18
C140 (\6\:CKN VSS) capacitor c=3.48714e-17
C141 (\19\:CKNb VSS) capacitor c=7.08546e-17
C142 (\20\:CKNb VSS) capacitor c=4.76646e-17
C143 (\5\:RN VSS) capacitor c=5.21703e-17
C144 (\7\:mout VSS) capacitor c=5.47667e-17
C145 (\8\:mout VSS) capacitor c=4.7052e-17
C146 (\9\:mout VSS) capacitor c=1.13258e-17
C147 (\10\:mout VSS) capacitor c=2.79311e-17
C148 (\11\:mout VSS) capacitor c=1.49205e-17
C149 (\12\:mout VSS) capacitor c=2.90509e-17
C150 (\10\:RNb VSS) capacitor c=6.68876e-17
C151 (\6\:n35 VSS) capacitor c=5.94682e-17
C152 (\16\:CKNbb VSS) capacitor c=3.32936e-17
C153 (\17\:CKNbb VSS) capacitor c=3.22833e-17
C154 (\8\:n35g VSS) capacitor c=3.24371e-17
C155 (\11\:n35 VSS) capacitor c=6.19851e-17
C156 (\12\:qbint VSS) capacitor c=8.81086e-17
C157 (\13\:qbint VSS) capacitor c=1.04822e-16
C158 (\13\:n35g VSS) capacitor c=1.08812e-16
C159 (\14\:n35g VSS) capacitor c=1.16492e-16
C160 (\5\:RTb VSS) capacitor c=4.92161e-17
C161 (\8\:RTb VSS) capacitor c=8.7885e-17
C162 (\9\:RTb VSS) capacitor c=5.17894e-17
C163 (\9\:RT VSS) capacitor c=1.06515e-16
C164 (\10\:RT VSS) capacitor c=1.18623e-16
C165 (\11\:RT VSS) capacitor c=3.82423e-17
C166 (\23\:CKNb VSS) capacitor c=9.53616e-17
C167 (\24\:CKNb VSS) capacitor c=9.42263e-17
C168 (\18\:qbint VSS) capacitor c=2.00548e-17
C169 (\19\:qbint VSS) capacitor c=2.99466e-17
C170 (\16\:n35 VSS) capacitor c=4.41844e-17
C171 (\3\:Q VSS) capacitor c=1.69952e-17
C172 (\3\:VDD VSS) capacitor c=3.97117e-17
C173 (\5\:VDD VSS) capacitor c=1.22036e-16
C174 (\6\:VDD VSS) capacitor c=5.95632e-17
C175 (\7\:VDD VSS) capacitor c=8.54102e-18
C176 (\9\:VDD VSS) capacitor c=2.17008e-17
C177 (\10\:VDD VSS) capacitor c=2.639e-17
C178 (\11\:VDD VSS) capacitor c=3.22907e-17
Rk53 (RT \9\:RT) resistor r=0.1834 c=0
Rk54 (\9\:RT \10\:RT) resistor r=0.6402 c=0
Rk55 (RT \11\:RT) resistor r=0.01476 c=0
Rk19 (RN \5\:RN) resistor r=0.02713 c=0
Rk2 (\4\:D D) resistor r=0.006389 c=0
Rk90 (\2\:VDD \3\:VDD) resistor r=0.4044 c=0
Rk92 (\5\:VDD VDD) resistor r=1.0522 c=0
Rk91 (\3\:VDD \5\:VDD) resistor r=0.06659 c=0
Rk93 (VDD \6\:VDD) resistor r=0.6271 c=0
Rk94 (\6\:VDD \7\:VDD) resistor r=0.0293 c=0
Rk95 (\7\:VDD \9\:VDD) resistor r=0.1012 c=0
Rk96 (\9\:VDD \10\:VDD) resistor r=0.08885 c=0
Rk98 (\11\:VDD VDD) resistor r=0.195 c=0
Rk97 (\10\:VDD \11\:VDD) resistor r=0.08124 c=0
Rk99 (VDD \13\:VDD) resistor r=0.5101 c=0
Rk100 (\3\:VDD \15\:VDD) resistor r=0.2921 c=0
Rk101 (\6\:VDD \17\:VDD) resistor r=0.3582 c=0
Rk102 (\7\:VDD \19\:VDD) resistor r=0.201 c=0
Rk103 (\10\:VDD \21\:VDD) resistor r=0.4023 c=0
Rk104 (\11\:VDD \23\:VDD) resistor r=0.201 c=0
Rk12 (CKN \5\:CKN) resistor r=0.0023 c=0
Rk15 (\5\:CKN \6\:CKN) resistor r=0.01102 c=0
Rk14 (\6\:CKN \7\:CKN) resistor r=0.006334 c=0
Rk40 (ExtVDD ExtVDD) resistor r=0.002057 c=0
Rk38 (\2\:ExtVDD ExtVDD) resistor r=0.0221 c=0
Rk41 (ExtVDD \5\:ExtVDD) resistor r=0.0201 c=0
Rk42 (ExtVDD \6\:ExtVDD) resistor r=0.1054 c=0
Rk61 (\3\:Q Q) resistor r=0.009578 c=0
Rk60 (\2\:Q \3\:Q) resistor r=0.2292 c=0
Rk62 (\3\:Q \5\:Q) resistor r=0.3184 c=0
Rk65 (\2\:VSS \4\:VSS) resistor r=0.3543 c=0
Rk66 (\4\:VSS \5\:VSS) resistor r=0.08885 c=0
Rk69 (\6\:VSS VSS) resistor r=0.3961 c=0
Rk67 (\5\:VSS \6\:VSS) resistor r=0.7025 c=0
Rk68 (\5\:VSS \8\:VSS) resistor r=0.2456 c=0
Rk70 (VSS \9\:VSS) resistor r=0.705 c=0
Rk72 (\10\:VSS VSS) resistor r=0.121 c=0
Rk71 (\9\:VSS \10\:VSS) resistor r=0.08638 c=0
Rk73 (VSS \12\:VSS) resistor r=0.2962 c=0
Rk74 (\6\:VSS \14\:VSS) resistor r=0.2882 c=0
Rk75 (\9\:VSS \16\:VSS) resistor r=0.2393 c=0
Rk76 (\18\:VSS \20\:VSS) resistor r=0.3052 c=0
Rk77 (\20\:VSS \21\:VSS) resistor r=0.7921 c=0
Rk78 (\21\:VSS \22\:VSS) resistor r=0.06659 c=0
Rk79 (\22\:VSS \24\:VSS) resistor r=0.1887 c=0
Rk82 (\25\:VSS VSS) resistor r=0.1208 c=0
Rk80 (\22\:VSS \25\:VSS) resistor r=0.2074 c=0
Rk81 (\25\:VSS \27\:VSS) resistor r=0.1938 c=0
Rk83 (VSS \28\:VSS) resistor r=0.6283 c=0
Rk84 (\28\:VSS \30\:VSS) resistor r=0.2353 c=0
Rk86 (\31\:VSS VSS) resistor r=0.01954 c=0
Rk85 (\28\:VSS \31\:VSS) resistor r=0.1631 c=0
Rk87 (VSS \32\:VSS) resistor r=0.03716 c=0
Rk88 (\32\:VSS \34\:VSS) resistor r=0.2358 c=0
Rk89 (\32\:VSS \36\:VSS) resistor r=0.6564 c=0
Rk1 (\15\:CKNb \16\:CKNb) resistor r=0.6826 c=0
Rk16 (\18\:CKNb \19\:CKNb) resistor r=0.3415 c=0
Rk17 (\19\:CKNb \20\:CKNb) resistor r=0.1628 c=0
Rk18 (\19\:CKNb \22\:CKNb) resistor r=0.2072 c=0
Rk56 (\23\:CKNb \24\:CKNb) resistor r=0.7171 c=0
Rk20 (\6\:mout \7\:mout) resistor r=0.4253 c=0
Rk21 (\7\:mout \8\:mout) resistor r=0.3621 c=0
Rk22 (\8\:mout \9\:mout) resistor r=0.1413 c=0
Rk23 (\9\:mout \10\:mout) resistor r=0.1929 c=0
Rk24 (\7\:mout \11\:mout) resistor r=0.1185 c=0
Rk25 (\11\:mout \12\:mout) resistor r=0.2157 c=0
Rk26 (\8\:mout \14\:mout) resistor r=0.3227 c=0
Rk27 (\9\:mout \16\:mout) resistor r=0.1036 c=0
Rk28 (\11\:mout \18\:mout) resistor r=0.1202 c=0
Rk8 (\10\:CKNbb \11\:CKNbb) resistor r=0.2124 c=0
Rk9 (\11\:CKNbb \12\:CKNbb) resistor r=0.0151 c=0
Rk10 (\11\:CKNbb \14\:CKNbb) resistor r=0.3374 c=0
Rk11 (\14\:CKNbb \15\:CKNbb) resistor r=0.2709 c=0
Rk33 (\16\:CKNbb \17\:CKNbb) resistor r=0.2958 c=0
Rk3 (\8\:n20 \9\:n20) resistor r=0.2062 c=0
Rk4 (\8\:n20 \10\:n20) resistor r=0.2091 c=0
Rk5 (\10\:n20 \12\:n20) resistor r=0.4399 c=0
Rk6 (\14\:n20 \16\:n20) resistor r=0.4876 c=0
Rk7 (\16\:n20 \17\:n20) resistor r=0.1574 c=0
Rk29 (\9\:RNb \10\:RNb) resistor r=0.3424 c=0
Rk30 (\10\:RNb \12\:RNb) resistor r=0.1478 c=0
Rk34 (\7\:n35g \8\:n35g) resistor r=0.2401 c=0
Rk35 (\7\:n35g \10\:n35g) resistor r=0.6898 c=0
Rk46 (\12\:n35g \13\:n35g) resistor r=0.2424 c=0
Rk47 (\13\:n35g \14\:n35g) resistor r=0.5641 c=0
Rk48 (\13\:n35g \16\:n35g) resistor r=0.4309 c=0
Rk43 (\12\:qbint \13\:qbint) resistor r=0.4933 c=0
Rk44 (\13\:qbint \15\:qbint) resistor r=0.5658 c=0
Rk45 (\13\:qbint \17\:qbint) resistor r=0.1459 c=0
Rk57 (\18\:qbint \19\:qbint) resistor r=0.2113 c=0
Rk49 (\5\:RTb \7\:RTb) resistor r=0.2157 c=0
Rk50 (\7\:RTb \8\:RTb) resistor r=0.5203 c=0
Rk51 (\8\:RTb \9\:RTb) resistor r=0.3878 c=0
Rk52 (\8\:RTb \11\:RTb) resistor r=0.2011 c=0
Rk31 (\5\:n35 \6\:n35) resistor r=0.3193 c=0
Rk32 (\6\:n35 \8\:n35) resistor r=0.4233 c=0
Rk36 (\10\:n35 \11\:n35) resistor r=0.3178 c=0
Rk37 (\11\:n35 \13\:n35) resistor r=0.3869 c=0
Rk58 (\15\:n35 \16\:n35) resistor r=0.2315 c=0
Rk59 (\16\:n35 \18\:n35) resistor r=0.3583 c=0
Rk64 (\2\:net098 \4\:net098) resistor r=0.7055 c=0
Rk63 (\2\:n40 \4\:n40) resistor r=0.6241 c=0
Rl43 (\7\:RT \8\:RT) resistor r=651.902 c=0
Rl30 (\1\:RT \2\:RT) resistor r=169.515 c=0
Rl33 (\4\:RT \6\:RT) resistor r=21.372 c=0
Rl32 (\4\:RT \5\:RT) resistor r=264.027 c=0
Rl31 (\3\:RT \4\:RT) resistor r=96.114 c=0
Rl20 (\2\:RN \4\:RN) resistor r=62.3411 c=0
Rl18 (\1\:RN \2\:RN) resistor r=152.726 c=0
Rl19 (\2\:RN \3\:RN) resistor r=0.6051 c=0
Rl2 (\2\:D \3\:D) resistor r=43.4636 c=0
Rl1 (\1\:D \2\:D) resistor r=135.391 c=0
Rl14 (\2\:CKN \4\:CKN) resistor r=147.791 c=0
Rl12 (\1\:CKN \2\:CKN) resistor r=63.1757 c=0
Rl13 (\2\:CKN \3\:CKN) resistor r=2.0166 c=0
Rl46 (\13\:CKNb \14\:CKNb) resistor r=159.438 c=0
Rl9 (\3\:CKNb \4\:CKNb) resistor r=349.426 c=0
Rl10 (\2\:CKNb \5\:CKNb) resistor r=59.4618 c=0
Rl8 (\2\:CKNb \3\:CKNb) resistor r=237.282 c=0
Rl7 (CKNb \2\:CKNb) resistor r=147.923 c=0
Rl11 (\2\:CKNb \6\:CKNb) resistor r=4.3228 c=0
Rl38 (\7\:CKNb \8\:CKNb) resistor r=66.1349 c=0
Rl41 (\8\:CKNb \11\:CKNb) resistor r=820.277 c=0
Rl42 (\9\:CKNb \12\:CKNb) resistor r=66.8717 c=0
Rl40 (\9\:CKNb \10\:CKNb) resistor r=132.647 c=0
Rl39 (\8\:CKNb \9\:CKNb) resistor r=339.792 c=0
Rl5 (mout \2\:mout) resistor r=24.2328 c=0
Rl6 (\3\:mout \4\:mout) resistor r=24.2328 c=0
Rl23 (\5\:CKNbb \6\:CKNbb) resistor r=177.372 c=0
Rl47 (\7\:CKNbb \8\:CKNbb) resistor r=908.226 c=0
Rl22 (\3\:CKNbb \5\:CKNbb) resistor r=446.949 c=0
Rl21 (\3\:CKNbb \4\:CKNbb) resistor r=188.95 c=0
Rl4 (CKNbb \2\:CKNbb) resistor r=183.837 c=0
Rl3 (n20 \2\:n20) resistor r=205.495 c=0
Rl15 (\3\:n20 \4\:n20) resistor r=154.568 c=0
Rl17 (\4\:n20 \6\:n20) resistor r=191.976 c=0
Rl16 (\4\:n20 \5\:n20) resistor r=128.737 c=0
Rl48 (RNb \2\:RNb) resistor r=234.8 c=0
Rl49 (\2\:RNb \3\:RNb) resistor r=1125.6 c=0
Rl52 (\3\:RNb \6\:RNb) resistor r=707.521 c=0
Rl51 (\4\:RNb \5\:RNb) resistor r=106.884 c=0
Rl53 (\4\:RNb \7\:RNb) resistor r=197.09 c=0
Rl50 (\3\:RNb \4\:RNb) resistor r=336.011 c=0
Rl26 (\3\:n35g \4\:n35g) resistor r=250.512 c=0
Rl25 (\2\:n35g \3\:n35g) resistor r=181.74 c=0
Rl27 (\2\:n35g \5\:n35g) resistor r=94.1963 c=0
Rl24 (n35g \2\:n35g) resistor r=2.4834 c=0
Rl54 (\6\:qbint \7\:qbint) resistor r=237.758 c=0
Rl58 (\10\:qbint \11\:qbint) resistor r=149.805 c=0
Rl37 (\3\:qbint \5\:qbint) resistor r=35.3072 c=0
Rl36 (\2\:qbint \4\:qbint) resistor r=70.093 c=0
Rl34 (qbint \2\:qbint) resistor r=112.732 c=0
Rl35 (\2\:qbint \3\:qbint) resistor r=152.601 c=0
Rl55 (\7\:qbint \8\:qbint) resistor r=252.339 c=0
Rl57 (\8\:qbint \10\:qbint) resistor r=60.508 c=0
Rl56 (\8\:qbint \9\:qbint) resistor r=419.685 c=0
Rl29 (\3\:RTb \4\:RTb) resistor r=239.402 c=0
Rl28 (RTb \2\:RTb) resistor r=121.113 c=0
Rl44 (n35 \2\:n35) resistor r=508.667 c=0
Rl45 (\2\:n35 \3\:n35) resistor r=358.667 c=0
Rz16 (\1\:Q \2\:Q) resistor r=37.5 c=0
Rz19 (\1\:VSS \2\:VSS) resistor r=75 c=0
Rz20 (\7\:VSS \8\:VSS) resistor r=75 c=0
Rz21 (\11\:VSS \12\:VSS) resistor r=75 c=0
Rz22 (\13\:VSS \14\:VSS) resistor r=75 c=0
Rz23 (\15\:VSS \16\:VSS) resistor r=75 c=0
Rz24 (\17\:VSS \18\:VSS) resistor r=37.5 c=0
Rz25 (\23\:VSS \24\:VSS) resistor r=75 c=0
Rz26 (\26\:VSS \27\:VSS) resistor r=75 c=0
Rz27 (\29\:VSS \30\:VSS) resistor r=75 c=0
Rz28 (\33\:VSS \34\:VSS) resistor r=75 c=0
Rz29 (\35\:VSS \36\:VSS) resistor r=75 c=0
Rz4 (\17\:CKNb \18\:CKNb) resistor r=75 c=0
Rz5 (\13\:mout \14\:mout) resistor r=75 c=0
Rz6 (\15\:mout \16\:mout) resistor r=75 c=0
Rz3 (\9\:CKNbb \10\:CKNbb) resistor r=75 c=0
Rz1 (\11\:n20 \12\:n20) resistor r=75 c=0
Rz2 (\13\:n20 \14\:n20) resistor r=75 c=0
Rz7 (\8\:RNb \9\:RNb) resistor r=75 c=0
Rz9 (\9\:n35g \10\:n35g) resistor r=75 c=0
Rz13 (\11\:n35g \12\:n35g) resistor r=75 c=0
Rz12 (\16\:qbint \17\:qbint) resistor r=75 c=0
Rz14 (\10\:RTb \11\:RTb) resistor r=75 c=0
Rz8 (\7\:n35 \8\:n35) resistor r=75 c=0
Rz10 (\12\:n35 \13\:n35) resistor r=75 c=0
Rz15 (\17\:n35 \18\:n35) resistor r=75 c=0
Rz17 (n40 \2\:n40) resistor r=75 c=0
Rz18 (\3\:n40 \4\:n40) resistor r=75 c=0
Ry27 (\1\:VDD \2\:VDD) resistor r=20.6667 c=0
Ry28 (\12\:VDD \13\:VDD) resistor r=62 c=0
Ry29 (\14\:VDD \15\:VDD) resistor r=62 c=0
Ry30 (\16\:VDD \17\:VDD) resistor r=62 c=0
Ry31 (\18\:VDD \19\:VDD) resistor r=62 c=0
Ry32 (\20\:VDD \21\:VDD) resistor r=62 c=0
Ry33 (\22\:VDD \23\:VDD) resistor r=62 c=0
Ry11 (\1\:ExtVDD \2\:ExtVDD) resistor r=62 c=0
Ry12 (\1\:ExtVDD \5\:ExtVDD) resistor r=62 c=0
Ry13 (\1\:ExtVDD \6\:ExtVDD) resistor r=62 c=0
Ry18 (\4\:Q \5\:Q) resistor r=20.6667 c=0
Ry21 (\3\:VSS \4\:VSS) resistor r=15.5 c=0
Ry22 (\3\:VSS \6\:VSS) resistor r=5.1667 c=0
Ry23 (\3\:VSS \10\:VSS) resistor r=5.1667 c=0
Ry24 (\19\:VSS \20\:VSS) resistor r=15.5 c=0
Ry25 (\19\:VSS \21\:VSS) resistor r=5.1667 c=0
Ry26 (\19\:VSS \31\:VSS) resistor r=5.1667 c=0
Ry4 (\21\:CKNb \22\:CKNb) resistor r=62 c=0
Ry5 (\5\:mout \6\:mout) resistor r=62 c=0
Ry6 (\17\:mout \18\:mout) resistor r=62 c=0
Ry3 (\13\:CKNbb \14\:CKNbb) resistor r=62 c=0
Ry1 (\7\:n20 \8\:n20) resistor r=62 c=0
Ry2 (\15\:n20 \16\:n20) resistor r=62 c=0
Ry7 (\11\:RNb \12\:RNb) resistor r=62 c=0
Ry9 (\6\:n35g \7\:n35g) resistor r=62 c=0
Ry15 (\15\:n35g \16\:n35g) resistor r=62 c=0
Ry14 (\14\:qbint \15\:qbint) resistor r=62 c=0
Ry16 (\6\:RTb \7\:RTb) resistor r=62 c=0
Ry8 (\4\:n35 \5\:n35) resistor r=62 c=0
Ry10 (\9\:n35 \10\:n35) resistor r=62 c=0
Ry17 (\14\:n35 \15\:n35) resistor r=62 c=0
Ry19 (net098 \2\:net098) resistor r=62 c=0
Ry20 (\3\:net098 \4\:net098) resistor r=62 c=0
Rx24 (\3\:RT \9\:RT) resistor r=45 c=0
Rx25 (\1\:RT \10\:RT) resistor r=45 c=0
Rx26 (\7\:RT \11\:RT) resistor r=45 c=0
Rx11 (\3\:RN \5\:RN) resistor r=45 c=0
Rx3 (\2\:D \4\:D) resistor r=45 c=0
Rx9 (\3\:CKN \7\:CKN) resistor r=45 c=0
Rx1 (\4\:CKNb \15\:CKNb) resistor r=45 c=0
Rx2 (\10\:CKNb \16\:CKNb) resistor r=45 c=0
Rx10 (\6\:CKNb \20\:CKNb) resistor r=45 c=0
Rx27 (\14\:CKNb \23\:CKNb) resistor r=45 c=0
Rx28 (\11\:CKNb \24\:CKNb) resistor r=45 c=0
Rx12 (\4\:mout \10\:mout) resistor r=45 c=0
Rx13 (\2\:mout \12\:mout) resistor r=45 c=0
Rx7 (CKNbb \12\:CKNbb) resistor r=45 c=0
Rx8 (\3\:CKNbb \15\:CKNbb) resistor r=45 c=0
Rx16 (\6\:CKNbb \16\:CKNbb) resistor r=45 c=0
Rx17 (\8\:CKNbb \17\:CKNbb) resistor r=45 c=0
Rx4 (\2\:n20 \9\:n20) resistor r=45 c=0
Rx5 (\5\:n20 \10\:n20) resistor r=45 c=0
Rx6 (n20 \17\:n20) resistor r=45 c=0
Rx14 (\6\:RNb \10\:RNb) resistor r=45 c=0
Rx18 (\4\:n35g \8\:n35g) resistor r=45 c=0
Rx21 (n35g \14\:n35g) resistor r=45 c=0
Rx20 (\3\:qbint \12\:qbint) resistor r=45 c=0
Rx29 (\9\:qbint \18\:qbint) resistor r=45 c=0
Rx30 (qbint \19\:qbint) resistor r=45 c=0
Rx22 (\3\:RTb \5\:RTb) resistor r=45 c=0
Rx23 (RTb \9\:RTb) resistor r=45 c=0
Rx15 (\3\:n35 \6\:n35) resistor r=45 c=0
Rx19 (\2\:n35 \11\:n35) resistor r=45 c=0
Rx31 (n35 \16\:n35) resistor r=45 c=0
mn26 (\13\:n20 \2\:CKNbb n21 VSS) g45n1svt w=(1.45e-07) l=4.5e-08 nf=1 \
        as=8.7e-15 ad=2.03e-14 ps=4.1e-07 pd=5.7e-07 nrd=1.16667 \
        nrs=1.16667 sa=2.45e-07 sb=1.4e-07 sd=160n sca=8.0352 \
        scb=0.00565402 scc=8.19771e-05 m=(1)
mn25 (n21 \1\:D \35\:VSS VSS) g45n1svt w=(1.45e-07) l=4.5e-08 nf=1 \
        as=2.03e-14 ad=8.7e-15 ps=5.7e-07 pd=4.1e-07 nrd=1.16667 \
        nrs=1.16667 sa=2.45e-07 sb=1.4e-07 sd=160n sca=8.0352 \
        scb=0.00565402 scc=8.19771e-05 m=(1)
NM3 (net0121 \5\:qbint \23\:VSS VSS) g45n1svt w=(1.45e-07) l=4.5e-08 \
        nf=1 as=8.7e-15 ad=2.03e-14 ps=4.1e-07 pd=5.7e-07 nrd=1.16667 \
        nrs=1.16667 sa=1.4e-07 sb=2.45e-07 sd=160n sca=9.33388 \
        scb=0.00788941 scc=0.00017958 m=(1)
mn35 (n30 \3\:mout \11\:VSS VSS) g45n1svt w=(1.45e-07) l=4.5e-08 nf=1 \
        as=2.32e-14 ad=8.7e-15 ps=6.1e-07 pd=4.1e-07 nrd=1.16667 \
        nrs=1.16667 sa=2.45e-07 sb=3.45e-07 sd=160n sca=8.42104 \
        scb=0.00632542 scc=0.000106623 m=(1)
mn52 (n40 \6\:qbint \1\:VSS VSS) g45n1svt w=(1.45e-07) l=4.5e-08 nf=1 \
        as=2.03e-14 ad=2.32e-14 ps=5.7e-07 pd=6.1e-07 nrd=1.16667 \
        nrs=1.16667 sa=3.45e-07 sb=1.4e-07 sd=160n sca=8.42104 \
        scb=0.00632542 scc=0.000106623 m=(1)
mn51 (n40 RNb \7\:VSS VSS) g45n1svt w=(1.45e-07) l=4.5e-08 nf=1 \
        as=2.32e-14 ad=2.03e-14 ps=6.1e-07 pd=5.7e-07 nrd=1.16667 \
        nrs=1.16667 sa=1.4e-07 sb=3.45e-07 sd=160n sca=8.42104 \
        scb=0.00632542 scc=0.000106623 m=(1)
mn36 (\11\:n20 \12\:CKNb n30 VSS) g45n1svt w=(1.45e-07) l=4.5e-08 nf=1 \
        as=8.7e-15 ad=2.03e-14 ps=4.1e-07 pd=5.7e-07 nrd=1.16667 \
        nrs=1.16667 sa=1.4e-07 sb=4.5e-07 sd=160n sca=8.42104 \
        scb=0.00632542 scc=0.000106623 m=(1)
mn21 (\9\:CKNbb CKNb \33\:VSS VSS) g45n1svt w=(1.45e-07) l=4.5e-08 nf=1 \
        as=2.32e-14 ad=2.03e-14 ps=6.1e-07 pd=5.7e-07 nrd=1.16667 \
        nrs=1.16667 sa=1.4e-07 sb=3.45e-07 sd=160n sca=8.0352 \
        scb=0.00565402 scc=8.19771e-05 m=(1)
mn32 (\15\:mout \6\:n20 \11\:VSS VSS) g45n1svt w=(1.45e-07) l=4.5e-08 \
        nf=1 as=2.32e-14 ad=2.03e-14 ps=6.1e-07 pd=5.7e-07 nrd=1.16667 \
        nrs=1.16667 sa=4.5e-07 sb=1.4e-07 sd=160n sca=8.42104 \
        scb=0.00632542 scc=0.000106623 m=(1)
mn20 (\17\:CKNb \1\:CKN \33\:VSS VSS) g45n1svt w=(1.45e-07) l=4.5e-08 \
        nf=1 as=2.32e-14 ad=2.03e-14 ps=6.1e-07 pd=5.7e-07 nrd=1.16667 \
        nrs=1.16667 sa=3.45e-07 sb=1.4e-07 sd=160n sca=8.0352 \
        scb=0.00565402 scc=8.19771e-05 m=(1)
mn31 (\13\:mout \7\:RNb \15\:VSS VSS) g45n1svt w=(1.45e-07) l=4.5e-08 \
        nf=1 as=2.03e-14 ad=2.32e-14 ps=5.7e-07 pd=6.1e-07 nrd=1.16667 \
        nrs=1.16667 sa=1.4e-07 sb=3.45e-07 sd=160n sca=8.42104 \
        scb=0.00632542 scc=0.000106623 m=(1)
mn22 (\8\:RNb \1\:RN \29\:VSS VSS) g45n1svt w=(1.45e-07) l=4.5e-08 nf=1 \
        as=2.03e-14 ad=2.03e-14 ps=5.7e-07 pd=5.7e-07 nrd=1.16667 \
        nrs=1.16667 sa=1.4e-07 sb=1.4e-07 sd=160n sca=8.0352 \
        scb=0.00565402 scc=8.19771e-05 m=(1)
mn40 (\7\:n35 \7\:CKNb \13\:mout VSS) g45n1svt w=(1.45e-07) l=4.5e-08 \
        nf=1 as=2.32e-14 ad=2.03e-14 ps=6.1e-07 pd=5.7e-07 nrd=1.16667 \
        nrs=1.16667 sa=3.45e-07 sb=1.4e-07 sd=160n sca=8.42104 \
        scb=0.00632542 scc=0.000106623 m=(1)
NM0 (\9\:n35g \2\:RTb \12\:n35 VSS) g45n1svt w=(1.45e-07) l=4.5e-08 nf=1 \
        as=2.03e-14 ad=2.03e-14 ps=5.7e-07 pd=5.7e-07 nrd=1.16667 \
        nrs=1.16667 sa=1.4e-07 sb=1.4e-07 sd=160n sca=8.42104 \
        scb=0.00632542 scc=0.000106623 m=(1)
NM1 (\16\:qbint \5\:n35g \26\:VSS VSS) g45n1svt w=(1.45e-07) l=4.5e-08 \
        nf=1 as=2.03e-14 ad=2.03e-14 ps=5.7e-07 pd=5.7e-07 nrd=1.16667 \
        nrs=1.16667 sa=1.4e-07 sb=1.4e-07 sd=160n sca=9.33388 \
        scb=0.00788941 scc=0.00017958 m=(1)
mn45 (\10\:RTb \2\:RT \13\:VSS VSS) g45n1svt w=(1.45e-07) l=4.5e-08 nf=1 \
        as=2.03e-14 ad=2.03e-14 ps=5.7e-07 pd=5.7e-07 nrd=1.16667 \
        nrs=1.16667 sa=1.4e-07 sb=1.4e-07 sd=160n sca=8.42104 \
        scb=0.00632542 scc=0.000106623 m=(1)
NM2 (\11\:n35g \8\:RT net0121 VSS) g45n1svt w=(1.45e-07) l=4.5e-08 nf=1 \
        as=8.7e-15 ad=2.03e-14 ps=4.1e-07 pd=5.7e-07 nrd=1.16667 \
        nrs=1.16667 sa=2.45e-07 sb=1.4e-07 sd=160n sca=9.33388 \
        scb=0.00788941 scc=0.00017958 m=(1)
mn53 (\17\:n35 \7\:CKNbb \3\:n40 VSS) g45n1svt w=(1.45e-07) l=4.5e-08 \
        nf=1 as=2.03e-14 ad=2.03e-14 ps=5.7e-07 pd=5.7e-07 nrd=1.16667 \
        nrs=1.16667 sa=1.4e-07 sb=1.4e-07 sd=160n sca=8.42104 \
        scb=0.00632542 scc=0.000106623 m=(1)
mn55 (\1\:Q \11\:qbint \17\:VSS VSS) g45n1svt w=(2.6e-07) l=4.5e-08 nf=1 \
        as=3.64e-14 ad=3.64e-14 ps=8e-07 pd=8e-07 nrd=1.16667 nrs=1.16667 \
        sa=1.4e-07 sb=1.4e-07 sd=160n sca=9.50447 scb=0.0081528 \
        scc=0.00025289 m=(1)
mp55 (\4\:Q \10\:qbint \1\:VDD VDD) g45p1svt w=(3.9e-07) l=4.5e-08 nf=1 \
        as=5.46e-14 ad=5.46e-14 ps=1.06e-06 pd=1.06e-06 nrd=1.16667 \
        nrs=1.16667 sa=1.4e-07 sb=1.4e-07 sd=160n sca=20.1325 \
        scb=0.0179115 scc=0.00149096 m=(1)
ends RDFFNRQX1
// End of subcircuit definition.
