// Generated for: spectre (May  1 09:15:28 2013 )
// Library name: gsclib045_lvt
// Cell name: SEDFFTRX1
// View name: extracted

simulator lang=spectre

subckt SEDFFTRX1 CK D E Q QN RN SE SI VDD VSS
mp57 (\3\:QN \4\:net582 \26\:VDD VDD) g45p1lvt w=(3.9e-07) l=4.5e-08 \
        nf=1 as=6.535e-14 ad=5.46e-14 ps=1.16e-06 pd=1.06e-06 nrd=1.16667 \
        nrs=1.16667 sa=1.4e-07 sb=2.69551e-07 sd=160n sca=43.1032 \
        scb=0.0380646 scc=0.00455683 m=(1)
mp55 (\3\:Q \7\:qbint \16\:VDD VDD) g45p1lvt w=(3.9e-07) l=4.5e-08 nf=1 \
        as=9e-14 ad=5.46e-14 ps=1.42e-06 pd=1.06e-06 nrd=1.16667 \
        nrs=1.16667 sa=8.67372e-07 sb=1.4e-07 sd=160n sca=19.0259 \
        scb=0.0163587 scc=0.00171562 m=(1)
C1 (D VSS) capacitor c=6.13315e-17
C2 (QN VSS) capacitor c=1.67867e-17
C3 (SE VSS) capacitor c=2.40022e-17
C4 (E VSS) capacitor c=2.35987e-17
C5 (SI VSS) capacitor c=4.5579e-17
C6 (VDD VSS) capacitor c=5.62414e-16
C7 (RN VSS) capacitor c=5.14804e-17
C8 (net582 VSS) capacitor c=2.18917e-17
C9 (qbint VSS) capacitor c=1.79575e-17
C10 (n30 VSS) capacitor c=3.42812e-17
C11 (net618 VSS) capacitor c=1.73213e-18
C12 (CKb VSS) capacitor c=3.49325e-17
C13 (mout VSS) capacitor c=6.51857e-17
C14 (CKbb VSS) capacitor c=5.70292e-17
C15 (n20 VSS) capacitor c=4.88898e-17
C16 (Dpb VSS) capacitor c=6.70669e-17
C17 (SEb VSS) capacitor c=4.33516e-17
C18 (net658 VSS) capacitor c=6.34019e-18
C19 (Dp VSS) capacitor c=3.79383e-17
C20 (RNb VSS) capacitor c=3.75629e-17
C21 (net634 VSS) capacitor c=2.06852e-18
C22 (Eb VSS) capacitor c=5.36958e-17
C23 (Db VSS) capacitor c=9.44253e-17
C24 (net529 VSS) capacitor c=3.92877e-19
C25 (net521 VSS) capacitor c=1.06974e-18
C26 (net557 VSS) capacitor c=3.88657e-18
C27 (net549 VSS) capacitor c=1.41178e-18
C28 (net493 VSS) capacitor c=8.63733e-17
C29 (net505 VSS) capacitor c=8.24737e-17
C30 (\1\:D VSS) capacitor c=3.50599e-17
C31 (\4\:E VSS) capacitor c=4.07627e-17
C32 (\2\:Db VSS) capacitor c=5.91707e-17
C33 (\3\:E VSS) capacitor c=4.0275e-17
C34 (\11\:qbint VSS) capacitor c=5.17552e-17
C35 (\3\:RNb VSS) capacitor c=5.83352e-17
C36 (\1\:RN VSS) capacitor c=3.10181e-17
C37 (\7\:qbint VSS) capacitor c=3.54775e-17
C38 (\4\:SE VSS) capacitor c=3.91612e-17
C39 (\1\:SI VSS) capacitor c=4.95342e-17
C40 (\1\:SE VSS) capacitor c=4.35271e-17
C41 (\1\:CK VSS) capacitor c=3.90431e-17
C42 (\7\:CKbb VSS) capacitor c=3.78608e-17
C43 (\4\:CKb VSS) capacitor c=1.37134e-16
C44 (\5\:CKb VSS) capacitor c=1.23557e-16
C45 (\4\:qbint VSS) capacitor c=5.50826e-17
C46 (\3\:n30 VSS) capacitor c=3.53738e-17
C47 (\2\:qbint VSS) capacitor c=3.18164e-17
C48 (\4\:net582 VSS) capacitor c=4.41686e-17
C49 (\3\:D VSS) capacitor c=3.05051e-17
C50 (\7\:E VSS) capacitor c=2.90524e-17
C51 (\1\:E VSS) capacitor c=6.90388e-17
C52 (\3\:Eb VSS) capacitor c=4.58908e-17
C53 (\10\:qbint VSS) capacitor c=9.97929e-17
C54 (\3\:RN VSS) capacitor c=3.26532e-17
C55 (\9\:qbint VSS) capacitor c=5.07459e-17
C56 (\3\:Dp VSS) capacitor c=4.80505e-17
C57 (\3\:SEb VSS) capacitor c=6.55197e-17
C58 (\6\:SE VSS) capacitor c=2.56765e-17
C59 (\3\:SI VSS) capacitor c=2.67583e-17
C60 (\3\:SE VSS) capacitor c=2.21581e-17
C61 (\3\:CK VSS) capacitor c=3.89824e-17
C62 (\8\:CKb VSS) capacitor c=2.73007e-17
C63 (\9\:CKb VSS) capacitor c=2.26122e-17
C64 (\5\:CKbb VSS) capacitor c=8.17137e-17
C65 (\3\:mout VSS) capacitor c=6.69927e-17
C66 (\3\:n20 VSS) capacitor c=3.2134e-17
C67 (\3\:CKbb VSS) capacitor c=6.03518e-17
C68 (\6\:CKb VSS) capacitor c=8.78379e-17
C69 (\5\:qbint VSS) capacitor c=5.62097e-17
C70 (\3\:qbint VSS) capacitor c=4.52794e-17
C71 (\3\:net582 VSS) capacitor c=3.91111e-17
C72 (\2\:D VSS) capacitor c=2.96106e-17
C73 (\6\:E VSS) capacitor c=2.88516e-17
C74 (\3\:Db VSS) capacitor c=1.94205e-17
C75 (\2\:E VSS) capacitor c=6.98852e-17
C76 (\2\:Eb VSS) capacitor c=4.34611e-17
C77 (\12\:qbint VSS) capacitor c=3.43841e-17
C78 (\2\:RNb VSS) capacitor c=6.33346e-17
C79 (\2\:RN VSS) capacitor c=3.63e-17
C80 (\8\:qbint VSS) capacitor c=2.09861e-17
C81 (\2\:Dp VSS) capacitor c=3.41757e-17
C82 (\4\:SEb VSS) capacitor c=3.07421e-17
C83 (\5\:SE VSS) capacitor c=3.48488e-17
C84 (\2\:SEb VSS) capacitor c=2.95979e-17
C85 (\2\:SI VSS) capacitor c=2.61504e-17
C86 (\2\:SE VSS) capacitor c=2.05842e-17
C87 (\2\:CK VSS) capacitor c=3.8465e-17
C88 (\7\:CKb VSS) capacitor c=2.57972e-17
C89 (\8\:CKbb VSS) capacitor c=5.08285e-17
C90 (\6\:CKbb VSS) capacitor c=2.47145e-17
C91 (\2\:mout VSS) capacitor c=5.37766e-17
C92 (\2\:n20 VSS) capacitor c=3.40546e-17
C93 (\4\:CKbb VSS) capacitor c=2.12867e-17
C94 (\2\:CKbb VSS) capacitor c=5.79721e-17
C95 (\6\:qbint VSS) capacitor c=3.20773e-17
C96 (\2\:n30 VSS) capacitor c=3.58901e-17
C97 (\4\:Db VSS) capacitor c=1.13604e-16
C98 (\1\:VDD VSS) capacitor c=1.88996e-17
C99 (\4\:Eb VSS) capacitor c=5.19987e-17
C100 (\4\:Dp VSS) capacitor c=7.32093e-17
C101 (\10\:Dp VSS) capacitor c=2.17434e-17
C102 (\3\:net505 VSS) capacitor c=7.55755e-17
C103 (\3\:net493 VSS) capacitor c=6.63825e-17
C104 (\14\:VDD VSS) capacitor c=1.67949e-17
C105 (\6\:RNb VSS) capacitor c=5.50645e-17
C106 (\3\:Q VSS) capacitor c=7.10559e-17
C107 (\16\:VDD VSS) capacitor c=4.81258e-17
C108 (\3\:Dpb VSS) capacitor c=2.8105e-16
C109 (\18\:VDD VSS) capacitor c=3.06367e-17
C110 (\8\:SEb VSS) capacitor c=1.36099e-16
C111 (\10\:CKb VSS) capacitor c=6.10549e-17
C112 (\20\:VDD VSS) capacitor c=2.72365e-17
C113 (\9\:CKbb VSS) capacitor c=5.98914e-17
C114 (\5\:Dpb VSS) capacitor c=2.4251e-16
C115 (\4\:n20 VSS) capacitor c=4.94959e-17
C116 (\22\:VDD VSS) capacitor c=6.78402e-17
C117 (\8\:mout VSS) capacitor c=5.59739e-17
C118 (\8\:n30 VSS) capacitor c=3.5377e-17
C119 (\24\:VDD VSS) capacitor c=4.31751e-17
C120 (\16\:qbint VSS) capacitor c=8.96871e-17
C121 (\5\:net582 VSS) capacitor c=3.46039e-17
C122 (\26\:VDD VSS) capacitor c=8.50874e-17
C123 (\3\:QN VSS) capacitor c=5.42789e-17
C124 (\3\:VDD VSS) capacitor c=1.75268e-16
C125 (\7\:Db VSS) capacitor c=4.5087e-17
C126 (\8\:Eb VSS) capacitor c=2.17386e-17
C127 (\13\:Dp VSS) capacitor c=1.11844e-16
C128 (\8\:Dp VSS) capacitor c=9.32583e-17
C129 (\8\:RNb VSS) capacitor c=4.79785e-17
C130 (\1\:Q VSS) capacitor c=8.05362e-17
C131 (\6\:SEb VSS) capacitor c=1.77032e-16
C132 (\14\:CKb VSS) capacitor c=2.96287e-17
C133 (\11\:CKbb VSS) capacitor c=7.30602e-17
C134 (\7\:Dpb VSS) capacitor c=8.80678e-17
C135 (\8\:n20 VSS) capacitor c=3.08565e-17
C136 (\6\:mout VSS) capacitor c=4.90382e-17
C137 (\4\:n30 VSS) capacitor c=6.81232e-17
C138 (\20\:qbint VSS) capacitor c=4.61268e-17
C139 (\9\:net582 VSS) capacitor c=1.58172e-17
C140 (\1\:QN VSS) capacitor c=9.56012e-18
C141 (\2\:net582 VSS) capacitor c=7.93253e-18
C142 (\2\:CKb VSS) capacitor c=3.06815e-17
C143 (\3\:CKb VSS) capacitor c=7.74218e-17
C144 (\7\:net582 VSS) capacitor c=2.23472e-17
C145 (\8\:net582 VSS) capacitor c=3.14573e-17
C146 (\6\:n30 VSS) capacitor c=8.51489e-17
C147 (\7\:n30 VSS) capacitor c=7.53563e-17
C148 (\4\:mout VSS) capacitor c=7.55431e-17
C149 (\5\:mout VSS) capacitor c=6.85378e-17
C150 (\6\:n20 VSS) capacitor c=6.7088e-17
C151 (\7\:n20 VSS) capacitor c=5.78229e-17
C152 (\5\:E VSS) capacitor c=2.6702e-17
C153 (\13\:CKbb VSS) capacitor c=5.76598e-17
C154 (\14\:CKbb VSS) capacitor c=7.0233e-17
C155 (\15\:CKbb VSS) capacitor c=1.00396e-16
C156 (\16\:CKbb VSS) capacitor c=8.66884e-17
C157 (\17\:CKbb VSS) capacitor c=8.84645e-17
C158 (\4\:CK VSS) capacitor c=3.84281e-17
C159 (\6\:CK VSS) capacitor c=6.30491e-17
C160 (\12\:CKb VSS) capacitor c=5.24709e-17
C161 (\13\:CKb VSS) capacitor c=4.96274e-17
C162 (\4\:SI VSS) capacitor c=8.22682e-17
C163 (\7\:SE VSS) capacitor c=1.03021e-16
C164 (\8\:SE VSS) capacitor c=1.11967e-16
C165 (\9\:SE VSS) capacitor c=2.52559e-17
C166 (\5\:SEb VSS) capacitor c=1.35876e-16
C167 (\10\:SEb VSS) capacitor c=1.06392e-16
C168 (\4\:RN VSS) capacitor c=7.3774e-17
C169 (\4\:RNb VSS) capacitor c=6.40148e-17
C170 (\5\:RNb VSS) capacitor c=5.65247e-17
C171 (\13\:qbint VSS) capacitor c=9.38957e-17
C172 (\14\:qbint VSS) capacitor c=5.04972e-16
C173 (\15\:qbint VSS) capacitor c=4.45567e-16
C174 (\18\:qbint VSS) capacitor c=5.52728e-17
C175 (\19\:qbint VSS) capacitor c=2.15831e-17
C176 (\22\:qbint VSS) capacitor c=3.74133e-17
C177 (\6\:Dp VSS) capacitor c=1.12129e-16
C178 (\7\:Dp VSS) capacitor c=2.41358e-16
C179 (\12\:Dp VSS) capacitor c=1.86115e-16
C180 (\8\:E VSS) capacitor c=5.70782e-17
C181 (\9\:E VSS) capacitor c=8.12991e-17
C182 (\6\:Eb VSS) capacitor c=1.08288e-16
C183 (\7\:Eb VSS) capacitor c=1.53376e-16
C184 (\4\:D VSS) capacitor c=4.95738e-17
C185 (\6\:Db VSS) capacitor c=8.38919e-17
C186 (\6\:VDD VSS) capacitor c=4.21635e-17
C187 (\7\:VDD VSS) capacitor c=3.952e-17
C188 (\9\:VDD VSS) capacitor c=3.628e-17
C189 (\10\:VDD VSS) capacitor c=5.79145e-17
C190 (\12\:VDD VSS) capacitor c=1.26935e-17
C191 (\13\:VDD VSS) capacitor c=1.55213e-17
Rk63 (\4\:D D) resistor r=0.1696 c=0
Rk1 (QN \2\:QN) resistor r=0.03908 c=0
Rk2 (QN \4\:QN) resistor r=0.2585 c=0
Rk29 (\8\:SE SE) resistor r=0.0121 c=0
Rk28 (\7\:SE \8\:SE) resistor r=0.8009 c=0
Rk30 (\8\:SE \9\:SE) resistor r=0.08252 c=0
Rk58 (E \8\:E) resistor r=0.03641 c=0
Rk59 (\8\:E \9\:E) resistor r=0.2615 c=0
Rk37 (\2\:Q Q) resistor r=0.04342 c=0
Rk38 (Q \4\:Q) resistor r=0.267 c=0
Rk27 (SI \4\:SI) resistor r=0.0195 c=0
Rk66 (\2\:VDD \4\:VDD) resistor r=0.2312 c=0
Rk67 (\4\:VDD \5\:VDD) resistor r=0.8538 c=0
Rk68 (\5\:VDD \6\:VDD) resistor r=0.4467 c=0
Rk69 (\6\:VDD \7\:VDD) resistor r=0.5004 c=0
Rk70 (\7\:VDD \8\:VDD) resistor r=0.2547 c=0
Rk71 (\8\:VDD \9\:VDD) resistor r=0.187 c=0
Rk72 (\9\:VDD \10\:VDD) resistor r=0.5481 c=0
Rk73 (\10\:VDD \11\:VDD) resistor r=0.4664 c=0
Rk74 (\11\:VDD \12\:VDD) resistor r=0.07757 c=0
Rk76 (\13\:VDD VDD) resistor r=0.1074 c=0
Rk75 (\12\:VDD \13\:VDD) resistor r=0.3659 c=0
Rk77 (\5\:VDD \15\:VDD) resistor r=0.0715 c=0
Rk78 (\6\:VDD \17\:VDD) resistor r=0.2064 c=0
Rk79 (\7\:VDD \19\:VDD) resistor r=0.04333 c=0
Rk80 (\9\:VDD \21\:VDD) resistor r=0.04333 c=0
Rk81 (\10\:VDD \23\:VDD) resistor r=0.3046 c=0
Rk82 (\12\:VDD \25\:VDD) resistor r=0.2064 c=0
Rk83 (\13\:VDD \27\:VDD) resistor r=0.4131 c=0
Rk39 (RN \4\:RN) resistor r=0.08752 c=0
Rk84 (\2\:VSS \4\:VSS) resistor r=0.4374 c=0
Rk85 (\4\:VSS \5\:VSS) resistor r=0.4087 c=0
Rk86 (\5\:VSS \6\:VSS) resistor r=0.115 c=0
Rk87 (\6\:VSS \7\:VSS) resistor r=0.2429 c=0
Rk88 (\7\:VSS \8\:VSS) resistor r=0.0851 c=0
Rk89 (\8\:VSS \9\:VSS) resistor r=0.4363 c=0
Rk90 (\9\:VSS \10\:VSS) resistor r=0.554 c=0
Rk91 (\10\:VSS \11\:VSS) resistor r=0.213 c=0
Rk92 (\11\:VSS \12\:VSS) resistor r=0.203 c=0
Rk93 (\12\:VSS \13\:VSS) resistor r=0.534 c=0
Rk94 (\13\:VSS \14\:VSS) resistor r=0.4664 c=0
Rk95 (\14\:VSS \15\:VSS) resistor r=0.05249 c=0
Rk97 (\16\:VSS VSS) resistor r=0.1074 c=0
Rk96 (\15\:VSS \16\:VSS) resistor r=0.391 c=0
Rk98 (\5\:VSS \18\:VSS) resistor r=0.19 c=0
Rk99 (\6\:VSS \20\:VSS) resistor r=0.2008 c=0
Rk100 (\7\:VSS \22\:VSS) resistor r=0.2709 c=0
Rk101 (\9\:VSS \24\:VSS) resistor r=0.3041 c=0
Rk102 (\10\:VSS \26\:VSS) resistor r=0.1029 c=0
Rk103 (\12\:VSS \28\:VSS) resistor r=0.2171 c=0
Rk104 (\13\:VSS \30\:VSS) resistor r=0.123 c=0
Rk105 (\15\:VSS \32\:VSS) resistor r=0.3679 c=0
Rk106 (\16\:VSS \34\:VSS) resistor r=0.2886 c=0
Rk21 (\4\:CK \5\:CK) resistor r=0.001437 c=0
Rk22 (CK \6\:CK) resistor r=0.001365 c=0
Rk23 (\4\:CK \6\:CK) resistor r=0.07063 c=0
Rk3 (\6\:net582 \7\:net582) resistor r=0.13 c=0
Rk4 (\7\:net582 \8\:net582) resistor r=0.1226 c=0
Rk5 (\7\:net582 \10\:net582) resistor r=0.0939 c=0
Rk43 (\13\:qbint \14\:qbint) resistor r=0.8565 c=0
Rk44 (\14\:qbint \15\:qbint) resistor r=3.3628 c=0
Rk45 (\15\:qbint \17\:qbint) resistor r=0.412 c=0
Rk46 (\14\:qbint \18\:qbint) resistor r=0.253 c=0
Rk47 (\15\:qbint \19\:qbint) resistor r=0.03527 c=0
Rk48 (\17\:qbint \21\:qbint) resistor r=0.437 c=0
Rk49 (\17\:qbint \22\:qbint) resistor r=0.2281 c=0
Rk6 (\5\:n30 \6\:n30) resistor r=0.3394 c=0
Rk7 (\6\:n30 \7\:n30) resistor r=0.4232 c=0
Rk8 (\6\:n30 \9\:n30) resistor r=0.05919 c=0
Rk24 (\11\:CKb \12\:CKb) resistor r=0.3426 c=0
Rk25 (\12\:CKb \13\:CKb) resistor r=0.2254 c=0
Rk26 (\12\:CKb \15\:CKb) resistor r=0.1298 c=0
Rk9 (\4\:mout \5\:mout) resistor r=0.3387 c=0
Rk10 (\5\:mout \7\:mout) resistor r=0.2599 c=0
Rk11 (\5\:mout \9\:mout) resistor r=0.185 c=0
Rk15 (\10\:CKbb \12\:CKbb) resistor r=0.4361 c=0
Rk16 (\12\:CKbb \13\:CKbb) resistor r=0.2609 c=0
Rk17 (\13\:CKbb \14\:CKbb) resistor r=0.1721 c=0
Rk18 (\14\:CKbb \15\:CKbb) resistor r=0.5416 c=0
Rk19 (\15\:CKbb \16\:CKbb) resistor r=0.5831 c=0
Rk20 (\13\:CKbb \17\:CKbb) resistor r=0.4083 c=0
Rk12 (\5\:n20 \6\:n20) resistor r=0.2925 c=0
Rk13 (\6\:n20 \7\:n20) resistor r=0.3095 c=0
Rk14 (\6\:n20 \9\:n20) resistor r=0.1352 c=0
Rk31 (\2\:Dpb \4\:Dpb) resistor r=0.4142 c=0
Rk32 (\4\:Dpb \6\:Dpb) resistor r=1.6426 c=0
Rk33 (\6\:Dpb \8\:Dpb) resistor r=0.4468 c=0
Rk34 (\5\:SEb \7\:SEb) resistor r=1.0724 c=0
Rk35 (\7\:SEb \9\:SEb) resistor r=0.4831 c=0
Rk36 (\9\:SEb \10\:SEb) resistor r=0.6472 c=0
Rk52 (\5\:Dp \6\:Dp) resistor r=0.3391 c=0
Rk53 (\6\:Dp \7\:Dp) resistor r=0.6329 c=0
Rk54 (\7\:Dp \9\:Dp) resistor r=0.071 c=0
Rk55 (\6\:Dp \11\:Dp) resistor r=0.04671 c=0
Rk56 (\7\:Dp \12\:Dp) resistor r=1.4712 c=0
Rk57 (\9\:Dp \14\:Dp) resistor r=0.7253 c=0
Rk40 (\4\:RNb \5\:RNb) resistor r=0.2829 c=0
Rk41 (\5\:RNb \7\:RNb) resistor r=0.2469 c=0
Rk42 (\5\:RNb \9\:RNb) resistor r=0.2138 c=0
Rk60 (\5\:Eb \6\:Eb) resistor r=0.2365 c=0
Rk61 (\6\:Eb \7\:Eb) resistor r=0.8246 c=0
Rk62 (\6\:Eb \9\:Eb) resistor r=0.06371 c=0
Rk64 (\5\:Db \6\:Db) resistor r=0.777 c=0
Rk65 (\5\:Db \8\:Db) resistor r=0.357 c=0
Rk50 (\2\:net493 \4\:net493) resistor r=0.3328 c=0
Rk51 (\2\:net505 \4\:net505) resistor r=0.5124 c=0
Rl55 (\1\:D \2\:D) resistor r=39.6174 c=0
Rl56 (\2\:D \3\:D) resistor r=37.6944 c=0
Rl33 (\4\:SE \5\:SE) resistor r=74.9772 c=0
Rl34 (\5\:SE \6\:SE) resistor r=24.7951 c=0
Rl28 (\1\:SE \2\:SE) resistor r=61.5385 c=0
Rl29 (\2\:SE \3\:SE) resistor r=29.9451 c=0
Rl49 (\2\:E \3\:E) resistor r=61.5157 c=0
Rl48 (\1\:E \2\:E) resistor r=134.41 c=0
Rl52 (\4\:E \5\:E) resistor r=47.3105 c=0
Rl54 (\5\:E \7\:E) resistor r=55.0028 c=0
Rl53 (\5\:E \6\:E) resistor r=92.681 c=0
Rl30 (\1\:SI \2\:SI) resistor r=60.3072 c=0
Rl31 (\2\:SI \3\:SI) resistor r=29.5379 c=0
Rl40 (\1\:RN \2\:RN) resistor r=29.5379 c=0
Rl41 (\2\:RN \3\:RN) resistor r=139.153 c=0
Rl26 (\1\:CK \2\:CK) resistor r=53.8462 c=0
Rl27 (\2\:CK \3\:CK) resistor r=100.676 c=0
Rl3 (\2\:net582 \4\:net582) resistor r=49.7141 c=0
Rl2 (\2\:net582 \3\:net582) resistor r=34.3295 c=0
Rl1 (net582 \2\:net582) resistor r=5.915 c=0
Rl44 (\10\:qbint \11\:qbint) resistor r=209.181 c=0
Rl8 (\4\:qbint \5\:qbint) resistor r=167.308 c=0
Rl5 (\2\:qbint \3\:qbint) resistor r=92.3077 c=0
Rl45 (\11\:qbint \12\:qbint) resistor r=32.908 c=0
Rl38 (\7\:qbint \8\:qbint) resistor r=29.5379 c=0
Rl39 (\8\:qbint \9\:qbint) resistor r=56.461 c=0
Rl9 (\4\:qbint \6\:qbint) resistor r=24.2328 c=0
Rl4 (qbint \2\:qbint) resistor r=31.0981 c=0
Rl7 (\2\:n30 \3\:n30) resistor r=45.708 c=0
Rl6 (n30 \2\:n30) resistor r=105.002 c=0
Rl21 (\4\:CKb \5\:CKb) resistor r=403.412 c=0
Rl22 (\5\:CKb \6\:CKb) resistor r=210.67 c=0
Rl24 (\7\:CKb \8\:CKb) resistor r=35.7134 c=0
Rl18 (CKb \2\:CKb) resistor r=53.0797 c=0
Rl23 (\2\:CKb \7\:CKb) resistor r=54.1777 c=0
Rl20 (\3\:CKb \4\:CKb) resistor r=184.159 c=0
Rl25 (\3\:CKb \9\:CKb) resistor r=30.4507 c=0
Rl19 (\2\:CKb \3\:CKb) resistor r=198.915 c=0
Rl14 (mout \2\:mout) resistor r=50.6918 c=0
Rl15 (\2\:mout \3\:mout) resistor r=91.0764 c=0
Rl17 (\7\:CKbb \8\:CKbb) resistor r=64.6174 c=0
Rl16 (\5\:CKbb \6\:CKbb) resistor r=51.1559 c=0
Rl11 (\3\:CKbb \4\:CKbb) resistor r=41.5405 c=0
Rl10 (CKbb \2\:CKbb) resistor r=64.6174 c=0
Rl12 (n20 \2\:n20) resistor r=112.23 c=0
Rl13 (\2\:n20 \3\:n20) resistor r=29.5379 c=0
Rl35 (\3\:SEb \4\:SEb) resistor r=93.4636 c=0
Rl32 (SEb \2\:SEb) resistor r=29.5379 c=0
Rl36 (Dp \2\:Dp) resistor r=60.3072 c=0
Rl37 (\2\:Dp \3\:Dp) resistor r=29.5379 c=0
Rl43 (\2\:RNb \3\:RNb) resistor r=89.6174 c=0
Rl42 (RNb \2\:RNb) resistor r=101.477 c=0
Rl46 (Eb \2\:Eb) resistor r=126.718 c=0
Rl47 (\2\:Eb \3\:Eb) resistor r=35.8888 c=0
Rl50 (Db \2\:Db) resistor r=226.489 c=0
Rl51 (\2\:Db \3\:Db) resistor r=24.2328 c=0
Rz1 (\1\:QN \2\:QN) resistor r=75 c=0
Rz11 (\1\:Q \2\:Q) resistor r=75 c=0
Rz18 (\3\:VDD \4\:VDD) resistor r=15 c=0
Rz19 (\3\:VDD \5\:VDD) resistor r=6.25 c=0
Rz20 (\3\:VDD \8\:VDD) resistor r=6.25 c=0
Rz21 (\3\:VDD \11\:VDD) resistor r=6.25 c=0
Rz22 (\1\:VSS \2\:VSS) resistor r=75 c=0
Rz23 (\17\:VSS \18\:VSS) resistor r=75 c=0
Rz24 (\19\:VSS \20\:VSS) resistor r=75 c=0
Rz25 (\21\:VSS \22\:VSS) resistor r=75 c=0
Rz26 (\23\:VSS \24\:VSS) resistor r=75 c=0
Rz27 (\25\:VSS \26\:VSS) resistor r=75 c=0
Rz28 (\27\:VSS \28\:VSS) resistor r=75 c=0
Rz29 (\29\:VSS \30\:VSS) resistor r=75 c=0
Rz30 (\31\:VSS \32\:VSS) resistor r=75 c=0
Rz31 (\33\:VSS \34\:VSS) resistor r=75 c=0
Rz2 (\9\:net582 \10\:net582) resistor r=75 c=0
Rz13 (\20\:qbint \21\:qbint) resistor r=75 c=0
Rz3 (\4\:n30 \5\:n30) resistor r=75 c=0
Rz7 (\14\:CKb \15\:CKb) resistor r=75 c=0
Rz4 (\6\:mout \7\:mout) resistor r=75 c=0
Rz6 (\11\:CKbb \12\:CKbb) resistor r=75 c=0
Rz5 (\8\:n20 \9\:n20) resistor r=75 c=0
Rz8 (Dpb \2\:Dpb) resistor r=75 c=0
Rz9 (\7\:Dpb \8\:Dpb) resistor r=75 c=0
Rz10 (\6\:SEb \7\:SEb) resistor r=75 c=0
Rz14 (\8\:Dp \9\:Dp) resistor r=75 c=0
Rz15 (\13\:Dp \14\:Dp) resistor r=75 c=0
Rz12 (\8\:RNb \9\:RNb) resistor r=75 c=0
Rz16 (\8\:Eb \9\:Eb) resistor r=75 c=0
Rz17 (\7\:Db \8\:Db) resistor r=75 c=0
Ry1 (\3\:QN \4\:QN) resistor r=20.6667 c=0
Ry11 (\3\:Q \4\:Q) resistor r=62 c=0
Ry22 (\1\:VDD \2\:VDD) resistor r=62 c=0
Ry23 (\14\:VDD \15\:VDD) resistor r=62 c=0
Ry24 (\16\:VDD \17\:VDD) resistor r=62 c=0
Ry25 (\18\:VDD \19\:VDD) resistor r=62 c=0
Ry26 (\20\:VDD \21\:VDD) resistor r=62 c=0
Ry27 (\22\:VDD \23\:VDD) resistor r=62 c=0
Ry28 (\24\:VDD \25\:VDD) resistor r=62 c=0
Ry29 (\26\:VDD \27\:VDD) resistor r=20.6667 c=0
Ry30 (\3\:VSS \4\:VSS) resistor r=12.4 c=0
Ry31 (\3\:VSS \8\:VSS) resistor r=5.1667 c=0
Ry32 (\3\:VSS \11\:VSS) resistor r=5.1667 c=0
Ry33 (\3\:VSS \14\:VSS) resistor r=5.1667 c=0
Ry2 (\5\:net582 \6\:net582) resistor r=62 c=0
Ry13 (\16\:qbint \17\:qbint) resistor r=62 c=0
Ry3 (\8\:n30 \9\:n30) resistor r=62 c=0
Ry7 (\10\:CKb \11\:CKb) resistor r=62 c=0
Ry4 (\8\:mout \9\:mout) resistor r=62 c=0
Ry6 (\9\:CKbb \10\:CKbb) resistor r=62 c=0
Ry5 (\4\:n20 \5\:n20) resistor r=62 c=0
Ry8 (\3\:Dpb \4\:Dpb) resistor r=62 c=0
Ry9 (\5\:Dpb \6\:Dpb) resistor r=62 c=0
Ry10 (\8\:SEb \9\:SEb) resistor r=62 c=0
Ry18 (\4\:Dp \5\:Dp) resistor r=62 c=0
Ry19 (\10\:Dp \11\:Dp) resistor r=62 c=0
Ry12 (\6\:RNb \7\:RNb) resistor r=62 c=0
Ry20 (\4\:Eb \5\:Eb) resistor r=62 c=0
Ry21 (\4\:Db \5\:Db) resistor r=62 c=0
Ry14 (net493 \2\:net493) resistor r=62 c=0
Ry15 (\3\:net493 \4\:net493) resistor r=62 c=0
Ry16 (net505 \2\:net505) resistor r=62 c=0
Ry17 (\3\:net505 \4\:net505) resistor r=62 c=0
Rx26 (\2\:D \4\:D) resistor r=45 c=0
Rx12 (\5\:SE \7\:SE) resistor r=45 c=0
Rx13 (\2\:SE \9\:SE) resistor r=45 c=0
Rx23 (\6\:E \8\:E) resistor r=45 c=0
Rx24 (\2\:E \9\:E) resistor r=45 c=0
Rx11 (\2\:SI \4\:SI) resistor r=45 c=0
Rx16 (\2\:RN \4\:RN) resistor r=45 c=0
Rx9 (\2\:CK \5\:CK) resistor r=45 c=0
Rx1 (net582 \8\:net582) resistor r=45 c=0
Rx18 (\12\:qbint \13\:qbint) resistor r=45 c=0
Rx19 (\8\:qbint \18\:qbint) resistor r=45 c=0
Rx20 (\6\:qbint \19\:qbint) resistor r=45 c=0
Rx21 (qbint \22\:qbint) resistor r=45 c=0
Rx2 (\2\:n30 \7\:n30) resistor r=45 c=0
Rx10 (\7\:CKb \13\:CKb) resistor r=45 c=0
Rx3 (\2\:mout \4\:mout) resistor r=45 c=0
Rx5 (\6\:CKbb \14\:CKbb) resistor r=45 c=0
Rx6 (\4\:CKbb \15\:CKbb) resistor r=45 c=0
Rx7 (\2\:CKbb \16\:CKbb) resistor r=45 c=0
Rx8 (\8\:CKbb \17\:CKbb) resistor r=45 c=0
Rx4 (\2\:n20 \7\:n20) resistor r=45 c=0
Rx14 (\4\:SEb \5\:SEb) resistor r=45 c=0
Rx15 (\2\:SEb \10\:SEb) resistor r=45 c=0
Rx22 (\2\:Dp \12\:Dp) resistor r=45 c=0
Rx17 (\2\:RNb \4\:RNb) resistor r=45 c=0
Rx25 (\2\:Eb \7\:Eb) resistor r=45 c=0
Rx27 (\3\:Db \6\:Db) resistor r=45 c=0
mn57 (\1\:QN \3\:net582 \33\:VSS VSS) g45n1lvt w=(2.6e-07) l=4.5e-08 \
        nf=1 as=4.365e-14 ad=3.64e-14 ps=9e-07 pd=8e-07 nrd=1.16667 \
        nrs=1.16667 sa=1.4e-07 sb=2.71058e-07 sd=160n sca=17.5885 \
        scb=0.0172826 scc=0.00162584 m=(1)
mn55 (\1\:Q \9\:qbint \23\:VSS VSS) g45n1lvt w=(2.6e-07) l=4.5e-08 nf=1 \
        as=5.325e-14 ad=5.59e-14 ps=9.8e-07 pd=9.5e-07 nrd=1.16667 \
        nrs=1.16667 sa=9.71635e-07 sb=2.15e-07 sd=160n sca=17.5885 \
        scb=0.0172826 scc=0.00162584 m=(1)
mn56 (\9\:net582 \3\:qbint \33\:VSS VSS) g45n1lvt w=(1.45e-07) l=4.5e-08 \
        nf=1 as=4.365e-14 ad=2.03e-14 ps=9e-07 pd=5.7e-07 nrd=1.16667 \
        nrs=1.16667 sa=3.75e-07 sb=1.4e-07 sd=160n sca=23.279 \
        scb=0.0230742 scc=0.00267719 m=(1)
mn45 (\20\:qbint n30 \31\:VSS VSS) g45n1lvt w=(1.45e-07) l=4.5e-08 nf=1 \
        as=3.19e-14 ad=2.32e-14 ps=7.3e-07 pd=6.1e-07 nrd=1.16667 \
        nrs=1.16667 sa=1.6e-07 sb=1.815e-06 sd=160n sca=23.279 \
        scb=0.0230742 scc=0.00267719 m=(1)
mn50 (net618 \5\:qbint \31\:VSS VSS) g45n1lvt w=(1.45e-07) l=4.5e-08 \
        nf=1 as=3.19e-14 ad=2.03e-14 ps=7.3e-07 pd=5.7e-07 nrd=1.16667 \
        nrs=1.16667 sa=4.25e-07 sb=1.55e-06 sd=160n sca=23.279 \
        scb=0.0230742 scc=0.00267719 m=(1)
mn51 (\4\:n30 \6\:CKb net618 VSS) g45n1lvt w=(1.45e-07) l=4.5e-08 nf=1 \
        as=2.03e-14 ad=2.32e-14 ps=5.7e-07 pd=6.1e-07 nrd=1.16667 \
        nrs=1.16667 sa=6.1e-07 sb=1.365e-06 sd=160n sca=23.279 \
        scb=0.0230742 scc=0.00267719 m=(1)
mn40 (\4\:n30 \3\:CKbb \6\:mout VSS) g45n1lvt w=(1.45e-07) l=4.5e-08 nf=1 \
        as=3.988e-14 ad=2.32e-14 ps=8.4e-07 pd=6.1e-07 nrd=1.16667 \
        nrs=1.16667 sa=8.15e-07 sb=1.16e-06 sd=160n sca=23.279 \
        scb=0.0230742 scc=0.00267719 m=(1)
mn30 (\6\:mout \3\:n20 \29\:VSS VSS) g45n1lvt w=(1.45e-07) l=4.5e-08 \
        nf=1 as=7.45e-14 ad=3.988e-14 ps=1.44e-06 pd=8.4e-07 nrd=1.16667 \
        nrs=1.16667 sa=1.135e-06 sb=8.4e-07 sd=160n sca=23.279 \
        scb=0.0230742 scc=0.00267719 m=(1)
mn35 (net606 \3\:mout \29\:VSS VSS) g45n1lvt w=(1.45e-07) l=4.5e-08 nf=1 \
        as=7.45e-14 ad=8.7e-15 ps=1.44e-06 pd=4.1e-07 nrd=1.16667 \
        nrs=1.16667 sa=1.4e-06 sb=5.75e-07 sd=160n sca=23.279 \
        scb=0.0230742 scc=0.00267719 m=(1)
mn36 (\8\:n20 \5\:CKbb net606 VSS) g45n1lvt w=(1.45e-07) l=4.5e-08 nf=1 \
        as=8.7e-15 ad=2.465e-14 ps=4.1e-07 pd=6.3e-07 nrd=1.16667 \
        nrs=1.16667 sa=1.505e-06 sb=4.7e-07 sd=160n sca=23.279 \
        scb=0.0230742 scc=0.00267719 m=(1)
mn25 (\8\:n20 \9\:CKb \7\:Dpb VSS) g45n1lvt w=(1.45e-07) l=4.5e-08 nf=1 \
        as=3.698e-14 ad=2.465e-14 ps=8e-07 pd=6.3e-07 nrd=1.16667 \
        nrs=1.16667 sa=1.72e-06 sb=2.55e-07 sd=160n sca=23.279 \
        scb=0.0230742 scc=0.00267719 m=(1)
mn21 (\11\:CKbb \8\:CKb \27\:VSS VSS) g45n1lvt w=(1.45e-07) l=4.5e-08 \
        nf=1 as=2.32e-14 ad=2.32e-14 ps=6.1e-07 pd=6.1e-07 nrd=1.16667 \
        nrs=1.16667 sa=1.6e-07 sb=4.25e-07 sd=160n sca=7.688 \
        scb=0.00504888 scc=6.29443e-05 m=(1)
mn20 (\14\:CKb \3\:CK \27\:VSS VSS) g45n1lvt w=(1.45e-07) l=4.5e-08 nf=1 \
        as=2.32e-14 ad=3.19e-14 ps=6.1e-07 pd=7.3e-07 nrd=1.16667 \
        nrs=1.16667 sa=3.65e-07 sb=2.2e-07 sd=160n sca=7.688 \
        scb=0.00504888 scc=6.29443e-05 m=(1)
mn10 (\6\:SEb \3\:SE \25\:VSS VSS) g45n1lvt w=(1.45e-07) l=4.5e-08 nf=1 \
        as=9.087e-14 ad=3.698e-14 ps=1.69e-06 pd=8e-07 nrd=1.16667 \
        nrs=1.16667 sa=2.55e-07 sb=1.565e-06 sd=160n sca=21.4614 \
        scb=0.0218523 scc=0.00230065 m=(1)
mn13 (net658 \3\:SI \25\:VSS VSS) g45n1lvt w=(1.45e-07) l=4.5e-08 nf=1 \
        as=9.087e-14 ad=5.365e-14 ps=1.69e-06 pd=1.03e-06 nrd=1.16667 \
        nrs=1.16667 sa=5.75e-07 sb=1.245e-06 sd=160n sca=21.4614 \
        scb=0.0218523 scc=0.00230065 m=(1)
mn14 (Dpb \6\:SE net658 VSS) g45n1lvt w=(1.45e-07) l=4.5e-08 nf=1 \
        as=5.365e-14 ad=2.755e-14 ps=1.03e-06 pd=6.7e-07 nrd=1.16667 \
        nrs=1.16667 sa=9.9e-07 sb=8.3e-07 sd=160n sca=21.4614 \
        scb=0.0218523 scc=0.00230065 m=(1)
mn12 (Dpb \3\:SEb net650 VSS) g45n1lvt w=(1.45e-07) l=4.5e-08 nf=1 \
        as=8.7e-15 ad=2.755e-14 ps=4.1e-07 pd=6.7e-07 nrd=1.16667 \
        nrs=1.16667 sa=1.225e-06 sb=5.95e-07 sd=160n sca=21.4614 \
        scb=0.0218523 scc=0.00230065 m=(1)
mn11 (net650 \3\:Dp \23\:VSS VSS) g45n1lvt w=(1.45e-07) l=4.5e-08 nf=1 \
        as=5.325e-14 ad=8.7e-15 ps=9.8e-07 pd=4.1e-07 nrd=1.16667 \
        nrs=1.16667 sa=1.33e-06 sb=4.9e-07 sd=160n sca=21.4614 \
        scb=0.0218523 scc=0.00230065 m=(1)
mn2 (\8\:RNb \3\:RN \21\:VSS VSS) g45n1lvt w=(1.45e-07) l=4.5e-08 nf=1 \
        as=4.422e-14 ad=2.465e-14 ps=9e-07 pd=6.3e-07 nrd=1.16667 \
        nrs=1.16667 sa=1.7e-07 sb=8.3e-07 sd=160n sca=9.87692 \
        scb=0.0087933 scc=0.000232488 m=(1)
mn3 (\8\:Dp RNb \21\:VSS VSS) g45n1lvt w=(1.45e-07) l=4.5e-08 nf=1 \
        as=4.422e-14 ad=2.32e-14 ps=9e-07 pd=6.1e-07 nrd=1.16667 \
        nrs=1.16667 sa=5.2e-07 sb=4.8e-07 sd=160n sca=9.87692 \
        scb=0.0087933 scc=0.000232488 m=(1)
mn5 (\8\:Dp \10\:qbint net634 VSS) g45n1lvt w=(1.45e-07) l=4.5e-08 nf=1 \
        as=8.7e-15 ad=2.32e-14 ps=4.1e-07 pd=6.1e-07 nrd=1.16667 \
        nrs=1.16667 sa=7.25e-07 sb=2.75e-07 sd=160n sca=9.87692 \
        scb=0.0087933 scc=0.000232488 m=(1)
mn4 (net634 \3\:Eb \19\:VSS VSS) g45n1lvt w=(1.45e-07) l=4.5e-08 nf=1 \
        as=3.725e-14 ad=8.7e-15 ps=8.4e-07 pd=4.1e-07 nrd=1.16667 \
        nrs=1.16667 sa=8.3e-07 sb=1.7e-07 sd=160n sca=9.87692 \
        scb=0.0087933 scc=0.000232488 m=(1)
mn6 (net638 \1\:E \17\:VSS VSS) g45n1lvt w=(1.45e-07) l=4.5e-08 nf=1 \
        as=2.03e-14 ad=8.7e-15 ps=5.7e-07 pd=4.1e-07 nrd=1.16667 \
        nrs=1.16667 sa=1.4e-07 sb=2.45e-07 sd=160n sca=7.09016 \
        scb=0.00401586 scc=3.69756e-05 m=(1)
mn7 (\13\:Dp Db net638 VSS) g45n1lvt w=(1.45e-07) l=4.5e-08 nf=1 \
        as=8.7e-15 ad=2.03e-14 ps=4.1e-07 pd=5.7e-07 nrd=1.16667 \
        nrs=1.16667 sa=2.45e-07 sb=1.4e-07 sd=160n sca=7.09016 \
        scb=0.00401586 scc=3.69756e-05 m=(1)
mn0 (\8\:Eb \7\:E \1\:VSS VSS) g45n1lvt w=(1.45e-07) l=4.5e-08 nf=1 \
        as=2.32e-14 ad=2.03e-14 ps=6.1e-07 pd=5.7e-07 nrd=1.16667 \
        nrs=1.16667 sa=1.4e-07 sb=3.65e-07 sd=160n sca=17.8702 \
        scb=0.0189183 scc=0.00156031 m=(1)
mn1 (\7\:Db \3\:D \1\:VSS VSS) g45n1lvt w=(1.45e-07) l=4.5e-08 nf=1 \
        as=2.32e-14 ad=2.32e-14 ps=6.1e-07 pd=6.1e-07 nrd=1.16667 \
        nrs=1.16667 sa=3.45e-07 sb=1.6e-07 sd=160n sca=17.8702 \
        scb=0.0189183 scc=0.00156031 m=(1)
mp56 (\5\:net582 \2\:qbint \26\:VDD VDD) g45p1lvt w=(2.15e-07) l=4.5e-08 \
        nf=1 as=6.535e-14 ad=3.01e-14 ps=1.16e-06 pd=7.1e-07 nrd=1.16667 \
        nrs=1.16667 sa=3.75e-07 sb=1.4e-07 sd=160n sca=48.724 scb=0.031482 \
        scc=0.00590454 m=(1)
mp45 (\16\:qbint \3\:n30 \24\:VDD VDD) g45p1lvt w=(2.15e-07) l=4.5e-08 \
        nf=1 as=7.245e-14 ad=3.01e-14 ps=1.21e-06 pd=7.1e-07 nrd=1.16667 \
        nrs=1.16667 sa=1.4e-07 sb=1.865e-06 sd=160n sca=11.99 scb=0.01053 \
        scc=0.000305882 m=(1)
mp50 (net529 \4\:qbint \24\:VDD VDD) g45p1lvt w=(2.15e-07) l=4.5e-08 \
        nf=1 as=7.245e-14 ad=2.903e-14 ps=1.21e-06 pd=7e-07 nrd=1.16667 \
        nrs=1.16667 sa=4.55e-07 sb=1.55e-06 sd=160n sca=11.9515 \
        scb=0.0105226 scc=0.000305882 m=(1)
mp51 (\8\:n30 CKbb net529 VDD) g45p1lvt w=(2.15e-07) l=4.5e-08 nf=1 \
        as=2.903e-14 ad=3.548e-14 ps=7e-07 pd=7.6e-07 nrd=1.16667 \
        nrs=1.16667 sa=6.35e-07 sb=1.37e-06 sd=160n sca=11.9515 \
        scb=0.0105226 scc=0.000305882 m=(1)
mp40 (\8\:n30 \5\:CKb \8\:mout VDD) g45p1lvt w=(2.15e-07) l=4.5e-08 nf=1 \
        as=5.913e-14 ad=3.548e-14 ps=9.8e-07 pd=7.6e-07 nrd=1.16667 \
        nrs=1.16667 sa=8.45e-07 sb=1.16e-06 sd=160n sca=11.9515 \
        scb=0.0105226 scc=0.000305882 m=(1)
mp30 (\8\:mout n20 \22\:VDD VDD) g45p1lvt w=(2.15e-07) l=4.5e-08 nf=1 \
        as=4.73e-14 ad=5.912e-14 ps=8.7e-07 pd=9.8e-07 nrd=1.16667 \
        nrs=1.16667 sa=1.165e-06 sb=8.4e-07 sd=160n sca=11.9515 \
        scb=0.0105226 scc=0.000305882 m=(1)
mp35 (net521 mout \22\:VDD VDD) g45p1lvt w=(2.15e-07) l=4.5e-08 nf=1 \
        as=4.73e-14 ad=1.29e-14 ps=8.7e-07 pd=5.5e-07 nrd=1.16667 \
        nrs=1.16667 sa=1.43e-06 sb=5.75e-07 sd=160n sca=11.9515 \
        scb=0.0105226 scc=0.000305882 m=(1)
mp36 (\4\:n20 \4\:CKb net521 VDD) g45p1lvt w=(2.15e-07) l=4.5e-08 nf=1 \
        as=1.29e-14 ad=4.085e-14 ps=5.5e-07 pd=8.1e-07 nrd=1.16667 \
        nrs=1.16667 sa=1.535e-06 sb=4.7e-07 sd=160n sca=11.9515 \
        scb=0.0105226 scc=0.000305882 m=(1)
mp25 (\4\:n20 \7\:CKbb \5\:Dpb VDD) g45p1lvt w=(2.15e-07) l=4.5e-08 nf=1 \
        as=5.052e-14 ad=4.085e-14 ps=9e-07 pd=8.1e-07 nrd=1.16667 \
        nrs=1.16667 sa=1.77e-06 sb=2.35e-07 sd=160n sca=11.9515 \
        scb=0.0105226 scc=0.000305882 m=(1)
mp21 (\9\:CKbb CKb \20\:VDD VDD) g45p1lvt w=(2.15e-07) l=4.5e-08 nf=1 \
        as=1.091e-13 ad=3.44e-14 ps=1.9e-06 pd=7.5e-07 nrd=1.16667 \
        nrs=1.16667 sa=1.6e-07 sb=4.25e-07 sd=160n sca=45.7906 \
        scb=0.0283307 scc=0.00588417 m=(1)
mp20 (\10\:CKb \1\:CK \20\:VDD VDD) g45p1lvt w=(2.15e-07) l=4.5e-08 nf=1 \
        as=1.091e-13 ad=3.44e-14 ps=1.9e-06 pd=7.5e-07 nrd=1.16667 \
        nrs=1.16667 sa=4.25e-07 sb=1.6e-07 sd=160n sca=45.7906 \
        scb=0.0283307 scc=0.00588417 m=(1)
mp10 (\8\:SEb \1\:SE \18\:VDD VDD) g45p1lvt w=(2.15e-07) l=4.5e-08 nf=1 \
        as=1.031e-13 ad=3.01e-14 ps=1.8e-06 pd=7.1e-07 nrd=1.16667 \
        nrs=1.16667 sa=1.4e-07 sb=1.435e-06 sd=160n sca=25.9192 \
        scb=0.0230503 scc=0.00301683 m=(1)
mp13 (net557 \1\:SI \18\:VDD VDD) g45p1lvt w=(2.15e-07) l=4.5e-08 nf=1 \
        as=1.031e-13 ad=3.333e-14 ps=1.8e-06 pd=7.4e-07 nrd=1.16667 \
        nrs=1.16667 sa=4.05e-07 sb=1.17e-06 sd=160n sca=25.9192 \
        scb=0.0230503 scc=0.00301683 m=(1)
mp14 (\3\:Dpb SEb net557 VDD) g45p1lvt w=(2.15e-07) l=4.5e-08 nf=1 \
        as=3.333e-14 ad=5.268e-14 ps=7.4e-07 pd=9.2e-07 nrd=1.16667 \
        nrs=1.16667 sa=6.05e-07 sb=9.7e-07 sd=160n sca=25.9192 \
        scb=0.0230503 scc=0.00301683 m=(1)
mp12 (\3\:Dpb \4\:SE net549 VDD) g45p1lvt w=(2.15e-07) l=4.5e-08 nf=1 \
        as=4.73e-14 ad=5.268e-14 ps=8.7e-07 pd=9.2e-07 nrd=1.16667 \
        nrs=1.16667 sa=8.95e-07 sb=6.8e-07 sd=160n sca=25.9192 \
        scb=0.0230503 scc=0.00301683 m=(1)
mp11 (net549 Dp \16\:VDD VDD) g45p1lvt w=(2.15e-07) l=4.5e-08 nf=1 \
        as=9e-14 ad=4.73e-14 ps=1.42e-06 pd=8.7e-07 nrd=1.16667 \
        nrs=1.16667 sa=1.16e-06 sb=4.15e-07 sd=160n sca=25.9192 \
        scb=0.0230503 scc=0.00301683 m=(1)
mp2 (\6\:RNb \1\:RN \14\:VDD VDD) g45p1lvt w=(2.15e-07) l=4.5e-08 nf=1 \
        as=9.53e-14 ad=4.3e-14 ps=1.67e-06 pd=8.3e-07 nrd=1.16667 \
        nrs=1.16667 sa=2e-07 sb=8.15e-07 sd=160n sca=16.4667 scb=0.0163489 \
        scc=0.00112485 m=(1)
mp3 (\3\:net493 \3\:RNb \14\:VDD VDD) g45p1lvt w=(2.15e-07) l=4.5e-08 \
        nf=1 as=9.53e-14 ad=3.44e-14 ps=1.67e-06 pd=7.5e-07 nrd=1.16667 \
        nrs=1.16667 sa=4.65e-07 sb=5.5e-07 sd=160n sca=16.4667 \
        scb=0.0163489 scc=0.00112485 m=(1)
mp5 (\3\:net505 \11\:qbint \3\:net493 VDD) g45p1lvt w=(2.15e-07) \
        l=4.5e-08 nf=1 as=3.44e-14 ad=3.44e-14 ps=7.5e-07 pd=7.5e-07 \
        nrd=1.16667 nrs=1.16667 sa=6.7e-07 sb=3.45e-07 sd=160n sca=16.4667 \
        scb=0.0163489 scc=0.00112485 m=(1)
mp4 (\3\:net505 Eb net493 VDD) g45p1lvt w=(2.15e-07) l=4.5e-08 nf=1 \
        as=3.01e-14 ad=3.44e-14 ps=7.1e-07 pd=7.5e-07 nrd=1.16667 \
        nrs=1.16667 sa=8.75e-07 sb=1.4e-07 sd=160n sca=16.4667 \
        scb=0.0163489 scc=0.00112485 m=(1)
mp6 (\10\:Dp \3\:E net505 VDD) g45p1lvt w=(2.15e-07) l=4.5e-08 nf=1 \
        as=3.44e-14 ad=3.01e-14 ps=7.5e-07 pd=7.1e-07 nrd=1.16667 \
        nrs=1.16667 sa=1.4e-07 sb=3.45e-07 sd=160n sca=19.7413 \
        scb=0.019281 scc=0.00179464 m=(1)
mp7 (\4\:Dp \2\:Db net505 VDD) g45p1lvt w=(2.15e-07) l=4.5e-08 nf=1 \
        as=3.44e-14 ad=3.01e-14 ps=7.5e-07 pd=7.1e-07 nrd=1.16667 \
        nrs=1.16667 sa=3.45e-07 sb=1.4e-07 sd=160n sca=19.7413 \
        scb=0.019281 scc=0.00179464 m=(1)
mp0 (\4\:Eb \4\:E \1\:VDD VDD) g45p1lvt w=(2.15e-07) l=4.5e-08 nf=1 \
        as=6.455e-14 ad=3.01e-14 ps=1.76e-06 pd=7.1e-07 nrd=1.16667 \
        nrs=1.16667 sa=1.4e-07 sb=3.65e-07 sd=160n sca=49.0504 \
        scb=0.032034 scc=0.00591335 m=(1)
mp1 (\4\:Db \1\:D \1\:VDD VDD) g45p1lvt w=(2.15e-07) l=4.5e-08 nf=1 \
        as=6.455e-14 ad=3.44e-14 ps=1.76e-06 pd=7.5e-07 nrd=1.16667 \
        nrs=1.16667 sa=3.45e-07 sb=1.6e-07 sd=160n sca=57.444 \
        scb=0.0450892 scc=0.00689963 m=(1)
ends SEDFFTRX1
// End of subcircuit definition.
