// Generated for: spectre (May  1 09:18:59 2013 )
// Library name: gsclib045_hvt
// Cell name: OAI222X4
// View name: extracted

simulator lang=spectre

subckt OAI222X4 A0 A1 B0 B1 C0 C1 VDD VSS Y
mp0_1__rcx (2 \1\:A0 \23\:VDD VDD) g45p1hvt w=(3.9e-07) l=4.5e-08 nf=1 \
        as=5.46e-14 ad=2.34e-14 ps=1.06e-06 pd=9e-07 nrd=1.16667 \
        nrs=1.16667 sa=1.4e-07 sb=2e-06 sd=160n sca=13.1864 scb=0.011023 \
        scc=0.000312795 m=(1)
mp1_1__rcx (\17\:Y \4\:A1 2 VDD) g45p1hvt w=(3.9e-07) l=4.5e-08 nf=1 \
        as=2.34e-14 ad=6.24e-14 ps=9e-07 pd=1.1e-06 nrd=1.16667 \
        nrs=1.16667 sa=2.45e-07 sb=2e-06 sd=160n sca=12.592 scb=0.010475 \
        scc=0.000311666 m=(1)
mp1_2__rcx (\17\:Y \1\:A1 9 VDD) g45p1hvt w=(3.9e-07) l=4.5e-08 nf=1 \
        as=4.29e-14 ad=6.24e-14 ps=1e-06 pd=1.1e-06 nrd=1.16667 \
        nrs=1.16667 sa=4.5e-07 sb=2e-06 sd=160n sca=11.9394 scb=0.0101617 \
        scc=0.000311483 m=(1)
mp0_2__rcx (9 \9\:A0 \20\:VDD VDD) g45p1hvt w=(3.9e-07) l=4.5e-08 nf=1 \
        as=6.24e-14 ad=4.29e-14 ps=1.1e-06 pd=1e-06 nrd=1.16667 \
        nrs=1.16667 sa=6.05e-07 sb=2e-06 sd=160n sca=11.8275 scb=0.0101379 \
        scc=0.000311481 m=(1)
mp0_3__rcx (3 \4\:A0 \20\:VDD VDD) g45p1hvt w=(3.9e-07) l=4.5e-08 nf=1 \
        as=6.24e-14 ad=2.34e-14 ps=1.1e-06 pd=9e-07 nrd=1.16667 \
        nrs=1.16667 sa=8.1e-07 sb=2e-06 sd=160n sca=11.8275 scb=0.0101379 \
        scc=0.000311481 m=(1)
mp1_3__rcx (\15\:Y \13\:A1 3 VDD) g45p1hvt w=(3.9e-07) l=4.5e-08 nf=1 \
        as=2.34e-14 ad=6.24e-14 ps=9e-07 pd=1.1e-06 nrd=1.16667 \
        nrs=1.16667 sa=9.15e-07 sb=2e-06 sd=160n sca=11.8275 scb=0.0101379 \
        scc=0.000311481 m=(1)
mp1 (\15\:Y \8\:A1 4 VDD) g45p1hvt w=(3.9e-07) l=4.5e-08 nf=1 as=2.34e-14 \
        ad=6.24e-14 ps=9e-07 pd=1.1e-06 nrd=1.16667 nrs=1.16667 \
        sa=1.12e-06 sb=2e-06 sd=160n sca=11.8275 scb=0.0101379 \
        scc=0.000311481 m=(1)
mp0 (4 \11\:A0 \16\:VDD VDD) g45p1hvt w=(3.9e-07) l=4.5e-08 nf=1 \
        as=1.404e-13 ad=2.34e-14 ps=1.5e-06 pd=9e-07 nrd=1.16667 \
        nrs=1.16667 sa=1.225e-06 sb=2e-06 sd=160n sca=11.8275 \
        scb=0.0101379 scc=0.000311481 m=(1)
mp2_1__rcx (8 \1\:B0 \16\:VDD VDD) g45p1hvt w=(3.9e-07) l=4.5e-08 nf=1 \
        as=1.404e-13 ad=6.24e-14 ps=1.5e-06 pd=1.1e-06 nrd=1.16667 \
        nrs=1.16667 sa=1.63e-06 sb=2e-06 sd=160n sca=11.8275 scb=0.0101379 \
        scc=0.000311481 m=(1)
mp3_1__rcx (\13\:Y \6\:B1 8 VDD) g45p1hvt w=(3.9e-07) l=4.5e-08 nf=1 \
        as=6.24e-14 ad=6.24e-14 ps=1.1e-06 pd=1.1e-06 nrd=1.16667 \
        nrs=1.16667 sa=1.835e-06 sb=2e-06 sd=160n sca=11.8275 \
        scb=0.0101379 scc=0.000311481 m=(1)
mp3_2__rcx (\13\:Y \1\:B1 10 VDD) g45p1hvt w=(3.9e-07) l=4.5e-08 nf=1 \
        as=9.36e-14 ad=6.24e-14 ps=1.26e-06 pd=1.1e-06 nrd=1.16667 \
        nrs=1.16667 sa=2e-06 sb=2e-06 sd=160n sca=11.8275 scb=0.0101379 \
        scc=0.000311481 m=(1)
mp2_2__rcx (10 \9\:B0 \13\:VDD VDD) g45p1hvt w=(3.9e-07) l=4.5e-08 nf=1 \
        as=6.24e-14 ad=9.36e-14 ps=1.1e-06 pd=1.26e-06 nrd=1.16667 \
        nrs=1.16667 sa=2e-06 sb=2e-06 sd=160n sca=11.8275 scb=0.0101379 \
        scc=0.000311481 m=(1)
mp2_3__rcx (11 \4\:B0 \13\:VDD VDD) g45p1hvt w=(3.9e-07) l=4.5e-08 nf=1 \
        as=6.24e-14 ad=4.485e-14 ps=1.1e-06 pd=1.01e-06 nrd=1.16667 \
        nrs=1.16667 sa=2e-06 sb=2e-06 sd=160n sca=11.8275 scb=0.0101379 \
        scc=0.000311481 m=(1)
mp3_3__rcx (\11\:Y \12\:B1 11 VDD) g45p1hvt w=(3.9e-07) l=4.5e-08 nf=1 \
        as=4.485e-14 ad=6.24e-14 ps=1.01e-06 pd=1.1e-06 nrd=1.16667 \
        nrs=1.16667 sa=2e-06 sb=1.86e-06 sd=160n sca=11.8275 scb=0.0101379 \
        scc=0.000311481 m=(1)
mp3 (\11\:Y \7\:B1 12 VDD) g45p1hvt w=(3.9e-07) l=4.5e-08 nf=1 \
        as=3.315e-14 ad=6.24e-14 ps=9.5e-07 pd=1.1e-06 nrd=1.16667 \
        nrs=1.16667 sa=2e-06 sb=1.655e-06 sd=160n sca=11.8275 \
        scb=0.0101379 scc=0.000311481 m=(1)
mp2 (12 \12\:B0 \10\:VDD VDD) g45p1hvt w=(3.9e-07) l=4.5e-08 nf=1 \
        as=9.165e-14 ad=3.315e-14 ps=1.25e-06 pd=9.5e-07 nrd=1.16667 \
        nrs=1.16667 sa=2e-06 sb=1.525e-06 sd=160n sca=11.8275 \
        scb=0.0101379 scc=0.000311481 m=(1)
mp4_1__rcx (13 \1\:C0 \10\:VDD VDD) g45p1hvt w=(3.9e-07) l=4.5e-08 nf=1 \
        as=9.165e-14 ad=4.875e-14 ps=1.25e-06 pd=1.03e-06 nrd=1.16667 \
        nrs=1.16667 sa=2e-06 sb=1.245e-06 sd=160n sca=11.8275 \
        scb=0.0101379 scc=0.000311481 m=(1)
mp5_1__rcx (\9\:Y \4\:C1 13 VDD) g45p1hvt w=(3.9e-07) l=4.5e-08 nf=1 \
        as=4.875e-14 ad=6.24e-14 ps=1.03e-06 pd=1.1e-06 nrd=1.16667 \
        nrs=1.16667 sa=2e-06 sb=1.075e-06 sd=160n sca=11.8275 \
        scb=0.0101379 scc=0.000311481 m=(1)
mp5_2__rcx (\9\:Y \5\:C1 5 VDD) g45p1hvt w=(3.9e-07) l=4.5e-08 nf=1 \
        as=2.34e-14 ad=6.24e-14 ps=9e-07 pd=1.1e-06 nrd=1.16667 \
        nrs=1.16667 sa=2e-06 sb=8.7e-07 sd=160n sca=11.8275 scb=0.0101379 \
        scc=0.000311481 m=(1)
mp4_2__rcx (5 \7\:C0 \8\:VDD VDD) g45p1hvt w=(3.9e-07) l=4.5e-08 nf=1 \
        as=6.24e-14 ad=2.34e-14 ps=1.1e-06 pd=9e-07 nrd=1.16667 \
        nrs=1.16667 sa=2e-06 sb=7.65e-07 sd=160n sca=11.8275 scb=0.0101379 \
        scc=0.000311481 m=(1)
mp4_3__rcx (14 \9\:C0 \8\:VDD VDD) g45p1hvt w=(3.9e-07) l=4.5e-08 nf=1 \
        as=6.24e-14 ad=2.535e-14 ps=1.1e-06 pd=9.1e-07 nrd=1.16667 \
        nrs=1.16667 sa=2e-06 sb=5.6e-07 sd=160n sca=11.8465 scb=0.0101414 \
        scc=0.000311481 m=(1)
mp5_3__rcx (\7\:Y \10\:C1 14 VDD) g45p1hvt w=(3.9e-07) l=4.5e-08 nf=1 \
        as=2.535e-14 ad=6.24e-14 ps=9.1e-07 pd=1.1e-06 nrd=1.16667 \
        nrs=1.16667 sa=2e-06 sb=4.5e-07 sd=160n sca=12.099 scb=0.0102099 \
        scc=0.000311493 m=(1)
mp5 (\7\:Y \11\:C1 6 VDD) g45p1hvt w=(3.9e-07) l=4.5e-08 nf=1 as=2.34e-14 \
        ad=6.24e-14 ps=9e-07 pd=1.1e-06 nrd=1.16667 nrs=1.16667 sa=2e-06 \
        sb=2.45e-07 sd=160n sca=12.9282 scb=0.0107566 scc=0.000312107 \
        m=(1)
mp4 (6 \12\:C0 \6\:VDD VDD) g45p1hvt w=(3.9e-07) l=4.5e-08 nf=1 \
        as=5.46e-14 ad=2.34e-14 ps=1.06e-06 pd=9e-07 nrd=1.16667 \
        nrs=1.16667 sa=2e-06 sb=1.4e-07 sd=160n sca=13.7232 scb=0.0116925 \
        scc=0.000315829 m=(1)
C1 (B0 VSS) capacitor c=6.44304e-16
C2 (A1 VSS) capacitor c=2.44526e-17
C3 (C0 VSS) capacitor c=6.20326e-16
C4 (Y VSS) capacitor c=6.41326e-17
C5 (VDD VSS) capacitor c=3.45062e-16
C6 (B1 VSS) capacitor c=2.71976e-17
C7 (A0 VSS) capacitor c=6.13597e-16
C8 (C1 VSS) capacitor c=4.44969e-16
C9 (n1 VSS) capacitor c=3.5227e-16
C10 (n0 VSS) capacitor c=5.87896e-16
C11 (9 VSS) capacitor c=3.21829e-18
C12 (3 VSS) capacitor c=1.75543e-18
C13 (4 VSS) capacitor c=1.75543e-18
C14 (8 VSS) capacitor c=4.6408e-18
C15 (10 VSS) capacitor c=7.46821e-18
C16 (11 VSS) capacitor c=3.36458e-18
C17 (12 VSS) capacitor c=2.48686e-18
C18 (13 VSS) capacitor c=3.31694e-18
C19 (5 VSS) capacitor c=1.75543e-18
C20 (14 VSS) capacitor c=1.90172e-18
C21 (6 VSS) capacitor c=1.75543e-18
C22 (\12\:C0 VSS) capacitor c=6.32253e-17
C23 (\11\:C1 VSS) capacitor c=6.62765e-17
C24 (\10\:C1 VSS) capacitor c=6.93177e-17
C25 (\9\:C0 VSS) capacitor c=5.48324e-17
C26 (\7\:C0 VSS) capacitor c=7.6507e-17
C27 (\5\:C1 VSS) capacitor c=6.84183e-17
C28 (\4\:C1 VSS) capacitor c=4.12338e-17
C29 (\1\:C0 VSS) capacitor c=5.13034e-17
C30 (\12\:B0 VSS) capacitor c=6.11341e-17
C31 (\7\:B1 VSS) capacitor c=5.42273e-17
C32 (\12\:B1 VSS) capacitor c=4.41057e-17
C33 (\4\:B0 VSS) capacitor c=4.04035e-17
C34 (\9\:B0 VSS) capacitor c=2.43736e-17
C35 (\1\:B1 VSS) capacitor c=3.04721e-17
C36 (\6\:B1 VSS) capacitor c=3.75168e-17
C37 (\1\:B0 VSS) capacitor c=3.58647e-17
C38 (\11\:A0 VSS) capacitor c=7.07011e-17
C39 (\8\:A1 VSS) capacitor c=7.14395e-17
C40 (\13\:A1 VSS) capacitor c=6.84327e-17
C41 (\4\:A0 VSS) capacitor c=6.28469e-17
C42 (\9\:A0 VSS) capacitor c=3.73384e-17
C43 (\1\:A1 VSS) capacitor c=4.97332e-17
C44 (\4\:A1 VSS) capacitor c=6.72197e-17
C45 (\1\:A0 VSS) capacitor c=8.40745e-17
C46 (\2\:B1 VSS) capacitor c=4.05908e-16
C47 (\3\:A1 VSS) capacitor c=3.76251e-16
C48 (\6\:VDD VSS) capacitor c=2.1932e-17
C49 (\7\:Y VSS) capacitor c=1.13923e-16
C50 (\8\:VDD VSS) capacitor c=2.4484e-17
C51 (\9\:Y VSS) capacitor c=1.1624e-16
C52 (\10\:VDD VSS) capacitor c=2.88056e-17
C53 (\11\:Y VSS) capacitor c=1.4911e-16
C54 (\13\:VDD VSS) capacitor c=2.69738e-17
C55 (\13\:Y VSS) capacitor c=1.39602e-16
C56 (\16\:VDD VSS) capacitor c=3.35013e-17
C57 (\15\:Y VSS) capacitor c=1.38729e-16
C58 (\20\:VDD VSS) capacitor c=2.49136e-17
C59 (\17\:Y VSS) capacitor c=7.32097e-17
C60 (\23\:VDD VSS) capacitor c=1.32896e-17
C61 (\1\:VDD VSS) capacitor c=5.15938e-17
C62 (\1\:Y VSS) capacitor c=3.08671e-16
C63 (\9\:n1 VSS) capacitor c=2.66144e-16
C64 (\2\:A1 VSS) capacitor c=5.51129e-17
C65 (\3\:VDD VSS) capacitor c=1.52686e-17
C66 (\4\:VDD VSS) capacitor c=2.80189e-17
C67 (\12\:VDD VSS) capacitor c=3.68087e-17
C68 (\15\:VDD VSS) capacitor c=3.09736e-17
C69 (\19\:VDD VSS) capacitor c=1.43222e-17
C70 (\22\:VDD VSS) capacitor c=1.95088e-17
Rk3 (\3\:A1 A1) resistor r=0.009916 c=0
Rk61 (\2\:VSS \3\:VSS) resistor r=0.7513 c=0
Rk68 (\4\:VSS VSS) resistor r=0.02209 c=0
Rk62 (\3\:VSS \4\:VSS) resistor r=0.9089 c=0
Rk29 (\1\:Y Y) resistor r=0.1729 c=0
Rk30 (Y \8\:Y) resistor r=0.5304 c=0
Rk31 (\8\:Y \10\:Y) resistor r=0.4577 c=0
Rk32 (\10\:Y \12\:Y) resistor r=0.5482 c=0
Rk33 (\12\:Y \14\:Y) resistor r=0.627 c=0
Rk34 (\14\:Y \16\:Y) resistor r=0.6475 c=0
Rk35 (\16\:Y \18\:Y) resistor r=0.4908 c=0
Rk45 (\2\:VDD \3\:VDD) resistor r=0.07995 c=0
Rk46 (\3\:VDD \4\:VDD) resistor r=0.3127 c=0
Rk47 (\4\:VDD \5\:VDD) resistor r=0.3579 c=0
Rk48 (\3\:VDD \7\:VDD) resistor r=0.1846 c=0
Rk49 (\4\:VDD \9\:VDD) resistor r=0.1846 c=0
Rk50 (\5\:VDD \11\:VDD) resistor r=0.2307 c=0
Rk51 (\5\:VDD \12\:VDD) resistor r=0.3736 c=0
Rk52 (\12\:VDD \14\:VDD) resistor r=0.1846 c=0
Rk53 (\12\:VDD \15\:VDD) resistor r=0.5506 c=0
Rk54 (\15\:VDD \17\:VDD) resistor r=0.1846 c=0
Rk55 (\15\:VDD \18\:VDD) resistor r=0.2778 c=0
Rk56 (\18\:VDD \19\:VDD) resistor r=0.03236 c=0
Rk57 (\19\:VDD \21\:VDD) resistor r=0.1846 c=0
Rk60 (\22\:VDD VDD) resistor r=0.1974 c=0
Rk58 (\19\:VDD \22\:VDD) resistor r=0.3202 c=0
Rk59 (\22\:VDD \24\:VDD) resistor r=0.1892 c=0
Rk9 (\2\:B1 B1) resistor r=0.01977 c=0
Rk13 (n1 \9\:n1) resistor r=0.4089 c=0
Rl40 (B0 \12\:B0) resistor r=70.3297 c=0
Rl29 (B0 \4\:B0) resistor r=67.2856 c=0
Rl33 (B0 \9\:B0) resistor r=22.4021 c=0
Rl22 (B0 \1\:B0) resistor r=29.5379 c=0
Rl15 (\3\:A1 \8\:A1) resistor r=119.539 c=0
Rl19 (\3\:A1 \13\:A1) resistor r=87.4359 c=0
Rl3 (\2\:A1 \1\:A1) resistor r=124.484 c=0
Rl5 (\2\:A1 \4\:A1) resistor r=80.3332 c=0
Rl4 (\2\:A1 \3\:A1) resistor r=3.9095 c=0
Rl58 (C0 \12\:C0) resistor r=24.7951 c=0
Rl51 (C0 \9\:C0) resistor r=28.7343 c=0
Rl49 (C0 \7\:C0) resistor r=74.6548 c=0
Rl41 (C0 \1\:C0) resistor r=64.1533 c=0
Rl34 (\2\:B1 \7\:B1) resistor r=83.8489 c=0
Rl38 (\2\:B1 \12\:B1) resistor r=83.4251 c=0
Rl24 (\2\:B1 \1\:B1) resistor r=83.4251 c=0
Rl28 (\2\:B1 \6\:B1) resistor r=83.8489 c=0
Rl20 (A0 \11\:A0) resistor r=69.9225 c=0
Rl9 (A0 \4\:A0) resistor r=67.9002 c=0
Rl13 (A0 \9\:A0) resistor r=33.6242 c=0
Rl1 (A0 \1\:A0) resistor r=119.208 c=0
Rl56 (C1 \11\:C1) resistor r=75.2936 c=0
Rl55 (C1 \10\:C1) resistor r=120.873 c=0
Rl46 (C1 \5\:C1) resistor r=94.6378 c=0
Rl45 (C1 \4\:C1) resistor r=114.708 c=0
Rz22 (\1\:VDD \2\:VDD) resistor r=25 c=0
Rz23 (\1\:VDD \5\:VDD) resistor r=6.25 c=0
Rz24 (\1\:VDD \18\:VDD) resistor r=6.25 c=0
Ry14 (\2\:VSS \1\:VSS) resistor r=20.6667 c=0
Ry15 (\3\:VSS \1\:VSS) resistor r=5.1667 c=0
Ry16 (\4\:VSS \1\:VSS) resistor r=5.1667 c=0
Ry1 (\8\:Y \7\:Y) resistor r=62 c=0
Ry2 (\10\:Y \9\:Y) resistor r=62 c=0
Ry3 (\12\:Y \11\:Y) resistor r=62 c=0
Ry4 (\14\:Y \13\:Y) resistor r=62 c=0
Ry5 (\16\:Y \15\:Y) resistor r=62 c=0
Ry6 (\18\:Y \17\:Y) resistor r=62 c=0
Ry7 (\6\:VDD \7\:VDD) resistor r=62 c=0
Ry8 (\8\:VDD \9\:VDD) resistor r=62 c=0
Ry9 (\10\:VDD \11\:VDD) resistor r=62 c=0
Ry10 (\13\:VDD \14\:VDD) resistor r=62 c=0
Ry11 (\16\:VDD \17\:VDD) resistor r=62 c=0
Ry12 (\20\:VDD \21\:VDD) resistor r=62 c=0
Ry13 (\23\:VDD \24\:VDD) resistor r=62 c=0
mn0_1__rcx (\9\:n1 A0 \4\:VSS VSS) g45n1hvt w=(2.6e-07) l=4.5e-08 nf=1 \
        as=3.9e-14 ad=4.16e-14 ps=8.2e-07 pd=8.4e-07 nrd=1.16667 \
        nrs=1.16667 sa=1.4e-07 sb=1.575e-06 sd=160n sca=16.9678 \
        scb=0.0167861 scc=0.00150639 m=(4)
mn1_1__rcx (\9\:n1 \3\:A1 \4\:VSS VSS) g45n1hvt w=(2.6e-07) l=4.5e-08 \
        nf=1 as=4.16e-14 ad=4.16e-14 ps=8.4e-07 pd=8.4e-07 nrd=1.16667 \
        nrs=1.16667 sa=3.45e-07 sb=1.37e-06 sd=160n sca=16.9678 \
        scb=0.0167861 scc=0.00150639 m=(4)
mn4_1__rcx (\1\:Y C0 n0 VSS) g45n1hvt w=(2.6e-07) l=4.5e-08 nf=1 \
        as=4.03e-14 ad=4.16e-14 ps=8.3e-07 pd=8.4e-07 nrd=1.16667 \
        nrs=1.16667 sa=1.815e-06 sb=1.575e-06 sd=160n sca=16.9678 \
        scb=0.0167861 scc=0.00150639 m=(4)
mn5_1__rcx (\1\:Y C1 n0 VSS) g45n1hvt w=(2.6e-07) l=4.5e-08 nf=1 \
        as=4.16e-14 ad=4.16e-14 ps=8.4e-07 pd=8.4e-07 nrd=1.16667 \
        nrs=1.16667 sa=2e-06 sb=1.37e-06 sd=160n sca=16.9678 scb=0.0167861 \
        scc=0.00150639 m=(4)
mn2_1__rcx (n0 B0 n1 VSS) g45n1hvt w=(2.6e-07) l=4.5e-08 nf=1 \
        as=4.388e-14 ad=4.03e-14 ps=8.575e-07 pd=8.3e-07 nrd=1.16667 \
        nrs=1.16667 sa=1.4e-07 sb=2e-06 sd=160n sca=16.9678 scb=0.0167861 \
        scc=0.00150639 m=(4)
mn3_1__rcx (n0 \2\:B1 n1 VSS) g45n1hvt w=(2.6e-07) l=4.5e-08 nf=1 \
        as=4.388e-14 ad=4.16e-14 ps=8.575e-07 pd=8.4e-07 nrd=1.16667 \
        nrs=1.16667 sa=3.45e-07 sb=2e-06 sd=160n sca=16.9678 scb=0.0167861 \
        scc=0.00150639 m=(4)
ends OAI222X4
// End of subcircuit definition.
