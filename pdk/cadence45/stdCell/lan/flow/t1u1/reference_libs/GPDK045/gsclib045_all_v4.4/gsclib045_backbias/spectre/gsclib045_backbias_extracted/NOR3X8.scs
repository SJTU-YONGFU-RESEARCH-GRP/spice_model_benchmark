// Generated for: spectre (May  1 11:30:55 2013 )
// Library name: gsclib045_backbias
// Cell name: NOR3X8
// View name: extracted

simulator lang=spectre

subckt NOR3X8 A B C NW VDD VSS Y
mp0_1__rcx (2 \1\:A \1\:VDD NW) g45p1svt w=(4.45e-07) l=4.5e-08 nf=1 \
        as=6.23e-14 ad=2.67e-14 ps=1.17e-06 pd=1.01e-06 nrd=1.16667 \
        nrs=1.16667 sa=1.4e-07 sb=2e-06 sd=160n sca=31.7728 scb=0.0232209 \
        scc=0.00300084 m=(1)
mp1_1__rcx (2 \1\:B 7 NW) g45p1svt w=(4.45e-07) l=4.5e-08 nf=1 \
        as=1.691e-13 ad=2.67e-14 ps=1.65e-06 pd=1.01e-06 nrd=1.16667 \
        nrs=1.16667 sa=2.45e-07 sb=2e-06 sd=160n sca=30.1491 scb=0.0205231 \
        scc=0.00295848 m=(1)
mp2_1__rcx (\30\:Y \6\:C 7 NW) g45p1svt w=(4.45e-07) l=4.5e-08 nf=1 \
        as=1.691e-13 ad=7.12e-14 ps=1.65e-06 pd=1.21e-06 nrd=1.16667 \
        nrs=1.16667 sa=6.7e-07 sb=2e-06 sd=160n sca=28.0095 scb=0.0185345 \
        scc=0.00295096 m=(1)
mp2_2__rcx (\30\:Y \1\:C 3 NW) g45p1svt w=(4.45e-07) l=4.5e-08 nf=1 \
        as=2.67e-14 ad=7.12e-14 ps=1.01e-06 pd=1.21e-06 nrd=1.16667 \
        nrs=1.16667 sa=8.75e-07 sb=2e-06 sd=160n sca=27.9404 scb=0.0185207 \
        scc=0.00295096 m=(1)
mp1_2__rcx (3 \4\:B 9 NW) g45p1svt w=(4.45e-07) l=4.5e-08 nf=1 \
        as=7.12e-14 ad=2.67e-14 ps=1.21e-06 pd=1.01e-06 nrd=1.16667 \
        nrs=1.16667 sa=9.8e-07 sb=2e-06 sd=160n sca=27.9404 scb=0.0185207 \
        scc=0.00295096 m=(1)
mp0_2__rcx (9 \10\:A \6\:VDD NW) g45p1svt w=(4.45e-07) l=4.5e-08 nf=1 \
        as=7.12e-14 ad=7.12e-14 ps=1.21e-06 pd=1.21e-06 nrd=1.16667 \
        nrs=1.16667 sa=1.185e-06 sb=2e-06 sd=160n sca=27.9404 \
        scb=0.0185207 scc=0.00295096 m=(1)
mp0_3__rcx (11 \9\:A \6\:VDD NW) g45p1svt w=(4.45e-07) l=4.5e-08 nf=1 \
        as=7.12e-14 ad=9.79e-14 ps=1.21e-06 pd=1.33e-06 nrd=1.16667 \
        nrs=1.16667 sa=1.39e-06 sb=2e-06 sd=160n sca=27.9404 scb=0.0185207 \
        scc=0.00295096 m=(1)
mp1_3__rcx (11 \7\:B 12 NW) g45p1svt w=(4.45e-07) l=4.5e-08 nf=1 \
        as=9.79e-14 ad=9.79e-14 ps=1.33e-06 pd=1.33e-06 nrd=1.16667 \
        nrs=1.16667 sa=1.655e-06 sb=2e-06 sd=160n sca=27.9404 \
        scb=0.0185207 scc=0.00295096 m=(1)
mp2_3__rcx (\28\:Y \12\:C 12 NW) g45p1svt w=(4.45e-07) l=4.5e-08 nf=1 \
        as=9.79e-14 ad=7.12e-14 ps=1.33e-06 pd=1.21e-06 nrd=1.16667 \
        nrs=1.16667 sa=1.92e-06 sb=2e-06 sd=160n sca=27.9404 scb=0.0185207 \
        scc=0.00295096 m=(1)
mp2_4__rcx (\28\:Y \7\:C 13 NW) g45p1svt w=(4.45e-07) l=4.5e-08 nf=1 \
        as=9.79e-14 ad=7.12e-14 ps=1.33e-06 pd=1.21e-06 nrd=1.16667 \
        nrs=1.16667 sa=2e-06 sb=2e-06 sd=160n sca=27.9404 scb=0.0185207 \
        scc=0.00295096 m=(1)
mp1_4__rcx (13 \10\:B 10 NW) g45p1svt w=(4.45e-07) l=4.5e-08 nf=1 \
        as=7.12e-14 ad=9.79e-14 ps=1.21e-06 pd=1.33e-06 nrd=1.16667 \
        nrs=1.16667 sa=2e-06 sb=2e-06 sd=160n sca=27.9404 scb=0.0185207 \
        scc=0.00295096 m=(1)
mp0_4__rcx (10 \17\:A \9\:VDD NW) g45p1svt w=(4.45e-07) l=4.5e-08 nf=1 \
        as=7.12e-14 ad=7.12e-14 ps=1.21e-06 pd=1.21e-06 nrd=1.16667 \
        nrs=1.16667 sa=2e-06 sb=2e-06 sd=160n sca=27.9404 scb=0.0185207 \
        scc=0.00295096 m=(1)
mp0_5__rcx (14 \15\:A \9\:VDD NW) g45p1svt w=(4.45e-07) l=4.5e-08 nf=1 \
        as=7.12e-14 ad=7.342e-14 ps=1.21e-06 pd=1.22e-06 nrd=1.16667 \
        nrs=1.16667 sa=2e-06 sb=1.92e-06 sd=160n sca=27.9404 scb=0.0185207 \
        scc=0.00295096 m=(1)
mp1_5__rcx (14 \15\:B 8 NW) g45p1svt w=(4.45e-07) l=4.5e-08 nf=1 \
        as=1.691e-13 ad=7.343e-14 ps=1.65e-06 pd=1.22e-06 nrd=1.16667 \
        nrs=1.16667 sa=2e-06 sb=1.71e-06 sd=160n sca=27.9404 scb=0.0185207 \
        scc=0.00295096 m=(1)
mp2_5__rcx (\26\:Y \18\:C 8 NW) g45p1svt w=(4.45e-07) l=4.5e-08 nf=1 \
        as=1.691e-13 ad=7.12e-14 ps=1.65e-06 pd=1.21e-06 nrd=1.16667 \
        nrs=1.16667 sa=2e-06 sb=1.285e-06 sd=160n sca=27.9404 \
        scb=0.0185207 scc=0.00295096 m=(1)
mp2_6__rcx (\26\:Y \13\:C 15 NW) g45p1svt w=(4.45e-07) l=4.5e-08 nf=1 \
        as=5.118e-14 ad=7.12e-14 ps=1.12e-06 pd=1.21e-06 nrd=1.16667 \
        nrs=1.16667 sa=2e-06 sb=1.08e-06 sd=160n sca=27.9404 scb=0.0185207 \
        scc=0.00295096 m=(1)
mp1_6__rcx (15 \16\:B 16 NW) g45p1svt w=(4.45e-07) l=4.5e-08 nf=1 \
        as=8.232e-14 ad=5.118e-14 ps=1.26e-06 pd=1.12e-06 nrd=1.16667 \
        nrs=1.16667 sa=2e-06 sb=9.2e-07 sd=160n sca=27.9404 scb=0.0185207 \
        scc=0.00295096 m=(1)
mp0_6__rcx (16 \24\:A \11\:VDD NW) g45p1svt w=(4.45e-07) l=4.5e-08 nf=1 \
        as=7.12e-14 ad=8.232e-14 ps=1.21e-06 pd=1.26e-06 nrd=1.16667 \
        nrs=1.16667 sa=2e-06 sb=6.9e-07 sd=160n sca=28.0414 scb=0.0185419 \
        scc=0.00295096 m=(1)
mp0 (17 \22\:A \11\:VDD NW) g45p1svt w=(4.45e-07) l=4.5e-08 nf=1 \
        as=7.12e-14 ad=8.677e-14 ps=1.21e-06 pd=1.28e-06 nrd=1.16667 \
        nrs=1.16667 sa=2e-06 sb=4.85e-07 sd=160n sca=28.6826 scb=0.0188419 \
        scc=0.00295113 m=(1)
mp1 (17 \19\:B 4 NW) g45p1svt w=(4.45e-07) l=4.5e-08 nf=1 as=2.67e-14 \
        ad=8.677e-14 ps=1.01e-06 pd=1.28e-06 nrd=1.16667 nrs=1.16667 \
        sa=2e-06 sb=2.45e-07 sd=160n sca=30.5839 scb=0.0211973 \
        scc=0.00296515 m=(1)
mp2 (\2\:Y \21\:C 4 NW) g45p1svt w=(4.45e-07) l=4.5e-08 nf=1 as=2.67e-14 \
        ad=6.23e-14 ps=1.01e-06 pd=1.17e-06 nrd=1.16667 nrs=1.16667 \
        sa=2e-06 sb=1.4e-07 sd=160n sca=32.6015 scb=0.02469 scc=0.00304367 \
        m=(1)
C1 (NW VSS) capacitor c=5.70029e-16
C2 (Y VSS) capacitor c=1.42476e-17
C3 (C VSS) capacitor c=1.41207e-15
C4 (B VSS) capacitor c=1.47364e-15
C5 (A VSS) capacitor c=2.0633e-17
C6 (VDD VSS) capacitor c=3.05463e-17
C7 (7 VSS) capacitor c=1.49425e-17
C8 (3 VSS) capacitor c=2.8629e-18
C9 (9 VSS) capacitor c=9.10285e-18
C10 (11 VSS) capacitor c=1.16539e-17
C11 (12 VSS) capacitor c=1.29223e-17
C12 (13 VSS) capacitor c=1.29409e-17
C13 (10 VSS) capacitor c=9.14969e-18
C14 (14 VSS) capacitor c=9.69562e-18
C15 (8 VSS) capacitor c=2.17145e-17
C16 (15 VSS) capacitor c=5.56191e-18
C17 (16 VSS) capacitor c=7.93447e-18
C18 (17 VSS) capacitor c=6.50893e-18
C19 (4 VSS) capacitor c=2.79218e-18
C20 (\21\:C VSS) capacitor c=8.01445e-17
C21 (\19\:B VSS) capacitor c=8.83086e-17
C22 (\22\:A VSS) capacitor c=3.33517e-17
C23 (\24\:A VSS) capacitor c=2.67902e-17
C24 (\16\:B VSS) capacitor c=6.60046e-17
C25 (\13\:C VSS) capacitor c=4.96135e-17
C26 (\18\:C VSS) capacitor c=2.6451e-17
C27 (\15\:B VSS) capacitor c=4.62828e-17
C28 (\15\:A VSS) capacitor c=3.5765e-17
C29 (\17\:A VSS) capacitor c=2.745e-17
C30 (\10\:B VSS) capacitor c=5.256e-17
C31 (\7\:C VSS) capacitor c=3.24969e-17
C32 (\12\:C VSS) capacitor c=3.22601e-17
C33 (\7\:B VSS) capacitor c=4.70365e-17
C34 (\9\:A VSS) capacitor c=2.47841e-17
C35 (\10\:A VSS) capacitor c=3.51364e-17
C36 (\4\:B VSS) capacitor c=9.17205e-17
C37 (\1\:C VSS) capacitor c=7.63308e-17
C38 (\6\:C VSS) capacitor c=2.65853e-17
C39 (\1\:B VSS) capacitor c=7.70808e-17
C40 (\1\:A VSS) capacitor c=6.69994e-17
C41 (\2\:A VSS) capacitor c=1.32106e-15
C42 (\2\:Y VSS) capacitor c=7.48198e-17
C43 (\11\:VDD VSS) capacitor c=2.00979e-16
C44 (\26\:Y VSS) capacitor c=2.21937e-16
C45 (\9\:VDD VSS) capacitor c=4.3509e-17
C46 (\28\:Y VSS) capacitor c=2.44076e-16
C47 (\6\:VDD VSS) capacitor c=4.67535e-17
C48 (\30\:Y VSS) capacitor c=1.37164e-16
C49 (\1\:VDD VSS) capacitor c=4.14802e-17
C50 (\4\:Y VSS) capacitor c=9.95499e-16
C51 (\1\:Y VSS) capacitor c=4.88207e-17
C52 (\3\:VDD VSS) capacitor c=6.79435e-17
C53 (\5\:VDD VSS) capacitor c=1.3222e-16
C54 (\8\:VDD VSS) capacitor c=1.55344e-16
Rk20 (Y \1\:Y) resistor r=0.0235 c=0
Rk22 (\1\:Y \4\:Y) resistor r=0.4843 c=0
Rk21 (\1\:Y \3\:Y) resistor r=0.07709 c=0
Rk33 (\3\:Y \27\:Y) resistor r=0.8154 c=0
Rk34 (\27\:Y \29\:Y) resistor r=1.1238 c=0
Rk35 (\29\:Y \31\:Y) resistor r=0.9267 c=0
Rk49 (\1\:VSS VSS) resistor r=0.04721 c=0
Rk3 (\2\:A A) resistor r=0.01663 c=0
Rk62 (\3\:VDD VDD) resistor r=0.09737 c=0
Rk61 (\2\:VDD \3\:VDD) resistor r=0.2648 c=0
Rk63 (\2\:VDD \4\:VDD) resistor r=0.1539 c=0
Rk64 (\3\:VDD \5\:VDD) resistor r=0.6116 c=0
Rk65 (\5\:VDD \7\:VDD) resistor r=0.2601 c=0
Rk66 (\5\:VDD \8\:VDD) resistor r=0.7069 c=0
Rk67 (\8\:VDD \10\:VDD) resistor r=0.2601 c=0
Rk68 (\8\:VDD \12\:VDD) resistor r=1.0149 c=0
Rl51 (C \21\:C) resistor r=83.0212 c=0
Rl35 (C \13\:C) resistor r=122.34 c=0
Rl39 (C \18\:C) resistor r=85.7463 c=0
Rl20 (C \7\:C) resistor r=85.7713 c=0
Rl24 (C \12\:C) resistor r=87.6951 c=0
Rl5 (C \1\:C) resistor r=110.155 c=0
Rl9 (C \6\:C) resistor r=84.1998 c=0
Rl48 (B \19\:B) resistor r=81.461 c=0
Rl40 (B \16\:B) resistor r=83.3841 c=0
Rl34 (B \15\:B) resistor r=83.7912 c=0
Rl25 (B \10\:B) resistor r=83.3841 c=0
Rl18 (B \7\:B) resistor r=75.6918 c=0
Rl10 (B \4\:B) resistor r=83.3841 c=0
Rl3 (B \1\:B) resistor r=62.2302 c=0
Rl45 (\2\:A \22\:A) resistor r=93.9123 c=0
Rl47 (\2\:A \24\:A) resistor r=24.2328 c=0
Rl30 (\2\:A \15\:A) resistor r=93.9123 c=0
Rl32 (\2\:A \17\:A) resistor r=24.848 c=0
Rl16 (\2\:A \9\:A) resistor r=24.2328 c=0
Rl17 (\2\:A \10\:A) resistor r=99.2335 c=0
Rl1 (\2\:A \1\:A) resistor r=30.5087 c=0
Ry1 (\3\:Y \2\:Y) resistor r=20.6667 c=0
Ry2 (\27\:Y \26\:Y) resistor r=62 c=0
Ry3 (\29\:Y \28\:Y) resistor r=62 c=0
Ry4 (\31\:Y \30\:Y) resistor r=62 c=0
Ry8 (\1\:VDD \2\:VDD) resistor r=62 c=0
Ry9 (\1\:VDD \4\:VDD) resistor r=62 c=0
Ry10 (\6\:VDD \7\:VDD) resistor r=62 c=0
Ry11 (\9\:VDD \10\:VDD) resistor r=62 c=0
Ry12 (\11\:VDD \12\:VDD) resistor r=62 c=0
mn0_1__rcx (\4\:Y \2\:A \1\:VSS VSS) g45n1svt w=(2.95e-07) l=4.5e-08 \
        nf=1 as=7.85e-14 ad=4.72e-14 ps=1.29e-06 pd=9.1e-07 nrd=1.16667 \
        nrs=1.16667 sa=1.4e-07 sb=2e-06 sd=160n sca=8.89726 scb=0.00719534 \
        scc=0.00020576 m=(7)
mn1_1__rcx (\4\:Y B \1\:VSS VSS) g45n1svt w=(2.95e-07) l=4.5e-08 nf=1 \
        as=8.47e-14 ad=4.72e-14 ps=1.36e-06 pd=9.1e-07 nrd=1.16667 \
        nrs=1.16667 sa=3.45e-07 sb=2e-06 sd=160n sca=8.89726 \
        scb=0.00719534 scc=0.00020576 m=(7)
mn2_1__rcx (\4\:Y C \1\:VSS VSS) g45n1svt w=(2.95e-07) l=4.5e-08 nf=1 \
        as=8.47e-14 ad=4.636e-14 ps=1.36e-06 pd=9.0429e-07 nrd=1.16667 \
        nrs=1.16667 sa=6.1e-07 sb=2e-06 sd=160n sca=8.89726 scb=0.00719534 \
        scc=0.00020576 m=(7)
ends NOR3X8
// End of subcircuit definition.
