// Generated for: spectre (May  1 09:17:38 2013 )
// Library name: gsclib045_hvt
// Cell name: NAND3X8
// View name: extracted

simulator lang=spectre

subckt NAND3X8 A B C VDD VSS Y
mp0_1__rcx (\3\:Y A \1\:VDD VDD) g45p1hvt w=(4.45e-07) l=4.5e-08 nf=1 \
        as=6.993e-14 ad=7.565e-14 ps=1.20429e-06 pd=1.23e-06 nrd=1.16667 \
        nrs=1.16667 sa=1.4e-07 sb=2e-06 sd=160n sca=23.275 scb=0.0264752 \
        scc=0.0013153 m=(7)
mp1_1__rcx (\3\:Y B \1\:VDD VDD) g45p1hvt w=(4.45e-07) l=4.5e-08 nf=1 \
        as=7.374e-14 ad=7.565e-14 ps=1.22143e-06 pd=1.23e-06 nrd=1.16667 \
        nrs=1.16667 sa=3.8e-07 sb=2e-06 sd=160n sca=15.6896 scb=0.014147 \
        scc=0.000596665 m=(7)
mp2_1__rcx (\3\:Y C \1\:VDD VDD) g45p1hvt w=(4.45e-07) l=4.5e-08 nf=1 \
        as=7.374e-14 ad=6.993e-14 ps=1.22143e-06 pd=1.20429e-06 \
        nrd=1.16667 nrs=1.16667 sa=5.85e-07 sb=2e-06 sd=160n sca=14.0773 \
        scb=0.0121711 scc=0.000586094 m=(7)
C1 (A VSS) capacitor c=1.30975e-15
C2 (VDD VSS) capacitor c=2.36501e-16
C3 (C VSS) capacitor c=1.37262e-15
C4 (Y VSS) capacitor c=3.98845e-17
C5 (B VSS) capacitor c=1.59415e-15
C6 (9 VSS) capacitor c=5.22845e-18
C7 (10 VSS) capacitor c=2.74606e-18
C8 (11 VSS) capacitor c=1.00667e-17
C9 (12 VSS) capacitor c=5.54197e-18
C10 (13 VSS) capacitor c=1.22378e-17
C11 (14 VSS) capacitor c=8.85504e-18
C12 (15 VSS) capacitor c=2.77099e-18
C13 (16 VSS) capacitor c=1.07273e-17
C14 (17 VSS) capacitor c=7.95323e-18
C15 (18 VSS) capacitor c=7.30018e-18
C16 (19 VSS) capacitor c=7.8426e-18
C17 (20 VSS) capacitor c=3.43879e-18
C18 (\21\:C VSS) capacitor c=5.7337e-17
C19 (\22\:B VSS) capacitor c=6.31065e-17
C20 (\20\:A VSS) capacitor c=4.40016e-17
C21 (\19\:A VSS) capacitor c=4.05076e-17
C22 (\18\:B VSS) capacitor c=4.32792e-17
C23 (\17\:C VSS) capacitor c=2.60189e-17
C24 (\16\:C VSS) capacitor c=1.96871e-17
C25 (\15\:B VSS) capacitor c=5.92851e-17
C26 (\10\:A VSS) capacitor c=6.39994e-17
C27 (\13\:A VSS) capacitor c=3.682e-17
C28 (\12\:B VSS) capacitor c=3.57027e-17
C29 (\11\:C VSS) capacitor c=1.85724e-17
C30 (\10\:C VSS) capacitor c=3.25302e-17
C31 (\9\:B VSS) capacitor c=4.27846e-17
C32 (\7\:A VSS) capacitor c=3.51885e-17
C33 (\8\:A VSS) capacitor c=6.84297e-17
C34 (\6\:B VSS) capacitor c=7.09512e-17
C35 (\1\:C VSS) capacitor c=2.95968e-17
C36 (\4\:C VSS) capacitor c=1.94813e-17
C37 (\3\:B VSS) capacitor c=7.02686e-17
C38 (\1\:A VSS) capacitor c=6.17758e-17
C39 (\1\:VDD VSS) capacitor c=6.01602e-16
C40 (\1\:Y VSS) capacitor c=1.45017e-16
C41 (\6\:Y VSS) capacitor c=2.17488e-16
C42 (\8\:Y VSS) capacitor c=2.12693e-16
C43 (\10\:Y VSS) capacitor c=1.23838e-16
C44 (\3\:Y VSS) capacitor c=9.71256e-16
Rk36 (\1\:VDD VDD) resistor r=0.01963 c=0
Rk58 (\2\:VSS \4\:VSS) resistor r=0.2028 c=0
Rk59 (\4\:VSS \5\:VSS) resistor r=0.4481 c=0
Rk60 (\5\:VSS \6\:VSS) resistor r=0.6853 c=0
Rk61 (\6\:VSS \7\:VSS) resistor r=0.06661 c=0
Rk63 (\8\:VSS VSS) resistor r=0.08739 c=0
Rk62 (\7\:VSS \8\:VSS) resistor r=0.4641 c=0
Rk64 (\5\:VSS \10\:VSS) resistor r=0.04335 c=0
Rk65 (\6\:VSS \12\:VSS) resistor r=0.04335 c=0
Rk66 (\8\:VSS \14\:VSS) resistor r=0.2659 c=0
Rk19 (\2\:Y Y) resistor r=0.5124 c=0
Rk20 (Y \3\:Y) resistor r=0.0144 c=0
Rk22 (\2\:Y \7\:Y) resistor r=0.8662 c=0
Rk23 (\7\:Y \9\:Y) resistor r=0.9783 c=0
Rk24 (\9\:Y \11\:Y) resistor r=0.8532 c=0
Rl43 (A \20\:A) resistor r=85.772 c=0
Rl42 (A \19\:A) resistor r=83.8482 c=0
Rl26 (A \10\:A) resistor r=99.9779 c=0
Rl28 (A \13\:A) resistor r=83.8482 c=0
Rl14 (A \7\:A) resistor r=84.7767 c=0
Rl15 (A \8\:A) resistor r=118.346 c=0
Rl1 (A \1\:A) resistor r=74.5443 c=0
Rl49 (C \21\:C) resistor r=45.4267 c=0
Rl36 (C \17\:C) resistor r=47.3105 c=0
Rl35 (C \16\:C) resistor r=24.2328 c=0
Rl22 (C \11\:C) resistor r=22.4021 c=0
Rl21 (C \10\:C) resistor r=67.2856 c=0
Rl5 (C \1\:C) resistor r=34.2718 c=0
Rl7 (C \4\:C) resistor r=23.7402 c=0
Rl47 (B \22\:B) resistor r=34.3295 c=0
Rl39 (B \18\:B) resistor r=29.5379 c=0
Rl32 (B \15\:B) resistor r=26.098 c=0
Rl25 (B \12\:B) resistor r=29.5379 c=0
Rl18 (B \9\:B) resistor r=29.5379 c=0
Rl11 (B \6\:B) resistor r=35.3072 c=0
Rl4 (B \3\:B) resistor r=81.461 c=0
Rz7 (\1\:VSS \2\:VSS) resistor r=75 c=0
Rz8 (\9\:VSS \10\:VSS) resistor r=75 c=0
Rz9 (\11\:VSS \12\:VSS) resistor r=75 c=0
Rz10 (\13\:VSS \14\:VSS) resistor r=75 c=0
Rz1 (\2\:Y \1\:Y) resistor r=75 c=0
Rz2 (\7\:Y \6\:Y) resistor r=75 c=0
Rz3 (\9\:Y \8\:Y) resistor r=75 c=0
Rz4 (\11\:Y \10\:Y) resistor r=75 c=0
Ry23 (\3\:VSS \4\:VSS) resistor r=5.1667 c=0
Ry24 (\3\:VSS \7\:VSS) resistor r=5.1667 c=0
mn0_1__rcx (7 \1\:A \13\:VSS VSS) g45n1hvt w=(2.95e-07) l=4.5e-08 nf=1 \
        as=4.13e-14 ad=1.77e-14 ps=8.7e-07 pd=7.1e-07 nrd=1.16667 \
        nrs=1.16667 sa=1.4e-07 sb=2e-06 sd=160n sca=16.4223 scb=0.0158966 \
        scc=0.0014413 m=(1)
mn1_1__rcx (7 \3\:B 8 VSS) g45n1hvt w=(2.95e-07) l=4.5e-08 nf=1 \
        as=6.047e-14 ad=1.77e-14 ps=1e-06 pd=7.1e-07 nrd=1.16667 \
        nrs=1.16667 sa=2.45e-07 sb=2e-06 sd=160n sca=16.4223 scb=0.0158966 \
        scc=0.0014413 m=(1)
mn2_1__rcx (\10\:Y \4\:C 8 VSS) g45n1hvt w=(2.95e-07) l=4.5e-08 nf=1 \
        as=6.047e-14 ad=4.72e-14 ps=1e-06 pd=9.1e-07 nrd=1.16667 \
        nrs=1.16667 sa=4.95e-07 sb=2e-06 sd=160n sca=16.4223 scb=0.0158966 \
        scc=0.0014413 m=(1)
mn2_2__rcx (\10\:Y \1\:C 9 VSS) g45n1hvt w=(2.95e-07) l=4.5e-08 nf=1 \
        as=3.393e-14 ad=4.72e-14 ps=8.2e-07 pd=9.1e-07 nrd=1.16667 \
        nrs=1.16667 sa=7e-07 sb=2e-06 sd=160n sca=16.4223 scb=0.0158966 \
        scc=0.0014413 m=(1)
mn1_2__rcx (9 \6\:B 10 VSS) g45n1hvt w=(2.95e-07) l=4.5e-08 nf=1 \
        as=1.77e-14 ad=3.393e-14 ps=7.1e-07 pd=8.2e-07 nrd=1.16667 \
        nrs=1.16667 sa=8.6e-07 sb=2e-06 sd=160n sca=16.4223 scb=0.0158966 \
        scc=0.0014413 m=(1)
mn0_2__rcx (10 \8\:A \11\:VSS VSS) g45n1hvt w=(2.95e-07) l=4.5e-08 nf=1 \
        as=9.91e-14 ad=1.77e-14 ps=1.6e-06 pd=7.1e-07 nrd=1.16667 \
        nrs=1.16667 sa=9.65e-07 sb=2e-06 sd=160n sca=16.4223 scb=0.0158966 \
        scc=0.0014413 m=(1)
mn0_3__rcx (11 \7\:A \11\:VSS VSS) g45n1hvt w=(2.95e-07) l=4.5e-08 nf=1 \
        as=9.91e-14 ad=5.9e-14 ps=1.6e-06 pd=9.9e-07 nrd=1.16667 \
        nrs=1.16667 sa=1.23e-06 sb=2e-06 sd=160n sca=16.4223 scb=0.0158966 \
        scc=0.0014413 m=(1)
mn1_3__rcx (11 \9\:B 12 VSS) g45n1hvt w=(2.95e-07) l=4.5e-08 nf=1 \
        as=3.54e-14 ad=5.9e-14 ps=8.3e-07 pd=9.9e-07 nrd=1.16667 \
        nrs=1.16667 sa=1.475e-06 sb=2e-06 sd=160n sca=16.4223 \
        scb=0.0158966 scc=0.0014413 m=(1)
mn2_3__rcx (\8\:Y \10\:C 12 VSS) g45n1hvt w=(2.95e-07) l=4.5e-08 nf=1 \
        as=3.54e-14 ad=4.72e-14 ps=8.3e-07 pd=9.1e-07 nrd=1.16667 \
        nrs=1.16667 sa=1.64e-06 sb=2e-06 sd=160n sca=16.4223 scb=0.0158966 \
        scc=0.0014413 m=(1)
mn2_4__rcx (\8\:Y \11\:C 13 VSS) g45n1hvt w=(2.95e-07) l=4.5e-08 nf=1 \
        as=7.08e-14 ad=4.72e-14 ps=1.07e-06 pd=9.1e-07 nrd=1.16667 \
        nrs=1.16667 sa=1.845e-06 sb=2e-06 sd=160n sca=16.4223 \
        scb=0.0158966 scc=0.0014413 m=(1)
mn1_4__rcx (13 \12\:B 14 VSS) g45n1hvt w=(2.95e-07) l=4.5e-08 nf=1 \
        as=4.72e-14 ad=7.08e-14 ps=9.1e-07 pd=1.07e-06 nrd=1.16667 \
        nrs=1.16667 sa=2e-06 sb=2e-06 sd=160n sca=16.4223 scb=0.0158966 \
        scc=0.0014413 m=(1)
mn0_4__rcx (14 \13\:A \9\:VSS VSS) g45n1hvt w=(2.95e-07) l=4.5e-08 nf=1 \
        as=9.91e-14 ad=4.72e-14 ps=1.6e-06 pd=9.1e-07 nrd=1.16667 \
        nrs=1.16667 sa=2e-06 sb=1.92e-06 sd=160n sca=16.4223 scb=0.0158966 \
        scc=0.0014413 m=(1)
mn0_5__rcx (15 \10\:A \9\:VSS VSS) g45n1hvt w=(2.95e-07) l=4.5e-08 nf=1 \
        as=9.91e-14 ad=1.77e-14 ps=1.6e-06 pd=7.1e-07 nrd=1.16667 \
        nrs=1.16667 sa=2e-06 sb=1.655e-06 sd=160n sca=16.4223 \
        scb=0.0158966 scc=0.0014413 m=(1)
mn1_5__rcx (15 \15\:B 16 VSS) g45n1hvt w=(2.95e-07) l=4.5e-08 nf=1 \
        as=5.9e-14 ad=1.77e-14 ps=9.9e-07 pd=7.1e-07 nrd=1.16667 \
        nrs=1.16667 sa=2e-06 sb=1.55e-06 sd=160n sca=16.4223 scb=0.0158966 \
        scc=0.0014413 m=(1)
mn2_5__rcx (\6\:Y \16\:C 16 VSS) g45n1hvt w=(2.95e-07) l=4.5e-08 nf=1 \
        as=5.9e-14 ad=4.72e-14 ps=9.9e-07 pd=9.1e-07 nrd=1.16667 \
        nrs=1.16667 sa=2e-06 sb=1.305e-06 sd=160n sca=16.4223 \
        scb=0.0158966 scc=0.0014413 m=(1)
mn2_6__rcx (\6\:Y \17\:C 17 VSS) g45n1hvt w=(2.95e-07) l=4.5e-08 nf=1 \
        as=4.72e-14 ad=4.72e-14 ps=9.1e-07 pd=9.1e-07 nrd=1.16667 \
        nrs=1.16667 sa=2e-06 sb=1.1e-06 sd=160n sca=16.4223 scb=0.0158966 \
        scc=0.0014413 m=(1)
mn1_6__rcx (17 \18\:B 18 VSS) g45n1hvt w=(2.95e-07) l=4.5e-08 nf=1 \
        as=3.983e-14 ad=4.72e-14 ps=8.6e-07 pd=9.1e-07 nrd=1.16667 \
        nrs=1.16667 sa=2e-06 sb=8.95e-07 sd=160n sca=16.4223 scb=0.0158966 \
        scc=0.0014413 m=(1)
mn0_6__rcx (18 \19\:A \1\:VSS VSS) g45n1hvt w=(2.95e-07) l=4.5e-08 nf=1 \
        as=9.91e-14 ad=3.983e-14 ps=1.6e-06 pd=8.6e-07 nrd=1.16667 \
        nrs=1.16667 sa=2e-06 sb=7.15e-07 sd=160n sca=16.4223 scb=0.0158966 \
        scc=0.0014413 m=(1)
mn0 (19 \20\:A \1\:VSS VSS) g45n1hvt w=(2.95e-07) l=4.5e-08 nf=1 \
        as=9.91e-14 ad=4.72e-14 ps=1.6e-06 pd=9.1e-07 nrd=1.16667 \
        nrs=1.16667 sa=2e-06 sb=4.5e-07 sd=160n sca=16.4223 scb=0.0158966 \
        scc=0.0014413 m=(1)
mn1 (19 \22\:B 20 VSS) g45n1hvt w=(2.95e-07) l=4.5e-08 nf=1 as=1.77e-14 \
        ad=4.72e-14 ps=7.1e-07 pd=9.1e-07 nrd=1.16667 nrs=1.16667 sa=2e-06 \
        sb=2.45e-07 sd=160n sca=16.4223 scb=0.0158966 scc=0.0014413 m=(1)
mn2 (\1\:Y \21\:C 20 VSS) g45n1hvt w=(2.95e-07) l=4.5e-08 nf=1 \
        as=1.77e-14 ad=4.13e-14 ps=7.1e-07 pd=8.7e-07 nrd=1.16667 \
        nrs=1.16667 sa=2e-06 sb=1.4e-07 sd=160n sca=16.4223 scb=0.0158966 \
        scc=0.0014413 m=(1)
ends NAND3X8
// End of subcircuit definition.
