// Generated for: spectre (May  1 09:13:22 2013 )
// Library name: gsclib045_lvt
// Cell name: DLY2X1
// View name: extracted

simulator lang=spectre

subckt DLY2X1 A VDD VSS Y
mp8 (\1\:Y n4 \20\:VDD VDD) g45p1lvt w=(3.9e-07) l=4.5e-08 nf=1 \
        as=9.008e-14 ad=5.46e-14 ps=1.39e-06 pd=1.06e-06 nrd=1.16667 \
        nrs=1.16667 sa=1.4e-07 sb=4.21154e-07 sd=160n sca=17.8302 \
        scb=0.0172414 scc=0.000800052 m=(1)
C1 (A VSS) capacitor c=2.87902e-17
C2 (Y VSS) capacitor c=8.76507e-17
C3 (VDD VSS) capacitor c=2.65726e-16
C4 (n4 VSS) capacitor c=3.90571e-17
C5 (n0 VSS) capacitor c=3.66846e-17
C6 (n1 VSS) capacitor c=9.03799e-17
C7 (n8 VSS) capacitor c=5.89322e-18
C8 (n2 VSS) capacitor c=1.04752e-16
C9 (n3 VSS) capacitor c=3.73211e-17
C10 (n10 VSS) capacitor c=1.37631e-18
C11 (n7 VSS) capacitor c=1.80608e-18
C12 (n11 VSS) capacitor c=1.58096e-18
C13 (\4\:A VSS) capacitor c=3.93202e-17
C14 (\5\:VDD VSS) capacitor c=4.7687e-17
C15 (\2\:n2 VSS) capacitor c=7.12218e-17
C16 (\3\:n3 VSS) capacitor c=5.19474e-17
C17 (\3\:VDD VSS) capacitor c=3.94583e-17
C18 (\2\:n1 VSS) capacitor c=3.17395e-17
C19 (\3\:A VSS) capacitor c=3.33348e-17
C20 (\1\:VDD VSS) capacitor c=4.07375e-17
C21 (\3\:n0 VSS) capacitor c=6.71445e-17
C22 (\3\:n4 VSS) capacitor c=4.6108e-17
C23 (\6\:VDD VSS) capacitor c=5.55117e-17
C24 (\3\:n2 VSS) capacitor c=3.14839e-17
C25 (\2\:n3 VSS) capacitor c=4.84732e-17
C26 (\4\:VDD VSS) capacitor c=3.61772e-17
C27 (\3\:n1 VSS) capacitor c=2.3324e-17
C28 (\1\:A VSS) capacitor c=1.76253e-17
C29 (\2\:n0 VSS) capacitor c=6.62739e-17
C30 (\2\:VDD VSS) capacitor c=3.94981e-17
C31 (\2\:n4 VSS) capacitor c=3.11748e-17
C32 (\5\:n3 VSS) capacitor c=1.10003e-16
C33 (\9\:VDD VSS) capacitor c=7.34986e-17
C34 (\8\:n4 VSS) capacitor c=4.29504e-17
C35 (\7\:n2 VSS) capacitor c=7.92613e-17
C36 (\18\:VDD VSS) capacitor c=2.92552e-17
C37 (\4\:n0 VSS) capacitor c=1.46559e-16
C38 (\7\:n1 VSS) capacitor c=8.83755e-17
C39 (\20\:VDD VSS) capacitor c=1.71656e-16
C40 (\1\:Y VSS) capacitor c=7.74668e-17
C41 (\13\:VDD VSS) capacitor c=5.70206e-17
C42 (\7\:n3 VSS) capacitor c=9.31947e-17
C43 (\4\:n4 VSS) capacitor c=1.36542e-16
C44 (\5\:n2 VSS) capacitor c=2.06166e-16
C45 (\7\:n0 VSS) capacitor c=6.67486e-17
C46 (\5\:n1 VSS) capacitor c=1.12442e-16
C47 (\3\:Y VSS) capacitor c=4.34196e-17
C48 (\2\:A VSS) capacitor c=1.54246e-17
C49 (\6\:n0 VSS) capacitor c=1.09002e-16
C50 (\5\:A VSS) capacitor c=7.52736e-17
C51 (\4\:n1 VSS) capacitor c=5.47307e-17
C52 (\6\:n4 VSS) capacitor c=2.61111e-16
C53 (\7\:n4 VSS) capacitor c=2.60871e-16
C54 (\4\:n2 VSS) capacitor c=1.79596e-16
C55 (\4\:n3 VSS) capacitor c=7.98834e-17
C56 (\7\:VDD VSS) capacitor c=7.92181e-17
C57 (\8\:VDD VSS) capacitor c=9.44665e-17
C58 (\11\:VDD VSS) capacitor c=2.88154e-17
C59 (\12\:VDD VSS) capacitor c=3.36399e-17
C60 (\15\:VDD VSS) capacitor c=2.10194e-17
C61 (\16\:VDD VSS) capacitor c=2.42531e-17
C62 (\22\:VDD VSS) capacitor c=1.27592e-16
Rk5 (A \5\:A) resistor r=0.06206 c=0
Rk1 (\2\:Y Y) resistor r=0.5484 c=0
Rk2 (Y \4\:Y) resistor r=0.2699 c=0
Rk28 (\7\:VDD \8\:VDD) resistor r=0.408 c=0
Rk29 (\8\:VDD \10\:VDD) resistor r=0.5772 c=0
Rk30 (\10\:VDD \11\:VDD) resistor r=0.2181 c=0
Rk31 (\11\:VDD \12\:VDD) resistor r=0.5844 c=0
Rk32 (\12\:VDD \14\:VDD) resistor r=0.1579 c=0
Rk34 (\15\:VDD VDD) resistor r=0.1909 c=0
Rk33 (\14\:VDD \15\:VDD) resistor r=0.3593 c=0
Rk35 (\8\:VDD \16\:VDD) resistor r=0.07969 c=0
Rk36 (\11\:VDD \17\:VDD) resistor r=0.1102 c=0
Rk37 (\12\:VDD \19\:VDD) resistor r=0.1033 c=0
Rk38 (\15\:VDD \21\:VDD) resistor r=0.1731 c=0
Rk39 (\21\:VDD \22\:VDD) resistor r=1.0471 c=0
Rk15 (\7\:VSS \9\:VSS) resistor r=0.9743 c=0
Rk16 (\9\:VSS \10\:VSS) resistor r=0.09769 c=0
Rk17 (\10\:VSS \11\:VSS) resistor r=0.4012 c=0
Rk18 (\11\:VSS \12\:VSS) resistor r=0.2145 c=0
Rk19 (\12\:VSS \13\:VSS) resistor r=0.1369 c=0
Rk20 (\13\:VSS \14\:VSS) resistor r=0.1253 c=0
Rk22 (\15\:VSS VSS) resistor r=0.2029 c=0
Rk21 (\14\:VSS \15\:VSS) resistor r=0.223 c=0
Rk23 (\10\:VSS \17\:VSS) resistor r=0.3595 c=0
Rk24 (\11\:VSS \18\:VSS) resistor r=0.6569 c=0
Rk25 (\12\:VSS \20\:VSS) resistor r=0.04336 c=0
Rk26 (\14\:VSS \21\:VSS) resistor r=0.552 c=0
Rk27 (\15\:VSS \23\:VSS) resistor r=0.2641 c=0
Rk8 (\5\:n4 \6\:n4) resistor r=0.6869 c=0
Rk9 (\6\:n4 \7\:n4) resistor r=1.7436 c=0
Rk10 (\6\:n4 \9\:n4) resistor r=0.1881 c=0
Rk3 (\5\:n0 \6\:n0) resistor r=0.7599 c=0
Rk4 (\5\:n0 \8\:n0) resistor r=0.3786 c=0
Rk6 (\4\:n1 \6\:n1) resistor r=0.4229 c=0
Rk7 (\6\:n1 \8\:n1) resistor r=0.5321 c=0
Rk11 (\4\:n2 \6\:n2) resistor r=1.2506 c=0
Rk12 (\6\:n2 \8\:n2) resistor r=0.4933 c=0
Rk13 (\4\:n3 \6\:n3) resistor r=0.4346 c=0
Rk14 (\6\:n3 \8\:n3) resistor r=0.7515 c=0
Rl9 (\2\:A \4\:A) resistor r=79.6488 c=0
Rl8 (\2\:A \3\:A) resistor r=37.3411 c=0
Rl7 (\1\:A \2\:A) resistor r=1.2334 c=0
Rl18 (\5\:VDD \6\:VDD) resistor r=98.7985 c=0
Rl13 (\3\:VDD \4\:VDD) resistor r=178.359 c=0
Rl5 (\1\:VDD \2\:VDD) resistor r=36.8016 c=0
Rl19 (\5\:VSS \6\:VSS) resistor r=53.1926 c=0
Rl12 (\3\:VSS \4\:VSS) resistor r=24.2328 c=0
Rl6 (\1\:VSS \2\:VSS) resistor r=66.5405 c=0
Rl1 (n4 \2\:n4) resistor r=67.9995 c=0
Rl2 (\2\:n4 \3\:n4) resistor r=56.461 c=0
Rl3 (n0 \2\:n0) resistor r=24.7951 c=0
Rl4 (\2\:n0 \3\:n0) resistor r=176.9 c=0
Rl10 (n1 \2\:n1) resistor r=126.923 c=0
Rl11 (\2\:n1 \3\:n1) resistor r=26.1559 c=0
Rl16 (n2 \2\:n2) resistor r=238.027 c=0
Rl17 (\2\:n2 \3\:n2) resistor r=24.2328 c=0
Rl14 (n3 \2\:n3) resistor r=49.2328 c=0
Rl15 (\2\:n3 \3\:n3) resistor r=149.233 c=0
Rz1 (\3\:Y \4\:Y) resistor r=75 c=0
Rz10 (\13\:VDD \14\:VDD) resistor r=6.25 c=0
Rz11 (\13\:VDD \17\:VDD) resistor r=15 c=0
Rz7 (\16\:VSS \17\:VSS) resistor r=75 c=0
Rz8 (\19\:VSS \20\:VSS) resistor r=75 c=0
Rz9 (\22\:VSS \23\:VSS) resistor r=75 c=0
Rz4 (\4\:n4 \5\:n4) resistor r=75 c=0
Rz2 (\7\:n0 \8\:n0) resistor r=75 c=0
Rz3 (\5\:n1 \6\:n1) resistor r=75 c=0
Rz5 (\5\:n2 \6\:n2) resistor r=75 c=0
Rz6 (\7\:n3 \8\:n3) resistor r=75 c=0
Ry1 (\1\:Y \2\:Y) resistor r=31 c=0
Ry9 (\9\:VDD \10\:VDD) resistor r=62 c=0
Ry10 (\18\:VDD \19\:VDD) resistor r=62 c=0
Ry11 (\20\:VDD \21\:VDD) resistor r=62 c=0
Ry7 (\8\:VSS \9\:VSS) resistor r=12.4 c=0
Ry8 (\8\:VSS \13\:VSS) resistor r=5.1667 c=0
Ry4 (\8\:n4 \9\:n4) resistor r=62 c=0
Ry2 (\4\:n0 \5\:n0) resistor r=62 c=0
Ry3 (\7\:n1 \8\:n1) resistor r=62 c=0
Ry5 (\7\:n2 \8\:n2) resistor r=62 c=0
Ry6 (\5\:n3 \6\:n3) resistor r=62 c=0
Rx2 (\1\:A \5\:A) resistor r=45 c=0
Rx10 (\6\:VDD \7\:VDD) resistor r=45 c=0
Rx11 (\4\:VDD \16\:VDD) resistor r=45 c=0
Rx12 (\2\:VDD \22\:VDD) resistor r=45 c=0
Rx7 (\5\:VSS \7\:VSS) resistor r=45 c=0
Rx8 (\4\:VSS \18\:VSS) resistor r=45 c=0
Rx9 (\2\:VSS \21\:VSS) resistor r=45 c=0
Rx4 (\2\:n4 \7\:n4) resistor r=45 c=0
Rx1 (\2\:n0 \6\:n0) resistor r=45 c=0
Rx3 (\3\:n1 \4\:n1) resistor r=45 c=0
Rx5 (\3\:n2 \4\:n2) resistor r=45 c=0
Rx6 (\2\:n3 \4\:n3) resistor r=45 c=0
mn8 (\3\:Y \3\:n4 \22\:VSS VSS) g45n1lvt w=(2.6e-07) l=4.5e-08 nf=1 \
        as=3.615e-14 ad=3.64e-14 ps=8.6e-07 pd=8e-07 nrd=1.16667 \
        nrs=1.16667 sa=1.4e-07 sb=4.59712e-07 sd=160n sca=13.198 \
        scb=0.0131159 scc=0.000803647 m=(1)
mn1 (n6 \3\:n0 \22\:VSS VSS) g45n1lvt w=(1.45e-07) l=4.5e-08 nf=1 \
        as=3.615e-14 ad=2.683e-14 ps=8.6e-07 pd=6.6e-07 nrd=1.16667 \
        nrs=1.16667 sa=3.55e-07 sb=5.3e-07 sd=160n sca=9.50767 \
        scb=0.00818119 scc=0.00019576 m=(1)
mn2 (\5\:n1 \1\:VDD n6 VSS) g45n1lvt w=(1.45e-07) l=4.5e-08 nf=1 \
        as=2.683e-14 ad=4.35e-14 ps=6.6e-07 pd=8.9e-07 nrd=1.16667 \
        nrs=1.16667 sa=5.85e-07 sb=3e-07 sd=160n sca=9.50767 \
        scb=0.00818119 scc=0.00019576 m=(1)
mn0 (\7\:n0 \3\:A \19\:VSS VSS) g45n1lvt w=(1.45e-07) l=4.5e-08 nf=1 \
        as=6.205e-14 ad=2.03e-14 ps=1.74e-06 pd=5.7e-07 nrd=1.16667 \
        nrs=1.16667 sa=1.4e-07 sb=6.9e-07 sd=160n sca=23.279 scb=0.0230742 \
        scc=0.00267719 m=(1)
mn3 (n8 \2\:n1 \19\:VSS VSS) g45n1lvt w=(1.45e-07) l=4.5e-08 nf=1 \
        as=6.205e-14 ad=3.48e-14 ps=1.74e-06 pd=7.7e-07 nrd=1.16667 \
        nrs=1.16667 sa=4.05e-07 sb=4.25e-07 sd=160n sca=23.279 \
        scb=0.0230742 scc=0.00267719 m=(1)
mn4 (\5\:n2 \3\:VDD n8 VSS) g45n1lvt w=(1.45e-07) l=4.5e-08 nf=1 \
        as=3.48e-14 ad=2.03e-14 ps=7.7e-07 pd=5.7e-07 nrd=1.16667 \
        nrs=1.16667 sa=6.9e-07 sb=1.4e-07 sd=160n sca=23.279 scb=0.0230742 \
        scc=0.00267719 m=(1)
mn7 (\4\:n4 \3\:n3 \16\:VSS VSS) g45n1lvt w=(1.45e-07) l=4.5e-08 nf=1 \
        as=3.408e-14 ad=3.335e-14 ps=7.6e-07 pd=7.5e-07 nrd=1.16667 \
        nrs=1.16667 sa=2.3e-07 sb=7.05e-07 sd=160n sca=16.7245 \
        scb=0.0178071 scc=0.00133148 m=(1)
mn5 (n10 \2\:n2 \16\:VSS VSS) g45n1lvt w=(1.45e-07) l=4.5e-08 nf=1 \
        as=3.408e-14 ad=1.958e-14 ps=7.6e-07 pd=5.6e-07 nrd=1.16667 \
        nrs=1.16667 sa=5.1e-07 sb=4.25e-07 sd=160n sca=16.7245 \
        scb=0.0178071 scc=0.00133148 m=(1)
mn6 (\7\:n3 \5\:VDD n10 VSS) g45n1lvt w=(1.45e-07) l=4.5e-08 nf=1 \
        as=1.958e-14 ad=3.553e-14 ps=5.6e-07 pd=7.8e-07 nrd=1.16667 \
        nrs=1.16667 sa=6.9e-07 sb=2.45e-07 sd=160n sca=16.7245 \
        scb=0.0178071 scc=0.00133148 m=(1)
mp1 (n7 n0 \20\:VDD VDD) g45p1lvt w=(2.15e-07) l=4.5e-08 nf=1 \
        as=9.008e-14 ad=2.473e-14 ps=1.39e-06 pd=6.6e-07 nrd=1.16667 \
        nrs=1.16667 sa=4.9e-07 sb=3e-07 sd=160n sca=17.9735 scb=0.0174913 \
        scc=0.0013169 m=(1)
mp2 (\7\:n1 \1\:VSS n7 VDD) g45p1lvt w=(2.15e-07) l=4.5e-08 nf=1 \
        as=2.473e-14 ad=3.01e-14 ps=6.6e-07 pd=7.1e-07 nrd=1.16667 \
        nrs=1.16667 sa=6.5e-07 sb=1.4e-07 sd=160n sca=17.5155 \
        scb=0.0173077 scc=0.00131683 m=(1)
mp0 (\4\:n0 \4\:A \18\:VDD VDD) g45p1lvt w=(2.15e-07) l=4.5e-08 nf=1 \
        as=9.83e-14 ad=3.01e-14 ps=1.72e-06 pd=7.1e-07 nrd=1.16667 \
        nrs=1.16667 sa=1.4e-07 sb=5.1e-07 sd=160n sca=19.0975 \
        scb=0.0187686 scc=0.00166224 m=(1)
mp3 (n9 n1 \18\:VDD VDD) g45p1lvt w=(2.15e-07) l=4.5e-08 nf=1 \
        as=9.83e-14 ad=1.29e-14 ps=1.72e-06 pd=5.5e-07 nrd=1.16667 \
        nrs=1.16667 sa=4.05e-07 sb=2.45e-07 sd=160n sca=19.0975 \
        scb=0.0187686 scc=0.00166224 m=(1)
mp4 (\7\:n2 \3\:VSS n9 VDD) g45p1lvt w=(2.15e-07) l=4.5e-08 nf=1 \
        as=1.29e-14 ad=3.01e-14 ps=5.5e-07 pd=7.1e-07 nrd=1.16667 \
        nrs=1.16667 sa=5.1e-07 sb=1.4e-07 sd=160n sca=19.0975 \
        scb=0.0187686 scc=0.00166224 m=(1)
mp7 (\8\:n4 n3 \9\:VDD VDD) g45p1lvt w=(2.15e-07) l=4.5e-08 nf=1 \
        as=3.44e-14 ad=3.01e-14 ps=7.5e-07 pd=7.1e-07 nrd=1.16667 \
        nrs=1.16667 sa=1.4e-07 sb=4.5e-07 sd=160n sca=10.4732 \
        scb=0.00744141 scc=7.36981e-05 m=(1)
mp5 (n11 n2 \9\:VDD VDD) g45p1lvt w=(2.15e-07) l=4.5e-08 nf=1 \
        as=3.44e-14 ad=1.29e-14 ps=7.5e-07 pd=5.5e-07 nrd=1.16667 \
        nrs=1.16667 sa=3.45e-07 sb=2.45e-07 sd=160n sca=11.3694 \
        scb=0.00808912 scc=7.45876e-05 m=(1)
mp6 (\5\:n3 \6\:VSS n11 VDD) g45p1lvt w=(2.15e-07) l=4.5e-08 nf=1 \
        as=1.29e-14 ad=3.01e-14 ps=5.5e-07 pd=7.1e-07 nrd=1.16667 \
        nrs=1.16667 sa=4.5e-07 sb=1.4e-07 sd=160n sca=12.2441 \
        scb=0.00918936 scc=7.99464e-05 m=(1)
ends DLY2X1
// End of subcircuit definition.
