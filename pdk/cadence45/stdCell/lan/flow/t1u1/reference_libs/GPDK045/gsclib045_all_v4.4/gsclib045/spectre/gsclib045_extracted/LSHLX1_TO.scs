// Generated for: spectre (May  1 08:11:42 2013 )
// Library name: gsclib045
// Cell name: LSHLX1_TO
// View name: extracted

simulator lang=spectre

subckt LSHLX1_TO A VDD VSS Y
mp0 (\9\:n0 \4\:A \1\:VDD VDD) g45p1svt w=(2.15e-07) l=4.5e-08 nf=1 \
        as=6.535e-14 ad=3.01e-14 ps=1.16e-06 pd=7.1e-07 nrd=1.16667 \
        nrs=1.16667 sa=1.4e-07 sb=3.75e-07 sd=160n sca=21.3061 \
        scb=0.0229136 scc=0.00064882 m=(1)
C1 (VDD VSS) capacitor c=8.43328e-17
C2 (A VSS) capacitor c=8.2178e-17
C3 (Y VSS) capacitor c=1.93592e-17
C4 (n0 VSS) capacitor c=6.10274e-17
C5 (\4\:A VSS) capacitor c=3.78573e-17
C6 (\4\:n0 VSS) capacitor c=3.54221e-17
C7 (\3\:A VSS) capacitor c=4.28369e-17
C8 (\3\:n0 VSS) capacitor c=2.23027e-17
C9 (\1\:A VSS) capacitor c=2.47786e-17
C10 (\4\:Y VSS) capacitor c=6.16228e-17
C11 (\1\:VDD VSS) capacitor c=7.67648e-17
C12 (\9\:n0 VSS) capacitor c=4.42567e-17
C13 (\2\:Y VSS) capacitor c=3.31993e-17
C14 (\7\:n0 VSS) capacitor c=2.46941e-17
C15 (\2\:A VSS) capacitor c=3.76397e-17
C16 (\2\:n0 VSS) capacitor c=2.75798e-17
C17 (\5\:n0 VSS) capacitor c=4.88002e-17
C18 (\6\:n0 VSS) capacitor c=6.50141e-17
C19 (\1\:Y VSS) capacitor c=4.7463e-17
Rk10 (\2\:VSS VSS) resistor r=0.3113 c=0
Rk8 (\2\:VDD VDD) resistor r=0.3732 c=0
Rk5 (Y \1\:Y) resistor r=0.0271 c=0
Rk6 (\1\:Y \3\:Y) resistor r=0.1987 c=0
Rk7 (\1\:Y \5\:Y) resistor r=0.3953 c=0
Rk2 (\5\:n0 \6\:n0) resistor r=0.1999 c=0
Rk3 (\6\:n0 \8\:n0) resistor r=0.171 c=0
Rk4 (\6\:n0 \10\:n0) resistor r=0.4249 c=0
Rl3 (\2\:A \4\:A) resistor r=92.4917 c=0
Rl2 (\2\:A \3\:A) resistor r=126.583 c=0
Rl1 (\1\:A \2\:A) resistor r=2.4834 c=0
Rl4 (n0 \2\:n0) resistor r=132.374 c=0
Rl6 (\2\:n0 \4\:n0) resistor r=38.1316 c=0
Rl5 (\2\:n0 \3\:n0) resistor r=2.4801 c=0
Rz4 (\1\:VSS \2\:VSS) resistor r=37.5 c=0
Rz2 (\2\:Y \3\:Y) resistor r=37.5 c=0
Rz1 (\7\:n0 \8\:n0) resistor r=75 c=0
Ry3 (\1\:VDD \2\:VDD) resistor r=20.6667 c=0
Ry2 (\4\:Y \5\:Y) resistor r=20.6667 c=0
Ry1 (\9\:n0 \10\:n0) resistor r=62 c=0
Rx1 (\1\:A A) resistor r=45 c=0
Rx2 (\3\:n0 \5\:n0) resistor r=45 c=0
mn0 (\1\:VSS \3\:A \7\:n0 VSS) g45n1svt w=(1.45e-07) l=4.5e-08 nf=1 \
        as=4.365e-14 ad=2.03e-14 ps=9e-07 pd=5.7e-07 nrd=1.16667 \
        nrs=1.16667 sa=1.4e-07 sb=3.75e-07 sd=160n sca=8.85152 \
        scb=0.00706865 scc=0.000138481 m=(1)
NM0 (\2\:Y \4\:n0 \1\:VSS VSS) g45n1svt w=(2.6e-07) l=4.5e-08 nf=1 \
        as=3.64e-14 ad=4.365e-14 ps=8e-07 pd=9e-07 nrd=1.16667 nrs=1.16667 \
        sa=2.71058e-07 sb=1.4e-07 sd=160n sca=8.97712 scb=0.00732387 \
        scc=0.000196032 m=(1)
PM0 (\4\:Y n0 \1\:VDD VDD) g45p1svt w=(3.9e-07) l=4.5e-08 nf=1 \
        as=5.46e-14 ad=6.535e-14 ps=1.06e-06 pd=1.16e-06 nrd=1.16667 \
        nrs=1.16667 sa=2.69551e-07 sb=1.4e-07 sd=160n sca=22.176 \
        scb=0.0237558 scc=0.000835591 m=(1)
ends LSHLX1_TO
// End of subcircuit definition.
