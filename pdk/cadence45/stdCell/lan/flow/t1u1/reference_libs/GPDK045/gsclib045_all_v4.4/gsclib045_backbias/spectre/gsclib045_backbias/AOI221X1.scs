// gsclib045_backbias/AOI221X1/schematic

simulator lang=spectre

subckt AOI221X1 A0 A1 B0 B1 C0 Y VSS VDD NW
mn2 (net120 B0 VSS VSS) g45n1svt w=(260n) l=45n nf=1 m=(1)
mn3 (Y B1 net120 VSS) g45n1svt w=(260n) l=45n nf=1 m=(1)
mn4 (Y C0 VSS VSS) g45n1svt w=(260n) l=45n nf=1 m=(1)
mn1 (Y A1 net128 VSS) g45n1svt w=(260n) l=45n nf=1 m=(1)
mn0 (net128 A0 VSS VSS) g45n1svt w=(260n) l=45n nf=1 m=(1)
mp3 (net108 B1 net111 NW) g45p1svt w=(390n) l=45n nf=1 m=(1)
mp2 (net108 B0 net111 NW) g45p1svt w=(390n) l=45n nf=1 m=(1)
mp0 (net111 A0 VDD NW) g45p1svt w=(390n) l=45n nf=1 m=(1)
mp1 (net111 A1 VDD NW) g45p1svt w=(390n) l=45n nf=1 m=(1)
mp4 (Y C0 net108 NW) g45p1svt w=(390n) l=45n nf=1 m=(1)
ends AOI221X1
