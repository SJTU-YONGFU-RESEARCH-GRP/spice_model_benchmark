// Generated for: spectre (May  1 08:12:34 2013 )
// Library name: gsclib045
// Cell name: SRDFFNSQX1
// View name: extracted

simulator lang=spectre

subckt SRDFFNSQX1 CKN D ExtVDD Q RT SE SI SN VDD VSS
mp11 (n1 \4\:D \22\:VDD VDD) g45p1svt w=(2.15e-07) l=4.5e-08 nf=1 \
        as=1.362e-13 ad=1.29e-14 ps=2.93e-06 pd=5.5e-07 nrd=1.16667 \
        nrs=1.16667 sa=1.7e-07 sb=7.6e-07 sd=160n sca=15.238 scb=0.0153511 \
        scc=0.00103803 m=(1)
mp21 (\12\:CKNbb \4\:CKNb \22\:VDD VDD) g45p1svt w=(2.15e-07) l=4.5e-08 \
        nf=1 as=1.362e-13 ad=3.01e-14 ps=2.93e-06 pd=7.1e-07 nrd=1.16667 \
        nrs=1.16667 sa=1.4e-07 sb=3.45e-07 sd=160n sca=15.2549 \
        scb=0.0153595 scc=0.00103804 m=(1)
mp20 (\20\:CKNb \4\:CKN \22\:VDD VDD) g45p1svt w=(2.15e-07) l=4.5e-08 \
        nf=1 as=3.01e-14 ad=1.362e-13 ps=7.1e-07 pd=2.93e-06 nrd=1.16667 \
        nrs=1.16667 sa=3.45e-07 sb=1.4e-07 sd=160n sca=14.7851 \
        scb=0.0152025 scc=0.00103799 m=(1)
mp25 (\10\:n20 \3\:CKNb \5\:Db VDD) g45p1svt w=(2.15e-07) l=4.5e-08 nf=1 \
        as=3.01e-14 ad=3.01e-14 ps=7.1e-07 pd=7.1e-07 nrd=1.16667 \
        nrs=1.16667 sa=1.4e-07 sb=1.4e-07 sd=160n sca=20.3407 scb=0.022946 \
        scc=0.00119484 m=(1)
mp36 (\13\:n20 \8\:CKNbb n7 VDD) g45p1svt w=(2.15e-07) l=4.5e-08 nf=1 \
        as=1.29e-14 ad=3.01e-14 ps=5.5e-07 pd=7.1e-07 nrd=1.16667 \
        nrs=1.16667 sa=1.4e-07 sb=8.1e-07 sd=160n sca=6.79882 \
        scb=0.00278203 scc=1.42286e-05 m=(1)
mp35 (n7 mout \20\:VDD VDD) g45p1svt w=(2.15e-07) l=4.5e-08 nf=1 \
        as=6.773e-14 ad=1.29e-14 ps=1.06e-06 pd=5.5e-07 nrd=1.16667 \
        nrs=1.16667 sa=2.45e-07 sb=7.05e-07 sd=160n sca=6.42122 \
        scb=0.00257522 scc=1.4095e-05 m=(1)
mp30 (\15\:mout \1\:SN \20\:VDD VDD) g45p1svt w=(2.15e-07) l=4.5e-08 \
        nf=1 as=6.773e-14 ad=3.44e-14 ps=1.06e-06 pd=7.5e-07 nrd=1.16667 \
        nrs=1.16667 sa=6.05e-07 sb=3.45e-07 sd=160n sca=6.07861 \
        scb=0.00247604 scc=1.40748e-05 m=(1)
mp32 (\15\:mout \3\:n20 \17\:VDD VDD) g45p1svt w=(2.15e-07) l=4.5e-08 \
        nf=1 as=3.01e-14 ad=3.44e-14 ps=7.1e-07 pd=7.5e-07 nrd=1.16667 \
        nrs=1.16667 sa=8.1e-07 sb=1.4e-07 sd=160n sca=6.37787 \
        scb=0.00255822 scc=1.40897e-05 m=(1)
mp12 (\3\:Db \4\:SE n1 VDD) g45p1svt w=(2.15e-07) l=4.5e-08 nf=1 \
        as=1.29e-14 ad=3.44e-14 ps=5.5e-07 pd=7.5e-07 nrd=1.16667 \
        nrs=1.16667 sa=2.75e-07 sb=6.55e-07 sd=160n sca=15.6684 \
        scb=0.0156302 scc=0.00103829 m=(1)
mp14 (\3\:Db SEb n3 VDD) g45p1svt w=(2.15e-07) l=4.5e-08 nf=1 as=1.29e-14 \
        ad=3.44e-14 ps=5.5e-07 pd=7.5e-07 nrd=1.16667 nrs=1.16667 \
        sa=4.8e-07 sb=4.5e-07 sd=160n sca=17.3611 scb=0.0177712 \
        scc=0.00105096 m=(1)
mp13 (n3 \3\:SI \15\:VDD VDD) g45p1svt w=(2.15e-07) l=4.5e-08 nf=1 \
        as=3.44e-14 ad=1.29e-14 ps=7.5e-07 pd=5.5e-07 nrd=1.16667 \
        nrs=1.16667 sa=5.85e-07 sb=3.45e-07 sd=160n sca=19.3151 \
        scb=0.0211393 scc=0.00112289 m=(1)
mp40 (\4\:n35 \7\:CKNbb \5\:mout VDD) g45p1svt w=(2.15e-07) l=4.5e-08 \
        nf=1 as=3.01e-14 ad=3.01e-14 ps=7.1e-07 pd=7.1e-07 nrd=1.16667 \
        nrs=1.16667 sa=1.4e-07 sb=1.4e-07 sd=160n sca=25.5298 \
        scb=0.0265038 scc=0.00266093 m=(1)
mp10 (\8\:SEb \3\:SE \15\:VDD VDD) g45p1svt w=(2.15e-07) l=4.5e-08 nf=1 \
        as=3.44e-14 ad=3.01e-14 ps=7.5e-07 pd=7.1e-07 nrd=1.16667 \
        nrs=1.16667 sa=7.9e-07 sb=1.4e-07 sd=160n sca=34.2363 \
        scb=0.0392303 scc=0.00368484 m=(1)
PM0 (\6\:n35g \5\:RT \9\:n35 ExtVDD) g45p1svt w=(2.15e-07) l=4.5e-08 nf=1 \
        as=3.01e-14 ad=3.01e-14 ps=7.1e-07 pd=7.1e-07 nrd=1.16667 \
        nrs=1.16667 sa=1.4e-07 sb=1.4e-07 sd=160n sca=26.0836 \
        scb=0.0271848 scc=0.00267095 m=(1)
mp45 (\14\:qbint \3\:n35g \1\:ExtVDD ExtVDD) g45p1svt w=(2.15e-07) \
        l=4.5e-08 nf=1 as=3.5882e-13 ad=3.01e-14 ps=3.6e-06 pd=7.1e-07 \
        nrd=1.16667 nrs=1.16667 sa=1.4e-07 sb=8.7e-07 sd=160n sca=25.2796 \
        scb=0.0259458 scc=0.00265434 m=(1)
PM2 (net234 \4\:qbint \1\:ExtVDD ExtVDD) g45p1svt w=(2.15e-07) l=4.5e-08 \
        nf=1 as=3.5882e-13 ad=1.29e-14 ps=3.6e-06 pd=5.5e-07 nrd=1.16667 \
        nrs=1.16667 sa=7.65e-07 sb=2.45e-07 sd=160n sca=14.5295 \
        scb=0.0144143 scc=0.000486924 m=(1)
PM1 (\6\:RTb \6\:RT \1\:ExtVDD ExtVDD) g45p1svt w=(2.15e-07) l=4.5e-08 \
        nf=1 as=3.5882e-13 ad=3.01e-14 ps=3.6e-06 pd=7.1e-07 nrd=1.16667 \
        nrs=1.16667 sa=3.3e-07 sb=1.4e-07 sd=160n sca=24.3731 \
        scb=0.0258873 scc=0.00229004 m=(1)
PM3 (\15\:n35g \4\:RTb net234 ExtVDD) g45p1svt w=(2.15e-07) l=4.5e-08 \
        nf=1 as=1.29e-14 ad=3.01e-14 ps=5.5e-07 pd=7.1e-07 nrd=1.16667 \
        nrs=1.16667 sa=8.7e-07 sb=1.4e-07 sd=160n sca=25.2796 \
        scb=0.0259458 scc=0.00265434 m=(1)
mp53 (\14\:n35 \12\:CKNb \3\:n11 VDD) g45p1svt w=(2.15e-07) l=4.5e-08 \
        nf=1 as=3.01e-14 ad=3.01e-14 ps=7.1e-07 pd=7.1e-07 nrd=1.16667 \
        nrs=1.16667 sa=1.4e-07 sb=1.4e-07 sd=160n sca=28.3325 \
        scb=0.0311878 scc=0.00281308 m=(1)
mp52 (n11 \10\:qbint \13\:VDD VDD) g45p1svt w=(2.15e-07) l=4.5e-08 nf=1 \
        as=3.01e-14 ad=3.44e-14 ps=7.1e-07 pd=7.5e-07 nrd=1.16667 \
        nrs=1.16667 sa=1.4e-07 sb=3.45e-07 sd=160n sca=11.272 \
        scb=0.00858882 scc=0.000167946 m=(1)
mp50 (n11 \7\:SN \1\:VDD VDD) g45p1svt w=(2.15e-07) l=4.5e-08 nf=1 \
        as=3.01e-14 ad=3.44e-14 ps=7.1e-07 pd=7.5e-07 nrd=1.16667 \
        nrs=1.16667 sa=3.45e-07 sb=1.4e-07 sd=160n sca=12.4133 \
        scb=0.0108228 scc=0.00019293 m=(1)
C1 (Q VSS) capacitor c=1.83687e-17
C2 (D VSS) capacitor c=4.48538e-17
C3 (RT VSS) capacitor c=2.32585e-17
C4 (SI VSS) capacitor c=4.98301e-17
C5 (CKN VSS) capacitor c=3.89757e-17
C6 (ExtVDD VSS) capacitor c=2.19508e-16
C7 (SN VSS) capacitor c=5.01584e-17
C8 (VDD VSS) capacitor c=6.83026e-16
C9 (SE VSS) capacitor c=3.53524e-17
C10 (n20 VSS) capacitor c=3.87782e-17
C11 (CKNb VSS) capacitor c=4.50288e-17
C12 (mout VSS) capacitor c=4.83533e-17
C13 (CKNbb VSS) capacitor c=3.41419e-17
C14 (SEb VSS) capacitor c=7.77679e-17
C15 (n35g VSS) capacitor c=1.81021e-17
C16 (qbint VSS) capacitor c=4.53515e-17
C17 (RTb VSS) capacitor c=5.18542e-17
C18 (n35 VSS) capacitor c=1.72903e-16
C19 (Db VSS) capacitor c=9.97183e-17
C20 (n11 VSS) capacitor c=8.17944e-17
C21 (n1 VSS) capacitor c=8.87983e-19
C22 (\7\:SN VSS) capacitor c=8.87051e-17
C23 (\7\:qbint VSS) capacitor c=3.73781e-17
C24 (\10\:qbint VSS) capacitor c=1.01993e-16
C25 (\12\:CKNb VSS) capacitor c=4.90104e-17
C26 (\4\:RTb VSS) capacitor c=9.80705e-17
C27 (\6\:RT VSS) capacitor c=2.32835e-17
C28 (\4\:qbint VSS) capacitor c=5.41916e-17
C29 (\3\:n35g VSS) capacitor c=5.41787e-17
C30 (\5\:RT VSS) capacitor c=6.63094e-17
C31 (\3\:SE VSS) capacitor c=7.83662e-17
C32 (\7\:CKNbb VSS) capacitor c=3.1648e-17
C33 (\3\:SI VSS) capacitor c=9.50293e-17
C34 (\4\:SE VSS) capacitor c=1.2579e-16
C35 (\4\:D VSS) capacitor c=7.00755e-17
C36 (\3\:n20 VSS) capacitor c=3.35316e-17
C37 (\1\:SN VSS) capacitor c=3.12993e-17
C38 (\4\:CKN VSS) capacitor c=5.64181e-17
C39 (\4\:CKNb VSS) capacitor c=4.66452e-17
C40 (\8\:CKNbb VSS) capacitor c=8.32535e-17
C41 (\3\:CKNb VSS) capacitor c=1.1588e-16
C42 (\6\:qbint VSS) capacitor c=4.18589e-17
C43 (\8\:SN VSS) capacitor c=1.47777e-16
C44 (\11\:qbint VSS) capacitor c=1.49963e-16
C45 (\9\:CKNbb VSS) capacitor c=2.55821e-16
C46 (\8\:RT VSS) capacitor c=1.22265e-16
C47 (\2\:RT VSS) capacitor c=6.24848e-17
C48 (\5\:qbint VSS) capacitor c=3.87528e-17
C49 (\5\:n35g VSS) capacitor c=3.28666e-17
C50 (\2\:RTb VSS) capacitor c=4.94719e-17
C51 (\5\:SE VSS) capacitor c=5.82406e-17
C52 (\6\:CKNb VSS) capacitor c=2.74136e-17
C53 (\1\:SI VSS) capacitor c=4.92085e-17
C54 (\6\:SE VSS) capacitor c=8.7218e-17
C55 (\3\:SEb VSS) capacitor c=6.67562e-17
C56 (\1\:D VSS) capacitor c=4.95122e-17
C57 (\7\:n20 VSS) capacitor c=6.1616e-17
C58 (\6\:SN VSS) capacitor c=6.66853e-17
C59 (\1\:CKN VSS) capacitor c=2.86904e-17
C60 (\3\:mout VSS) capacitor c=4.55405e-17
C61 (\11\:CKNb VSS) capacitor c=4.83019e-17
C62 (\9\:qbint VSS) capacitor c=8.57372e-17
C63 (\13\:CKNb VSS) capacitor c=5.16078e-17
C64 (\3\:SN VSS) capacitor c=2.96023e-16
C65 (\9\:SN VSS) capacitor c=6.35566e-17
C66 (\7\:RT VSS) capacitor c=1.47691e-16
C67 (\10\:CKNb VSS) capacitor c=1.68367e-16
C68 (\3\:RT VSS) capacitor c=3.93273e-17
C69 (\1\:RT VSS) capacitor c=5.31338e-17
C70 (\3\:RTb VSS) capacitor c=7.60026e-17
C71 (\3\:qbint VSS) capacitor c=4.39891e-17
C72 (\2\:n35 VSS) capacitor c=2.52702e-16
C73 (\4\:n35g VSS) capacitor c=6.67993e-17
C74 (\3\:CKNbb VSS) capacitor c=5.11201e-17
C75 (\10\:CKNbb VSS) capacitor c=2.18682e-16
C76 (\3\:n35 VSS) capacitor c=1.15032e-16
C77 (\1\:SE VSS) capacitor c=2.42797e-17
C78 (\2\:SI VSS) capacitor c=7.79437e-17
C79 (\2\:SEb VSS) capacitor c=7.70283e-17
C80 (\4\:n20 VSS) capacitor c=9.85816e-17
C81 (\6\:n20 VSS) capacitor c=5.88027e-17
C82 (\3\:D VSS) capacitor c=1.46382e-17
C83 (\2\:SN VSS) capacitor c=4.74799e-17
C84 (\5\:SN VSS) capacitor c=1.95194e-17
C85 (\3\:CKN VSS) capacitor c=2.36967e-17
C86 (\2\:mout VSS) capacitor c=4.33856e-17
C87 (\4\:mout VSS) capacitor c=3.10825e-17
C88 (\2\:CKNb VSS) capacitor c=8.0488e-17
C89 (\6\:CKNbb VSS) capacitor c=3.65531e-17
C90 (\5\:n20 VSS) capacitor c=6.37961e-17
C91 (\2\:CKNbb VSS) capacitor c=5.81334e-17
C92 (\5\:CKNb VSS) capacitor c=7.2597e-17
C93 (\9\:CKNb VSS) capacitor c=2.58903e-17
C94 (\2\:n20 VSS) capacitor c=3.96498e-17
C95 (\1\:VDD VSS) capacitor c=2.80565e-17
C96 (\11\:VDD VSS) capacitor c=4.74301e-17
C97 (\4\:Q VSS) capacitor c=5.95026e-17
C98 (\13\:VDD VSS) capacitor c=5.28803e-17
C99 (\3\:n11 VSS) capacitor c=8.43214e-17
C100 (\14\:n35 VSS) capacitor c=5.13299e-17
C101 (\15\:n35g VSS) capacitor c=5.75861e-17
C102 (\6\:RTb VSS) capacitor c=7.37189e-17
C103 (\1\:ExtVDD VSS) capacitor c=2.78217e-16
C104 (\9\:n35 VSS) capacitor c=6.22857e-17
C105 (\14\:qbint VSS) capacitor c=6.82643e-17
C106 (\6\:n35g VSS) capacitor c=9.42155e-17
C107 (\8\:SEb VSS) capacitor c=4.17901e-17
C108 (\4\:n35 VSS) capacitor c=6.40446e-17
C109 (\15\:VDD VSS) capacitor c=5.71573e-17
C110 (\5\:mout VSS) capacitor c=7.57309e-17
C111 (\3\:Db VSS) capacitor c=1.82856e-16
C112 (\17\:VDD VSS) capacitor c=3.63314e-17
C113 (\22\:VDD VSS) capacitor c=3.87252e-17
C114 (\15\:mout VSS) capacitor c=1.02027e-16
C115 (\20\:VDD VSS) capacitor c=6.72655e-17
C116 (\20\:CKNb VSS) capacitor c=2.73889e-17
C117 (\12\:CKNbb VSS) capacitor c=5.81342e-17
C118 (\13\:n20 VSS) capacitor c=6.25083e-17
C119 (\5\:Db VSS) capacitor c=2.32388e-16
C120 (\10\:n20 VSS) capacitor c=6.34404e-17
C121 (\1\:Q VSS) capacitor c=3.36374e-17
C122 (\17\:n35 VSS) capacitor c=3.93197e-17
C123 (\11\:n35g VSS) capacitor c=2.62975e-17
C124 (\10\:RTb VSS) capacitor c=5.83264e-17
C125 (\12\:n35 VSS) capacitor c=6.36879e-17
C126 (\16\:qbint VSS) capacitor c=2.43782e-17
C127 (\9\:n35g VSS) capacitor c=8.05569e-17
C128 (\4\:SEb VSS) capacitor c=3.83281e-17
C129 (\7\:n35 VSS) capacitor c=4.10206e-17
C130 (\11\:mout VSS) capacitor c=2.2299e-17
C131 (\13\:mout VSS) capacitor c=1.74468e-17
C132 (\16\:CKNb VSS) capacitor c=6.05987e-17
C133 (\15\:CKNbb VSS) capacitor c=5.95132e-17
C134 (\17\:n20 VSS) capacitor c=8.70237e-17
C135 (\7\:Db VSS) capacitor c=1.10731e-16
C136 (\8\:n20 VSS) capacitor c=5.97532e-17
C137 (\2\:CKN VSS) capacitor c=3.53915e-17
C138 (\2\:D VSS) capacitor c=3.5374e-17
C139 (\2\:SE VSS) capacitor c=2.68399e-17
C140 (\4\:CKNbb VSS) capacitor c=1.52093e-16
C141 (\5\:CKNbb VSS) capacitor c=8.78061e-17
C142 (VDD VSS) capacitor c=2.27964e-16
C143 (\2\:n35g VSS) capacitor c=2.90002e-17
C144 (\4\:RT VSS) capacitor c=4.7642e-17
C145 (\2\:qbint VSS) capacitor c=4.13898e-17
C146 (\7\:CKNb VSS) capacitor c=1.23268e-16
C147 (\8\:CKNb VSS) capacitor c=7.87407e-17
C148 (\4\:SN VSS) capacitor c=2.48419e-16
C149 (\12\:n20 VSS) capacitor c=4.64148e-17
C150 (\8\:qbint VSS) capacitor c=8.98965e-17
C151 (\14\:CKNb VSS) capacitor c=9.91967e-17
C152 (\15\:CKNb VSS) capacitor c=9.61835e-17
C153 (\15\:n20 VSS) capacitor c=5.24094e-17
C154 (\16\:n20 VSS) capacitor c=9.1656e-17
C155 (\11\:CKNbb VSS) capacitor c=5.50393e-17
C156 (\14\:CKNbb VSS) capacitor c=8.20385e-17
C157 (\5\:CKN VSS) capacitor c=3.99911e-18
C158 (\6\:CKN VSS) capacitor c=3.40868e-17
C159 (\18\:CKNb VSS) capacitor c=6.50951e-17
C160 (\19\:CKNb VSS) capacitor c=4.30918e-17
C161 (\10\:SN VSS) capacitor c=3.66087e-17
C162 (\11\:SN VSS) capacitor c=4.37435e-17
C163 (\7\:D VSS) capacitor c=4.18483e-17
C164 (\19\:n20 VSS) capacitor c=4.95987e-17
C165 (\20\:n20 VSS) capacitor c=5.61366e-17
C166 (\7\:mout VSS) capacitor c=7.88882e-17
C167 (\8\:mout VSS) capacitor c=3.73045e-17
C168 (\9\:mout VSS) capacitor c=1.17347e-16
C169 (\10\:mout VSS) capacitor c=8.73467e-17
C170 (\17\:mout VSS) capacitor c=7.07294e-17
C171 (\5\:SI VSS) capacitor c=3.46838e-17
C172 (\6\:SI VSS) capacitor c=2.61172e-18
C173 (\7\:SE VSS) capacitor c=3.99056e-17
C174 (\6\:SEb VSS) capacitor c=8.30403e-17
C175 (\7\:SEb VSS) capacitor c=6.7995e-17
C176 (\6\:n35 VSS) capacitor c=7.79713e-17
C177 (\17\:CKNbb VSS) capacitor c=3.91869e-17
C178 (\18\:CKNbb VSS) capacitor c=4.23494e-17
C179 (\8\:n35g VSS) capacitor c=3.46984e-17
C180 (\11\:n35 VSS) capacitor c=7.51579e-17
C181 (\12\:qbint VSS) capacitor c=8.78839e-17
C182 (\13\:qbint VSS) capacitor c=1.12271e-16
C183 (\13\:n35g VSS) capacitor c=1.01792e-16
C184 (\14\:n35g VSS) capacitor c=1.16397e-16
C185 (\5\:RTb VSS) capacitor c=4.95162e-17
C186 (\8\:RTb VSS) capacitor c=9.94755e-17
C187 (\9\:RTb VSS) capacitor c=9.16465e-17
C188 (\9\:RT VSS) capacitor c=1.0991e-16
C189 (\10\:RT VSS) capacitor c=1.18317e-16
C190 (\11\:RT VSS) capacitor c=4.01173e-17
C191 (\12\:SN VSS) capacitor c=8.31472e-17
C192 (\13\:SN VSS) capacitor c=7.86483e-17
C193 (\22\:CKNb VSS) capacitor c=1.29769e-16
C194 (\23\:CKNb VSS) capacitor c=1.34536e-16
C195 (\18\:qbint VSS) capacitor c=1.9511e-17
C196 (\19\:qbint VSS) capacitor c=2.98697e-17
C197 (\16\:n35 VSS) capacitor c=4.54459e-17
C198 (\3\:Q VSS) capacitor c=1.89406e-17
C199 (\3\:VDD VSS) capacitor c=2.42393e-17
C200 (\4\:VDD VSS) capacitor c=2.95656e-17
C201 (\6\:VDD VSS) capacitor c=1.12722e-16
C202 (\7\:VDD VSS) capacitor c=7.39943e-17
C203 (\8\:VDD VSS) capacitor c=2.38596e-17
C204 (\10\:VDD VSS) capacitor c=2.13781e-17
C205 (\19\:VDD VSS) capacitor c=1.65989e-17
C206 (\24\:VDD VSS) capacitor c=3.53297e-17
Rk75 (\3\:Q Q) resistor r=0.01828 c=0
Rk74 (\2\:Q \3\:Q) resistor r=0.208 c=0
Rk76 (\3\:Q \5\:Q) resistor r=0.3657 c=0
Rk19 (\5\:D D) resistor r=0.007198 c=0
Rk21 (\5\:D \7\:D) resistor r=0.01668 c=0
Rk20 (\6\:D \7\:D) resistor r=0.007198 c=0
Rk95 (\2\:VSS \4\:VSS) resistor r=0.3588 c=0
Rk96 (\4\:VSS \5\:VSS) resistor r=0.8595 c=0
Rk97 (\5\:VSS \6\:VSS) resistor r=0.03202 c=0
Rk99 (\7\:VSS VSS) resistor r=0.121 c=0
Rk98 (\6\:VSS \7\:VSS) resistor r=0.1757 c=0
Rk100 (VSS \8\:VSS) resistor r=0.5204 c=0
Rk101 (\8\:VSS \9\:VSS) resistor r=0.3068 c=0
Rk103 (\10\:VSS VSS) resistor r=0.1212 c=0
Rk102 (\9\:VSS \10\:VSS) resistor r=0.06422 c=0
Rk104 (VSS \12\:VSS) resistor r=0.3116 c=0
Rk105 (\5\:VSS \14\:VSS) resistor r=0.189 c=0
Rk106 (\7\:VSS \16\:VSS) resistor r=0.194 c=0
Rk107 (\8\:VSS \18\:VSS) resistor r=0.253 c=0
Rk108 (\9\:VSS \20\:VSS) resistor r=0.2486 c=0
Rk109 (\22\:VSS \23\:VSS) resistor r=0.08157 c=0
Rk110 (\23\:VSS \24\:VSS) resistor r=0.7309 c=0
Rk112 (\25\:VSS VSS) resistor r=0.2971 c=0
Rk111 (\24\:VSS \25\:VSS) resistor r=0.07909 c=0
Rk114 (\26\:VSS VSS) resistor r=0.1212 c=0
Rk113 (VSS \26\:VSS) resistor r=0.8922 c=0
Rk115 (\23\:VSS \28\:VSS) resistor r=0.2345 c=0
Rk116 (\24\:VSS \30\:VSS) resistor r=0.2432 c=0
Rk117 (VSS \32\:VSS) resistor r=0.3078 c=0
Rk66 (RT \9\:RT) resistor r=0.1837 c=0
Rk67 (\9\:RT \10\:RT) resistor r=0.6456 c=0
Rk68 (RT \11\:RT) resistor r=0.01478 c=0
Rk34 (SI \4\:SI) resistor r=0.01021 c=0
Rk35 (\5\:SI \4\:SI) resistor r=0.001848 c=0
Rk36 (SI \6\:SI) resistor r=0.001848 c=0
Rk37 (\5\:SI \6\:SI) resistor r=0.01021 c=0
Rk38 (\7\:SI SI) resistor r=0.001848 c=0
Rk39 (\6\:SI \7\:SI) resistor r=0.009883 c=0
Rk10 (CKN \5\:CKN) resistor r=0.001943 c=0
Rk13 (\5\:CKN \6\:CKN) resistor r=0.01016 c=0
Rk12 (\6\:CKN \7\:CKN) resistor r=0.004796 c=0
Rk53 (ExtVDD ExtVDD) resistor r=0.00206 c=0
Rk51 (\2\:ExtVDD ExtVDD) resistor r=0.02213 c=0
Rk54 (ExtVDD \5\:ExtVDD) resistor r=0.02012 c=0
Rk55 (ExtVDD \6\:ExtVDD) resistor r=0.1495 c=0
Rk17 (\10\:SN SN) resistor r=0.02545 c=0
Rk18 (SN \11\:SN) resistor r=0.2163 c=0
Rk69 (\12\:SN \13\:SN) resistor r=0.5353 c=0
Rk78 (\2\:VDD \3\:VDD) resistor r=0.3366 c=0
Rk79 (\3\:VDD \4\:VDD) resistor r=0.1656 c=0
Rk81 (\6\:VDD VDD) resistor r=1.0044 c=0
Rk80 (\4\:VDD \6\:VDD) resistor r=0.1163 c=0
Rk82 (VDD \7\:VDD) resistor r=0.5191 c=0
Rk83 (\7\:VDD \8\:VDD) resistor r=0.23 c=0
Rk84 (\8\:VDD \10\:VDD) resistor r=0.1094 c=0
Rk85 (\3\:VDD \12\:VDD) resistor r=0.3561 c=0
Rk86 (\4\:VDD \14\:VDD) resistor r=0.301 c=0
Rk87 (\7\:VDD \16\:VDD) resistor r=0.3658 c=0
Rk88 (\8\:VDD \18\:VDD) resistor r=0.2067 c=0
Rk89 (\10\:VDD \19\:VDD) resistor r=0.09396 c=0
Rk90 (\19\:VDD \21\:VDD) resistor r=0.2286 c=0
Rk91 (\10\:VDD \23\:VDD) resistor r=0.2347 c=0
Rk94 (\24\:VDD VDD) resistor r=0.1953 c=0
Rk92 (\19\:VDD \24\:VDD) resistor r=0.07642 c=0
Rk93 (\24\:VDD \25\:VDD) resistor r=0.2186 c=0
Rk40 (SE \7\:SE) resistor r=0.05519 c=0
Rk1 (\9\:n20 \11\:n20) resistor r=0.5425 c=0
Rk2 (\11\:n20 \12\:n20) resistor r=0.2539 c=0
Rk4 (\14\:n20 \15\:n20) resistor r=0.3399 c=0
Rk5 (\14\:n20 \16\:n20) resistor r=0.2292 c=0
Rk6 (\16\:n20 \18\:n20) resistor r=0.4959 c=0
Rk22 (\19\:n20 \20\:n20) resistor r=0.2604 c=0
Rk3 (\14\:CKNb \15\:CKNb) resistor r=0.7504 c=0
Rk14 (\17\:CKNb \18\:CKNb) resistor r=0.3243 c=0
Rk15 (\18\:CKNb \19\:CKNb) resistor r=0.183 c=0
Rk16 (\18\:CKNb \21\:CKNb) resistor r=0.1863 c=0
Rk70 (\22\:CKNb \23\:CKNb) resistor r=0.8238 c=0
Rk26 (\6\:mout \7\:mout) resistor r=0.6015 c=0
Rk27 (\7\:mout \8\:mout) resistor r=0.3501 c=0
Rk28 (\8\:mout \9\:mout) resistor r=0.1024 c=0
Rk29 (\9\:mout \10\:mout) resistor r=0.3407 c=0
Rk30 (\7\:mout \12\:mout) resistor r=0.1277 c=0
Rk31 (\8\:mout \14\:mout) resistor r=0.09184 c=0
Rk32 (\9\:mout \16\:mout) resistor r=0.6351 c=0
Rk33 (\10\:mout \17\:mout) resistor r=0.4247 c=0
Rk7 (\11\:CKNbb \13\:CKNbb) resistor r=0.1419 c=0
Rk8 (\13\:CKNbb \14\:CKNbb) resistor r=0.4204 c=0
Rk9 (\14\:CKNbb \16\:CKNbb) resistor r=0.236 c=0
Rk46 (\17\:CKNbb \18\:CKNbb) resistor r=0.3711 c=0
Rk41 (\5\:SEb \6\:SEb) resistor r=0.2167 c=0
Rk42 (\6\:SEb \7\:SEb) resistor r=0.3464 c=0
Rk43 (\6\:SEb \9\:SEb) resistor r=0.3048 c=0
Rk47 (\7\:n35g \8\:n35g) resistor r=0.273 c=0
Rk48 (\7\:n35g \10\:n35g) resistor r=0.6908 c=0
Rk59 (\12\:n35g \13\:n35g) resistor r=0.2427 c=0
Rk60 (\13\:n35g \14\:n35g) resistor r=0.5649 c=0
Rk61 (\13\:n35g \16\:n35g) resistor r=0.4315 c=0
Rk56 (\12\:qbint \13\:qbint) resistor r=0.494 c=0
Rk57 (\13\:qbint \15\:qbint) resistor r=0.5666 c=0
Rk58 (\13\:qbint \17\:qbint) resistor r=0.1462 c=0
Rk71 (\18\:qbint \19\:qbint) resistor r=0.2116 c=0
Rk62 (\5\:RTb \7\:RTb) resistor r=0.216 c=0
Rk63 (\7\:RTb \8\:RTb) resistor r=0.4161 c=0
Rk64 (\8\:RTb \9\:RTb) resistor r=0.6878 c=0
Rk65 (\8\:RTb \11\:RTb) resistor r=0.3063 c=0
Rk44 (\5\:n35 \6\:n35) resistor r=0.4094 c=0
Rk45 (\6\:n35 \8\:n35) resistor r=0.29 c=0
Rk49 (\10\:n35 \11\:n35) resistor r=0.4005 c=0
Rk50 (\11\:n35 \13\:n35) resistor r=0.3296 c=0
Rk72 (\15\:n35 \16\:n35) resistor r=0.3034 c=0
Rk73 (\16\:n35 \18\:n35) resistor r=0.2669 c=0
Rk23 (\2\:Db \4\:Db) resistor r=0.635 c=0
Rk24 (\4\:Db \6\:Db) resistor r=1.316 c=0
Rk25 (\6\:Db \8\:Db) resistor r=0.6314 c=0
Rk77 (\2\:n11 \4\:n11) resistor r=0.6522 c=0
Rl15 (\2\:D \4\:D) resistor r=115.099 c=0
Rl13 (\1\:D \2\:D) resistor r=84.3295 c=0
Rl14 (\2\:D \3\:D) resistor r=5.1123 c=0
Rl52 (\7\:RT \8\:RT) resistor r=651.902 c=0
Rl39 (\1\:RT \2\:RT) resistor r=169.515 c=0
Rl42 (\4\:RT \6\:RT) resistor r=21.372 c=0
Rl41 (\4\:RT \5\:RT) resistor r=264.027 c=0
Rl40 (\3\:RT \4\:RT) resistor r=96.114 c=0
Rl22 (\2\:SI \3\:SI) resistor r=155.002 c=0
Rl21 (\1\:SI \2\:SI) resistor r=24.2328 c=0
Rl11 (\2\:CKN \4\:CKN) resistor r=147.791 c=0
Rl9 (\1\:CKN \2\:CKN) resistor r=63.1757 c=0
Rl10 (\2\:CKN \3\:CKN) resistor r=2.0166 c=0
Rl65 (\7\:SN \8\:SN) resistor r=366.394 c=0
Rl66 (\8\:SN \9\:SN) resistor r=284.764 c=0
Rl12 (\1\:SN \2\:SN) resistor r=37.2721 c=0
Rl55 (\4\:SN \6\:SN) resistor r=106.74 c=0
Rl53 (\3\:SN \4\:SN) resistor r=1145.23 c=0
Rl54 (\4\:SN \5\:SN) resistor r=8.9604 c=0
Rl25 (\3\:SE \4\:SE) resistor r=294.192 c=0
Rl27 (\5\:SE \6\:SE) resistor r=241.873 c=0
Rl24 (\2\:SE \3\:SE) resistor r=49.6369 c=0
Rl26 (\2\:SE \5\:SE) resistor r=147.714 c=0
Rl23 (\1\:SE \2\:SE) resistor r=0.767 c=0
Rl16 (\3\:n20 \4\:n20) resistor r=56.7001 c=0
Rl18 (\6\:n20 \7\:n20) resistor r=98.0144 c=0
Rl17 (\4\:n20 \5\:n20) resistor r=249.192 c=0
Rl1 (n20 \2\:n20) resistor r=123.512 c=0
Rl59 (\12\:CKNb \13\:CKNb) resistor r=166.412 c=0
Rl5 (\2\:CKNb \4\:CKNb) resistor r=63.2566 c=0
Rl4 (\2\:CKNb \3\:CKNb) resistor r=216.019 c=0
Rl3 (CKNb \2\:CKNb) resistor r=120.949 c=0
Rl6 (\3\:CKNb \5\:CKNb) resistor r=330.626 c=0
Rl47 (\6\:CKNb \7\:CKNb) resistor r=66.1349 c=0
Rl50 (\7\:CKNb \10\:CKNb) resistor r=762.322 c=0
Rl51 (\8\:CKNb \11\:CKNb) resistor r=60.7265 c=0
Rl49 (\8\:CKNb \9\:CKNb) resistor r=81.3209 c=0
Rl48 (\7\:CKNb \8\:CKNb) resistor r=462.851 c=0
Rl7 (mout \2\:mout) resistor r=24.2328 c=0
Rl8 (\3\:mout \4\:mout) resistor r=24.2328 c=0
Rl58 (\9\:CKNbb \10\:CKNbb) resistor r=870.726 c=0
Rl2 (CKNbb \2\:CKNbb) resistor r=138.16 c=0
Rl31 (\4\:CKNbb \7\:CKNbb) resistor r=127.816 c=0
Rl28 (\3\:CKNbb \4\:CKNbb) resistor r=349.798 c=0
Rl32 (\5\:CKNbb \8\:CKNbb) resistor r=128.908 c=0
Rl30 (\5\:CKNbb \6\:CKNbb) resistor r=84.3215 c=0
Rl29 (\4\:CKNbb \5\:CKNbb) resistor r=453.624 c=0
Rl19 (SEb \2\:SEb) resistor r=101.718 c=0
Rl20 (\2\:SEb \3\:SEb) resistor r=132.669 c=0
Rl35 (\3\:n35g \4\:n35g) resistor r=265.853 c=0
Rl34 (\2\:n35g \3\:n35g) resistor r=181.74 c=0
Rl36 (\2\:n35g \5\:n35g) resistor r=94.1963 c=0
Rl33 (n35g \2\:n35g) resistor r=2.4834 c=0
Rl60 (\6\:qbint \7\:qbint) resistor r=149.805 c=0
Rl64 (\10\:qbint \11\:qbint) resistor r=343.229 c=0
Rl46 (\3\:qbint \5\:qbint) resistor r=35.3072 c=0
Rl45 (\2\:qbint \4\:qbint) resistor r=70.093 c=0
Rl43 (qbint \2\:qbint) resistor r=112.732 c=0
Rl44 (\2\:qbint \3\:qbint) resistor r=152.601 c=0
Rl61 (\7\:qbint \8\:qbint) resistor r=99.804 c=0
Rl63 (\8\:qbint \10\:qbint) resistor r=180.657 c=0
Rl62 (\8\:qbint \9\:qbint) resistor r=458.889 c=0
Rl38 (\3\:RTb \4\:RTb) resistor r=239.402 c=0
Rl37 (RTb \2\:RTb) resistor r=112.412 c=0
Rl56 (n35 \2\:n35) resistor r=508.667 c=0
Rl57 (\2\:n35 \3\:n35) resistor r=334.803 c=0
Rz18 (\1\:Q \2\:Q) resistor r=37.5 c=0
Rz21 (\1\:VSS \2\:VSS) resistor r=37.5 c=0
Rz22 (\11\:VSS \12\:VSS) resistor r=75 c=0
Rz23 (\13\:VSS \14\:VSS) resistor r=75 c=0
Rz24 (\15\:VSS \16\:VSS) resistor r=75 c=0
Rz25 (\17\:VSS \18\:VSS) resistor r=75 c=0
Rz26 (\19\:VSS \20\:VSS) resistor r=75 c=0
Rz27 (\27\:VSS \28\:VSS) resistor r=75 c=0
Rz28 (\29\:VSS \30\:VSS) resistor r=75 c=0
Rz29 (\31\:VSS \32\:VSS) resistor r=37.5 c=0
Rz1 (\8\:n20 \9\:n20) resistor r=75 c=0
Rz2 (\17\:n20 \18\:n20) resistor r=75 c=0
Rz4 (\16\:CKNb \17\:CKNb) resistor r=75 c=0
Rz7 (\11\:mout \12\:mout) resistor r=75 c=0
Rz8 (\13\:mout \14\:mout) resistor r=75 c=0
Rz3 (\15\:CKNbb \16\:CKNbb) resistor r=75 c=0
Rz9 (\4\:SEb \5\:SEb) resistor r=75 c=0
Rz11 (\9\:n35g \10\:n35g) resistor r=75 c=0
Rz15 (\11\:n35g \12\:n35g) resistor r=75 c=0
Rz14 (\16\:qbint \17\:qbint) resistor r=75 c=0
Rz16 (\10\:RTb \11\:RTb) resistor r=75 c=0
Rz10 (\7\:n35 \8\:n35) resistor r=75 c=0
Rz12 (\12\:n35 \13\:n35) resistor r=75 c=0
Rz17 (\17\:n35 \18\:n35) resistor r=75 c=0
Rz5 (Db \2\:Db) resistor r=75 c=0
Rz6 (\7\:Db \8\:Db) resistor r=75 c=0
Ry20 (\4\:Q \5\:Q) resistor r=20.6667 c=0
Ry31 (\3\:VSS \4\:VSS) resistor r=10.3333 c=0
Ry32 (\3\:VSS \6\:VSS) resistor r=5.1667 c=0
Ry33 (\3\:VSS \10\:VSS) resistor r=5.1667 c=0
Ry34 (\21\:VSS \22\:VSS) resistor r=10.3333 c=0
Ry35 (\21\:VSS \25\:VSS) resistor r=5.1667 c=0
Ry36 (\21\:VSS \26\:VSS) resistor r=5.1667 c=0
Ry13 (\1\:ExtVDD \2\:ExtVDD) resistor r=62 c=0
Ry14 (\1\:ExtVDD \5\:ExtVDD) resistor r=62 c=0
Ry15 (\1\:ExtVDD \6\:ExtVDD) resistor r=62 c=0
Ry23 (\1\:VDD \2\:VDD) resistor r=62 c=0
Ry24 (\11\:VDD \12\:VDD) resistor r=20.6667 c=0
Ry25 (\13\:VDD \14\:VDD) resistor r=62 c=0
Ry26 (\15\:VDD \16\:VDD) resistor r=62 c=0
Ry27 (\17\:VDD \18\:VDD) resistor r=62 c=0
Ry28 (\20\:VDD \21\:VDD) resistor r=62 c=0
Ry29 (\22\:VDD \23\:VDD) resistor r=62 c=0
Ry30 (\20\:VDD \25\:VDD) resistor r=62 c=0
Ry1 (\10\:n20 \11\:n20) resistor r=62 c=0
Ry2 (\13\:n20 \14\:n20) resistor r=62 c=0
Ry4 (\20\:CKNb \21\:CKNb) resistor r=62 c=0
Ry7 (\5\:mout \6\:mout) resistor r=62 c=0
Ry8 (\15\:mout \16\:mout) resistor r=62 c=0
Ry3 (\12\:CKNbb \13\:CKNbb) resistor r=62 c=0
Ry9 (\8\:SEb \9\:SEb) resistor r=62 c=0
Ry11 (\6\:n35g \7\:n35g) resistor r=62 c=0
Ry17 (\15\:n35g \16\:n35g) resistor r=62 c=0
Ry16 (\14\:qbint \15\:qbint) resistor r=62 c=0
Ry18 (\6\:RTb \7\:RTb) resistor r=62 c=0
Ry10 (\4\:n35 \5\:n35) resistor r=62 c=0
Ry12 (\9\:n35 \10\:n35) resistor r=62 c=0
Ry19 (\14\:n35 \15\:n35) resistor r=62 c=0
Ry5 (\3\:Db \4\:Db) resistor r=62 c=0
Ry6 (\5\:Db \6\:Db) resistor r=62 c=0
Ry21 (n11 \2\:n11) resistor r=62 c=0
Ry22 (\3\:n11 \4\:n11) resistor r=62 c=0
Rx12 (\3\:D \6\:D) resistor r=45 c=0
Rx29 (\3\:RT \9\:RT) resistor r=45 c=0
Rx30 (\1\:RT \10\:RT) resistor r=45 c=0
Rx31 (\7\:RT \11\:RT) resistor r=45 c=0
Rx17 (\2\:SI \4\:SI) resistor r=45 c=0
Rx8 (\3\:CKN \7\:CKN) resistor r=45 c=0
Rx10 (\5\:SN \10\:SN) resistor r=45 c=0
Rx11 (\2\:SN \11\:SN) resistor r=45 c=0
Rx32 (\3\:SN \12\:SN) resistor r=45 c=0
Rx33 (\9\:SN \13\:SN) resistor r=45 c=0
Rx18 (\1\:SE \7\:SE) resistor r=45 c=0
Rx1 (n20 \12\:n20) resistor r=45 c=0
Rx4 (\2\:n20 \15\:n20) resistor r=45 c=0
Rx5 (\5\:n20 \16\:n20) resistor r=45 c=0
Rx13 (\4\:n20 \19\:n20) resistor r=45 c=0
Rx14 (\6\:n20 \20\:n20) resistor r=45 c=0
Rx2 (\5\:CKNb \14\:CKNb) resistor r=45 c=0
Rx3 (\9\:CKNb \15\:CKNb) resistor r=45 c=0
Rx9 (\2\:CKNb \19\:CKNb) resistor r=45 c=0
Rx34 (\13\:CKNb \22\:CKNb) resistor r=45 c=0
Rx35 (\10\:CKNb \23\:CKNb) resistor r=45 c=0
Rx15 (\4\:mout \10\:mout) resistor r=45 c=0
Rx16 (\2\:mout \17\:mout) resistor r=45 c=0
Rx6 (\6\:CKNbb \11\:CKNbb) resistor r=45 c=0
Rx7 (\2\:CKNbb \14\:CKNbb) resistor r=45 c=0
Rx21 (\3\:CKNbb \17\:CKNbb) resistor r=45 c=0
Rx22 (\10\:CKNbb \18\:CKNbb) resistor r=45 c=0
Rx19 (\2\:SEb \7\:SEb) resistor r=45 c=0
Rx23 (\4\:n35g \8\:n35g) resistor r=45 c=0
Rx26 (n35g \14\:n35g) resistor r=45 c=0
Rx25 (\3\:qbint \12\:qbint) resistor r=45 c=0
Rx36 (\9\:qbint \18\:qbint) resistor r=45 c=0
Rx37 (qbint \19\:qbint) resistor r=45 c=0
Rx27 (\3\:RTb \5\:RTb) resistor r=45 c=0
Rx28 (RTb \9\:RTb) resistor r=45 c=0
Rx20 (\3\:n35 \6\:n35) resistor r=45 c=0
Rx24 (\2\:n35 \11\:n35) resistor r=45 c=0
Rx38 (n35 \16\:n35) resistor r=45 c=0
mn10 (\4\:SEb \5\:SE \17\:VSS VSS) g45n1svt w=(1.45e-07) l=4.5e-08 nf=1 \
        as=2.32e-14 ad=2.03e-14 ps=6.1e-07 pd=5.7e-07 nrd=1.16667 \
        nrs=1.16667 sa=7.6e-07 sb=1.4e-07 sd=160n sca=8.85152 \
        scb=0.00706865 scc=0.000138481 m=(1)
mn21 (\15\:CKNbb CKNb \11\:VSS VSS) g45n1svt w=(1.45e-07) l=4.5e-08 nf=1 \
        as=2.32e-14 ad=2.03e-14 ps=6.1e-07 pd=5.7e-07 nrd=1.16667 \
        nrs=1.16667 sa=1.4e-07 sb=3.45e-07 sd=160n sca=8.0352 \
        scb=0.00565402 scc=8.19771e-05 m=(1)
mn20 (\16\:CKNb \1\:CKN \11\:VSS VSS) g45n1svt w=(1.45e-07) l=4.5e-08 \
        nf=1 as=2.03e-14 ad=2.32e-14 ps=5.7e-07 pd=6.1e-07 nrd=1.16667 \
        nrs=1.16667 sa=3.45e-07 sb=1.4e-07 sd=160n sca=8.0352 \
        scb=0.00565402 scc=8.19771e-05 m=(1)
mn12 (Db \3\:SEb n0 VSS) g45n1svt w=(1.45e-07) l=4.5e-08 nf=1 as=2.32e-14 \
        ad=8.7e-15 ps=6.1e-07 pd=4.1e-07 nrd=1.16667 nrs=1.16667 \
        sa=2.45e-07 sb=6.55e-07 sd=160n sca=8.85152 scb=0.00706865 \
        scc=0.000138481 m=(1)
mn13 (n2 \1\:SI \17\:VSS VSS) g45n1svt w=(1.45e-07) l=4.5e-08 nf=1 \
        as=2.32e-14 ad=8.7e-15 ps=6.1e-07 pd=4.1e-07 nrd=1.16667 \
        nrs=1.16667 sa=5.55e-07 sb=3.45e-07 sd=160n sca=8.85152 \
        scb=0.00706865 scc=0.000138481 m=(1)
mn25 (\7\:Db CKNbb \8\:n20 VSS) g45n1svt w=(1.45e-07) l=4.5e-08 nf=1 \
        as=2.03e-14 ad=2.03e-14 ps=5.7e-07 pd=5.7e-07 nrd=1.16667 \
        nrs=1.16667 sa=1.4e-07 sb=1.4e-07 sd=160n sca=8.0352 \
        scb=0.00565402 scc=8.19771e-05 m=(1)
mn36 (\17\:n20 \11\:CKNb n6 VSS) g45n1svt w=(1.45e-07) l=4.5e-08 nf=1 \
        as=8.7e-15 ad=2.03e-14 ps=4.1e-07 pd=5.7e-07 nrd=1.16667 \
        nrs=1.16667 sa=1.4e-07 sb=7.3e-07 sd=160n sca=8.42104 \
        scb=0.00632542 scc=0.000106623 m=(1)
mn35 (n6 \3\:mout \31\:VSS VSS) g45n1svt w=(1.45e-07) l=4.5e-08 nf=1 \
        as=4.858e-14 ad=8.7e-15 ps=9.6e-07 pd=4.1e-07 nrd=1.16667 \
        nrs=1.16667 sa=2.45e-07 sb=6.25e-07 sd=160n sca=8.42104 \
        scb=0.00632542 scc=0.000106623 m=(1)
mn30 (net0118 \6\:SN \31\:VSS VSS) g45n1svt w=(1.45e-07) l=4.5e-08 nf=1 \
        as=4.858e-14 ad=8.7e-15 ps=9.6e-07 pd=4.1e-07 nrd=1.16667 \
        nrs=1.16667 sa=6.25e-07 sb=2.45e-07 sd=160n sca=8.42104 \
        scb=0.00632542 scc=0.000106623 m=(1)
mn32 (\13\:mout \7\:n20 net0118 VSS) g45n1svt w=(1.45e-07) l=4.5e-08 nf=1 \
        as=8.7e-15 ad=2.03e-14 ps=4.1e-07 pd=5.7e-07 nrd=1.16667 \
        nrs=1.16667 sa=7.3e-07 sb=1.4e-07 sd=160n sca=8.42104 \
        scb=0.00632542 scc=0.000106623 m=(1)
mn11 (n0 \1\:D \19\:VSS VSS) g45n1svt w=(1.45e-07) l=4.5e-08 nf=1 \
        as=2.03e-14 ad=8.7e-15 ps=5.7e-07 pd=4.1e-07 nrd=1.16667 \
        nrs=1.16667 sa=1.4e-07 sb=7.6e-07 sd=160n sca=8.85152 \
        scb=0.00706865 scc=0.000138481 m=(1)
mn14 (Db \6\:SE n2 VSS) g45n1svt w=(1.45e-07) l=4.5e-08 nf=1 as=8.7e-15 \
        ad=2.32e-14 ps=4.1e-07 pd=6.1e-07 nrd=1.16667 nrs=1.16667 \
        sa=4.5e-07 sb=4.5e-07 sd=160n sca=8.85152 scb=0.00706865 \
        scc=0.000138481 m=(1)
mn40 (\7\:n35 \6\:CKNb \11\:mout VSS) g45n1svt w=(1.45e-07) l=4.5e-08 \
        nf=1 as=2.03e-14 ad=2.03e-14 ps=5.7e-07 pd=5.7e-07 nrd=1.16667 \
        nrs=1.16667 sa=1.4e-07 sb=1.4e-07 sd=160n sca=8.42104 \
        scb=0.00632542 scc=0.000106623 m=(1)
NM0 (\9\:n35g \2\:RTb \12\:n35 VSS) g45n1svt w=(1.45e-07) l=4.5e-08 nf=1 \
        as=2.03e-14 ad=2.03e-14 ps=5.7e-07 pd=5.7e-07 nrd=1.16667 \
        nrs=1.16667 sa=1.4e-07 sb=1.4e-07 sd=160n sca=8.42104 \
        scb=0.00632542 scc=0.000106623 m=(1)
mn45 (\16\:qbint \5\:n35g \15\:VSS VSS) g45n1svt w=(1.45e-07) l=4.5e-08 \
        nf=1 as=2.03e-14 ad=2.03e-14 ps=5.7e-07 pd=5.7e-07 nrd=1.16667 \
        nrs=1.16667 sa=1.4e-07 sb=1.4e-07 sd=160n sca=9.33388 \
        scb=0.00788941 scc=0.00017958 m=(1)
NM3 (net0134 \5\:qbint \13\:VSS VSS) g45n1svt w=(1.45e-07) l=4.5e-08 \
        nf=1 as=2.03e-14 ad=8.7e-15 ps=5.7e-07 pd=4.1e-07 nrd=1.16667 \
        nrs=1.16667 sa=1.4e-07 sb=2.45e-07 sd=160n sca=9.33388 \
        scb=0.00788941 scc=0.00017958 m=(1)
NM1 (\10\:RTb \2\:RT \29\:VSS VSS) g45n1svt w=(1.45e-07) l=4.5e-08 nf=1 \
        as=2.03e-14 ad=2.03e-14 ps=5.7e-07 pd=5.7e-07 nrd=1.16667 \
        nrs=1.16667 sa=1.4e-07 sb=1.4e-07 sd=160n sca=8.42104 \
        scb=0.00632542 scc=0.000106623 m=(1)
NM2 (\11\:n35g \8\:RT net0134 VSS) g45n1svt w=(1.45e-07) l=4.5e-08 nf=1 \
        as=8.7e-15 ad=2.03e-14 ps=4.1e-07 pd=5.7e-07 nrd=1.16667 \
        nrs=1.16667 sa=2.45e-07 sb=1.4e-07 sd=160n sca=9.33388 \
        scb=0.00788941 scc=0.00017958 m=(1)
mn53 (\17\:n35 \9\:CKNbb net0119 VSS) g45n1svt w=(1.45e-07) l=4.5e-08 \
        nf=1 as=8.7e-15 ad=2.03e-14 ps=4.1e-07 pd=5.7e-07 nrd=1.16667 \
        nrs=1.16667 sa=1.4e-07 sb=3.5e-07 sd=160n sca=8.42104 \
        scb=0.00632542 scc=0.000106623 m=(1)
mn52 (net0119 \11\:qbint net0117 VSS) g45n1svt w=(1.45e-07) l=4.5e-08 \
        nf=1 as=8.7e-15 ad=8.7e-15 ps=4.1e-07 pd=4.1e-07 nrd=1.16667 \
        nrs=1.16667 sa=2.45e-07 sb=2.45e-07 sd=160n sca=8.42104 \
        scb=0.00632542 scc=0.000106623 m=(1)
mn50 (net0117 \8\:SN \27\:VSS VSS) g45n1svt w=(1.45e-07) l=4.5e-08 nf=1 \
        as=2.03e-14 ad=8.7e-15 ps=5.7e-07 pd=4.1e-07 nrd=1.16667 \
        nrs=1.16667 sa=3.5e-07 sb=1.4e-07 sd=160n sca=8.42104 \
        scb=0.00632542 scc=0.000106623 m=(1)
mn55 (\1\:Q \6\:qbint \1\:VSS VSS) g45n1svt w=(2.6e-07) l=4.5e-08 nf=1 \
        as=3.64e-14 ad=3.64e-14 ps=8e-07 pd=8e-07 nrd=1.16667 nrs=1.16667 \
        sa=1.4e-07 sb=1.4e-07 sd=160n sca=9.50447 scb=0.0081528 \
        scc=0.00025289 m=(1)
mp55 (\4\:Q \7\:qbint \11\:VDD VDD) g45p1svt w=(3.9e-07) l=4.5e-08 nf=1 \
        as=5.46e-14 ad=5.46e-14 ps=1.06e-06 pd=1.06e-06 nrd=1.16667 \
        nrs=1.16667 sa=1.4e-07 sb=1.4e-07 sd=160n sca=18.88 scb=0.0166149 \
        scc=0.00148638 m=(1)
ends SRDFFNSQX1
// End of subcircuit definition.
