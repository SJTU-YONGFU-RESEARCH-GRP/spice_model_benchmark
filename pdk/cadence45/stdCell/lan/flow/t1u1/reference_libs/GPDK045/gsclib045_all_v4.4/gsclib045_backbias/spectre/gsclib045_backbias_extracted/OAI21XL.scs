// Generated for: spectre (May  1 11:31:22 2013 )
// Library name: gsclib045_backbias
// Cell name: OAI21XL
// View name: extracted

simulator lang=spectre

subckt OAI21XL A0 A1 B0 NW VDD VSS Y
mp0 (n1 \1\:A0 \4\:VDD NW) g45p1svt w=(2.15e-07) l=4.5e-08 nf=1 \
        as=3.01e-14 ad=3.44e-14 ps=7.1e-07 pd=7.5e-07 nrd=1.16667 \
        nrs=1.16667 sa=1.4e-07 sb=6.45e-07 sd=160n sca=19.4229 \
        scb=0.0204259 scc=0.000577964 m=(1)
mp1 (\3\:Y \1\:A1 n1 NW) g45p1svt w=(2.15e-07) l=4.5e-08 nf=1 as=3.44e-14 \
        ad=5.483e-14 ps=7.5e-07 pd=9.4e-07 nrd=1.16667 nrs=1.16667 \
        sa=3.45e-07 sb=4.4e-07 sd=160n sca=14.8962 scb=0.0119773 \
        scc=0.000116187 m=(1)
mp2 (\3\:Y \1\:B0 \1\:VDD NW) g45p1svt w=(2.15e-07) l=4.5e-08 nf=1 \
        as=3.01e-14 ad=5.483e-14 ps=7.1e-07 pd=9.4e-07 nrd=1.16667 \
        nrs=1.16667 sa=6.45e-07 sb=1.4e-07 sd=160n sca=22.0785 \
        scb=0.0241761 scc=0.00103379 m=(1)
C1 (NW VSS) capacitor c=2.16713e-16
C2 (A1 VSS) capacitor c=4.62877e-17
C3 (Y VSS) capacitor c=8.00603e-17
C4 (A0 VSS) capacitor c=6.92329e-17
C5 (B0 VSS) capacitor c=1.23861e-16
C6 (VDD VSS) capacitor c=2.58093e-17
C7 (n0 VSS) capacitor c=4.94932e-17
C8 (\1\:B0 VSS) capacitor c=4.4533e-17
C9 (\1\:A1 VSS) capacitor c=4.79558e-17
C10 (\1\:A0 VSS) capacitor c=3.40546e-17
C11 (\3\:B0 VSS) capacitor c=2.84243e-17
C12 (\3\:A1 VSS) capacitor c=4.58349e-17
C13 (\4\:A0 VSS) capacitor c=5.05288e-17
C14 (\2\:B0 VSS) capacitor c=4.93716e-17
C15 (\2\:A1 VSS) capacitor c=5.54226e-17
C16 (\3\:A0 VSS) capacitor c=1.72885e-17
C17 (\1\:VDD VSS) capacitor c=8.26145e-17
C18 (\3\:Y VSS) capacitor c=6.42342e-17
C19 (\4\:VDD VSS) capacitor c=2.18101e-17
C20 (\1\:Y VSS) capacitor c=6.23607e-17
C21 (\3\:n0 VSS) capacitor c=8.05906e-17
C22 (\2\:A0 VSS) capacitor c=3.73052e-17
C23 (\4\:A1 VSS) capacitor c=5.06674e-17
C24 (\3\:VDD VSS) capacitor c=5.26685e-17
Rk2 (A1 \4\:A1) resistor r=0.2246 c=0
Rk5 (\2\:Y Y) resistor r=0.4753 c=0
Rk6 (Y \4\:Y) resistor r=0.3247 c=0
Rk1 (\5\:A0 A0) resistor r=0.002995 c=0
Rk11 (\3\:VSS VSS) resistor r=0.1349 c=0
Rk12 (\3\:VSS \5\:VSS) resistor r=0.2805 c=0
Rk4 (\4\:B0 B0) resistor r=0.002995 c=0
Rk8 (\3\:VDD VDD) resistor r=0.03213 c=0
Rk7 (\2\:VDD \3\:VDD) resistor r=0.529 c=0
Rk9 (\3\:VDD \5\:VDD) resistor r=0.1731 c=0
Rk3 (\2\:n0 \4\:n0) resistor r=0.4851 c=0
Rl4 (\1\:A1 \2\:A1) resistor r=143 c=0
Rl5 (\2\:A1 \3\:A1) resistor r=116.076 c=0
Rl1 (\1\:A0 \2\:A0) resistor r=81.5719 c=0
Rl3 (\2\:A0 \4\:A0) resistor r=193.11 c=0
Rl2 (\2\:A0 \3\:A0) resistor r=14.2236 c=0
Rl6 (\1\:B0 \2\:B0) resistor r=221.551 c=0
Rl7 (\2\:B0 \3\:B0) resistor r=39.5604 c=0
Rz3 (\1\:Y \2\:Y) resistor r=75 c=0
Rz4 (\4\:VSS \5\:VSS) resistor r=75 c=0
Rz1 (n0 \2\:n0) resistor r=75 c=0
Rz2 (\3\:n0 \4\:n0) resistor r=75 c=0
Ry1 (\3\:Y \4\:Y) resistor r=62 c=0
Ry2 (\1\:VDD \2\:VDD) resistor r=62 c=0
Ry3 (\4\:VDD \5\:VDD) resistor r=62 c=0
Rx2 (\2\:A1 \4\:A1) resistor r=45 c=0
Rx1 (\3\:A0 \5\:A0) resistor r=45 c=0
Rx3 (\2\:B0 \4\:B0) resistor r=45 c=0
mn0 (n0 \4\:A0 \4\:VSS VSS) g45n1svt w=(1.45e-07) l=4.5e-08 nf=1 \
        as=2.32e-14 ad=2.03e-14 ps=6.1e-07 pd=5.7e-07 nrd=1.16667 \
        nrs=1.16667 sa=1.4e-07 sb=5.55e-07 sd=160n sca=10.4914 \
        scb=0.00978575 scc=0.000300434 m=(1)
mn1 (\3\:n0 \3\:A1 \4\:VSS VSS) g45n1svt w=(1.45e-07) l=4.5e-08 nf=1 \
        as=2.32e-14 ad=2.392e-14 ps=6.1e-07 pd=6.2e-07 nrd=1.16667 \
        nrs=1.16667 sa=3.45e-07 sb=3.5e-07 sd=160n sca=10.4914 \
        scb=0.00978575 scc=0.000300434 m=(1)
mn2 (\1\:Y \3\:B0 \3\:n0 VSS) g45n1svt w=(1.45e-07) l=4.5e-08 nf=1 \
        as=2.392e-14 ad=2.03e-14 ps=6.2e-07 pd=5.7e-07 nrd=1.16667 \
        nrs=1.16667 sa=5.55e-07 sb=1.4e-07 sd=160n sca=10.4914 \
        scb=0.00978575 scc=0.000300434 m=(1)
ends OAI21XL
// End of subcircuit definition.
