// gsclib045_lvt/NOR4BBX4/schematic

simulator lang=spectre

subckt NOR4BBX4 AN BN C D Y VSS VDD
mp0 (n0 AN VDD VDD) g45p1lvt w=(390n) l=45n nf=1 m=(1)
mp5 (Y D n4 VDD) g45p1lvt w=(1.56u) l=45n nf=1 m=(1)
mp4 (n4 C n3 VDD) g45p1lvt w=(1.56u) l=45n nf=1 m=(1)
mp1 (n1 BN VDD VDD) g45p1lvt w=(390n) l=45n nf=1 m=(1)
mp3 (n3 n1 n2 VDD) g45p1lvt w=(1.56u) l=45n nf=1 m=(1)
mp2 (n2 n0 VDD VDD) g45p1lvt w=(1.56u) l=45n nf=1 m=(1)
mn2 (Y n0 VSS VSS) g45n1lvt w=(1.04u) l=45n nf=1 m=(1)
mn1 (n1 BN VSS VSS) g45n1lvt w=(260n) l=45n nf=1 m=(1)
mn3 (Y n1 VSS VSS) g45n1lvt w=(1.04u) l=45n nf=1 m=(1)
mn5 (Y D VSS VSS) g45n1lvt w=(1.04u) l=45n nf=1 m=(1)
mn4 (Y C VSS VSS) g45n1lvt w=(1.04u) l=45n nf=1 m=(1)
mn0 (n0 AN VSS VSS) g45n1lvt w=(260n) l=45n nf=1 m=(1)
ends NOR4BBX4
