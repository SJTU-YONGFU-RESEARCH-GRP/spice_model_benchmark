// Generated for: spectre (May  1 11:31:38 2013 )
// Library name: gsclib045_backbias
// Cell name: OAI2BB2X2
// View name: extracted

simulator lang=spectre

subckt OAI2BB2X2 A0N A1N B0 B1 NW VDD VSS Y
mp1 (\10\:n1 \1\:A1N \10\:VDD NW) g45p1svt w=(2.15e-07) l=4.5e-08 nf=1 \
        as=8.062e-14 ad=3.01e-14 ps=1.18e-06 pd=7.1e-07 nrd=1.16667 \
        nrs=1.16667 sa=1.4e-07 sb=5.8e-07 sd=160n sca=52.067 scb=0.0373106 \
        scc=0.00610613 m=(1)
mp0 (\13\:n0 \4\:A0N \10\:VDD NW) g45p1svt w=(2.15e-07) l=4.5e-08 nf=1 \
        as=8.062e-14 ad=3.44e-14 ps=1.18e-06 pd=7.5e-07 nrd=1.16667 \
        nrs=1.16667 sa=5.6e-07 sb=1.6e-07 sd=160n sca=46.4272 \
        scb=0.0285818 scc=0.00588427 m=(1)
C1 (NW VSS) capacitor c=4.24933e-16
C2 (A0N VSS) capacitor c=5.50107e-17
C3 (B0 VSS) capacitor c=1.72402e-17
C4 (Y VSS) capacitor c=3.54616e-17
C5 (A1N VSS) capacitor c=1.2873e-16
C6 (VDD VSS) capacitor c=3.86764e-17
C7 (B1 VSS) capacitor c=8.4726e-17
C8 (n1 VSS) capacitor c=4.65766e-17
C9 (n0 VSS) capacitor c=5.6244e-17
C10 (n4 VSS) capacitor c=7.95853e-17
C11 (5 VSS) capacitor c=3.14137e-18
C12 (7 VSS) capacitor c=4.39937e-18
C13 (6 VSS) capacitor c=4.42239e-18
C14 (9 VSS) capacitor c=1.50384e-18
C15 (\6\:B0 VSS) capacitor c=8.51262e-17
C16 (\6\:B1 VSS) capacitor c=6.35455e-17
C17 (\5\:B1 VSS) capacitor c=4.53854e-17
C18 (\1\:B0 VSS) capacitor c=5.70757e-17
C19 (\4\:n0 VSS) capacitor c=5.33468e-17
C20 (\6\:n1 VSS) capacitor c=5.57491e-17
C21 (\4\:A0N VSS) capacitor c=2.28545e-17
C22 (\1\:A1N VSS) capacitor c=2.7023e-17
C23 (\1\:B1 VSS) capacitor c=1.07499e-16
C24 (\1\:A0N VSS) capacitor c=2.39614e-17
C25 (\3\:A1N VSS) capacitor c=1.86659e-17
C26 (\2\:B0 VSS) capacitor c=3.74796e-16
C27 (\2\:n0 VSS) capacitor c=3.26373e-16
C28 (\3\:A0N VSS) capacitor c=2.92287e-17
C29 (\2\:A1N VSS) capacitor c=2.91669e-17
C30 (\1\:VDD VSS) capacitor c=9.79126e-17
C31 (\8\:Y VSS) capacitor c=5.87645e-17
C32 (\6\:VDD VSS) capacitor c=3.88355e-17
C33 (\1\:Y VSS) capacitor c=3.68699e-17
C34 (\8\:VDD VSS) capacitor c=4.06362e-17
C35 (\13\:n0 VSS) capacitor c=1.85006e-17
C36 (\10\:VDD VSS) capacitor c=4.9908e-17
C37 (\10\:n1 VSS) capacitor c=5.83172e-17
C38 (\7\:n4 VSS) capacitor c=9.40191e-17
C39 (\11\:n0 VSS) capacitor c=5.27752e-17
C40 (\8\:n1 VSS) capacitor c=2.1019e-16
C41 (\2\:n1 VSS) capacitor c=1.33746e-16
C42 (\4\:B1 VSS) capacitor c=2.92233e-17
C43 (\5\:A0N VSS) capacitor c=6.74873e-17
C44 (\7\:n1 VSS) capacitor c=1.94739e-16
C45 (\10\:n0 VSS) capacitor c=6.56151e-17
C46 (\3\:Y VSS) capacitor c=2.83883e-17
C47 (\4\:Y VSS) capacitor c=1.06375e-16
C48 (\5\:Y VSS) capacitor c=1.88292e-16
C49 (\7\:B1 VSS) capacitor c=3.60051e-17
C50 (\2\:n4 VSS) capacitor c=1.72765e-16
C51 (\3\:VDD VSS) capacitor c=9.03273e-17
C52 (\4\:VDD VSS) capacitor c=7.74857e-17
C53 (\5\:VDD VSS) capacitor c=6.35391e-17
Rk2 (\5\:A0N A0N) resistor r=0.1983 c=0
Rk18 (\2\:B0 B0) resistor r=0.01895 c=0
Rk10 (\3\:Y Y) resistor r=0.1229 c=0
Rk9 (\2\:Y \3\:Y) resistor r=0.1205 c=0
Rk11 (\3\:Y \4\:Y) resistor r=0.2838 c=0
Rk12 (\4\:Y \5\:Y) resistor r=0.4737 c=0
Rk14 (\4\:Y \9\:Y) resistor r=0.4072 c=0
Rk1 (A1N \4\:A1N) resistor r=0.00411 c=0
Rk30 (\2\:VSS \3\:VSS) resistor r=0.4709 c=0
Rk32 (\3\:VSS \5\:VSS) resistor r=0.1101 c=0
Rk34 (\6\:VSS VSS) resistor r=0.2025 c=0
Rk33 (\5\:VSS \6\:VSS) resistor r=0.3481 c=0
Rk37 (\6\:VSS \12\:VSS) resistor r=0.188 c=0
Rk23 (\2\:VDD \3\:VDD) resistor r=0.5636 c=0
Rk24 (\3\:VDD \4\:VDD) resistor r=0.3805 c=0
Rk26 (\5\:VDD VDD) resistor r=0.1574 c=0
Rk25 (\4\:VDD \5\:VDD) resistor r=0.4456 c=0
Rk27 (\3\:VDD \7\:VDD) resistor r=0.1849 c=0
Rk28 (\4\:VDD \9\:VDD) resistor r=0.279 c=0
Rk29 (\5\:VDD \11\:VDD) resistor r=0.4195 c=0
Rk16 (\7\:B1 B1) resistor r=0.06822 c=0
Rk3 (\7\:n1 \9\:n1) resistor r=1.4234 c=0
Rk4 (\9\:n1 \11\:n1) resistor r=0.4681 c=0
Rk6 (\2\:n0 \10\:n0) resistor r=0.3619 c=0
Rk7 (\10\:n0 \12\:n0) resistor r=0.2495 c=0
Rk8 (\10\:n0 \14\:n0) resistor r=0.1364 c=0
Rl5 (\2\:A0N \4\:A0N) resistor r=84.3339 c=0
Rl3 (\1\:A0N \2\:A0N) resistor r=67.0262 c=0
Rl4 (\2\:A0N \3\:A0N) resistor r=3.3229 c=0
Rl24 (\2\:B0 \6\:B0) resistor r=115.362 c=0
Rl16 (\2\:B0 \1\:B0) resistor r=75.6918 c=0
Rl1 (\1\:A1N \2\:A1N) resistor r=71.1538 c=0
Rl2 (\2\:A1N \3\:A1N) resistor r=53.022 c=0
Rl22 (\4\:B1 \6\:B1) resistor r=59.1794 c=0
Rl21 (\4\:B1 \5\:B1) resistor r=103.331 c=0
Rl20 (\4\:B1 \1\:B1) resistor r=6.3032 c=0
Rl8 (\2\:n1 n1) resistor r=181.926 c=0
Rl12 (\2\:n1 \6\:n1) resistor r=160.771 c=0
Rl13 (\2\:n0 \4\:n0) resistor r=105.483 c=0
Rl6 (\2\:n0 n0) resistor r=92.1028 c=0
Rz12 (\12\:VSS \11\:VSS) resistor r=75 c=0
Rz1 (\9\:n1 \8\:n1) resistor r=75 c=0
Rz2 (\12\:n0 \11\:n0) resistor r=75 c=0
Rz8 (\2\:n4 \7\:n4) resistor r=75 c=0
Rz5 (\2\:n4 n4) resistor r=75 c=0
Ry3 (\2\:Y \1\:Y) resistor r=20.6667 c=0
Ry4 (\9\:Y \8\:Y) resistor r=62 c=0
Ry9 (\2\:VSS \1\:VSS) resistor r=15.5 c=0
Ry10 (\5\:VSS \1\:VSS) resistor r=5.1667 c=0
Ry5 (\1\:VDD \2\:VDD) resistor r=62 c=0
Ry6 (\6\:VDD \7\:VDD) resistor r=62 c=0
Ry7 (\8\:VDD \9\:VDD) resistor r=20.6667 c=0
Ry8 (\10\:VDD \11\:VDD) resistor r=62 c=0
Ry1 (\11\:n1 \10\:n1) resistor r=62 c=0
Ry2 (\14\:n0 \13\:n0) resistor r=62 c=0
Rx2 (\3\:A0N \5\:A0N) resistor r=45 c=0
Rx1 (\2\:A1N \4\:A1N) resistor r=45 c=0
Rx6 (\7\:B1 \1\:B1) resistor r=45 c=0
Rx3 (\7\:n1 \2\:n1) resistor r=45 c=0
mn1 (\8\:n1 \3\:A1N \11\:VSS VSS) g45n1svt w=(1.45e-07) l=4.5e-08 nf=1 \
        as=1.09e-13 ad=2.03e-14 ps=1.44e-06 pd=5.7e-07 nrd=1.16667 \
        nrs=1.16667 sa=1.4e-07 sb=6.35e-07 sd=160n sca=10.0732 \
        scb=0.00911402 scc=0.000253284 m=(1)
mn0 (\11\:n0 \1\:A0N \11\:VSS VSS) g45n1svt w=(1.45e-07) l=4.5e-08 nf=1 \
        as=1.09e-13 ad=2.03e-14 ps=1.44e-06 pd=5.7e-07 nrd=1.16667 \
        nrs=1.16667 sa=6.35e-07 sb=1.4e-07 sd=160n sca=10.0732 \
        scb=0.00911402 scc=0.000253284 m=(1)
mn4_1__rcx (\5\:Y \2\:B0 \2\:n4 VSS) g45n1svt w=(2.6e-07) l=4.5e-08 nf=1 \
        as=4.42e-14 ad=6.045e-14 ps=8.6e-07 pd=9.85e-07 nrd=1.16667 \
        nrs=1.16667 sa=1.045e-06 sb=9e-07 sd=160n sca=7.84363 \
        scb=0.00546499 scc=9.84911e-05 m=(2)
mn2 (\2\:n4 \2\:n0 \3\:VSS VSS) g45n1svt w=(2.6e-07) l=4.5e-08 nf=1 \
        as=4.55e-14 ad=4.615e-14 ps=8.7e-07 pd=8.75e-07 nrd=1.16667 \
        nrs=1.16667 sa=1.55e-07 sb=1.79e-06 sd=160n sca=7.84363 \
        scb=0.00546499 scc=9.84911e-05 m=(2)
mn3_1__rcx (n4 \2\:n1 \3\:VSS VSS) g45n1svt w=(2.6e-07) l=4.5e-08 nf=1 \
        as=4.55e-14 ad=4.16e-14 ps=8.7e-07 pd=8.4e-07 nrd=1.16667 \
        nrs=1.16667 sa=3.75e-07 sb=1.57e-06 sd=160n sca=7.84363 \
        scb=0.00546499 scc=9.84911e-05 m=(2)
mn5_1__rcx (\5\:Y \1\:B1 \7\:n4 VSS) g45n1svt w=(2.6e-07) l=4.5e-08 nf=1 \
        as=4.16e-14 ad=6.045e-14 ps=8.4e-07 pd=9.85e-07 nrd=1.16667 \
        nrs=1.16667 sa=1.25e-06 sb=6.95e-07 sd=160n sca=7.84363 \
        scb=0.00546499 scc=9.84911e-05 m=(2)
mp2_1__rcx (5 n0 \8\:VDD NW) g45p1svt w=(3.9e-07) l=4.5e-08 nf=1 \
        as=5.46e-14 ad=4.485e-14 ps=1.06e-06 pd=1.01e-06 nrd=1.16667 \
        nrs=1.16667 sa=1.4e-07 sb=1.44e-06 sd=160n sca=11.8275 \
        scb=0.0101379 scc=0.000311481 m=(1)
mp3_1__rcx (\1\:Y \6\:n1 5 NW) g45p1svt w=(3.9e-07) l=4.5e-08 nf=1 \
        as=4.485e-14 ad=6.24e-14 ps=1.01e-06 pd=1.1e-06 nrd=1.16667 \
        nrs=1.16667 sa=3e-07 sb=1.28e-06 sd=160n sca=11.8275 scb=0.0101379 \
        scc=0.000311481 m=(1)
mp3 (\1\:Y n1 7 NW) g45p1svt w=(3.9e-07) l=4.5e-08 nf=1 as=6.825e-14 \
        ad=6.24e-14 ps=1.13e-06 pd=1.1e-06 nrd=1.16667 nrs=1.16667 \
        sa=5.05e-07 sb=1.075e-06 sd=160n sca=11.8275 scb=0.0101379 \
        scc=0.000311481 m=(1)
mp2 (7 \4\:n0 \6\:VDD NW) g45p1svt w=(3.9e-07) l=4.5e-08 nf=1 as=7.8e-14 \
        ad=6.825e-14 ps=1.18e-06 pd=1.13e-06 nrd=1.16667 nrs=1.16667 \
        sa=7.25e-07 sb=8.55e-07 sd=160n sca=11.8275 scb=0.0101379 \
        scc=0.000311481 m=(1)
mp4_1__rcx (6 \1\:B0 \6\:VDD NW) g45p1svt w=(3.9e-07) l=4.5e-08 nf=1 \
        as=7.8e-14 ad=4.485e-14 ps=1.18e-06 pd=1.01e-06 nrd=1.16667 \
        nrs=1.16667 sa=9.7e-07 sb=6.1e-07 sd=160n sca=11.8275 \
        scb=0.0101379 scc=0.000311481 m=(1)
mp5_1__rcx (\8\:Y \5\:B1 6 NW) g45p1svt w=(3.9e-07) l=4.5e-08 nf=1 \
        as=4.485e-14 ad=6.24e-14 ps=1.01e-06 pd=1.1e-06 nrd=1.16667 \
        nrs=1.16667 sa=1.13e-06 sb=4.5e-07 sd=160n sca=12.2157 \
        scb=0.0102564 scc=0.000311508 m=(1)
mp5 (\8\:Y \6\:B1 9 NW) g45p1svt w=(3.9e-07) l=4.5e-08 nf=1 as=2.34e-14 \
        ad=6.24e-14 ps=9e-07 pd=1.1e-06 nrd=1.16667 nrs=1.16667 \
        sa=1.335e-06 sb=2.45e-07 sd=160n sca=13.1864 scb=0.011023 \
        scc=0.000312795 m=(1)
mp4 (9 \6\:B0 \1\:VDD NW) g45p1svt w=(3.9e-07) l=4.5e-08 nf=1 \
        as=5.46e-14 ad=2.34e-14 ps=1.06e-06 pd=9e-07 nrd=1.16667 \
        nrs=1.16667 sa=1.44e-06 sb=1.4e-07 sd=160n sca=14.1519 \
        scb=0.0123146 scc=0.000320502 m=(1)
ends OAI2BB2X2
// End of subcircuit definition.
