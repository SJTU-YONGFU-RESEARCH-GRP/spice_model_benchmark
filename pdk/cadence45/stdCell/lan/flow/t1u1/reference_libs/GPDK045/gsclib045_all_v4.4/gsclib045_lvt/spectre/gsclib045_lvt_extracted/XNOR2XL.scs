// Generated for: spectre (May  1 09:19:43 2013 )
// Library name: gsclib045_lvt
// Cell name: XNOR2XL
// View name: extracted

simulator lang=spectre

subckt XNOR2XL A B VDD VSS Y
mp5 (\1\:Y n0 \6\:VDD VDD) g45p1lvt w=(2.15e-07) l=4.5e-08 nf=1 \
        as=7.315e-14 ad=3.17e-14 ps=1.74e-06 pd=8e-07 nrd=1.16667 \
        nrs=1.16667 sa=1.47442e-07 sb=1.15733e-06 sd=160n sca=27.5082 \
        scb=0.031157 scc=0.00214164 m=(1)
mp0 (\7\:n1 \1\:A \6\:VDD VDD) g45p1lvt w=(2.15e-07) l=4.5e-08 nf=1 \
        as=7.315e-14 ad=3.548e-14 ps=1.74e-06 pd=7.6e-07 nrd=1.16667 \
        nrs=1.16667 sa=3.52442e-07 sb=9.52326e-07 sd=160n sca=21.6735 \
        scb=0.0213374 scc=0.00167521 m=(1)
mp4 (\7\:n1 n2 \4\:n0 VDD) g45p1lvt w=(2.15e-07) l=4.5e-08 nf=1 \
        as=3.44e-14 ad=3.548e-14 ps=7.5e-07 pd=7.6e-07 nrd=1.16667 \
        nrs=1.16667 sa=5.62442e-07 sb=7.42326e-07 sd=160n sca=20.0463 \
        scb=0.0191953 scc=0.00166251 m=(1)
mp3 (\4\:n0 \1\:B net112 VDD) g45p1lvt w=(2.15e-07) l=4.5e-08 nf=1 \
        as=3.44e-14 ad=3.44e-14 ps=7.5e-07 pd=7.5e-07 nrd=1.16667 \
        nrs=1.16667 sa=7.67442e-07 sb=5.37326e-07 sd=160n sca=19.9753 \
        scb=0.0191105 scc=0.0016624 m=(1)
mp2 (net112 n1 \1\:VDD VDD) g45p1lvt w=(2.15e-07) l=4.5e-08 nf=1 \
        as=7.457e-14 ad=3.44e-14 ps=1.75e-06 pd=7.5e-07 nrd=1.16667 \
        nrs=1.16667 sa=9.72442e-07 sb=3.32326e-07 sd=160n sca=21.2505 \
        scb=0.0206889 scc=0.0016691 m=(1)
mp1 (\8\:n2 \5\:B \1\:VDD VDD) g45p1lvt w=(2.15e-07) l=4.5e-08 nf=1 \
        as=7.457e-14 ad=2.63e-14 ps=1.75e-06 pd=7.1e-07 nrd=1.16667 \
        nrs=1.16667 sa=1.18244e-06 sb=1.22326e-07 sd=160n sca=25.996 \
        scb=0.028784 scc=0.00194969 m=(1)
C1 (A VSS) capacitor c=6.38222e-17
C2 (VDD VSS) capacitor c=1.3561e-16
C3 (Y VSS) capacitor c=3.98427e-17
C4 (B VSS) capacitor c=2.75544e-17
C5 (n0 VSS) capacitor c=3.30706e-17
C6 (n1 VSS) capacitor c=7.99282e-17
C7 (n2 VSS) capacitor c=5.31397e-17
C8 (net112 VSS) capacitor c=4.43785e-18
C9 (\5\:B VSS) capacitor c=3.76994e-17
C10 (\1\:B VSS) capacitor c=4.00226e-17
C11 (\1\:A VSS) capacitor c=5.16865e-17
C12 (\7\:B VSS) capacitor c=3.38154e-17
C13 (\2\:n1 VSS) capacitor c=4.36806e-17
C14 (\3\:n2 VSS) capacitor c=3.91347e-17
C15 (\3\:B VSS) capacitor c=6.10931e-17
C16 (\3\:A VSS) capacitor c=3.14351e-17
C17 (\3\:n0 VSS) capacitor c=3.70164e-17
C18 (\6\:B VSS) capacitor c=3.88823e-17
C19 (\3\:n1 VSS) capacitor c=3.06491e-17
C20 (\4\:B VSS) capacitor c=3.01567e-17
C21 (\4\:n2 VSS) capacitor c=4.27941e-17
C22 (\2\:n2 VSS) capacitor c=2.3665e-17
C23 (\2\:A VSS) capacitor c=3.99165e-17
C24 (\2\:n0 VSS) capacitor c=3.24908e-17
C25 (\8\:n2 VSS) capacitor c=9.31861e-17
C26 (\1\:VDD VSS) capacitor c=3.4911e-17
C27 (\4\:n0 VSS) capacitor c=1.6305e-16
C28 (\7\:n1 VSS) capacitor c=8.92966e-17
C29 (\6\:VDD VSS) capacitor c=2.83553e-17
C30 (\1\:Y VSS) capacitor c=5.86672e-17
C31 (\5\:n2 VSS) capacitor c=1.93713e-17
C32 (\7\:n0 VSS) capacitor c=7.81621e-17
C33 (\5\:n1 VSS) capacitor c=1.2375e-16
C34 (\3\:Y VSS) capacitor c=2.59561e-17
C35 (\2\:B VSS) capacitor c=4.5307e-17
C36 (\4\:A VSS) capacitor c=3.57017e-17
C37 (\6\:n0 VSS) capacitor c=1.21188e-16
C38 (\4\:n1 VSS) capacitor c=6.44533e-17
C39 (\8\:B VSS) capacitor c=5.18835e-17
C40 (\9\:B VSS) capacitor c=4.77602e-17
C41 (\7\:n2 VSS) capacitor c=5.77562e-17
C42 (\10\:n2 VSS) capacitor c=7.7645e-17
C43 (\11\:n2 VSS) capacitor c=1.0555e-16
C44 (\4\:VDD VSS) capacitor c=3.20429e-17
C45 (\5\:VDD VSS) capacitor c=1.00136e-17
Rk3 (A \4\:A) resistor r=0.08017 c=0
Rk14 (\2\:VSS \4\:VSS) resistor r=0.551 c=0
Rk16 (\5\:VSS VSS) resistor r=0.135 c=0
Rk15 (\4\:VSS \5\:VSS) resistor r=0.2155 c=0
Rk17 (\5\:VSS \7\:VSS) resistor r=0.3456 c=0
Rk18 (\2\:VDD \4\:VDD) resistor r=0.2921 c=0
Rk20 (\5\:VDD VDD) resistor r=0.15 c=0
Rk19 (\4\:VDD \5\:VDD) resistor r=0.2004 c=0
Rk21 (\5\:VDD \7\:VDD) resistor r=0.1608 c=0
Rk1 (\2\:Y Y) resistor r=0.2937 c=0
Rk2 (Y \4\:Y) resistor r=0.08433 c=0
Rk8 (\8\:B B) resistor r=0.07907 c=0
Rk9 (B \9\:B) resistor r=0.0911 c=0
Rk4 (\5\:n0 \6\:n0) resistor r=0.8388 c=0
Rk5 (\5\:n0 \8\:n0) resistor r=0.3989 c=0
Rk6 (\4\:n1 \6\:n1) resistor r=0.4559 c=0
Rk7 (\6\:n1 \8\:n1) resistor r=0.5094 c=0
Rk10 (\6\:n2 \7\:n2) resistor r=0.1047 c=0
Rk11 (\7\:n2 \9\:n2) resistor r=0.2748 c=0
Rk12 (\7\:n2 \10\:n2) resistor r=0.3435 c=0
Rk13 (\9\:n2 \11\:n2) resistor r=0.7396 c=0
Rl3 (\1\:A \2\:A) resistor r=83.3841 c=0
Rl4 (\2\:A \3\:A) resistor r=39.1533 c=0
Rl12 (\5\:B \6\:B) resistor r=39.5596 c=0
Rl13 (\6\:B \7\:B) resistor r=76.098 c=0
Rl7 (\1\:B \2\:B) resistor r=25.7494 c=0
Rl8 (\2\:B \3\:B) resistor r=146.518 c=0
Rl9 (\2\:B \4\:B) resistor r=5.783 c=0
Rl1 (n0 \2\:n0) resistor r=33.3841 c=0
Rl2 (\2\:n0 \3\:n0) resistor r=89.1533 c=0
Rl10 (n1 \2\:n1) resistor r=148.077 c=0
Rl11 (\2\:n1 \3\:n1) resistor r=26.1559 c=0
Rl6 (\3\:n2 \4\:n2) resistor r=29.5379 c=0
Rl5 (n2 \2\:n2) resistor r=69.9225 c=0
Rz5 (\1\:VSS \2\:VSS) resistor r=75 c=0
Rz6 (\6\:VSS \7\:VSS) resistor r=75 c=0
Rz1 (\3\:Y \4\:Y) resistor r=75 c=0
Rz2 (\7\:n0 \8\:n0) resistor r=75 c=0
Rz3 (\5\:n1 \6\:n1) resistor r=75 c=0
Rz4 (\5\:n2 \6\:n2) resistor r=75 c=0
Ry6 (\1\:VDD \2\:VDD) resistor r=62 c=0
Ry7 (\6\:VDD \7\:VDD) resistor r=62 c=0
Ry1 (\1\:Y \2\:Y) resistor r=62 c=0
Ry2 (\4\:n0 \5\:n0) resistor r=62 c=0
Ry3 (\7\:n1 \8\:n1) resistor r=62 c=0
Ry4 (\8\:n2 \9\:n2) resistor r=62 c=0
Rx1 (\2\:A \4\:A) resistor r=45 c=0
Rx4 (\6\:B \8\:B) resistor r=45 c=0
Rx5 (\4\:B \9\:B) resistor r=45 c=0
Rx2 (\2\:n0 \6\:n0) resistor r=45 c=0
Rx3 (\3\:n1 \4\:n1) resistor r=45 c=0
Rx6 (\4\:n2 \10\:n2) resistor r=45 c=0
Rx7 (\2\:n2 \11\:n2) resistor r=45 c=0
mn5 (\3\:Y \3\:n0 \6\:VSS VSS) g45n1lvt w=(1.45e-07) l=4.5e-08 nf=1 \
        as=2.32e-14 ad=2.03e-14 ps=6.1e-07 pd=5.7e-07 nrd=1.16667 \
        nrs=1.16667 sa=1.4e-07 sb=1.175e-06 sd=160n sca=15.7071 \
        scb=0.0167369 scc=0.00113434 m=(1)
mn0 (\5\:n1 \3\:A \6\:VSS VSS) g45n1lvt w=(1.45e-07) l=4.5e-08 nf=1 \
        as=2.32e-14 ad=2.392e-14 ps=6.1e-07 pd=6.2e-07 nrd=1.16667 \
        nrs=1.16667 sa=3.45e-07 sb=9.7e-07 sd=160n sca=15.7071 \
        scb=0.0167369 scc=0.00113434 m=(1)
mn4 (\7\:n0 \3\:B \5\:n1 VSS) g45n1lvt w=(1.45e-07) l=4.5e-08 nf=1 \
        as=2.392e-14 ad=2.392e-14 ps=6.2e-07 pd=6.2e-07 nrd=1.16667 \
        nrs=1.16667 sa=5.55e-07 sb=7.6e-07 sd=160n sca=15.7071 \
        scb=0.0167369 scc=0.00113434 m=(1)
mn3 (\7\:n0 \3\:n2 net145 VSS) g45n1lvt w=(1.45e-07) l=4.5e-08 nf=1 \
        as=2.247e-14 ad=2.392e-14 ps=6e-07 pd=6.2e-07 nrd=1.16667 \
        nrs=1.16667 sa=7.65e-07 sb=5.5e-07 sd=160n sca=15.7071 \
        scb=0.0167369 scc=0.00113434 m=(1)
mn2 (net145 \2\:n1 \1\:VSS VSS) g45n1lvt w=(1.45e-07) l=4.5e-08 nf=1 \
        as=2.392e-14 ad=2.247e-14 ps=6.2e-07 pd=6e-07 nrd=1.16667 \
        nrs=1.16667 sa=9.65e-07 sb=3.5e-07 sd=160n sca=15.7071 \
        scb=0.0167369 scc=0.00113434 m=(1)
mn1 (\5\:n2 \7\:B \1\:VSS VSS) g45n1lvt w=(1.45e-07) l=4.5e-08 nf=1 \
        as=2.392e-14 ad=2.03e-14 ps=6.2e-07 pd=5.7e-07 nrd=1.16667 \
        nrs=1.16667 sa=1.175e-06 sb=1.4e-07 sd=160n sca=15.7071 \
        scb=0.0167369 scc=0.00113434 m=(1)
ends XNOR2XL
// End of subcircuit definition.
