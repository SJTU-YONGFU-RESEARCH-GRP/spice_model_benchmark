// Generated for: spectre (May  1 09:14:55 2013 )
// Library name: gsclib045_lvt
// Cell name: SDFFSHQX1
// View name: extracted

simulator lang=spectre

subckt SDFFSHQX1 CK D Q SE SI SN VDD VSS
mp55 (\1\:Q \3\:qbint \28\:VDD VDD) g45p1lvt w=(3.9e-07) l=4.5e-08 nf=1 \
        as=5.46e-14 ad=4.8e-14 ps=1.06e-06 pd=1.13e-06 nrd=1.16667 \
        nrs=1.16667 sa=1.4e-07 sb=1.23077e-07 sd=160n sca=34.9044 \
        scb=0.0259128 scc=0.00343869 m=(1)
mp11 (net390 \1\:D \8\:VDD VDD) g45p1lvt w=(3.9e-07) l=4.5e-08 nf=1 \
        as=6.535e-14 ad=1.248e-13 ps=1.16e-06 pd=1.42e-06 nrd=1.16667 \
        nrs=1.16667 sa=2.69551e-07 sb=7.87308e-07 sd=160n sca=13.5671 \
        scb=0.012183 scc=0.000647513 m=(1)
mp12 (\6\:Db \3\:SE net390 VDD) g45p1lvt w=(3.9e-07) l=4.5e-08 nf=1 \
        as=1.248e-13 ad=6.24e-14 ps=1.42e-06 pd=1.1e-06 nrd=1.16667 \
        nrs=1.16667 sa=6.34551e-07 sb=4.22308e-07 sd=160n sca=13.5671 \
        scb=0.012183 scc=0.000647513 m=(1)
mp14 (\6\:Db \3\:SEb net398 VDD) g45p1lvt w=(3.9e-07) l=4.5e-08 nf=1 \
        as=2.34e-14 ad=6.24e-14 ps=9e-07 pd=1.1e-06 nrd=1.16667 \
        nrs=1.16667 sa=8.39551e-07 sb=2.17308e-07 sd=160n sca=13.5765 \
        scb=0.0121847 scc=0.000647513 m=(1)
mp13 (net398 \1\:SI \5\:VDD VDD) g45p1lvt w=(3.9e-07) l=4.5e-08 nf=1 \
        as=4.38e-14 ad=2.34e-14 ps=1.06e-06 pd=9e-07 nrd=1.16667 \
        nrs=1.16667 sa=9.44551e-07 sb=1.12308e-07 sd=160n sca=13.8119 \
        scb=0.0122457 scc=0.000647522 m=(1)
C1 (D VSS) capacitor c=5.88872e-17
C2 (Q VSS) capacitor c=3.91174e-17
C3 (CK VSS) capacitor c=4.66852e-17
C4 (SE VSS) capacitor c=9.34148e-17
C5 (SN VSS) capacitor c=1.49038e-16
C6 (SI VSS) capacitor c=7.24525e-17
C7 (VDD VSS) capacitor c=3.44773e-16
C8 (qbint VSS) capacitor c=2.30889e-17
C9 (n30 VSS) capacitor c=3.6891e-17
C10 (net459 VSS) capacitor c=2.23493e-18
C11 (net467 VSS) capacitor c=1.76019e-18
C12 (CKb VSS) capacitor c=4.27708e-17
C13 (mout VSS) capacitor c=5.2055e-17
C14 (CKbb VSS) capacitor c=5.0052e-17
C15 (n20 VSS) capacitor c=1.77838e-17
C16 (net427 VSS) capacitor c=1.82309e-18
C17 (Db VSS) capacitor c=4.34767e-17
C18 (net443 VSS) capacitor c=5.17867e-18
C19 (SEb VSS) capacitor c=4.11859e-17
C20 (net455 VSS) capacitor c=2.6916e-18
C21 (net355 VSS) capacitor c=6.37152e-17
C22 (net378 VSS) capacitor c=1.94844e-18
C23 (net390 VSS) capacitor c=7.41841e-18
C24 (net398 VSS) capacitor c=1.65861e-18
C25 (\4\:SE VSS) capacitor c=2.91345e-17
C26 (\1\:SI VSS) capacitor c=7.31794e-17
C27 (\3\:SEb VSS) capacitor c=7.13102e-17
C28 (\3\:SE VSS) capacitor c=5.28274e-17
C29 (\1\:D VSS) capacitor c=5.57951e-17
C30 (\1\:CK VSS) capacitor c=3.5424e-17
C31 (\7\:CKb VSS) capacitor c=2.25241e-17
C32 (\4\:CKbb VSS) capacitor c=2.23745e-17
C33 (\5\:CKb VSS) capacitor c=5.39062e-17
C34 (\3\:mout VSS) capacitor c=7.86687e-17
C35 (\4\:n20 VSS) capacitor c=4.11907e-17
C36 (\5\:SN VSS) capacitor c=3.94846e-17
C37 (\4\:CKb VSS) capacitor c=5.99704e-17
C38 (\4\:qbint VSS) capacitor c=5.95689e-17
C39 (\1\:SN VSS) capacitor c=4.0552e-17
C40 (\3\:n30 VSS) capacitor c=6.09592e-17
C41 (\3\:qbint VSS) capacitor c=3.21415e-17
C42 (\6\:SE VSS) capacitor c=2.13407e-17
C43 (\3\:SI VSS) capacitor c=6.07582e-17
C44 (\1\:SE VSS) capacitor c=4.74715e-17
C45 (\4\:D VSS) capacitor c=4.74624e-17
C46 (\3\:CK VSS) capacitor c=5.58182e-17
C47 (\12\:CKb VSS) capacitor c=1.47828e-17
C48 (\11\:CKb VSS) capacitor c=2.52375e-17
C49 (\6\:CKbb VSS) capacitor c=9.49699e-17
C50 (\3\:n20 VSS) capacitor c=6.81676e-17
C51 (\8\:SN VSS) capacitor c=6.68929e-17
C52 (\2\:CKbb VSS) capacitor c=4.5712e-17
C53 (\6\:qbint VSS) capacitor c=4.324e-17
C54 (\4\:SN VSS) capacitor c=6.44756e-17
C55 (\5\:SE VSS) capacitor c=2.26956e-17
C56 (\2\:SI VSS) capacitor c=5.91823e-17
C57 (\4\:SEb VSS) capacitor c=4.5037e-17
C58 (\2\:SE VSS) capacitor c=7.101e-17
C59 (\2\:SEb VSS) capacitor c=4.18882e-17
C60 (\3\:D VSS) capacitor c=2.79765e-17
C61 (\2\:CK VSS) capacitor c=3.87226e-17
C62 (\7\:CKbb VSS) capacitor c=1.2852e-17
C63 (\10\:CKb VSS) capacitor c=4.49209e-17
C64 (\6\:CKb VSS) capacitor c=4.59271e-17
C65 (\2\:mout VSS) capacitor c=5.51251e-17
C66 (\7\:SN VSS) capacitor c=4.37988e-17
C67 (\3\:CKb VSS) capacitor c=4.00918e-17
C68 (\3\:CKbb VSS) capacitor c=2.69588e-17
C69 (\2\:CKb VSS) capacitor c=4.04424e-17
C70 (\5\:qbint VSS) capacitor c=5.76553e-17
C71 (\3\:SN VSS) capacitor c=3.39318e-17
C72 (\2\:n30 VSS) capacitor c=5.19368e-17
C73 (\2\:qbint VSS) capacitor c=1.7022e-17
C74 (\1\:VDD VSS) capacitor c=1.21669e-17
C75 (\9\:SEb VSS) capacitor c=7.93699e-17
C76 (\5\:VDD VSS) capacitor c=2.86947e-17
C77 (\6\:Db VSS) capacitor c=1.09323e-16
C78 (\8\:VDD VSS) capacitor c=3.97673e-17
C79 (\23\:CKb VSS) capacitor c=7.9432e-17
C80 (\11\:VDD VSS) capacitor c=6.52106e-17
C81 (\10\:CKbb VSS) capacitor c=9.44957e-17
C82 (\8\:Db VSS) capacitor c=1.22749e-16
C83 (\7\:n20 VSS) capacitor c=1.08254e-16
C84 (\15\:VDD VSS) capacitor c=2.88006e-17
C85 (\12\:mout VSS) capacitor c=5.84144e-17
C86 (\18\:VDD VSS) capacitor c=2.35275e-17
C87 (\14\:mout VSS) capacitor c=3.5681e-17
C88 (\8\:n30 VSS) capacitor c=3.98641e-17
C89 (\21\:VDD VSS) capacitor c=1.39684e-17
C90 (\3\:net355 VSS) capacitor c=6.99263e-17
C91 (\25\:VDD VSS) capacitor c=1.37502e-17
C92 (\11\:qbint VSS) capacitor c=6.20582e-17
C93 (\1\:Q VSS) capacitor c=2.08298e-17
C94 (\28\:VDD VSS) capacitor c=3.21825e-17
C95 (\3\:VDD VSS) capacitor c=8.88707e-17
C96 (\5\:SEb VSS) capacitor c=1.14949e-16
C97 (\19\:CKb VSS) capacitor c=5.66474e-17
C98 (\13\:CKbb VSS) capacitor c=5.74554e-17
C99 (\4\:Db VSS) capacitor c=2.14563e-16
C100 (\5\:n20 VSS) capacitor c=9.5838e-17
C101 (\10\:mout VSS) capacitor c=3.38797e-17
C102 (\8\:mout VSS) capacitor c=5.96934e-17
C103 (\4\:n30 VSS) capacitor c=6.75504e-17
C104 (\9\:qbint VSS) capacitor c=6.40479e-17
C105 (\4\:Q VSS) capacitor c=5.09471e-17
C106 (\2\:SN VSS) capacitor c=3.30105e-17
C107 (\2\:n20 VSS) capacitor c=4.20735e-17
C108 (\5\:CKbb VSS) capacitor c=3.67422e-17
C109 (\9\:CKb VSS) capacitor c=2.94712e-17
C110 (\2\:D VSS) capacitor c=2.74171e-17
C111 (\3\:Q VSS) capacitor c=2.32031e-17
C112 (\7\:qbint VSS) capacitor c=7.12586e-17
C113 (\8\:qbint VSS) capacitor c=7.72901e-17
C114 (\13\:qbint VSS) capacitor c=7.26154e-17
C115 (\6\:n30 VSS) capacitor c=9.64694e-17
C116 (\7\:n30 VSS) capacitor c=9.98037e-17
C117 (\9\:SN VSS) capacitor c=2.2152e-17
C118 (\10\:SN VSS) capacitor c=1.78873e-16
C119 (\4\:mout VSS) capacitor c=4.66176e-17
C120 (\6\:mout VSS) capacitor c=6.82045e-17
C121 (\7\:mout VSS) capacitor c=6.16454e-17
C122 (\9\:n20 VSS) capacitor c=7.33189e-17
C123 (\13\:CKb VSS) capacitor c=1.13205e-16
C124 (\14\:CKb VSS) capacitor c=1.93248e-16
C125 (\15\:CKb VSS) capacitor c=1.43839e-16
C126 (\16\:CKb VSS) capacitor c=1.05029e-16
C127 (\17\:CKb VSS) capacitor c=5.01987e-17
C128 (\18\:CKb VSS) capacitor c=3.40016e-17
C129 (\8\:CKbb VSS) capacitor c=7.63299e-17
C130 (\9\:CKbb VSS) capacitor c=1.87442e-16
C131 (\12\:CKbb VSS) capacitor c=1.49945e-16
C132 (\21\:CKb VSS) capacitor c=6.62043e-17
C133 (\22\:CKb VSS) capacitor c=2.28854e-17
C134 (\4\:CK VSS) capacitor c=8.56792e-17
C135 (\5\:D VSS) capacitor c=4.3805e-17
C136 (\3\:Db VSS) capacitor c=2.58932e-16
C137 (\4\:SI VSS) capacitor c=3.742e-17
C138 (\7\:SEb VSS) capacitor c=1.46552e-16
C139 (\8\:SEb VSS) capacitor c=1.18907e-16
C140 (\7\:SE VSS) capacitor c=1.14557e-16
C141 (\7\:VDD VSS) capacitor c=2.20836e-17
C142 (\10\:VDD VSS) capacitor c=2.73677e-17
C143 (\14\:VDD VSS) capacitor c=3.23674e-17
C144 (\17\:VDD VSS) capacitor c=3.14422e-17
C145 (\20\:VDD VSS) capacitor c=2.47622e-17
C146 (\24\:VDD VSS) capacitor c=9.76404e-18
C147 (\27\:VDD VSS) capacitor c=7.91302e-18
Rk36 (D \5\:D) resistor r=0.0269 c=0
Rk3 (\3\:Q Q) resistor r=0.08203 c=0
Rk1 (\2\:Q \3\:Q) resistor r=0.08182 c=0
Rk2 (\3\:Q \5\:Q) resistor r=0.1375 c=0
Rk66 (\2\:VSS \4\:VSS) resistor r=0.6318 c=0
Rk67 (\4\:VSS \5\:VSS) resistor r=0.4017 c=0
Rk68 (\5\:VSS \6\:VSS) resistor r=0.4025 c=0
Rk69 (\6\:VSS \7\:VSS) resistor r=0.197 c=0
Rk70 (\7\:VSS \8\:VSS) resistor r=0.2958 c=0
Rk71 (\8\:VSS \9\:VSS) resistor r=0.3307 c=0
Rk72 (\9\:VSS \10\:VSS) resistor r=0.5767 c=0
Rk73 (\10\:VSS \11\:VSS) resistor r=0.04495 c=0
Rk75 (\12\:VSS VSS) resistor r=0.0151 c=0
Rk74 (\11\:VSS \12\:VSS) resistor r=0.4912 c=0
Rk76 (\4\:VSS \14\:VSS) resistor r=0.2376 c=0
Rk77 (\5\:VSS \16\:VSS) resistor r=0.1879 c=0
Rk78 (\6\:VSS \18\:VSS) resistor r=0.04332 c=0
Rk79 (\8\:VSS \20\:VSS) resistor r=0.2752 c=0
Rk80 (\9\:VSS \22\:VSS) resistor r=0.1276 c=0
Rk81 (\11\:VSS \24\:VSS) resistor r=0.2601 c=0
Rk82 (\12\:VSS \26\:VSS) resistor r=0.285 c=0
Rk35 (CK \4\:CK) resistor r=0.06218 c=0
Rk45 (\7\:SE SE) resistor r=0.4738 c=0
Rk46 (SE \8\:SE) resistor r=0.01427 c=0
Rk12 (\9\:SN SN) resistor r=0.07197 c=0
Rk13 (SN \10\:SN) resistor r=1.2748 c=0
Rk41 (SI \4\:SI) resistor r=0.06296 c=0
Rk47 (\2\:VDD \4\:VDD) resistor r=0.65 c=0
Rk48 (\4\:VDD \6\:VDD) resistor r=0.271 c=0
Rk49 (\4\:VDD \7\:VDD) resistor r=0.4162 c=0
Rk50 (\7\:VDD \9\:VDD) resistor r=0.2832 c=0
Rk51 (\7\:VDD \10\:VDD) resistor r=0.3382 c=0
Rk52 (\10\:VDD \12\:VDD) resistor r=0.4529 c=0
Rk53 (\10\:VDD \13\:VDD) resistor r=0.2481 c=0
Rk54 (\13\:VDD \14\:VDD) resistor r=0.3626 c=0
Rk55 (\14\:VDD \16\:VDD) resistor r=0.04332 c=0
Rk56 (\14\:VDD \17\:VDD) resistor r=0.251 c=0
Rk57 (\17\:VDD \19\:VDD) resistor r=0.04332 c=0
Rk58 (\17\:VDD \20\:VDD) resistor r=0.394 c=0
Rk59 (\20\:VDD \22\:VDD) resistor r=0.04332 c=0
Rk60 (\20\:VDD \23\:VDD) resistor r=0.1895 c=0
Rk61 (\23\:VDD \24\:VDD) resistor r=0.044 c=0
Rk62 (\24\:VDD \26\:VDD) resistor r=0.04332 c=0
Rk65 (\27\:VDD VDD) resistor r=0.08483 c=0
Rk63 (\24\:VDD \27\:VDD) resistor r=0.42 c=0
Rk64 (\27\:VDD \29\:VDD) resistor r=0.3852 c=0
Rk4 (\7\:qbint \8\:qbint) resistor r=0.4185 c=0
Rk5 (\8\:qbint \10\:qbint) resistor r=0.0632 c=0
Rk6 (\8\:qbint \12\:qbint) resistor r=0.3929 c=0
Rk7 (\10\:qbint \13\:qbint) resistor r=0.6428 c=0
Rk9 (\5\:n30 \6\:n30) resistor r=0.2753 c=0
Rk10 (\6\:n30 \7\:n30) resistor r=0.6455 c=0
Rk11 (\6\:n30 \9\:n30) resistor r=0.1578 c=0
Rk23 (\13\:CKb \14\:CKb) resistor r=0.7225 c=0
Rk24 (\14\:CKb \15\:CKb) resistor r=0.7874 c=0
Rk25 (\15\:CKb \16\:CKb) resistor r=0.7368 c=0
Rk26 (\14\:CKb \17\:CKb) resistor r=0.2372 c=0
Rk27 (\15\:CKb \18\:CKb) resistor r=0.1246 c=0
Rk32 (\20\:CKb \21\:CKb) resistor r=0.2855 c=0
Rk33 (\21\:CKb \22\:CKb) resistor r=0.135 c=0
Rk34 (\21\:CKb \24\:CKb) resistor r=0.5006 c=0
Rk14 (\4\:mout \5\:mout) resistor r=0.2213 c=0
Rk15 (\5\:mout \6\:mout) resistor r=0.05931 c=0
Rk16 (\6\:mout \7\:mout) resistor r=0.3259 c=0
Rk17 (\7\:mout \9\:mout) resistor r=0.3117 c=0
Rk18 (\5\:mout \11\:mout) resistor r=0.1012 c=0
Rk19 (\6\:mout \13\:mout) resistor r=0.2547 c=0
Rk20 (\7\:mout \15\:mout) resistor r=0.1196 c=0
Rk28 (\8\:CKbb \9\:CKbb) resistor r=0.3224 c=0
Rk29 (\9\:CKbb \11\:CKbb) resistor r=0.6265 c=0
Rk30 (\9\:CKbb \12\:CKbb) resistor r=1.0964 c=0
Rk31 (\11\:CKbb \14\:CKbb) resistor r=0.2948 c=0
Rk21 (\6\:n20 \8\:n20) resistor r=0.4863 c=0
Rk22 (\8\:n20 \9\:n20) resistor r=0.4589 c=0
Rk37 (\2\:Db \3\:Db) resistor r=0.2547 c=0
Rk38 (\3\:Db \5\:Db) resistor r=1.1126 c=0
Rk39 (\3\:Db \7\:Db) resistor r=0.8681 c=0
Rk40 (\5\:Db \9\:Db) resistor r=0.6024 c=0
Rk42 (\6\:SEb \7\:SEb) resistor r=0.8008 c=0
Rk43 (\7\:SEb \8\:SEb) resistor r=0.3798 c=0
Rk44 (\8\:SEb \10\:SEb) resistor r=0.6659 c=0
Rk8 (\2\:net355 \4\:net355) resistor r=0.2136 c=0
Rl33 (\1\:D \2\:D) resistor r=134.329 c=0
Rl35 (\2\:D \4\:D) resistor r=49.7141 c=0
Rl34 (\2\:D \3\:D) resistor r=8.3038 c=0
Rl31 (\1\:CK \2\:CK) resistor r=26.911 c=0
Rl32 (\2\:CK \3\:CK) resistor r=132.487 c=0
Rl42 (\4\:SE \5\:SE) resistor r=74.2328 c=0
Rl43 (\5\:SE \6\:SE) resistor r=30.0021 c=0
Rl38 (\2\:SE \3\:SE) resistor r=125.789 c=0
Rl37 (\1\:SE \2\:SE) resistor r=43.4636 c=0
Rl5 (\1\:SN \2\:SN) resistor r=37.3411 c=0
Rl7 (\2\:SN \4\:SN) resistor r=135.418 c=0
Rl6 (\2\:SN \3\:SN) resistor r=10.9341 c=0
Rl14 (\5\:SN \6\:SN) resistor r=49.7185 c=0
Rl16 (\6\:SN \8\:SN) resistor r=111.257 c=0
Rl15 (\6\:SN \7\:SN) resistor r=3.3229 c=0
Rl40 (\1\:SI \2\:SI) resistor r=41.0764 c=0
Rl41 (\2\:SI \3\:SI) resistor r=144.488 c=0
Rl8 (\4\:qbint \5\:qbint) resistor r=131.81 c=0
Rl9 (\5\:qbint \6\:qbint) resistor r=26.3736 c=0
Rl2 (\2\:qbint \3\:qbint) resistor r=39.6174 c=0
Rl1 (qbint \2\:qbint) resistor r=24.2328 c=0
Rl4 (\2\:n30 \3\:n30) resistor r=116.862 c=0
Rl3 (n30 \2\:n30) resistor r=53.079 c=0
Rl26 (\7\:CKb \8\:CKb) resistor r=55.0021 c=0
Rl29 (\10\:CKb \11\:CKb) resistor r=24.2328 c=0
Rl22 (\5\:CKb \6\:CKb) resistor r=47.3097 c=0
Rl13 (\3\:CKb \4\:CKb) resistor r=122.977 c=0
Rl10 (CKb \2\:CKb) resistor r=29.5379 c=0
Rl30 (\9\:CKb \12\:CKb) resistor r=23.4163 c=0
Rl27 (\8\:CKb \9\:CKb) resistor r=12.6847 c=0
Rl28 (\9\:CKb \10\:CKb) resistor r=157.901 c=0
Rl21 (\2\:mout \3\:mout) resistor r=97.872 c=0
Rl20 (mout \2\:mout) resistor r=92.2849 c=0
Rl11 (CKbb \2\:CKbb) resistor r=126.923 c=0
Rl12 (CKbb \3\:CKbb) resistor r=64.1533 c=0
Rl23 (\4\:CKbb \5\:CKbb) resistor r=23.7402 c=0
Rl24 (\5\:CKbb \6\:CKbb) resistor r=197.951 c=0
Rl25 (\5\:CKbb \7\:CKbb) resistor r=5.1011 c=0
Rl19 (\2\:n20 \4\:n20) resistor r=37.3411 c=0
Rl18 (\2\:n20 \3\:n20) resistor r=152.291 c=0
Rl17 (n20 \2\:n20) resistor r=0.6084 c=0
Rl39 (\3\:SEb \4\:SEb) resistor r=24.2328 c=0
Rl36 (SEb \2\:SEb) resistor r=49.2328 c=0
Rz1 (\4\:Q \5\:Q) resistor r=75 c=0
Rz15 (\1\:VSS \2\:VSS) resistor r=75 c=0
Rz16 (\13\:VSS \14\:VSS) resistor r=75 c=0
Rz17 (\15\:VSS \16\:VSS) resistor r=75 c=0
Rz18 (\17\:VSS \18\:VSS) resistor r=75 c=0
Rz19 (\19\:VSS \20\:VSS) resistor r=75 c=0
Rz20 (\21\:VSS \22\:VSS) resistor r=75 c=0
Rz21 (\23\:VSS \24\:VSS) resistor r=75 c=0
Rz22 (\25\:VSS \26\:VSS) resistor r=75 c=0
Rz12 (\3\:VDD \4\:VDD) resistor r=9.375 c=0
Rz13 (\3\:VDD \13\:VDD) resistor r=6.25 c=0
Rz14 (\3\:VDD \23\:VDD) resistor r=6.25 c=0
Rz2 (\9\:qbint \10\:qbint) resistor r=75 c=0
Rz3 (\4\:n30 \5\:n30) resistor r=75 c=0
Rz8 (\19\:CKb \20\:CKb) resistor r=75 c=0
Rz4 (\8\:mout \9\:mout) resistor r=75 c=0
Rz5 (\10\:mout \11\:mout) resistor r=75 c=0
Rz7 (\13\:CKbb \14\:CKbb) resistor r=75 c=0
Rz6 (\5\:n20 \6\:n20) resistor r=75 c=0
Rz9 (Db \2\:Db) resistor r=75 c=0
Rz10 (\4\:Db \5\:Db) resistor r=75 c=0
Rz11 (\5\:SEb \6\:SEb) resistor r=75 c=0
Ry1 (\1\:Q \2\:Q) resistor r=62 c=0
Ry23 (\3\:VSS \4\:VSS) resistor r=7.75 c=0
Ry24 (\3\:VSS \7\:VSS) resistor r=5.1667 c=0
Ry25 (\3\:VSS \10\:VSS) resistor r=5.1667 c=0
Ry14 (\1\:VDD \2\:VDD) resistor r=62 c=0
Ry15 (\5\:VDD \6\:VDD) resistor r=62 c=0
Ry16 (\8\:VDD \9\:VDD) resistor r=31 c=0
Ry17 (\11\:VDD \12\:VDD) resistor r=62 c=0
Ry18 (\15\:VDD \16\:VDD) resistor r=62 c=0
Ry19 (\18\:VDD \19\:VDD) resistor r=62 c=0
Ry20 (\21\:VDD \22\:VDD) resistor r=62 c=0
Ry21 (\25\:VDD \26\:VDD) resistor r=62 c=0
Ry22 (\28\:VDD \29\:VDD) resistor r=20.6667 c=0
Ry2 (\11\:qbint \12\:qbint) resistor r=62 c=0
Ry5 (\8\:n30 \9\:n30) resistor r=62 c=0
Ry10 (\23\:CKb \24\:CKb) resistor r=62 c=0
Ry6 (\12\:mout \13\:mout) resistor r=62 c=0
Ry7 (\14\:mout \15\:mout) resistor r=62 c=0
Ry9 (\10\:CKbb \11\:CKbb) resistor r=62 c=0
Ry8 (\7\:n20 \8\:n20) resistor r=62 c=0
Ry11 (\6\:Db \7\:Db) resistor r=62 c=0
Ry12 (\8\:Db \9\:Db) resistor r=62 c=0
Ry13 (\9\:SEb \10\:SEb) resistor r=62 c=0
Ry3 (net355 \2\:net355) resistor r=62 c=0
Ry4 (\3\:net355 \4\:net355) resistor r=62 c=0
Rx16 (\3\:D \5\:D) resistor r=45 c=0
Rx15 (\2\:CK \4\:CK) resistor r=45 c=0
Rx20 (\2\:SE \7\:SE) resistor r=45 c=0
Rx21 (\5\:SE \8\:SE) resistor r=45 c=0
Rx4 (\3\:SN \9\:SN) resistor r=45 c=0
Rx5 (\7\:SN \10\:SN) resistor r=45 c=0
Rx17 (\2\:SI \4\:SI) resistor r=45 c=0
Rx1 (\5\:qbint \7\:qbint) resistor r=45 c=0
Rx2 (\2\:qbint \13\:qbint) resistor r=45 c=0
Rx3 (\2\:n30 \7\:n30) resistor r=45 c=0
Rx8 (\10\:CKb \13\:CKb) resistor r=45 c=0
Rx9 (\2\:CKb \16\:CKb) resistor r=45 c=0
Rx10 (\6\:CKb \17\:CKb) resistor r=45 c=0
Rx11 (\3\:CKb \18\:CKb) resistor r=45 c=0
Rx14 (\8\:CKb \22\:CKb) resistor r=45 c=0
Rx6 (\2\:mout \4\:mout) resistor r=45 c=0
Rx12 (\7\:CKbb \8\:CKbb) resistor r=45 c=0
Rx13 (\3\:CKbb \12\:CKbb) resistor r=45 c=0
Rx7 (n20 \9\:n20) resistor r=45 c=0
Rx18 (\2\:SEb \7\:SEb) resistor r=45 c=0
Rx19 (\4\:SEb \8\:SEb) resistor r=45 c=0
mn55 (\4\:Q qbint \25\:VSS VSS) g45n1lvt w=(2.6e-07) l=4.5e-08 nf=1 \
        as=6.89e-14 ad=4.94e-14 ps=1.05e-06 pd=9e-07 nrd=1.16667 \
        nrs=1.16667 sa=2.65e-07 sb=1.9e-07 sd=160n sca=17.5885 \
        scb=0.0172826 scc=0.00162584 m=(1)
mn11 (net443 \4\:D \15\:VSS VSS) g45n1lvt w=(2.6e-07) l=4.5e-08 nf=1 \
        as=4.51e-14 ad=4.29e-14 ps=9.2e-07 pd=8.5e-07 nrd=1.16667 \
        nrs=1.16667 sa=3.51923e-07 sb=7.2e-07 sd=160n sca=8.51051 \
        scb=0.00656948 scc=0.000151659 m=(1)
mn12 (Db SEb net443 VSS) g45n1lvt w=(2.6e-07) l=4.5e-08 nf=1 as=4.29e-14 \
        ad=4.16e-14 ps=8.5e-07 pd=8.4e-07 nrd=1.16667 nrs=1.16667 \
        sa=5.61923e-07 sb=5.1e-07 sd=160n sca=8.51051 scb=0.00656948 \
        scc=0.000151659 m=(1)
mn14 (Db \1\:SE net455 VSS) g45n1lvt w=(2.6e-07) l=4.5e-08 nf=1 \
        as=3.12e-14 ad=4.16e-14 ps=7.6e-07 pd=8.4e-07 nrd=1.16667 \
        nrs=1.16667 sa=7.66923e-07 sb=3.05e-07 sd=160n sca=8.51051 \
        scb=0.00656948 scc=0.000151659 m=(1)
mn13 (net455 \3\:SI \13\:VSS VSS) g45n1lvt w=(2.6e-07) l=4.5e-08 nf=1 \
        as=3.64e-14 ad=3.12e-14 ps=8e-07 pd=7.6e-07 nrd=1.16667 \
        nrs=1.16667 sa=9.31923e-07 sb=1.4e-07 sd=160n sca=8.51051 \
        scb=0.00656948 scc=0.000151659 m=(1)
mn45 (\9\:qbint n30 \23\:VSS VSS) g45n1lvt w=(2.05e-07) l=4.5e-08 nf=1 \
        as=3.28e-14 ad=2.87e-14 ps=7.3e-07 pd=6.9e-07 nrd=1.16667 \
        nrs=1.16667 sa=1.4e-07 sb=1e-06 sd=160n sca=11.535 scb=0.0112489 \
        scc=0.00047927 m=(1)
mn50 (net459 \4\:SN \23\:VSS VSS) g45n1lvt w=(2.05e-07) l=4.5e-08 nf=1 \
        as=3.28e-14 ad=2.152e-14 ps=7.3e-07 pd=6.2e-07 nrd=1.16667 \
        nrs=1.16667 sa=3.45e-07 sb=7.95e-07 sd=160n sca=11.535 \
        scb=0.0112489 scc=0.00047927 m=(1)
mn51 (net467 \6\:qbint net459 VSS) g45n1lvt w=(2.05e-07) l=4.5e-08 nf=1 \
        as=2.153e-14 ad=2.768e-14 ps=6.2e-07 pd=6.8e-07 nrd=1.16667 \
        nrs=1.16667 sa=4.95e-07 sb=6.45e-07 sd=160n sca=11.535 \
        scb=0.0112489 scc=0.00047927 m=(1)
mn52 (\4\:n30 CKb net467 VSS) g45n1lvt w=(2.05e-07) l=4.5e-08 nf=1 \
        as=2.767e-14 ad=5.432e-14 ps=6.8e-07 pd=9.4e-07 nrd=1.16667 \
        nrs=1.16667 sa=6.75e-07 sb=4.65e-07 sd=160n sca=11.535 \
        scb=0.0112489 scc=0.00047927 m=(1)
mn40 (\4\:n30 \2\:CKbb \8\:mout VSS) g45n1lvt w=(2.05e-07) l=4.5e-08 nf=1 \
        as=3.177e-14 ad=5.432e-14 ps=7.2e-07 pd=9.4e-07 nrd=1.16667 \
        nrs=1.16667 sa=9.85e-07 sb=1.55e-07 sd=160n sca=11.535 \
        scb=0.0112489 scc=0.00047927 m=(1)
mn30 (net435 \8\:SN \21\:VSS VSS) g45n1lvt w=(2.05e-07) l=4.5e-08 nf=1 \
        as=4.365e-14 ad=1.23e-14 ps=1.34e-06 pd=5.3e-07 nrd=1.16667 \
        nrs=1.16667 sa=1e-07 sb=2.45e-07 sd=160n sca=19.867 scb=0.0198061 \
        scc=0.00201945 m=(1)
mn31 (\10\:mout \3\:n20 net435 VSS) g45n1lvt w=(2.05e-07) l=4.5e-08 nf=1 \
        as=1.23e-14 ad=2.87e-14 ps=5.3e-07 pd=6.9e-07 nrd=1.16667 \
        nrs=1.16667 sa=2.05e-07 sb=1.4e-07 sd=160n sca=19.867 \
        scb=0.0198061 scc=0.00201945 m=(1)
mn35 (net427 mout \19\:VSS VSS) g45n1lvt w=(2.05e-07) l=4.5e-08 nf=1 \
        as=2.87e-14 ad=1.435e-14 ps=6.9e-07 pd=5.5e-07 nrd=1.16667 \
        nrs=1.16667 sa=1.4e-07 sb=5.75e-07 sd=160n sca=11.2689 \
        scb=0.0108709 scc=0.000440973 m=(1)
mn36 (\5\:n20 \6\:CKbb net427 VSS) g45n1lvt w=(2.05e-07) l=4.5e-08 nf=1 \
        as=1.435e-14 ad=3.69e-14 ps=5.5e-07 pd=7.7e-07 nrd=1.16667 \
        nrs=1.16667 sa=2.55e-07 sb=4.6e-07 sd=160n sca=11.2689 \
        scb=0.0108709 scc=0.000440973 m=(1)
mn25 (\5\:n20 \11\:CKb \4\:Db VSS) g45n1lvt w=(2.05e-07) l=4.5e-08 nf=1 \
        as=4.818e-14 ad=3.69e-14 ps=8.8e-07 pd=7.7e-07 nrd=1.16667 \
        nrs=1.16667 sa=4.8e-07 sb=2.35e-07 sd=160n sca=11.2689 \
        scb=0.0108709 scc=0.000440973 m=(1)
mn21 (\13\:CKbb \12\:CKb \17\:VSS VSS) g45n1lvt w=(1.45e-07) l=4.5e-08 \
        nf=1 as=4.48e-14 ad=2.03e-14 ps=1.45e-06 pd=5.7e-07 nrd=1.16667 \
        nrs=1.16667 sa=1.4e-07 sb=1e-07 sd=160n sca=16.7245 scb=0.0178071 \
        scc=0.00133148 m=(1)
mn20 (\19\:CKb \3\:CK \15\:VSS VSS) g45n1lvt w=(1.45e-07) l=4.5e-08 nf=1 \
        as=4.51e-14 ad=3.988e-14 ps=9.2e-07 pd=8.4e-07 nrd=1.16667 \
        nrs=1.16667 sa=2.75e-07 sb=9.65e-07 sd=160n sca=10.0732 \
        scb=0.00911402 scc=0.000253284 m=(1)
mn10 (\5\:SEb \6\:SE \1\:VSS VSS) g45n1lvt w=(1.45e-07) l=4.5e-08 nf=1 \
        as=2.03e-14 ad=2.973e-14 ps=5.7e-07 pd=7e-07 nrd=1.16667 \
        nrs=1.16667 sa=2.05e-07 sb=1.4e-07 sd=160n sca=11.9911 \
        scb=0.0120555 scc=0.000498628 m=(1)
mp45 (\11\:qbint \3\:n30 \25\:VDD VDD) g45p1lvt w=(3.1e-07) l=4.5e-08 \
        nf=1 as=1.012e-13 ad=4.34e-14 ps=1.61e-06 pd=9e-07 nrd=1.16667 \
        nrs=1.16667 sa=1.4e-07 sb=5.7e-07 sd=160n sca=12.9031 \
        scb=0.0116454 scc=0.000496931 m=(1)
mp50 (\3\:net355 \1\:SN \25\:VDD VDD) g45p1lvt w=(3.1e-07) l=4.5e-08 \
        nf=1 as=1.012e-13 ad=4.96e-14 ps=1.61e-06 pd=9.4e-07 nrd=1.16667 \
        nrs=1.16667 sa=4.05e-07 sb=3.05e-07 sd=160n sca=12.9031 \
        scb=0.0116454 scc=0.000496931 m=(1)
mp51 (\3\:net355 \4\:qbint \21\:VDD VDD) g45p1lvt w=(3.1e-07) l=4.5e-08 \
        nf=1 as=5.315e-14 ad=4.96e-14 ps=1.51e-06 pd=9.4e-07 nrd=1.16667 \
        nrs=1.16667 sa=6.1e-07 sb=1e-07 sd=160n sca=12.9031 scb=0.0116454 \
        scc=0.000496931 m=(1)
mp52 (\8\:n30 CKbb net355 VDD) g45p1lvt w=(3.1e-07) l=4.5e-08 nf=1 \
        as=5.52e-14 ad=4.96e-14 ps=1.04e-06 pd=9.4e-07 nrd=1.16667 \
        nrs=1.16667 sa=1.78065e-07 sb=3.20484e-07 sd=160n sca=35.6995 \
        scb=0.0234062 scc=0.00420468 m=(1)
mp40 (\8\:n30 \4\:CKb \14\:mout VDD) g45p1lvt w=(3.1e-07) l=4.5e-08 nf=1 \
        as=3.58e-14 ad=4.96e-14 ps=9e-07 pd=9.4e-07 nrd=1.16667 \
        nrs=1.16667 sa=3.83065e-07 sb=1.15484e-07 sd=160n sca=35.6995 \
        scb=0.0234062 scc=0.00420468 m=(1)
mp30 (\12\:mout \5\:SN \18\:VDD VDD) g45p1lvt w=(3.1e-07) l=4.5e-08 nf=1 \
        as=5.19e-14 ad=6.045e-14 ps=1.46e-06 pd=1.01e-06 nrd=1.16667 \
        nrs=1.16667 sa=1e-07 sb=1.14339e-06 sd=160n sca=11.9807 \
        scb=0.0103871 scc=0.000334607 m=(1)
mp31 (\12\:mout \4\:n20 \15\:VDD VDD) g45p1lvt w=(3.1e-07) l=4.5e-08 \
        nf=1 as=9.82e-14 ad=6.045e-14 ps=1.56e-06 pd=1.01e-06 nrd=1.16667 \
        nrs=1.16667 sa=3.4e-07 sb=9.03387e-07 sd=160n sca=11.9807 \
        scb=0.0103871 scc=0.000334607 m=(1)
mp35 (net378 \3\:mout \15\:VDD VDD) g45p1lvt w=(3.1e-07) l=4.5e-08 nf=1 \
        as=9.82e-14 ad=2.48e-14 ps=1.56e-06 pd=7.8e-07 nrd=1.16667 \
        nrs=1.16667 sa=6.05e-07 sb=6.38387e-07 sd=160n sca=11.9807 \
        scb=0.0103871 scc=0.000334607 m=(1)
mp36 (\7\:n20 \5\:CKb net378 VDD) g45p1lvt w=(3.1e-07) l=4.5e-08 nf=1 \
        as=2.48e-14 ad=7.905e-14 ps=7.8e-07 pd=1.13e-06 nrd=1.16667 \
        nrs=1.16667 sa=7.3e-07 sb=5.13387e-07 sd=160n sca=11.9807 \
        scb=0.0103871 scc=0.000334607 m=(1)
mp25 (\7\:n20 \4\:CKbb \8\:Db VDD) g45p1lvt w=(3.1e-07) l=4.5e-08 nf=1 \
        as=6.615e-14 ad=7.905e-14 ps=1.19e-06 pd=1.13e-06 nrd=1.16667 \
        nrs=1.16667 sa=1.03e-06 sb=2.13387e-07 sd=160n sca=11.9807 \
        scb=0.0103871 scc=0.000334607 m=(1)
mp21 (\10\:CKbb \7\:CKb \11\:VDD VDD) g45p1lvt w=(2.15e-07) l=4.5e-08 \
        nf=1 as=3.333e-14 ad=4.97e-14 ps=7.4e-07 pd=1.1e-06 nrd=1.16667 \
        nrs=1.16667 sa=2.31163e-07 sb=1.55e-07 sd=160n sca=45.7906 \
        scb=0.0283307 scc=0.00588417 m=(1)
mp20 (\23\:CKb \1\:CK \8\:VDD VDD) g45p1lvt w=(2.15e-07) l=4.5e-08 nf=1 \
        as=6.535e-14 ad=3.01e-14 ps=1.16e-06 pd=7.1e-07 nrd=1.16667 \
        nrs=1.16667 sa=1.4e-07 sb=1.01e-06 sd=160n sca=16.4667 \
        scb=0.0163489 scc=0.00112485 m=(1)
mp10 (\9\:SEb \4\:SE \1\:VDD VDD) g45p1lvt w=(2.15e-07) l=4.5e-08 nf=1 \
        as=3.89e-14 ad=3.01e-14 ps=1.13e-06 pd=7.1e-07 nrd=1.16667 \
        nrs=1.16667 sa=1.4e-07 sb=1e-07 sd=160n sca=56.5915 scb=0.0440321 \
        scc=0.00674534 m=(1)
ends SDFFSHQX1
// End of subcircuit definition.
