// Generated for: spectre (May  1 09:20:09 2013 )
// Library name: gsclib045_hvt
// Cell name: TLATNX1
// View name: extracted

simulator lang=spectre

subckt TLATNX1 D GN Q QN VDD VSS
mp1 (\6\:GNbb GNb \13\:VDD VDD) g45p1hvt w=(2.15e-07) l=4.5e-08 nf=1 \
        as=5.93e-14 ad=3.01e-14 ps=1.07e-06 pd=7.1e-07 nrd=1.16667 \
        nrs=1.16667 sa=1.4e-07 sb=1.235e-06 sd=160n sca=19.0466 \
        scb=0.0202158 scc=0.000796115 m=(1)
mp5 (net220 \1\:D \13\:VDD VDD) g45p1hvt w=(2.15e-07) l=4.5e-08 nf=1 \
        as=5.93e-14 ad=1.828e-14 ps=1.07e-06 pd=6e-07 nrd=1.16667 \
        nrs=1.16667 sa=4.05e-07 sb=9.7e-07 sd=160n sca=15.442 \
        scb=0.0145142 scc=0.000695697 m=(1)
mp6 (\8\:n0 \3\:GNbb net220 VDD) g45p1hvt w=(2.15e-07) l=4.5e-08 nf=1 \
        as=1.828e-14 ad=6.128e-14 ps=6e-07 pd=1e-06 nrd=1.16667 \
        nrs=1.16667 sa=5.35e-07 sb=8.4e-07 sd=160n sca=14.8088 \
        scb=0.0140105 scc=0.000694942 m=(1)
mp16 (\8\:n0 \6\:GNb net212 VDD) g45p1hvt w=(2.15e-07) l=4.5e-08 nf=1 \
        as=1.29e-14 ad=6.128e-14 ps=5.5e-07 pd=1e-06 nrd=1.16667 \
        nrs=1.16667 sa=8.65e-07 sb=5.1e-07 sd=160n sca=14.2498 \
        scb=0.0138057 scc=0.00069487 m=(1)
mp15 (net212 Qint \9\:VDD VDD) g45p1hvt w=(2.15e-07) l=4.5e-08 nf=1 \
        as=9.17e-14 ad=1.29e-14 ps=1.61e-06 pd=5.5e-07 nrd=1.16667 \
        nrs=1.16667 sa=9.7e-07 sb=4.05e-07 sd=160n sca=14.2498 \
        scb=0.0138057 scc=0.00069487 m=(1)
mp10 (\17\:Qint n0 \9\:VDD VDD) g45p1hvt w=(2.15e-07) l=4.5e-08 nf=1 \
        as=9.17e-14 ad=3.01e-14 ps=1.61e-06 pd=7.1e-07 nrd=1.16667 \
        nrs=1.16667 sa=1.235e-06 sb=1.4e-07 sd=160n sca=14.2498 \
        scb=0.0138057 scc=0.00069487 m=(1)
mp0 (\8\:GNb \1\:GN \6\:VDD VDD) g45p1hvt w=(2.15e-07) l=4.5e-08 nf=1 \
        as=7.825e-14 ad=4.837e-14 ps=1.28e-06 pd=8.8e-07 nrd=1.16667 \
        nrs=1.16667 sa=2.25e-07 sb=4.35e-07 sd=160n sca=25.9192 \
        scb=0.0230503 scc=0.00301683 m=(1)
C1 (GN VSS) capacitor c=7.44111e-17
C2 (D VSS) capacitor c=5.43347e-17
C3 (VDD VSS) capacitor c=2.03008e-16
C4 (QN VSS) capacitor c=4.4691e-17
C5 (GNb VSS) capacitor c=5.4269e-17
C6 (GNbb VSS) capacitor c=4.77635e-17
C7 (n0 VSS) capacitor c=4.61991e-17
C8 (net245 VSS) capacitor c=5.30936e-18
C9 (Qint VSS) capacitor c=5.83044e-17
C10 (Qbint VSS) capacitor c=4.00576e-17
C11 (net220 VSS) capacitor c=1.66212e-18
C12 (\4\:Qint VSS) capacitor c=3.52103e-17
C13 (\10\:Qint VSS) capacitor c=3.65694e-17
C14 (\1\:GN VSS) capacitor c=3.13949e-17
C15 (\6\:GNb VSS) capacitor c=7.04062e-17
C16 (\3\:GNbb VSS) capacitor c=5.11417e-17
C17 (\1\:D VSS) capacitor c=5.15389e-17
C18 (\4\:Qbint VSS) capacitor c=3.30143e-17
C19 (\8\:Qint VSS) capacitor c=2.98001e-17
C20 (\9\:Qint VSS) capacitor c=2.45701e-17
C21 (\3\:GN VSS) capacitor c=3.22688e-17
C22 (\3\:n0 VSS) capacitor c=2.68625e-17
C23 (\3\:Qint VSS) capacitor c=5.21876e-17
C24 (\4\:GNb VSS) capacitor c=6.87346e-17
C25 (\4\:D VSS) capacitor c=8.33768e-17
C26 (\3\:GNb VSS) capacitor c=2.88967e-17
C27 (\3\:Qbint VSS) capacitor c=2.20825e-17
C28 (\7\:Qint VSS) capacitor c=3.23719e-17
C29 (\2\:GN VSS) capacitor c=2.48118e-17
C30 (\2\:n0 VSS) capacitor c=3.95701e-17
C31 (\2\:Qint VSS) capacitor c=4.95702e-17
C32 (\7\:GNb VSS) capacitor c=3.3883e-17
C33 (\2\:GNbb VSS) capacitor c=7.70379e-17
C34 (\5\:GNb VSS) capacitor c=5.13101e-17
C35 (\3\:D VSS) capacitor c=2.66669e-17
C36 (\2\:GNb VSS) capacitor c=4.67251e-17
C37 (\1\:Q VSS) capacitor c=6.74737e-17
C38 (\1\:VDD VSS) capacitor c=8.68661e-17
C39 (\9\:Qbint VSS) capacitor c=8.63197e-17
C40 (\3\:QN VSS) capacitor c=9.75881e-17
C41 (\6\:VDD VSS) capacitor c=4.92072e-17
C42 (\8\:GNb VSS) capacitor c=1.61246e-16
C43 (\17\:Qint VSS) capacitor c=2.42428e-17
C44 (\9\:VDD VSS) capacitor c=1.44553e-17
C45 (\8\:n0 VSS) capacitor c=7.58755e-17
C46 (\13\:VDD VSS) capacitor c=3.46444e-17
C47 (\6\:GNbb VSS) capacitor c=1.11794e-16
C48 (\3\:VDD VSS) capacitor c=4.41571e-17
C49 (\3\:Q VSS) capacitor c=5.12914e-17
C50 (\7\:Qbint VSS) capacitor c=2.78317e-17
C51 (\1\:QN VSS) capacitor c=2.93361e-17
C52 (\11\:GNb VSS) capacitor c=5.32732e-17
C53 (\15\:Qint VSS) capacitor c=2.36654e-17
C54 (\6\:n0 VSS) capacitor c=5.70581e-17
C55 (\4\:GNbb VSS) capacitor c=6.54722e-17
C56 (\2\:D VSS) capacitor c=4.51148e-17
C57 (\5\:Qint VSS) capacitor c=3.7592e-17
C58 (\2\:Qbint VSS) capacitor c=1.30135e-17
C59 (\5\:D VSS) capacitor c=6.63458e-17
C60 (\8\:GNbb VSS) capacitor c=1.01822e-16
C61 (\4\:n0 VSS) capacitor c=5.29839e-17
C62 (\5\:n0 VSS) capacitor c=8.79215e-17
C63 (\10\:GNb VSS) capacitor c=1.98212e-16
C64 (\13\:GNb VSS) capacitor c=7.60269e-17
C65 (\14\:GNb VSS) capacitor c=4.86262e-17
C66 (\4\:GN VSS) capacitor c=3.99135e-17
C67 (\11\:Qint VSS) capacitor c=1.30189e-16
C68 (\12\:Qint VSS) capacitor c=7.82226e-17
C69 (\13\:Qint VSS) capacitor c=4.43587e-17
C70 (\14\:Qint VSS) capacitor c=5.23157e-17
C71 (\5\:Qbint VSS) capacitor c=3.53507e-17
C72 (\6\:Qbint VSS) capacitor c=2.97772e-17
C73 (\5\:VDD VSS) capacitor c=2.92928e-17
C74 (\8\:VDD VSS) capacitor c=2.22886e-17
C75 (\12\:VDD VSS) capacitor c=1.87265e-17
Rk11 (\4\:GN GN) resistor r=0.1254 c=0
Rk1 (\5\:D D) resistor r=0.1521 c=0
Rk33 (\2\:VSS \4\:VSS) resistor r=0.3329 c=0
Rk34 (\4\:VSS \5\:VSS) resistor r=0.3184 c=0
Rk35 (\5\:VSS \6\:VSS) resistor r=0.5008 c=0
Rk36 (\6\:VSS \7\:VSS) resistor r=0.03238 c=0
Rk38 (\8\:VSS VSS) resistor r=0.18 c=0
Rk37 (\7\:VSS \8\:VSS) resistor r=0.3707 c=0
Rk39 (\5\:VSS \10\:VSS) resistor r=0.2916 c=0
Rk40 (\6\:VSS \12\:VSS) resistor r=0.2953 c=0
Rk41 (\8\:VSS \14\:VSS) resistor r=0.2934 c=0
Rk24 (\2\:VDD \4\:VDD) resistor r=0.4602 c=0
Rk25 (\4\:VDD \5\:VDD) resistor r=0.3084 c=0
Rk26 (\5\:VDD \7\:VDD) resistor r=0.2849 c=0
Rk27 (\5\:VDD \8\:VDD) resistor r=0.4832 c=0
Rk28 (\8\:VDD \10\:VDD) resistor r=0.07334 c=0
Rk29 (\8\:VDD \11\:VDD) resistor r=0.05994 c=0
Rk32 (\12\:VDD VDD) resistor r=0.195 c=0
Rk30 (\11\:VDD \12\:VDD) resistor r=0.3556 c=0
Rk31 (\12\:VDD \14\:VDD) resistor r=0.2525 c=0
Rk22 (\2\:Q Q) resistor r=0.3732 c=0
Rk23 (Q \4\:Q) resistor r=0.01117 c=0
Rk17 (QN \2\:QN) resistor r=0.03891 c=0
Rk18 (QN \4\:QN) resistor r=0.2873 c=0
Rk7 (\9\:GNb \10\:GNb) resistor r=1.3057 c=0
Rk8 (\9\:GNb \12\:GNb) resistor r=0.2949 c=0
Rk9 (\10\:GNb \13\:GNb) resistor r=0.3651 c=0
Rk10 (\13\:GNb \14\:GNb) resistor r=0.2223 c=0
Rk2 (\5\:GNbb \7\:GNbb) resistor r=0.5809 c=0
Rk3 (\7\:GNbb \8\:GNbb) resistor r=0.4962 c=0
Rk4 (\4\:n0 \5\:n0) resistor r=0.2114 c=0
Rk5 (\5\:n0 \7\:n0) resistor r=0.391 c=0
Rk6 (\5\:n0 \9\:n0) resistor r=0.3421 c=0
Rk12 (\11\:Qint \12\:Qint) resistor r=0.7883 c=0
Rk13 (\12\:Qint \13\:Qint) resistor r=0.298 c=0
Rk14 (\13\:Qint \14\:Qint) resistor r=0.2114 c=0
Rk15 (\12\:Qint \16\:Qint) resistor r=0.03766 c=0
Rk16 (\13\:Qint \18\:Qint) resistor r=0.1368 c=0
Rk19 (\5\:Qbint \6\:Qbint) resistor r=0.1514 c=0
Rk20 (\6\:Qbint \8\:Qbint) resistor r=0.1265 c=0
Rk21 (\6\:Qbint \10\:Qbint) resistor r=0.2772 c=0
Rl14 (\1\:GN \2\:GN) resistor r=30.7692 c=0
Rl15 (\2\:GN \3\:GN) resistor r=56.8681 c=0
Rl3 (\1\:D \2\:D) resistor r=52.2314 c=0
Rl5 (\2\:D \4\:D) resistor r=127.586 c=0
Rl4 (\2\:D \3\:D) resistor r=5.8511 c=0
Rl9 (\6\:GNb \7\:GNb) resistor r=56.7875 c=0
Rl6 (\4\:GNb \5\:GNb) resistor r=26.1559 c=0
Rl1 (GNb \2\:GNb) resistor r=135.771 c=0
Rl2 (\2\:GNb \3\:GNb) resistor r=26.1559 c=0
Rl8 (\2\:GNbb \3\:GNbb) resistor r=74.2328 c=0
Rl7 (GNbb \2\:GNbb) resistor r=126.477 c=0
Rl12 (n0 \2\:n0) resistor r=115.643 c=0
Rl13 (\2\:n0 \3\:n0) resistor r=49.7951 c=0
Rl10 (Qint \2\:Qint) resistor r=24.2328 c=0
Rl11 (\2\:Qint \3\:Qint) resistor r=141.213 c=0
Rl16 (\4\:Qint \5\:Qint) resistor r=60.772 c=0
Rl19 (\5\:Qint \8\:Qint) resistor r=30.0028 c=0
Rl21 (\6\:Qint \10\:Qint) resistor r=74.7185 c=0
Rl20 (\6\:Qint \9\:Qint) resistor r=40.1031 c=0
Rl18 (\6\:Qint \7\:Qint) resistor r=2.9824 c=0
Rl17 (\5\:Qint \6\:Qint) resistor r=146.3 c=0
Rl22 (Qbint \2\:Qbint) resistor r=51.6372 c=0
Rl24 (\2\:Qbint \4\:Qbint) resistor r=34.3295 c=0
Rl23 (\2\:Qbint \3\:Qbint) resistor r=2.0166 c=0
Rz10 (\1\:VSS \2\:VSS) resistor r=75 c=0
Rz11 (\9\:VSS \10\:VSS) resistor r=75 c=0
Rz12 (\11\:VSS \12\:VSS) resistor r=75 c=0
Rz13 (\13\:VSS \14\:VSS) resistor r=75 c=0
Rz8 (\3\:VDD \4\:VDD) resistor r=15 c=0
Rz9 (\3\:VDD \11\:VDD) resistor r=6.25 c=0
Rz7 (\3\:Q \4\:Q) resistor r=75 c=0
Rz5 (\1\:QN \2\:QN) resistor r=75 c=0
Rz3 (\11\:GNb \12\:GNb) resistor r=75 c=0
Rz1 (\4\:GNbb \5\:GNbb) resistor r=75 c=0
Rz2 (\6\:n0 \7\:n0) resistor r=75 c=0
Rz4 (\15\:Qint \16\:Qint) resistor r=75 c=0
Rz6 (\7\:Qbint \8\:Qbint) resistor r=75 c=0
Ry12 (\3\:VSS \4\:VSS) resistor r=12.4 c=0
Ry13 (\3\:VSS \7\:VSS) resistor r=5.1667 c=0
Ry8 (\1\:VDD \2\:VDD) resistor r=20.6667 c=0
Ry9 (\6\:VDD \7\:VDD) resistor r=62 c=0
Ry10 (\9\:VDD \10\:VDD) resistor r=62 c=0
Ry11 (\13\:VDD \14\:VDD) resistor r=62 c=0
Ry7 (\1\:Q \2\:Q) resistor r=20.6667 c=0
Ry5 (\3\:QN \4\:QN) resistor r=20.6667 c=0
Ry3 (\8\:GNb \9\:GNb) resistor r=62 c=0
Ry1 (\6\:GNbb \7\:GNbb) resistor r=62 c=0
Ry2 (\8\:n0 \9\:n0) resistor r=62 c=0
Ry4 (\17\:Qint \18\:Qint) resistor r=62 c=0
Ry6 (\9\:Qbint \10\:Qbint) resistor r=20.6667 c=0
Rx7 (\2\:GN \4\:GN) resistor r=45 c=0
Rx1 (\3\:D \5\:D) resistor r=45 c=0
Rx4 (\7\:GNb \10\:GNb) resistor r=45 c=0
Rx5 (\5\:GNb \13\:GNb) resistor r=45 c=0
Rx6 (\2\:GNb \14\:GNb) resistor r=45 c=0
Rx2 (\2\:GNbb \8\:GNbb) resistor r=45 c=0
Rx3 (\2\:n0 \4\:n0) resistor r=45 c=0
Rx8 (\7\:Qint \11\:Qint) resistor r=45 c=0
Rx9 (\2\:Qint \14\:Qint) resistor r=45 c=0
Rx10 (\3\:Qbint \5\:Qbint) resistor r=45 c=0
mn1 (\4\:GNbb \3\:GNb \13\:VSS VSS) g45n1hvt w=(1.45e-07) l=4.5e-08 nf=1 \
        as=2.32e-14 ad=2.03e-14 ps=6.1e-07 pd=5.7e-07 nrd=1.16667 \
        nrs=1.16667 sa=1.4e-07 sb=1.15e-06 sd=160n sca=11.7118 \
        scb=0.0116498 scc=0.000458536 m=(1)
mn5 (net257 \4\:D \13\:VSS VSS) g45n1hvt w=(1.45e-07) l=4.5e-08 nf=1 \
        as=2.32e-14 ad=8.7e-15 ps=6.1e-07 pd=4.1e-07 nrd=1.16667 \
        nrs=1.16667 sa=3.45e-07 sb=9.45e-07 sd=160n sca=11.7118 \
        scb=0.0116498 scc=0.000458536 m=(1)
mn6 (\6\:n0 \4\:GNb net257 VSS) g45n1hvt w=(1.45e-07) l=4.5e-08 nf=1 \
        as=8.7e-15 ad=2.32e-14 ps=4.1e-07 pd=6.1e-07 nrd=1.16667 \
        nrs=1.16667 sa=4.5e-07 sb=8.4e-07 sd=160n sca=11.7118 \
        scb=0.0116498 scc=0.000458536 m=(1)
mn16 (\6\:n0 GNbb net245 VSS) g45n1hvt w=(1.45e-07) l=4.5e-08 nf=1 \
        as=3.553e-14 ad=2.32e-14 ps=7.8e-07 pd=6.1e-07 nrd=1.16667 \
        nrs=1.16667 sa=6.55e-07 sb=6.35e-07 sd=160n sca=11.7118 \
        scb=0.0116498 scc=0.000458536 m=(1)
mn15 (net245 \3\:Qint \11\:VSS VSS) g45n1hvt w=(1.45e-07) l=4.5e-08 nf=1 \
        as=2.32e-14 ad=3.553e-14 ps=6.1e-07 pd=7.8e-07 nrd=1.16667 \
        nrs=1.16667 sa=9.45e-07 sb=3.45e-07 sd=160n sca=11.7118 \
        scb=0.0116498 scc=0.000458536 m=(1)
mn10 (\15\:Qint \3\:n0 \11\:VSS VSS) g45n1hvt w=(1.45e-07) l=4.5e-08 \
        nf=1 as=2.32e-14 ad=2.03e-14 ps=6.1e-07 pd=5.7e-07 nrd=1.16667 \
        nrs=1.16667 sa=1.15e-06 sb=1.4e-07 sd=160n sca=11.7118 \
        scb=0.0116498 scc=0.000458536 m=(1)
mn0 (\11\:GNb \3\:GN \9\:VSS VSS) g45n1hvt w=(1.45e-07) l=4.5e-08 nf=1 \
        as=5.742e-14 ad=2.465e-14 ps=1.09e-06 pd=6.3e-07 nrd=1.16667 \
        nrs=1.16667 sa=1.7e-07 sb=4.9e-07 sd=160n sca=23.279 scb=0.0230742 \
        scc=0.00267719 m=(1)
mn22 (\1\:QN \9\:Qint \9\:VSS VSS) g45n1hvt w=(2.6e-07) l=4.5e-08 nf=1 \
        as=5.742e-14 ad=4.16e-14 ps=1.09e-06 pd=8.4e-07 nrd=1.16667 \
        nrs=1.16667 sa=3.40769e-07 sb=1.6e-07 sd=160n sca=17.5885 \
        scb=0.0172826 scc=0.00162584 m=(1)
mn20 (\7\:Qbint \8\:Qint \1\:VSS VSS) g45n1hvt w=(2.6e-07) l=4.5e-08 \
        nf=1 as=4.16e-14 ad=3.64e-14 ps=8.4e-07 pd=8e-07 nrd=1.16667 \
        nrs=1.16667 sa=1.4e-07 sb=3.45e-07 sd=160n sca=16.9678 \
        scb=0.0167861 scc=0.00150639 m=(1)
mn21 (\3\:Q \4\:Qbint \1\:VSS VSS) g45n1hvt w=(2.6e-07) l=4.5e-08 nf=1 \
        as=4.16e-14 ad=3.64e-14 ps=8.4e-07 pd=8e-07 nrd=1.16667 \
        nrs=1.16667 sa=3.45e-07 sb=1.4e-07 sd=160n sca=16.9678 \
        scb=0.0167861 scc=0.00150639 m=(1)
mp22 (\3\:QN \10\:Qint \6\:VDD VDD) g45p1hvt w=(3.9e-07) l=4.5e-08 nf=1 \
        as=7.825e-14 ad=5.46e-14 ps=1.28e-06 pd=1.06e-06 nrd=1.16667 \
        nrs=1.16667 sa=3.49487e-07 sb=1.4e-07 sd=160n sca=19.0259 \
        scb=0.0163587 scc=0.00171562 m=(1)
mp20 (\9\:Qbint \4\:Qint \1\:VDD VDD) g45p1hvt w=(3.9e-07) l=4.5e-08 \
        nf=1 as=6.24e-14 ad=5.46e-14 ps=1.1e-06 pd=1.06e-06 nrd=1.16667 \
        nrs=1.16667 sa=1.4e-07 sb=3.7e-07 sd=160n sca=31.7909 \
        scb=0.0210107 scc=0.00336206 m=(1)
mp21 (\1\:Q Qbint \1\:VDD VDD) g45p1hvt w=(3.9e-07) l=4.5e-08 nf=1 \
        as=6.24e-14 ad=6.435e-14 ps=1.1e-06 pd=1.11e-06 nrd=1.16667 \
        nrs=1.16667 sa=3.45e-07 sb=1.65e-07 sd=160n sca=34.23 \
        scb=0.0247192 scc=0.00340661 m=(1)
ends TLATNX1
// End of subcircuit definition.
