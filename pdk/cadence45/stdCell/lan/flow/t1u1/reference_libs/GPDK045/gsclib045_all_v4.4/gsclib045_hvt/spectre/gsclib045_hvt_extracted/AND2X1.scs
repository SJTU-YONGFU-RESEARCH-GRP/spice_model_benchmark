// Generated for: spectre (May  1 09:12:06 2013 )
// Library name: gsclib045_hvt
// Cell name: AND2X1
// View name: extracted

simulator lang=spectre

subckt AND2X1 A B VDD VSS Y
mp1 (\8\:n0 \4\:B \5\:VDD VDD) g45p1hvt w=(2.15e-07) l=4.5e-08 nf=1 \
        as=5.38e-14 ad=3.548e-14 ps=1.39e-06 pd=7.6e-07 nrd=1.16667 \
        nrs=1.16667 sa=1.2e-07 sb=5.55e-07 sd=160n sca=28.7776 \
        scb=0.0317346 scc=0.0021577 m=(1)
mp0 (\8\:n0 \1\:A \1\:VDD VDD) g45p1hvt w=(2.15e-07) l=4.5e-08 nf=1 \
        as=5.19e-14 ad=3.548e-14 ps=1.1e-06 pd=7.6e-07 nrd=1.16667 \
        nrs=1.16667 sa=3.3e-07 sb=3.45e-07 sd=160n sca=18.926 \
        scb=0.0187755 scc=0.000316918 m=(1)
C1 (Y VSS) capacitor c=5.39034e-17
C2 (VDD VSS) capacitor c=7.01328e-17
C3 (A VSS) capacitor c=7.97774e-17
C4 (n0 VSS) capacitor c=4.97999e-17
C5 (\1\:A VSS) capacitor c=4.94423e-17
C6 (\4\:B VSS) capacitor c=4.16052e-17
C7 (\3\:n0 VSS) capacitor c=4.0145e-17
C8 (\3\:A VSS) capacitor c=5.93263e-17
C9 (\1\:B VSS) capacitor c=5.24568e-17
C10 (\2\:n0 VSS) capacitor c=3.36276e-17
C11 (\2\:A VSS) capacitor c=6.62669e-17
C12 (\3\:B VSS) capacitor c=1.51302e-17
C13 (\1\:Y VSS) capacitor c=5.15264e-17
C14 (\1\:VDD VSS) capacitor c=4.55278e-17
C15 (\8\:n0 VSS) capacitor c=6.4416e-17
C16 (\5\:VDD VSS) capacitor c=8.93502e-18
C17 (\3\:Y VSS) capacitor c=3.03564e-17
C18 (\6\:n0 VSS) capacitor c=3.39163e-17
C19 (\2\:B VSS) capacitor c=4.6336e-17
C20 (\5\:B VSS) capacitor c=3.52173e-17
C21 (\7\:B VSS) capacitor c=3.91733e-17
C22 (\4\:A VSS) capacitor c=5.76527e-17
C23 (\4\:n0 VSS) capacitor c=7.30519e-17
C24 (\5\:n0 VSS) capacitor c=9.47543e-17
C25 (\4\:VDD VSS) capacitor c=2.04796e-17
Rk14 (\4\:VSS VSS) resistor r=0.1503 c=0
Rk13 (\2\:VSS \4\:VSS) resistor r=0.3451 c=0
Rk1 (\5\:B \6\:B) resistor r=0.001776 c=0
Rk2 (B \7\:B) resistor r=0.001658 c=0
Rk3 (\5\:B \7\:B) resistor r=0.03546 c=0
Rk8 (\2\:Y Y) resistor r=0.3325 c=0
Rk9 (Y \4\:Y) resistor r=0.1462 c=0
Rk11 (\4\:VDD VDD) resistor r=0.1511 c=0
Rk10 (\2\:VDD \4\:VDD) resistor r=0.3363 c=0
Rk12 (VDD \6\:VDD) resistor r=0.06875 c=0
Rk4 (A \4\:A) resistor r=0.1436 c=0
Rk5 (\4\:n0 \5\:n0) resistor r=0.2844 c=0
Rk6 (\5\:n0 \7\:n0) resistor r=0.1371 c=0
Rk7 (\5\:n0 \9\:n0) resistor r=0.4669 c=0
Rl3 (\2\:B \4\:B) resistor r=106.246 c=0
Rl1 (\1\:B \2\:B) resistor r=74.3274 c=0
Rl2 (\2\:B \3\:B) resistor r=5.1529 c=0
Rl4 (\1\:A \2\:A) resistor r=89.5596 c=0
Rl5 (\2\:A \3\:A) resistor r=81.8672 c=0
Rl6 (n0 \2\:n0) resistor r=39.5596 c=0
Rl7 (\2\:n0 \3\:n0) resistor r=64.5595 c=0
Rz4 (\1\:VSS \2\:VSS) resistor r=37.5 c=0
Rz2 (\3\:Y \4\:Y) resistor r=37.5 c=0
Rz1 (\6\:n0 \7\:n0) resistor r=75 c=0
Ry2 (\1\:Y \2\:Y) resistor r=20.6667 c=0
Ry3 (\1\:VDD \2\:VDD) resistor r=62 c=0
Ry4 (\5\:VDD \6\:VDD) resistor r=62 c=0
Ry1 (\8\:n0 \9\:n0) resistor r=62 c=0
Rx1 (\3\:B \6\:B) resistor r=45 c=0
Rx2 (\2\:A \4\:A) resistor r=45 c=0
Rx3 (\2\:n0 \4\:n0) resistor r=45 c=0
mn0 (net127 \1\:B \6\:n0 VSS) g45n1hvt w=(1.45e-07) l=4.5e-08 nf=1 \
        as=2.03e-14 ad=8.7e-15 ps=5.7e-07 pd=4.1e-07 nrd=1.16667 \
        nrs=1.16667 sa=1.4e-07 sb=4.85e-07 sd=160n sca=13.9854 \
        scb=0.014728 scc=0.000819645 m=(1)
mn1 (\1\:VSS \3\:A net127 VSS) g45n1hvt w=(1.45e-07) l=4.5e-08 nf=1 \
        as=8.7e-15 ad=4.438e-14 ps=4.1e-07 pd=9.1e-07 nrd=1.16667 \
        nrs=1.16667 sa=2.45e-07 sb=3.8e-07 sd=160n sca=13.9854 \
        scb=0.014728 scc=0.000819645 m=(1)
mn2 (\3\:Y \3\:n0 \1\:VSS VSS) g45n1hvt w=(2.6e-07) l=4.5e-08 nf=1 \
        as=4.438e-14 ad=3.64e-14 ps=9.1e-07 pd=8e-07 nrd=1.16667 \
        nrs=1.16667 sa=3.32404e-07 sb=1.4e-07 sd=160n sca=11.3041 \
        scb=0.010759 scc=0.000493236 m=(1)
mp2 (\1\:Y n0 \1\:VDD VDD) g45p1hvt w=(3.9e-07) l=4.5e-08 nf=1 \
        as=5.19e-14 ad=5.46e-14 ps=1.1e-06 pd=1.06e-06 nrd=1.16667 \
        nrs=1.16667 sa=3.39808e-07 sb=1.4e-07 sd=160n sca=35.5228 \
        scb=0.0370147 scc=0.0033854 m=(1)
ends AND2X1
// End of subcircuit definition.
