// gsclib045_hvt/MX4X4/schematic

simulator lang=spectre

subckt MX4X4 A B C D S0 S1 Y VDD VSS
mp9 (n1 S0b n10 VDD) g45p1hvt w=(215n) l=45n nf=1 m=(1)
mp8 (n10 D VDD VDD) g45p1hvt w=(215n) l=45n nf=1 m=(1)
mp7 (n1 S0 n8 VDD) g45p1hvt w=(215n) l=45n nf=1 m=(1)
mp6 (n8 C VDD VDD) g45p1hvt w=(215n) l=45n nf=1 m=(1)
mp5 (n0 S0b n6 VDD) g45p1hvt w=(215n) l=45n nf=1 m=(1)
mp4 (n6 B VDD VDD) g45p1hvt w=(215n) l=45n nf=1 m=(1)
mp3 (n0 S0 n4 VDD) g45p1hvt w=(215n) l=45n nf=1 m=(1)
mp2 (n4 A VDD VDD) g45p1hvt w=(215n) l=45n nf=1 m=(1)
mp12 (Y n2 VDD VDD) g45p1hvt w=(1.56u) l=45n nf=1 m=(1)
mp0 (S0b S0 VDD VDD) g45p1hvt w=(215n) l=45n nf=1 m=(1)
mp10 (n2 S1 n0 VDD) g45p1hvt w=(390n) l=45n nf=1 m=(1)
mp11 (n1 S1b n2 VDD) g45p1hvt w=(390n) l=45n nf=1 m=(1)
mp1 (S1b S1 VDD VDD) g45p1hvt w=(215n) l=45n nf=1 m=(1)
mn9 (n1 S0 n9 VSS) g45n1hvt w=(145n) l=45n nf=1 m=(1)
mn6 (n7 C VSS VSS) g45n1hvt w=(145n) l=45n nf=1 m=(1)
mn7 (n1 S0b n7 VSS) g45n1hvt w=(145n) l=45n nf=1 m=(1)
mn4 (n5 B VSS VSS) g45n1hvt w=(145n) l=45n nf=1 m=(1)
mn5 (n0 S0 n5 VSS) g45n1hvt w=(145n) l=45n nf=1 m=(1)
mn3 (n0 S0b n3 VSS) g45n1hvt w=(145n) l=45n nf=1 m=(1)
mn2 (n3 A VSS VSS) g45n1hvt w=(145n) l=45n nf=1 m=(1)
mn12 (Y n2 VSS VSS) g45n1hvt w=(1.04u) l=45n nf=1 m=(1)
mn1 (S1b S1 VSS VSS) g45n1hvt w=(145n) l=45n nf=1 m=(1)
mn11 (n2 S1 n1 VSS) g45n1hvt w=(260n) l=45n nf=1 m=(1)
mn8 (n9 D VSS VSS) g45n1hvt w=(145n) l=45n nf=1 m=(1)
mn10 (n2 S1b n0 VSS) g45n1hvt w=(260n) l=45n nf=1 m=(1)
mn0 (S0b S0 VSS VSS) g45n1hvt w=(145n) l=45n nf=1 m=(1)
ends MX4X4
