// Generated for: spectre (May  1 09:13:16 2013 )
// Library name: gsclib045_hvt
// Cell name: AOI33XL
// View name: extracted

simulator lang=spectre

subckt AOI33XL A0 A1 A2 B0 B1 B2 VDD VSS Y
mp0 (net124 \3\:A0 \4\:VDD VDD) g45p1hvt w=(2.15e-07) l=4.5e-08 nf=1 \
        as=4.38e-14 ad=3.655e-14 ps=1.33e-06 pd=7.7e-07 nrd=1.16667 \
        nrs=1.16667 sa=1e-07 sb=1.165e-06 sd=160n sca=30.1692 \
        scb=0.0324471 scc=0.00278498 m=(1)
mp1 (net124 \1\:A1 \6\:VDD VDD) g45p1hvt w=(2.15e-07) l=4.5e-08 nf=1 \
        as=5.415e-14 ad=3.655e-14 ps=1.41e-06 pd=7.7e-07 nrd=1.16667 \
        nrs=1.16667 sa=3.15e-07 sb=9.5e-07 sd=160n sca=14.9994 \
        scb=0.0139145 scc=0.000209273 m=(1)
mp2 (\3\:net124 \1\:A2 \6\:VDD VDD) g45p1hvt w=(2.15e-07) l=4.5e-08 nf=1 \
        as=5.415e-14 ad=3.44e-14 ps=1.41e-06 pd=7.5e-07 nrd=1.16667 \
        nrs=1.16667 sa=5.1e-07 sb=7.55e-07 sd=160n sca=12.5773 \
        scb=0.00960893 scc=0.000140232 m=(1)
mp5 (\1\:Y \1\:B2 \3\:net124 VDD) g45p1hvt w=(2.15e-07) l=4.5e-08 nf=1 \
        as=3.44e-14 ad=3.44e-14 ps=7.5e-07 pd=7.5e-07 nrd=1.16667 \
        nrs=1.16667 sa=7.15e-07 sb=5.5e-07 sd=160n sca=12.38 \
        scb=0.00928483 scc=0.000139001 m=(1)
mp4 (\1\:Y \1\:B1 \5\:net124 VDD) g45p1hvt w=(2.15e-07) l=4.5e-08 nf=1 \
        as=3.44e-14 ad=3.44e-14 ps=7.5e-07 pd=7.5e-07 nrd=1.16667 \
        nrs=1.16667 sa=9.2e-07 sb=3.45e-07 sd=160n sca=14.1566 \
        scb=0.012431 scc=0.000173041 m=(1)
mp3 (\6\:Y \1\:B0 \5\:net124 VDD) g45p1hvt w=(2.15e-07) l=4.5e-08 nf=1 \
        as=3.44e-14 ad=3.01e-14 ps=7.5e-07 pd=7.1e-07 nrd=1.16667 \
        nrs=1.16667 sa=1.125e-06 sb=1.4e-07 sd=160n sca=23.3203 \
        scb=0.0262833 scc=0.00133399 m=(1)
C1 (A1 VSS) capacitor c=2.44331e-17
C2 (Y VSS) capacitor c=1.52511e-17
C3 (B1 VSS) capacitor c=6.50267e-17
C4 (A0 VSS) capacitor c=2.32528e-17
C5 (VDD VSS) capacitor c=1.46605e-16
C6 (B2 VSS) capacitor c=2.38322e-17
C7 (A2 VSS) capacitor c=3.24808e-17
C8 (net149 VSS) capacitor c=8.56837e-22
C9 (net141 VSS) capacitor c=4.74221e-18
C10 (net137 VSS) capacitor c=2.34552e-18
C11 (net124 VSS) capacitor c=4.4457e-17
C12 (\1\:B0 VSS) capacitor c=3.94003e-17
C13 (\1\:B1 VSS) capacitor c=6.66627e-17
C14 (\1\:B2 VSS) capacitor c=3.36522e-17
C15 (\1\:A2 VSS) capacitor c=7.07933e-17
C16 (\1\:A1 VSS) capacitor c=5.54484e-17
C17 (\3\:A0 VSS) capacitor c=2.34929e-17
C18 (\3\:B0 VSS) capacitor c=6.07505e-17
C19 (\3\:B1 VSS) capacitor c=4.69085e-17
C20 (\3\:B2 VSS) capacitor c=6.97696e-17
C21 (\3\:A2 VSS) capacitor c=3.78072e-17
C22 (\3\:A1 VSS) capacitor c=5.95908e-17
C23 (\1\:A0 VSS) capacitor c=6.75054e-17
C24 (\2\:B0 VSS) capacitor c=6.64075e-17
C25 (\2\:B1 VSS) capacitor c=7.88943e-17
C26 (\2\:B2 VSS) capacitor c=6.06366e-17
C27 (\2\:A2 VSS) capacitor c=6.34458e-17
C28 (\2\:A1 VSS) capacitor c=6.77665e-17
C29 (\2\:A0 VSS) capacitor c=6.21201e-17
C30 (\5\:net124 VSS) capacitor c=6.94605e-17
C31 (\1\:Y VSS) capacitor c=6.08877e-17
C32 (\3\:net124 VSS) capacitor c=6.31978e-17
C33 (\6\:VDD VSS) capacitor c=1.16442e-17
C34 (\4\:VDD VSS) capacitor c=4.6552e-18
C35 (\4\:Y VSS) capacitor c=1.28763e-16
C36 (\4\:A0 VSS) capacitor c=1.95604e-17
C37 (\4\:A1 VSS) capacitor c=2.75884e-17
C38 (\4\:A2 VSS) capacitor c=2.9357e-17
C39 (\6\:B2 VSS) capacitor c=2.60102e-17
C40 (\4\:B1 VSS) capacitor c=6.57859e-17
C41 (\4\:B0 VSS) capacitor c=7.55684e-17
C42 (\5\:B0 VSS) capacitor c=7.17587e-17
C43 (\3\:Y VSS) capacitor c=1.18168e-16
C44 (\3\:VDD VSS) capacitor c=5.94233e-17
Rk2 (\4\:A1 A1) resistor r=0.04585 c=0
Rk13 (\2\:Y \3\:Y) resistor r=0.3216 c=0
Rk14 (\3\:Y \5\:Y) resistor r=0.9777 c=0
Rk16 (\7\:Y Y) resistor r=0.002814 c=0
Rk15 (\3\:Y \7\:Y) resistor r=0.07134 c=0
Rk7 (B1 \4\:B1) resistor r=0.1592 c=0
Rk1 (\4\:A0 A0) resistor r=0.04463 c=0
Rk18 (\3\:VSS VSS) resistor r=0.0171 c=0
Rk17 (\2\:VSS \3\:VSS) resistor r=0.213 c=0
Rk19 (\3\:VSS \5\:VSS) resistor r=0.283 c=0
Rk20 (\5\:VSS \7\:VSS) resistor r=0.3742 c=0
Rk22 (\3\:VDD VDD) resistor r=0.1704 c=0
Rk23 (VDD \5\:VDD) resistor r=0.07947 c=0
Rk24 (\3\:VDD \7\:VDD) resistor r=0.07346 c=0
Rk4 (\4\:B2 B2) resistor r=0.005012 c=0
Rk6 (\4\:B2 \6\:B2) resistor r=0.01641 c=0
Rk5 (\5\:B2 \6\:B2) resistor r=0.005012 c=0
Rk10 (B0 \4\:B0) resistor r=0.001228 c=0
Rk12 (\4\:B0 \5\:B0) resistor r=0.1041 c=0
Rk11 (\5\:B0 \6\:B0) resistor r=0.001293 c=0
Rk3 (A2 \4\:A2) resistor r=0.0404 c=0
Rk8 (\2\:net124 \4\:net124) resistor r=0.2726 c=0
Rk9 (\4\:net124 \6\:net124) resistor r=0.3667 c=0
Rl3 (\1\:A1 \2\:A1) resistor r=106.461 c=0
Rl4 (\2\:A1 \3\:A1) resistor r=141.076 c=0
Rl9 (\1\:B1 \2\:B1) resistor r=204.944 c=0
Rl10 (\2\:B1 \3\:B1) resistor r=35.7134 c=0
Rl2 (\2\:A0 \3\:A0) resistor r=26.3736 c=0
Rl1 (\1\:A0 \2\:A0) resistor r=223.077 c=0
Rl7 (\1\:B2 \2\:B2) resistor r=33.3841 c=0
Rl8 (\2\:B2 \3\:B2) resistor r=214.153 c=0
Rl11 (\1\:B0 \2\:B0) resistor r=102.978 c=0
Rl12 (\2\:B0 \3\:B0) resistor r=147.253 c=0
Rl5 (\1\:A2 \2\:A2) resistor r=175.692 c=0
Rl6 (\2\:A2 \3\:A2) resistor r=71.8456 c=0
Rz1 (\4\:Y \5\:Y) resistor r=75 c=0
Rz2 (\1\:VSS \2\:VSS) resistor r=75 c=0
Rz3 (\6\:VSS \7\:VSS) resistor r=75 c=0
Ry4 (\1\:Y \2\:Y) resistor r=62 c=0
Ry5 (\6\:Y \7\:Y) resistor r=62 c=0
Ry7 (\4\:VDD \5\:VDD) resistor r=62 c=0
Ry8 (\6\:VDD \7\:VDD) resistor r=62 c=0
Ry1 (net124 \2\:net124) resistor r=62 c=0
Ry2 (\3\:net124 \4\:net124) resistor r=62 c=0
Ry3 (\5\:net124 \6\:net124) resistor r=62 c=0
Rx2 (\2\:A1 \4\:A1) resistor r=45 c=0
Rx5 (\2\:B1 \4\:B1) resistor r=45 c=0
Rx1 (\2\:A0 \4\:A0) resistor r=45 c=0
Rx4 (\2\:B2 \5\:B2) resistor r=45 c=0
Rx6 (\2\:B0 \6\:B0) resistor r=45 c=0
Rx3 (\2\:A2 \4\:A2) resistor r=45 c=0
mn0 (net149 \1\:A0 \1\:VSS VSS) g45n1hvt w=(1.45e-07) l=4.5e-08 nf=1 \
        as=2.03e-14 ad=1.378e-14 ps=5.7e-07 pd=4.8e-07 nrd=1.16667 \
        nrs=1.16667 sa=1.4e-07 sb=1.025e-06 sd=160n sca=7.688 \
        scb=0.00504888 scc=6.29443e-05 m=(1)
mn1 (net153 \3\:A1 net149 VSS) g45n1hvt w=(1.45e-07) l=4.5e-08 nf=1 \
        as=1.378e-14 ad=2.175e-14 ps=4.8e-07 pd=5.9e-07 nrd=1.16667 \
        nrs=1.16667 sa=2.8e-07 sb=8.85e-07 sd=160n sca=7.688 \
        scb=0.00504888 scc=6.29443e-05 m=(1)
mn2 (\4\:Y \3\:A2 net153 VSS) g45n1hvt w=(1.45e-07) l=4.5e-08 nf=1 \
        as=2.175e-14 ad=2.32e-14 ps=5.9e-07 pd=6.1e-07 nrd=1.16667 \
        nrs=1.16667 sa=4.75e-07 sb=6.9e-07 sd=160n sca=7.688 \
        scb=0.00504888 scc=6.29443e-05 m=(1)
mn5 (\4\:Y \3\:B2 net141 VSS) g45n1hvt w=(1.45e-07) l=4.5e-08 nf=1 \
        as=2.32e-14 ad=2.32e-14 ps=6.1e-07 pd=6.1e-07 nrd=1.16667 \
        nrs=1.16667 sa=6.8e-07 sb=4.85e-07 sd=160n sca=7.688 \
        scb=0.00504888 scc=6.29443e-05 m=(1)
mn4 (net137 \3\:B1 net141 VSS) g45n1hvt w=(1.45e-07) l=4.5e-08 nf=1 \
        as=2.32e-14 ad=9.43e-15 ps=6.1e-07 pd=4.2e-07 nrd=1.16667 \
        nrs=1.16667 sa=8.85e-07 sb=2.8e-07 sd=160n sca=7.688 \
        scb=0.00504888 scc=6.29443e-05 m=(1)
mn3 (\6\:VSS \3\:B0 net137 VSS) g45n1hvt w=(1.45e-07) l=4.5e-08 nf=1 \
        as=9.43e-15 ad=4.025e-14 ps=4.2e-07 pd=8.9e-07 nrd=1.16667 \
        nrs=1.16667 sa=9.95e-07 sb=1.7e-07 sd=160n sca=7.688 \
        scb=0.00504888 scc=6.29443e-05 m=(1)
ends AOI33XL
// End of subcircuit definition.
