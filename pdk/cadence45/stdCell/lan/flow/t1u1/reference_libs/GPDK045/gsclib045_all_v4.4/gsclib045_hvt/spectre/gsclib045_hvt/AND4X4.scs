// gsclib045_hvt/AND4X4/schematic

simulator lang=spectre

subckt AND4X4 A B C D Y VDD VSS
mp3 (net100 D VDD VDD) g45p1hvt w=(390n) l=45n nf=1 m=(1)
mp2 (net100 C VDD VDD) g45p1hvt w=(390n) l=45n nf=1 m=(1)
mp1 (net100 B VDD VDD) g45p1hvt w=(390n) l=45n nf=1 m=(1)
mp4 (Y net100 VDD VDD) g45p1hvt w=(1.56u) l=45n nf=1 m=(1)
mp0 (net100 A VDD VDD) g45p1hvt w=(390n) l=45n nf=1 m=(1)
mn3 (net100 D net132 VSS) g45n1hvt w=(260n) l=45n nf=1 m=(1)
mn2 (net132 C net124 VSS) g45n1hvt w=(260n) l=45n nf=1 m=(1)
mn4 (Y net100 VSS VSS) g45n1hvt w=(1.04u) l=45n nf=1 m=(1)
mn1 (net124 B net120 VSS) g45n1hvt w=(260n) l=45n nf=1 m=(1)
mn0 (net120 A VSS VSS) g45n1hvt w=(260n) l=45n nf=1 m=(1)
ends AND4X4
