// Generated for: spectre (May  1 09:14:50 2013 )
// Library name: gsclib045_hvt
// Cell name: DFFSRXL
// View name: extracted

simulator lang=spectre

subckt DFFSRXL CK D Q QN RN SN VDD VSS
mp57 (\1\:QN \4\:qint \25\:VDD VDD) g45p1hvt w=(2.15e-07) l=4.5e-08 nf=1 \
        as=4.91e-14 ad=3.01e-14 ps=9e-07 pd=7.1e-07 nrd=1.16667 \
        nrs=1.16667 sa=1.4e-07 sb=4.05e-07 sd=160n sca=49.8399 \
        scb=0.0334143 scc=0.00594375 m=(1)
mp56 (\9\:qint \6\:qbint \25\:VDD VDD) g45p1hvt w=(2.15e-07) l=4.5e-08 \
        nf=1 as=4.91e-14 ad=3.01e-14 ps=9e-07 pd=7.1e-07 nrd=1.16667 \
        nrs=1.16667 sa=4.05e-07 sb=1.4e-07 sd=160n sca=46.8055 \
        scb=0.0288702 scc=0.00588464 m=(1)
mp55 (\1\:Q qbint \22\:VDD VDD) g45p1hvt w=(2.15e-07) l=4.5e-08 nf=1 \
        as=3.44e-14 ad=4.3e-14 ps=7.5e-07 pd=8.3e-07 nrd=1.16667 \
        nrs=1.16667 sa=2e-07 sb=4.48023e-07 sd=160n sca=10.1832 \
        scb=0.00742094 scc=7.76436e-05 m=(1)
mp22 (\7\:RNb \1\:RN \22\:VDD VDD) g45p1hvt w=(2.15e-07) l=4.5e-08 nf=1 \
        as=3.44e-14 ad=5.225e-14 ps=7.5e-07 pd=9.3e-07 nrd=1.16667 \
        nrs=1.16667 sa=4.05e-07 sb=2.43023e-07 sd=160n sca=10.1832 \
        scb=0.00742094 scc=7.76436e-05 m=(1)
mp45 (\14\:qbint \4\:n35 \20\:VDD VDD) g45p1hvt w=(2.15e-07) l=4.5e-08 \
        nf=1 as=6.64e-14 ad=2.69e-14 ps=1.9e-06 pd=7.2e-07 nrd=1.16667 \
        nrs=1.16667 sa=1.25116e-07 sb=7.7e-07 sd=160n sca=45.7906 \
        scb=0.0283307 scc=0.00588417 m=(1)
mp50 (\3\:n41 \3\:SN \20\:VDD VDD) g45p1hvt w=(2.15e-07) l=4.5e-08 nf=1 \
        as=6.64e-14 ad=3.44e-14 ps=1.9e-06 pd=7.5e-07 nrd=1.16667 \
        nrs=1.16667 sa=3.20116e-07 sb=5.75e-07 sd=160n sca=45.7906 \
        scb=0.0283307 scc=0.00588417 m=(1)
mp52 (\3\:n41 \9\:qbint n43 VDD) g45p1hvt w=(2.15e-07) l=4.5e-08 nf=1 \
        as=1.29e-14 ad=3.44e-14 ps=5.5e-07 pd=7.5e-07 nrd=1.16667 \
        nrs=1.16667 sa=5.25116e-07 sb=3.7e-07 sd=160n sca=45.7906 \
        scb=0.0283307 scc=0.00588417 m=(1)
mp51 (n43 \4\:RNb \18\:VDD VDD) g45p1hvt w=(2.15e-07) l=4.5e-08 nf=1 \
        as=8.217e-14 ad=1.29e-14 ps=1.38e-06 pd=5.5e-07 nrd=1.16667 \
        nrs=1.16667 sa=6.30116e-07 sb=2.65e-07 sd=160n sca=45.7906 \
        scb=0.0283307 scc=0.00588417 m=(1)
mp53 (\9\:n35 CKbb n41 VDD) g45p1hvt w=(2.15e-07) l=4.5e-08 nf=1 \
        as=3.01e-14 ad=3.44e-14 ps=7.1e-07 pd=7.5e-07 nrd=1.16667 \
        nrs=1.16667 sa=1.4e-07 sb=5.75e-07 sd=160n sca=45.7906 \
        scb=0.0283307 scc=0.00588417 m=(1)
mp40 (\9\:n35 \2\:CKb \9\:mout VDD) g45p1hvt w=(2.15e-07) l=4.5e-08 nf=1 \
        as=7.955e-14 ad=3.44e-14 ps=1.17e-06 pd=7.5e-07 nrd=1.16667 \
        nrs=1.16667 sa=3.45e-07 sb=3.7e-07 sd=160n sca=45.7906 \
        scb=0.0283307 scc=0.00588417 m=(1)
mp31 (net402 RNb \16\:VDD VDD) g45p1hvt w=(2.15e-07) l=4.5e-08 nf=1 \
        as=9.475e-14 ad=1.29e-14 ps=1.74e-06 pd=5.5e-07 nrd=1.16667 \
        nrs=1.16667 sa=1.7e-07 sb=1.67e-06 sd=160n sca=31.508 \
        scb=0.0252524 scc=0.00399199 m=(1)
mp32 (\7\:mout \3\:n20 net402 VDD) g45p1hvt w=(2.15e-07) l=4.5e-08 nf=1 \
        as=1.29e-14 ad=3.977e-14 ps=5.5e-07 pd=8e-07 nrd=1.16667 \
        nrs=1.16667 sa=2.75e-07 sb=1.565e-06 sd=160n sca=31.508 \
        scb=0.0252524 scc=0.00399199 m=(1)
mp30 (\7\:mout \4\:SN \14\:VDD VDD) g45p1hvt w=(2.15e-07) l=4.5e-08 nf=1 \
        as=1.1088e-13 ad=3.977e-14 ps=1.89e-06 pd=8e-07 nrd=1.16667 \
        nrs=1.16667 sa=5.05e-07 sb=1.335e-06 sd=160n sca=31.508 \
        scb=0.0252524 scc=0.00399199 m=(1)
mp35 (n31 mout \14\:VDD VDD) g45p1hvt w=(2.15e-07) l=4.5e-08 nf=1 \
        as=1.1088e-13 ad=3.977e-14 ps=1.89e-06 pd=8e-07 nrd=1.16667 \
        nrs=1.16667 sa=7.95e-07 sb=1.045e-06 sd=160n sca=31.508 \
        scb=0.0252524 scc=0.00399199 m=(1)
mp36 (\7\:n20 \5\:CKb n31 VDD) g45p1hvt w=(2.15e-07) l=4.5e-08 nf=1 \
        as=3.977e-14 ad=6.127e-14 ps=8e-07 pd=1e-06 nrd=1.16667 \
        nrs=1.16667 sa=1.025e-06 sb=8.15e-07 sd=160n sca=31.508 \
        scb=0.0252524 scc=0.00399199 m=(1)
mp26 (\7\:n20 \7\:CKbb n22 VDD) g45p1hvt w=(2.15e-07) l=4.5e-08 nf=1 \
        as=2.042e-14 ad=6.127e-14 ps=6.2e-07 pd=1e-06 nrd=1.16667 \
        nrs=1.16667 sa=1.355e-06 sb=4.85e-07 sd=160n sca=31.508 \
        scb=0.0252524 scc=0.00399199 m=(1)
mp25 (n22 \4\:D \12\:VDD VDD) g45p1hvt w=(2.15e-07) l=4.5e-08 nf=1 \
        as=6.705e-14 ad=2.042e-14 ps=1.86e-06 pd=6.2e-07 nrd=1.16667 \
        nrs=1.16667 sa=1.495e-06 sb=3.45e-07 sd=160n sca=31.508 \
        scb=0.0252524 scc=0.00399199 m=(1)
mp21 (\11\:CKbb \7\:CKb \12\:VDD VDD) g45p1hvt w=(2.15e-07) l=4.5e-08 \
        nf=1 as=6.705e-14 ad=3.01e-14 ps=1.86e-06 pd=7.1e-07 nrd=1.16667 \
        nrs=1.16667 sa=1.7e-06 sb=1.4e-07 sd=160n sca=31.995 scb=0.0254181 \
        scc=0.00399203 m=(1)
mp20 (\10\:CKb \1\:CK \1\:VDD VDD) g45p1hvt w=(2.15e-07) l=4.5e-08 nf=1 \
        as=5.267e-14 ad=3.655e-14 ps=9.2e-07 pd=7.7e-07 nrd=1.16667 \
        nrs=1.16667 sa=1.7e-07 sb=2.45e-07 sd=160n sca=38.6695 \
        scb=0.0332521 scc=0.00441508 m=(1)
C1 (RN VSS) capacitor c=8.30862e-17
C2 (CK VSS) capacitor c=1.00586e-16
C3 (D VSS) capacitor c=6.83961e-17
C4 (Q VSS) capacitor c=6.35514e-17
C5 (VDD VSS) capacitor c=3.86069e-16
C6 (SN VSS) capacitor c=3.12982e-16
C7 (QN VSS) capacitor c=2.25228e-17
C8 (qint VSS) capacitor c=2.23816e-17
C9 (qbint VSS) capacitor c=5.01473e-17
C10 (RNb VSS) capacitor c=1.01541e-16
C11 (n35 VSS) capacitor c=2.42379e-17
C12 (n42 VSS) capacitor c=8.5051e-17
C13 (n40 VSS) capacitor c=8.46181e-17
C14 (CKb VSS) capacitor c=5.38311e-17
C15 (mout VSS) capacitor c=4.65146e-17
C16 (CKbb VSS) capacitor c=4.90962e-17
C17 (net426 VSS) capacitor c=1.00218e-16
C18 (n20 VSS) capacitor c=3.06596e-17
C19 (n30 VSS) capacitor c=2.7422e-18
C20 (n41 VSS) capacitor c=9.80885e-17
C21 (n43 VSS) capacitor c=1.57959e-18
C22 (net402 VSS) capacitor c=1.4968e-18
C23 (n31 VSS) capacitor c=5.50675e-18
C24 (n22 VSS) capacitor c=3.16327e-18
C25 (\1\:CK VSS) capacitor c=2.32735e-17
C26 (\7\:CKb VSS) capacitor c=5.34076e-17
C27 (\4\:D VSS) capacitor c=7.71813e-17
C28 (\7\:CKbb VSS) capacitor c=4.89532e-17
C29 (\5\:CKb VSS) capacitor c=6.19266e-17
C30 (\4\:SN VSS) capacitor c=4.03943e-17
C31 (\3\:n20 VSS) capacitor c=9.08146e-17
C32 (\2\:CKb VSS) capacitor c=5.07044e-17
C33 (\4\:RNb VSS) capacitor c=8.37342e-17
C34 (\9\:qbint VSS) capacitor c=8.16414e-17
C35 (\3\:SN VSS) capacitor c=5.03824e-17
C36 (\4\:n35 VSS) capacitor c=3.92866e-17
C37 (\1\:RN VSS) capacitor c=3.8764e-17
C38 (\6\:qbint VSS) capacitor c=3.09039e-17
C39 (\4\:qint VSS) capacitor c=3.31678e-17
C40 (\3\:CK VSS) capacitor c=2.42698e-17
C41 (\8\:CKb VSS) capacitor c=6.8258e-17
C42 (\3\:D VSS) capacitor c=3.0605e-17
C43 (\4\:CKb VSS) capacitor c=5.90228e-17
C44 (\5\:CKbb VSS) capacitor c=5.63326e-17
C45 (\3\:mout VSS) capacitor c=6.45024e-17
C46 (\7\:SN VSS) capacitor c=5.08997e-17
C47 (\2\:n20 VSS) capacitor c=3.72801e-17
C48 (\2\:RNb VSS) capacitor c=1.10585e-16
C49 (\3\:CKbb VSS) capacitor c=4.31034e-17
C50 (\3\:RNb VSS) capacitor c=1.10206e-16
C51 (\7\:qbint VSS) capacitor c=3.02669e-17
C52 (\1\:SN VSS) capacitor c=3.99228e-17
C53 (\3\:n35 VSS) capacitor c=3.83225e-17
C54 (\3\:RN VSS) capacitor c=3.58457e-17
C55 (\3\:qbint VSS) capacitor c=2.1972e-17
C56 (\5\:qbint VSS) capacitor c=2.13241e-17
C57 (\3\:qint VSS) capacitor c=2.64634e-17
C58 (\2\:CK VSS) capacitor c=1.71363e-17
C59 (\9\:CKb VSS) capacitor c=2.24468e-17
C60 (\1\:D VSS) capacitor c=2.39385e-17
C61 (\8\:CKbb VSS) capacitor c=3.88233e-17
C62 (\6\:CKb VSS) capacitor c=2.43147e-17
C63 (\6\:CKbb VSS) capacitor c=4.81093e-17
C64 (\2\:mout VSS) capacitor c=5.20175e-17
C65 (\6\:SN VSS) capacitor c=2.72343e-17
C66 (\4\:CKbb VSS) capacitor c=4.1186e-17
C67 (\3\:CKb VSS) capacitor c=3.19753e-17
C68 (\2\:CKbb VSS) capacitor c=2.62992e-17
C69 (\5\:RNb VSS) capacitor c=2.46108e-17
C70 (\8\:qbint VSS) capacitor c=5.49017e-17
C71 (\2\:SN VSS) capacitor c=6.3775e-17
C72 (\2\:RN VSS) capacitor c=4.17331e-17
C73 (\2\:qbint VSS) capacitor c=4.80846e-17
C74 (\1\:VDD VSS) capacitor c=5.01559e-17
C75 (\10\:CKb VSS) capacitor c=7.45906e-17
C76 (\11\:CKbb VSS) capacitor c=1.14178e-16
C77 (\12\:VDD VSS) capacitor c=1.14339e-17
C78 (\7\:n20 VSS) capacitor c=9.66039e-17
C79 (\14\:VDD VSS) capacitor c=1.79323e-17
C80 (\7\:mout VSS) capacitor c=1.59899e-16
C81 (\16\:VDD VSS) capacitor c=2.2796e-17
C82 (\9\:mout VSS) capacitor c=1.53963e-16
C83 (\9\:n35 VSS) capacitor c=2.28327e-17
C84 (\18\:VDD VSS) capacitor c=4.38414e-17
C85 (\3\:n41 VSS) capacitor c=1.36698e-16
C86 (\20\:VDD VSS) capacitor c=1.288e-17
C87 (\14\:qbint VSS) capacitor c=5.46563e-17
C88 (\7\:RNb VSS) capacitor c=1.13217e-16
C89 (\22\:VDD VSS) capacitor c=2.81806e-17
C90 (\1\:Q VSS) capacitor c=7.04086e-17
C91 (\9\:qint VSS) capacitor c=3.7528e-17
C92 (\25\:VDD VSS) capacitor c=3.86089e-17
C93 (\1\:QN VSS) capacitor c=2.07565e-17
C94 (\4\:VDD VSS) capacitor c=8.75316e-17
C95 (\15\:CKb VSS) capacitor c=5.97623e-17
C96 (\9\:CKbb VSS) capacitor c=7.30447e-17
C97 (\5\:n20 VSS) capacitor c=8.00119e-17
C98 (\4\:mout VSS) capacitor c=1.00865e-16
C99 (\3\:net426 VSS) capacitor c=8.70379e-17
C100 (\12\:mout VSS) capacitor c=7.52772e-17
C101 (\5\:n35 VSS) capacitor c=7.26316e-17
C102 (\3\:n40 VSS) capacitor c=8.88927e-17
C103 (\3\:n42 VSS) capacitor c=9.49039e-17
C104 (\12\:qbint VSS) capacitor c=8.08818e-17
C105 (\9\:RNb VSS) capacitor c=8.38923e-17
C106 (\3\:Q VSS) capacitor c=4.10824e-17
C107 (\7\:qint VSS) capacitor c=3.71773e-17
C108 (\3\:QN VSS) capacitor c=3.543e-17
C109 (\2\:qint VSS) capacitor c=8.04017e-18
C110 (\4\:qbint VSS) capacitor c=3.56838e-17
C111 (\2\:n35 VSS) capacitor c=2.62199e-17
C112 (\5\:SN VSS) capacitor c=1.75003e-17
C113 (\2\:D VSS) capacitor c=3.51444e-17
C114 (\5\:qint VSS) capacitor c=2.95759e-17
C115 (\6\:qint VSS) capacitor c=3.96373e-17
C116 (\4\:RN VSS) capacitor c=4.24708e-17
C117 (\10\:qbint VSS) capacitor c=8.07721e-17
C118 (\11\:qbint VSS) capacitor c=6.72658e-17
C119 (\16\:qbint VSS) capacitor c=1.16215e-16
C120 (\6\:RNb VSS) capacitor c=9.78244e-17
C121 (\7\:n35 VSS) capacitor c=1.94271e-16
C122 (\8\:n35 VSS) capacitor c=1.85594e-16
C123 (\8\:SN VSS) capacitor c=2.53892e-16
C124 (\9\:SN VSS) capacitor c=1.40818e-16
C125 (\6\:mout VSS) capacitor c=8.62345e-17
C126 (\11\:mout VSS) capacitor c=3.04527e-17
C127 (\4\:n20 VSS) capacitor c=7.89554e-17
C128 (\5\:D VSS) capacitor c=3.63337e-17
C129 (\13\:CKbb VSS) capacitor c=7.79022e-17
C130 (\14\:CKbb VSS) capacitor c=2.33319e-16
C131 (\15\:CKbb VSS) capacitor c=2.16674e-16
C132 (\16\:CKbb VSS) capacitor c=3.81223e-17
C133 (\17\:CKbb VSS) capacitor c=3.76578e-17
C134 (\18\:CKbb VSS) capacitor c=7.16821e-17
C135 (\19\:CKbb VSS) capacitor c=6.69468e-17
C136 (\12\:CKb VSS) capacitor c=9.59135e-17
C137 (\13\:CKb VSS) capacitor c=2.1868e-16
C138 (\14\:CKb VSS) capacitor c=1.67902e-16
C139 (\4\:CK VSS) capacitor c=2.27008e-17
C140 (\3\:VDD VSS) capacitor c=2.49131e-17
C141 (\6\:VDD VSS) capacitor c=2.88473e-17
C142 (\7\:VDD VSS) capacitor c=1.93195e-17
C143 (\9\:VDD VSS) capacitor c=2.26602e-17
C144 (\10\:VDD VSS) capacitor c=2.21688e-17
C145 (\24\:VDD VSS) capacitor c=1.31463e-17
Rk8 (\4\:RN RN) resistor r=0.03374 c=0
Rk46 (\4\:CK CK) resistor r=0.02402 c=0
Rk31 (\5\:D D) resistor r=0.186 c=0
Rk6 (\2\:Q Q) resistor r=0.4329 c=0
Rk7 (Q \4\:Q) resistor r=0.04556 c=0
Rk64 (\2\:VSS \4\:VSS) resistor r=0.7007 c=0
Rk65 (\4\:VSS \5\:VSS) resistor r=0.4678 c=0
Rk66 (\5\:VSS \6\:VSS) resistor r=0.5832 c=0
Rk67 (\6\:VSS \7\:VSS) resistor r=0.8224 c=0
Rk68 (\7\:VSS \8\:VSS) resistor r=0.381 c=0
Rk70 (\9\:VSS VSS) resistor r=0.1952 c=0
Rk69 (\8\:VSS \9\:VSS) resistor r=0.3565 c=0
Rk71 (\4\:VSS \11\:VSS) resistor r=0.2465 c=0
Rk72 (\5\:VSS \13\:VSS) resistor r=0.04331 c=0
Rk73 (\7\:VSS \15\:VSS) resistor r=0.2402 c=0
Rk74 (\8\:VSS \17\:VSS) resistor r=0.4333 c=0
Rk75 (\9\:VSS \19\:VSS) resistor r=0.3705 c=0
Rk47 (\2\:VDD \3\:VDD) resistor r=0.7685 c=0
Rk48 (\3\:VDD \5\:VDD) resistor r=0.03241 c=0
Rk49 (\5\:VDD \6\:VDD) resistor r=0.4678 c=0
Rk50 (\6\:VDD \7\:VDD) resistor r=0.2986 c=0
Rk51 (\7\:VDD \8\:VDD) resistor r=0.2822 c=0
Rk52 (\8\:VDD \9\:VDD) resistor r=0.5064 c=0
Rk53 (\9\:VDD \10\:VDD) resistor r=0.3347 c=0
Rk54 (\10\:VDD \11\:VDD) resistor r=0.36 c=0
Rk55 (\3\:VDD \13\:VDD) resistor r=0.07393 c=0
Rk56 (\6\:VDD \15\:VDD) resistor r=0.04331 c=0
Rk57 (\7\:VDD \17\:VDD) resistor r=0.04331 c=0
Rk58 (\9\:VDD \19\:VDD) resistor r=0.2777 c=0
Rk59 (\10\:VDD \21\:VDD) resistor r=0.04331 c=0
Rk60 (\11\:VDD \23\:VDD) resistor r=0.2673 c=0
Rk63 (\24\:VDD VDD) resistor r=0.2102 c=0
Rk61 (\11\:VDD \24\:VDD) resistor r=0.3414 c=0
Rk62 (\24\:VDD \26\:VDD) resistor r=0.4081 c=0
Rk22 (\8\:SN SN) resistor r=1.6494 c=0
Rk23 (SN \9\:SN) resistor r=0.8257 c=0
Rk2 (\4\:QN QN) resistor r=0.08804 c=0
Rk1 (\2\:QN \4\:QN) resistor r=0.2248 c=0
Rk3 (\5\:qint \6\:qint) resistor r=0.1194 c=0
Rk4 (\6\:qint \8\:qint) resistor r=0.1088 c=0
Rk5 (\6\:qint \10\:qint) resistor r=0.116 c=0
Rk9 (\10\:qbint \11\:qbint) resistor r=0.3841 c=0
Rk10 (\11\:qbint \13\:qbint) resistor r=0.1237 c=0
Rk11 (\11\:qbint \15\:qbint) resistor r=0.2837 c=0
Rk12 (\13\:qbint \16\:qbint) resistor r=0.7447 c=0
Rk13 (\6\:RNb \8\:RNb) resistor r=0.6233 c=0
Rk14 (\8\:RNb \10\:RNb) resistor r=0.4444 c=0
Rk18 (\6\:n35 \7\:n35) resistor r=0.4152 c=0
Rk19 (\7\:n35 \8\:n35) resistor r=1.1382 c=0
Rk20 (\7\:n35 \10\:n35) resistor r=0.02826 c=0
Rk15 (\2\:n42 \4\:n42) resistor r=0.421 c=0
Rk16 (\2\:n40 \4\:n40) resistor r=0.3539 c=0
Rk40 (\11\:CKb \12\:CKb) resistor r=0.2642 c=0
Rk41 (\12\:CKb \13\:CKb) resistor r=0.6136 c=0
Rk42 (\13\:CKb \14\:CKb) resistor r=1.3328 c=0
Rk43 (\11\:CKb \16\:CKb) resistor r=0.3881 c=0
Rk24 (\5\:mout \6\:mout) resistor r=0.559 c=0
Rk25 (\6\:mout \8\:mout) resistor r=0.3846 c=0
Rk26 (\8\:mout \10\:mout) resistor r=0.7091 c=0
Rk27 (\6\:mout \11\:mout) resistor r=0.1126 c=0
Rk28 (\10\:mout \13\:mout) resistor r=0.3665 c=0
Rk32 (\10\:CKbb \12\:CKbb) resistor r=0.5696 c=0
Rk33 (\12\:CKbb \13\:CKbb) resistor r=0.341 c=0
Rk34 (\13\:CKbb \14\:CKbb) resistor r=0.3743 c=0
Rk35 (\14\:CKbb \15\:CKbb) resistor r=1.3221 c=0
Rk36 (\15\:CKbb \16\:CKbb) resistor r=0.2422 c=0
Rk37 (\13\:CKbb \17\:CKbb) resistor r=0.1825 c=0
Rk38 (\14\:CKbb \18\:CKbb) resistor r=0.3233 c=0
Rk39 (\15\:CKbb \19\:CKbb) resistor r=0.2475 c=0
Rk21 (\2\:net426 \4\:net426) resistor r=0.6342 c=0
Rk29 (\4\:n20 \6\:n20) resistor r=0.5107 c=0
Rk30 (\6\:n20 \8\:n20) resistor r=0.4679 c=0
Rk17 (\2\:n41 \4\:n41) resistor r=0.5104 c=0
Rl9 (\1\:RN \2\:RN) resistor r=81.461 c=0
Rl10 (\2\:RN \3\:RN) resistor r=98.7687 c=0
Rl42 (\1\:CK \2\:CK) resistor r=29.5379 c=0
Rl43 (\2\:CK \3\:CK) resistor r=46.8456 c=0
Rl39 (\2\:D \4\:D) resistor r=143.11 c=0
Rl38 (\2\:D \3\:D) resistor r=46.9565 c=0
Rl37 (\1\:D \2\:D) resistor r=2.4834 c=0
Rl15 (\2\:SN \3\:SN) resistor r=50.2509 c=0
Rl14 (\1\:SN \2\:SN) resistor r=87.6944 c=0
Rl28 (\4\:SN \5\:SN) resistor r=34.3295 c=0
Rl30 (\5\:SN \7\:SN) resistor r=86.2526 c=0
Rl29 (\5\:SN \6\:SN) resistor r=5.9102 c=0
Rl3 (\2\:qint \4\:qint) resistor r=47.791 c=0
Rl2 (\2\:qint \3\:qint) resistor r=36.2526 c=0
Rl1 (qint \2\:qint) resistor r=5.915 c=0
Rl17 (\8\:qbint \9\:qbint) resistor r=112.912 c=0
Rl16 (\7\:qbint \8\:qbint) resistor r=28.8462 c=0
Rl4 (qbint \2\:qbint) resistor r=147.807 c=0
Rl5 (\2\:qbint \3\:qbint) resistor r=25.1665 c=0
Rl8 (\4\:qbint \6\:qbint) resistor r=49.521 c=0
Rl7 (\4\:qbint \5\:qbint) resistor r=42.7196 c=0
Rl6 (\2\:qbint \4\:qbint) resistor r=158.001 c=0
Rl22 (RNb \2\:RNb) resistor r=211.104 c=0
Rl24 (\3\:RNb \4\:RNb) resistor r=230.335 c=0
Rl23 (\2\:RNb \3\:RNb) resistor r=666.873 c=0
Rl25 (\4\:RNb \5\:RNb) resistor r=31.9251 c=0
Rl13 (\2\:n35 \4\:n35) resistor r=43.9449 c=0
Rl12 (\2\:n35 \3\:n35) resistor r=113.176 c=0
Rl11 (n35 \2\:n35) resistor r=0.5213 c=0
Rl40 (\7\:CKb \8\:CKb) resistor r=200 c=0
Rl34 (\4\:CKb \5\:CKb) resistor r=243.469 c=0
Rl19 (CKb \2\:CKb) resistor r=121.524 c=0
Rl41 (\7\:CKb \9\:CKb) resistor r=66.8207 c=0
Rl35 (\5\:CKb \6\:CKb) resistor r=50.6918 c=0
Rl20 (\2\:CKb \3\:CKb) resistor r=75.5311 c=0
Rl31 (mout \2\:mout) resistor r=73.7687 c=0
Rl32 (\2\:mout \3\:mout) resistor r=100.692 c=0
Rl36 (\7\:CKbb \8\:CKbb) resistor r=35.7713 c=0
Rl33 (\5\:CKbb \6\:CKbb) resistor r=93.4636 c=0
Rl21 (\3\:CKbb \4\:CKbb) resistor r=76.3887 c=0
Rl18 (CKbb \2\:CKbb) resistor r=31.9251 c=0
Rl27 (\2\:n20 \3\:n20) resistor r=128.846 c=0
Rl26 (n20 \2\:n20) resistor r=51.4361 c=0
Rz3 (\3\:Q \4\:Q) resistor r=75 c=0
Rz21 (\1\:VSS \2\:VSS) resistor r=75 c=0
Rz22 (\10\:VSS \11\:VSS) resistor r=75 c=0
Rz23 (\12\:VSS \13\:VSS) resistor r=75 c=0
Rz24 (\14\:VSS \15\:VSS) resistor r=75 c=0
Rz25 (\16\:VSS \17\:VSS) resistor r=75 c=0
Rz26 (\18\:VSS \19\:VSS) resistor r=75 c=0
Rz18 (\4\:VDD \5\:VDD) resistor r=8.3333 c=0
Rz19 (\4\:VDD \8\:VDD) resistor r=6.25 c=0
Rz20 (\4\:VDD \11\:VDD) resistor r=6.25 c=0
Rz1 (\3\:QN \4\:QN) resistor r=75 c=0
Rz2 (\7\:qint \8\:qint) resistor r=75 c=0
Rz4 (\12\:qbint \13\:qbint) resistor r=75 c=0
Rz5 (\9\:RNb \10\:RNb) resistor r=75 c=0
Rz10 (\5\:n35 \6\:n35) resistor r=75 c=0
Rz6 (n42 \2\:n42) resistor r=75 c=0
Rz7 (\3\:n42 \4\:n42) resistor r=75 c=0
Rz8 (n40 \2\:n40) resistor r=75 c=0
Rz9 (\3\:n40 \4\:n40) resistor r=75 c=0
Rz17 (\15\:CKb \16\:CKb) resistor r=75 c=0
Rz13 (\4\:mout \5\:mout) resistor r=75 c=0
Rz14 (\12\:mout \13\:mout) resistor r=75 c=0
Rz16 (\9\:CKbb \10\:CKbb) resistor r=75 c=0
Rz11 (net426 \2\:net426) resistor r=75 c=0
Rz12 (\3\:net426 \4\:net426) resistor r=75 c=0
Rz15 (\5\:n20 \6\:n20) resistor r=75 c=0
Ry3 (\1\:Q \2\:Q) resistor r=62 c=0
Ry22 (\3\:VSS \4\:VSS) resistor r=6.8889 c=0
Ry23 (\3\:VSS \6\:VSS) resistor r=5.1667 c=0
Ry24 (\3\:VSS \8\:VSS) resistor r=5.1667 c=0
Ry14 (\1\:VDD \2\:VDD) resistor r=62 c=0
Ry15 (\12\:VDD \13\:VDD) resistor r=62 c=0
Ry16 (\14\:VDD \15\:VDD) resistor r=62 c=0
Ry17 (\16\:VDD \17\:VDD) resistor r=62 c=0
Ry18 (\18\:VDD \19\:VDD) resistor r=62 c=0
Ry19 (\20\:VDD \21\:VDD) resistor r=62 c=0
Ry20 (\22\:VDD \23\:VDD) resistor r=62 c=0
Ry21 (\25\:VDD \26\:VDD) resistor r=62 c=0
Ry1 (\1\:QN \2\:QN) resistor r=62 c=0
Ry2 (\9\:qint \10\:qint) resistor r=62 c=0
Ry4 (\14\:qbint \15\:qbint) resistor r=62 c=0
Ry5 (\7\:RNb \8\:RNb) resistor r=62 c=0
Ry8 (\9\:n35 \10\:n35) resistor r=62 c=0
Ry13 (\10\:CKb \11\:CKb) resistor r=62 c=0
Ry9 (\7\:mout \8\:mout) resistor r=62 c=0
Ry10 (\9\:mout \10\:mout) resistor r=62 c=0
Ry12 (\11\:CKbb \12\:CKbb) resistor r=62 c=0
Ry11 (\7\:n20 \8\:n20) resistor r=62 c=0
Ry6 (n41 \2\:n41) resistor r=62 c=0
Ry7 (\3\:n41 \4\:n41) resistor r=62 c=0
Rx2 (\2\:RN \4\:RN) resistor r=45 c=0
Rx19 (\2\:CK \4\:CK) resistor r=45 c=0
Rx11 (\1\:D \5\:D) resistor r=45 c=0
Rx7 (\6\:SN \8\:SN) resistor r=45 c=0
Rx8 (\2\:SN \9\:SN) resistor r=45 c=0
Rx1 (qint \5\:qint) resistor r=45 c=0
Rx3 (\8\:qbint \10\:qbint) resistor r=45 c=0
Rx4 (\2\:qbint \16\:qbint) resistor r=45 c=0
Rx5 (\5\:RNb \6\:RNb) resistor r=45 c=0
Rx6 (n35 \8\:n35) resistor r=45 c=0
Rx16 (\9\:CKb \12\:CKb) resistor r=45 c=0
Rx17 (\6\:CKb \13\:CKb) resistor r=45 c=0
Rx18 (\3\:CKb \14\:CKb) resistor r=45 c=0
Rx9 (\2\:mout \11\:mout) resistor r=45 c=0
Rx12 (\2\:CKbb \16\:CKbb) resistor r=45 c=0
Rx13 (\8\:CKbb \17\:CKbb) resistor r=45 c=0
Rx14 (\6\:CKbb \18\:CKbb) resistor r=45 c=0
Rx15 (\4\:CKbb \19\:CKbb) resistor r=45 c=0
Rx10 (n20 \4\:n20) resistor r=45 c=0
mn57 (\3\:QN \3\:qint \18\:VSS VSS) g45n1hvt w=(1.45e-07) l=4.5e-08 nf=1 \
        as=2.682e-14 ad=2.03e-14 ps=6.6e-07 pd=5.7e-07 nrd=1.16667 \
        nrs=1.16667 sa=1.4e-07 sb=3.7e-07 sd=160n sca=23.279 scb=0.0230742 \
        scc=0.00267719 m=(1)
mn56 (\7\:qint \5\:qbint \18\:VSS VSS) g45n1hvt w=(1.45e-07) l=4.5e-08 \
        nf=1 as=2.682e-14 ad=2.03e-14 ps=6.6e-07 pd=5.7e-07 nrd=1.16667 \
        nrs=1.16667 sa=3.7e-07 sb=1.4e-07 sd=160n sca=23.279 scb=0.0230742 \
        scc=0.00267719 m=(1)
mn55 (\3\:Q \3\:qbint \16\:VSS VSS) g45n1hvt w=(1.45e-07) l=4.5e-08 nf=1 \
        as=2.392e-14 ad=2.03e-14 ps=6.2e-07 pd=5.7e-07 nrd=1.16667 \
        nrs=1.16667 sa=1.4e-07 sb=4.6e-07 sd=160n sca=23.279 scb=0.0230742 \
        scc=0.00267719 m=(1)
mn22 (\9\:RNb \3\:RN \16\:VSS VSS) g45n1hvt w=(1.45e-07) l=4.5e-08 nf=1 \
        as=2.392e-14 ad=3.625e-14 ps=6.2e-07 pd=7.9e-07 nrd=1.16667 \
        nrs=1.16667 sa=3.5e-07 sb=2.5e-07 sd=160n sca=23.279 scb=0.0230742 \
        scc=0.00267719 m=(1)
mn45 (\12\:qbint \3\:n35 \14\:VSS VSS) g45n1hvt w=(1.45e-07) l=4.5e-08 \
        nf=1 as=2.32e-14 ad=2.103e-14 ps=6.1e-07 pd=5.8e-07 nrd=1.16667 \
        nrs=1.16667 sa=1.45e-07 sb=8.75e-07 sd=160n sca=8.55924 \
        scb=0.0065649 scc=0.000116351 m=(1)
mn50 (n42 \1\:SN \14\:VSS VSS) g45n1hvt w=(1.45e-07) l=4.5e-08 nf=1 \
        as=2.32e-14 ad=3.263e-14 ps=6.1e-07 pd=7.4e-07 nrd=1.16667 \
        nrs=1.16667 sa=3.5e-07 sb=6.7e-07 sd=160n sca=8.55924 \
        scb=0.0065649 scc=0.000116351 m=(1)
mn52 (n40 \7\:qbint n42 VSS) g45n1hvt w=(1.45e-07) l=4.5e-08 nf=1 \
        as=3.263e-14 ad=2.9e-14 ps=7.4e-07 pd=6.9e-07 nrd=1.16667 \
        nrs=1.16667 sa=6.2e-07 sb=4e-07 sd=160n sca=8.55924 scb=0.0065649 \
        scc=0.000116351 m=(1)
mn51 (n40 \3\:RNb \3\:n42 VSS) g45n1hvt w=(1.45e-07) l=4.5e-08 nf=1 \
        as=2.248e-14 ad=2.9e-14 ps=6e-07 pd=6.9e-07 nrd=1.16667 \
        nrs=1.16667 sa=8.65e-07 sb=1.55e-07 sd=160n sca=8.55924 \
        scb=0.0065649 scc=0.000116351 m=(1)
mn53 (\5\:n35 CKb \3\:n40 VSS) g45n1hvt w=(1.45e-07) l=4.5e-08 nf=1 \
        as=5.8e-14 ad=2.32e-14 ps=1.09e-06 pd=6.1e-07 nrd=1.16667 \
        nrs=1.16667 sa=4e-07 sb=3.45e-07 sd=160n sca=13.6097 scb=0.014254 \
        scc=0.000755054 m=(1)
mn40 (\5\:n35 \3\:CKbb \12\:mout VSS) g45n1hvt w=(1.45e-07) l=4.5e-08 \
        nf=1 as=2.03e-14 ad=2.32e-14 ps=5.7e-07 pd=6.1e-07 nrd=1.16667 \
        nrs=1.16667 sa=6.05e-07 sb=1.4e-07 sd=160n sca=13.6097 \
        scb=0.014254 scc=0.000755054 m=(1)
mn31 (\4\:mout \2\:RNb \3\:net426 VSS) g45n1hvt w=(1.45e-07) l=4.5e-08 \
        nf=1 as=2.03e-14 ad=4.64e-14 ps=5.7e-07 pd=9.3e-07 nrd=1.16667 \
        nrs=1.16667 sa=1.4e-07 sb=6.95e-07 sd=160n sca=14.7993 \
        scb=0.0157101 scc=0.000964917 m=(1)
mn32 (\4\:mout \2\:n20 net426 VSS) g45n1hvt w=(1.45e-07) l=4.5e-08 nf=1 \
        as=2.683e-14 ad=4.64e-14 ps=6.6e-07 pd=9.3e-07 nrd=1.16667 \
        nrs=1.16667 sa=5.05e-07 sb=3.3e-07 sd=160n sca=14.7993 \
        scb=0.0157101 scc=0.000964917 m=(1)
mn30 (net426 \7\:SN \12\:VSS VSS) g45n1hvt w=(1.45e-07) l=4.5e-08 nf=1 \
        as=6.698e-14 ad=2.683e-14 ps=1.52e-06 pd=6.6e-07 nrd=1.16667 \
        nrs=1.16667 sa=7.35e-07 sb=1e-07 sd=160n sca=14.7993 scb=0.0157101 \
        scc=0.000964917 m=(1)
mn35 (n30 \3\:mout \12\:VSS VSS) g45n1hvt w=(1.45e-07) l=4.5e-08 nf=1 \
        as=6.698e-14 ad=8.7e-15 ps=1.52e-06 pd=4.1e-07 nrd=1.16667 \
        nrs=1.16667 sa=1.95e-07 sb=1.045e-06 sd=160n sca=7.18188 \
        scb=0.00417289 scc=4.04165e-05 m=(1)
mn36 (\5\:n20 \5\:CKbb n30 VSS) g45n1hvt w=(1.45e-07) l=4.5e-08 nf=1 \
        as=8.7e-15 ad=3.698e-14 ps=4.1e-07 pd=8e-07 nrd=1.16667 \
        nrs=1.16667 sa=3e-07 sb=9.4e-07 sd=160n sca=7.18188 scb=0.00417289 \
        scc=4.04165e-05 m=(1)
mn26 (\5\:n20 \4\:CKb n21 VSS) g45n1hvt w=(1.45e-07) l=4.5e-08 nf=1 \
        as=3.625e-14 ad=3.698e-14 ps=7.9e-07 pd=8e-07 nrd=1.16667 \
        nrs=1.16667 sa=6e-07 sb=6.4e-07 sd=160n sca=7.18188 scb=0.00417289 \
        scc=4.04165e-05 m=(1)
mn25 (n21 \3\:D \10\:VSS VSS) g45n1hvt w=(1.45e-07) l=4.5e-08 nf=1 \
        as=2.32e-14 ad=3.625e-14 ps=6.1e-07 pd=7.9e-07 nrd=1.16667 \
        nrs=1.16667 sa=8.95e-07 sb=3.45e-07 sd=160n sca=7.18188 \
        scb=0.00417289 scc=4.04165e-05 m=(1)
mn21 (\9\:CKbb \8\:CKb \10\:VSS VSS) g45n1hvt w=(1.45e-07) l=4.5e-08 \
        nf=1 as=2.32e-14 ad=2.03e-14 ps=6.1e-07 pd=5.7e-07 nrd=1.16667 \
        nrs=1.16667 sa=1.1e-06 sb=1.4e-07 sd=160n sca=7.18188 \
        scb=0.00417289 scc=4.04165e-05 m=(1)
mn20 (\15\:CKb \3\:CK \1\:VSS VSS) g45n1hvt w=(1.45e-07) l=4.5e-08 nf=1 \
        as=2.538e-14 ad=2.465e-14 ps=6.4e-07 pd=6.3e-07 nrd=1.16667 \
        nrs=1.16667 sa=1.7e-07 sb=1.75e-07 sd=160n sca=23.279 \
        scb=0.0230742 scc=0.00267719 m=(1)
ends DFFSRXL
// End of subcircuit definition.
