// Generated for: spectre (May  1 09:17:17 2013 )
// Library name: gsclib045_lvt
// Cell name: NOR3BX1
// View name: extracted

simulator lang=spectre

subckt NOR3BX1 AN B C VDD VSS Y
mp3 (\6\:Y \1\:C net90 VDD) g45p1lvt w=(3.9e-07) l=4.5e-08 nf=1 \
        as=2.34e-14 ad=5.46e-14 ps=9e-07 pd=1.06e-06 nrd=1.16667 \
        nrs=1.16667 sa=1.4e-07 sb=5.84167e-07 sd=160n sca=25.1103 \
        scb=0.022702 scc=0.00204888 m=(1)
mp2 (net90 \3\:B net86 VDD) g45p1lvt w=(3.9e-07) l=4.5e-08 nf=1 \
        as=4.485e-14 ad=2.34e-14 ps=1.01e-06 pd=9e-07 nrd=1.16667 \
        nrs=1.16667 sa=2.45e-07 sb=4.79167e-07 sd=160n sca=23.6464 \
        scb=0.01977 scc=0.00198868 m=(1)
mp1 (net86 \3\:net91 \1\:VDD VDD) g45p1lvt w=(3.9e-07) l=4.5e-08 nf=1 \
        as=6.535e-14 ad=4.485e-14 ps=1.16e-06 pd=1.01e-06 nrd=1.16667 \
        nrs=1.16667 sa=4.05e-07 sb=3.19167e-07 sd=160n sca=23.2415 \
        scb=0.0189596 scc=0.00198104 m=(1)
C1 (Y VSS) capacitor c=7.57623e-17
C2 (C VSS) capacitor c=4.43569e-17
C3 (AN VSS) capacitor c=7.22202e-17
C4 (VDD VSS) capacitor c=7.19522e-17
C5 (B VSS) capacitor c=5.46213e-17
C6 (net91 VSS) capacitor c=4.82023e-17
C7 (net86 VSS) capacitor c=1.7867e-18
C8 (\3\:AN VSS) capacitor c=3.32825e-17
C9 (\3\:net91 VSS) capacitor c=6.53998e-17
C10 (\3\:B VSS) capacitor c=9.81056e-17
C11 (\1\:C VSS) capacitor c=7.67428e-17
C12 (\1\:AN VSS) capacitor c=4.89238e-17
C13 (\1\:B VSS) capacitor c=4.04319e-17
C14 (\4\:C VSS) capacitor c=4.29401e-17
C15 (\2\:AN VSS) capacitor c=4.41686e-17
C16 (\2\:net91 VSS) capacitor c=5.45306e-17
C17 (\2\:B VSS) capacitor c=6.02049e-17
C18 (\3\:C VSS) capacitor c=4.78852e-17
C19 (\4\:net91 VSS) capacitor c=3.29109e-17
C20 (\1\:VDD VSS) capacitor c=4.90364e-17
C21 (\6\:Y VSS) capacitor c=5.55134e-17
C22 (\8\:net91 VSS) capacitor c=2.89126e-17
C23 (\1\:Y VSS) capacitor c=7.20705e-17
C24 (\4\:Y VSS) capacitor c=3.49536e-17
C25 (\7\:C VSS) capacitor c=7.12723e-17
C26 (\4\:B VSS) capacitor c=6.74597e-17
C27 (\3\:Y VSS) capacitor c=4.25413e-17
C28 (\6\:net91 VSS) capacitor c=4.86723e-17
C29 (\7\:net91 VSS) capacitor c=5.38442e-17
C30 (\4\:VDD VSS) capacitor c=2.4219e-17
Rk6 (\3\:Y Y) resistor r=0.1445 c=0
Rk5 (\2\:Y \3\:Y) resistor r=0.3587 c=0
Rk7 (\3\:Y \5\:Y) resistor r=0.03868 c=0
Rk8 (Y \7\:Y) resistor r=0.3946 c=0
Rk1 (\5\:C C) resistor r=0.001113 c=0
Rk3 (\5\:C \7\:C) resistor r=0.0315 c=0
Rk2 (\6\:C \7\:C) resistor r=0.001011 c=0
Rk9 (\4\:AN AN) resistor r=0.03051 c=0
Rk18 (\4\:VDD VDD) resistor r=0.2503 c=0
Rk17 (\2\:VDD \4\:VDD) resistor r=0.4258 c=0
Rk13 (\2\:VSS \4\:VSS) resistor r=0.3149 c=0
Rk15 (\5\:VSS VSS) resistor r=0.1775 c=0
Rk14 (\4\:VSS \5\:VSS) resistor r=0.07247 c=0
Rk16 (\5\:VSS \7\:VSS) resistor r=0.1812 c=0
Rk4 (B \4\:B) resistor r=0.2604 c=0
Rk10 (\5\:net91 \6\:net91) resistor r=0.2618 c=0
Rk11 (\6\:net91 \7\:net91) resistor r=0.2325 c=0
Rk12 (\6\:net91 \9\:net91) resistor r=0.229 c=0
Rl1 (\1\:C \2\:C) resistor r=91.8973 c=0
Rl3 (\2\:C \4\:C) resistor r=75.5064 c=0
Rl2 (\2\:C \3\:C) resistor r=2.257 c=0
Rl9 (\2\:AN \3\:AN) resistor r=39.8352 c=0
Rl8 (\1\:AN \2\:AN) resistor r=155.966 c=0
Rl5 (\2\:B \3\:B) resistor r=114.56 c=0
Rl4 (\1\:B \2\:B) resistor r=34.6154 c=0
Rl7 (\2\:net91 \3\:net91) resistor r=106.296 c=0
Rl6 (net91 \2\:net91) resistor r=46.1538 c=0
Rz1 (\1\:Y \2\:Y) resistor r=37.5 c=0
Rz2 (\4\:Y \5\:Y) resistor r=37.5 c=0
Rz4 (\1\:VSS \2\:VSS) resistor r=75 c=0
Rz5 (\6\:VSS \7\:VSS) resistor r=75 c=0
Rz3 (\8\:net91 \9\:net91) resistor r=75 c=0
Ry1 (\6\:Y \7\:Y) resistor r=20.6667 c=0
Ry4 (\1\:VDD \2\:VDD) resistor r=20.6667 c=0
Ry2 (\4\:net91 \5\:net91) resistor r=62 c=0
Rx1 (\3\:C \6\:C) resistor r=45 c=0
Rx3 (\2\:AN \4\:AN) resistor r=45 c=0
Rx2 (\2\:B \4\:B) resistor r=45 c=0
Rx4 (\2\:net91 \7\:net91) resistor r=45 c=0
mn3 (\4\:Y \4\:C \6\:VSS VSS) g45n1lvt w=(2.6e-07) l=4.5e-08 nf=1 \
        as=4.16e-14 ad=3.64e-14 ps=8.4e-07 pd=8e-07 nrd=1.16667 \
        nrs=1.16667 sa=1.4e-07 sb=6.46635e-07 sd=160n sca=7.84363 \
        scb=0.00546499 scc=9.84911e-05 m=(1)
mn2 (\1\:Y \1\:B \6\:VSS VSS) g45n1lvt w=(2.6e-07) l=4.5e-08 nf=1 \
        as=4.16e-14 ad=4.16e-14 ps=8.4e-07 pd=8.4e-07 nrd=1.16667 \
        nrs=1.16667 sa=3.45e-07 sb=4.41635e-07 sd=160n sca=7.84363 \
        scb=0.00546499 scc=9.84911e-05 m=(1)
mn1 (\1\:Y net91 \1\:VSS VSS) g45n1lvt w=(2.6e-07) l=4.5e-08 nf=1 \
        as=3.47e-14 ad=4.16e-14 ps=8.4e-07 pd=8.4e-07 nrd=1.16667 \
        nrs=1.16667 sa=5.5e-07 sb=2.36635e-07 sd=160n sca=7.84363 \
        scb=0.00546499 scc=9.84911e-05 m=(1)
mn0 (\8\:net91 \1\:AN \1\:VSS VSS) g45n1lvt w=(1.45e-07) l=4.5e-08 nf=1 \
        as=3.47e-14 ad=2.03e-14 ps=8.4e-07 pd=5.7e-07 nrd=1.16667 \
        nrs=1.16667 sa=7.55e-07 sb=1.4e-07 sd=160n sca=6.59604 \
        scb=0.00318587 scc=2.16275e-05 m=(1)
mp0 (\4\:net91 \3\:AN \1\:VDD VDD) g45p1lvt w=(2.15e-07) l=4.5e-08 nf=1 \
        as=6.535e-14 ad=4.945e-14 ps=1.16e-06 pd=8.9e-07 nrd=1.16667 \
        nrs=1.16667 sa=6.4e-07 sb=2.3e-07 sd=160n sca=34.5374 \
        scb=0.0325399 scc=0.0036632 m=(1)
ends NOR3BX1
// End of subcircuit definition.
