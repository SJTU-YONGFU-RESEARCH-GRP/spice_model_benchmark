// gsclib045_hvt/SDFFSRHQX8/schematic

simulator lang=spectre

subckt SDFFSRHQX8 CK D Q RN SE SI SN VDD VSS
mp14 (Db SEb net453 VDD) g45p1hvt w=(390n) l=45n nf=1 m=(1)
mp13 (net453 SI VDD VDD) g45p1hvt w=(390n) l=45n nf=1 m=(1)
mp12 (Db SE net445 VDD) g45p1hvt w=(390n) l=45n nf=1 m=(1)
mp11 (net445 D VDD VDD) g45p1hvt w=(390n) l=45n nf=1 m=(1)
mp52 (net394 qbint net437 VDD) g45p1hvt w=(310n) l=45n nf=1 m=(1)
mp51 (net437 RNb VDD VDD) g45p1hvt w=(310n) l=45n nf=1 m=(1)
mp55 (Q qbint VDD VDD) g45p1hvt w=(3.115u) l=45n nf=1 m=(1)
mp36 (n20 CKb net425 VDD) g45p1hvt w=(310n) l=45n nf=1 m=(1)
mp35 (net425 mout VDD VDD) g45p1hvt w=(310n) l=45n nf=1 m=(1)
mp32 (mout n20 net417 VDD) g45p1hvt w=(310n) l=45n nf=1 m=(1)
mp31 (net417 RNb VDD VDD) g45p1hvt w=(310n) l=45n nf=1 m=(1)
mp22 (RNb RN VDD VDD) g45p1hvt w=(215n) l=45n nf=1 m=(1)
mp20 (CKb CK VDD VDD) g45p1hvt w=(215n) l=45n nf=1 m=(1)
mp53 (n35 CKbb net394 VDD) g45p1hvt w=(310n) l=45n nf=1 m=(1)
mp50 (net394 SN VDD VDD) g45p1hvt w=(310n) l=45n nf=1 m=(1)
mp45 (qbint n35 VDD VDD) g45p1hvt w=(1.17u) l=45n nf=1 m=(1)
mp25 (n20 CKbb Db VDD) g45p1hvt w=(310n) l=45n nf=1 m=(1)
mp30 (mout SN VDD VDD) g45p1hvt w=(310n) l=45n nf=1 m=(1)
mp40 (n35 CKb mout VDD) g45p1hvt w=(310n) l=45n nf=1 m=(1)
mp21 (CKbb CKb VDD VDD) g45p1hvt w=(215n) l=45n nf=1 m=(1)
mp10 (SEb SE VDD VDD) g45p1hvt w=(215n) l=45n nf=1 m=(1)
mn13 (net534 SI VSS VSS) g45n1hvt w=(260n) l=45n nf=1 m=(1)
mn14 (Db SE net534 VSS) g45n1hvt w=(260n) l=45n nf=1 m=(1)
mn12 (Db SEb net522 VSS) g45n1hvt w=(260n) l=45n nf=1 m=(1)
mn11 (net522 D VSS VSS) g45n1hvt w=(260n) l=45n nf=1 m=(1)
mn55 (Q qbint VSS VSS) g45n1hvt w=(2.065u) l=45n nf=1 m=(1)
mn35 (net514 mout VSS VSS) g45n1hvt w=(205n) l=45n nf=1 m=(1)
mn36 (n20 CKbb net514 VSS) g45n1hvt w=(205n) l=45n nf=1 m=(1)
mn22 (RNb RN VSS VSS) g45n1hvt w=(145n) l=45n nf=1 m=(1)
mn20 (CKb CK VSS VSS) g45n1hvt w=(145n) l=45n nf=1 m=(1)
mn45 (qbint n35 VSS VSS) g45n1hvt w=(780n) l=45n nf=1 m=(1)
mn52 (net490 qbint net486 VSS) g45n1hvt w=(205n) l=45n nf=1 m=(1)
mn51 (net490 RNb net486 VSS) g45n1hvt w=(205n) l=45n nf=1 m=(1)
mn50 (net486 SN VSS VSS) g45n1hvt w=(205n) l=45n nf=1 m=(1)
mn53 (n35 CKb net490 VSS) g45n1hvt w=(205n) l=45n nf=1 m=(1)
mn10 (SEb SE VSS VSS) g45n1hvt w=(145n) l=45n nf=1 m=(1)
mn25 (Db CKb n20 VSS) g45n1hvt w=(205n) l=45n nf=1 m=(1)
mn30 (net469 SN VSS VSS) g45n1hvt w=(205n) l=45n nf=1 m=(1)
mn32 (mout n20 net469 VSS) g45n1hvt w=(205n) l=45n nf=1 m=(1)
mn31 (mout RNb net469 VSS) g45n1hvt w=(205n) l=45n nf=1 m=(1)
mn40 (n35 CKbb mout VSS) g45n1hvt w=(205n) l=45n nf=1 m=(1)
mn21 (CKbb CKb VSS VSS) g45n1hvt w=(145n) l=45n nf=1 m=(1)
ends SDFFSRHQX8
