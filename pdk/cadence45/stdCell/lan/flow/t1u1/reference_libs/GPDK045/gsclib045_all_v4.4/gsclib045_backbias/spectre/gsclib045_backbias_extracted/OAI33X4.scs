// Generated for: spectre (May  1 11:31:49 2013 )
// Library name: gsclib045_backbias
// Cell name: OAI33X4
// View name: extracted

simulator lang=spectre

subckt OAI33X4 A0 A1 A2 B0 B1 B2 NW VDD VSS Y
mp0_1__rcx (n1 A0 \4\:VDD NW) g45p1svt w=(3.9e-07) l=4.5e-08 nf=1 \
        as=6.24e-14 ad=6.045e-14 ps=1.1e-06 pd=1.09e-06 nrd=1.16667 \
        nrs=1.16667 sa=1.4e-07 sb=1.575e-06 sd=160n sca=20.9952 \
        scb=0.0222834 scc=0.00110072 m=(4)
mp1_1__rcx (\5\:n2 A1 n1 NW) g45p1svt w=(3.9e-07) l=4.5e-08 nf=1 \
        as=6.045e-14 ad=6.24e-14 ps=1.09e-06 pd=1.1e-06 nrd=1.16667 \
        nrs=1.16667 sa=9.6e-07 sb=7.55e-07 sd=160n sca=14.7189 \
        scb=0.0133035 scc=0.000878755 m=(4)
mp3_1__rcx (n3 B1 n4 NW) g45p1svt w=(3.9e-07) l=4.5e-08 nf=1 as=6.24e-14 \
        ad=6.045e-14 ps=1.1e-06 pd=1.09e-06 nrd=1.16667 nrs=1.16667 \
        sa=1.4e-07 sb=1.575e-06 sd=160n sca=15.4348 scb=0.0139233 \
        scc=0.00102271 m=(4)
mp5_1__rcx (\15\:Y B2 \5\:n4 NW) g45p1svt w=(3.9e-07) l=4.5e-08 nf=1 \
        as=6.24e-14 ad=6.24e-14 ps=1.1e-06 pd=1.1e-06 nrd=1.16667 \
        nrs=1.16667 sa=9.7e-07 sb=7.65e-07 sd=160n sca=18.3796 \
        scb=0.0159892 scc=0.00159615 m=(4)
mp2_1__rcx (\15\:Y A2 n2 NW) g45p1svt w=(3.9e-07) l=4.5e-08 nf=1 \
        as=6.24e-14 ad=6.24e-14 ps=1.1e-06 pd=1.1e-06 nrd=1.16667 \
        nrs=1.16667 sa=1.4e-07 sb=1.595e-06 sd=160n sca=18.3796 \
        scb=0.0159892 scc=0.00159615 m=(4)
mp4_1__rcx (\1\:VDD B0 n3 NW) g45p1svt w=(3.9e-07) l=4.5e-08 nf=1 \
        as=6.045e-14 ad=6.24e-14 ps=1.09e-06 pd=1.1e-06 nrd=1.16667 \
        nrs=1.16667 sa=9.6e-07 sb=7.55e-07 sd=160n sca=15.4443 \
        scb=0.013925 scc=0.00102271 m=(4)
C1 (NW VSS) capacitor c=6.49411e-16
C2 (A1 VSS) capacitor c=3.7881e-16
C3 (B1 VSS) capacitor c=3.85596e-16
C4 (A0 VSS) capacitor c=3.36693e-16
C5 (VDD VSS) capacitor c=3.9884e-17
C6 (B2 VSS) capacitor c=3.77258e-16
C7 (B0 VSS) capacitor c=3.60507e-16
C8 (Y VSS) capacitor c=1.38079e-17
C9 (A2 VSS) capacitor c=3.98733e-16
C10 (no VSS) capacitor c=8.85002e-16
C11 (n1 VSS) capacitor c=3.58117e-16
C12 (n2 VSS) capacitor c=1.34976e-16
C13 (n4 VSS) capacitor c=1.22215e-16
C14 (n3 VSS) capacitor c=3.57379e-16
C15 (\1\:VDD VSS) capacitor c=4.19717e-16
C16 (\5\:n4 VSS) capacitor c=1.33529e-16
C17 (\5\:n2 VSS) capacitor c=1.25028e-16
C18 (\1\:Y VSS) capacitor c=1.46598e-16
C19 (\5\:Y VSS) capacitor c=1.65888e-16
C20 (\9\:Y VSS) capacitor c=2.21921e-16
C21 (\14\:Y VSS) capacitor c=1.34668e-16
C22 (\15\:Y VSS) capacitor c=3.76393e-16
C23 (\4\:VDD VSS) capacitor c=3.77237e-16
Rk71 (\2\:VSS \3\:VSS) resistor r=0.852 c=0
Rk72 (\3\:VSS \4\:VSS) resistor r=0.4759 c=0
Rk74 (\4\:VSS \6\:VSS) resistor r=0.2051 c=0
Rk76 (\6\:VSS \8\:VSS) resistor r=0.105 c=0
Rk79 (\9\:VSS VSS) resistor r=0.2451 c=0
Rk77 (\8\:VSS \9\:VSS) resistor r=0.1 c=0
Rk67 (\4\:VDD VDD) resistor r=0.1574 c=0
Rk65 (\1\:VDD \4\:VDD) resistor r=2.0643 c=0
Rk27 (\1\:Y \5\:Y) resistor r=0.2789 c=0
Rk29 (\5\:Y \9\:Y) resistor r=0.2789 c=0
Rk33 (\14\:Y Y) resistor r=0.003068 c=0
Rk32 (\9\:Y \14\:Y) resistor r=0.9402 c=0
Rk34 (\14\:Y \15\:Y) resistor r=0.1112 c=0
Rk14 (n2 \5\:n2) resistor r=0.4078 c=0
Rk24 (n4 \5\:n4) resistor r=0.4061 c=0
Ry29 (\2\:VSS \1\:VSS) resistor r=12.4 c=0
Ry30 (\3\:VSS \1\:VSS) resistor r=5.1667 c=0
Ry31 (\8\:VSS \1\:VSS) resistor r=5.1667 c=0
mn2_1__rcx (no A2 \4\:VSS VSS) g45n1svt w=(2.6e-07) l=4.5e-08 nf=1 \
        as=4.16e-14 ad=4.29e-14 ps=8.4e-07 pd=8.5e-07 nrd=1.16667 \
        nrs=1.16667 sa=1.78e-06 sb=2e-06 sd=160n sca=10.3222 \
        scb=0.00938145 scc=0.000353946 m=(4)
mn1_1__rcx (no A1 \6\:VSS VSS) g45n1svt w=(2.6e-07) l=4.5e-08 nf=1 \
        as=4.16e-14 ad=4.16e-14 ps=8.4e-07 pd=8.4e-07 nrd=1.16667 \
        nrs=1.16667 sa=9.6e-07 sb=2e-06 sd=160n sca=10.3222 scb=0.00938145 \
        scc=0.000353946 m=(4)
mn4_1__rcx (\1\:Y B0 no VSS) g45n1svt w=(2.6e-07) l=4.5e-08 nf=1 \
        as=4.03e-14 ad=4.16e-14 ps=8.3e-07 pd=8.4e-07 nrd=1.16667 \
        nrs=1.16667 sa=2e-06 sb=7.55e-07 sd=160n sca=10.3222 \
        scb=0.00938145 scc=0.000353946 m=(4)
mn3_1__rcx (\5\:Y B1 no VSS) g45n1svt w=(2.6e-07) l=4.5e-08 nf=1 \
        as=4.16e-14 ad=4.16e-14 ps=8.4e-07 pd=8.4e-07 nrd=1.16667 \
        nrs=1.16667 sa=2e-06 sb=1.575e-06 sd=160n sca=10.3222 \
        scb=0.00938145 scc=0.000353946 m=(4)
mn5_1__rcx (\9\:Y B2 no VSS) g45n1svt w=(2.6e-07) l=4.5e-08 nf=1 \
        as=4.29e-14 ad=4.16e-14 ps=8.5e-07 pd=8.4e-07 nrd=1.16667 \
        nrs=1.16667 sa=2e-06 sb=2e-06 sd=160n sca=10.3222 scb=0.00938145 \
        scc=0.000353946 m=(4)
mn0_1__rcx (no A0 \9\:VSS VSS) g45n1svt w=(2.6e-07) l=4.5e-08 nf=1 \
        as=4.16e-14 ad=4.03e-14 ps=8.4e-07 pd=8.3e-07 nrd=1.16667 \
        nrs=1.16667 sa=1.4e-07 sb=2e-06 sd=160n sca=10.3222 scb=0.00938145 \
        scc=0.000353946 m=(4)
ends OAI33X4
// End of subcircuit definition.
