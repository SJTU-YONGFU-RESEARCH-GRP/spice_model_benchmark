// Generated for: spectre (May  1 08:13:51 2013 )
// Library name: gsclib045
// Cell name: SDFFSRHQX8
// View name: extracted

simulator lang=spectre

subckt SDFFSRHQX8 CK D Q RN SE SI SN VDD VSS
mp55_1__rcx (Q qbint \13\:VDD VDD) g45p1svt w=(4.45e-07) l=4.5e-08 nf=1 \
        as=7.073e-14 ad=6.993e-14 ps=1.21e-06 pd=1.20429e-06 nrd=1.16667 \
        nrs=1.16667 sa=1.4e-07 sb=1.90404e-06 sd=160n sca=40.5428 \
        scb=0.0363846 scc=0.00414682 m=(7)
C1 (RN VSS) capacitor c=6.80718e-17
C2 (D VSS) capacitor c=5.87372e-17
C3 (Q VSS) capacitor c=5.05805e-16
C4 (VDD VSS) capacitor c=5.45355e-16
C5 (CK VSS) capacitor c=4.48297e-17
C6 (SN VSS) capacitor c=3.76482e-16
C7 (SI VSS) capacitor c=8.68465e-17
C8 (qbint VSS) capacitor c=3.73935e-16
C9 (n35 VSS) capacitor c=2.11491e-16
C10 (RNb VSS) capacitor c=1.65796e-16
C11 (net486 VSS) capacitor c=7.34225e-17
C12 (net490 VSS) capacitor c=8.21598e-17
C13 (CKb VSS) capacitor c=3.93974e-17
C14 (mout VSS) capacitor c=4.43525e-17
C15 (CKbb VSS) capacitor c=2.70528e-17
C16 (net469 VSS) capacitor c=6.3493e-17
C17 (n20 VSS) capacitor c=3.0866e-17
C18 (Db VSS) capacitor c=1.21801e-16
C19 (net522 VSS) capacitor c=2.73138e-18
C20 (SEb VSS) capacitor c=4.72231e-17
C21 (net394 VSS) capacitor c=1.04385e-16
C22 (net437 VSS) capacitor c=1.85622e-18
C23 (net417 VSS) capacitor c=2.55223e-18
C24 (net425 VSS) capacitor c=3.3732e-18
C25 (net445 VSS) capacitor c=2.58747e-18
C26 (net453 VSS) capacitor c=4.5356e-18
C27 (\7\:SE VSS) capacitor c=7.42423e-17
C28 (\3\:SI VSS) capacitor c=6.39435e-17
C29 (\1\:SE VSS) capacitor c=7.60101e-17
C30 (\1\:D VSS) capacitor c=9.29108e-17
C31 (\1\:CK VSS) capacitor c=3.21348e-17
C32 (\5\:CKb VSS) capacitor c=3.91371e-17
C33 (\7\:CKbb VSS) capacitor c=3.6374e-17
C34 (\9\:CKb VSS) capacitor c=7.15662e-17
C35 (\5\:SN VSS) capacitor c=6.66106e-17
C36 (\3\:n20 VSS) capacitor c=9.84322e-17
C37 (\3\:CKb VSS) capacitor c=4.25917e-17
C38 (\3\:CKbb VSS) capacitor c=5.46046e-17
C39 (\3\:RNb VSS) capacitor c=7.14671e-17
C40 (\22\:qbint VSS) capacitor c=1.22939e-16
C41 (\1\:SN VSS) capacitor c=5.04756e-17
C42 (\1\:RN VSS) capacitor c=3.88914e-17
C43 (\5\:SE VSS) capacitor c=2.66632e-17
C44 (\1\:SI VSS) capacitor c=7.90242e-17
C45 (\3\:SE VSS) capacitor c=6.77048e-17
C46 (\3\:SEb VSS) capacitor c=7.70485e-17
C47 (\4\:D VSS) capacitor c=4.68856e-17
C48 (\3\:CK VSS) capacitor c=2.87783e-17
C49 (\10\:CKb VSS) capacitor c=2.78284e-17
C50 (\11\:CKb VSS) capacitor c=2.68988e-17
C51 (\5\:CKbb VSS) capacitor c=4.60856e-17
C52 (\3\:mout VSS) capacitor c=5.776e-17
C53 (\4\:SN VSS) capacitor c=6.22609e-17
C54 (\4\:RNb VSS) capacitor c=5.25231e-17
C55 (\5\:RNb VSS) capacitor c=6.50315e-17
C56 (\24\:qbint VSS) capacitor c=5.86858e-17
C57 (\3\:SN VSS) capacitor c=3.77502e-17
C58 (\3\:RN VSS) capacitor c=4.45976e-17
C59 (\6\:SE VSS) capacitor c=4.96322e-17
C60 (\2\:SI VSS) capacitor c=5.10002e-17
C61 (\4\:SE VSS) capacitor c=4.75732e-17
C62 (\2\:SEb VSS) capacitor c=5.39941e-17
C63 (\2\:SE VSS) capacitor c=4.85419e-17
C64 (\3\:D VSS) capacitor c=2.67646e-17
C65 (\2\:CK VSS) capacitor c=4.11857e-17
C66 (\6\:CKb VSS) capacitor c=2.04382e-17
C67 (\8\:CKbb VSS) capacitor c=3.3007e-17
C68 (\6\:CKbb VSS) capacitor c=4.28551e-17
C69 (\2\:mout VSS) capacitor c=4.33917e-17
C70 (\6\:SN VSS) capacitor c=2.10287e-17
C71 (\4\:n20 VSS) capacitor c=3.02945e-17
C72 (\4\:CKbb VSS) capacitor c=3.13422e-17
C73 (\4\:CKb VSS) capacitor c=4.02631e-17
C74 (\2\:CKb VSS) capacitor c=2.30048e-17
C75 (\2\:RNb VSS) capacitor c=1.02458e-16
C76 (\2\:SN VSS) capacitor c=3.5735e-17
C77 (\2\:RN VSS) capacitor c=2.86426e-17
C78 (\23\:qbint VSS) capacitor c=4.41693e-17
C79 (\8\:SEb VSS) capacitor c=2.79066e-17
C80 (\1\:VDD VSS) capacitor c=6.85217e-17
C81 (\19\:VDD VSS) capacitor c=3.67025e-17
C82 (\12\:CKb VSS) capacitor c=4.32854e-17
C83 (\21\:VDD VSS) capacitor c=5.12829e-17
C84 (\11\:CKbb VSS) capacitor c=1.14596e-16
C85 (\8\:Db VSS) capacitor c=1.02615e-16
C86 (\5\:n20 VSS) capacitor c=9.22141e-17
C87 (\23\:VDD VSS) capacitor c=7.32794e-17
C88 (\11\:mout VSS) capacitor c=2.07383e-16
C89 (\25\:VDD VSS) capacitor c=6.9828e-17
C90 (\7\:mout VSS) capacitor c=4.34262e-17
C91 (\10\:n35 VSS) capacitor c=7.8723e-17
C92 (\27\:VDD VSS) capacitor c=5.6792e-17
C93 (\3\:net394 VSS) capacitor c=9.258e-17
C94 (\29\:VDD VSS) capacitor c=5.70016e-17
C95 (\7\:RNb VSS) capacitor c=1.80829e-16
C96 (\26\:qbint VSS) capacitor c=3.58869e-16
C97 (\3\:VDD VSS) capacitor c=9.44387e-17
C98 (\4\:SEb VSS) capacitor c=6.51732e-17
C99 (\6\:Db VSS) capacitor c=4.43461e-17
C100 (\18\:CKb VSS) capacitor c=7.74269e-17
C101 (\9\:CKbb VSS) capacitor c=9.38674e-17
C102 (\4\:Db VSS) capacitor c=1.89135e-16
C103 (\9\:n20 VSS) capacitor c=1.99873e-17
C104 (\9\:mout VSS) capacitor c=1.41815e-16
C105 (\3\:net469 VSS) capacitor c=7.87615e-17
C106 (\4\:mout VSS) capacitor c=1.23894e-16
C107 (\14\:n35 VSS) capacitor c=6.20465e-17
C108 (\3\:net490 VSS) capacitor c=9.92022e-17
C109 (\3\:net486 VSS) capacitor c=6.31852e-17
C110 (\9\:RNb VSS) capacitor c=1.09881e-16
C111 (\2\:CKbb VSS) capacitor c=6.31969e-17
C112 (\2\:n20 VSS) capacitor c=3.9342e-17
C113 (\25\:qbint VSS) capacitor c=6.62662e-17
C114 (\31\:qbint VSS) capacitor c=2.7599e-17
C115 (\7\:CKb VSS) capacitor c=2.43988e-17
C116 (\8\:CKb VSS) capacitor c=5.74116e-17
C117 (\4\:RN VSS) capacitor c=5.04418e-17
C118 (\2\:D VSS) capacitor c=2.80808e-17
C119 (\6\:RNb VSS) capacitor c=9.59001e-17
C120 (\12\:n35 VSS) capacitor c=3.24173e-16
C121 (\13\:n35 VSS) capacitor c=2.65705e-16
C122 (\7\:SN VSS) capacitor c=3.30025e-16
C123 (\6\:mout VSS) capacitor c=1.57353e-16
C124 (\13\:mout VSS) capacitor c=9.1204e-17
C125 (\7\:n20 VSS) capacitor c=1.07738e-16
C126 (\8\:n20 VSS) capacitor c=8.90043e-17
C127 (\13\:CKbb VSS) capacitor c=1.36622e-16
C128 (\14\:CKbb VSS) capacitor c=2.78252e-16
C129 (\15\:CKbb VSS) capacitor c=2.08412e-16
C130 (\16\:CKbb VSS) capacitor c=6.99873e-17
C131 (\14\:CKb VSS) capacitor c=4.15954e-16
C132 (\15\:CKb VSS) capacitor c=5.77785e-16
C133 (\16\:CKb VSS) capacitor c=1.22748e-16
C134 (\17\:CKb VSS) capacitor c=7.87225e-17
C135 (\4\:CK VSS) capacitor c=8.21788e-17
C136 (\5\:D VSS) capacitor c=8.52e-17
C137 (\3\:Db VSS) capacitor c=2.12e-16
C138 (\4\:SI VSS) capacitor c=4.65526e-17
C139 (\8\:SE VSS) capacitor c=7.0349e-17
C140 (\9\:SE VSS) capacitor c=7.93743e-17
C141 (\10\:SE VSS) capacitor c=6.63719e-17
C142 (\6\:SEb VSS) capacitor c=9.46081e-17
C143 (\7\:SEb VSS) capacitor c=1.19372e-16
C144 (\5\:VDD VSS) capacitor c=9.49446e-18
C145 (\6\:VDD VSS) capacitor c=4.28071e-17
C146 (\7\:VDD VSS) capacitor c=3.78258e-17
C147 (\9\:VDD VSS) capacitor c=5.53742e-17
C148 (\10\:VDD VSS) capacitor c=3.57565e-17
C149 (\12\:VDD VSS) capacitor c=4.93612e-17
C150 (\13\:VDD VSS) capacitor c=5.37272e-16
Rk19 (\4\:RN RN) resistor r=0.07561 c=0
Rk50 (D \5\:D) resistor r=0.1234 c=0
Rk62 (\2\:VSS \4\:VSS) resistor r=0.5685 c=0
Rk63 (\4\:VSS \5\:VSS) resistor r=0.1243 c=0
Rk64 (\5\:VSS \6\:VSS) resistor r=0.3315 c=0
Rk65 (\6\:VSS \7\:VSS) resistor r=0.6511 c=0
Rk66 (\7\:VSS \8\:VSS) resistor r=0.09266 c=0
Rk67 (\8\:VSS \9\:VSS) resistor r=1.2046 c=0
Rk68 (\9\:VSS \10\:VSS) resistor r=0.2959 c=0
Rk75 (\11\:VSS VSS) resistor r=0.1075 c=0
Rk69 (\10\:VSS \11\:VSS) resistor r=0.5291 c=0
Rk76 (\5\:VSS \18\:VSS) resistor r=0.04335 c=0
Rk77 (\6\:VSS \20\:VSS) resistor r=0.04335 c=0
Rk78 (\7\:VSS \22\:VSS) resistor r=0.235 c=0
Rk79 (\10\:VSS \24\:VSS) resistor r=0.3239 c=0
Rk85 (\2\:VDD \4\:VDD) resistor r=0.5043 c=0
Rk86 (\4\:VDD \5\:VDD) resistor r=0.1554 c=0
Rk87 (\5\:VDD \6\:VDD) resistor r=0.2455 c=0
Rk88 (\6\:VDD \7\:VDD) resistor r=0.7374 c=0
Rk89 (\7\:VDD \8\:VDD) resistor r=0.06505 c=0
Rk90 (\8\:VDD \9\:VDD) resistor r=0.4465 c=0
Rk91 (\9\:VDD \10\:VDD) resistor r=0.7073 c=0
Rk92 (\10\:VDD \11\:VDD) resistor r=0.04999 c=0
Rk93 (\11\:VDD \12\:VDD) resistor r=0.3587 c=0
Rk100 (\13\:VDD VDD) resistor r=0.1075 c=0
Rk94 (\12\:VDD \13\:VDD) resistor r=0.4664 c=0
Rk101 (\5\:VDD \20\:VDD) resistor r=0.3869 c=0
Rk102 (\6\:VDD \22\:VDD) resistor r=0.3388 c=0
Rk103 (\7\:VDD \24\:VDD) resistor r=0.2944 c=0
Rk104 (\9\:VDD \26\:VDD) resistor r=0.235 c=0
Rk105 (\10\:VDD \28\:VDD) resistor r=0.2477 c=0
Rk106 (\12\:VDD \30\:VDD) resistor r=0.2421 c=0
Rk49 (CK \4\:CK) resistor r=0.1415 c=0
Rk56 (SE \8\:SE) resistor r=0.005081 c=0
Rk57 (\8\:SE \9\:SE) resistor r=0.4194 c=0
Rk58 (\9\:SE \10\:SE) resistor r=0.3461 c=0
Rk29 (\8\:SN SN) resistor r=0.01255 c=0
Rk28 (\7\:SN \8\:SN) resistor r=2.6244 c=0
Rk55 (\4\:SI SI) resistor r=0.01944 c=0
Rk11 (\25\:qbint \26\:qbint) resistor r=0.5959 c=0
Rk15 (\26\:qbint \31\:qbint) resistor r=0.1671 c=0
Rk25 (\11\:n35 \12\:n35) resistor r=0.1981 c=0
Rk26 (\12\:n35 \13\:n35) resistor r=2.2074 c=0
Rk27 (\12\:n35 \15\:n35) resistor r=0.2639 c=0
Rk20 (\6\:RNb \8\:RNb) resistor r=0.7607 c=0
Rk21 (\8\:RNb \10\:RNb) resistor r=0.7313 c=0
Rk22 (\2\:net486 \4\:net486) resistor r=0.3453 c=0
Rk24 (\2\:net490 \4\:net490) resistor r=0.3602 c=0
Rk44 (\13\:CKb \14\:CKb) resistor r=0.2884 c=0
Rk45 (\14\:CKb \15\:CKb) resistor r=3.358 c=0
Rk46 (\15\:CKb \16\:CKb) resistor r=0.8883 c=0
Rk47 (\14\:CKb \17\:CKb) resistor r=0.2735 c=0
Rk48 (\17\:CKb \19\:CKb) resistor r=0.454 c=0
Rk31 (\5\:mout \6\:mout) resistor r=0.2545 c=0
Rk32 (\6\:mout \8\:mout) resistor r=0.1517 c=0
Rk33 (\5\:mout \10\:mout) resistor r=0.8346 c=0
Rk34 (\6\:mout \12\:mout) resistor r=1.0011 c=0
Rk35 (\12\:mout \13\:mout) resistor r=0.4052 c=0
Rk39 (\10\:CKbb \12\:CKbb) resistor r=0.4998 c=0
Rk40 (\12\:CKbb \13\:CKbb) resistor r=0.3917 c=0
Rk41 (\13\:CKbb \14\:CKbb) resistor r=0.6589 c=0
Rk42 (\14\:CKbb \15\:CKbb) resistor r=1.5174 c=0
Rk43 (\13\:CKbb \16\:CKbb) resistor r=0.2487 c=0
Rk30 (\2\:net469 \4\:net469) resistor r=0.3376 c=0
Rk36 (\6\:n20 \7\:n20) resistor r=0.4712 c=0
Rk37 (\7\:n20 \8\:n20) resistor r=0.5281 c=0
Rk38 (\7\:n20 \10\:n20) resistor r=0.06512 c=0
Rk51 (\2\:Db \3\:Db) resistor r=0.7142 c=0
Rk52 (\3\:Db \5\:Db) resistor r=1.0156 c=0
Rk53 (\3\:Db \7\:Db) resistor r=0.1796 c=0
Rk54 (\5\:Db \9\:Db) resistor r=0.6334 c=0
Rk59 (\5\:SEb \6\:SEb) resistor r=0.5034 c=0
Rk60 (\6\:SEb \7\:SEb) resistor r=0.7712 c=0
Rk61 (\6\:SEb \9\:SEb) resistor r=0.4152 c=0
Rk23 (\2\:net394 \4\:net394) resistor r=0.4937 c=0
Rl29 (\1\:RN \2\:RN) resistor r=47.3097 c=0
Rl30 (\2\:RN \3\:RN) resistor r=76.1559 c=0
Rl61 (\1\:D \2\:D) resistor r=103.08 c=0
Rl63 (\2\:D \4\:D) resistor r=47.3105 c=0
Rl62 (\2\:D \3\:D) resistor r=46.5271 c=0
Rl59 (\1\:CK \2\:CK) resistor r=90.9234 c=0
Rl60 (\2\:CK \3\:CK) resistor r=39.1533 c=0
Rl71 (\6\:SE \7\:SE) resistor r=261.796 c=0
Rl70 (\5\:SE \6\:SE) resistor r=39.1533 c=0
Rl67 (\3\:SE \4\:SE) resistor r=31.3807 c=0
Rl64 (\1\:SE \2\:SE) resistor r=33.7903 c=0
Rl47 (\4\:SN \5\:SN) resistor r=172.643 c=0
Rl48 (\5\:SN \6\:SN) resistor r=24.2328 c=0
Rl31 (\1\:SN \2\:SN) resistor r=24.2328 c=0
Rl32 (\2\:SN \3\:SN) resistor r=93.4636 c=0
Rl69 (\2\:SI \3\:SI) resistor r=37.4409 c=0
Rl68 (\1\:SI \2\:SI) resistor r=110.771 c=0
Rl34 (\24\:qbint \22\:qbint) resistor r=146.154 c=0
Rl33 (\23\:qbint \22\:qbint) resistor r=314.898 c=0
Rl42 (RNb \4\:RNb) resistor r=150 c=0
Rl43 (\3\:RNb \5\:RNb) resistor r=166.873 c=0
Rl40 (RNb \2\:RNb) resistor r=873.616 c=0
Rl41 (\2\:RNb \3\:RNb) resistor r=39.6174 c=0
Rl53 (\5\:CKb \6\:CKb) resistor r=133.848 c=0
Rl36 (\3\:CKb \4\:CKb) resistor r=35.3072 c=0
Rl35 (CKb \2\:CKb) resistor r=29.5379 c=0
Rl57 (\7\:CKb \10\:CKb) resistor r=30.4507 c=0
Rl54 (\6\:CKb \7\:CKb) resistor r=15.351 c=0
Rl56 (\8\:CKb \9\:CKb) resistor r=194.953 c=0
Rl58 (\8\:CKb \11\:CKb) resistor r=45.3874 c=0
Rl55 (\7\:CKb \8\:CKb) resistor r=208.53 c=0
Rl49 (mout \2\:mout) resistor r=28.079 c=0
Rl50 (\2\:mout \3\:mout) resistor r=131.925 c=0
Rl52 (\7\:CKbb \8\:CKbb) resistor r=29.5379 c=0
Rl51 (\5\:CKbb \6\:CKbb) resistor r=70.3867 c=0
Rl38 (\2\:CKbb \3\:CKbb) resistor r=164.928 c=0
Rl37 (CKbb \2\:CKbb) resistor r=32.3738 c=0
Rl39 (\2\:CKbb \4\:CKbb) resistor r=153.772 c=0
Rl45 (\2\:n20 \3\:n20) resistor r=156.078 c=0
Rl44 (n20 \2\:n20) resistor r=23.7402 c=0
Rl46 (\2\:n20 \4\:n20) resistor r=6.6011 c=0
Rl65 (SEb \2\:SEb) resistor r=24.2328 c=0
Rl66 (\2\:SEb \3\:SEb) resistor r=121.875 c=0
Rz23 (\2\:VSS \1\:VSS) resistor r=75 c=0
Rz24 (\18\:VSS \17\:VSS) resistor r=75 c=0
Rz25 (\20\:VSS \19\:VSS) resistor r=75 c=0
Rz26 (\22\:VSS \21\:VSS) resistor r=75 c=0
Rz27 (\24\:VSS \23\:VSS) resistor r=75 c=0
Rz33 (\4\:VDD \3\:VDD) resistor r=6.25 c=0
Rz34 (\8\:VDD \3\:VDD) resistor r=6.25 c=0
Rz35 (\11\:VDD \3\:VDD) resistor r=6.25 c=0
Rz36 (\13\:VDD \3\:VDD) resistor r=6.25 c=0
Rz12 (\15\:n35 \14\:n35) resistor r=75 c=0
Rz7 (\9\:RNb \10\:RNb) resistor r=75 c=0
Rz8 (net486 \2\:net486) resistor r=75 c=0
Rz9 (\3\:net486 \4\:net486) resistor r=75 c=0
Rz10 (net490 \2\:net490) resistor r=75 c=0
Rz11 (\3\:net490 \4\:net490) resistor r=75 c=0
Rz19 (\18\:CKb \19\:CKb) resistor r=75 c=0
Rz15 (\4\:mout \5\:mout) resistor r=75 c=0
Rz16 (\9\:mout \10\:mout) resistor r=75 c=0
Rz18 (\9\:CKbb \10\:CKbb) resistor r=75 c=0
Rz13 (net469 \2\:net469) resistor r=75 c=0
Rz14 (\3\:net469 \4\:net469) resistor r=75 c=0
Rz17 (\9\:n20 \10\:n20) resistor r=75 c=0
Rz20 (\4\:Db \5\:Db) resistor r=75 c=0
Rz21 (\6\:Db \7\:Db) resistor r=75 c=0
Rz22 (\4\:SEb \5\:SEb) resistor r=75 c=0
Ry19 (\4\:VSS \3\:VSS) resistor r=5.1667 c=0
Ry20 (\8\:VSS \3\:VSS) resistor r=5.1667 c=0
Ry21 (\9\:VSS \3\:VSS) resistor r=5.1667 c=0
Ry22 (\11\:VSS \3\:VSS) resistor r=5.1667 c=0
Ry23 (\2\:VDD \1\:VDD) resistor r=62 c=0
Ry24 (\20\:VDD \19\:VDD) resistor r=62 c=0
Ry25 (\22\:VDD \21\:VDD) resistor r=62 c=0
Ry26 (\24\:VDD \23\:VDD) resistor r=62 c=0
Ry27 (\26\:VDD \25\:VDD) resistor r=62 c=0
Ry28 (\28\:VDD \27\:VDD) resistor r=62 c=0
Ry29 (\30\:VDD \29\:VDD) resistor r=62 c=0
Ry10 (\11\:n35 \10\:n35) resistor r=31 c=0
Ry7 (\7\:RNb \8\:RNb) resistor r=62 c=0
Ry15 (\12\:CKb \13\:CKb) resistor r=62 c=0
Ry11 (\7\:mout \8\:mout) resistor r=62 c=0
Ry12 (\11\:mout \12\:mout) resistor r=62 c=0
Ry14 (\11\:CKbb \12\:CKbb) resistor r=62 c=0
Ry13 (\5\:n20 \6\:n20) resistor r=62 c=0
Ry16 (Db \2\:Db) resistor r=20.6667 c=0
Ry17 (\8\:Db \9\:Db) resistor r=62 c=0
Ry18 (\8\:SEb \9\:SEb) resistor r=62 c=0
Ry8 (net394 \2\:net394) resistor r=62 c=0
Ry9 (\3\:net394 \4\:net394) resistor r=62 c=0
Rx3 (\2\:RN \4\:RN) resistor r=45 c=0
Rx17 (\3\:D \5\:D) resistor r=45 c=0
Rx16 (\2\:CK \4\:CK) resistor r=45 c=0
Rx19 (\6\:SE \8\:SE) resistor r=45 c=0
Rx20 (\4\:SE \9\:SE) resistor r=45 c=0
Rx21 (\2\:SE \10\:SE) resistor r=45 c=0
Rx6 (\6\:SN \7\:SN) resistor r=45 c=0
Rx7 (\2\:SN \8\:SN) resistor r=45 c=0
Rx18 (\2\:SI \4\:SI) resistor r=45 c=0
Rx1 (\25\:qbint \23\:qbint) resistor r=45 c=0
Rx2 (\31\:qbint qbint) resistor r=45 c=0
Rx5 (\13\:n35 n35) resistor r=45 c=0
Rx4 (\2\:RNb \6\:RNb) resistor r=45 c=0
Rx13 (\4\:CKb \15\:CKb) resistor r=45 c=0
Rx14 (\2\:CKb \16\:CKb) resistor r=45 c=0
Rx15 (\6\:CKb \17\:CKb) resistor r=45 c=0
Rx8 (\2\:mout \13\:mout) resistor r=45 c=0
Rx10 (\6\:CKbb \14\:CKbb) resistor r=45 c=0
Rx11 (\4\:CKbb \15\:CKbb) resistor r=45 c=0
Rx12 (\8\:CKbb \16\:CKbb) resistor r=45 c=0
Rx9 (\4\:n20 \8\:n20) resistor r=45 c=0
Rx22 (\2\:SEb \7\:SEb) resistor r=45 c=0
mn55_1__rcx (Q qbint \11\:VSS VSS) g45n1svt w=(2.95e-07) l=4.5e-08 nf=1 \
        as=4.69e-14 ad=4.636e-14 ps=9.1e-07 pd=9.0429e-07 nrd=1.16667 \
        nrs=1.16667 sa=1.4e-07 sb=1.92051e-06 sd=160n sca=16.4223 \
        scb=0.0158966 scc=0.0014413 m=(7)
mn11 (net522 \4\:D \17\:VSS VSS) g45n1svt w=(2.6e-07) l=4.5e-08 nf=1 \
        as=8.535e-14 ad=4.03e-14 ps=1.5e-06 pd=8.3e-07 nrd=1.16667 \
        nrs=1.16667 sa=3.34519e-07 sb=8.94038e-07 sd=160n sca=9.69565 \
        scb=0.00844644 scc=0.000275168 m=(1)
mn12 (\6\:Db \3\:SEb net522 VSS) g45n1svt w=(2.6e-07) l=4.5e-08 nf=1 \
        as=4.03e-14 ad=6.257e-14 ps=8.3e-07 pd=1.06e-06 nrd=1.16667 \
        nrs=1.16667 sa=5.34519e-07 sb=6.94038e-07 sd=160n sca=9.69565 \
        scb=0.00844644 scc=0.000275168 m=(1)
mn14 (\6\:Db \3\:SE net534 VSS) g45n1svt w=(2.6e-07) l=4.5e-08 nf=1 \
        as=1.56e-14 ad=6.257e-14 ps=6.4e-07 pd=1.06e-06 nrd=1.16667 \
        nrs=1.16667 sa=7.42308e-07 sb=4.42019e-07 sd=160n sca=8.81533 \
        scb=0.00706435 scc=0.000179997 m=(1)
mn13 (net534 \1\:SI \1\:VSS VSS) g45n1svt w=(2.6e-07) l=4.5e-08 nf=1 \
        as=6.08e-14 ad=1.56e-14 ps=1.2e-06 pd=6.4e-07 nrd=1.16667 \
        nrs=1.16667 sa=8.47308e-07 sb=3.37019e-07 sd=160n sca=8.81533 \
        scb=0.00706435 scc=0.000179997 m=(1)
mn45_1__rcx (\26\:qbint n35 \11\:VSS VSS) g45n1svt w=(2.6e-07) l=4.5e-08 \
        nf=1 as=4.623e-14 ad=4.81e-14 ps=8.9e-07 pd=8.9e-07 nrd=1.16667 \
        nrs=1.16667 sa=1.575e-06 sb=6.65e-07 sd=160n sca=13.9783 \
        scb=0.013979 scc=0.000942864 m=(3)
mn22 (\9\:RNb \3\:RN \23\:VSS VSS) g45n1svt w=(1.45e-07) l=4.5e-08 nf=1 \
        as=4.297e-14 ad=2.755e-14 ps=9.2e-07 pd=6.7e-07 nrd=1.16667 \
        nrs=1.16667 sa=1.9e-07 sb=9.3e-07 sd=160n sca=13.9854 scb=0.014728 \
        scc=0.000819645 m=(1)
mn21 (\9\:CKbb \10\:CKb \19\:VSS VSS) g45n1svt w=(1.45e-07) l=4.5e-08 \
        nf=1 as=6.185e-14 ad=2.03e-14 ps=1.25e-06 pd=5.7e-07 nrd=1.16667 \
        nrs=1.16667 sa=1.4e-07 sb=1.7e-07 sd=160n sca=10.9472 \
        scb=0.0104991 scc=0.000356047 m=(1)
mn20 (\18\:CKb \3\:CK \17\:VSS VSS) g45n1svt w=(1.45e-07) l=4.5e-08 nf=1 \
        as=8.535e-14 ad=2.03e-14 ps=1.5e-06 pd=5.7e-07 nrd=1.16667 \
        nrs=1.16667 sa=1.4e-07 sb=1.30362e-06 sd=160n sca=11.7118 \
        scb=0.0116498 scc=0.000458536 m=(1)
mn10 (\4\:SEb \5\:SE \1\:VSS VSS) g45n1svt w=(1.45e-07) l=4.5e-08 nf=1 \
        as=6.08e-14 ad=2.03e-14 ps=1.2e-06 pd=5.7e-07 nrd=1.16667 \
        nrs=1.16667 sa=1.39414e-06 sb=1.4e-07 sd=160n sca=10.4914 \
        scb=0.00978575 scc=0.000300434 m=(1)
mn50 (\3\:net486 \3\:SN \23\:VSS VSS) g45n1svt w=(2.05e-07) l=4.5e-08 \
        nf=1 as=4.297e-14 ad=4.92e-14 ps=9.2e-07 pd=8.9e-07 nrd=1.16667 \
        nrs=1.16667 sa=3.75854e-07 sb=6.3e-07 sd=160n sca=13.4389 \
        scb=0.0137383 scc=0.000784938 m=(1)
mn52 (net490 \24\:qbint \3\:net486 VSS) g45n1svt w=(2.05e-07) l=4.5e-08 \
        nf=1 as=4.92e-14 ad=3.28e-14 ps=8.9e-07 pd=7.3e-07 nrd=1.16667 \
        nrs=1.16667 sa=6.60854e-07 sb=3.45e-07 sd=160n sca=13.4389 \
        scb=0.0137383 scc=0.000784938 m=(1)
mn51 (net490 \5\:RNb net486 VSS) g45n1svt w=(2.05e-07) l=4.5e-08 nf=1 \
        as=2.87e-14 ad=3.28e-14 ps=6.9e-07 pd=7.3e-07 nrd=1.16667 \
        nrs=1.16667 sa=8.65854e-07 sb=1.4e-07 sd=160n sca=13.4389 \
        scb=0.0137383 scc=0.000784938 m=(1)
mn53 (\14\:n35 CKb \3\:net490 VSS) g45n1svt w=(2.05e-07) l=4.5e-08 nf=1 \
        as=4.612e-14 ad=5.125e-14 ps=8.6e-07 pd=9.1e-07 nrd=1.16667 \
        nrs=1.16667 sa=2.25e-07 sb=5.8e-07 sd=160n sca=10.7727 \
        scb=0.0101457 scc=0.000373012 m=(1)
mn40 (\14\:n35 CKbb \4\:mout VSS) g45n1svt w=(2.05e-07) l=4.5e-08 nf=1 \
        as=5.842e-14 ad=5.125e-14 ps=9.8e-07 pd=9.1e-07 nrd=1.16667 \
        nrs=1.16667 sa=5.2e-07 sb=2.85e-07 sd=160n sca=10.7727 \
        scb=0.0101457 scc=0.000373012 m=(1)
mn31 (\9\:mout \4\:RNb \3\:net469 VSS) g45n1svt w=(2.05e-07) l=4.5e-08 \
        nf=1 as=2.87e-14 ad=4.612e-14 ps=6.9e-07 pd=8.6e-07 nrd=1.16667 \
        nrs=1.16667 sa=1.4e-07 sb=1.325e-06 sd=160n sca=9.00745 \
        scb=0.0073653 scc=0.000173562 m=(1)
mn32 (\9\:mout n20 net469 VSS) g45n1svt w=(2.05e-07) l=4.5e-08 nf=1 \
        as=3.382e-14 ad=4.612e-14 ps=7.4e-07 pd=8.6e-07 nrd=1.16667 \
        nrs=1.16667 sa=4.1e-07 sb=1.055e-06 sd=160n sca=9.00745 \
        scb=0.0073653 scc=0.000173562 m=(1)
mn30 (net469 \4\:SN \21\:VSS VSS) g45n1svt w=(2.05e-07) l=4.5e-08 nf=1 \
        as=4.715e-14 ad=3.382e-14 ps=8.7e-07 pd=7.4e-07 nrd=1.16667 \
        nrs=1.16667 sa=6.2e-07 sb=8.45e-07 sd=160n sca=9.00745 \
        scb=0.0073653 scc=0.000173562 m=(1)
mn35 (net514 \3\:mout \21\:VSS VSS) g45n1svt w=(2.05e-07) l=4.5e-08 nf=1 \
        as=4.715e-14 ad=2.05e-14 ps=8.7e-07 pd=6.1e-07 nrd=1.16667 \
        nrs=1.16667 sa=8.95e-07 sb=5.7e-07 sd=160n sca=9.00745 \
        scb=0.0073653 scc=0.000173562 m=(1)
mn36 (\9\:n20 \5\:CKbb net514 VSS) g45n1svt w=(2.05e-07) l=4.5e-08 nf=1 \
        as=2.05e-14 ad=4.92e-14 ps=6.1e-07 pd=8.9e-07 nrd=1.16667 \
        nrs=1.16667 sa=1.04e-06 sb=4.25e-07 sd=160n sca=9.00745 \
        scb=0.0073653 scc=0.000173562 m=(1)
mn25 (\4\:Db \11\:CKb \9\:n20 VSS) g45n1svt w=(2.05e-07) l=4.5e-08 nf=1 \
        as=4.92e-14 ad=2.87e-14 ps=8.9e-07 pd=6.9e-07 nrd=1.16667 \
        nrs=1.16667 sa=1.325e-06 sb=1.4e-07 sd=160n sca=9.00745 \
        scb=0.0073653 scc=0.000173562 m=(1)
mp11 (net445 \1\:D \19\:VDD VDD) g45p1svt w=(3.9e-07) l=4.5e-08 nf=1 \
        as=7.125e-14 ad=2.34e-14 ps=1.28e-06 pd=9e-07 nrd=1.16667 \
        nrs=1.16667 sa=2.84679e-07 sb=7.15064e-07 sd=160n sca=19.0259 \
        scb=0.0163587 scc=0.00171562 m=(1)
mp12 (Db \1\:SE net445 VDD) g45p1svt w=(3.9e-07) l=4.5e-08 nf=1 \
        as=2.34e-14 ad=6.24e-14 ps=9e-07 pd=1.1e-06 nrd=1.16667 \
        nrs=1.16667 sa=3.89679e-07 sb=6.10064e-07 sd=160n sca=19.0259 \
        scb=0.0163587 scc=0.00171562 m=(1)
mp14 (Db SEb net453 VDD) g45p1svt w=(3.9e-07) l=4.5e-08 nf=1 as=4.875e-14 \
        ad=6.24e-14 ps=1.03e-06 pd=1.1e-06 nrd=1.16667 nrs=1.16667 \
        sa=5.94679e-07 sb=4.05064e-07 sd=160n sca=19.0259 scb=0.0163587 \
        scc=0.00171562 m=(1)
mp13 (net453 \3\:SI \1\:VDD VDD) g45p1svt w=(3.9e-07) l=4.5e-08 nf=1 \
        as=5.19e-14 ad=4.875e-14 ps=1.1e-06 pd=1.03e-06 nrd=1.16667 \
        nrs=1.16667 sa=7.64679e-07 sb=2.35064e-07 sd=160n sca=19.3112 \
        scb=0.0164357 scc=0.00171563 m=(1)
mp45_1__rcx (\26\:qbint n35 \13\:VDD VDD) g45p1svt w=(3.9e-07) l=4.5e-08 \
        nf=1 as=6.423e-14 ad=5.98e-14 ps=1.13667e-06 pd=1.08667e-06 \
        nrd=1.16667 nrs=1.16667 sa=1.575e-06 sb=5.5e-07 sd=160n \
        sca=18.3796 scb=0.0159892 scc=0.00159615 m=(3)
mp22 (\7\:RNb \1\:RN \29\:VDD VDD) g45p1svt w=(2.15e-07) l=4.5e-08 nf=1 \
        as=8.57e-14 ad=3.01e-14 ps=1.32e-06 pd=7.1e-07 nrd=1.16667 \
        nrs=1.16667 sa=1.4e-07 sb=9.85e-07 sd=160n sca=20.4333 \
        scb=0.0198015 scc=0.00193653 m=(1)
mp21 (\11\:CKbb \5\:CKb \21\:VDD VDD) g45p1svt w=(2.15e-07) l=4.5e-08 \
        nf=1 as=5.053e-14 ad=3.44e-14 ps=9e-07 pd=7.5e-07 nrd=1.16667 \
        nrs=1.16667 sa=1.6e-07 sb=2.35e-07 sd=160n sca=14.2498 \
        scb=0.0138057 scc=0.00069487 m=(1)
mp20 (\12\:CKb \1\:CK \19\:VDD VDD) g45p1svt w=(2.15e-07) l=4.5e-08 nf=1 \
        as=7.125e-14 ad=3.01e-14 ps=1.28e-06 pd=7.1e-07 nrd=1.16667 \
        nrs=1.16667 sa=1.4e-07 sb=9.20581e-07 sd=160n sca=25.9192 \
        scb=0.0230503 scc=0.00301683 m=(1)
mp10 (\8\:SEb \7\:SE \1\:VDD VDD) g45p1svt w=(2.15e-07) l=4.5e-08 nf=1 \
        as=5.19e-14 ad=3.01e-14 ps=1.1e-06 pd=7.1e-07 nrd=1.16667 \
        nrs=1.16667 sa=8.47326e-07 sb=1.4e-07 sd=160n sca=12.2443 \
        scb=0.00977105 scc=0.000188654 m=(1)
mp50 (\3\:net394 \1\:SN \29\:VDD VDD) g45p1svt w=(3.1e-07) l=4.5e-08 \
        nf=1 as=8.57e-14 ad=7.44e-14 ps=1.32e-06 pd=1.1e-06 nrd=1.16667 \
        nrs=1.16667 sa=3.67984e-07 sb=6.85e-07 sd=160n sca=17.3904 \
        scb=0.0162056 scc=0.00137566 m=(1)
mp52 (\3\:net394 \22\:qbint net437 VDD) g45p1svt w=(3.1e-07) l=4.5e-08 \
        nf=1 as=1.86e-14 ad=7.44e-14 ps=7.4e-07 pd=1.1e-06 nrd=1.16667 \
        nrs=1.16667 sa=6.52984e-07 sb=4e-07 sd=160n sca=17.3904 \
        scb=0.0162056 scc=0.00137566 m=(1)
mp51 (net437 \3\:RNb \27\:VDD VDD) g45p1svt w=(3.1e-07) l=4.5e-08 nf=1 \
        as=1.0045e-13 ad=1.86e-14 ps=1.36e-06 pd=7.4e-07 nrd=1.16667 \
        nrs=1.16667 sa=7.57984e-07 sb=2.95e-07 sd=160n sca=17.3904 \
        scb=0.0162056 scc=0.00137566 m=(1)
mp53 (\10\:n35 \3\:CKbb net394 VDD) g45p1svt w=(3.1e-07) l=4.5e-08 nf=1 \
        as=7.905e-14 ad=5.89e-14 ps=1.13e-06 pd=1e-06 nrd=1.16667 \
        nrs=1.16667 sa=2.55e-07 sb=4.6e-07 sd=160n sca=26.7199 \
        scb=0.0211429 scc=0.00304348 m=(1)
mp40 (\10\:n35 \3\:CKb \7\:mout VDD) g45p1svt w=(3.1e-07) l=4.5e-08 nf=1 \
        as=6.975e-14 ad=5.89e-14 ps=1.07e-06 pd=1e-06 nrd=1.16667 \
        nrs=1.16667 sa=4.9e-07 sb=2.25e-07 sd=160n sca=26.7199 \
        scb=0.0211429 scc=0.00304348 m=(1)
mp31 (net417 RNb \25\:VDD VDD) g45p1svt w=(3.1e-07) l=4.5e-08 nf=1 \
        as=1.946e-13 ad=1.86e-14 ps=2.09e-06 pd=7.4e-07 nrd=1.16667 \
        nrs=1.16667 sa=5.6e-07 sb=1.17952e-06 sd=160n sca=35.6995 \
        scb=0.0234062 scc=0.00420468 m=(1)
mp32 (\11\:mout \3\:n20 net417 VDD) g45p1svt w=(3.1e-07) l=4.5e-08 nf=1 \
        as=1.86e-14 ad=6.975e-14 ps=7.4e-07 pd=1.07e-06 nrd=1.16667 \
        nrs=1.16667 sa=6.65e-07 sb=1.07452e-06 sd=160n sca=35.6995 \
        scb=0.0234062 scc=0.00420468 m=(1)
mp30 (\11\:mout \5\:SN \23\:VDD VDD) g45p1svt w=(3.1e-07) l=4.5e-08 nf=1 \
        as=1.0385e-13 ad=6.975e-14 ps=1.49e-06 pd=1.07e-06 nrd=1.16667 \
        nrs=1.16667 sa=9.35e-07 sb=8.04516e-07 sd=160n sca=35.6995 \
        scb=0.0234062 scc=0.00420468 m=(1)
mp35 (net425 mout \23\:VDD VDD) g45p1svt w=(3.1e-07) l=4.5e-08 nf=1 \
        as=1.0385e-13 ad=6.045e-14 ps=1.49e-06 pd=1.01e-06 nrd=1.16667 \
        nrs=1.16667 sa=9.66613e-07 sb=7.26129e-07 sd=160n sca=15.5687 \
        scb=0.0146164 scc=0.00101158 m=(1)
mp36 (\5\:n20 \9\:CKb net425 VDD) g45p1svt w=(3.1e-07) l=4.5e-08 nf=1 \
        as=6.045e-14 ad=9.193e-14 ps=1.01e-06 pd=1.28e-06 nrd=1.16667 \
        nrs=1.16667 sa=1.20661e-06 sb=4.86129e-07 sd=160n sca=15.5687 \
        scb=0.0146164 scc=0.00101158 m=(1)
mp25 (\5\:n20 \7\:CKbb \8\:Db VDD) g45p1svt w=(3.1e-07) l=4.5e-08 nf=1 \
        as=5.27e-14 ad=9.193e-14 ps=9.6e-07 pd=1.28e-06 nrd=1.16667 \
        nrs=1.16667 sa=1.49815e-06 sb=1.7e-07 sd=160n sca=17.9343 \
        scb=0.0166254 scc=0.0014837 m=(1)
ends SDFFSRHQX8
// End of subcircuit definition.
