// Generated for: spectre (May  1 09:20:16 2013 )
// Library name: gsclib045_hvt
// Cell name: TLATX1
// View name: extracted

simulator lang=spectre

subckt TLATX1 D G Q QN VDD VSS
mp1 (\8\:Gbb \3\:Gb \13\:VDD VDD) g45p1hvt w=(2.15e-07) l=4.5e-08 nf=1 \
        as=4.408e-14 ad=3.655e-14 ps=8.4e-07 pd=7.7e-07 nrd=1.16667 \
        nrs=1.16667 sa=1.7e-07 sb=1.265e-06 sd=160n sca=16.8928 \
        scb=0.0171325 scc=0.000344283 m=(1)
mp5 (net220 \1\:D \13\:VDD VDD) g45p1hvt w=(2.15e-07) l=4.5e-08 nf=1 \
        as=4.408e-14 ad=2.795e-14 ps=8.4e-07 pd=6.9e-07 nrd=1.16667 \
        nrs=1.16667 sa=4.2e-07 sb=1.015e-06 sd=160n sca=11.9226 \
        scb=0.00878315 scc=8.35278e-05 m=(1)
mp6 (\6\:n0 \4\:Gb net220 VDD) g45p1hvt w=(2.15e-07) l=4.5e-08 nf=1 \
        as=2.795e-14 ad=5.483e-14 ps=6.9e-07 pd=9.4e-07 nrd=1.16667 \
        nrs=1.16667 sa=5.95e-07 sb=8.4e-07 sd=160n sca=10.8672 \
        scb=0.00773693 scc=8.06307e-05 m=(1)
mp16 (\6\:n0 Gbb net212 VDD) g45p1hvt w=(2.15e-07) l=4.5e-08 nf=1 \
        as=1.935e-14 ad=5.483e-14 ps=6.1e-07 pd=9.4e-07 nrd=1.16667 \
        nrs=1.16667 sa=8.95e-07 sb=5.4e-07 sd=160n sca=10.2104 \
        scb=0.00747301 scc=8.05149e-05 m=(1)
mp15 (net212 \3\:Qint \11\:VDD VDD) g45p1hvt w=(2.15e-07) l=4.5e-08 nf=1 \
        as=7.43e-14 ad=1.935e-14 ps=1.32e-06 pd=6.1e-07 nrd=1.16667 \
        nrs=1.16667 sa=1.03e-06 sb=4.05e-07 sd=160n sca=10.2104 \
        scb=0.00747301 scc=8.05149e-05 m=(1)
mp10 (\17\:Qint \3\:n0 \11\:VDD VDD) g45p1hvt w=(2.15e-07) l=4.5e-08 \
        nf=1 as=7.43e-14 ad=3.01e-14 ps=1.32e-06 pd=7.1e-07 nrd=1.16667 \
        nrs=1.16667 sa=1.295e-06 sb=1.4e-07 sd=160n sca=10.2104 \
        scb=0.00747301 scc=8.05149e-05 m=(1)
mp0 (\14\:Gb \3\:G \9\:VDD VDD) g45p1hvt w=(2.15e-07) l=4.5e-08 nf=1 \
        as=8.47e-14 ad=4.085e-14 ps=1.34e-06 pd=8.1e-07 nrd=1.16667 \
        nrs=1.16667 sa=1.9e-07 sb=4.65e-07 sd=160n sca=15.6338 \
        scb=0.015455 scc=0.000959319 m=(1)
C1 (G VSS) capacitor c=6.84202e-17
C2 (D VSS) capacitor c=5.89881e-17
C3 (VDD VSS) capacitor c=2.14929e-16
C4 (Gb VSS) capacitor c=5.59756e-17
C5 (Gbb VSS) capacitor c=7.39553e-17
C6 (net257 VSS) capacitor c=1.02534e-17
C7 (n0 VSS) capacitor c=3.49379e-17
C8 (Qint VSS) capacitor c=8.77254e-17
C9 (Qbint VSS) capacitor c=3.79923e-17
C10 (net212 VSS) capacitor c=1.24322e-18
C11 (\4\:Qint VSS) capacitor c=4.47415e-17
C12 (\10\:Qint VSS) capacitor c=3.9163e-17
C13 (\3\:G VSS) capacitor c=3.4608e-17
C14 (\3\:n0 VSS) capacitor c=5.93526e-17
C15 (\3\:Qint VSS) capacitor c=6.27632e-17
C16 (\4\:Gb VSS) capacitor c=3.54836e-17
C17 (\1\:D VSS) capacitor c=5.70367e-17
C18 (\3\:Gb VSS) capacitor c=2.6379e-17
C19 (\4\:Qbint VSS) capacitor c=3.6169e-17
C20 (\8\:Qint VSS) capacitor c=2.96839e-17
C21 (\9\:Qint VSS) capacitor c=3.40936e-17
C22 (\1\:G VSS) capacitor c=3.7566e-17
C23 (\6\:Gb VSS) capacitor c=8.16104e-17
C24 (\4\:Gbb VSS) capacitor c=3.39945e-17
C25 (\3\:D VSS) capacitor c=3.93273e-17
C26 (\3\:Qbint VSS) capacitor c=2.07223e-17
C27 (\7\:Qint VSS) capacitor c=2.25328e-17
C28 (\2\:G VSS) capacitor c=4.45204e-17
C29 (\2\:n0 VSS) capacitor c=6.60806e-17
C30 (\2\:Qint VSS) capacitor c=8.39404e-17
C31 (\7\:Gb VSS) capacitor c=3.90226e-17
C32 (\5\:Gb VSS) capacitor c=3.71283e-17
C33 (\3\:Gbb VSS) capacitor c=2.90025e-17
C34 (\2\:D VSS) capacitor c=5.27518e-17
C35 (\2\:Gb VSS) capacitor c=4.84107e-17
C36 (\1\:Q VSS) capacitor c=6.87429e-17
C37 (\1\:VDD VSS) capacitor c=8.20891e-17
C38 (\9\:Qbint VSS) capacitor c=5.92956e-17
C39 (\1\:QN VSS) capacitor c=6.80609e-17
C40 (\9\:VDD VSS) capacitor c=3.44471e-17
C41 (\14\:Gb VSS) capacitor c=1.46633e-16
C42 (\17\:Qint VSS) capacitor c=5.25522e-17
C43 (\11\:VDD VSS) capacitor c=2.37212e-17
C44 (\6\:n0 VSS) capacitor c=7.94198e-17
C45 (\13\:VDD VSS) capacitor c=3.47588e-17
C46 (\8\:Gbb VSS) capacitor c=6.21618e-17
C47 (\3\:VDD VSS) capacitor c=5.55854e-17
C48 (\3\:Q VSS) capacitor c=4.33733e-17
C49 (\7\:Qbint VSS) capacitor c=2.08446e-17
C50 (\3\:QN VSS) capacitor c=5.78076e-17
C51 (\8\:Gb VSS) capacitor c=8.57893e-17
C52 (\15\:Qint VSS) capacitor c=3.02688e-17
C53 (\8\:n0 VSS) capacitor c=4.33038e-17
C54 (\6\:Gbb VSS) capacitor c=8.59724e-17
C55 (\2\:Gbb VSS) capacitor c=3.94204e-17
C56 (\5\:Qint VSS) capacitor c=3.31242e-17
C57 (\6\:Qint VSS) capacitor c=2.24381e-17
C58 (\2\:Qbint VSS) capacitor c=1.4053e-17
C59 (\4\:D VSS) capacitor c=5.4181e-17
C60 (\5\:Gbb VSS) capacitor c=7.29194e-17
C61 (\4\:n0 VSS) capacitor c=3.90318e-17
C62 (\5\:n0 VSS) capacitor c=7.54118e-17
C63 (\10\:Gb VSS) capacitor c=1.62482e-16
C64 (\11\:Gb VSS) capacitor c=1.04039e-16
C65 (\12\:Gb VSS) capacitor c=1.41876e-16
C66 (\13\:Gb VSS) capacitor c=6.66875e-17
C67 (\4\:G VSS) capacitor c=2.46207e-17
C68 (\11\:Qint VSS) capacitor c=6.57054e-17
C69 (\12\:Qint VSS) capacitor c=5.66581e-17
C70 (\13\:Qint VSS) capacitor c=4.45992e-17
C71 (\14\:Qint VSS) capacitor c=2.82232e-17
C72 (\5\:Qbint VSS) capacitor c=3.37595e-17
C73 (\6\:Qbint VSS) capacitor c=2.19354e-17
C74 (\5\:VDD VSS) capacitor c=2.86414e-17
C75 (\6\:VDD VSS) capacitor c=2.20562e-17
C76 (\8\:VDD VSS) capacitor c=2.56124e-17
Rk14 (\4\:G G) resistor r=0.00899 c=0
Rk20 (\2\:QN QN) resistor r=0.3868 c=0
Rk21 (QN \4\:QN) resistor r=0.05406 c=0
Rk1 (D \4\:D) resistor r=0.0245 c=0
Rk27 (\2\:VDD \4\:VDD) resistor r=0.417 c=0
Rk28 (\4\:VDD \5\:VDD) resistor r=0.3482 c=0
Rk29 (\5\:VDD \6\:VDD) resistor r=0.4047 c=0
Rk30 (\6\:VDD \7\:VDD) resistor r=0.04648 c=0
Rk32 (\8\:VDD VDD) resistor r=0.1525 c=0
Rk31 (\7\:VDD \8\:VDD) resistor r=0.3983 c=0
Rk33 (\5\:VDD \10\:VDD) resistor r=0.2211 c=0
Rk34 (\6\:VDD \12\:VDD) resistor r=0.04328 c=0
Rk35 (\8\:VDD \14\:VDD) resistor r=0.2233 c=0
Rk25 (\2\:Q Q) resistor r=0.2589 c=0
Rk26 (Q \4\:Q) resistor r=0.03299 c=0
Rk36 (\2\:VSS \4\:VSS) resistor r=0.3224 c=0
Rk37 (\4\:VSS \5\:VSS) resistor r=0.3633 c=0
Rk38 (\5\:VSS \6\:VSS) resistor r=0.3631 c=0
Rk39 (\6\:VSS \7\:VSS) resistor r=0.075 c=0
Rk41 (\8\:VSS VSS) resistor r=0.1951 c=0
Rk40 (\7\:VSS \8\:VSS) resistor r=0.3557 c=0
Rk42 (\5\:VSS \10\:VSS) resistor r=0.3009 c=0
Rk43 (\6\:VSS \12\:VSS) resistor r=0.07358 c=0
Rk44 (\8\:VSS \14\:VSS) resistor r=0.07358 c=0
Rk7 (\9\:Gb \10\:Gb) resistor r=0.6464 c=0
Rk8 (\10\:Gb \11\:Gb) resistor r=0.7159 c=0
Rk9 (\11\:Gb \12\:Gb) resistor r=0.1305 c=0
Rk10 (\12\:Gb \13\:Gb) resistor r=0.3437 c=0
Rk11 (\12\:Gb \15\:Gb) resistor r=1.1234 c=0
Rk2 (\5\:Gbb \7\:Gbb) resistor r=0.452 c=0
Rk3 (\7\:Gbb \9\:Gbb) resistor r=0.5659 c=0
Rk4 (\4\:n0 \5\:n0) resistor r=0.2351 c=0
Rk5 (\5\:n0 \7\:n0) resistor r=0.5031 c=0
Rk6 (\5\:n0 \9\:n0) resistor r=0.1459 c=0
Rk15 (\11\:Qint \12\:Qint) resistor r=0.384 c=0
Rk16 (\12\:Qint \13\:Qint) resistor r=0.295 c=0
Rk17 (\13\:Qint \14\:Qint) resistor r=0.1871 c=0
Rk18 (\12\:Qint \16\:Qint) resistor r=0.1231 c=0
Rk19 (\13\:Qint \18\:Qint) resistor r=0.1968 c=0
Rk22 (\5\:Qbint \6\:Qbint) resistor r=0.1519 c=0
Rk23 (\6\:Qbint \8\:Qbint) resistor r=0.1671 c=0
Rk24 (\6\:Qbint \10\:Qbint) resistor r=0.2193 c=0
Rl15 (\2\:G \3\:G) resistor r=58.7912 c=0
Rl14 (\1\:G \2\:G) resistor r=102.32 c=0
Rl3 (\1\:D \2\:D) resistor r=143 c=0
Rl4 (\2\:D \3\:D) resistor r=79.5379 c=0
Rl9 (\6\:Gb \7\:Gb) resistor r=31.0185 c=0
Rl5 (\4\:Gb \5\:Gb) resistor r=66.5405 c=0
Rl2 (\2\:Gb \3\:Gb) resistor r=29.9451 c=0
Rl1 (Gb \2\:Gb) resistor r=194.231 c=0
Rl6 (Gbb \2\:Gbb) resistor r=198.145 c=0
Rl8 (\2\:Gbb \4\:Gbb) resistor r=50.349 c=0
Rl7 (\2\:Gbb \3\:Gbb) resistor r=80.5242 c=0
Rl13 (\2\:n0 \3\:n0) resistor r=178.641 c=0
Rl12 (n0 \2\:n0) resistor r=43.3029 c=0
Rl11 (\2\:Qint \3\:Qint) resistor r=111.516 c=0
Rl10 (Qint \2\:Qint) resistor r=132.487 c=0
Rl16 (\4\:Qint \5\:Qint) resistor r=74.2335 c=0
Rl19 (\5\:Qint \8\:Qint) resistor r=28.0797 c=0
Rl21 (\6\:Qint \10\:Qint) resistor r=96.8988 c=0
Rl20 (\6\:Qint \9\:Qint) resistor r=33.4373 c=0
Rl18 (\6\:Qint \7\:Qint) resistor r=7.9329 c=0
Rl17 (\5\:Qint \6\:Qint) resistor r=206.01 c=0
Rl22 (Qbint \2\:Qbint) resistor r=34.3295 c=0
Rl24 (\2\:Qbint \4\:Qbint) resistor r=63.1757 c=0
Rl23 (\2\:Qbint \3\:Qbint) resistor r=2.0166 c=0
Rz5 (\3\:QN \4\:QN) resistor r=75 c=0
Rz8 (\3\:VDD \4\:VDD) resistor r=18.75 c=0
Rz9 (\3\:VDD \7\:VDD) resistor r=6.25 c=0
Rz7 (\3\:Q \4\:Q) resistor r=75 c=0
Rz10 (\1\:VSS \2\:VSS) resistor r=75 c=0
Rz11 (\9\:VSS \10\:VSS) resistor r=75 c=0
Rz12 (\11\:VSS \12\:VSS) resistor r=75 c=0
Rz13 (\13\:VSS \14\:VSS) resistor r=75 c=0
Rz3 (\8\:Gb \9\:Gb) resistor r=75 c=0
Rz1 (\6\:Gbb \7\:Gbb) resistor r=75 c=0
Rz2 (\8\:n0 \9\:n0) resistor r=75 c=0
Rz4 (\15\:Qint \16\:Qint) resistor r=75 c=0
Rz6 (\7\:Qbint \8\:Qbint) resistor r=75 c=0
Ry5 (\1\:QN \2\:QN) resistor r=20.6667 c=0
Ry8 (\1\:VDD \2\:VDD) resistor r=20.6667 c=0
Ry9 (\9\:VDD \10\:VDD) resistor r=62 c=0
Ry10 (\11\:VDD \12\:VDD) resistor r=62 c=0
Ry11 (\13\:VDD \14\:VDD) resistor r=62 c=0
Ry7 (\1\:Q \2\:Q) resistor r=20.6667 c=0
Ry12 (\3\:VSS \4\:VSS) resistor r=15.5 c=0
Ry13 (\3\:VSS \7\:VSS) resistor r=5.1667 c=0
Ry3 (\14\:Gb \15\:Gb) resistor r=62 c=0
Ry1 (\8\:Gbb \9\:Gbb) resistor r=62 c=0
Ry2 (\6\:n0 \7\:n0) resistor r=62 c=0
Ry4 (\17\:Qint \18\:Qint) resistor r=62 c=0
Ry6 (\9\:Qbint \10\:Qbint) resistor r=20.6667 c=0
Rx7 (\2\:G \4\:G) resistor r=45 c=0
Rx1 (\2\:D \4\:D) resistor r=45 c=0
Rx4 (\7\:Gb \10\:Gb) resistor r=45 c=0
Rx5 (\5\:Gb \11\:Gb) resistor r=45 c=0
Rx6 (\2\:Gb \13\:Gb) resistor r=45 c=0
Rx2 (\3\:Gbb \5\:Gbb) resistor r=45 c=0
Rx3 (\2\:n0 \4\:n0) resistor r=45 c=0
Rx8 (\7\:Qint \11\:Qint) resistor r=45 c=0
Rx9 (\2\:Qint \14\:Qint) resistor r=45 c=0
Rx10 (\3\:Qbint \5\:Qbint) resistor r=45 c=0
mn1 (\6\:Gbb Gb \13\:VSS VSS) g45n1hvt w=(1.45e-07) l=4.5e-08 nf=1 \
        as=4.615e-14 ad=2.03e-14 ps=1.37e-06 pd=5.7e-07 nrd=1.16667 \
        nrs=1.16667 sa=1.4e-07 sb=1.35e-06 sd=160n sca=11.4452 \
        scb=0.0112553 scc=0.00042156 m=(1)
mn5 (net257 \3\:D \13\:VSS VSS) g45n1hvt w=(1.45e-07) l=4.5e-08 nf=1 \
        as=4.615e-14 ad=6.017e-14 ps=1.37e-06 pd=1.12e-06 nrd=1.16667 \
        nrs=1.16667 sa=3.35e-07 sb=1.155e-06 sd=160n sca=11.4452 \
        scb=0.0112553 scc=0.00042156 m=(1)
mn6 (\8\:n0 \4\:Gbb net257 VSS) g45n1hvt w=(1.45e-07) l=4.5e-08 nf=1 \
        as=6.017e-14 ad=2.32e-14 ps=1.12e-06 pd=6.1e-07 nrd=1.16667 \
        nrs=1.16667 sa=7.95e-07 sb=6.95e-07 sd=160n sca=11.4452 \
        scb=0.0112553 scc=0.00042156 m=(1)
mn16 (\8\:n0 \6\:Gb net245 VSS) g45n1hvt w=(1.45e-07) l=4.5e-08 nf=1 \
        as=8.7e-15 ad=2.32e-14 ps=4.1e-07 pd=6.1e-07 nrd=1.16667 \
        nrs=1.16667 sa=1e-06 sb=4.9e-07 sd=160n sca=11.4452 scb=0.0112553 \
        scc=0.00042156 m=(1)
mn15 (net245 Qint \11\:VSS VSS) g45n1hvt w=(1.45e-07) l=4.5e-08 nf=1 \
        as=5.035e-14 ad=8.7e-15 ps=1.44e-06 pd=4.1e-07 nrd=1.16667 \
        nrs=1.16667 sa=1.105e-06 sb=3.85e-07 sd=160n sca=11.4452 \
        scb=0.0112553 scc=0.00042156 m=(1)
mn10 (\15\:Qint n0 \11\:VSS VSS) g45n1hvt w=(1.45e-07) l=4.5e-08 nf=1 \
        as=5.035e-14 ad=2.755e-14 ps=1.44e-06 pd=6.7e-07 nrd=1.16667 \
        nrs=1.16667 sa=1.3e-06 sb=1.9e-07 sd=160n sca=11.4452 \
        scb=0.0112553 scc=0.00042156 m=(1)
mn0 (\8\:Gb \1\:G \9\:VSS VSS) g45n1hvt w=(1.45e-07) l=4.5e-08 nf=1 \
        as=3.905e-14 ad=2.03e-14 ps=9e-07 pd=5.7e-07 nrd=1.16667 \
        nrs=1.16667 sa=1.4e-07 sb=3.75e-07 sd=160n sca=11.4452 \
        scb=0.0112553 scc=0.00042156 m=(1)
mn22 (\3\:QN \9\:Qint \9\:VSS VSS) g45n1hvt w=(2.6e-07) l=4.5e-08 nf=1 \
        as=3.905e-14 ad=3.64e-14 ps=9e-07 pd=8e-07 nrd=1.16667 nrs=1.16667 \
        sa=2.53365e-07 sb=1.4e-07 sd=160n sca=17.5885 scb=0.0172826 \
        scc=0.00162584 m=(1)
mn20 (\7\:Qbint \8\:Qint \1\:VSS VSS) g45n1hvt w=(2.6e-07) l=4.5e-08 \
        nf=1 as=4.16e-14 ad=3.64e-14 ps=8.4e-07 pd=8e-07 nrd=1.16667 \
        nrs=1.16667 sa=1.4e-07 sb=3.45e-07 sd=160n sca=17.5885 \
        scb=0.0172826 scc=0.00162584 m=(1)
mn21 (\3\:Q \4\:Qbint \1\:VSS VSS) g45n1hvt w=(2.6e-07) l=4.5e-08 nf=1 \
        as=4.16e-14 ad=3.64e-14 ps=8.4e-07 pd=8e-07 nrd=1.16667 \
        nrs=1.16667 sa=3.45e-07 sb=1.4e-07 sd=160n sca=17.5885 \
        scb=0.0172826 scc=0.00162584 m=(1)
mp22 (\1\:QN \10\:Qint \9\:VDD VDD) g45p1hvt w=(3.9e-07) l=4.5e-08 nf=1 \
        as=8.47e-14 ad=5.46e-14 ps=1.34e-06 pd=1.06e-06 nrd=1.16667 \
        nrs=1.16667 sa=3.46731e-07 sb=1.4e-07 sd=160n sca=13.1056 \
        scb=0.0116857 scc=0.000556045 m=(1)
mp20 (\9\:Qbint \4\:Qint \1\:VDD VDD) g45p1hvt w=(3.9e-07) l=4.5e-08 \
        nf=1 as=6.24e-14 ad=5.46e-14 ps=1.1e-06 pd=1.06e-06 nrd=1.16667 \
        nrs=1.16667 sa=1.4e-07 sb=3.7e-07 sd=160n sca=24.5199 \
        scb=0.0210547 scc=0.00214754 m=(1)
mp21 (\1\:Q Qbint \1\:VDD VDD) g45p1hvt w=(3.9e-07) l=4.5e-08 nf=1 \
        as=6.24e-14 ad=6.435e-14 ps=1.1e-06 pd=1.11e-06 nrd=1.16667 \
        nrs=1.16667 sa=3.45e-07 sb=1.65e-07 sd=160n sca=32.5614 \
        scb=0.033721 scc=0.00305615 m=(1)
ends TLATX1
// End of subcircuit definition.
