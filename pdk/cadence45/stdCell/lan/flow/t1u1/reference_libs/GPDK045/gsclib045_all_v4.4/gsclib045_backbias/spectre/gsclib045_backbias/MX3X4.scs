// gsclib045_backbias/MX3X4/schematic

simulator lang=spectre

subckt MX3X4 A B C S0 S1 Y VDD NW VSS
mn7 (net245 C VSS VSS) g45n1svt w=(260n) l=45n nf=1 m=(1)
mn8 (n1 S1 net245 VSS) g45n1svt w=(260n) l=45n nf=1 m=(1)
mn4 (net234 B VSS VSS) g45n1svt w=(145n) l=45n nf=1 m=(1)
mn5 (n0 S0 net234 VSS) g45n1svt w=(145n) l=45n nf=1 m=(1)
mn3 (n0 S0b net229 VSS) g45n1svt w=(145n) l=45n nf=1 m=(1)
mn2 (net229 A VSS VSS) g45n1svt w=(145n) l=45n nf=1 m=(1)
mn9 (Y n1 VSS VSS) g45n1svt w=(1.04u) l=45n nf=1 m=(1)
mn0 (S0b S0 VSS VSS) g45n1svt w=(145n) l=45n nf=1 m=(1)
mn1 (S1b S1 VSS VSS) g45n1svt w=(145n) l=45n nf=1 m=(1)
mn6 (n1 S1b n0 VSS) g45n1svt w=(260n) l=45n nf=1 m=(1)
mp8 (n1 S1b net202 NW) g45p1svt w=(390n) l=45n nf=1 m=(1)
mp7 (net202 C VDD NW) g45p1svt w=(390n) l=45n nf=1 m=(1)
mp5 (n0 S0b net190 NW) g45p1svt w=(215n) l=45n nf=1 m=(1)
mp4 (net190 B VDD NW) g45p1svt w=(215n) l=45n nf=1 m=(1)
mp3 (n0 S0 net189 NW) g45p1svt w=(215n) l=45n nf=1 m=(1)
mp2 (net189 A VDD NW) g45p1svt w=(215n) l=45n nf=1 m=(1)
mp9 (Y n1 VDD NW) g45p1svt w=(1.56u) l=45n nf=1 m=(1)
mp1 (S1b S1 VDD NW) g45p1svt w=(215n) l=45n nf=1 m=(1)
mp6 (n0 S1 n1 NW) g45p1svt w=(390n) l=45n nf=1 m=(1)
mp0 (S0b S0 VDD NW) g45p1svt w=(215n) l=45n nf=1 m=(1)
ends MX3X4
