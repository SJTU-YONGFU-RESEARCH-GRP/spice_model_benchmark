// Generated for: spectre (May  1 11:28:13 2013 )
// Library name: gsclib045_backbias
// Cell name: CLKBUFX12
// View name: extracted

simulator lang=spectre

subckt CLKBUFX12 A NW VDD VSS Y
mp1_1__rcx (Y net44 VDD NW) g45p1svt w=(4.7e-07) l=4.5e-08 nf=1 \
        as=7.573e-14 ad=7.52e-14 ps=1.266e-06 pd=1.26e-06 nrd=1.16667 \
        nrs=1.16667 sa=1.4e-07 sb=1.99064e-06 sd=160n sca=28.0481 \
        scb=0.031636 scc=0.00223037 m=(10)
C1 (NW VSS) capacitor c=3.59795e-16
C2 (VDD VSS) capacitor c=7.66523e-16
C3 (A VSS) capacitor c=5.11987e-17
C4 (Y VSS) capacitor c=5.25637e-16
C5 (net44 VSS) capacitor c=8.18715e-16
C6 (\1\:A VSS) capacitor c=2.32793e-16
C7 (\31\:net44 VSS) capacitor c=1.39008e-16
C8 (\7\:Y VSS) capacitor c=4.7554e-16
C9 (\10\:A VSS) capacitor c=4.44273e-17
C10 (\34\:net44 VSS) capacitor c=1.08545e-16
Rk19 (A \10\:A) resistor r=0.1302 c=0
Rk5 (Y \7\:Y) resistor r=0.4369 c=0
Rk23 (\34\:net44 net44) resistor r=0.4423 c=0
Rk21 (\31\:net44 \34\:net44) resistor r=0.276 c=0
Rx1 (\10\:A \1\:A) resistor r=45 c=0
mn1_1__rcx (\7\:Y net44 VSS VSS) g45n1svt w=(3.1e-07) l=4.5e-08 nf=1 \
        as=4.998e-14 ad=4.96e-14 ps=9.46e-07 pd=9.4e-07 nrd=1.16667 \
        nrs=1.16667 sa=1.4e-07 sb=1.99113e-06 sd=160n sca=9.61806 \
        scb=0.00827687 scc=0.000298696 m=(10)
mn0_1__rcx (\34\:net44 \1\:A VSS VSS) g45n1svt w=(2.6e-07) l=4.5e-08 \
        nf=1 as=4.76e-14 ad=5.373e-14 ps=9.0667e-07 pd=9.3333e-07 \
        nrd=1.16667 nrs=1.16667 sa=2e-06 sb=6.3e-07 sd=160n sca=10.3222 \
        scb=0.00938145 scc=0.000353946 m=(3)
mp0_1__rcx (\31\:net44 \1\:A VDD NW) g45p1svt w=(3.9e-07) l=4.5e-08 nf=1 \
        as=7.157e-14 ad=8.06e-14 ps=1.18667e-06 pd=1.19333e-06 nrd=1.16667 \
        nrs=1.16667 sa=2e-06 sb=6.3e-07 sd=160n sca=12.7559 scb=0.0106631 \
        scc=0.000333478 m=(3)
ends CLKBUFX12
// End of subcircuit definition.
