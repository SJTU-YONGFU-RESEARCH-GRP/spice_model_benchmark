// gsclib045_lvt/AO21X4/schematic

simulator lang=spectre

subckt AO21X4 A0 A1 B0 Y VDD VSS
mp1 (net88 A1 VDD VDD) g45p1lvt w=(390n) l=45n nf=1 m=(1)
mp0 (net88 A0 VDD VDD) g45p1lvt w=(390n) l=45n nf=1 m=(1)
mp3 (Y net100 VDD VDD) g45p1lvt w=(1.56u) l=45n nf=1 m=(1)
mp2 (net100 B0 net88 VDD) g45p1lvt w=(390n) l=45n nf=1 m=(1)
mn1 (net100 A1 net104 VSS) g45n1lvt w=(260n) l=45n nf=1 m=(1)
mn0 (net104 A0 VSS VSS) g45n1lvt w=(260n) l=45n nf=1 m=(1)
mn3 (Y net100 VSS VSS) g45n1lvt w=(1.04u) l=45n nf=1 m=(1)
mn2 (net100 B0 VSS VSS) g45n1lvt w=(260n) l=45n nf=1 m=(1)
ends AO21X4
