// Generated for: spectre (May  1 11:31:48 2013 )
// Library name: gsclib045_backbias
// Cell name: OAI33X2
// View name: extracted

simulator lang=spectre

subckt OAI33X2 A0 A1 A2 B0 B1 B2 NW VDD VSS Y
mp0_1__rcx (3 \1\:A0 \1\:VDD NW) g45p1svt w=(2.65e-07) l=4.5e-08 nf=1 \
        as=3.71e-14 ad=1.59e-14 ps=8.1e-07 pd=6.5e-07 nrd=1.16667 \
        nrs=1.16667 sa=1.4e-07 sb=1.98151e-06 sd=160n sca=14.2659 \
        scb=0.0126092 scc=0.000180096 m=(1)
mp1_1__rcx (3 \1\:A1 6 NW) g45p1svt w=(2.65e-07) l=4.5e-08 nf=1 \
        as=5.83e-14 ad=1.59e-14 ps=9.7e-07 pd=6.5e-07 nrd=1.16667 \
        nrs=1.16667 sa=2.45e-07 sb=1.97953e-06 sd=160n sca=12.7796 \
        scb=0.0101999 scc=0.00014764 m=(1)
mp2_1__rcx (\8\:Y \1\:A2 6 NW) g45p1svt w=(2.65e-07) l=4.5e-08 nf=1 \
        as=5.83e-14 ad=4.505e-14 ps=9.7e-07 pd=8.7e-07 nrd=1.16667 \
        nrs=1.16667 sa=5.1e-07 sb=1.97453e-06 sd=160n sca=11.1864 \
        scb=0.00858333 scc=0.000141961 m=(1)
mp2_2__rcx (\8\:Y \4\:A2 7 NW) g45p1svt w=(2.65e-07) l=4.5e-08 nf=1 \
        as=3.048e-14 ad=4.505e-14 ps=7.6e-07 pd=8.7e-07 nrd=1.16667 \
        nrs=1.16667 sa=7.25e-07 sb=1.97047e-06 sd=160n sca=10.7335 \
        scb=0.00843468 scc=0.00014192 m=(1)
mp1_2__rcx (7 \6\:A1 4 NW) g45p1svt w=(2.65e-07) l=4.5e-08 nf=1 \
        as=1.59e-14 ad=3.048e-14 ps=6.5e-07 pd=7.6e-07 nrd=1.16667 \
        nrs=1.16667 sa=8.85e-07 sb=1.96745e-06 sd=160n sca=10.7335 \
        scb=0.00843468 scc=0.00014192 m=(1)
mp0_2__rcx (4 \8\:A0 \5\:VDD NW) g45p1svt w=(2.65e-07) l=4.5e-08 nf=1 \
        as=6.525e-14 ad=1.59e-14 ps=1.09e-06 pd=6.5e-07 nrd=1.16667 \
        nrs=1.16667 sa=9.9e-07 sb=1.96547e-06 sd=160n sca=10.7335 \
        scb=0.00843468 scc=0.00014192 m=(1)
mp5_1__rcx (\6\:Y \1\:B2 5 NW) g45p1svt w=(2.65e-07) l=4.5e-08 nf=1 \
        as=1.59e-14 ad=7.85e-14 ps=6.5e-07 pd=1.13e-06 nrd=1.16667 \
        nrs=1.16667 sa=1.96415e-06 sb=1.58406e-06 sd=160n sca=10.7335 \
        scb=0.00843468 scc=0.00014192 m=(1)
mp3_1__rcx (5 \4\:B1 10 NW) g45p1svt w=(2.65e-07) l=4.5e-08 nf=1 \
        as=4.373e-14 ad=1.59e-14 ps=8.6e-07 pd=6.5e-07 nrd=1.16667 \
        nrs=1.16667 sa=1.96613e-06 sb=1.47906e-06 sd=160n sca=10.7335 \
        scb=0.00843468 scc=0.00014192 m=(1)
mp4_1__rcx (\8\:VDD \1\:B0 10 NW) g45p1svt w=(2.65e-07) l=4.5e-08 nf=1 \
        as=4.373e-14 ad=6.55e-14 ps=8.6e-07 pd=1.09e-06 nrd=1.16667 \
        nrs=1.16667 sa=1.97009e-06 sb=1.26906e-06 sd=160n sca=10.7335 \
        scb=0.00843468 scc=0.00014192 m=(1)
mp4_2__rcx (\8\:VDD \4\:B0 12 NW) g45p1svt w=(2.65e-07) l=4.5e-08 nf=1 \
        as=3.313e-14 ad=6.55e-14 ps=7.8e-07 pd=1.09e-06 nrd=1.16667 \
        nrs=1.16667 sa=1.97509e-06 sb=1.00406e-06 sd=160n sca=10.7335 \
        scb=0.00843468 scc=0.00014192 m=(1)
mp3_2__rcx (12 \5\:B1 11 NW) g45p1svt w=(2.65e-07) l=4.5e-08 nf=1 \
        as=3.18e-14 ad=3.313e-14 ps=7.7e-07 pd=7.8e-07 nrd=1.16667 \
        nrs=1.16667 sa=1.9783e-06 sb=8.34057e-07 sd=160n sca=10.7335 \
        scb=0.00843468 scc=0.00014192 m=(1)
mp5_2__rcx (\1\:Y \6\:B2 11 NW) g45p1svt w=(2.65e-07) l=4.5e-08 nf=1 \
        as=3.18e-14 ad=4.47e-14 ps=7.7e-07 pd=8.7e-07 nrd=1.16667 \
        nrs=1.16667 sa=1.98142e-06 sb=6.69057e-07 sd=160n sca=10.7821 \
        scb=0.00844411 scc=0.000141921 m=(1)
C1 (A0 VSS) capacitor c=4.87793e-16
C2 (B2 VSS) capacitor c=2.47601e-17
C3 (B0 VSS) capacitor c=5.58594e-16
C4 (VDD VSS) capacitor c=3.09599e-17
C5 (A2 VSS) capacitor c=5.50424e-16
C6 (NW VSS) capacitor c=6.69899e-16
C7 (A1 VSS) capacitor c=6.47088e-16
C8 (Y VSS) capacitor c=2.91182e-17
C9 (B1 VSS) capacitor c=2.45554e-17
C10 (n0 VSS) capacitor c=7.27792e-16
C11 (7 VSS) capacitor c=3.54575e-18
C12 (4 VSS) capacitor c=1.84995e-18
C13 (8 VSS) capacitor c=1.19208e-17
C14 (9 VSS) capacitor c=6.08751e-18
C15 (5 VSS) capacitor c=2.1945e-18
C16 (10 VSS) capacitor c=5.0251e-18
C17 (12 VSS) capacitor c=3.60968e-18
C18 (11 VSS) capacitor c=3.62862e-18
C19 (14 VSS) capacitor c=3.47743e-18
C20 (15 VSS) capacitor c=2.72147e-18
C21 (\9\:B0 VSS) capacitor c=4.13399e-17
C22 (\10\:B1 VSS) capacitor c=6.74207e-17
C23 (\9\:B2 VSS) capacitor c=4.85975e-17
C24 (\6\:B2 VSS) capacitor c=4.7128e-17
C25 (\5\:B1 VSS) capacitor c=5.87322e-17
C26 (\4\:B0 VSS) capacitor c=3.18852e-17
C27 (\1\:B0 VSS) capacitor c=2.53622e-17
C28 (\4\:B1 VSS) capacitor c=6.08727e-17
C29 (\1\:B2 VSS) capacitor c=8.84814e-17
C30 (\7\:A2 VSS) capacitor c=3.77539e-17
C31 (\7\:A1 VSS) capacitor c=3.83779e-17
C32 (\10\:A0 VSS) capacitor c=2.329e-17
C33 (\8\:A0 VSS) capacitor c=7.35364e-17
C34 (\6\:A1 VSS) capacitor c=8.66331e-17
C35 (\4\:A2 VSS) capacitor c=2.99952e-17
C36 (\1\:A2 VSS) capacitor c=2.0173e-17
C37 (\1\:A1 VSS) capacitor c=7.07638e-17
C38 (\1\:A0 VSS) capacitor c=8.25206e-17
C39 (\1\:B1 VSS) capacitor c=6.98896e-16
C40 (\2\:B2 VSS) capacitor c=5.61302e-16
C41 (\10\:VDD VSS) capacitor c=1.28896e-16
C42 (\1\:Y VSS) capacitor c=2.01504e-16
C43 (\8\:VDD VSS) capacitor c=3.42304e-17
C44 (\6\:Y VSS) capacitor c=1.69865e-16
C45 (\5\:VDD VSS) capacitor c=3.9481e-17
C46 (\8\:Y VSS) capacitor c=1.27687e-16
C47 (\1\:VDD VSS) capacitor c=1.60868e-17
C48 (\7\:A0 VSS) capacitor c=3.22721e-17
C49 (\3\:Y VSS) capacitor c=4.68651e-16
C50 (\3\:VDD VSS) capacitor c=6.37706e-17
C51 (\4\:VDD VSS) capacitor c=1.38225e-16
C52 (\7\:VDD VSS) capacitor c=1.53366e-16
Rk11 (\2\:B2 B2) resistor r=0.08585 c=0
Rk54 (\3\:VSS VSS) resistor r=0.05469 c=0
Rk48 (\2\:VSS \3\:VSS) resistor r=0.6815 c=0
Rk42 (\3\:VDD VDD) resistor r=0.1048 c=0
Rk41 (\2\:VDD \3\:VDD) resistor r=0.2263 c=0
Rk43 (\3\:VDD \4\:VDD) resistor r=0.5284 c=0
Rk44 (\4\:VDD \6\:VDD) resistor r=0.1818 c=0
Rk45 (\4\:VDD \7\:VDD) resistor r=0.8016 c=0
Rk46 (\7\:VDD \9\:VDD) resistor r=0.1818 c=0
Rk47 (\7\:VDD \11\:VDD) resistor r=0.7493 c=0
Rk40 (\3\:Y Y) resistor r=0.01995 c=0
Rk29 (\2\:Y \3\:Y) resistor r=0.8504 c=0
Rk31 (\2\:Y \7\:Y) resistor r=0.9077 c=0
Rk32 (\7\:Y \9\:Y) resistor r=1.0469 c=0
Rk14 (\1\:B1 B1) resistor r=0.0584 c=0
Rl1 (A0 \1\:A0) resistor r=159.411 c=0
Rl13 (\7\:A0 A0) resistor r=119.604 c=0
Rl16 (\7\:A0 \10\:A0) resistor r=49.9779 c=0
Rl14 (\7\:A0 \8\:A0) resistor r=105.747 c=0
Rl36 (\2\:B2 \9\:B2) resistor r=145.949 c=0
Rl34 (\2\:B2 \6\:B2) resistor r=149.176 c=0
Rl22 (\2\:B2 \1\:B2) resistor r=144.026 c=0
Rl40 (B0 \9\:B0) resistor r=34.4104 c=0
Rl29 (B0 \4\:B0) resistor r=24.2328 c=0
Rl27 (B0 \1\:B0) resistor r=24.2328 c=0
Rl20 (A2 \7\:A2) resistor r=29.5379 c=0
Rl7 (A2 \4\:A2) resistor r=29.5379 c=0
Rl5 (A2 \1\:A2) resistor r=29.5379 c=0
Rl17 (A1 \7\:A1) resistor r=106.572 c=0
Rl10 (A1 \6\:A1) resistor r=94.0258 c=0
Rl3 (A1 \1\:A1) resistor r=98.7687 c=0
Rl38 (\1\:B1 \10\:B1) resistor r=84.4104 c=0
Rl31 (\1\:B1 \5\:B1) resistor r=87.2302 c=0
Rl26 (\1\:B1 \4\:B1) resistor r=54.6488 c=0
Ry8 (\2\:VSS \1\:VSS) resistor r=6.2 c=0
Ry9 (\3\:VSS \1\:VSS) resistor r=5.1667 c=0
Ry4 (\1\:VDD \2\:VDD) resistor r=62 c=0
Ry5 (\5\:VDD \6\:VDD) resistor r=62 c=0
Ry6 (\8\:VDD \9\:VDD) resistor r=62 c=0
Ry7 (\10\:VDD \11\:VDD) resistor r=62 c=0
Ry1 (\2\:Y \1\:Y) resistor r=62 c=0
Ry2 (\7\:Y \6\:Y) resistor r=62 c=0
Ry3 (\9\:Y \8\:Y) resistor r=62 c=0
mn0_1__rcx (n0 A0 \3\:VSS VSS) g45n1svt w=(1.75e-07) l=4.5e-08 nf=1 \
        as=3.438e-14 ad=2.8e-14 ps=7.6e-07 pd=6.7e-07 nrd=1.16667 \
        nrs=1.16667 sa=1.4e-07 sb=1.98071e-06 sd=160n sca=9.07807 \
        scb=0.007472 scc=0.000167841 m=(2)
mn1 (n0 A1 \3\:VSS VSS) g45n1svt w=(1.75e-07) l=4.5e-08 nf=1 as=4.45e-14 \
        ad=2.8e-14 ps=8.9e-07 pd=6.7e-07 nrd=1.16667 nrs=1.16667 \
        sa=3.45e-07 sb=1.97486e-06 sd=160n sca=9.07807 scb=0.007472 \
        scc=0.000167841 m=(2)
mn2_1__rcx (n0 A2 \3\:VSS VSS) g45n1svt w=(1.75e-07) l=4.5e-08 nf=1 \
        as=4.45e-14 ad=2.975e-14 ps=8.9e-07 pd=6.9e-07 nrd=1.16667 \
        nrs=1.16667 sa=6.1e-07 sb=1.96729e-06 sd=160n sca=9.07807 \
        scb=0.007472 scc=0.000167841 m=(2)
mn5 (\3\:Y \2\:B2 n0 VSS) g45n1svt w=(1.75e-07) l=4.5e-08 nf=1 \
        as=3.11e-14 ad=3.063e-14 ps=7.1e-07 pd=7e-07 nrd=1.16667 \
        nrs=1.16667 sa=1.94571e-06 sb=1.85043e-06 sd=160n sca=9.24372 \
        scb=0.00774894 scc=0.000182948 m=(2)
mn3_1__rcx (\3\:Y \1\:B1 n0 VSS) g45n1svt w=(1.75e-07) l=4.5e-08 nf=1 \
        as=2.844e-14 ad=3.063e-14 ps=6.75e-07 pd=7e-07 nrd=1.16667 \
        nrs=1.16667 sa=1.952e-06 sb=1.63043e-06 sd=160n sca=9.24372 \
        scb=0.00774894 scc=0.000182948 m=(2)
mn4_1__rcx (\3\:Y B0 n0 VSS) g45n1svt w=(1.75e-07) l=4.5e-08 nf=1 \
        as=2.844e-14 ad=3.238e-14 ps=6.75e-07 pd=7.2e-07 nrd=1.16667 \
        nrs=1.16667 sa=1.958e-06 sb=1.42043e-06 sd=160n sca=9.24372 \
        scb=0.00774894 scc=0.000182948 m=(2)
mn0_2__rcx (n0 A0 \3\:VSS VSS) g45n1svt w=(1.7e-07) l=4.5e-08 nf=1 \
        as=4.425e-14 ad=2.72e-14 ps=8.9e-07 pd=6.6e-07 nrd=1.16667 \
        nrs=1.16667 sa=1.56e-06 sb=1.99662e-06 sd=160n sca=9.14613 \
        scb=0.00758408 scc=0.000172013 m=(1)
mn1_2__rcx (n0 A1 \3\:VSS VSS) g45n1svt w=(1.7e-07) l=4.5e-08 nf=1 \
        as=4.4e-14 ad=2.72e-14 ps=8.9e-07 pd=6.6e-07 nrd=1.16667 \
        nrs=1.16667 sa=1.765e-06 sb=1.99059e-06 sd=160n sca=9.14613 \
        scb=0.00758408 scc=0.000172013 m=(1)
mn2_2__rcx (n0 A2 \3\:VSS VSS) g45n1svt w=(1.7e-07) l=4.5e-08 nf=1 \
        as=4.4e-14 ad=3.195e-14 ps=8.9e-07 pd=7.2e-07 nrd=1.16667 \
        nrs=1.16667 sa=2e-06 sb=1.98279e-06 sd=160n sca=9.14613 \
        scb=0.00758408 scc=0.000172013 m=(1)
mn5_2__rcx (\3\:Y \2\:B2 n0 VSS) g45n1svt w=(1.7e-07) l=4.5e-08 nf=1 \
        as=3.025e-14 ad=2.975e-14 ps=7e-07 pd=6.9e-07 nrd=1.16667 \
        nrs=1.16667 sa=1.9825e-06 sb=5.65e-07 sd=160n sca=9.31415 \
        scb=0.0078649 scc=0.000187493 m=(1)
mn3 (\3\:Y \1\:B1 n0 VSS) g45n1svt w=(1.7e-07) l=4.5e-08 nf=1 as=2.72e-14 \
        ad=2.975e-14 ps=6.6e-07 pd=6.9e-07 nrd=1.16667 nrs=1.16667 \
        sa=1.98897e-06 sb=3.45e-07 sd=160n sca=9.31415 scb=0.0078649 \
        scc=0.000187493 m=(1)
mn4_2__rcx (\3\:Y B0 n0 VSS) g45n1svt w=(1.7e-07) l=4.5e-08 nf=1 \
        as=2.72e-14 ad=2.38e-14 ps=6.6e-07 pd=6.2e-07 nrd=1.16667 \
        nrs=1.16667 sa=1.995e-06 sb=1.4e-07 sd=160n sca=9.31415 \
        scb=0.0078649 scc=0.000187493 m=(1)
mp0 (8 \10\:A0 \5\:VDD NW) g45p1svt w=(2.6e-07) l=4.5e-08 nf=1 \
        as=6.525e-14 ad=9.49e-14 ps=1.09e-06 pd=1.25e-06 nrd=1.16667 \
        nrs=1.16667 sa=1.255e-06 sb=2e-06 sd=160n sca=10.7426 \
        scb=0.0084509 scc=0.000143085 m=(1)
mp1 (8 \7\:A1 9 NW) g45p1svt w=(2.6e-07) l=4.5e-08 nf=1 as=5.72e-14 \
        ad=9.49e-14 ps=9.6e-07 pd=1.25e-06 nrd=1.16667 nrs=1.16667 \
        sa=1.665e-06 sb=1.99279e-06 sd=160n sca=10.7426 scb=0.0084509 \
        scc=0.000143085 m=(1)
mp2 (\6\:Y \7\:A2 9 NW) g45p1svt w=(2.6e-07) l=4.5e-08 nf=1 as=5.72e-14 \
        ad=7.85e-14 ps=9.6e-07 pd=1.13e-06 nrd=1.16667 nrs=1.16667 \
        sa=1.93e-06 sb=1.92885e-06 sd=160n sca=10.7426 scb=0.0084509 \
        scc=0.000143085 m=(1)
mp5 (\1\:Y \9\:B2 14 NW) g45p1svt w=(2.6e-07) l=4.5e-08 nf=1 as=2.99e-14 \
        ad=4.47e-14 ps=7.5e-07 pd=8.7e-07 nrd=1.16667 nrs=1.16667 \
        sa=1.98519e-06 sb=4.65e-07 sd=160n sca=11.3498 scb=0.00860452 \
        scc=0.000134096 m=(1)
mp3 (14 \10\:B1 15 NW) g45p1svt w=(2.6e-07) l=4.5e-08 nf=1 as=2.34e-14 \
        ad=2.99e-14 ps=7e-07 pd=7.5e-07 nrd=1.16667 nrs=1.16667 \
        sa=1.98827e-06 sb=3.05e-07 sd=160n sca=12.2993 scb=0.00952904 \
        scc=0.000136475 m=(1)
mp4 (\10\:VDD \9\:B0 15 NW) g45p1svt w=(2.6e-07) l=4.5e-08 nf=1 \
        as=2.34e-14 ad=5.14e-14 ps=7e-07 pd=9.8e-07 nrd=1.16667 \
        nrs=1.16667 sa=1.99087e-06 sb=1.7e-07 sd=160n sca=13.932 \
        scb=0.0120305 scc=0.000163154 m=(1)
ends OAI33X2
// End of subcircuit definition.
