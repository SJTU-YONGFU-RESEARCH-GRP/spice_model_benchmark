// gsclib045_hvt/MXI2X8/schematic

simulator lang=spectre

subckt MXI2X8 A B S0 Y VSS VDD
mp4 (n0 S0b n6 VDD) g45p1hvt w=(215n) l=45n nf=1 m=(1)
mp3 (n6 B VDD VDD) g45p1hvt w=(215n) l=45n nf=1 m=(1)
mp2 (n0 S0 n4 VDD) g45p1hvt w=(215n) l=45n nf=1 m=(1)
mp1 (n4 A VDD VDD) g45p1hvt w=(215n) l=45n nf=1 m=(1)
mp6 (Y n1 VDD VDD) g45p1hvt w=(3.115u) l=45n nf=1 m=(1)
mp5 (n1 n0 VDD VDD) g45p1hvt w=(780n) l=45n nf=1 m=(1)
mp0 (S0b S0 VDD VDD) g45p1hvt w=(215n) l=45n nf=1 m=(1)
mn3 (n5 B VSS VSS) g45n1hvt w=(145n) l=45n nf=1 m=(1)
mn4 (n0 S0 n5 VSS) g45n1hvt w=(145n) l=45n nf=1 m=(1)
mn2 (n0 S0b n3 VSS) g45n1hvt w=(145n) l=45n nf=1 m=(1)
mn1 (n3 A VSS VSS) g45n1hvt w=(145n) l=45n nf=1 m=(1)
mn5 (n1 n0 VSS VSS) g45n1hvt w=(520n) l=45n nf=1 m=(1)
mn6 (Y n1 VSS VSS) g45n1hvt w=(2.065u) l=45n nf=1 m=(1)
mn0 (S0b S0 VSS VSS) g45n1hvt w=(145n) l=45n nf=1 m=(1)
ends MXI2X8
