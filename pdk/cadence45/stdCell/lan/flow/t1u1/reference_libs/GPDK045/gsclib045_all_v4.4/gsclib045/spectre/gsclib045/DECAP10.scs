// Generated for: spectre (Sep 25 11:22:06 2014 )
// Library name: gsclib045
// Cell name: DECAP10
// View name: schematic

simulator lang=spectre

subckt DECAP10 VDD VSS
mp0 (VDD VSS VDD VDD) g45p1svt w=(550n) l=1.64u nf=1 as=77f ad=77f \
        ps=1.38u pd=1.38u nrd=254.545m nrs=254.545m sa=140n sb=140n \
        sd=160n sca=66.54957 scb=0.04397 scc=0.00674 m=(1)
mn0 (VSS VDD VSS VSS) g45n1svt w=(400n) l=1.64u nf=1 as=56f ad=56f \
        ps=1.08u pd=1.08u nrd=350m nrs=350m sa=140n sb=140n sd=160n \
        sca=84.36853 scb=0.05371 scc=0.00899 m=(1)
ends DECAP10
// End of subcircuit definition.
