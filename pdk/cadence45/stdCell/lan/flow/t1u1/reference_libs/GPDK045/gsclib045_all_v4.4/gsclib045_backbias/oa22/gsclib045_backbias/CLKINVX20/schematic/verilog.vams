// Verilog-AMS netlist generated by the AMS netlister, version  ICADV12.1-64b.341 .
// Cadence Design Systems, Inc.

`include "disciplines.vams"

(* cds_ams_schematic *)
module CLKINVX20 ( Y,.VDD(\VDD! ),A,.NW(\NW! ),
.VSS(\VSS! ) );

output   Y;
input  (*
integer inh_conn_prop_name = "VDD";
integer
inh_conn_def_value = "cds_globals.\\VDD! ";
 *)
 \VDD! ;
input   A;

input  (*
integer inh_conn_prop_name = "NW";
integer
inh_conn_def_value = "cds_globals.\\NW! ";
integer supplySensitivity
 = "VDD";
 *)
 \NW! ;
input  (*
integer inh_conn_prop_name = "VSS";

integer inh_conn_def_value = "cds_globals.\\VSS! ";
 *)
 \VSS! ;

wire Y;
wire (*
integer inh_conn_prop_name = "VSS";
integer inh_conn_def_value
 = "cds_globals.\\VSS! ";
 *)
\VSS! ;
wire A;
wire (*
integer inh_conn_prop_name = "VDD";
integer inh_conn_def_value
 = "cds_globals.\\VDD! ";
 *)
\VDD! ;

g45p1svt #(.ad(1.0941p), .nrd(17.9143m), .sca(45.04913), .pd(15.91u),
.scc(0.00572), .scb(0.05038), .as(1.0941p), .nrs(17.9143m), .m(1), .ps(15.91u),
 .w(7.815u), .sa(140n), .nf(1), .sb(140n), .sd(160n), .l(45n)) (*

integer library_binding = "gpdk045";
integer passed_mfactor = "m";

 *)
mp0 ( Y, A, \VDD! , \NW!  );

g45n1svt #(.ad(725.9f), .nrd(27.001m), .sca(47.17159), .pd(10.65u), .scc(0.00593),
 .scb(0.05152), .as(725.9f), .nrs(27.001m), .m(1), .ps(10.65u), .w(5.185u),
 .sa(140n), .nf(1), .sb(140n), .sd(160n), .l(45n)) (*
integer
library_binding = "gpdk045";
integer passed_mfactor = "m";
 *)
mn0 ( Y,
A, \VSS! , \VSS!  );

endmodule
