// Generated for: spectre (May  1 08:13:00 2013 )
// Library name: gsclib045
// Cell name: DFF2X2
// View name: extracted

simulator lang=spectre

subckt DFF2X2 CK D1 D2 Q1 Q1N Q2 Q2N VDD VSS
mp55 (\3\:Q1 qbint \17\:VDD VDD) g45p1svt w=(3.9e-07) l=4.5e-08 nf=1 \
        as=6.688e-14 ad=6.869e-14 ps=1.455e-06 pd=1.47e-06 nrd=1.16667 \
        nrs=1.16667 sa=1.03654e-07 sb=3.15e-07 sd=160n sca=30.5009 \
        scb=0.0202006 scc=0.00336097 m=(2)
PM17_1__rcx (\3\:Q2 \7\:qbint_2 \6\:VDD VDD) g45p1svt w=(3.9e-07) \
        l=4.5e-08 nf=1 as=6.688e-14 ad=6.869e-14 ps=1.455e-06 pd=1.47e-06 \
        nrd=1.16667 nrs=1.16667 sa=1.03654e-07 sb=3.15e-07 sd=160n \
        sca=30.5009 scb=0.0202006 scc=0.00336097 m=(2)
mp57 (\1\:Q1N qint \20\:VDD VDD) g45p1svt w=(3.9e-07) l=4.5e-08 nf=1 \
        as=8.348e-14 ad=6.24e-14 ps=1.85e-06 pd=1.1e-06 nrd=1.16667 \
        nrs=1.16667 sa=4.54551e-07 sb=1.2e-07 sd=160n sca=39.514 \
        scb=0.0334743 scc=0.00392846 m=(2)
PM19 (\4\:Q2N qint_2 \1\:VDD VDD) g45p1svt w=(3.9e-07) l=4.5e-08 nf=1 \
        as=8.348e-14 ad=6.24e-14 ps=1.85e-06 pd=1.1e-06 nrd=1.16667 \
        nrs=1.16667 sa=4.54551e-07 sb=1.2e-07 sd=160n sca=39.514 \
        scb=0.0334743 scc=0.00392846 m=(2)
C1 (Q1N VSS) capacitor c=4.06759e-17
C2 (Q2N VSS) capacitor c=2.12734e-17
C3 (Q2 VSS) capacitor c=5.01617e-17
C4 (VDD VSS) capacitor c=5.55057e-16
C5 (Q1 VSS) capacitor c=5.12199e-17
C6 (CK VSS) capacitor c=4.65325e-17
C7 (D1 VSS) capacitor c=4.31263e-17
C8 (CKb VSS) capacitor c=2.59997e-17
C9 (Ckbb VSS) capacitor c=5.34612e-17
C10 (qint VSS) capacitor c=1.44395e-16
C11 (qbint VSS) capacitor c=1.10646e-16
C12 (n8 VSS) capacitor c=2.18955e-18
C13 (n30 VSS) capacitor c=5.06612e-17
C14 (mout VSS) capacitor c=5.68316e-17
C15 (n20 VSS) capacitor c=2.65732e-17
C16 (n6 VSS) capacitor c=5.22432e-19
C17 (Db VSS) capacitor c=9.25629e-17
C18 (n11 VSS) capacitor c=1.91055e-18
C19 (n5 VSS) capacitor c=1.66244e-18
C20 (qint_2 VSS) capacitor c=1.43238e-16
C21 (qbint_2 VSS) capacitor c=2.59268e-17
C22 (n8_2 VSS) capacitor c=2.1296e-18
C23 (n30_2 VSS) capacitor c=5.06166e-17
C24 (mout_2 VSS) capacitor c=8.72781e-17
C25 (n20_2 VSS) capacitor c=4.06729e-17
C26 (n6_2 VSS) capacitor c=5.1413e-19
C27 (Db_2 VSS) capacitor c=9.22704e-17
C28 (n11_2 VSS) capacitor c=1.9105e-18
C29 (n5_2 VSS) capacitor c=1.66244e-18
C30 (\5\:qbint_2 VSS) capacitor c=3.61538e-17
C31 (\4\:qbint_2 VSS) capacitor c=6.53431e-17
C32 (\13\:Ckbb VSS) capacitor c=4.62497e-17
C33 (\18\:CKb VSS) capacitor c=2.63962e-17
C34 (\14\:CKb VSS) capacitor c=5.79244e-17
C35 (\10\:Ckbb VSS) capacitor c=6.38844e-17
C36 (\1\:D2 VSS) capacitor c=2.57587e-17
C37 (\1\:CK VSS) capacitor c=3.95465e-17
C38 (\11\:CKb VSS) capacitor c=3.4152e-17
C39 (\4\:D1 VSS) capacitor c=2.62143e-17
C40 (\5\:Ckbb VSS) capacitor c=6.39038e-17
C41 (\4\:CKb VSS) capacitor c=5.81525e-17
C42 (\4\:mout VSS) capacitor c=8.81865e-17
C43 (\4\:n20 VSS) capacitor c=3.98711e-17
C44 (\2\:Ckbb VSS) capacitor c=4.66435e-17
C45 (\10\:qbint VSS) capacitor c=6.52687e-17
C46 (\9\:qbint VSS) capacitor c=3.60137e-17
C47 (\9\:qbint_2 VSS) capacitor c=2.60087e-17
C48 (\3\:n30_2 VSS) capacitor c=5.34485e-17
C49 (\3\:qbint_2 VSS) capacitor c=4.45915e-17
C50 (\16\:CKb VSS) capacitor c=8.39064e-17
C51 (\11\:Ckbb VSS) capacitor c=3.97624e-17
C52 (\4\:n20_2 VSS) capacitor c=4.61473e-17
C53 (\3\:mout_2 VSS) capacitor c=5.70409e-17
C54 (\9\:Ckbb VSS) capacitor c=6.38392e-17
C55 (\12\:CKb VSS) capacitor c=3.45131e-17
C56 (\4\:D2 VSS) capacitor c=4.04651e-17
C57 (\3\:CK VSS) capacitor c=4.24326e-17
C58 (\10\:CKb VSS) capacitor c=3.02908e-17
C59 (\3\:D1 VSS) capacitor c=3.69734e-17
C60 (\6\:CKb VSS) capacitor c=3.49679e-17
C61 (\6\:Ckbb VSS) capacitor c=6.42404e-17
C62 (\3\:n20 VSS) capacitor c=4.54287e-17
C63 (\3\:Ckbb VSS) capacitor c=3.97195e-17
C64 (\3\:CKb VSS) capacitor c=8.3037e-17
C65 (\13\:qbint VSS) capacitor c=4.43965e-17
C66 (\3\:n30 VSS) capacitor c=5.30727e-17
C67 (\7\:qbint VSS) capacitor c=2.61776e-17
C68 (\2\:n30_2 VSS) capacitor c=4.63317e-17
C69 (\14\:Ckbb VSS) capacitor c=5.35955e-17
C70 (\12\:Ckbb VSS) capacitor c=2.07913e-17
C71 (\17\:CKb VSS) capacitor c=7.58059e-17
C72 (\3\:n20_2 VSS) capacitor c=2.62699e-17
C73 (\4\:mout_2 VSS) capacitor c=2.48223e-17
C74 (\15\:CKb VSS) capacitor c=2.78777e-17
C75 (\8\:Ckbb VSS) capacitor c=3.33048e-17
C76 (\13\:CKb VSS) capacitor c=3.39366e-17
C77 (\3\:D2 VSS) capacitor c=1.77717e-17
C78 (\2\:CK VSS) capacitor c=3.43861e-17
C79 (\8\:CKb VSS) capacitor c=2.04394e-17
C80 (\1\:D1 VSS) capacitor c=1.78488e-17
C81 (\7\:CKb VSS) capacitor c=3.41151e-17
C82 (\7\:Ckbb VSS) capacitor c=3.29873e-17
C83 (\5\:CKb VSS) capacitor c=2.80275e-17
C84 (\3\:mout VSS) capacitor c=2.48297e-17
C85 (\2\:CKb VSS) capacitor c=7.61125e-17
C86 (\4\:Ckbb VSS) capacitor c=2.08044e-17
C87 (\12\:qbint VSS) capacitor c=2.55507e-17
C88 (\2\:n30 VSS) capacitor c=4.62395e-17
C89 (\1\:VDD VSS) capacitor c=8.87076e-18
C90 (\4\:Q2N VSS) capacitor c=3.17883e-19
C91 (\7\:qint_2 VSS) capacitor c=2.35461e-17
C92 (\3\:Q2 VSS) capacitor c=4.54093e-17
C93 (\18\:qbint_2 VSS) capacitor c=4.37657e-17
C94 (\29\:VDD VSS) capacitor c=6.04497e-18
C95 (\6\:n30_2 VSS) capacitor c=4.90322e-17
C96 (\5\:mout_2 VSS) capacitor c=6.81685e-17
C97 (\31\:VDD VSS) capacitor c=3.04045e-17
C98 (\5\:n20_2 VSS) capacitor c=3.7517e-17
C99 (\33\:VDD VSS) capacitor c=3.51506e-17
C100 (\32\:CKb VSS) capacitor c=3.621e-17
C101 (\35\:VDD VSS) capacitor c=3.84067e-17
C102 (\24\:Ckbb VSS) capacitor c=1.1666e-16
C103 (\37\:VDD VSS) capacitor c=3.49503e-17
C104 (\9\:n20 VSS) capacitor c=3.83518e-17
C105 (\39\:VDD VSS) capacitor c=3.04045e-17
C106 (\9\:mout VSS) capacitor c=6.85466e-17
C107 (\4\:n30 VSS) capacitor c=4.93798e-17
C108 (\41\:VDD VSS) capacitor c=6.14058e-18
C109 (\14\:qbint VSS) capacitor c=4.35449e-17
C110 (\3\:Q1 VSS) capacitor c=4.58825e-17
C111 (\7\:qint VSS) capacitor c=2.27572e-17
C112 (\1\:Q1N VSS) capacitor c=4.16868e-17
C113 (\3\:VDD VSS) capacitor c=6.44605e-17
C114 (\2\:Q2N VSS) capacitor c=1.53861e-17
C115 (\10\:qint_2 VSS) capacitor c=1.92873e-17
C116 (\1\:Q2 VSS) capacitor c=7.00878e-17
C117 (\20\:qbint_2 VSS) capacitor c=2.56589e-17
C118 (\8\:n30_2 VSS) capacitor c=5.9967e-17
C119 (\9\:mout_2 VSS) capacitor c=4.71872e-17
C120 (\8\:n20_2 VSS) capacitor c=5.62778e-17
C121 (\3\:Db_2 VSS) capacitor c=7.75216e-17
C122 (\29\:CKb VSS) capacitor c=4.62663e-17
C123 (\22\:Ckbb VSS) capacitor c=4.08686e-17
C124 (\3\:Db VSS) capacitor c=7.59384e-17
C125 (\5\:n20 VSS) capacitor c=5.71158e-17
C126 (\7\:mout VSS) capacitor c=4.70334e-17
C127 (\8\:n30 VSS) capacitor c=5.86733e-17
C128 (\19\:qbint VSS) capacitor c=2.56589e-17
C129 (\1\:Q1 VSS) capacitor c=7.05707e-17
C130 (\11\:qint VSS) capacitor c=1.92387e-17
C131 (\3\:Q1N VSS) capacitor c=1.5297e-17
C132 (\6\:qbint VSS) capacitor c=2.74617e-17
C133 (\11\:qbint VSS) capacitor c=4.19112e-17
C134 (\2\:n20 VSS) capacitor c=3.65493e-17
C135 (\2\:mout VSS) capacitor c=4.51139e-17
C136 (\2\:D1 VSS) capacitor c=1.85123e-17
C137 (\9\:CKb VSS) capacitor c=1.38364e-17
C138 (\2\:D2 VSS) capacitor c=1.95166e-17
C139 (\2\:mout_2 VSS) capacitor c=4.46851e-17
C140 (\2\:n20_2 VSS) capacitor c=3.58959e-17
C141 (\9\:qint VSS) capacitor c=2.59701e-17
C142 (\10\:qint VSS) capacitor c=3.61402e-17
C143 (\2\:qbint_2 VSS) capacitor c=4.2911e-17
C144 (\17\:qbint VSS) capacitor c=5.26542e-17
C145 (\18\:qbint VSS) capacitor c=4.78865e-17
C146 (\21\:qbint VSS) capacitor c=4.7699e-17
C147 (\6\:n30 VSS) capacitor c=7.30324e-17
C148 (\7\:n30 VSS) capacitor c=4.3111e-17
C149 (\6\:qbint_2 VSS) capacitor c=2.79939e-17
C150 (\7\:qbint_2 VSS) capacitor c=1.12643e-16
C151 (\5\:mout VSS) capacitor c=3.90896e-17
C152 (\6\:mout VSS) capacitor c=6.90776e-17
C153 (\7\:n20 VSS) capacitor c=4.97755e-17
C154 (\8\:n20 VSS) capacitor c=4.43047e-17
C155 (\6\:D1 VSS) capacitor c=5.19289e-17
C156 (\5\:CK VSS) capacitor c=4.45014e-17
C157 (\5\:D2 VSS) capacitor c=4.12827e-17
C158 (\7\:D2 VSS) capacitor c=3.83902e-17
C159 (\7\:n20_2 VSS) capacitor c=4.97795e-17
C160 (\10\:n20_2 VSS) capacitor c=4.43508e-17
C161 (\7\:mout_2 VSS) capacitor c=6.90755e-17
C162 (\8\:mout_2 VSS) capacitor c=3.91202e-17
C163 (\19\:CKb VSS) capacitor c=1.57269e-16
C164 (\20\:CKb VSS) capacitor c=1.00522e-16
C165 (\21\:CKb VSS) capacitor c=1.42587e-16
C166 (\22\:CKb VSS) capacitor c=1.31079e-16
C167 (\23\:CKb VSS) capacitor c=1.25647e-16
C168 (\24\:CKb VSS) capacitor c=1.00266e-16
C169 (\25\:CKb VSS) capacitor c=1.57659e-16
C170 (\26\:CKb VSS) capacitor c=8.70632e-17
C171 (\27\:CKb VSS) capacitor c=5.7458e-17
C172 (\28\:CKb VSS) capacitor c=1.01216e-16
C173 (\31\:CKb VSS) capacitor c=8.69024e-17
C174 (\15\:Ckbb VSS) capacitor c=1.2178e-16
C175 (\16\:Ckbb VSS) capacitor c=1.42872e-16
C176 (\17\:Ckbb VSS) capacitor c=1.74135e-16
C177 (\18\:Ckbb VSS) capacitor c=1.65051e-16
C178 (\19\:Ckbb VSS) capacitor c=1.3044e-16
C179 (\20\:Ckbb VSS) capacitor c=1.42223e-16
C180 (\21\:Ckbb VSS) capacitor c=1.20467e-17
C181 (\26\:Ckbb VSS) capacitor c=1.15461e-17
C182 (\27\:Ckbb VSS) capacitor c=1.21355e-16
C183 (\4\:n30_2 VSS) capacitor c=4.29463e-17
C184 (\5\:n30_2 VSS) capacitor c=7.38339e-17
C185 (\14\:qbint_2 VSS) capacitor c=5.03811e-17
C186 (\16\:qbint_2 VSS) capacitor c=4.80289e-17
C187 (\17\:qbint_2 VSS) capacitor c=4.76726e-17
C188 (\9\:qint_2 VSS) capacitor c=2.62406e-17
C189 (\12\:qint_2 VSS) capacitor c=3.69881e-17
C190 (\1\:Q2N VSS) capacitor c=5.96533e-17
C191 (\6\:VDD VSS) capacitor c=3.57531e-17
C192 (\8\:VDD VSS) capacitor c=8.72959e-18
C193 (\10\:VDD VSS) capacitor c=4.51281e-17
C194 (\11\:VDD VSS) capacitor c=4.3088e-17
C195 (\12\:VDD VSS) capacitor c=2.12704e-17
C196 (\14\:VDD VSS) capacitor c=8.1995e-19
C197 (\15\:VDD VSS) capacitor c=4.69327e-17
C198 (\16\:VDD VSS) capacitor c=3.1266e-17
C199 (\17\:VDD VSS) capacitor c=2.93151e-17
C200 (\20\:VDD VSS) capacitor c=1.72655e-17
Rk1 (\2\:Q1N Q1N) resistor r=0.2556 c=0
Rk2 (Q1N \4\:Q1N) resistor r=0.07392 c=0
Rk73 (Q2N \1\:Q2N) resistor r=0.006009 c=0
Rk74 (\1\:Q2N \3\:Q2N) resistor r=0.2086 c=0
Rk75 (\1\:Q2N \5\:Q2N) resistor r=0.2787 c=0
Rk110 (\1\:VSS \6\:VSS) resistor r=0.2259 c=0
Rk112 (\6\:VSS \8\:VSS) resistor r=0.2108 c=0
Rk113 (\8\:VSS \9\:VSS) resistor r=0.1167 c=0
Rk114 (\9\:VSS \10\:VSS) resistor r=0.3374 c=0
Rk115 (\10\:VSS \11\:VSS) resistor r=0.3989 c=0
Rk116 (\11\:VSS \12\:VSS) resistor r=0.2672 c=0
Rk117 (\12\:VSS \13\:VSS) resistor r=0.1931 c=0
Rk119 (\14\:VSS VSS) resistor r=0.08636 c=0
Rk118 (\13\:VSS \14\:VSS) resistor r=0.06154 c=0
Rk120 (VSS \15\:VSS) resistor r=0.3125 c=0
Rk121 (\15\:VSS \16\:VSS) resistor r=0.4541 c=0
Rk122 (\16\:VSS \17\:VSS) resistor r=0.2108 c=0
Rk125 (\17\:VSS \20\:VSS) resistor r=0.2259 c=0
Rk130 (\8\:VSS \30\:VSS) resistor r=0.0433 c=0
Rk131 (\10\:VSS \32\:VSS) resistor r=0.0433 c=0
Rk132 (\11\:VSS \34\:VSS) resistor r=0.0433 c=0
Rk133 (\12\:VSS \36\:VSS) resistor r=0.04148 c=0
Rk134 (\14\:VSS \38\:VSS) resistor r=0.0433 c=0
Rk135 (\15\:VSS \40\:VSS) resistor r=0.0433 c=0
Rk136 (\16\:VSS \42\:VSS) resistor r=0.0433 c=0
Rk68 (\2\:Q2 Q2) resistor r=0.429 c=0
Rk69 (Q2 \4\:Q2) resistor r=0.02374 c=0
Rk78 (\1\:VDD \6\:VDD) resistor r=0.2259 c=0
Rk80 (\6\:VDD \8\:VDD) resistor r=0.2259 c=0
Rk81 (\8\:VDD \9\:VDD) resistor r=0.1017 c=0
Rk82 (\9\:VDD \10\:VDD) resistor r=0.2797 c=0
Rk83 (\10\:VDD \11\:VDD) resistor r=0.4566 c=0
Rk84 (\11\:VDD \12\:VDD) resistor r=0.266 c=0
Rk85 (\12\:VDD \13\:VDD) resistor r=0.1944 c=0
Rk87 (\14\:VDD VDD) resistor r=0.08636 c=0
Rk86 (\13\:VDD \14\:VDD) resistor r=0.06154 c=0
Rk88 (VDD \15\:VDD) resistor r=0.3702 c=0
Rk89 (\15\:VDD \16\:VDD) resistor r=0.3813 c=0
Rk90 (\16\:VDD \17\:VDD) resistor r=0.2259 c=0
Rk93 (\17\:VDD \20\:VDD) resistor r=0.2259 c=0
Rk98 (\8\:VDD \30\:VDD) resistor r=0.0433 c=0
Rk99 (\10\:VDD \32\:VDD) resistor r=0.0433 c=0
Rk100 (\11\:VDD \34\:VDD) resistor r=0.0433 c=0
Rk101 (\12\:VDD \36\:VDD) resistor r=0.0433 c=0
Rk102 (\14\:VDD \38\:VDD) resistor r=0.0433 c=0
Rk103 (\15\:VDD \40\:VDD) resistor r=0.0433 c=0
Rk104 (\16\:VDD \42\:VDD) resistor r=0.0433 c=0
Rk6 (\2\:Q1 Q1) resistor r=0.4276 c=0
Rk7 (Q1 \4\:Q1) resistor r=0.02508 c=0
Rk27 (CK \5\:CK) resistor r=0.01177 c=0
Rk26 (\4\:CK \5\:CK) resistor r=0.004218 c=0
Rk23 (\5\:D1 \6\:D1) resistor r=0.004706 c=0
Rk24 (\7\:D1 D1) resistor r=0.004792 c=0
Rk25 (\6\:D1 \7\:D1) resistor r=0.04415 c=0
Rk28 (\5\:D2 \6\:D2) resistor r=0.004706 c=0
Rk29 (D2 \7\:D2) resistor r=0.004621 c=0
Rk30 (\5\:D2 \7\:D2) resistor r=0.04415 c=0
Rk38 (\19\:CKb \20\:CKb) resistor r=0.7973 c=0
Rk39 (\20\:CKb \21\:CKb) resistor r=0.1864 c=0
Rk40 (\21\:CKb \22\:CKb) resistor r=0.6973 c=0
Rk41 (\22\:CKb \23\:CKb) resistor r=0.583 c=0
Rk42 (\23\:CKb \24\:CKb) resistor r=0.1864 c=0
Rk43 (\24\:CKb \25\:CKb) resistor r=0.8235 c=0
Rk44 (\21\:CKb \26\:CKb) resistor r=0.4652 c=0
Rk45 (\22\:CKb \27\:CKb) resistor r=0.262 c=0
Rk46 (\27\:CKb \28\:CKb) resistor r=0.1981 c=0
Rk47 (\28\:CKb \30\:CKb) resistor r=0.2702 c=0
Rk48 (\23\:CKb \31\:CKb) resistor r=0.4596 c=0
Rk49 (\27\:CKb \33\:CKb) resistor r=0.1743 c=0
Rk50 (\15\:Ckbb \16\:Ckbb) resistor r=0.6646 c=0
Rk51 (\16\:Ckbb \17\:Ckbb) resistor r=0.5 c=0
Rk52 (\17\:Ckbb \18\:Ckbb) resistor r=0.8499 c=0
Rk53 (\18\:Ckbb \19\:Ckbb) resistor r=0.5325 c=0
Rk54 (\19\:Ckbb \20\:Ckbb) resistor r=0.5 c=0
Rk55 (\17\:Ckbb \21\:Ckbb) resistor r=0.04038 c=0
Rk56 (\18\:Ckbb \23\:Ckbb) resistor r=0.1905 c=0
Rk57 (\23\:Ckbb \25\:Ckbb) resistor r=0.3026 c=0
Rk58 (\19\:Ckbb \26\:Ckbb) resistor r=0.04038 c=0
Rk59 (\20\:Ckbb \27\:Ckbb) resistor r=0.6628 c=0
Rk3 (\8\:qint \9\:qint) resistor r=0.167 c=0
Rk4 (\9\:qint \10\:qint) resistor r=0.1395 c=0
Rk5 (\9\:qint \12\:qint) resistor r=0.117 c=0
Rk8 (\15\:qbint \16\:qbint) resistor r=0.3092 c=0
Rk9 (\16\:qbint \17\:qbint) resistor r=0.2264 c=0
Rk10 (\16\:qbint \18\:qbint) resistor r=0.04915 c=0
Rk11 (\18\:qbint \20\:qbint) resistor r=0.1376 c=0
Rk12 (\18\:qbint \21\:qbint) resistor r=0.1522 c=0
Rk13 (\5\:n30 \6\:n30) resistor r=0.2677 c=0
Rk14 (\6\:n30 \7\:n30) resistor r=0.1488 c=0
Rk15 (\6\:n30 \9\:n30) resistor r=0.3904 c=0
Rk16 (\5\:mout \6\:mout) resistor r=0.1606 c=0
Rk17 (\6\:mout \8\:mout) resistor r=0.1663 c=0
Rk18 (\6\:mout \10\:mout) resistor r=0.2924 c=0
Rk19 (\6\:n20 \7\:n20) resistor r=0.3668 c=0
Rk20 (\7\:n20 \8\:n20) resistor r=0.1518 c=0
Rk21 (\7\:n20 \10\:n20) resistor r=0.2414 c=0
Rk22 (\2\:Db \4\:Db) resistor r=0.4738 c=0
Rk70 (\8\:qint_2 \9\:qint_2) resistor r=0.167 c=0
Rk71 (\9\:qint_2 \11\:qint_2) resistor r=0.117 c=0
Rk72 (\9\:qint_2 \12\:qint_2) resistor r=0.1395 c=0
Rk63 (\14\:qbint_2 \15\:qbint_2) resistor r=0.2195 c=0
Rk64 (\15\:qbint_2 \16\:qbint_2) resistor r=0.06162 c=0
Rk65 (\16\:qbint_2 \17\:qbint_2) resistor r=0.1522 c=0
Rk66 (\15\:qbint_2 \19\:qbint_2) resistor r=0.3047 c=0
Rk67 (\16\:qbint_2 \21\:qbint_2) resistor r=0.1376 c=0
Rk60 (\4\:n30_2 \5\:n30_2) resistor r=0.1488 c=0
Rk61 (\5\:n30_2 \7\:n30_2) resistor r=0.2677 c=0
Rk62 (\5\:n30_2 \9\:n30_2) resistor r=0.4121 c=0
Rk35 (\6\:mout_2 \7\:mout_2) resistor r=0.3325 c=0
Rk36 (\7\:mout_2 \8\:mout_2) resistor r=0.1606 c=0
Rk37 (\7\:mout_2 \10\:mout_2) resistor r=0.1663 c=0
Rk32 (\6\:n20_2 \7\:n20_2) resistor r=0.242 c=0
Rk33 (\7\:n20_2 \9\:n20_2) resistor r=0.3734 c=0
Rk34 (\7\:n20_2 \10\:n20_2) resistor r=0.1518 c=0
Rk31 (\2\:Db_2 \4\:Db_2) resistor r=0.4738 c=0
Rl39 (\1\:CK \2\:CK) resistor r=24.2328 c=0
Rl40 (\2\:CK \3\:CK) resistor r=58.8482 c=0
Rl35 (\2\:D1 \4\:D1) resistor r=46.9565 c=0
Rl34 (\2\:D1 \3\:D1) resistor r=120.033 c=0
Rl33 (\1\:D1 \2\:D1) resistor r=6.99 c=0
Rl41 (\1\:D2 \2\:D2) resistor r=46.9565 c=0
Rl43 (\2\:D2 \4\:D2) resistor r=120.033 c=0
Rl42 (\2\:D2 \3\:D2) resistor r=6.9867 c=0
Rl57 (\17\:CKb \18\:CKb) resistor r=24.2328 c=0
Rl56 (\16\:CKb \17\:CKb) resistor r=193.029 c=0
Rl47 (\14\:CKb \15\:CKb) resistor r=41.5405 c=0
Rl44 (\12\:CKb \13\:CKb) resistor r=37.6944 c=0
Rl32 (\6\:CKb \7\:CKb) resistor r=37.6944 c=0
Rl29 (\4\:CKb \5\:CKb) resistor r=41.5405 c=0
Rl21 (CKb \2\:CKb) resistor r=24.2328 c=0
Rl22 (\2\:CKb \3\:CKb) resistor r=193.029 c=0
Rl38 (\9\:CKb \11\:CKb) resistor r=64.2642 c=0
Rl37 (\9\:CKb \10\:CKb) resistor r=37.3411 c=0
Rl36 (\8\:CKb \9\:CKb) resistor r=1.2334 c=0
Rl46 (\9\:Ckbb \10\:Ckbb) resistor r=195.72 c=0
Rl30 (\5\:Ckbb \6\:Ckbb) resistor r=195.72 c=0
Rl55 (\13\:Ckbb \14\:Ckbb) resistor r=38.4387 c=0
Rl54 (\11\:Ckbb \12\:Ckbb) resistor r=66.0764 c=0
Rl45 (\8\:Ckbb \9\:Ckbb) resistor r=26.1559 c=0
Rl31 (\6\:Ckbb \7\:Ckbb) resistor r=26.1559 c=0
Rl20 (\3\:Ckbb \4\:Ckbb) resistor r=66.0764 c=0
Rl19 (Ckbb \2\:Ckbb) resistor r=38.4387 c=0
Rl10 (\6\:qbint qbint) resistor r=142 c=0
Rl13 (\6\:qbint \9\:qbint) resistor r=60.772 c=0
Rl11 (\6\:qbint \7\:qbint) resistor r=28.0797 c=0
Rl16 (\11\:qbint \10\:qbint) resistor r=120.868 c=0
Rl18 (\11\:qbint \13\:qbint) resistor r=47.791 c=0
Rl17 (\11\:qbint \12\:qbint) resistor r=2.7666 c=0
Rl14 (n30 \2\:n30) resistor r=49.2328 c=0
Rl15 (\2\:n30 \3\:n30) resistor r=99.2328 c=0
Rl28 (\2\:mout \4\:mout) resistor r=114.125 c=0
Rl26 (mout \2\:mout) resistor r=73.3853 c=0
Rl27 (\2\:mout \3\:mout) resistor r=5.8511 c=0
Rl25 (\2\:n20 \4\:n20) resistor r=51.6372 c=0
Rl24 (\2\:n20 \3\:n20) resistor r=117.022 c=0
Rl23 (n20 \2\:n20) resistor r=3.5213 c=0
Rl60 (\2\:qbint_2 \4\:qbint_2) resistor r=120.868 c=0
Rl59 (\2\:qbint_2 \3\:qbint_2) resistor r=47.791 c=0
Rl58 (\2\:qbint_2 qbint_2) resistor r=2.7713 c=0
Rl63 (\6\:qbint_2 \5\:qbint_2) resistor r=60.772 c=0
Rl66 (\6\:qbint_2 \9\:qbint_2) resistor r=28.0797 c=0
Rl64 (\7\:qbint_2 \6\:qbint_2) resistor r=142 c=0
Rl61 (n30_2 \2\:n30_2) resistor r=49.2328 c=0
Rl62 (\2\:n30_2 \3\:n30_2) resistor r=99.2328 c=0
Rl48 (mout_2 \2\:mout_2) resistor r=114.125 c=0
Rl49 (\2\:mout_2 \3\:mout_2) resistor r=73.3853 c=0
Rl50 (\2\:mout_2 \4\:mout_2) resistor r=5.8511 c=0
Rl51 (n20_2 \2\:n20_2) resistor r=51.6372 c=0
Rl53 (\2\:n20_2 \4\:n20_2) resistor r=117.022 c=0
Rl52 (\2\:n20_2 \3\:n20_2) resistor r=3.5166 c=0
Rz1 (\4\:Q1N \3\:Q1N) resistor r=37.5 c=0
Rz18 (\3\:Q2N \2\:Q2N) resistor r=37.5 c=0
Rz28 (\30\:VSS \29\:VSS) resistor r=75 c=0
Rz29 (\32\:VSS \31\:VSS) resistor r=75 c=0
Rz30 (\34\:VSS \33\:VSS) resistor r=75 c=0
Rz31 (\36\:VSS \35\:VSS) resistor r=75 c=0
Rz32 (\38\:VSS \37\:VSS) resistor r=75 c=0
Rz33 (\40\:VSS \39\:VSS) resistor r=75 c=0
Rz34 (\42\:VSS \41\:VSS) resistor r=75 c=0
Rz16 (\2\:Q2 \1\:Q2) resistor r=37.5 c=0
Rz19 (\1\:VDD \3\:VDD) resistor r=18.75 c=0
Rz20 (\9\:VDD \3\:VDD) resistor r=6.25 c=0
Rz21 (\13\:VDD \3\:VDD) resistor r=6.25 c=0
Rz22 (\17\:VDD \3\:VDD) resistor r=6.25 c=0
Rz3 (\2\:Q1 \1\:Q1) resistor r=37.5 c=0
Rz12 (\29\:CKb \30\:CKb) resistor r=75 c=0
Rz13 (\22\:Ckbb \23\:Ckbb) resistor r=75 c=0
Rz2 (\12\:qint \11\:qint) resistor r=75 c=0
Rz4 (\20\:qbint \19\:qbint) resistor r=75 c=0
Rz5 (\8\:n30 \9\:n30) resistor r=75 c=0
Rz6 (\7\:mout \8\:mout) resistor r=75 c=0
Rz7 (\5\:n20 \6\:n20) resistor r=75 c=0
Rz8 (\3\:Db \4\:Db) resistor r=75 c=0
Rz17 (\11\:qint_2 \10\:qint_2) resistor r=75 c=0
Rz15 (\21\:qbint_2 \20\:qbint_2) resistor r=75 c=0
Rz14 (\8\:n30_2 \9\:n30_2) resistor r=75 c=0
Rz11 (\9\:mout_2 \10\:mout_2) resistor r=75 c=0
Rz10 (\8\:n20_2 \9\:n20_2) resistor r=75 c=0
Rz9 (\3\:Db_2 \4\:Db_2) resistor r=75 c=0
Ry1 (\2\:Q1N \1\:Q1N) resistor r=20.6667 c=0
Ry18 (\5\:Q2N \4\:Q2N) resistor r=20.6667 c=0
Ry34 (\1\:VSS \3\:VSS) resistor r=15.5 c=0
Ry35 (\9\:VSS \3\:VSS) resistor r=5.1667 c=0
Ry36 (\13\:VSS \3\:VSS) resistor r=5.1667 c=0
Ry37 (\17\:VSS \3\:VSS) resistor r=5.1667 c=0
Ry16 (\4\:Q2 \3\:Q2) resistor r=20.6667 c=0
Ry24 (\30\:VDD \29\:VDD) resistor r=62 c=0
Ry25 (\32\:VDD \31\:VDD) resistor r=62 c=0
Ry26 (\34\:VDD \33\:VDD) resistor r=62 c=0
Ry27 (\36\:VDD \35\:VDD) resistor r=62 c=0
Ry28 (\38\:VDD \37\:VDD) resistor r=62 c=0
Ry29 (\40\:VDD \39\:VDD) resistor r=62 c=0
Ry30 (\42\:VDD \41\:VDD) resistor r=62 c=0
Ry3 (\4\:Q1 \3\:Q1) resistor r=20.6667 c=0
Ry12 (\32\:CKb \33\:CKb) resistor r=62 c=0
Ry13 (\24\:Ckbb \25\:Ckbb) resistor r=62 c=0
Ry2 (\8\:qint \7\:qint) resistor r=62 c=0
Ry4 (\15\:qbint \14\:qbint) resistor r=31 c=0
Ry5 (\4\:n30 \5\:n30) resistor r=62 c=0
Ry6 (\9\:mout \10\:mout) resistor r=62 c=0
Ry7 (\9\:n20 \10\:n20) resistor r=62 c=0
Ry8 (Db \2\:Db) resistor r=62 c=0
Ry17 (\8\:qint_2 \7\:qint_2) resistor r=62 c=0
Ry15 (\19\:qbint_2 \18\:qbint_2) resistor r=31 c=0
Ry14 (\6\:n30_2 \7\:n30_2) resistor r=62 c=0
Ry11 (\5\:mout_2 \6\:mout_2) resistor r=62 c=0
Ry10 (\5\:n20_2 \6\:n20_2) resistor r=62 c=0
Ry9 (Db_2 \2\:Db_2) resistor r=62 c=0
Rx8 (\2\:CK \4\:CK) resistor r=45 c=0
Rx7 (\1\:D1 \5\:D1) resistor r=45 c=0
Rx9 (\3\:D2 \6\:D2) resistor r=45 c=0
Rx12 (\17\:CKb \19\:CKb) resistor r=45 c=0
Rx13 (\15\:CKb \20\:CKb) resistor r=45 c=0
Rx14 (\5\:CKb \24\:CKb) resistor r=45 c=0
Rx15 (\2\:CKb \25\:CKb) resistor r=45 c=0
Rx16 (\13\:CKb \26\:CKb) resistor r=45 c=0
Rx17 (\8\:CKb \28\:CKb) resistor r=45 c=0
Rx18 (\7\:CKb \31\:CKb) resistor r=45 c=0
Rx19 (\14\:Ckbb \15\:Ckbb) resistor r=45 c=0
Rx20 (\12\:Ckbb \16\:Ckbb) resistor r=45 c=0
Rx21 (\4\:Ckbb \20\:Ckbb) resistor r=45 c=0
Rx22 (\8\:Ckbb \21\:Ckbb) resistor r=45 c=0
Rx23 (\7\:Ckbb \26\:Ckbb) resistor r=45 c=0
Rx24 (Ckbb \27\:Ckbb) resistor r=45 c=0
Rx1 (\10\:qint qint) resistor r=45 c=0
Rx2 (\17\:qbint qbint) resistor r=22.5 c=0
Rx3 (\21\:qbint \12\:qbint) resistor r=45 c=0
Rx4 (\2\:n30 \7\:n30) resistor r=45 c=0
Rx5 (\3\:mout \5\:mout) resistor r=45 c=0
Rx6 (n20 \8\:n20) resistor r=45 c=0
Rx28 (\12\:qint_2 qint_2) resistor r=45 c=0
Rx26 (\14\:qbint_2 \7\:qbint_2) resistor r=22.5 c=0
Rx27 (\17\:qbint_2 qbint_2) resistor r=45 c=0
Rx25 (\2\:n30_2 \4\:n30_2) resistor r=45 c=0
Rx11 (\4\:mout_2 \8\:mout_2) resistor r=45 c=0
Rx10 (\3\:n20_2 \10\:n20_2) resistor r=45 c=0
NM19 (\2\:Q2N qint_2 \1\:VSS VSS) g45n1svt w=(2.6e-07) l=4.5e-08 nf=1 \
        as=5.447e-14 ad=5.085e-14 ps=1.22e-06 pd=1.17e-06 nrd=1.16667 \
        nrs=1.16667 sa=1.2e-07 sb=4.56058e-07 sd=160n sca=17.5885 \
        scb=0.0172826 scc=0.00162584 m=(2)
mn55 (\1\:Q1 qbint \17\:VSS VSS) g45n1svt w=(2.6e-07) l=4.5e-08 nf=1 \
        as=5.24e-14 ad=4.812e-14 ps=1.205e-06 pd=1.175e-06 nrd=1.16667 \
        nrs=1.16667 sa=3.15e-07 sb=1.04615e-07 sd=160n sca=17.5885 \
        scb=0.0172826 scc=0.00162584 m=(2)
NM17 (\1\:Q2 \7\:qbint_2 \6\:VSS VSS) g45n1svt w=(2.6e-07) l=4.5e-08 \
        nf=1 as=5.24e-14 ad=4.812e-14 ps=1.205e-06 pd=1.175e-06 \
        nrd=1.16667 nrs=1.16667 sa=3.15e-07 sb=1.04615e-07 sd=160n \
        sca=17.5885 scb=0.0172826 scc=0.00162584 m=(2)
mn57_1__rcx (\3\:Q1N qint \20\:VSS VSS) g45n1svt w=(2.6e-07) l=4.5e-08 \
        nf=1 as=5.447e-14 ad=5.085e-14 ps=1.22e-06 pd=1.17e-06 nrd=1.16667 \
        nrs=1.16667 sa=1.2e-07 sb=4.56058e-07 sd=160n sca=17.5885 \
        scb=0.0172826 scc=0.00162584 m=(2)
NM18 (\10\:qint_2 \9\:qbint_2 \1\:VSS VSS) g45n1svt w=(1.45e-07) \
        l=4.5e-08 nf=1 as=2.03e-14 ad=6.735e-14 ps=5.7e-07 pd=1.6e-06 \
        nrd=1.16667 nrs=1.16667 sa=5.4e-07 sb=1.4e-07 sd=160n sca=23.279 \
        scb=0.0230742 scc=0.00267719 m=(1)
NM15 (n11_2 \3\:qbint_2 \29\:VSS VSS) g45n1svt w=(1.45e-07) l=4.5e-08 \
        nf=1 as=1.087e-14 ad=6.302e-14 ps=4.4e-07 pd=1.54e-06 nrd=1.16667 \
        nrs=1.16667 sa=3.5e-07 sb=1.64e-06 sd=160n sca=18.4982 \
        scb=0.0194884 scc=0.00168796 m=(1)
NM16 (\8\:n30_2 \16\:CKb n11_2 VSS) g45n1svt w=(1.45e-07) l=4.5e-08 nf=1 \
        as=1.087e-14 ad=2.537e-14 ps=4.4e-07 pd=6.4e-07 nrd=1.16667 \
        nrs=1.16667 sa=1.52e-06 sb=4.7e-07 sd=160n sca=18.4982 \
        scb=0.0194884 scc=0.00168796 m=(1)
NM12 (\9\:mout_2 \11\:Ckbb \8\:n30_2 VSS) g45n1svt w=(1.45e-07) l=4.5e-08 \
        nf=1 as=2.537e-14 ad=3.19e-14 ps=6.4e-07 pd=7.3e-07 nrd=1.16667 \
        nrs=1.16667 sa=1.3e-06 sb=6.9e-07 sd=160n sca=18.4982 \
        scb=0.0194884 scc=0.00168796 m=(1)
NM8 (\9\:mout_2 \4\:n20_2 \31\:VSS VSS) g45n1svt w=(1.45e-07) l=4.5e-08 \
        nf=1 as=8.992e-14 ad=3.19e-14 ps=1.67e-06 pd=7.3e-07 nrd=1.16667 \
        nrs=1.16667 sa=1.035e-06 sb=9.55e-07 sd=160n sca=18.4982 \
        scb=0.0194884 scc=0.00168796 m=(1)
NM11 (n5_2 \3\:mout_2 \31\:VSS VSS) g45n1svt w=(1.45e-07) l=4.5e-08 nf=1 \
        as=8.992e-14 ad=8.7e-15 ps=1.67e-06 pd=4.1e-07 nrd=1.16667 \
        nrs=1.16667 sa=7.05e-07 sb=1.285e-06 sd=160n sca=18.4982 \
        scb=0.0194884 scc=0.00168796 m=(1)
NM9 (\8\:n20_2 \9\:Ckbb n5_2 VSS) g45n1svt w=(1.45e-07) l=4.5e-08 nf=1 \
        as=2.32e-14 ad=8.7e-15 ps=6.1e-07 pd=4.1e-07 nrd=1.16667 \
        nrs=1.16667 sa=1.39e-06 sb=6e-07 sd=160n sca=18.4982 scb=0.0194884 \
        scc=0.00168796 m=(1)
NM7 (\3\:Db_2 \12\:CKb \8\:n20_2 VSS) g45n1svt w=(1.45e-07) l=4.5e-08 \
        nf=1 as=2.61e-14 ad=2.32e-14 ps=6.5e-07 pd=6.1e-07 nrd=1.16667 \
        nrs=1.16667 sa=1.595e-06 sb=3.95e-07 sd=160n sca=18.4982 \
        scb=0.0194884 scc=0.00168796 m=(1)
NM1 (\3\:Db_2 \4\:D2 \33\:VSS VSS) g45n1svt w=(1.45e-07) l=4.5e-08 nf=1 \
        as=2.61e-14 ad=7.325e-14 ps=6.5e-07 pd=1.44e-06 nrd=1.16667 \
        nrs=1.16667 sa=1.82e-06 sb=1.7e-07 sd=160n sca=18.4982 \
        scb=0.0194884 scc=0.00168796 m=(1)
mn56 (\11\:qint \7\:qbint \20\:VSS VSS) g45n1svt w=(1.45e-07) l=4.5e-08 \
        nf=1 as=2.03e-14 ad=6.735e-14 ps=5.7e-07 pd=1.6e-06 nrd=1.16667 \
        nrs=1.16667 sa=5.4e-07 sb=1.4e-07 sd=160n sca=23.279 scb=0.0230742 \
        scc=0.00267719 m=(1)
mn50 (n11 \13\:qbint \41\:VSS VSS) g45n1svt w=(1.45e-07) l=4.5e-08 nf=1 \
        as=1.087e-14 ad=6.302e-14 ps=4.4e-07 pd=1.54e-06 nrd=1.16667 \
        nrs=1.16667 sa=3.5e-07 sb=1.64e-06 sd=160n sca=18.4982 \
        scb=0.0194884 scc=0.00168796 m=(1)
mn51 (\8\:n30 \3\:CKb n11 VSS) g45n1svt w=(1.45e-07) l=4.5e-08 nf=1 \
        as=1.087e-14 ad=2.537e-14 ps=4.4e-07 pd=6.4e-07 nrd=1.16667 \
        nrs=1.16667 sa=1.52e-06 sb=4.7e-07 sd=160n sca=18.4982 \
        scb=0.0194884 scc=0.00168796 m=(1)
mn40 (\7\:mout \3\:Ckbb \8\:n30 VSS) g45n1svt w=(1.45e-07) l=4.5e-08 nf=1 \
        as=2.537e-14 ad=3.19e-14 ps=6.4e-07 pd=7.3e-07 nrd=1.16667 \
        nrs=1.16667 sa=1.3e-06 sb=6.9e-07 sd=160n sca=18.4982 \
        scb=0.0194884 scc=0.00168796 m=(1)
mn30 (\7\:mout \3\:n20 \39\:VSS VSS) g45n1svt w=(1.45e-07) l=4.5e-08 \
        nf=1 as=8.992e-14 ad=3.19e-14 ps=1.67e-06 pd=7.3e-07 nrd=1.16667 \
        nrs=1.16667 sa=1.035e-06 sb=9.55e-07 sd=160n sca=18.4982 \
        scb=0.0194884 scc=0.00168796 m=(1)
mn36 (n5 mout \39\:VSS VSS) g45n1svt w=(1.45e-07) l=4.5e-08 nf=1 \
        as=8.992e-14 ad=8.7e-15 ps=1.67e-06 pd=4.1e-07 nrd=1.16667 \
        nrs=1.16667 sa=7.05e-07 sb=1.285e-06 sd=160n sca=18.4982 \
        scb=0.0194884 scc=0.00168796 m=(1)
mn37 (\5\:n20 \6\:Ckbb n5 VSS) g45n1svt w=(1.45e-07) l=4.5e-08 nf=1 \
        as=2.32e-14 ad=8.7e-15 ps=6.1e-07 pd=4.1e-07 nrd=1.16667 \
        nrs=1.16667 sa=1.39e-06 sb=6e-07 sd=160n sca=18.4982 scb=0.0194884 \
        scc=0.00168796 m=(1)
mn25 (\3\:Db \6\:CKb \5\:n20 VSS) g45n1svt w=(1.45e-07) l=4.5e-08 nf=1 \
        as=2.61e-14 ad=2.32e-14 ps=6.5e-07 pd=6.1e-07 nrd=1.16667 \
        nrs=1.16667 sa=1.595e-06 sb=3.95e-07 sd=160n sca=18.4982 \
        scb=0.0194884 scc=0.00168796 m=(1)
mn11 (\3\:Db \3\:D1 \37\:VSS VSS) g45n1svt w=(1.45e-07) l=4.5e-08 nf=1 \
        as=2.61e-14 ad=7.325e-14 ps=6.5e-07 pd=1.44e-06 nrd=1.16667 \
        nrs=1.16667 sa=1.82e-06 sb=1.7e-07 sd=160n sca=18.4982 \
        scb=0.0194884 scc=0.00168796 m=(1)
mn21 (\22\:Ckbb \10\:CKb \35\:VSS VSS) g45n1svt w=(1.45e-07) l=4.5e-08 \
        nf=1 as=2.03e-14 ad=6.752e-14 ps=5.7e-07 pd=1.56e-06 nrd=1.16667 \
        nrs=1.16667 sa=1.4e-07 sb=3.6e-07 sd=160n sca=19.8813 \
        scb=0.0206549 scc=0.00197265 m=(1)
mn20 (\29\:CKb \3\:CK \35\:VSS VSS) g45n1svt w=(1.45e-07) l=4.5e-08 nf=1 \
        as=2.03e-14 ad=6.752e-14 ps=5.7e-07 pd=1.56e-06 nrd=1.16667 \
        nrs=1.16667 sa=3.6e-07 sb=1.4e-07 sd=160n sca=19.8813 \
        scb=0.0206549 scc=0.00197265 m=(1)
NM13 (\20\:qbint_2 \3\:n30_2 \29\:VSS VSS) g45n1svt w=(2.05e-07) \
        l=4.5e-08 nf=1 as=6.302e-14 ad=2.87e-14 ps=1.54e-06 pd=6.9e-07 \
        nrd=1.16667 nrs=1.16667 sa=1.3422e-06 sb=1.4e-07 sd=160n \
        sca=16.0682 scb=0.0166045 scc=0.00126927 m=(1)
mn46 (\19\:qbint \3\:n30 \41\:VSS VSS) g45n1svt w=(2.05e-07) l=4.5e-08 \
        nf=1 as=6.302e-14 ad=2.87e-14 ps=1.54e-06 pd=6.9e-07 nrd=1.16667 \
        nrs=1.16667 sa=1.3422e-06 sb=1.4e-07 sd=160n sca=16.0682 \
        scb=0.0166045 scc=0.00126927 m=(1)
PM18 (\7\:qint_2 \5\:qbint_2 \1\:VDD VDD) g45p1svt w=(2.15e-07) \
        l=4.5e-08 nf=1 as=3.01e-14 ad=8.885e-14 ps=7.1e-07 pd=1.9e-06 \
        nrd=1.16667 nrs=1.16667 sa=5.4e-07 sb=1.4e-07 sd=160n sca=46.674 \
        scb=0.0287584 scc=0.00588446 m=(1)
PM15 (n8_2 \4\:qbint_2 \29\:VDD VDD) g45p1svt w=(2.15e-07) l=4.5e-08 \
        nf=1 as=1.828e-14 ad=6.96e-14 ps=6e-07 pd=1.52e-06 nrd=1.16667 \
        nrs=1.16667 sa=3.5e-07 sb=1.64e-06 sd=160n sca=12.1244 \
        scb=0.0107968 scc=0.000332109 m=(1)
PM16 (\6\:n30_2 \13\:Ckbb n8_2 VDD) g45p1svt w=(2.15e-07) l=4.5e-08 nf=1 \
        as=1.828e-14 ad=3.655e-14 ps=6e-07 pd=7.7e-07 nrd=1.16667 \
        nrs=1.16667 sa=1.51e-06 sb=4.8e-07 sd=160n sca=12.1244 \
        scb=0.0107968 scc=0.000332109 m=(1)
PM12 (\6\:n30_2 \18\:CKb \5\:mout_2 VDD) g45p1svt w=(2.15e-07) l=4.5e-08 \
        nf=1 as=4.623e-14 ad=3.655e-14 ps=8.6e-07 pd=7.7e-07 nrd=1.16667 \
        nrs=1.16667 sa=1.295e-06 sb=6.95e-07 sd=160n sca=12.1244 \
        scb=0.0107968 scc=0.000332109 m=(1)
PM8 (\5\:mout_2 n20_2 \31\:VDD VDD) g45p1svt w=(2.15e-07) l=4.5e-08 nf=1 \
        as=6.593e-14 ad=4.623e-14 ps=1.53e-06 pd=8.6e-07 nrd=1.16667 \
        nrs=1.16667 sa=1.035e-06 sb=9.55e-07 sd=160n sca=12.1244 \
        scb=0.0107968 scc=0.000332109 m=(1)
PM11 (n6_2 mout_2 \31\:VDD VDD) g45p1svt w=(2.15e-07) l=4.5e-08 nf=1 \
        as=6.593e-14 ad=1.398e-14 ps=1.53e-06 pd=5.6e-07 nrd=1.16667 \
        nrs=1.16667 sa=8.2e-07 sb=1.17e-06 sd=160n sca=12.1244 \
        scb=0.0107968 scc=0.000332109 m=(1)
PM10 (\5\:n20_2 \14\:CKb n6_2 VDD) g45p1svt w=(2.15e-07) l=4.5e-08 nf=1 \
        as=3.44e-14 ad=1.398e-14 ps=7.5e-07 pd=5.6e-07 nrd=1.16667 \
        nrs=1.16667 sa=1.28e-06 sb=7.1e-07 sd=160n sca=12.1244 \
        scb=0.0107968 scc=0.000332109 m=(1)
PM7 (\5\:n20_2 \10\:Ckbb Db_2 VDD) g45p1svt w=(2.15e-07) l=4.5e-08 nf=1 \
        as=3.44e-14 ad=6.235e-14 ps=7.5e-07 pd=1.01e-06 nrd=1.16667 \
        nrs=1.16667 sa=1.485e-06 sb=5.05e-07 sd=160n sca=12.1244 \
        scb=0.0107968 scc=0.000332109 m=(1)
PM1 (Db_2 \1\:D2 \33\:VDD VDD) g45p1svt w=(2.15e-07) l=4.5e-08 nf=1 \
        as=6.235e-14 ad=7.555e-14 ps=1.01e-06 pd=1.42e-06 nrd=1.16667 \
        nrs=1.16667 sa=1.82e-06 sb=1.7e-07 sd=160n sca=12.1244 \
        scb=0.0107968 scc=0.000332109 m=(1)
mp56 (\7\:qint \9\:qbint \20\:VDD VDD) g45p1svt w=(2.15e-07) l=4.5e-08 \
        nf=1 as=3.01e-14 ad=8.885e-14 ps=7.1e-07 pd=1.9e-06 nrd=1.16667 \
        nrs=1.16667 sa=5.4e-07 sb=1.4e-07 sd=160n sca=46.674 scb=0.0287584 \
        scc=0.00588446 m=(1)
mp50 (n8 \10\:qbint \41\:VDD VDD) g45p1svt w=(2.15e-07) l=4.5e-08 nf=1 \
        as=1.828e-14 ad=6.96e-14 ps=6e-07 pd=1.52e-06 nrd=1.16667 \
        nrs=1.16667 sa=3.5e-07 sb=1.64e-06 sd=160n sca=12.1244 \
        scb=0.0107968 scc=0.000332109 m=(1)
mp51 (\4\:n30 \2\:Ckbb n8 VDD) g45p1svt w=(2.15e-07) l=4.5e-08 nf=1 \
        as=1.828e-14 ad=3.655e-14 ps=6e-07 pd=7.7e-07 nrd=1.16667 \
        nrs=1.16667 sa=1.51e-06 sb=4.8e-07 sd=160n sca=12.1244 \
        scb=0.0107968 scc=0.000332109 m=(1)
mp40 (\4\:n30 CKb \9\:mout VDD) g45p1svt w=(2.15e-07) l=4.5e-08 nf=1 \
        as=4.623e-14 ad=3.655e-14 ps=8.6e-07 pd=7.7e-07 nrd=1.16667 \
        nrs=1.16667 sa=1.295e-06 sb=6.95e-07 sd=160n sca=12.1244 \
        scb=0.0107968 scc=0.000332109 m=(1)
mp30 (\9\:mout \4\:n20 \39\:VDD VDD) g45p1svt w=(2.15e-07) l=4.5e-08 \
        nf=1 as=6.593e-14 ad=4.623e-14 ps=1.53e-06 pd=8.6e-07 nrd=1.16667 \
        nrs=1.16667 sa=1.035e-06 sb=9.55e-07 sd=160n sca=12.1244 \
        scb=0.0107968 scc=0.000332109 m=(1)
mp36 (n6 \4\:mout \39\:VDD VDD) g45p1svt w=(2.15e-07) l=4.5e-08 nf=1 \
        as=6.593e-14 ad=1.398e-14 ps=1.53e-06 pd=5.6e-07 nrd=1.16667 \
        nrs=1.16667 sa=8.2e-07 sb=1.17e-06 sd=160n sca=12.1244 \
        scb=0.0107968 scc=0.000332109 m=(1)
mp37 (\9\:n20 \4\:CKb n6 VDD) g45p1svt w=(2.15e-07) l=4.5e-08 nf=1 \
        as=3.44e-14 ad=1.398e-14 ps=7.5e-07 pd=5.6e-07 nrd=1.16667 \
        nrs=1.16667 sa=1.28e-06 sb=7.1e-07 sd=160n sca=12.1244 \
        scb=0.0107968 scc=0.000332109 m=(1)
mp25 (\9\:n20 \5\:Ckbb Db VDD) g45p1svt w=(2.15e-07) l=4.5e-08 nf=1 \
        as=3.44e-14 ad=6.235e-14 ps=7.5e-07 pd=1.01e-06 nrd=1.16667 \
        nrs=1.16667 sa=1.485e-06 sb=5.05e-07 sd=160n sca=12.1244 \
        scb=0.0107968 scc=0.000332109 m=(1)
mp11 (Db \4\:D1 \37\:VDD VDD) g45p1svt w=(2.15e-07) l=4.5e-08 nf=1 \
        as=6.235e-14 ad=7.555e-14 ps=1.01e-06 pd=1.42e-06 nrd=1.16667 \
        nrs=1.16667 sa=1.82e-06 sb=1.7e-07 sd=160n sca=12.1244 \
        scb=0.0107968 scc=0.000332109 m=(1)
mp21 (\24\:Ckbb \11\:CKb \35\:VDD VDD) g45p1svt w=(2.15e-07) l=4.5e-08 \
        nf=1 as=3.01e-14 ad=8.733e-14 ps=7.1e-07 pd=1.85e-06 nrd=1.16667 \
        nrs=1.16667 sa=1.4e-07 sb=3.6e-07 sd=160n sca=31.508 scb=0.0252524 \
        scc=0.00399199 m=(1)
mp20 (\32\:CKb \1\:CK \35\:VDD VDD) g45p1svt w=(2.15e-07) l=4.5e-08 nf=1 \
        as=3.01e-14 ad=8.733e-14 ps=7.1e-07 pd=1.85e-06 nrd=1.16667 \
        nrs=1.16667 sa=3.6e-07 sb=1.4e-07 sd=160n sca=31.508 scb=0.0252524 \
        scc=0.00399199 m=(1)
PM14 (\18\:qbint_2 n30_2 \29\:VDD VDD) g45p1svt w=(3.1e-07) l=4.5e-08 \
        nf=1 as=4.34e-14 ad=6.96e-14 ps=9e-07 pd=1.52e-06 nrd=1.16667 \
        nrs=1.16667 sa=1.4e-07 sb=1.31831e-06 sd=160n sca=11.4422 \
        scb=0.00958599 scc=0.000246391 m=(1)
mp46 (\14\:qbint n30 \41\:VDD VDD) g45p1svt w=(3.1e-07) l=4.5e-08 nf=1 \
        as=4.34e-14 ad=6.96e-14 ps=9e-07 pd=1.52e-06 nrd=1.16667 \
        nrs=1.16667 sa=1.4e-07 sb=1.31831e-06 sd=160n sca=11.4422 \
        scb=0.00958599 scc=0.000246391 m=(1)
ends DFF2X2
// End of subcircuit definition.
