// gsclib045_lvt/DLY3X4/schematic

simulator lang=spectre

subckt DLY3X4 A Y VSS VDD
mp8 (n4 VSS n14 VDD) g45p1lvt w=(215n) l=45n nf=1 m=(1)
mp7 (n14 n3 VDD VDD) g45p1lvt w=(215n) l=45n nf=1 m=(1)
mp9 (n16 n4 VDD VDD) g45p1lvt w=(215n) l=45n nf=1 m=(1)
mp10 (n5 VSS n16 VDD) g45p1lvt w=(215n) l=45n nf=1 m=(1)
mp6 (n3 VSS n12 VDD) g45p1lvt w=(215n) l=45n nf=1 m=(1)
mp5 (n12 n2 VDD VDD) g45p1lvt w=(215n) l=45n nf=1 m=(1)
mp4 (n2 VSS n10 VDD) g45p1lvt w=(215n) l=45n nf=1 m=(1)
mp3 (n10 n1 VDD VDD) g45p1lvt w=(215n) l=45n nf=1 m=(1)
mp2 (n1 VSS n8 VDD) g45p1lvt w=(215n) l=45n nf=1 m=(1)
mp1 (n8 n0 VDD VDD) g45p1lvt w=(215n) l=45n nf=1 m=(1)
mp12 (Y n6 VDD VDD) g45p1lvt w=(1.56u) l=45n nf=1 m=(1)
mp0 (n0 A VDD VDD) g45p1lvt w=(215n) l=45n nf=1 m=(1)
mp11 (n6 n5 VDD VDD) g45p1lvt w=(390n) l=45n nf=1 m=(1)
mn10 (n5 VDD n15 VSS) g45n1lvt w=(145n) l=45n nf=1 m=(1)
mn9 (n15 n4 VSS VSS) g45n1lvt w=(145n) l=45n nf=1 m=(1)
mn8 (n4 VDD n13 VSS) g45n1lvt w=(145n) l=45n nf=1 m=(1)
mn7 (n13 n3 VSS VSS) g45n1lvt w=(145n) l=45n nf=1 m=(1)
mn6 (n3 VDD n11 VSS) g45n1lvt w=(145n) l=45n nf=1 m=(1)
mn5 (n11 n2 VSS VSS) g45n1lvt w=(145n) l=45n nf=1 m=(1)
mn4 (n2 VDD n9 VSS) g45n1lvt w=(145n) l=45n nf=1 m=(1)
mn3 (n9 n1 VSS VSS) g45n1lvt w=(145n) l=45n nf=1 m=(1)
mn2 (n1 VDD n7 VSS) g45n1lvt w=(145n) l=45n nf=1 m=(1)
mn1 (n7 n0 VSS VSS) g45n1lvt w=(145n) l=45n nf=1 m=(1)
mn11 (n6 n5 VSS VSS) g45n1lvt w=(260n) l=45n nf=1 m=(1)
mn12 (Y n6 VSS VSS) g45n1lvt w=(1.04u) l=45n nf=1 m=(1)
mn0 (n0 A VSS VSS) g45n1lvt w=(145n) l=45n nf=1 m=(1)
ends DLY3X4
