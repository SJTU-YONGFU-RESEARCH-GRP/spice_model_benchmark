// Generated for: spectre (May  1 11:28:07 2013 )
// Library name: gsclib045_backbias
// Cell name: BUFX6
// View name: extracted

simulator lang=spectre

subckt BUFX6 A NW VDD VSS Y
mp1 (Y n0 \1\:VDD NW) g45p1svt w=(4.7e-07) l=4.5e-08 nf=1 as=7.424e-14 \
        ad=7.332e-14 ps=1.26e-06 pd=1.252e-06 nrd=1.16667 nrs=1.16667 \
        sa=1.4e-07 sb=1.2934e-06 sd=160n sca=40.6416 scb=0.0369115 \
        scc=0.00420297 m=(5)
C1 (NW VSS) capacitor c=2.24752e-16
C2 (VDD VSS) capacitor c=3.64324e-17
C3 (A VSS) capacitor c=3.54023e-17
C4 (Y VSS) capacitor c=4.73264e-16
C5 (n0 VSS) capacitor c=3.00249e-16
C6 (\1\:A VSS) capacitor c=1.55664e-16
C7 (\6\:A VSS) capacitor c=1.06276e-17
C8 (\1\:VDD VSS) capacitor c=5.04939e-16
C9 (\17\:n0 VSS) capacitor c=7.78215e-17
C10 (\21\:n0 VSS) capacitor c=5.79466e-17
C11 (\19\:n0 VSS) capacitor c=4.30942e-17
C12 (\20\:n0 VSS) capacitor c=3.3815e-17
C13 (\8\:A VSS) capacitor c=2.90062e-17
Rk27 (\1\:VSS VSS) resistor r=0.1024 c=0
Rk19 (\1\:VDD VDD) resistor r=0.1024 c=0
Rk13 (\8\:A \9\:A) resistor r=0.006005 c=0
Rk14 (\10\:A A) resistor r=0.006353 c=0
Rk15 (\9\:A \10\:A) resistor r=0.03706 c=0
Rk10 (\18\:n0 \19\:n0) resistor r=0.2612 c=0
Rk11 (\19\:n0 \20\:n0) resistor r=0.1652 c=0
Rk12 (\19\:n0 \22\:n0) resistor r=0.2473 c=0
Rl20 (\1\:A \6\:A) resistor r=4.8851 c=0
Rl8 (n0 \9\:n0) resistor r=3.8088 c=0
Rz4 (\22\:n0 \21\:n0) resistor r=37.5 c=0
Ry4 (\18\:n0 \17\:n0) resistor r=20.6667 c=0
Rx2 (\8\:A \6\:A) resistor r=45 c=0
Rx1 (\20\:n0 \9\:n0) resistor r=45 c=0
mn1 (\1\:VSS n0 Y VSS) g45n1svt w=(3.1e-07) l=4.5e-08 nf=1 as=4.836e-14 \
        ad=4.9e-14 ps=9.32e-07 pd=9.4e-07 nrd=1.16667 nrs=1.16667 \
        sa=1.4e-07 sb=1.29742e-06 sd=160n sca=15.9751 scb=0.0153507 \
        scc=0.00137372 m=(5)
mn0 (\1\:VSS \1\:A \21\:n0 VSS) g45n1svt w=(2.6e-07) l=4.5e-08 nf=1 \
        as=4.16e-14 ad=4.15e-14 ps=8.4e-07 pd=8.7e-07 nrd=1.16667 \
        nrs=1.16667 sa=1.165e-06 sb=3.45e-07 sd=160n sca=12.8392 \
        scb=0.0126987 scc=0.00074151 m=(2)
mp0 (\17\:n0 \1\:A \1\:VDD NW) g45p1svt w=(3.9e-07) l=4.5e-08 nf=1 \
        as=6.25e-14 ad=6.24e-14 ps=1.16e-06 pd=1.1e-06 nrd=1.16667 \
        nrs=1.16667 sa=1.165e-06 sb=3.45e-07 sd=160n sca=32.0467 \
        scb=0.0213026 scc=0.00336306 m=(2)
ends BUFX6
// End of subcircuit definition.
