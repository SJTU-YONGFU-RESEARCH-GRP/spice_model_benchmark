// Generated for: spectre (May  1 08:11:34 2013 )
// Library name: gsclib045
// Cell name: ISOHX1_OFF
// View name: extracted

simulator lang=spectre

subckt ISOHX1_OFF A ExtVDD ISO VSS Y
mp0 (n1 \1\:A \5\:ExtVDD ExtVDD) g45p1svt w=(2.15e-07) l=4.5e-08 nf=1 \
        as=1.29e-14 ad=3.01e-14 ps=5.5e-07 pd=7.1e-07 nrd=1.16667 \
        nrs=1.16667 sa=1.4e-07 sb=2.45e-07 sd=160n sca=22.4693 \
        scb=0.0242319 scc=0.00195457 m=(1)
mp1 (\8\:n0 \1\:ISO n1 ExtVDD) g45p1svt w=(2.15e-07) l=4.5e-08 nf=1 \
        as=3.01e-14 ad=1.29e-14 ps=7.1e-07 pd=5.5e-07 nrd=1.16667 \
        nrs=1.16667 sa=2.45e-07 sb=1.4e-07 sd=160n sca=13.6327 \
        scb=0.0135423 scc=0.000359605 m=(1)
C1 (ExtVDD VSS) capacitor c=2.96759e-16
C2 (Y VSS) capacitor c=4.31542e-17
C3 (A VSS) capacitor c=2.0322e-17
C4 (VDD VSS) capacitor c=1.41676e-16
C5 (ISO VSS) capacitor c=2.45155e-17
C6 (n0 VSS) capacitor c=2.74179e-17
C7 (\3\:n0 VSS) capacitor c=4.64117e-17
C8 (\1\:ISO VSS) capacitor c=7.36989e-17
C9 (\1\:A VSS) capacitor c=6.51132e-17
C10 (\3\:ISO VSS) capacitor c=3.24884e-17
C11 (\3\:A VSS) capacitor c=5.13458e-17
C12 (\2\:n0 VSS) capacitor c=2.66334e-17
C13 (\2\:ISO VSS) capacitor c=5.41884e-17
C14 (\2\:A VSS) capacitor c=6.79445e-17
C15 (\1\:Y VSS) capacitor c=5.68987e-17
C16 (\1\:ExtVDD VSS) capacitor c=5.77469e-17
C17 (\8\:n0 VSS) capacitor c=6.83734e-17
C18 (\5\:ExtVDD VSS) capacitor c=1.1507e-16
C19 (\3\:Y VSS) capacitor c=5.66369e-17
C20 (\6\:n0 VSS) capacitor c=7.18028e-17
C21 (VDD VSS) capacitor c=1.61555e-16
C22 (\4\:A VSS) capacitor c=2.00396e-17
C23 (\5\:ISO VSS) capacitor c=9.89236e-18
C24 (\7\:ISO VSS) capacitor c=3.70756e-17
C25 (\4\:n0 VSS) capacitor c=7.29981e-17
C26 (\5\:n0 VSS) capacitor c=1.2266e-16
Rk8 (ExtVDD ExtVDD) resistor r=0.002413 c=0
Rk7 (\2\:ExtVDD ExtVDD) resistor r=0.4341 c=0
Rk10 (ExtVDD \6\:ExtVDD) resistor r=1.0207 c=0
Rk14 (Y \2\:Y) resistor r=0.2855 c=0
Rk15 (Y \4\:Y) resistor r=0.338 c=0
Rk1 (\4\:A A) resistor r=0.02992 c=0
Rk27 (VDD VDD) resistor r=0.1725 c=0
Rk18 (VSS VSS) resistor r=0.08927 c=0
Rk17 (\3\:VSS VSS) resistor r=0.1226 c=0
Rk16 (\2\:VSS \3\:VSS) resistor r=0.4293 c=0
Rk19 (VSS \4\:VSS) resistor r=0.03402 c=0
Rk20 (\4\:VSS \5\:VSS) resistor r=0.06254 c=0
Rk21 (\5\:VSS \7\:VSS) resistor r=0.4305 c=0
Rk22 (\3\:VSS \9\:VSS) resistor r=0.2248 c=0
Rk23 (\5\:VSS \11\:VSS) resistor r=0.2051 c=0
Rk24 (\13\:VSS VSS) resistor r=0.5788 c=0
Rk26 (\14\:VSS VSS) resistor r=0.1035 c=0
Rk25 (VSS \14\:VSS) resistor r=0.09675 c=0
Rk2 (\4\:ISO ISO) resistor r=0.003933 c=0
Rk3 (ISO \5\:ISO) resistor r=0.003933 c=0
Rk4 (\4\:ISO \5\:ISO) resistor r=0.03257 c=0
Rk6 (\5\:ISO \7\:ISO) resistor r=0.02268 c=0
Rk5 (\6\:ISO \7\:ISO) resistor r=0.003933 c=0
Rk11 (\4\:n0 \5\:n0) resistor r=0.4359 c=0
Rk12 (\5\:n0 \7\:n0) resistor r=0.3811 c=0
Rk13 (\5\:n0 \9\:n0) resistor r=0.427 c=0
Rl1 (\1\:A \2\:A) resistor r=102.646 c=0
Rl2 (\2\:A \3\:A) resistor r=166.884 c=0
Rl3 (\1\:ISO \2\:ISO) resistor r=155.766 c=0
Rl4 (\2\:ISO \3\:ISO) resistor r=82.6066 c=0
Rl6 (\2\:n0 \3\:n0) resistor r=133.743 c=0
Rl5 (n0 \2\:n0) resistor r=45.3288 c=0
Rz3 (\3\:Y \4\:Y) resistor r=37.5 c=0
Rz4 (\6\:VSS \7\:VSS) resistor r=75 c=0
Rz5 (\8\:VSS \9\:VSS) resistor r=37.5 c=0
Rz6 (\10\:VSS \11\:VSS) resistor r=75 c=0
Rz2 (\6\:n0 \7\:n0) resistor r=75 c=0
Ry1 (\1\:ExtVDD \2\:ExtVDD) resistor r=20.6667 c=0
Ry2 (\5\:ExtVDD \6\:ExtVDD) resistor r=62 c=0
Ry4 (\1\:Y \2\:Y) resistor r=20.6667 c=0
Ry5 (\1\:VSS \2\:VSS) resistor r=31 c=0
Ry6 (\1\:VSS \4\:VSS) resistor r=5.1667 c=0
Ry7 (\12\:VSS \13\:VSS) resistor r=31 c=0
Ry8 (\12\:VSS \14\:VSS) resistor r=5.1667 c=0
Ry3 (\8\:n0 \9\:n0) resistor r=62 c=0
Rx1 (\2\:A \4\:A) resistor r=45 c=0
Rx2 (\2\:ISO \6\:ISO) resistor r=45 c=0
Rx3 (\2\:n0 \4\:n0) resistor r=45 c=0
mn0 (\6\:n0 \3\:A \6\:VSS VSS) g45n1svt w=(1.45e-07) l=4.5e-08 nf=1 \
        as=2.32e-14 ad=2.03e-14 ps=6.1e-07 pd=5.7e-07 nrd=1.16667 \
        nrs=1.16667 sa=1.4e-07 sb=3.45e-07 sd=160n sca=10.0732 \
        scb=0.00911402 scc=0.000253284 m=(1)
mn1 (\6\:n0 \3\:ISO \10\:VSS VSS) g45n1svt w=(1.45e-07) l=4.5e-08 nf=1 \
        as=2.03e-14 ad=2.32e-14 ps=5.7e-07 pd=6.1e-07 nrd=1.16667 \
        nrs=1.16667 sa=3.45e-07 sb=1.4e-07 sd=160n sca=10.0732 \
        scb=0.00911402 scc=0.000253284 m=(1)
mn2 (\3\:Y n0 \8\:VSS VSS) g45n1svt w=(2.6e-07) l=4.5e-08 nf=1 \
        as=3.64e-14 ad=3.64e-14 ps=8e-07 pd=8e-07 nrd=1.16667 nrs=1.16667 \
        sa=1.4e-07 sb=1.4e-07 sd=160n sca=12.1772 scb=0.0118935 \
        scc=0.000630577 m=(1)
mp2 (\1\:Y \3\:n0 \1\:ExtVDD ExtVDD) g45p1svt w=(3.9e-07) l=4.5e-08 nf=1 \
        as=5.46e-14 ad=5.46e-14 ps=1.06e-06 pd=1.06e-06 nrd=1.16667 \
        nrs=1.16667 sa=1.4e-07 sb=1.4e-07 sd=160n sca=25.7882 \
        scb=0.0272171 scc=0.00268607 m=(1)
ends ISOHX1_OFF
// End of subcircuit definition.
