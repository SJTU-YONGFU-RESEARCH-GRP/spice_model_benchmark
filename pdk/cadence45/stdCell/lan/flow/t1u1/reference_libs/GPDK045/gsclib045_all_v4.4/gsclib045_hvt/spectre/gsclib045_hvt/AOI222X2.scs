// gsclib045_hvt/AOI222X2/schematic

simulator lang=spectre

subckt AOI222X2 A0 A1 B0 B1 C0 C1 Y VSS VDD
mp5 (Y C1 net134 VDD) g45p1hvt w=(780n) l=45n nf=1 m=(1)
mp4 (Y C0 net134 VDD) g45p1hvt w=(780n) l=45n nf=1 m=(1)
mp3 (net134 B1 net126 VDD) g45p1hvt w=(780n) l=45n nf=1 m=(1)
mp2 (net134 B0 net126 VDD) g45p1hvt w=(780n) l=45n nf=1 m=(1)
mp0 (net126 A0 VDD VDD) g45p1hvt w=(780n) l=45n nf=1 m=(1)
mp1 (net126 A1 VDD VDD) g45p1hvt w=(780n) l=45n nf=1 m=(1)
mn5 (Y C1 net155 VSS) g45n1hvt w=(520n) l=45n nf=1 m=(1)
mn4 (net155 C0 VSS VSS) g45n1hvt w=(520n) l=45n nf=1 m=(1)
mn2 (net151 B0 VSS VSS) g45n1hvt w=(520n) l=45n nf=1 m=(1)
mn0 (net147 A0 VSS VSS) g45n1hvt w=(520n) l=45n nf=1 m=(1)
mn1 (Y A1 net147 VSS) g45n1hvt w=(520n) l=45n nf=1 m=(1)
mn3 (Y B1 net151 VSS) g45n1hvt w=(520n) l=45n nf=1 m=(1)
ends AOI222X2
