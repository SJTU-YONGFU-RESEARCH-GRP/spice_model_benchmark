// Generated for: spectre (May  1 11:29:15 2013 )
// Library name: gsclib045_backbias
// Cell name: DLY1X1
// View name: extracted

simulator lang=spectre

subckt DLY1X1 A NW VDD VSS Y
mp0 (\8\:n0 \1\:A \8\:VDD NW) g45p1svt w=(2.15e-07) l=4.5e-08 nf=1 \
        as=3.44e-14 ad=3.655e-14 ps=7.5e-07 pd=7.7e-07 nrd=1.16667 \
        nrs=1.16667 sa=1.7e-07 sb=5.85e-07 sd=160n sca=34.7345 \
        scb=0.0347529 scc=0.00361149 m=(1)
mp1 (n5 n0 \8\:VDD NW) g45p1svt w=(2.15e-07) l=4.5e-08 nf=1 as=3.44e-14 \
        ad=4.193e-14 ps=7.5e-07 pd=8.2e-07 nrd=1.16667 nrs=1.16667 \
        sa=3.75e-07 sb=3.8e-07 sd=160n sca=29.5145 scb=0.0258721 \
        scc=0.00324978 m=(1)
mp2 (\8\:n1 \2\:VSS n5 NW) g45p1svt w=(2.15e-07) l=4.5e-08 nf=1 \
        as=4.193e-14 ad=3.01e-14 ps=8.2e-07 pd=7.1e-07 nrd=1.16667 \
        nrs=1.16667 sa=6.15e-07 sb=1.4e-07 sd=160n sca=27.7866 \
        scb=0.0238669 scc=0.00324002 m=(1)
mp3 (\8\:n2 n1 \3\:VDD NW) g45p1svt w=(2.15e-07) l=4.5e-08 nf=1 \
        as=6.535e-14 ad=3.01e-14 ps=1.16e-06 pd=7.1e-07 nrd=1.16667 \
        nrs=1.16667 sa=1.4e-07 sb=3.75e-07 sd=160n sca=48.724 scb=0.031482 \
        scc=0.00590454 m=(1)
C1 (NW VSS) capacitor c=2.62628e-16
C2 (Y VSS) capacitor c=2.54847e-17
C3 (VDD VSS) capacitor c=3.54163e-17
C4 (A VSS) capacitor c=8.4435e-17
C5 (n0 VSS) capacitor c=5.79695e-17
C6 (n1 VSS) capacitor c=3.82999e-17
C7 (n2 VSS) capacitor c=4.69384e-17
C8 (n5 VSS) capacitor c=2.62229e-18
C9 (\1\:A VSS) capacitor c=2.95229e-17
C10 (\4\:n2 VSS) capacitor c=3.5342e-17
C11 (\3\:n1 VSS) capacitor c=3.21896e-17
C12 (\1\:VDD VSS) capacitor c=4.48904e-17
C13 (\3\:n0 VSS) capacitor c=3.24146e-17
C14 (\3\:A VSS) capacitor c=5.11216e-17
C15 (\3\:n2 VSS) capacitor c=1.726e-17
C16 (\2\:n1 VSS) capacitor c=2.63843e-17
C17 (\2\:VDD VSS) capacitor c=3.96155e-17
C18 (\2\:n0 VSS) capacitor c=5.23914e-17
C19 (\2\:A VSS) capacitor c=3.81271e-17
C20 (\3\:Y VSS) capacitor c=6.38368e-17
C21 (\3\:VDD VSS) capacitor c=1.22998e-16
C22 (\8\:n2 VSS) capacitor c=5.32235e-17
C23 (\8\:n1 VSS) capacitor c=5.0167e-17
C24 (\8\:VDD VSS) capacitor c=2.78399e-17
C25 (\8\:n0 VSS) capacitor c=4.11999e-17
C26 (\1\:Y VSS) capacitor c=1.56035e-17
C27 (\5\:n2 VSS) capacitor c=5.03688e-17
C28 (\6\:n1 VSS) capacitor c=7.46699e-17
C29 (\6\:n0 VSS) capacitor c=2.13963e-17
C30 (\2\:n2 VSS) capacitor c=1.3386e-17
C31 (\4\:n0 VSS) capacitor c=4.56463e-17
C32 (\5\:n0 VSS) capacitor c=3.54597e-17
C33 (\4\:A VSS) capacitor c=3.16811e-17
C34 (\4\:n1 VSS) capacitor c=5.05632e-17
C35 (\5\:n1 VSS) capacitor c=9.20113e-17
C36 (\7\:n2 VSS) capacitor c=8.90723e-17
C37 (\5\:VDD VSS) capacitor c=8.04245e-17
C38 (\6\:VDD VSS) capacitor c=3.21886e-17
C39 (\7\:VDD VSS) capacitor c=1.22722e-16
Rk17 (\4\:VSS \6\:VSS) resistor r=0.5668 c=0
Rk18 (\6\:VSS \7\:VSS) resistor r=0.1151 c=0
Rk20 (\8\:VSS VSS) resistor r=0.1424 c=0
Rk19 (\7\:VSS \8\:VSS) resistor r=0.1425 c=0
Rk21 (\7\:VSS \9\:VSS) resistor r=0.7178 c=0
Rk22 (\8\:VSS \11\:VSS) resistor r=0.1777 c=0
Rk10 (Y \2\:Y) resistor r=0.05091 c=0
Rk11 (Y \4\:Y) resistor r=0.2575 c=0
Rk12 (\4\:VDD \5\:VDD) resistor r=0.7467 c=0
Rk14 (\6\:VDD VDD) resistor r=0.1424 c=0
Rk13 (\5\:VDD \6\:VDD) resistor r=0.1425 c=0
Rk15 (\5\:VDD \7\:VDD) resistor r=0.7156 c=0
Rk16 (\6\:VDD \9\:VDD) resistor r=0.3858 c=0
Rk4 (\4\:A A) resistor r=0.08652 c=0
Rk1 (\4\:n0 \5\:n0) resistor r=0.1949 c=0
Rk2 (\5\:n0 \7\:n0) resistor r=0.1249 c=0
Rk3 (\5\:n0 \9\:n0) resistor r=0.3618 c=0
Rk5 (\4\:n1 \5\:n1) resistor r=0.1846 c=0
Rk6 (\5\:n1 \7\:n1) resistor r=0.4884 c=0
Rk7 (\5\:n1 \9\:n1) resistor r=0.2867 c=0
Rk8 (\6\:n2 \7\:n2) resistor r=0.2686 c=0
Rk9 (\7\:n2 \9\:n2) resistor r=0.3492 c=0
Rl6 (\1\:VSS \2\:VSS) resistor r=66.8207 c=0
Rl5 (\1\:VDD \2\:VDD) resistor r=93.4636 c=0
Rl1 (\1\:A \2\:A) resistor r=29.5379 c=0
Rl2 (\2\:A \3\:A) resistor r=162.23 c=0
Rl3 (n0 \2\:n0) resistor r=162.23 c=0
Rl4 (\2\:n0 \3\:n0) resistor r=29.5379 c=0
Rl7 (n1 \2\:n1) resistor r=29.5379 c=0
Rl8 (\2\:n1 \3\:n1) resistor r=44.9225 c=0
Rl9 (n2 \2\:n2) resistor r=57.4064 c=0
Rl11 (\2\:n2 \4\:n2) resistor r=34.3295 c=0
Rl10 (\2\:n2 \3\:n2) resistor r=1.2666 c=0
Rz5 (\3\:VSS \4\:VSS) resistor r=75 c=0
Rz6 (\10\:VSS \11\:VSS) resistor r=75 c=0
Rz4 (\1\:Y \2\:Y) resistor r=75 c=0
Rz1 (\6\:n0 \7\:n0) resistor r=75 c=0
Rz2 (\6\:n1 \7\:n1) resistor r=75 c=0
Rz3 (\5\:n2 \6\:n2) resistor r=75 c=0
Ry4 (\3\:Y \4\:Y) resistor r=20.6667 c=0
Ry5 (\3\:VDD \4\:VDD) resistor r=62 c=0
Ry6 (\8\:VDD \9\:VDD) resistor r=62 c=0
Ry1 (\8\:n0 \9\:n0) resistor r=62 c=0
Ry2 (\8\:n1 \9\:n1) resistor r=62 c=0
Ry3 (\8\:n2 \9\:n2) resistor r=62 c=0
Rx6 (\1\:VSS \9\:VSS) resistor r=45 c=0
Rx5 (\2\:VDD \7\:VDD) resistor r=45 c=0
Rx2 (\2\:A \4\:A) resistor r=45 c=0
Rx1 (\2\:n0 \4\:n0) resistor r=45 c=0
Rx3 (\2\:n1 \4\:n1) resistor r=45 c=0
Rx4 (\3\:n2 \7\:n2) resistor r=45 c=0
mn0 (\6\:n0 \3\:A \10\:VSS VSS) g45n1svt w=(1.45e-07) l=4.5e-08 nf=1 \
        as=2.32e-14 ad=2.465e-14 ps=6.1e-07 pd=6.3e-07 nrd=1.16667 \
        nrs=1.16667 sa=1.7e-07 sb=5.85e-07 sd=160n sca=6.67224 \
        scb=0.00331168 scc=2.36561e-05 m=(1)
mn1 (n4 \3\:n0 \10\:VSS VSS) g45n1svt w=(1.45e-07) l=4.5e-08 nf=1 \
        as=2.32e-14 ad=1.885e-14 ps=6.1e-07 pd=5.5e-07 nrd=1.16667 \
        nrs=1.16667 sa=3.75e-07 sb=3.8e-07 sd=160n sca=6.67224 \
        scb=0.00331168 scc=2.36561e-05 m=(1)
mn2 (\6\:n1 \1\:VDD n4 VSS) g45n1svt w=(1.45e-07) l=4.5e-08 nf=1 \
        as=1.885e-14 ad=2.973e-14 ps=5.5e-07 pd=7e-07 nrd=1.16667 \
        nrs=1.16667 sa=5.5e-07 sb=2.05e-07 sd=160n sca=6.67224 \
        scb=0.00331168 scc=2.36561e-05 m=(1)
mn3 (\5\:n2 \3\:n1 \3\:VSS VSS) g45n1svt w=(1.45e-07) l=4.5e-08 nf=1 \
        as=4.365e-14 ad=2.03e-14 ps=9e-07 pd=5.7e-07 nrd=1.16667 \
        nrs=1.16667 sa=1.4e-07 sb=3.75e-07 sd=160n sca=19.8813 \
        scb=0.0206549 scc=0.00197265 m=(1)
mn4 (\1\:Y \4\:n2 \3\:VSS VSS) g45n1svt w=(2.6e-07) l=4.5e-08 nf=1 \
        as=4.365e-14 ad=3.64e-14 ps=9e-07 pd=8e-07 nrd=1.16667 nrs=1.16667 \
        sa=2.71058e-07 sb=1.4e-07 sd=160n sca=15.3338 scb=0.0153436 \
        scc=0.00119435 m=(1)
mp4 (\3\:Y n2 \3\:VDD NW) g45p1svt w=(3.9e-07) l=4.5e-08 nf=1 \
        as=6.535e-14 ad=5.46e-14 ps=1.16e-06 pd=1.06e-06 nrd=1.16667 \
        nrs=1.16667 sa=2.69551e-07 sb=1.4e-07 sd=160n sca=43.1032 \
        scb=0.0380646 scc=0.00455683 m=(1)
ends DLY1X1
// End of subcircuit definition.
