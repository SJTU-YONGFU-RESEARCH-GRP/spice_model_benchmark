// gsclib045_lvt/NAND4BBX4/schematic

simulator lang=spectre

subckt NAND4BBX4 AN BN C D Y VDD VSS
mp2 (Y n0 VDD VDD) g45p1lvt w=(1.56u) l=45n nf=1 m=(1)
mp0 (n0 AN VDD VDD) g45p1lvt w=(390n) l=45n nf=1 m=(1)
mp5 (Y D VDD VDD) g45p1lvt w=(1.56u) l=45n nf=1 m=(1)
mp4 (Y C VDD VDD) g45p1lvt w=(1.56u) l=45n nf=1 m=(1)
mp1 (n1 BN VDD VDD) g45p1lvt w=(390n) l=45n nf=1 m=(1)
mp3 (Y n1 VDD VDD) g45p1lvt w=(1.56u) l=45n nf=1 m=(1)
mn1 (n1 BN VSS VSS) g45n1lvt w=(260n) l=45n nf=1 m=(1)
mn2 (n4 n0 VSS VSS) g45n1lvt w=(1.04u) l=45n nf=1 m=(1)
mn4 (n2 C n3 VSS) g45n1lvt w=(1.04u) l=45n nf=1 m=(1)
mn5 (Y D n2 VSS) g45n1lvt w=(1.04u) l=45n nf=1 m=(1)
mn0 (n0 AN VSS VSS) g45n1lvt w=(260n) l=45n nf=1 m=(1)
mn3 (n3 n1 n4 VSS) g45n1lvt w=(1.04u) l=45n nf=1 m=(1)
ends NAND4BBX4
