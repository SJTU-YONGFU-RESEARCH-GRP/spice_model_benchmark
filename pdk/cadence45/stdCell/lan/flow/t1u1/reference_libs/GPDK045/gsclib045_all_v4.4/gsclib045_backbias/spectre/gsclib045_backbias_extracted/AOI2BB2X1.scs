// Generated for: spectre (May  1 11:27:46 2013 )
// Library name: gsclib045_backbias
// Cell name: AOI2BB2X1
// View name: extracted

simulator lang=spectre

subckt AOI2BB2X1 A0N A1N B0 B1 NW VDD VSS Y
mp1 (\4\:n1 \1\:A1N \4\:VDD NW) g45p1svt w=(2.15e-07) l=4.5e-08 nf=1 \
        as=3.548e-14 ad=3.655e-14 ps=7.6e-07 pd=7.7e-07 nrd=1.16667 \
        nrs=1.16667 sa=1.7e-07 sb=3.5e-07 sd=160n sca=20.0627 \
        scb=0.0223685 scc=0.000742304 m=(1)
mp0 (\6\:n0 \3\:A0N \4\:VDD NW) g45p1svt w=(2.15e-07) l=4.5e-08 nf=1 \
        as=3.548e-14 ad=3.01e-14 ps=7.6e-07 pd=7.1e-07 nrd=1.16667 \
        nrs=1.16667 sa=3.8e-07 sb=1.4e-07 sd=160n sca=13.9338 \
        scb=0.0121124 scc=0.00023362 m=(1)
C1 (A0N VSS) capacitor c=5.83417e-17
C2 (B0 VSS) capacitor c=1.87804e-17
C3 (A1N VSS) capacitor c=5.43238e-17
C4 (NW VSS) capacitor c=2.80535e-16
C5 (Y VSS) capacitor c=2.81816e-17
C6 (VDD VSS) capacitor c=3.68684e-17
C7 (B1 VSS) capacitor c=2.99196e-17
C8 (n1 VSS) capacitor c=5.79347e-17
C9 (n0 VSS) capacitor c=3.89407e-17
C10 (n2 VSS) capacitor c=2.72591e-18
C11 (n3 VSS) capacitor c=9.12392e-18
C12 (n4 VSS) capacitor c=4.21968e-17
C13 (\1\:B0 VSS) capacitor c=4.42745e-17
C14 (\1\:B1 VSS) capacitor c=4.10917e-17
C15 (\3\:n0 VSS) capacitor c=4.62718e-17
C16 (\3\:A0N VSS) capacitor c=3.26023e-17
C17 (\1\:A1N VSS) capacitor c=4.32831e-17
C18 (\3\:B0 VSS) capacitor c=3.90126e-17
C19 (\4\:B1 VSS) capacitor c=5.35834e-17
C20 (\3\:n1 VSS) capacitor c=3.63051e-17
C21 (\1\:A0N VSS) capacitor c=3.6942e-17
C22 (\3\:A1N VSS) capacitor c=2.63198e-17
C23 (\4\:B0 VSS) capacitor c=1.23836e-17
C24 (\3\:B1 VSS) capacitor c=1.70874e-17
C25 (\2\:n1 VSS) capacitor c=4.02976e-17
C26 (\2\:n0 VSS) capacitor c=3.38295e-17
C27 (\2\:A0N VSS) capacitor c=3.5824e-17
C28 (\2\:A1N VSS) capacitor c=3.3674e-17
C29 (\1\:Y VSS) capacitor c=1.13617e-16
C30 (\3\:n4 VSS) capacitor c=7.32918e-17
C31 (\1\:VDD VSS) capacitor c=1.78323e-16
C32 (\5\:n4 VSS) capacitor c=6.00871e-17
C33 (\6\:n0 VSS) capacitor c=6.40732e-17
C34 (\4\:VDD VSS) capacitor c=3.5594e-17
C35 (\4\:n1 VSS) capacitor c=5.42105e-17
C36 (\3\:Y VSS) capacitor c=9.94278e-17
C37 (\8\:n0 VSS) capacitor c=2.57684e-17
C38 (\6\:n1 VSS) capacitor c=1.26933e-16
C39 (\2\:B1 VSS) capacitor c=2.71219e-17
C40 (\2\:B0 VSS) capacitor c=2.41282e-17
C41 (\4\:A1N VSS) capacitor c=5.33688e-17
C42 (\4\:A0N VSS) capacitor c=5.67496e-17
C43 (\4\:n0 VSS) capacitor c=5.22508e-17
C44 (\5\:n0 VSS) capacitor c=5.40022e-17
C45 (\8\:n1 VSS) capacitor c=1.68242e-16
C46 (\5\:B1 VSS) capacitor c=1.0009e-16
C47 (\5\:B0 VSS) capacitor c=8.02673e-17
C48 (\3\:VDD VSS) capacitor c=7.0148e-17
Rk2 (\4\:A0N A0N) resistor r=0.1907 c=0
Rk15 (B0 \5\:B0) resistor r=0.02177 c=0
Rk16 (\2\:VSS \4\:VSS) resistor r=0.6122 c=0
Rk18 (\5\:VSS VSS) resistor r=0.1474 c=0
Rk17 (\4\:VSS \5\:VSS) resistor r=0.303 c=0
Rk19 (\4\:VSS \7\:VSS) resistor r=0.2392 c=0
Rk20 (\5\:VSS \9\:VSS) resistor r=0.07346 c=0
Rk1 (\4\:A1N A1N) resistor r=0.1524 c=0
Rk12 (\4\:Y Y) resistor r=0.01611 c=0
Rk11 (\2\:Y \4\:Y) resistor r=0.6902 c=0
Rk22 (\3\:VDD VDD) resistor r=0.1324 c=0
Rk21 (\2\:VDD \3\:VDD) resistor r=0.7045 c=0
Rk23 (\3\:VDD \5\:VDD) resistor r=0.2728 c=0
Rk10 (\5\:B1 B1) resistor r=0.01497 c=0
Rk6 (\5\:n1 \7\:n1) resistor r=0.4253 c=0
Rk7 (\7\:n1 \8\:n1) resistor r=1.0427 c=0
Rk3 (\4\:n0 \5\:n0) resistor r=0.248 c=0
Rk4 (\5\:n0 \7\:n0) resistor r=0.4196 c=0
Rk5 (\5\:n0 \9\:n0) resistor r=0.06021 c=0
Rk13 (\2\:n4 \4\:n4) resistor r=0.4736 c=0
Rk14 (\4\:n4 \6\:n4) resistor r=0.4226 c=0
Rl4 (\2\:A0N \3\:A0N) resistor r=74.1758 c=0
Rl3 (\1\:A0N \2\:A0N) resistor r=76.9231 c=0
Rl12 (\1\:B0 \2\:B0) resistor r=92.9709 c=0
Rl13 (\2\:B0 \3\:B0) resistor r=52.2314 c=0
Rl14 (\2\:B0 \4\:B0) resistor r=5.1011 c=0
Rl1 (\1\:A1N \2\:A1N) resistor r=119.922 c=0
Rl2 (\2\:A1N \3\:A1N) resistor r=29.5379 c=0
Rl9 (\1\:B1 \2\:B1) resistor r=37.3411 c=0
Rl11 (\2\:B1 \4\:B1) resistor r=114.264 c=0
Rl10 (\2\:B1 \3\:B1) resistor r=1.2301 c=0
Rl7 (n1 \2\:n1) resistor r=106.461 c=0
Rl8 (\2\:n1 \3\:n1) resistor r=29.5379 c=0
Rl6 (\2\:n0 \3\:n0) resistor r=87.6365 c=0
Rl5 (n0 \2\:n0) resistor r=46.6893 c=0
Rz4 (\1\:VSS \2\:VSS) resistor r=75 c=0
Rz5 (\6\:VSS \7\:VSS) resistor r=75 c=0
Rz6 (\8\:VSS \9\:VSS) resistor r=75 c=0
Rz3 (\3\:Y \4\:Y) resistor r=75 c=0
Rz2 (\6\:n1 \7\:n1) resistor r=75 c=0
Rz1 (\8\:n0 \9\:n0) resistor r=75 c=0
Ry3 (\1\:Y \2\:Y) resistor r=62 c=0
Ry8 (\1\:VDD \2\:VDD) resistor r=62 c=0
Ry9 (\4\:VDD \5\:VDD) resistor r=62 c=0
Ry2 (\4\:n1 \5\:n1) resistor r=62 c=0
Ry1 (\6\:n0 \7\:n0) resistor r=62 c=0
Ry4 (n4 \2\:n4) resistor r=31 c=0
Ry5 (\3\:n4 \4\:n4) resistor r=31 c=0
Ry6 (\5\:n4 \6\:n4) resistor r=31 c=0
Rx2 (\2\:A0N \4\:A0N) resistor r=45 c=0
Rx6 (\4\:B0 \5\:B0) resistor r=45 c=0
Rx1 (\2\:A1N \4\:A1N) resistor r=45 c=0
Rx5 (\3\:B1 \5\:B1) resistor r=45 c=0
Rx4 (\2\:n1 \8\:n1) resistor r=45 c=0
Rx3 (\2\:n0 \4\:n0) resistor r=45 c=0
mn1 (\6\:n1 \3\:A1N \8\:VSS VSS) g45n1svt w=(1.45e-07) l=4.5e-08 nf=1 \
        as=8.41e-14 ad=2.465e-14 ps=1.6e-06 pd=6.3e-07 nrd=1.16667 \
        nrs=1.16667 sa=1.7e-07 sb=4.9e-07 sd=160n sca=23.279 scb=0.0230742 \
        scc=0.00267719 m=(1)
mn0 (\8\:n0 \1\:A0N \8\:VSS VSS) g45n1svt w=(1.45e-07) l=4.5e-08 nf=1 \
        as=8.41e-14 ad=3.263e-14 ps=1.6e-06 pd=7.4e-07 nrd=1.16667 \
        nrs=1.16667 sa=4.35e-07 sb=2.25e-07 sd=160n sca=23.279 \
        scb=0.0230742 scc=0.00267719 m=(1)
mn2 (n2 n0 \6\:VSS VSS) g45n1svt w=(2.6e-07) l=4.5e-08 nf=1 as=3.64e-14 \
        ad=3.12e-14 ps=8e-07 pd=7.6e-07 nrd=1.16667 nrs=1.16667 sa=1.4e-07 \
        sb=7.3e-07 sd=160n sca=8.65991 scb=0.00681295 scc=0.000165238 \
        m=(1)
mn3 (\3\:Y \3\:n1 n2 VSS) g45n1svt w=(2.6e-07) l=4.5e-08 nf=1 as=3.12e-14 \
        ad=5.72e-14 ps=7.6e-07 pd=9.6e-07 nrd=1.16667 nrs=1.16667 \
        sa=3.05e-07 sb=5.65e-07 sd=160n sca=8.65991 scb=0.00681295 \
        scc=0.000165238 m=(1)
mn5 (n3 \4\:B1 \3\:Y VSS) g45n1svt w=(2.6e-07) l=4.5e-08 nf=1 as=5.72e-14 \
        ad=2.99e-14 ps=9.6e-07 pd=7.5e-07 nrd=1.16667 nrs=1.16667 \
        sa=5.7e-07 sb=3e-07 sd=160n sca=8.65991 scb=0.00681295 \
        scc=0.000165238 m=(1)
mn4 (\1\:VSS \3\:B0 n3 VSS) g45n1svt w=(2.6e-07) l=4.5e-08 nf=1 \
        as=2.99e-14 ad=3.64e-14 ps=7.5e-07 pd=8e-07 nrd=1.16667 \
        nrs=1.16667 sa=7.3e-07 sb=1.4e-07 sd=160n sca=8.65991 \
        scb=0.00681295 scc=0.000165238 m=(1)
mp2 (\5\:n4 \3\:n0 \1\:VDD NW) g45p1svt w=(3.9e-07) l=4.5e-08 nf=1 \
        as=6.24e-14 ad=5.46e-14 ps=1.1e-06 pd=1.06e-06 nrd=1.16667 \
        nrs=1.16667 sa=1.4e-07 sb=8.15e-07 sd=160n sca=20.624 \
        scb=0.0171402 scc=0.00197772 m=(1)
mp3 (\3\:n4 n1 \1\:VDD NW) g45p1svt w=(3.9e-07) l=4.5e-08 nf=1 \
        as=6.24e-14 ad=8.58e-14 ps=1.1e-06 pd=1.22e-06 nrd=1.16667 \
        nrs=1.16667 sa=3.45e-07 sb=6.1e-07 sd=160n sca=21.2883 \
        scb=0.0174673 scc=0.00197792 m=(1)
mp5 (\1\:Y \1\:B1 \3\:n4 NW) g45p1svt w=(3.9e-07) l=4.5e-08 nf=1 \
        as=8.58e-14 ad=6.24e-14 ps=1.22e-06 pd=1.1e-06 nrd=1.16667 \
        nrs=1.16667 sa=6.1e-07 sb=3.45e-07 sd=160n sca=23.6754 \
        scb=0.020671 scc=0.0020044 m=(1)
mp4 (\1\:Y \1\:B0 n4 NW) g45p1svt w=(3.9e-07) l=4.5e-08 nf=1 as=5.46e-14 \
        ad=6.24e-14 ps=1.06e-06 pd=1.1e-06 nrd=1.16667 nrs=1.16667 \
        sa=8.15e-07 sb=1.4e-07 sd=160n sca=31.7169 scb=0.0333373 \
        scc=0.002913 m=(1)
ends AOI2BB2X1
// End of subcircuit definition.
