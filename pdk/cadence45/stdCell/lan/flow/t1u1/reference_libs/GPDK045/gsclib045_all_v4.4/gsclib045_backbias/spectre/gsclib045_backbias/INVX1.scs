// Generated for: spectre (Apr 26 15:38:57 2013 )
// Library name: gsclib045_backbias
// Cell name: INVX1
// View name: schematic

simulator lang=spectre

subckt INVX1 A Y VSS NW VDD
mp0 (Y A VDD NW) g45p1svt w=(390n) l=45n nf=1 as=54.6f ad=54.6f ps=1.06u \
        pd=1.06u nrd=358.974m nrs=358.974m sa=140n sb=140n sd=160n \
        sca=114.89040 scb=0.09003 scc=0.01377 m=(1)
mn0 (Y A VSS VSS) g45n1svt w=(260n) l=45n nf=1 as=36.4f ad=36.4f ps=800n \
        pd=800n nrd=538.462m nrs=538.462m sa=140n sb=140n sd=160n \
        sca=144.98299 scb=0.10251 scc=0.01780 m=(1)
ends INVX1
// End of subcircuit definition.
