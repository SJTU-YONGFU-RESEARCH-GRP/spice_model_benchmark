// Generated for: spectre (May  1 09:19:20 2013 )
// Library name: gsclib045_lvt
// Cell name: TLATNTSCAX20
// View name: extracted

simulator lang=spectre

subckt TLATNTSCAX20 CK E ECK SE VDD VSS
mp1 (\8\:Eb \1\:E net246 VDD) g45p1lvt w=(2.15e-07) l=4.5e-08 nf=1 \
        as=1.29e-14 ad=3.01e-14 ps=5.5e-07 pd=7.1e-07 nrd=1.16667 \
        nrs=1.16667 sa=1.4e-07 sb=4.8e-07 sd=160n sca=48.9651 \
        scb=0.0318882 scc=0.00591085 m=(1)
mp0 (net246 \1\:SE \53\:VDD VDD) g45p1lvt w=(2.15e-07) l=4.5e-08 nf=1 \
        as=4.085e-14 ad=1.29e-14 ps=8.1e-07 pd=5.5e-07 nrd=1.16667 \
        nrs=1.16667 sa=2.45e-07 sb=3.75e-07 sd=160n sca=47.6387 \
        scb=0.0298205 scc=0.00588813 m=(1)
mp2 (\11\:CKb \3\:CK \53\:VDD VDD) g45p1lvt w=(2.15e-07) l=4.5e-08 nf=1 \
        as=4.085e-14 ad=3.01e-14 ps=8.1e-07 pd=7.1e-07 nrd=1.16667 \
        nrs=1.16667 sa=4.8e-07 sb=1.4e-07 sd=160n sca=46.2776 \
        scb=0.0284965 scc=0.00588421 m=(1)
mp5 (\13\:n5 \3\:CKbb Eb VDD) g45p1lvt w=(2.15e-07) l=4.5e-08 nf=1 \
        as=6.128e-14 ad=3.44e-14 ps=1e-06 pd=7.5e-07 nrd=1.16667 \
        nrs=1.16667 sa=2.85e-07 sb=6.30233e-07 sd=160n sca=19.7413 \
        scb=0.019281 scc=0.00179464 m=(1)
mp16 (\13\:n5 \3\:CKb net234 VDD) g45p1lvt w=(2.15e-07) l=4.5e-08 nf=1 \
        as=1.505e-14 ad=3.44e-14 ps=5.7e-07 pd=7.5e-07 nrd=1.16667 \
        nrs=1.16667 sa=4.9e-07 sb=4.25233e-07 sd=160n sca=19.7413 \
        scb=0.019281 scc=0.00179464 m=(1)
mp15 (net234 Eint \49\:VDD VDD) g45p1lvt w=(2.15e-07) l=4.5e-08 nf=1 \
        as=8.595e-14 ad=1.505e-14 ps=1.61e-06 pd=5.7e-07 nrd=1.16667 \
        nrs=1.16667 sa=6.05e-07 sb=3.10233e-07 sd=160n sca=19.7413 \
        scb=0.019281 scc=0.00179464 m=(1)
mp3 (\23\:CKbb \5\:CKb \49\:VDD VDD) g45p1lvt w=(2.15e-07) l=4.5e-08 \
        nf=1 as=8.595e-14 ad=2.71e-14 ps=1.61e-06 pd=7.1e-07 nrd=1.16667 \
        nrs=1.16667 sa=5.77674e-07 sb=1.26047e-07 sd=160n sca=45.7906 \
        scb=0.0283307 scc=0.00588417 m=(1)
C1 (CK VSS) capacitor c=6.25885e-17
C2 (SE VSS) capacitor c=5.79578e-17
C3 (E VSS) capacitor c=4.98465e-17
C4 (VDD VSS) capacitor c=3.72648e-16
C5 (ECK VSS) capacitor c=1.6237e-15
C6 (Eb VSS) capacitor c=9.97873e-17
C7 (CKb VSS) capacitor c=3.57516e-17
C8 (n5 VSS) capacitor c=3.56879e-16
C9 (net263 VSS) capacitor c=1.50435e-18
C10 (CKbb VSS) capacitor c=5.9076e-17
C11 (Eint VSS) capacitor c=5.86006e-17
C12 (ECKb VSS) capacitor c=7.91221e-16
C13 (17 VSS) capacitor c=1.72384e-18
C14 (18 VSS) capacitor c=1.72384e-18
C15 (19 VSS) capacitor c=1.72384e-18
C16 (20 VSS) capacitor c=2.10413e-18
C17 (net246 VSS) capacitor c=2.36136e-18
C18 (net234 VSS) capacitor c=1.23525e-18
C19 (\5\:CKb VSS) capacitor c=4.1108e-17
C20 (\3\:CKb VSS) capacitor c=6.52652e-17
C21 (\3\:CKbb VSS) capacitor c=4.42127e-17
C22 (\3\:CK VSS) capacitor c=2.51866e-17
C23 (\1\:SE VSS) capacitor c=5.40373e-17
C24 (\1\:E VSS) capacitor c=6.11667e-17
C25 (\19\:CKbb VSS) capacitor c=8.15055e-17
C26 (\18\:Eint VSS) capacitor c=4.93281e-17
C27 (\16\:Eint VSS) capacitor c=6.54334e-17
C28 (\15\:CKbb VSS) capacitor c=5.97292e-17
C29 (\14\:CKbb VSS) capacitor c=6.1427e-17
C30 (\11\:Eint VSS) capacitor c=4.89386e-17
C31 (\10\:Eint VSS) capacitor c=4.82017e-17
C32 (\5\:CKbb VSS) capacitor c=6.27606e-17
C33 (\9\:CKbb VSS) capacitor c=3.91468e-17
C34 (\4\:Eint VSS) capacitor c=4.35826e-17
C35 (\6\:CKb VSS) capacitor c=5.11055e-17
C36 (\3\:Eint VSS) capacitor c=6.79366e-17
C37 (\1\:CK VSS) capacitor c=2.90938e-17
C38 (\3\:SE VSS) capacitor c=3.0378e-17
C39 (\4\:E VSS) capacitor c=2.47304e-17
C40 (\19\:ECKb VSS) capacitor c=1.6911e-17
C41 (\5\:Eint VSS) capacitor c=7.30874e-16
C42 (\7\:CKb VSS) capacitor c=1.9226e-17
C43 (\2\:Eint VSS) capacitor c=7.10848e-17
C44 (\4\:CKbb VSS) capacitor c=3.39835e-17
C45 (\4\:CKb VSS) capacitor c=3.31032e-17
C46 (\2\:CKb VSS) capacitor c=2.74564e-17
C47 (\2\:CK VSS) capacitor c=2.66919e-17
C48 (\2\:SE VSS) capacitor c=3.58506e-17
C49 (\3\:E VSS) capacitor c=1.44707e-17
C50 (\1\:VDD VSS) capacitor c=1.38201e-15
C51 (\53\:ECKb VSS) capacitor c=5.87666e-16
C52 (\27\:Eint VSS) capacitor c=4.19547e-17
C53 (\23\:CKbb VSS) capacitor c=1.88083e-16
C54 (\49\:VDD VSS) capacitor c=3.08042e-17
C55 (\13\:n5 VSS) capacitor c=1.00332e-16
C56 (\11\:CKb VSS) capacitor c=1.26594e-16
C57 (\53\:VDD VSS) capacitor c=4.91884e-17
C58 (\8\:Eb VSS) capacitor c=7.12659e-17
C59 (\62\:ECKb VSS) capacitor c=8.77729e-17
C60 (\70\:ECKb VSS) capacitor c=1.16696e-16
C61 (\72\:ECKb VSS) capacitor c=7.47248e-17
C62 (\23\:Eint VSS) capacitor c=2.91131e-17
C63 (\26\:CKbb VSS) capacitor c=9.38121e-17
C64 (\11\:n5 VSS) capacitor c=1.95782e-16
C65 (\6\:Eb VSS) capacitor c=2.30057e-17
C66 (\15\:CKb VSS) capacitor c=1.21505e-16
C67 (\4\:Eb VSS) capacitor c=1.46266e-16
C68 (\2\:E VSS) capacitor c=2.47457e-17
C69 (\2\:CKbb VSS) capacitor c=3.99071e-17
C70 (\6\:CKbb VSS) capacitor c=8.64092e-16
C71 (\5\:E VSS) capacitor c=4.45731e-17
C72 (\4\:SE VSS) capacitor c=5.96068e-17
C73 (\4\:CK VSS) capacitor c=6.28934e-17
C74 (\3\:Eb VSS) capacitor c=1.40878e-16
C75 (\8\:CKb VSS) capacitor c=4.03982e-17
C76 (\9\:CKb VSS) capacitor c=6.19684e-17
C77 (\10\:CKb VSS) capacitor c=1.06756e-16
C78 (\13\:CKb VSS) capacitor c=2.89204e-17
C79 (\14\:CKb VSS) capacitor c=9.2195e-17
C80 (\22\:Eint VSS) capacitor c=5.31698e-17
C81 (\25\:Eint VSS) capacitor c=9.33335e-17
C82 (\26\:Eint VSS) capacitor c=9.25399e-17
C83 (\25\:CKbb VSS) capacitor c=1.41925e-16
C84 (\61\:ECKb VSS) capacitor c=6.86157e-17
C85 (\48\:VDD VSS) capacitor c=2.83159e-17
C86 (\52\:VDD VSS) capacitor c=1.65641e-17
Rk114 (\1\:VSS \13\:VSS) resistor r=0.3359 c=0
Rk115 (\13\:VSS \14\:VSS) resistor r=0.3108 c=0
Rk116 (\14\:VSS \15\:VSS) resistor r=0.09767 c=0
Rk117 (\15\:VSS \16\:VSS) resistor r=0.2307 c=0
Rk119 (\16\:VSS \18\:VSS) resistor r=0.3811 c=0
Rk120 (\18\:VSS \19\:VSS) resistor r=0.3863 c=0
Rk121 (\19\:VSS \20\:VSS) resistor r=0.2649 c=0
Rk123 (\21\:VSS VSS) resistor r=0.03469 c=0
Rk122 (\20\:VSS \21\:VSS) resistor r=0.2496 c=0
Rk132 (\13\:VSS \39\:VSS) resistor r=0.1839 c=0
Rk133 (\14\:VSS \41\:VSS) resistor r=0.1839 c=0
Rk136 (\18\:VSS \47\:VSS) resistor r=0.1637 c=0
Rk137 (\20\:VSS \49\:VSS) resistor r=0.04335 c=0
Rk138 (\21\:VSS \51\:VSS) resistor r=0.3574 c=0
Rk3 (\4\:CK CK) resistor r=0.0284 c=0
Rk2 (\4\:SE SE) resistor r=0.07449 c=0
Rk1 (\5\:E E) resistor r=0.1753 c=0
Rk99 (\1\:VDD \48\:VDD) resistor r=0.1928 c=0
Rk100 (\48\:VDD \50\:VDD) resistor r=0.1858 c=0
Rk101 (\48\:VDD \51\:VDD) resistor r=0.4214 c=0
Rk104 (\52\:VDD VDD) resistor r=0.2856 c=0
Rk102 (\51\:VDD \52\:VDD) resistor r=0.2658 c=0
Rk103 (\52\:VDD \54\:VDD) resistor r=0.4362 c=0
Rk4 (\2\:Eb \3\:Eb) resistor r=0.4377 c=0
Rk5 (\3\:Eb \5\:Eb) resistor r=0.8153 c=0
Rk6 (\3\:Eb \7\:Eb) resistor r=0.05787 c=0
Rk7 (\5\:Eb \9\:Eb) resistor r=0.3455 c=0
Rk8 (\8\:CKb \9\:CKb) resistor r=0.404 c=0
Rk9 (\9\:CKb \10\:CKb) resistor r=0.2456 c=0
Rk10 (\10\:CKb \12\:CKb) resistor r=0.5473 c=0
Rk11 (\9\:CKb \13\:CKb) resistor r=0.04543 c=0
Rk12 (\10\:CKb \14\:CKb) resistor r=0.4838 c=0
Rk13 (\12\:CKb \16\:CKb) resistor r=0.7966 c=0
Rk15 (n5 \12\:n5) resistor r=1.0206 c=0
Rk16 (\12\:n5 \14\:n5) resistor r=0.536 c=0
Rk26 (\6\:CKbb \24\:CKbb) resistor r=1.1642 c=0
Rk27 (\24\:CKbb \25\:CKbb) resistor r=0.5452 c=0
Rk28 (\25\:CKbb \27\:CKbb) resistor r=0.5838 c=0
Rk19 (\5\:Eint \22\:Eint) resistor r=0.2208 c=0
Rk20 (\22\:Eint \24\:Eint) resistor r=0.144 c=0
Rk21 (\22\:Eint \25\:Eint) resistor r=0.3088 c=0
Rk22 (\25\:Eint \26\:Eint) resistor r=0.5477 c=0
Rk23 (\25\:Eint \28\:Eint) resistor r=0.08721 c=0
Rk34 (\53\:ECKb \61\:ECKb) resistor r=0.3335 c=0
Rk35 (\61\:ECKb \63\:ECKb) resistor r=0.4448 c=0
Rk39 (\63\:ECKb \71\:ECKb) resistor r=0.4512 c=0
Rk40 (\71\:ECKb \73\:ECKb) resistor r=0.4717 c=0
Rl7 (\2\:CK \3\:CK) resistor r=29.9451 c=0
Rl6 (\1\:CK \2\:CK) resistor r=51.9231 c=0
Rl4 (\1\:SE \2\:SE) resistor r=50.6918 c=0
Rl5 (\2\:SE \3\:SE) resistor r=29.5379 c=0
Rl1 (\1\:E \2\:E) resistor r=115.362 c=0
Rl3 (\2\:E \4\:E) resistor r=34.2969 c=0
Rl2 (\2\:E \3\:E) resistor r=24.9253 c=0
Rl15 (\5\:CKb \6\:CKb) resistor r=121.154 c=0
Rl16 (\5\:CKb \7\:CKb) resistor r=24.2328 c=0
Rl9 (\3\:CKb \4\:CKb) resistor r=71.8456 c=0
Rl8 (CKb \2\:CKb) resistor r=43.855 c=0
Rl11 (\2\:CKbb \3\:CKbb) resistor r=137.971 c=0
Rl10 (\2\:CKbb CKbb) resistor r=78.3081 c=0
Rl12 (\2\:CKbb \4\:CKbb) resistor r=4.5402 c=0
Rl46 (\6\:CKbb \19\:CKbb) resistor r=171.506 c=0
Rl38 (\6\:CKbb \15\:CKbb) resistor r=107.374 c=0
Rl37 (\6\:CKbb \14\:CKbb) resistor r=135.031 c=0
Rl25 (\6\:CKbb \5\:CKbb) resistor r=141.817 c=0
Rl28 (\6\:CKbb \9\:CKbb) resistor r=111.923 c=0
Rl44 (\5\:Eint \18\:Eint) resistor r=35.7713 c=0
Rl42 (\5\:Eint \16\:Eint) resistor r=77.4625 c=0
Rl33 (\5\:Eint \11\:Eint) resistor r=37.6951 c=0
Rl32 (\5\:Eint \10\:Eint) resistor r=35.7713 c=0
Rl23 (\5\:Eint \4\:Eint) resistor r=37.2302 c=0
Rl13 (\2\:Eint Eint) resistor r=61.7959 c=0
Rl14 (\2\:Eint \3\:Eint) resistor r=115.642 c=0
Rl64 (ECKb \19\:ECKb) resistor r=9.5287 c=0
Rz32 (\39\:VSS \38\:VSS) resistor r=75 c=0
Rz33 (\41\:VSS \40\:VSS) resistor r=75 c=0
Rz36 (\47\:VSS \46\:VSS) resistor r=75 c=0
Rz37 (\49\:VSS \48\:VSS) resistor r=75 c=0
Rz38 (\51\:VSS \50\:VSS) resistor r=75 c=0
Rz22 (\51\:VDD \1\:VDD) resistor r=6.25 c=0
Rz1 (\4\:Eb \5\:Eb) resistor r=75 c=0
Rz2 (\6\:Eb \7\:Eb) resistor r=75 c=0
Rz3 (\15\:CKb \16\:CKb) resistor r=75 c=0
Rz4 (\12\:n5 \11\:n5) resistor r=75 c=0
Rz6 (\27\:CKbb \26\:CKbb) resistor r=75 c=0
Rz5 (\24\:Eint \23\:Eint) resistor r=75 c=0
Rz7 (\63\:ECKb \62\:ECKb) resistor r=75 c=0
Rz8 (\71\:ECKb \70\:ECKb) resistor r=75 c=0
Rz9 (\73\:ECKb \72\:ECKb) resistor r=75 c=0
Ry40 (\15\:VSS \1\:VSS) resistor r=5.1667 c=0
Ry41 (\19\:VSS \1\:VSS) resistor r=5.1667 c=0
Ry36 (\50\:VDD \49\:VDD) resistor r=62 c=0
Ry37 (\54\:VDD \53\:VDD) resistor r=62 c=0
Ry1 (Eb \2\:Eb) resistor r=62 c=0
Ry2 (\8\:Eb \9\:Eb) resistor r=62 c=0
Ry3 (\11\:CKb \12\:CKb) resistor r=62 c=0
Ry4 (\14\:n5 \13\:n5) resistor r=62 c=0
Ry6 (\24\:CKbb \23\:CKbb) resistor r=62 c=0
Ry5 (\28\:Eint \27\:Eint) resistor r=62 c=0
Rx3 (\2\:CK \4\:CK) resistor r=45 c=0
Rx2 (\2\:SE \4\:SE) resistor r=45 c=0
Rx1 (\3\:E \5\:E) resistor r=45 c=0
Rx4 (\7\:CKb \8\:CKb) resistor r=45 c=0
Rx5 (\4\:CKb \13\:CKb) resistor r=45 c=0
Rx6 (\2\:CKb \14\:CKb) resistor r=45 c=0
Rx16 (\25\:CKbb \4\:CKbb) resistor r=45 c=0
Rx12 (\26\:Eint \2\:Eint) resistor r=45 c=0
Rx17 (\61\:ECKb \19\:ECKb) resistor r=45 c=0
mn1 (\4\:Eb \4\:E \50\:VSS VSS) g45n1lvt w=(1.45e-07) l=4.5e-08 nf=1 \
        as=2.03e-14 ad=3.19e-14 ps=5.7e-07 pd=7.3e-07 nrd=1.16667 \
        nrs=1.16667 sa=1.4e-07 sb=6.95e-07 sd=160n sca=17.8702 \
        scb=0.0189183 scc=0.00156031 m=(1)
mn0 (\4\:Eb \3\:SE \48\:VSS VSS) g45n1lvt w=(1.45e-07) l=4.5e-08 nf=1 \
        as=8.353e-14 ad=3.19e-14 ps=1.58e-06 pd=7.3e-07 nrd=1.16667 \
        nrs=1.16667 sa=4.05e-07 sb=4.3e-07 sd=160n sca=17.8702 \
        scb=0.0189183 scc=0.00156031 m=(1)
mn2 (\15\:CKb \1\:CK \48\:VSS VSS) g45n1lvt w=(1.45e-07) l=4.5e-08 nf=1 \
        as=8.353e-14 ad=2.03e-14 ps=1.58e-06 pd=5.7e-07 nrd=1.16667 \
        nrs=1.16667 sa=6.95e-07 sb=1.4e-07 sd=160n sca=17.8702 \
        scb=0.0189183 scc=0.00156031 m=(1)
mn5 (\6\:Eb CKb \11\:n5 VSS) g45n1lvt w=(1.45e-07) l=4.5e-08 nf=1 \
        as=2.393e-14 ad=2.03e-14 ps=6.2e-07 pd=5.7e-07 nrd=1.16667 \
        nrs=1.16667 sa=1.4e-07 sb=6.29138e-07 sd=160n sca=9.33388 \
        scb=0.00788941 scc=0.00017958 m=(1)
mn16 (\11\:n5 CKbb net263 VSS) g45n1lvt w=(1.45e-07) l=4.5e-08 nf=1 \
        as=8.7e-15 ad=2.393e-14 ps=4.1e-07 pd=6.2e-07 nrd=1.16667 \
        nrs=1.16667 sa=3.5e-07 sb=4.19138e-07 sd=160n sca=9.33388 \
        scb=0.00788941 scc=0.00017958 m=(1)
mn15 (net263 \3\:Eint \46\:VSS VSS) g45n1lvt w=(1.45e-07) l=4.5e-08 nf=1 \
        as=5.53e-14 ad=8.7e-15 ps=1.29e-06 pd=4.1e-07 nrd=1.16667 \
        nrs=1.16667 sa=4.55e-07 sb=3.14138e-07 sd=160n sca=9.33388 \
        scb=0.00788941 scc=0.00017958 m=(1)
mn3 (\26\:CKbb \6\:CKb \46\:VSS VSS) g45n1lvt w=(1.45e-07) l=4.5e-08 \
        nf=1 as=5.53e-14 ad=3.263e-14 ps=1.29e-06 pd=7.4e-07 nrd=1.16667 \
        nrs=1.16667 sa=3.57931e-07 sb=2.25e-07 sd=160n sca=13.9854 \
        scb=0.014728 scc=0.000819645 m=(1)
mn20_1__rcx (16 \4\:Eint \16\:VSS VSS) g45n1lvt w=(2.6e-07) l=4.5e-08 \
        nf=1 as=4.16e-14 ad=3.25e-14 ps=8.4e-07 pd=7.7e-07 nrd=1.16667 \
        nrs=1.16667 sa=5.5e-07 sb=1.55e-06 sd=160n sca=8.36684 \
        scb=0.00633377 scc=0.000139167 m=(1)
mn21_1__rcx (\72\:ECKb \9\:CKbb 16 VSS) g45n1lvt w=(2.6e-07) l=4.5e-08 \
        nf=1 as=3.25e-14 ad=4.16e-14 ps=7.7e-07 pd=8.4e-07 nrd=1.16667 \
        nrs=1.16667 sa=7.2e-07 sb=1.38e-06 sd=160n sca=8.36684 \
        scb=0.00633377 scc=0.000139167 m=(1)
mn21_2__rcx (\72\:ECKb \5\:CKbb 17 VSS) g45n1lvt w=(2.6e-07) l=4.5e-08 \
        nf=1 as=1.56e-14 ad=4.16e-14 ps=6.4e-07 pd=8.4e-07 nrd=1.16667 \
        nrs=1.16667 sa=9.25e-07 sb=1.175e-06 sd=160n sca=8.36684 \
        scb=0.00633377 scc=0.000139167 m=(1)
mn20_2__rcx (17 \10\:Eint \40\:VSS VSS) g45n1lvt w=(2.6e-07) l=4.5e-08 \
        nf=1 as=4.16e-14 ad=1.56e-14 ps=8.4e-07 pd=6.4e-07 nrd=1.16667 \
        nrs=1.16667 sa=1.03e-06 sb=1.07e-06 sd=160n sca=8.36684 \
        scb=0.00633377 scc=0.000139167 m=(1)
mn20_3__rcx (18 \11\:Eint \40\:VSS VSS) g45n1lvt w=(2.6e-07) l=4.5e-08 \
        nf=1 as=4.16e-14 ad=1.56e-14 ps=8.4e-07 pd=6.4e-07 nrd=1.16667 \
        nrs=1.16667 sa=1.235e-06 sb=8.65e-07 sd=160n sca=8.36684 \
        scb=0.00633377 scc=0.000139167 m=(1)
mn21_3__rcx (\70\:ECKb \14\:CKbb 18 VSS) g45n1lvt w=(2.6e-07) l=4.5e-08 \
        nf=1 as=1.56e-14 ad=4.16e-14 ps=6.4e-07 pd=8.4e-07 nrd=1.16667 \
        nrs=1.16667 sa=1.34e-06 sb=7.6e-07 sd=160n sca=8.36684 \
        scb=0.00633377 scc=0.000139167 m=(1)
mn21_4__rcx (\70\:ECKb \15\:CKbb 19 VSS) g45n1lvt w=(2.6e-07) l=4.5e-08 \
        nf=1 as=1.56e-14 ad=4.16e-14 ps=6.4e-07 pd=8.4e-07 nrd=1.16667 \
        nrs=1.16667 sa=1.545e-06 sb=5.55e-07 sd=160n sca=8.36684 \
        scb=0.00633377 scc=0.000139167 m=(1)
mn20_4__rcx (19 \16\:Eint \38\:VSS VSS) g45n1lvt w=(2.6e-07) l=4.5e-08 \
        nf=1 as=4.16e-14 ad=1.56e-14 ps=8.4e-07 pd=6.4e-07 nrd=1.16667 \
        nrs=1.16667 sa=1.65e-06 sb=4.5e-07 sd=160n sca=8.36684 \
        scb=0.00633377 scc=0.000139167 m=(1)
mn20 (20 \18\:Eint \38\:VSS VSS) g45n1lvt w=(2.6e-07) l=4.5e-08 nf=1 \
        as=4.16e-14 ad=1.56e-14 ps=8.4e-07 pd=6.4e-07 nrd=1.16667 \
        nrs=1.16667 sa=1.855e-06 sb=2.45e-07 sd=160n sca=8.36684 \
        scb=0.00633377 scc=0.000139167 m=(1)
mn21 (\62\:ECKb \19\:CKbb 20 VSS) g45n1lvt w=(2.6e-07) l=4.5e-08 nf=1 \
        as=1.56e-14 ad=3.64e-14 ps=6.4e-07 pd=8e-07 nrd=1.16667 \
        nrs=1.16667 sa=1.96e-06 sb=1.4e-07 sd=160n sca=8.36684 \
        scb=0.00633377 scc=0.000139167 m=(1)
mn10_1__rcx (\23\:Eint n5 \16\:VSS VSS) g45n1lvt w=(2.6e-07) l=4.5e-08 \
        nf=1 as=3.9e-14 ad=4.16e-14 ps=8.2e-07 pd=8.4e-07 nrd=1.16667 \
        nrs=1.16667 sa=1.4e-07 sb=1.96e-06 sd=160n sca=8.36684 \
        scb=0.00633377 scc=0.000139167 m=(2)
mn22_1__rcx (ECK ECKb \1\:VSS VSS) g45n1lvt w=(3.05e-07) l=4.5e-08 nf=1 \
        as=4.844e-14 ad=4.844e-14 ps=9.2765e-07 pd=9.2765e-07 nrd=1.16667 \
        nrs=1.16667 sa=1.4e-07 sb=2e-06 sd=160n sca=16.121 scb=0.0155296 \
        scc=0.00139557 m=(17)
mp10 (\27\:Eint n5 \1\:VDD VDD) g45p1lvt w=(3.9e-07) l=4.5e-08 nf=1 \
        as=7.705e-14 ad=6.24e-14 ps=1.36e-06 pd=1.1e-06 nrd=1.16667 \
        nrs=1.16667 sa=1.08974e-07 sb=1.69577e-06 sd=160n sca=30.5009 \
        scb=0.0202006 scc=0.00336097 m=(2)
mp20_1__rcx (\53\:ECKb \5\:Eint \1\:VDD VDD) g45p1lvt w=(3.9e-07) \
        l=4.5e-08 nf=1 as=7.056e-14 ad=6.24e-14 ps=1.172e-06 pd=1.1e-06 \
        nrd=1.16667 nrs=1.16667 sa=5.42821e-07 sb=2e-06 sd=160n \
        sca=16.7336 scb=0.0149207 scc=0.00128056 m=(5)
mp21_1__rcx (\53\:ECKb \6\:CKbb \1\:VDD VDD) g45p1lvt w=(3.9e-07) \
        l=4.5e-08 nf=1 as=6.614e-14 ad=6.24e-14 ps=1.14e-06 pd=1.1e-06 \
        nrd=1.16667 nrs=1.16667 sa=7.47821e-07 sb=2e-06 sd=160n \
        sca=16.7336 scb=0.0149207 scc=0.00128056 m=(5)
mp22_1__rcx (ECK ECKb \1\:VDD VDD) g45p1lvt w=(4.6e-07) l=4.5e-08 nf=1 \
        as=7.405e-14 ad=7.36e-14 ps=1.24375e-06 pd=1.24e-06 nrd=1.16667 \
        nrs=1.16667 sa=1.71087e-06 sb=2e-06 sd=160n sca=27.3498 \
        scb=0.0181352 scc=0.00285625 m=(16)
mp22_16__rcx (ECK ECKb \1\:VDD VDD) g45p1lvt w=(4.55e-07) l=4.5e-08 nf=1 \
        as=7.33e-14 ad=6.37e-14 ps=1.24e-06 pd=1.19e-06 nrd=1.16667 \
        nrs=1.16667 sa=2e-06 sb=1.4e-07 sd=160n sca=33.0977 scb=0.0260038 \
        scc=0.00304396 m=(1)
ends TLATNTSCAX20
// End of subcircuit definition.
