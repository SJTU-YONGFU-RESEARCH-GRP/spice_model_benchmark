// Generated for: spectre (May  1 08:13:14 2013 )
// Library name: gsclib045
// Cell name: SPDFF2RX2
// View name: extracted

simulator lang=spectre

subckt SPDFF2RX2 CK D1 D2 Q1 Q1N Q2 Q2N RN SE SI1 SI2 VDD VSS
mp55 (\6\:Q1 qbint \48\:VDD VDD) g45p1svt w=(3.9e-07) l=4.5e-08 nf=1 \
        as=1.1475e-13 ad=1.1287e-13 ps=1.68e-06 pd=1.995e-06 nrd=1.16667 \
        nrs=1.16667 sa=1.2e-07 sb=1.43019e-06 sd=160n sca=30.5009 \
        scb=0.0202006 scc=0.00336097 m=(2)
PM19 (\3\:Q2N qint_2 \1\:VDD VDD) g45p1svt w=(3.9e-07) l=4.5e-08 nf=1 \
        as=6.24e-14 ad=8.951e-14 ps=1.1e-06 pd=1.885e-06 nrd=1.16667 \
        nrs=1.16667 sa=1.2e-07 sb=4.55e-07 sd=160n sca=34.6642 \
        scb=0.0254864 scc=0.00342609 m=(2)
PM17_1__rcx (\5\:Q2 \6\:qbint_2 \5\:VDD VDD) g45p1svt w=(3.9e-07) \
        l=4.5e-08 nf=1 as=1.1475e-13 ad=1.1287e-13 ps=1.68e-06 \
        pd=1.995e-06 nrd=1.16667 nrs=1.16667 sa=1.2e-07 sb=1.43019e-06 \
        sd=160n sca=30.5009 scb=0.0202006 scc=0.00336097 m=(2)
mp57 (\3\:Q1N qint \54\:VDD VDD) g45p1svt w=(3.9e-07) l=4.5e-08 nf=1 \
        as=6.24e-14 ad=8.951e-14 ps=1.1e-06 pd=1.885e-06 nrd=1.16667 \
        nrs=1.16667 sa=1.2e-07 sb=4.55e-07 sd=160n sca=34.6642 \
        scb=0.0254864 scc=0.00342609 m=(2)
C1 (VDD VSS) capacitor c=8.49295e-16
C2 (Q1N VSS) capacitor c=2.43999e-17
C3 (RN VSS) capacitor c=3.56847e-17
C4 (SE VSS) capacitor c=2.73936e-17
C5 (D1 VSS) capacitor c=2.03453e-17
C6 (Q2N VSS) capacitor c=2.4688e-17
C7 (Q2 VSS) capacitor c=2.9242e-17
C8 (D2 VSS) capacitor c=2.09505e-17
C9 (CK VSS) capacitor c=4.63529e-17
C10 (Ckbb VSS) capacitor c=2.22894e-17
C11 (CKb VSS) capacitor c=3.43291e-17
C12 (Db VSS) capacitor c=5.07987e-17
C13 (qint VSS) capacitor c=1.21904e-16
C14 (n8 VSS) capacitor c=1.76436e-18
C15 (n6 VSS) capacitor c=6.74368e-17
C16 (SEb VSS) capacitor c=4.29388e-17
C17 (qbint VSS) capacitor c=1.26536e-16
C18 (n30 VSS) capacitor c=4.09537e-17
C19 (mout VSS) capacitor c=5.22996e-17
C20 (n20 VSS) capacitor c=2.55521e-17
C21 (n2 VSS) capacitor c=3.96884e-18
C22 (n4 VSS) capacitor c=1.50187e-18
C23 (n9 VSS) capacitor c=1.21856e-18
C24 (n11 VSS) capacitor c=3.08921e-18
C25 (n5 VSS) capacitor c=2.3104e-19
C26 (n1 VSS) capacitor c=2.88673e-18
C27 (Db_2 VSS) capacitor c=1.03282e-16
C28 (qint_2 VSS) capacitor c=1.21976e-16
C29 (n8_2 VSS) capacitor c=1.76436e-18
C30 (n6_2 VSS) capacitor c=7.51434e-17
C31 (SEb_2 VSS) capacitor c=5.68096e-17
C32 (qbint_2 VSS) capacitor c=4.73566e-17
C33 (n30_2 VSS) capacitor c=4.93501e-17
C34 (mout_2 VSS) capacitor c=5.25784e-17
C35 (n20_2 VSS) capacitor c=4.67206e-17
C36 (n2_2 VSS) capacitor c=3.95036e-18
C37 (n4_2 VSS) capacitor c=1.50247e-18
C38 (n9_2 VSS) capacitor c=1.18302e-18
C39 (n11_2 VSS) capacitor c=3.08921e-18
C40 (n5_2 VSS) capacitor c=2.3104e-19
C41 (n1_2 VSS) capacitor c=2.88673e-18
C42 (\4\:qbint_2 VSS) capacitor c=3.52654e-17
C43 (\13\:RN VSS) capacitor c=3.27082e-17
C44 (\12\:Ckbb VSS) capacitor c=7.65184e-17
C45 (\15\:CKb VSS) capacitor c=2.87131e-17
C46 (\9\:RN VSS) capacitor c=6.5104e-17
C47 (\13\:CKb VSS) capacitor c=3.75016e-17
C48 (\8\:Ckbb VSS) capacitor c=9.09046e-17
C49 (\1\:D2 VSS) capacitor c=4.7642e-17
C50 (\13\:SE VSS) capacitor c=4.13386e-17
C51 (\3\:SEb_2 VSS) capacitor c=4.27899e-17
C52 (\3\:SI2 VSS) capacitor c=8.3691e-17
C53 (\8\:SE VSS) capacitor c=4.64075e-17
C54 (\1\:CK VSS) capacitor c=3.97193e-17
C55 (\11\:CKb VSS) capacitor c=3.4982e-17
C56 (\5\:SE VSS) capacitor c=4.42341e-17
C57 (\3\:SI1 VSS) capacitor c=8.22819e-17
C58 (\1\:SE VSS) capacitor c=4.09456e-17
C59 (\1\:D1 VSS) capacitor c=4.65678e-17
C60 (\6\:Ckbb VSS) capacitor c=9.02248e-17
C61 (\6\:CKb VSS) capacitor c=3.66746e-17
C62 (\6\:RN VSS) capacitor c=6.54428e-17
C63 (\4\:n20 VSS) capacitor c=4.61477e-17
C64 (\3\:CKb VSS) capacitor c=2.85035e-17
C65 (\3\:Ckbb VSS) capacitor c=7.66774e-17
C66 (\11\:qbint VSS) capacitor c=4.83281e-17
C67 (\3\:RN VSS) capacitor c=3.28447e-17
C68 (\3\:n30 VSS) capacitor c=4.79749e-17
C69 (\10\:qbint VSS) capacitor c=3.51339e-17
C70 (\9\:qbint_2 VSS) capacitor c=3.04938e-17
C71 (\3\:n30_2 VSS) capacitor c=4.16089e-17
C72 (\11\:RN VSS) capacitor c=5.15561e-17
C73 (\3\:qbint_2 VSS) capacitor c=4.03738e-17
C74 (\17\:CKb VSS) capacitor c=3.408e-17
C75 (\13\:Ckbb VSS) capacitor c=6.02147e-17
C76 (\4\:n20_2 VSS) capacitor c=4.02749e-17
C77 (\10\:RN VSS) capacitor c=8.26804e-17
C78 (\3\:mout_2 VSS) capacitor c=4.93331e-17
C79 (\10\:Ckbb VSS) capacitor c=5.7908e-17
C80 (\12\:CKb VSS) capacitor c=5.7991e-17
C81 (\3\:D2 VSS) capacitor c=4.06457e-17
C82 (\11\:SE VSS) capacitor c=4.33001e-17
C83 (\1\:SI2 VSS) capacitor c=5.68102e-17
C84 (\10\:SE VSS) capacitor c=4.05177e-17
C85 (\3\:CK VSS) capacitor c=4.14933e-17
C86 (\10\:CKb VSS) capacitor c=3.06741e-17
C87 (\7\:SE VSS) capacitor c=4.03782e-17
C88 (\1\:SI1 VSS) capacitor c=5.48548e-17
C89 (\3\:SE VSS) capacitor c=4.33001e-17
C90 (\3\:SEb VSS) capacitor c=5.71879e-17
C91 (\3\:D1 VSS) capacitor c=4.06724e-17
C92 (\7\:CKb VSS) capacitor c=5.81133e-17
C93 (\4\:Ckbb VSS) capacitor c=5.79322e-17
C94 (\3\:mout VSS) capacitor c=4.93391e-17
C95 (\5\:RN VSS) capacitor c=8.25573e-17
C96 (\3\:n20 VSS) capacitor c=3.9835e-17
C97 (\2\:Ckbb VSS) capacitor c=6.03045e-17
C98 (\13\:qbint VSS) capacitor c=4.03738e-17
C99 (\1\:RN VSS) capacitor c=5.13394e-17
C100 (\5\:qbint VSS) capacitor c=3.04921e-17
C101 (\4\:qint_2 VSS) capacitor c=2.31475e-17
C102 (\8\:qbint_2 VSS) capacitor c=1.78944e-17
C103 (\2\:n30_2 VSS) capacitor c=4.09825e-17
C104 (\14\:RN VSS) capacitor c=2.882e-17
C105 (\12\:RN VSS) capacitor c=1.37113e-16
C106 (\2\:qbint_2 VSS) capacitor c=4.34306e-17
C107 (\18\:CKb VSS) capacitor c=5.05396e-17
C108 (\14\:Ckbb VSS) capacitor c=2.22781e-17
C109 (\16\:CKb VSS) capacitor c=3.9247e-17
C110 (\3\:n20_2 VSS) capacitor c=2.51716e-17
C111 (\8\:RN VSS) capacitor c=2.95056e-17
C112 (\2\:mout_2 VSS) capacitor c=4.88284e-17
C113 (\11\:Ckbb VSS) capacitor c=2.17719e-17
C114 (\14\:CKb VSS) capacitor c=4.08679e-17
C115 (\9\:Ckbb VSS) capacitor c=4.46126e-17
C116 (\2\:D2 VSS) capacitor c=3.65523e-17
C117 (\14\:SE VSS) capacitor c=5.0586e-17
C118 (\2\:SEb_2 VSS) capacitor c=7.66847e-17
C119 (\12\:SE VSS) capacitor c=5.0179e-17
C120 (\2\:SI2 VSS) capacitor c=4.89202e-17
C121 (\9\:SE VSS) capacitor c=2.58442e-17
C122 (\2\:CK VSS) capacitor c=3.26581e-17
C123 (\8\:CKb VSS) capacitor c=2.08504e-17
C124 (\6\:SE VSS) capacitor c=2.66574e-17
C125 (\2\:SI1 VSS) capacitor c=4.89409e-17
C126 (\4\:SE VSS) capacitor c=5.02372e-17
C127 (\2\:SEb VSS) capacitor c=7.59001e-17
C128 (\2\:SE VSS) capacitor c=5.05765e-17
C129 (\2\:D1 VSS) capacitor c=3.65353e-17
C130 (\7\:Ckbb VSS) capacitor c=4.45376e-17
C131 (\5\:CKb VSS) capacitor c=4.08469e-17
C132 (\5\:Ckbb VSS) capacitor c=2.17719e-17
C133 (\2\:mout VSS) capacitor c=4.88244e-17
C134 (\7\:RN VSS) capacitor c=2.96267e-17
C135 (\4\:CKb VSS) capacitor c=3.97497e-17
C136 (\2\:CKb VSS) capacitor c=5.05451e-17
C137 (\12\:qbint VSS) capacitor c=4.34465e-17
C138 (\2\:RN VSS) capacitor c=1.37183e-16
C139 (\4\:RN VSS) capacitor c=2.88e-17
C140 (\2\:n30 VSS) capacitor c=4.10083e-17
C141 (\6\:qint VSS) capacitor c=2.3136e-17
C142 (\1\:VDD VSS) capacitor c=1.74713e-17
C143 (\3\:Q2N VSS) capacitor c=4.47524e-17
C144 (\8\:qint_2 VSS) capacitor c=1.90277e-17
C145 (\5\:Q2 VSS) capacitor c=3.28147e-19
C146 (\16\:qbint_2 VSS) capacitor c=1.26317e-16
C147 (\14\:VDD VSS) capacitor c=2.86154e-17
C148 (\4\:n30_2 VSS) capacitor c=8.66991e-17
C149 (\4\:mout_2 VSS) capacitor c=5.66178e-17
C150 (\17\:VDD VSS) capacitor c=1.97485e-17
C151 (\20\:VDD VSS) capacitor c=2.18944e-17
C152 (\3\:n6_2 VSS) capacitor c=6.76702e-17
C153 (\7\:n20_2 VSS) capacitor c=6.91627e-17
C154 (\4\:Db_2 VSS) capacitor c=9.05923e-17
C155 (\24\:VDD VSS) capacitor c=1.94546e-17
C156 (\6\:Db_2 VSS) capacitor c=5.0837e-17
C157 (\27\:VDD VSS) capacitor c=2.47253e-17
C158 (\5\:SEb_2 VSS) capacitor c=1.08848e-16
C159 (\32\:CKb VSS) capacitor c=3.59357e-17
C160 (\30\:VDD VSS) capacitor c=1.74455e-17
C161 (\17\:Ckbb VSS) capacitor c=1.19731e-16
C162 (\6\:SEb VSS) capacitor c=1.09231e-16
C163 (\33\:VDD VSS) capacitor c=2.43531e-17
C164 (\36\:VDD VSS) capacitor c=1.94853e-17
C165 (\4\:Db VSS) capacitor c=9.00592e-17
C166 (\5\:n20 VSS) capacitor c=6.93367e-17
C167 (\40\:VDD VSS) capacitor c=2.18139e-17
C168 (\3\:n6 VSS) capacitor c=7.59254e-17
C169 (\43\:VDD VSS) capacitor c=1.97407e-17
C170 (\8\:mout VSS) capacitor c=5.65411e-17
C171 (\4\:n30 VSS) capacitor c=8.67841e-17
C172 (\46\:VDD VSS) capacitor c=2.8625e-17
C173 (\15\:qbint VSS) capacitor c=1.25845e-16
C174 (\6\:Q1 VSS) capacitor c=3.28147e-19
C175 (\8\:qint VSS) capacitor c=1.90943e-17
C176 (\3\:Q1N VSS) capacitor c=3.89969e-17
C177 (\4\:VDD VSS) capacitor c=9.50962e-17
C178 (\1\:Q2N VSS) capacitor c=1.74566e-17
C179 (\11\:qint_2 VSS) capacitor c=1.80527e-17
C180 (\19\:qbint_2 VSS) capacitor c=4.67129e-17
C181 (\6\:n30_2 VSS) capacitor c=1.41889e-16
C182 (\8\:mout_2 VSS) capacitor c=3.0247e-17
C183 (\9\:n20_2 VSS) capacitor c=4.68448e-17
C184 (\8\:Db_2 VSS) capacitor c=7.38099e-17
C185 (\7\:SEb_2 VSS) capacitor c=7.92195e-17
C186 (\29\:CKb VSS) capacitor c=5.76045e-17
C187 (\15\:Ckbb VSS) capacitor c=5.42954e-16
C188 (\4\:SEb VSS) capacitor c=8.01357e-17
C189 (\6\:Db VSS) capacitor c=1.03519e-16
C190 (\8\:Db VSS) capacitor c=7.40468e-17
C191 (\9\:n20 VSS) capacitor c=4.6863e-17
C192 (\6\:mout VSS) capacitor c=3.02734e-17
C193 (\6\:n30 VSS) capacitor c=1.43353e-16
C194 (\19\:qbint VSS) capacitor c=4.6633e-17
C195 (\12\:qint VSS) capacitor c=1.80527e-17
C196 (\1\:Q1N VSS) capacitor c=1.37657e-17
C197 (\4\:qbint VSS) capacitor c=3.16698e-17
C198 (\2\:n20 VSS) capacitor c=2.37037e-17
C199 (\9\:CKb VSS) capacitor c=1.35609e-17
C200 (\10\:qint VSS) capacitor c=1.72734e-17
C201 (\11\:qint VSS) capacitor c=3.85936e-17
C202 (\1\:Q1 VSS) capacitor c=2.66586e-17
C203 (\4\:Q1 VSS) capacitor c=2.91756e-17
C204 (\5\:Q1 VSS) capacitor c=2.39405e-17
C205 (\14\:qbint VSS) capacitor c=9.67793e-17
C206 (\17\:qbint VSS) capacitor c=5.06486e-17
C207 (\18\:qbint VSS) capacitor c=1.76152e-17
C208 (\8\:n30 VSS) capacitor c=1.33486e-16
C209 (\4\:mout VSS) capacitor c=7.94376e-17
C210 (\5\:mout VSS) capacitor c=7.38941e-17
C211 (\7\:n20 VSS) capacitor c=1.00297e-16
C212 (\8\:n20 VSS) capacitor c=1.04066e-16
C213 (\2\:n20_2 VSS) capacitor c=2.31147e-17
C214 (\4\:D1 VSS) capacitor c=5.27315e-17
C215 (\3\:Db VSS) capacitor c=1.05021e-16
C216 (\4\:SI1 VSS) capacitor c=3.06119e-17
C217 (\6\:SI1 VSS) capacitor c=4.23548e-17
C218 (\8\:SEb VSS) capacitor c=9.32026e-17
C219 (\5\:CK VSS) capacitor c=4.948e-17
C220 (\5\:qbint_2 VSS) capacitor c=3.2019e-17
C221 (\6\:qbint_2 VSS) capacitor c=1.08627e-16
C222 (\4\:SI2 VSS) capacitor c=4.25619e-17
C223 (\5\:SI2 VSS) capacitor c=3.04891e-17
C224 (\4\:SEb_2 VSS) capacitor c=9.30214e-17
C225 (\4\:D2 VSS) capacitor c=5.27439e-17
C226 (\3\:Db_2 VSS) capacitor c=1.05815e-16
C227 (\5\:n20_2 VSS) capacitor c=1.04032e-16
C228 (\6\:n20_2 VSS) capacitor c=1.00887e-16
C229 (\6\:mout_2 VSS) capacitor c=7.39903e-17
C230 (\7\:mout_2 VSS) capacitor c=7.95563e-17
C231 (\8\:n30_2 VSS) capacitor c=1.33799e-16
C232 (\19\:CKb VSS) capacitor c=1.13332e-16
C233 (\20\:CKb VSS) capacitor c=4.06024e-16
C234 (\21\:CKb VSS) capacitor c=4.02473e-16
C235 (\22\:CKb VSS) capacitor c=4.8698e-16
C236 (\23\:CKb VSS) capacitor c=3.8778e-16
C237 (\24\:CKb VSS) capacitor c=4.05774e-16
C238 (\25\:CKb VSS) capacitor c=1.13475e-16
C239 (\26\:CKb VSS) capacitor c=7.25236e-17
C240 (\27\:CKb VSS) capacitor c=3.66869e-17
C241 (\28\:CKb VSS) capacitor c=1.08098e-16
C242 (\31\:CKb VSS) capacitor c=7.34164e-17
C243 (\15\:RN VSS) capacitor c=2.14146e-16
C244 (\16\:RN VSS) capacitor c=4.13539e-16
C245 (\17\:RN VSS) capacitor c=5.95595e-16
C246 (\18\:RN VSS) capacitor c=4.53244e-16
C247 (\19\:RN VSS) capacitor c=2.14954e-16
C248 (\15\:SE VSS) capacitor c=5.58523e-17
C249 (\16\:SE VSS) capacitor c=8.79018e-16
C250 (\17\:SE VSS) capacitor c=2.35547e-16
C251 (\18\:SE VSS) capacitor c=2.5088e-16
C252 (\19\:SE VSS) capacitor c=8.80515e-16
C253 (\20\:SE VSS) capacitor c=5.57734e-17
C254 (\21\:SE VSS) capacitor c=8.60384e-17
C255 (\22\:SE VSS) capacitor c=5.81702e-17
C256 (\19\:Ckbb VSS) capacitor c=3.52885e-16
C257 (\20\:Ckbb VSS) capacitor c=1.60304e-16
C258 (\21\:Ckbb VSS) capacitor c=3.25746e-16
C259 (\23\:Ckbb VSS) capacitor c=2.37799e-16
C260 (\24\:Ckbb VSS) capacitor c=1.6024e-16
C261 (\25\:Ckbb VSS) capacitor c=3.52889e-16
C262 (\14\:qbint_2 VSS) capacitor c=1.76768e-17
C263 (\15\:qbint_2 VSS) capacitor c=5.06574e-17
C264 (\18\:qbint_2 VSS) capacitor c=9.69067e-17
C265 (\3\:Q2 VSS) capacitor c=2.66588e-17
C266 (\7\:Q2 VSS) capacitor c=2.39701e-17
C267 (\10\:qint_2 VSS) capacitor c=1.72511e-17
C268 (\13\:qint_2 VSS) capacitor c=3.88155e-17
C269 (\5\:VDD VSS) capacitor c=2.83137e-17
C270 (\13\:VDD VSS) capacitor c=2.56801e-17
C271 (\16\:VDD VSS) capacitor c=2.02925e-17
C272 (\19\:VDD VSS) capacitor c=4.25955e-18
C273 (\23\:VDD VSS) capacitor c=2.72478e-17
C274 (\26\:VDD VSS) capacitor c=3.45047e-17
C275 (\32\:VDD VSS) capacitor c=3.34033e-17
C276 (\35\:VDD VSS) capacitor c=2.73958e-17
C277 (\39\:VDD VSS) capacitor c=4.21172e-18
C278 (\42\:VDD VSS) capacitor c=2.02609e-17
C279 (\45\:VDD VSS) capacitor c=2.59347e-17
C280 (\48\:VDD VSS) capacitor c=2.82284e-17
C281 (\54\:VDD VSS) capacitor c=1.73239e-17
Rk141 (\1\:VSS \5\:VSS) resistor r=0.2675 c=0
Rk144 (\5\:VSS \9\:VSS) resistor r=0.3131 c=0
Rk145 (\9\:VSS \10\:VSS) resistor r=0.5099 c=0
Rk146 (\10\:VSS \11\:VSS) resistor r=0.1982 c=0
Rk147 (\11\:VSS \12\:VSS) resistor r=0.3571 c=0
Rk148 (\12\:VSS \13\:VSS) resistor r=0.4089 c=0
Rk149 (\13\:VSS \14\:VSS) resistor r=0.4409 c=0
Rk150 (\14\:VSS \15\:VSS) resistor r=0.4411 c=0
Rk151 (\15\:VSS \16\:VSS) resistor r=0.4089 c=0
Rk152 (\16\:VSS \17\:VSS) resistor r=0.3571 c=0
Rk153 (\17\:VSS \18\:VSS) resistor r=0.1982 c=0
Rk154 (\18\:VSS \19\:VSS) resistor r=0.5099 c=0
Rk155 (\19\:VSS \20\:VSS) resistor r=0.3131 c=0
Rk159 (\22\:VSS VSS) resistor r=0.09952 c=0
Rk157 (\20\:VSS \22\:VSS) resistor r=0.2675 c=0
Rk162 (\9\:VSS \29\:VSS) resistor r=0.04367 c=0
Rk163 (\10\:VSS \31\:VSS) resistor r=0.04367 c=0
Rk164 (\12\:VSS \33\:VSS) resistor r=0.04367 c=0
Rk165 (\13\:VSS \35\:VSS) resistor r=0.04367 c=0
Rk166 (\14\:VSS \37\:VSS) resistor r=0.06974 c=0
Rk167 (\15\:VSS \39\:VSS) resistor r=0.04367 c=0
Rk168 (\16\:VSS \41\:VSS) resistor r=0.04367 c=0
Rk169 (\18\:VSS \43\:VSS) resistor r=0.04367 c=0
Rk170 (\19\:VSS \45\:VSS) resistor r=0.04367 c=0
Rk102 (\1\:VDD \5\:VDD) resistor r=0.258 c=0
Rk107 (\5\:VDD \13\:VDD) resistor r=0.2878 c=0
Rk108 (\13\:VDD \15\:VDD) resistor r=0.04367 c=0
Rk109 (\13\:VDD \16\:VDD) resistor r=0.4594 c=0
Rk110 (\16\:VDD \18\:VDD) resistor r=0.04367 c=0
Rk111 (\16\:VDD \19\:VDD) resistor r=0.1743 c=0
Rk112 (\19\:VDD \21\:VDD) resistor r=0.04367 c=0
Rk113 (\19\:VDD \22\:VDD) resistor r=0.07201 c=0
Rk114 (\22\:VDD \23\:VDD) resistor r=0.3697 c=0
Rk115 (\23\:VDD \25\:VDD) resistor r=0.04367 c=0
Rk116 (\23\:VDD \26\:VDD) resistor r=0.3963 c=0
Rk117 (\26\:VDD \28\:VDD) resistor r=0.04367 c=0
Rk118 (\26\:VDD \29\:VDD) resistor r=0.4409 c=0
Rk119 (\29\:VDD \31\:VDD) resistor r=0.07191 c=0
Rk120 (\29\:VDD \32\:VDD) resistor r=0.4411 c=0
Rk121 (\32\:VDD \34\:VDD) resistor r=0.04367 c=0
Rk122 (\32\:VDD \35\:VDD) resistor r=0.3963 c=0
Rk123 (\35\:VDD \37\:VDD) resistor r=0.04367 c=0
Rk124 (\35\:VDD \38\:VDD) resistor r=0.3697 c=0
Rk125 (\38\:VDD \39\:VDD) resistor r=0.07201 c=0
Rk126 (\39\:VDD \41\:VDD) resistor r=0.04367 c=0
Rk127 (\39\:VDD \42\:VDD) resistor r=0.1743 c=0
Rk128 (\42\:VDD \44\:VDD) resistor r=0.04367 c=0
Rk129 (\42\:VDD \45\:VDD) resistor r=0.4594 c=0
Rk130 (\45\:VDD \47\:VDD) resistor r=0.04367 c=0
Rk131 (\45\:VDD \48\:VDD) resistor r=0.2878 c=0
Rk139 (\54\:VDD VDD) resistor r=0.09952 c=0
Rk135 (\48\:VDD \54\:VDD) resistor r=0.258 c=0
Rk1 (Q1N \2\:Q1N) resistor r=0.02797 c=0
Rk2 (Q1N \4\:Q1N) resistor r=0.1527 c=0
Rk6 (\1\:Q1 \3\:Q1) resistor r=0.001729 c=0
Rk7 (Q1 \4\:Q1) resistor r=0.002824 c=0
Rk8 (\1\:Q1 \4\:Q1) resistor r=0.09514 c=0
Rk10 (\4\:Q1 \5\:Q1) resistor r=0.06082 c=0
Rk9 (\5\:Q1 \7\:Q1) resistor r=0.002882 c=0
Rk68 (\15\:RN \16\:RN) resistor r=1.2936 c=0
Rk72 (\17\:RN RN) resistor r=0.01676 c=0
Rk69 (\16\:RN \17\:RN) resistor r=2.4995 c=0
Rk70 (\17\:RN \18\:RN) resistor r=2.8484 c=0
Rk71 (\18\:RN \19\:RN) resistor r=1.2936 c=0
Rk73 (\15\:SE \16\:SE) resistor r=0.263 c=0
Rk74 (\16\:SE \17\:SE) resistor r=0.5966 c=0
Rk75 (\17\:SE \18\:SE) resistor r=1.2529 c=0
Rk76 (\18\:SE \19\:SE) resistor r=0.6992 c=0
Rk77 (\19\:SE \20\:SE) resistor r=0.263 c=0
Rk78 (\17\:SE \21\:SE) resistor r=0.2336 c=0
Rk80 (\22\:SE SE) resistor r=0.0331 c=0
Rk79 (\18\:SE \22\:SE) resistor r=0.2336 c=0
Rk24 (\4\:D1 D1) resistor r=0.01767 c=0
Rk29 (\4\:SI1 \5\:SI1) resistor r=0.007732 c=0
Rk30 (SI1 \6\:SI1) resistor r=0.007732 c=0
Rk31 (\4\:SI1 \6\:SI1) resistor r=0.0332 c=0
Rk99 (Q2N \2\:Q2N) resistor r=0.02797 c=0
Rk100 (Q2N \4\:Q2N) resistor r=0.1527 c=0
Rk91 (\2\:Q2 \3\:Q2) resistor r=0.001729 c=0
Rk92 (\4\:Q2 Q2) resistor r=0.00294 c=0
Rk93 (\3\:Q2 \4\:Q2) resistor r=0.09514 c=0
Rk95 (\4\:Q2 \7\:Q2) resistor r=0.06082 c=0
Rk94 (\6\:Q2 \7\:Q2) resistor r=0.002882 c=0
Rk42 (\4\:D2 D2) resistor r=0.01746 c=0
Rk37 (SI2 \4\:SI2) resistor r=0.007732 c=0
Rk39 (\4\:SI2 \5\:SI2) resistor r=0.03278 c=0
Rk38 (\5\:SI2 \6\:SI2) resistor r=0.007732 c=0
Rk36 (CK \5\:CK) resistor r=0.01183 c=0
Rk35 (\4\:CK \5\:CK) resistor r=0.004252 c=0
Rk34 (\16\:Ckbb \18\:Ckbb) resistor r=0.3066 c=0
Rk81 (\19\:Ckbb \20\:Ckbb) resistor r=0.7985 c=0
Rk82 (\20\:Ckbb \21\:Ckbb) resistor r=0.4817 c=0
Rk83 (\21\:Ckbb \22\:Ckbb) resistor r=2.1046 c=0
Rk84 (\22\:Ckbb \23\:Ckbb) resistor r=1.4764 c=0
Rk85 (\23\:Ckbb \24\:Ckbb) resistor r=0.4817 c=0
Rk86 (\24\:Ckbb \25\:Ckbb) resistor r=0.7985 c=0
Rk56 (\19\:CKb \20\:CKb) resistor r=0.6692 c=0
Rk57 (\20\:CKb \21\:CKb) resistor r=0.9842 c=0
Rk58 (\21\:CKb \22\:CKb) resistor r=1.995 c=0
Rk59 (\22\:CKb \23\:CKb) resistor r=1.8675 c=0
Rk60 (\23\:CKb \24\:CKb) resistor r=0.9842 c=0
Rk61 (\24\:CKb \25\:CKb) resistor r=0.7246 c=0
Rk62 (\20\:CKb \26\:CKb) resistor r=0.2774 c=0
Rk63 (\22\:CKb \27\:CKb) resistor r=0.1105 c=0
Rk64 (\27\:CKb \28\:CKb) resistor r=0.2119 c=0
Rk65 (\28\:CKb \30\:CKb) resistor r=0.2732 c=0
Rk66 (\24\:CKb \31\:CKb) resistor r=0.2774 c=0
Rk67 (\27\:CKb \33\:CKb) resistor r=0.1969 c=0
Rk25 (\2\:Db \3\:Db) resistor r=0.2035 c=0
Rk26 (\3\:Db \5\:Db) resistor r=0.2951 c=0
Rk27 (\3\:Db \7\:Db) resistor r=0.5457 c=0
Rk28 (\5\:Db \9\:Db) resistor r=0.4327 c=0
Rk3 (\9\:qint \10\:qint) resistor r=0.106 c=0
Rk4 (\10\:qint \11\:qint) resistor r=0.1389 c=0
Rk5 (\10\:qint \13\:qint) resistor r=0.1181 c=0
Rk20 (\2\:n6 \4\:n6) resistor r=0.221 c=0
Rk32 (\5\:SEb \7\:SEb) resistor r=0.408 c=0
Rk33 (\7\:SEb \8\:SEb) resistor r=0.5346 c=0
Rk11 (\14\:qbint \16\:qbint) resistor r=0.5522 c=0
Rk12 (\16\:qbint \17\:qbint) resistor r=0.3335 c=0
Rk13 (\17\:qbint \18\:qbint) resistor r=0.1547 c=0
Rk14 (\17\:qbint \20\:qbint) resistor r=0.2012 c=0
Rk15 (\5\:n30 \7\:n30) resistor r=0.3635 c=0
Rk16 (\7\:n30 \8\:n30) resistor r=0.5719 c=0
Rk17 (\4\:mout \5\:mout) resistor r=0.4446 c=0
Rk18 (\5\:mout \7\:mout) resistor r=0.1181 c=0
Rk19 (\5\:mout \9\:mout) resistor r=0.2096 c=0
Rk21 (\6\:n20 \7\:n20) resistor r=0.2627 c=0
Rk22 (\7\:n20 \8\:n20) resistor r=0.5662 c=0
Rk23 (\7\:n20 \10\:n20) resistor r=0.1899 c=0
Rk43 (\2\:Db_2 \3\:Db_2) resistor r=0.5919 c=0
Rk44 (\3\:Db_2 \5\:Db_2) resistor r=0.2951 c=0
Rk45 (\3\:Db_2 \7\:Db_2) resistor r=0.2035 c=0
Rk46 (\5\:Db_2 \9\:Db_2) resistor r=0.4327 c=0
Rk96 (\9\:qint_2 \10\:qint_2) resistor r=0.106 c=0
Rk97 (\10\:qint_2 \12\:qint_2) resistor r=0.1181 c=0
Rk98 (\10\:qint_2 \13\:qint_2) resistor r=0.1389 c=0
Rk47 (\2\:n6_2 \4\:n6_2) resistor r=0.221 c=0
Rk40 (\4\:SEb_2 \6\:SEb_2) resistor r=0.536 c=0
Rk41 (\6\:SEb_2 \8\:SEb_2) resistor r=0.4056 c=0
Rk87 (\14\:qbint_2 \15\:qbint_2) resistor r=0.1547 c=0
Rk88 (\15\:qbint_2 \17\:qbint_2) resistor r=0.3335 c=0
Rk89 (\17\:qbint_2 \18\:qbint_2) resistor r=0.5518 c=0
Rk90 (\15\:qbint_2 \20\:qbint_2) resistor r=0.197 c=0
Rk54 (\5\:n30_2 \7\:n30_2) resistor r=0.3643 c=0
Rk55 (\7\:n30_2 \8\:n30_2) resistor r=0.5749 c=0
Rk51 (\5\:mout_2 \6\:mout_2) resistor r=0.2391 c=0
Rk52 (\6\:mout_2 \7\:mout_2) resistor r=0.4446 c=0
Rk53 (\6\:mout_2 \9\:mout_2) resistor r=0.1181 c=0
Rk48 (\5\:n20_2 \6\:n20_2) resistor r=0.5662 c=0
Rk49 (\6\:n20_2 \8\:n20_2) resistor r=0.2604 c=0
Rk50 (\6\:n20_2 \10\:n20_2) resistor r=0.1899 c=0
Rl70 (\9\:RN \10\:RN) resistor r=147.643 c=0
Rl30 (\5\:RN \6\:RN) resistor r=147.643 c=0
Rl82 (\13\:RN \14\:RN) resistor r=29.5379 c=0
Rl81 (\12\:RN \13\:RN) resistor r=37.6944 c=0
Rl80 (\11\:RN \12\:RN) resistor r=47.3097 c=0
Rl69 (\8\:RN \9\:RN) resistor r=52.6149 c=0
Rl31 (\6\:RN \7\:RN) resistor r=52.6149 c=0
Rl19 (\2\:RN \3\:RN) resistor r=37.6944 c=0
Rl18 (\1\:RN \2\:RN) resistor r=47.3097 c=0
Rl20 (\3\:RN \4\:RN) resistor r=29.5379 c=0
Rl60 (\13\:SE \14\:SE) resistor r=52.6149 c=0
Rl57 (\11\:SE \12\:SE) resistor r=33.3841 c=0
Rl53 (\8\:SE \9\:SE) resistor r=54.5379 c=0
Rl54 (\9\:SE \10\:SE) resistor r=41.0764 c=0
Rl46 (\5\:SE \6\:SE) resistor r=54.5379 c=0
Rl47 (\6\:SE \7\:SE) resistor r=41.0764 c=0
Rl43 (\3\:SE \4\:SE) resistor r=33.3841 c=0
Rl40 (\1\:SE \2\:SE) resistor r=52.6149 c=0
Rl38 (\1\:D1 \2\:D1) resistor r=91.5405 c=0
Rl39 (\2\:D1 \3\:D1) resistor r=35.7713 c=0
Rl45 (\2\:SI1 \3\:SI1) resistor r=89.1533 c=0
Rl44 (\1\:SI1 \2\:SI1) resistor r=41.0764 c=0
Rl61 (\1\:D2 \2\:D2) resistor r=91.5405 c=0
Rl62 (\2\:D2 \3\:D2) resistor r=35.7713 c=0
Rl56 (\2\:SI2 \3\:SI2) resistor r=89.1533 c=0
Rl55 (\1\:SI2 \2\:SI2) resistor r=41.0764 c=0
Rl51 (\1\:CK \2\:CK) resistor r=24.2328 c=0
Rl52 (\2\:CK \3\:CK) resistor r=58.8482 c=0
Rl75 (\12\:Ckbb \13\:Ckbb) resistor r=183.747 c=0
Rl25 (\2\:Ckbb \3\:Ckbb) resistor r=183.747 c=0
Rl76 (\13\:Ckbb \14\:Ckbb) resistor r=62.6944 c=0
Rl66 (\10\:Ckbb \11\:Ckbb) resistor r=62.6944 c=0
Rl63 (\8\:Ckbb \9\:Ckbb) resistor r=230.67 c=0
Rl37 (\6\:Ckbb \7\:Ckbb) resistor r=230.67 c=0
Rl34 (\4\:Ckbb \5\:Ckbb) resistor r=62.6944 c=0
Rl24 (Ckbb \2\:Ckbb) resistor r=62.6944 c=0
Rl64 (\12\:CKb \13\:CKb) resistor r=109.983 c=0
Rl36 (\6\:CKb \7\:CKb) resistor r=109.983 c=0
Rl77 (\17\:CKb \18\:CKb) resistor r=31.9251 c=0
Rl74 (\15\:CKb \16\:CKb) resistor r=24.2328 c=0
Rl65 (\13\:CKb \14\:CKb) resistor r=32.9066 c=0
Rl35 (\5\:CKb \6\:CKb) resistor r=33.8727 c=0
Rl26 (\3\:CKb \4\:CKb) resistor r=24.2328 c=0
Rl23 (CKb \2\:CKb) resistor r=31.9251 c=0
Rl50 (\9\:CKb \11\:CKb) resistor r=64.2642 c=0
Rl49 (\9\:CKb \10\:CKb) resistor r=37.3411 c=0
Rl48 (\8\:CKb \9\:CKb) resistor r=1.2334 c=0
Rl5 (qint \6\:qint) resistor r=6.6351 c=0
Rl41 (SEb \2\:SEb) resistor r=26.9231 c=0
Rl42 (\2\:SEb \3\:SEb) resistor r=148.376 c=0
Rl21 (\12\:qbint \11\:qbint) resistor r=62.2302 c=0
Rl22 (\12\:qbint \13\:qbint) resistor r=39.1533 c=0
Rl12 (qbint \7\:qbint) resistor r=5.8198 c=0
Rl9 (\4\:qbint qbint) resistor r=145.471 c=0
Rl15 (\4\:qbint \10\:qbint) resistor r=37.6951 c=0
Rl10 (\4\:qbint \5\:qbint) resistor r=51.1566 c=0
Rl17 (\2\:n30 \3\:n30) resistor r=44.9638 c=0
Rl16 (n30 \2\:n30) resistor r=49.9532 c=0
Rl32 (mout \2\:mout) resistor r=72.3097 c=0
Rl33 (\2\:mout \3\:mout) resistor r=26.1559 c=0
Rl29 (\2\:n20 \4\:n20) resistor r=36.2526 c=0
Rl28 (\2\:n20 \3\:n20) resistor r=82.4064 c=0
Rl27 (n20 \2\:n20) resistor r=2.7713 c=0
Rl96 (qint_2 \4\:qint_2) resistor r=6.6351 c=0
Rl59 (\2\:SEb_2 \3\:SEb_2) resistor r=26.3736 c=0
Rl58 (SEb_2 \2\:SEb_2) resistor r=147.512 c=0
Rl78 (\2\:qbint_2 qbint_2) resistor r=62.2302 c=0
Rl79 (\2\:qbint_2 \3\:qbint_2) resistor r=39.1533 c=0
Rl85 (\5\:qbint_2 \4\:qbint_2) resistor r=37.6951 c=0
Rl89 (\5\:qbint_2 \9\:qbint_2) resistor r=51.1566 c=0
Rl88 (\6\:qbint_2 \8\:qbint_2) resistor r=5.8198 c=0
Rl86 (\6\:qbint_2 \5\:qbint_2) resistor r=145.471 c=0
Rl83 (n30_2 \2\:n30_2) resistor r=44.1006 c=0
Rl84 (\2\:n30_2 \3\:n30_2) resistor r=49.8142 c=0
Rl67 (mout_2 \2\:mout_2) resistor r=72.3097 c=0
Rl68 (\2\:mout_2 \3\:mout_2) resistor r=26.1559 c=0
Rl71 (n20_2 \2\:n20_2) resistor r=36.2526 c=0
Rl73 (\2\:n20_2 \4\:n20_2) resistor r=82.4064 c=0
Rl72 (\2\:n20_2 \3\:n20_2) resistor r=2.7666 c=0
Rz33 (\29\:VSS \28\:VSS) resistor r=75 c=0
Rz34 (\31\:VSS \30\:VSS) resistor r=75 c=0
Rz35 (\33\:VSS \32\:VSS) resistor r=75 c=0
Rz36 (\35\:VSS \34\:VSS) resistor r=75 c=0
Rz37 (\37\:VSS \36\:VSS) resistor r=75 c=0
Rz38 (\39\:VSS \38\:VSS) resistor r=75 c=0
Rz39 (\41\:VSS \40\:VSS) resistor r=75 c=0
Rz40 (\43\:VSS \42\:VSS) resistor r=75 c=0
Rz41 (\45\:VSS \44\:VSS) resistor r=75 c=0
Rz24 (\5\:VDD \4\:VDD) resistor r=6.25 c=0
Rz25 (\22\:VDD \4\:VDD) resistor r=6.25 c=0
Rz26 (\29\:VDD \4\:VDD) resistor r=6.25 c=0
Rz27 (\38\:VDD \4\:VDD) resistor r=6.25 c=0
Rz28 (\48\:VDD \4\:VDD) resistor r=6.25 c=0
Rz1 (\2\:Q1N \1\:Q1N) resistor r=75 c=0
Rz3 (\3\:Q1 \2\:Q1) resistor r=75 c=0
Rz23 (\2\:Q2N \1\:Q2N) resistor r=75 c=0
Rz21 (\2\:Q2 \1\:Q2) resistor r=75 c=0
Rz11 (\15\:Ckbb \16\:Ckbb) resistor r=75 c=0
Rz19 (\15\:Ckbb \22\:Ckbb) resistor r=37.5 c=0
Rz18 (\29\:CKb \30\:CKb) resistor r=75 c=0
Rz8 (\6\:Db \7\:Db) resistor r=75 c=0
Rz9 (\8\:Db \9\:Db) resistor r=75 c=0
Rz2 (\13\:qint \12\:qint) resistor r=75 c=0
Rz10 (\4\:SEb \5\:SEb) resistor r=75 c=0
Rz4 (\20\:qbint \19\:qbint) resistor r=75 c=0
Rz5 (\6\:n30 \7\:n30) resistor r=75 c=0
Rz6 (\6\:mout \7\:mout) resistor r=75 c=0
Rz7 (\9\:n20 \10\:n20) resistor r=75 c=0
Rz13 (Db_2 \2\:Db_2) resistor r=75 c=0
Rz14 (\8\:Db_2 \9\:Db_2) resistor r=75 c=0
Rz22 (\12\:qint_2 \11\:qint_2) resistor r=75 c=0
Rz12 (\7\:SEb_2 \8\:SEb_2) resistor r=75 c=0
Rz20 (\20\:qbint_2 \19\:qbint_2) resistor r=75 c=0
Rz17 (\6\:n30_2 \7\:n30_2) resistor r=75 c=0
Rz16 (\8\:mout_2 \9\:mout_2) resistor r=75 c=0
Rz15 (\9\:n20_2 \10\:n20_2) resistor r=75 c=0
Ry46 (\5\:VSS \4\:VSS) resistor r=5.1667 c=0
Ry47 (\11\:VSS \4\:VSS) resistor r=5.1667 c=0
Ry48 (\14\:VSS \4\:VSS) resistor r=5.1667 c=0
Ry49 (\17\:VSS \4\:VSS) resistor r=5.1667 c=0
Ry50 (\20\:VSS \4\:VSS) resistor r=5.1667 c=0
Ry31 (\15\:VDD \14\:VDD) resistor r=62 c=0
Ry32 (\18\:VDD \17\:VDD) resistor r=62 c=0
Ry33 (\21\:VDD \20\:VDD) resistor r=62 c=0
Ry34 (\25\:VDD \24\:VDD) resistor r=62 c=0
Ry35 (\28\:VDD \27\:VDD) resistor r=62 c=0
Ry36 (\31\:VDD \30\:VDD) resistor r=62 c=0
Ry37 (\34\:VDD \33\:VDD) resistor r=62 c=0
Ry38 (\37\:VDD \36\:VDD) resistor r=62 c=0
Ry39 (\41\:VDD \40\:VDD) resistor r=62 c=0
Ry40 (\44\:VDD \43\:VDD) resistor r=62 c=0
Ry41 (\47\:VDD \46\:VDD) resistor r=62 c=0
Ry1 (\4\:Q1N \3\:Q1N) resistor r=31 c=0
Ry3 (\7\:Q1 \6\:Q1) resistor r=31 c=0
Ry26 (\4\:Q2N \3\:Q2N) resistor r=31 c=0
Ry24 (\6\:Q2 \5\:Q2) resistor r=31 c=0
Ry13 (\17\:Ckbb \18\:Ckbb) resistor r=62 c=0
Ry22 (\32\:CKb \33\:CKb) resistor r=62 c=0
Ry10 (Db \2\:Db) resistor r=62 c=0
Ry11 (\4\:Db \5\:Db) resistor r=62 c=0
Ry2 (\9\:qint \8\:qint) resistor r=62 c=0
Ry7 (n6 \2\:n6) resistor r=62 c=0
Ry8 (\3\:n6 \4\:n6) resistor r=62 c=0
Ry12 (\6\:SEb \7\:SEb) resistor r=62 c=0
Ry4 (\16\:qbint \15\:qbint) resistor r=62 c=0
Ry5 (\4\:n30 \5\:n30) resistor r=62 c=0
Ry6 (\8\:mout \9\:mout) resistor r=62 c=0
Ry9 (\5\:n20 \6\:n20) resistor r=62 c=0
Ry15 (\4\:Db_2 \5\:Db_2) resistor r=62 c=0
Ry16 (\6\:Db_2 \7\:Db_2) resistor r=62 c=0
Ry25 (\9\:qint_2 \8\:qint_2) resistor r=62 c=0
Ry17 (n6_2 \2\:n6_2) resistor r=62 c=0
Ry18 (\3\:n6_2 \4\:n6_2) resistor r=62 c=0
Ry14 (\5\:SEb_2 \6\:SEb_2) resistor r=62 c=0
Ry23 (\17\:qbint_2 \16\:qbint_2) resistor r=62 c=0
Ry21 (\4\:n30_2 \5\:n30_2) resistor r=62 c=0
Ry20 (\4\:mout_2 \5\:mout_2) resistor r=62 c=0
Ry19 (\7\:n20_2 \8\:n20_2) resistor r=62 c=0
Rx24 (\14\:RN \15\:RN) resistor r=45 c=0
Rx25 (\8\:RN \16\:RN) resistor r=45 c=0
Rx26 (\7\:RN \18\:RN) resistor r=45 c=0
Rx27 (\4\:RN \19\:RN) resistor r=45 c=0
Rx28 (\14\:SE \15\:SE) resistor r=45 c=0
Rx29 (\12\:SE \16\:SE) resistor r=45 c=0
Rx30 (\4\:SE \19\:SE) resistor r=45 c=0
Rx31 (\2\:SE \20\:SE) resistor r=45 c=0
Rx32 (\9\:SE \21\:SE) resistor r=45 c=0
Rx33 (\6\:SE \22\:SE) resistor r=45 c=0
Rx7 (\2\:D1 \4\:D1) resistor r=45 c=0
Rx8 (\2\:SI1 \5\:SI1) resistor r=45 c=0
Rx13 (\2\:D2 \4\:D2) resistor r=45 c=0
Rx11 (\2\:SI2 \6\:SI2) resistor r=45 c=0
Rx10 (\2\:CK \4\:CK) resistor r=45 c=0
Rx34 (\14\:Ckbb \19\:Ckbb) resistor r=45 c=0
Rx35 (\11\:Ckbb \20\:Ckbb) resistor r=45 c=0
Rx36 (\9\:Ckbb \21\:Ckbb) resistor r=45 c=0
Rx37 (\7\:Ckbb \23\:Ckbb) resistor r=45 c=0
Rx38 (\5\:Ckbb \24\:Ckbb) resistor r=45 c=0
Rx39 (Ckbb \25\:Ckbb) resistor r=45 c=0
Rx17 (\18\:CKb \19\:CKb) resistor r=45 c=0
Rx18 (\14\:CKb \21\:CKb) resistor r=45 c=0
Rx19 (\5\:CKb \23\:CKb) resistor r=45 c=0
Rx20 (\2\:CKb \25\:CKb) resistor r=45 c=0
Rx21 (\16\:CKb \26\:CKb) resistor r=45 c=0
Rx22 (\8\:CKb \28\:CKb) resistor r=45 c=0
Rx23 (\4\:CKb \31\:CKb) resistor r=45 c=0
Rx1 (\11\:qint \6\:qint) resistor r=45 c=0
Rx9 (\2\:SEb \8\:SEb) resistor r=45 c=0
Rx2 (\14\:qbint \12\:qbint) resistor r=45 c=0
Rx3 (\18\:qbint \7\:qbint) resistor r=45 c=0
Rx4 (\2\:n30 \8\:n30) resistor r=45 c=0
Rx5 (\2\:mout \4\:mout) resistor r=45 c=0
Rx6 (n20 \8\:n20) resistor r=45 c=0
Rx42 (\13\:qint_2 \4\:qint_2) resistor r=45 c=0
Rx12 (\2\:SEb_2 \4\:SEb_2) resistor r=45 c=0
Rx40 (\14\:qbint_2 \8\:qbint_2) resistor r=45 c=0
Rx41 (\18\:qbint_2 \2\:qbint_2) resistor r=45 c=0
Rx16 (\2\:n30_2 \8\:n30_2) resistor r=45 c=0
Rx15 (\2\:mout_2 \7\:mout_2) resistor r=45 c=0
Rx14 (\3\:n20_2 \5\:n20_2) resistor r=45 c=0
mn55 (\2\:Q1 qbint \20\:VSS VSS) g45n1svt w=(2.6e-07) l=4.5e-08 nf=1 \
        as=5.46e-14 ad=6.32e-14 ps=9.4e-07 pd=1.52e-06 nrd=1.16667 \
        nrs=1.16667 sa=1.2e-07 sb=3.95e-07 sd=160n sca=17.5885 \
        scb=0.0172826 scc=0.00162584 m=(2)
mn57_1__rcx (\1\:Q1N qint \22\:VSS VSS) g45n1svt w=(2.6e-07) l=4.5e-08 \
        nf=1 as=5.085e-14 ad=5.448e-14 ps=1.17e-06 pd=1.22e-06 nrd=1.16667 \
        nrs=1.16667 sa=4.56058e-07 sb=1.2e-07 sd=160n sca=17.5885 \
        scb=0.0172826 scc=0.00162584 m=(2)
NM19 (\1\:Q2N qint_2 \1\:VSS VSS) g45n1svt w=(2.6e-07) l=4.5e-08 nf=1 \
        as=5.085e-14 ad=5.448e-14 ps=1.17e-06 pd=1.22e-06 nrd=1.16667 \
        nrs=1.16667 sa=4.56058e-07 sb=1.2e-07 sd=160n sca=17.5885 \
        scb=0.0172826 scc=0.00162584 m=(2)
NM17 (\1\:Q2 \6\:qbint_2 \5\:VSS VSS) g45n1svt w=(2.6e-07) l=4.5e-08 \
        nf=1 as=5.46e-14 ad=6.32e-14 ps=9.4e-07 pd=1.52e-06 nrd=1.16667 \
        nrs=1.16667 sa=1.2e-07 sb=3.95e-07 sd=160n sca=17.5885 \
        scb=0.0172826 scc=0.00162584 m=(2)
mn21 (\15\:Ckbb \10\:CKb \36\:VSS VSS) g45n1svt w=(1.45e-07) l=4.5e-08 \
        nf=1 as=9.708e-14 ad=6.752e-14 ps=1.51e-06 pd=1.56e-06 nrd=1.16667 \
        nrs=1.16667 sa=2.3e-07 sb=3.6e-07 sd=160n sca=19.8813 \
        scb=0.0206549 scc=0.00197265 m=(1)
mn20 (\29\:CKb \3\:CK \36\:VSS VSS) g45n1svt w=(1.45e-07) l=4.5e-08 nf=1 \
        as=2.03e-14 ad=6.752e-14 ps=5.7e-07 pd=1.56e-06 nrd=1.16667 \
        nrs=1.16667 sa=4.5e-07 sb=1.4e-07 sd=160n sca=19.8813 \
        scb=0.0206549 scc=0.00197265 m=(1)
NM18 (\11\:qint_2 \9\:qbint_2 \1\:VSS VSS) g45n1svt w=(1.45e-07) \
        l=4.5e-08 nf=1 as=6.735e-14 ad=2.03e-14 ps=1.6e-06 pd=5.7e-07 \
        nrd=1.16667 nrs=1.16667 sa=1.4e-07 sb=5.4e-07 sd=160n sca=23.279 \
        scb=0.0230742 scc=0.00267719 m=(1)
NM15 (n11_2 \3\:qbint_2 \28\:VSS VSS) g45n1svt w=(1.45e-07) l=4.5e-08 \
        nf=1 as=1.957e-14 ad=8.05e-14 ps=5.6e-07 pd=1.49e-06 nrd=1.16667 \
        nrs=1.16667 sa=5.75e-07 sb=1.645e-06 sd=160n sca=15.7071 \
        scb=0.0167369 scc=0.00113434 m=(1)
NM16 (\6\:n30_2 \17\:CKb n11_2 VSS) g45n1svt w=(1.45e-07) l=4.5e-08 nf=1 \
        as=1.957e-14 ad=2.9e-14 ps=5.6e-07 pd=6.9e-07 nrd=1.16667 \
        nrs=1.16667 sa=1.465e-06 sb=7.55e-07 sd=160n sca=15.7071 \
        scb=0.0167369 scc=0.00113434 m=(1)
NM12 (\8\:mout_2 \13\:Ckbb \6\:n30_2 VSS) g45n1svt w=(1.45e-07) l=4.5e-08 \
        nf=1 as=3.335e-14 ad=2.9e-14 ps=7.5e-07 pd=6.9e-07 nrd=1.16667 \
        nrs=1.16667 sa=1e-06 sb=1.22e-06 sd=160n sca=15.7071 scb=0.0167369 \
        scc=0.00113434 m=(1)
NM8 (\8\:mout_2 \4\:n20_2 \30\:VSS VSS) g45n1svt w=(1.45e-07) l=4.5e-08 \
        nf=1 as=8.475e-14 ad=3.335e-14 ps=1.59e-06 pd=7.5e-07 nrd=1.16667 \
        nrs=1.16667 sa=9.45e-07 sb=1.275e-06 sd=160n sca=15.7071 \
        scb=0.0167369 scc=0.00113434 m=(1)
NM10 (n7_2 \10\:RN \30\:VSS VSS) g45n1svt w=(1.45e-07) l=4.5e-08 nf=1 \
        as=8.475e-14 ad=8.7e-15 ps=1.59e-06 pd=4.1e-07 nrd=1.16667 \
        nrs=1.16667 sa=6.3e-07 sb=1.59e-06 sd=160n sca=15.7071 \
        scb=0.0167369 scc=0.00113434 m=(1)
NM11 (n5_2 \3\:mout_2 n7_2 VSS) g45n1svt w=(1.45e-07) l=4.5e-08 nf=1 \
        as=8.7e-15 ad=1.957e-14 ps=4.1e-07 pd=5.6e-07 nrd=1.16667 \
        nrs=1.16667 sa=5.25e-07 sb=1.695e-06 sd=160n sca=15.7071 \
        scb=0.0167369 scc=0.00113434 m=(1)
NM9 (\9\:n20_2 \10\:Ckbb n5_2 VSS) g45n1svt w=(1.45e-07) l=4.5e-08 nf=1 \
        as=2.32e-14 ad=1.957e-14 ps=6.1e-07 pd=5.6e-07 nrd=1.16667 \
        nrs=1.16667 sa=1.875e-06 sb=3.45e-07 sd=160n sca=15.7071 \
        scb=0.0167369 scc=0.00113434 m=(1)
NM7 (\8\:Db_2 \12\:CKb \9\:n20_2 VSS) g45n1svt w=(1.45e-07) l=4.5e-08 \
        nf=1 as=2.32e-14 ad=2.03e-14 ps=6.1e-07 pd=5.7e-07 nrd=1.16667 \
        nrs=1.16667 sa=1.4e-07 sb=2e-06 sd=160n sca=15.7071 scb=0.0167369 \
        scc=0.00113434 m=(1)
NM1 (n1_2 \3\:D2 \32\:VSS VSS) g45n1svt w=(1.45e-07) l=4.5e-08 nf=1 \
        as=5.027e-14 ad=2.03e-14 ps=1.33e-06 pd=5.7e-07 nrd=1.16667 \
        nrs=1.16667 sa=8.86379e-07 sb=1.25e-07 sd=160n sca=12.9138 \
        scb=0.0133404 scc=0.000640143 m=(1)
NM2 (Db_2 SEb_2 n1_2 VSS) g45n1svt w=(1.45e-07) l=4.5e-08 nf=1 \
        as=3.77e-14 ad=2.03e-14 ps=8.1e-07 pd=5.7e-07 nrd=1.16667 \
        nrs=1.16667 sa=3.1e-07 sb=7.01379e-07 sd=160n sca=12.9138 \
        scb=0.0133404 scc=0.000640143 m=(1)
NM3 (Db_2 \11\:SE n3_2 VSS) g45n1svt w=(1.45e-07) l=4.5e-08 nf=1 \
        as=8.7e-15 ad=3.77e-14 ps=4.1e-07 pd=8.1e-07 nrd=1.16667 \
        nrs=1.16667 sa=3.96379e-07 sb=6.15e-07 sd=160n sca=12.9138 \
        scb=0.0133404 scc=0.000640143 m=(1)
NM4 (n3_2 \1\:SI2 \34\:VSS VSS) g45n1svt w=(1.45e-07) l=4.5e-08 nf=1 \
        as=7.87e-14 ad=8.7e-15 ps=1.6e-06 pd=4.1e-07 nrd=1.16667 \
        nrs=1.16667 sa=2.91379e-07 sb=7.2e-07 sd=160n sca=12.9138 \
        scb=0.0133404 scc=0.000640143 m=(1)
NM0 (\7\:SEb_2 \10\:SE \34\:VSS VSS) g45n1svt w=(1.45e-07) l=4.5e-08 \
        nf=1 as=3.262e-14 ad=7.87e-14 ps=7.4e-07 pd=1.6e-06 nrd=1.16667 \
        nrs=1.16667 sa=4.41897e-07 sb=2.25e-07 sd=160n sca=23.279 \
        scb=0.0230742 scc=0.00267719 m=(1)
mn56 (\12\:qint \5\:qbint \22\:VSS VSS) g45n1svt w=(1.45e-07) l=4.5e-08 \
        nf=1 as=6.735e-14 ad=2.03e-14 ps=1.6e-06 pd=5.7e-07 nrd=1.16667 \
        nrs=1.16667 sa=1.4e-07 sb=5.4e-07 sd=160n sca=23.279 scb=0.0230742 \
        scc=0.00267719 m=(1)
mn50 (n11 \13\:qbint \44\:VSS VSS) g45n1svt w=(1.45e-07) l=4.5e-08 nf=1 \
        as=1.957e-14 ad=8.05e-14 ps=5.6e-07 pd=1.49e-06 nrd=1.16667 \
        nrs=1.16667 sa=5.75e-07 sb=1.645e-06 sd=160n sca=15.7071 \
        scb=0.0167369 scc=0.00113434 m=(1)
mn51 (\6\:n30 CKb n11 VSS) g45n1svt w=(1.45e-07) l=4.5e-08 nf=1 \
        as=1.957e-14 ad=2.9e-14 ps=5.6e-07 pd=6.9e-07 nrd=1.16667 \
        nrs=1.16667 sa=1.465e-06 sb=7.55e-07 sd=160n sca=15.7071 \
        scb=0.0167369 scc=0.00113434 m=(1)
mn40 (\6\:mout \2\:Ckbb \6\:n30 VSS) g45n1svt w=(1.45e-07) l=4.5e-08 nf=1 \
        as=3.335e-14 ad=2.9e-14 ps=7.5e-07 pd=6.9e-07 nrd=1.16667 \
        nrs=1.16667 sa=1e-06 sb=1.22e-06 sd=160n sca=15.7071 scb=0.0167369 \
        scc=0.00113434 m=(1)
mn30 (\6\:mout \3\:n20 \42\:VSS VSS) g45n1svt w=(1.45e-07) l=4.5e-08 \
        nf=1 as=8.475e-14 ad=3.335e-14 ps=1.59e-06 pd=7.5e-07 nrd=1.16667 \
        nrs=1.16667 sa=9.45e-07 sb=1.275e-06 sd=160n sca=15.7071 \
        scb=0.0167369 scc=0.00113434 m=(1)
mn35 (n7 \5\:RN \42\:VSS VSS) g45n1svt w=(1.45e-07) l=4.5e-08 nf=1 \
        as=8.475e-14 ad=8.7e-15 ps=1.59e-06 pd=4.1e-07 nrd=1.16667 \
        nrs=1.16667 sa=6.3e-07 sb=1.59e-06 sd=160n sca=15.7071 \
        scb=0.0167369 scc=0.00113434 m=(1)
mn36 (n5 \3\:mout n7 VSS) g45n1svt w=(1.45e-07) l=4.5e-08 nf=1 as=8.7e-15 \
        ad=1.957e-14 ps=4.1e-07 pd=5.6e-07 nrd=1.16667 nrs=1.16667 \
        sa=5.25e-07 sb=1.695e-06 sd=160n sca=15.7071 scb=0.0167369 \
        scc=0.00113434 m=(1)
mn37 (\9\:n20 \4\:Ckbb n5 VSS) g45n1svt w=(1.45e-07) l=4.5e-08 nf=1 \
        as=2.32e-14 ad=1.957e-14 ps=6.1e-07 pd=5.6e-07 nrd=1.16667 \
        nrs=1.16667 sa=1.875e-06 sb=3.45e-07 sd=160n sca=15.7071 \
        scb=0.0167369 scc=0.00113434 m=(1)
mn25 (\8\:Db \7\:CKb \9\:n20 VSS) g45n1svt w=(1.45e-07) l=4.5e-08 nf=1 \
        as=2.32e-14 ad=2.03e-14 ps=6.1e-07 pd=5.7e-07 nrd=1.16667 \
        nrs=1.16667 sa=1.4e-07 sb=2e-06 sd=160n sca=15.7071 scb=0.0167369 \
        scc=0.00113434 m=(1)
mn11 (n1 \3\:D1 \40\:VSS VSS) g45n1svt w=(1.45e-07) l=4.5e-08 nf=1 \
        as=5.027e-14 ad=2.03e-14 ps=1.33e-06 pd=5.7e-07 nrd=1.16667 \
        nrs=1.16667 sa=8.86379e-07 sb=1.25e-07 sd=160n sca=12.9138 \
        scb=0.0133404 scc=0.000640143 m=(1)
mn12 (\6\:Db \3\:SEb n1 VSS) g45n1svt w=(1.45e-07) l=4.5e-08 nf=1 \
        as=3.77e-14 ad=2.03e-14 ps=8.1e-07 pd=5.7e-07 nrd=1.16667 \
        nrs=1.16667 sa=3.1e-07 sb=7.01379e-07 sd=160n sca=12.9138 \
        scb=0.0133404 scc=0.000640143 m=(1)
mn14 (\6\:Db \3\:SE n3 VSS) g45n1svt w=(1.45e-07) l=4.5e-08 nf=1 \
        as=8.7e-15 ad=3.77e-14 ps=4.1e-07 pd=8.1e-07 nrd=1.16667 \
        nrs=1.16667 sa=3.96379e-07 sb=6.15e-07 sd=160n sca=12.9138 \
        scb=0.0133404 scc=0.000640143 m=(1)
mn13 (n3 \1\:SI1 \38\:VSS VSS) g45n1svt w=(1.45e-07) l=4.5e-08 nf=1 \
        as=7.87e-14 ad=8.7e-15 ps=1.6e-06 pd=4.1e-07 nrd=1.16667 \
        nrs=1.16667 sa=2.91379e-07 sb=7.2e-07 sd=160n sca=12.9138 \
        scb=0.0133404 scc=0.000640143 m=(1)
mn10 (\4\:SEb \7\:SE \38\:VSS VSS) g45n1svt w=(1.45e-07) l=4.5e-08 nf=1 \
        as=3.262e-14 ad=7.87e-14 ps=7.4e-07 pd=1.6e-06 nrd=1.16667 \
        nrs=1.16667 sa=4.41897e-07 sb=2.25e-07 sd=160n sca=23.279 \
        scb=0.0230742 scc=0.00267719 m=(1)
NM13 (\19\:qbint_2 \3\:n30_2 n9_2 VSS) g45n1svt w=(2.05e-07) l=4.5e-08 \
        nf=1 as=2.05e-14 ad=3.383e-14 ps=6.1e-07 pd=7.4e-07 nrd=1.16667 \
        nrs=1.16667 sa=1.50683e-06 sb=1.65e-07 sd=160n sca=13.8179 \
        scb=0.0141903 scc=0.000851218 m=(1)
NM14 (n9_2 \11\:RN \28\:VSS VSS) g45n1svt w=(2.05e-07) l=4.5e-08 nf=1 \
        as=8.05e-14 ad=2.05e-14 ps=1.49e-06 pd=6.1e-07 nrd=1.16667 \
        nrs=1.16667 sa=1.40073e-06 sb=3.1e-07 sd=160n sca=13.8179 \
        scb=0.0141903 scc=0.000851218 m=(1)
mn46 (\19\:qbint n30 n9 VSS) g45n1svt w=(2.05e-07) l=4.5e-08 nf=1 \
        as=2.05e-14 ad=3.383e-14 ps=6.1e-07 pd=7.4e-07 nrd=1.16667 \
        nrs=1.16667 sa=1.50683e-06 sb=1.65e-07 sd=160n sca=13.8179 \
        scb=0.0141903 scc=0.000851218 m=(1)
mn45 (n9 \1\:RN \44\:VSS VSS) g45n1svt w=(2.05e-07) l=4.5e-08 nf=1 \
        as=8.05e-14 ad=2.05e-14 ps=1.49e-06 pd=6.1e-07 nrd=1.16667 \
        nrs=1.16667 sa=1.40073e-06 sb=3.1e-07 sd=160n sca=13.8179 \
        scb=0.0141903 scc=0.000851218 m=(1)
mp21 (\17\:Ckbb \11\:CKb \30\:VDD VDD) g45p1svt w=(2.15e-07) l=4.5e-08 \
        nf=1 as=3.01e-14 ad=8.732e-14 ps=7.1e-07 pd=1.85e-06 nrd=1.16667 \
        nrs=1.16667 sa=1.4e-07 sb=3.6e-07 sd=160n sca=31.508 scb=0.0252524 \
        scc=0.00399199 m=(1)
mp20 (\32\:CKb \1\:CK \30\:VDD VDD) g45p1svt w=(2.15e-07) l=4.5e-08 nf=1 \
        as=3.01e-14 ad=8.732e-14 ps=7.1e-07 pd=1.85e-06 nrd=1.16667 \
        nrs=1.16667 sa=3.6e-07 sb=1.4e-07 sd=160n sca=31.508 scb=0.0252524 \
        scc=0.00399199 m=(1)
PM18 (\8\:qint_2 \4\:qbint_2 \1\:VDD VDD) g45p1svt w=(2.15e-07) \
        l=4.5e-08 nf=1 as=3.01e-14 ad=1.0092e-13 ps=7.1e-07 pd=1.97e-06 \
        nrd=1.16667 nrs=1.16667 sa=5.4e-07 sb=1.4e-07 sd=160n sca=46.1789 \
        scb=0.0284493 scc=0.00588419 m=(1)
PM15 (n8_2 qbint_2 \14\:VDD VDD) g45p1svt w=(2.15e-07) l=4.5e-08 nf=1 \
        as=3.01e-14 ad=1.1192e-13 ps=7.1e-07 pd=1.9e-06 nrd=1.16667 \
        nrs=1.16667 sa=1.235e-06 sb=1.22e-06 sd=160n sca=29.9075 \
        scb=0.0247057 scc=0.00372713 m=(1)
PM16 (\4\:n30_2 \12\:Ckbb n8_2 VDD) g45p1svt w=(2.15e-07) l=4.5e-08 nf=1 \
        as=3.01e-14 ad=5.375e-14 ps=7.1e-07 pd=9.3e-07 nrd=1.16667 \
        nrs=1.16667 sa=1.035e-06 sb=1.42e-06 sd=160n sca=29.9075 \
        scb=0.0247057 scc=0.00372713 m=(1)
PM12 (\4\:n30_2 \15\:CKb \4\:mout_2 VDD) g45p1svt w=(2.15e-07) l=4.5e-08 \
        nf=1 as=3.762e-14 ad=5.375e-14 ps=7.8e-07 pd=9.3e-07 nrd=1.16667 \
        nrs=1.16667 sa=7.4e-07 sb=1.715e-06 sd=160n sca=29.9075 \
        scb=0.0247057 scc=0.00372713 m=(1)
PM8 (\4\:mout_2 n20_2 \17\:VDD VDD) g45p1svt w=(2.15e-07) l=4.5e-08 nf=1 \
        as=8.415e-14 ad=3.762e-14 ps=1.83e-06 pd=7.8e-07 nrd=1.16667 \
        nrs=1.16667 sa=5.2e-07 sb=1.935e-06 sd=160n sca=29.9075 \
        scb=0.0247057 scc=0.00372713 m=(1)
PM9 (n6_2 \9\:RN \17\:VDD VDD) g45p1svt w=(2.15e-07) l=4.5e-08 nf=1 \
        as=8.415e-14 ad=3.44e-14 ps=1.83e-06 pd=7.5e-07 nrd=1.16667 \
        nrs=1.16667 sa=3.05e-07 sb=2e-06 sd=160n sca=29.9075 scb=0.0247057 \
        scc=0.00372713 m=(1)
PM11 (n6_2 mout_2 \20\:VDD VDD) g45p1svt w=(2.15e-07) l=4.5e-08 nf=1 \
        as=6.29e-14 ad=3.44e-14 ps=1.83e-06 pd=7.5e-07 nrd=1.16667 \
        nrs=1.16667 sa=1e-07 sb=2e-06 sd=160n sca=29.9075 scb=0.0247057 \
        scc=0.00372713 m=(1)
PM10 (\7\:n20_2 \13\:CKb \3\:n6_2 VDD) g45p1svt w=(2.15e-07) l=4.5e-08 \
        nf=1 as=3.44e-14 ad=3.01e-14 ps=7.5e-07 pd=7.1e-07 nrd=1.16667 \
        nrs=1.16667 sa=1.4e-07 sb=3.31047e-07 sd=160n sca=45.7906 \
        scb=0.0283307 scc=0.00588417 m=(1)
PM7 (\7\:n20_2 \8\:Ckbb \4\:Db_2 VDD) g45p1svt w=(2.15e-07) l=4.5e-08 \
        nf=1 as=2.71e-14 ad=3.44e-14 ps=7.1e-07 pd=7.5e-07 nrd=1.16667 \
        nrs=1.16667 sa=1.26047e-07 sb=3.45e-07 sd=160n sca=45.7906 \
        scb=0.0283307 scc=0.00588417 m=(1)
PM1 (n2_2 \1\:D2 \24\:VDD VDD) g45p1svt w=(2.15e-07) l=4.5e-08 nf=1 \
        as=3.87e-14 ad=7.07e-14 ps=7.9e-07 pd=1.71e-06 nrd=1.16667 \
        nrs=1.16667 sa=1.10465e-07 sb=1e-06 sd=160n sca=21.1782 \
        scb=0.0203295 scc=0.00208843 m=(1)
PM2 (\6\:Db_2 \13\:SE n2_2 VDD) g45p1svt w=(2.15e-07) l=4.5e-08 nf=1 \
        as=3.87e-14 ad=3.44e-14 ps=7.9e-07 pd=7.5e-07 nrd=1.16667 \
        nrs=1.16667 sa=7.75e-07 sb=3.35465e-07 sd=160n sca=21.1782 \
        scb=0.0203295 scc=0.00208843 m=(1)
PM4 (\6\:Db_2 \3\:SEb_2 n4_2 VDD) g45p1svt w=(2.15e-07) l=4.5e-08 nf=1 \
        as=2.58e-14 ad=3.44e-14 ps=6.7e-07 pd=7.5e-07 nrd=1.16667 \
        nrs=1.16667 sa=5.7e-07 sb=5.40465e-07 sd=160n sca=21.1782 \
        scb=0.0203295 scc=0.00208843 m=(1)
PM3 (n4_2 \3\:SI2 \27\:VDD VDD) g45p1svt w=(2.15e-07) l=4.5e-08 nf=1 \
        as=1.001e-13 ad=2.58e-14 ps=1.75e-06 pd=6.7e-07 nrd=1.16667 \
        nrs=1.16667 sa=4.05e-07 sb=7.05465e-07 sd=160n sca=21.1782 \
        scb=0.0203295 scc=0.00208843 m=(1)
PM0 (\5\:SEb_2 \8\:SE \27\:VDD VDD) g45p1svt w=(2.15e-07) l=4.5e-08 nf=1 \
        as=3.01e-14 ad=1.001e-13 ps=7.1e-07 pd=1.75e-06 nrd=1.16667 \
        nrs=1.16667 sa=9.70465e-07 sb=1.4e-07 sd=160n sca=21.1782 \
        scb=0.0203295 scc=0.00208843 m=(1)
mp56 (\8\:qint \10\:qbint \54\:VDD VDD) g45p1svt w=(2.15e-07) l=4.5e-08 \
        nf=1 as=3.01e-14 ad=1.0092e-13 ps=7.1e-07 pd=1.97e-06 nrd=1.16667 \
        nrs=1.16667 sa=5.4e-07 sb=1.4e-07 sd=160n sca=46.1789 \
        scb=0.0284493 scc=0.00588419 m=(1)
mp50 (n8 \11\:qbint \46\:VDD VDD) g45p1svt w=(2.15e-07) l=4.5e-08 nf=1 \
        as=3.01e-14 ad=1.1192e-13 ps=7.1e-07 pd=1.9e-06 nrd=1.16667 \
        nrs=1.16667 sa=1.235e-06 sb=1.22e-06 sd=160n sca=29.9075 \
        scb=0.0247057 scc=0.00372713 m=(1)
mp51 (\4\:n30 \3\:Ckbb n8 VDD) g45p1svt w=(2.15e-07) l=4.5e-08 nf=1 \
        as=3.01e-14 ad=5.375e-14 ps=7.1e-07 pd=9.3e-07 nrd=1.16667 \
        nrs=1.16667 sa=1.035e-06 sb=1.42e-06 sd=160n sca=29.9075 \
        scb=0.0247057 scc=0.00372713 m=(1)
mp40 (\4\:n30 \3\:CKb \8\:mout VDD) g45p1svt w=(2.15e-07) l=4.5e-08 nf=1 \
        as=3.762e-14 ad=5.375e-14 ps=7.8e-07 pd=9.3e-07 nrd=1.16667 \
        nrs=1.16667 sa=7.4e-07 sb=1.715e-06 sd=160n sca=29.9075 \
        scb=0.0247057 scc=0.00372713 m=(1)
mp30 (\8\:mout \4\:n20 \43\:VDD VDD) g45p1svt w=(2.15e-07) l=4.5e-08 \
        nf=1 as=8.415e-14 ad=3.762e-14 ps=1.83e-06 pd=7.8e-07 nrd=1.16667 \
        nrs=1.16667 sa=5.2e-07 sb=1.935e-06 sd=160n sca=29.9075 \
        scb=0.0247057 scc=0.00372713 m=(1)
mp35 (\3\:n6 \6\:RN \43\:VDD VDD) g45p1svt w=(2.15e-07) l=4.5e-08 nf=1 \
        as=8.415e-14 ad=3.44e-14 ps=1.83e-06 pd=7.5e-07 nrd=1.16667 \
        nrs=1.16667 sa=3.05e-07 sb=2e-06 sd=160n sca=29.9075 scb=0.0247057 \
        scc=0.00372713 m=(1)
mp36 (\3\:n6 mout \40\:VDD VDD) g45p1svt w=(2.15e-07) l=4.5e-08 nf=1 \
        as=6.29e-14 ad=3.44e-14 ps=1.83e-06 pd=7.5e-07 nrd=1.16667 \
        nrs=1.16667 sa=1e-07 sb=2e-06 sd=160n sca=29.9075 scb=0.0247057 \
        scc=0.00372713 m=(1)
mp37 (\5\:n20 \6\:CKb n6 VDD) g45p1svt w=(2.15e-07) l=4.5e-08 nf=1 \
        as=3.44e-14 ad=3.01e-14 ps=7.5e-07 pd=7.1e-07 nrd=1.16667 \
        nrs=1.16667 sa=1.4e-07 sb=3.31047e-07 sd=160n sca=45.7906 \
        scb=0.0283307 scc=0.00588417 m=(1)
mp25 (\5\:n20 \6\:Ckbb \4\:Db VDD) g45p1svt w=(2.15e-07) l=4.5e-08 nf=1 \
        as=2.71e-14 ad=3.44e-14 ps=7.1e-07 pd=7.5e-07 nrd=1.16667 \
        nrs=1.16667 sa=1.26047e-07 sb=3.45e-07 sd=160n sca=45.7906 \
        scb=0.0283307 scc=0.00588417 m=(1)
mp11 (n2 \1\:D1 \36\:VDD VDD) g45p1svt w=(2.15e-07) l=4.5e-08 nf=1 \
        as=3.87e-14 ad=7.07e-14 ps=7.9e-07 pd=1.71e-06 nrd=1.16667 \
        nrs=1.16667 sa=1.10465e-07 sb=1e-06 sd=160n sca=21.1782 \
        scb=0.0203295 scc=0.00208843 m=(1)
mp12 (Db \1\:SE n2 VDD) g45p1svt w=(2.15e-07) l=4.5e-08 nf=1 as=3.87e-14 \
        ad=3.44e-14 ps=7.9e-07 pd=7.5e-07 nrd=1.16667 nrs=1.16667 \
        sa=7.75e-07 sb=3.35465e-07 sd=160n sca=21.1782 scb=0.0203295 \
        scc=0.00208843 m=(1)
mp14 (Db SEb n4 VDD) g45p1svt w=(2.15e-07) l=4.5e-08 nf=1 as=2.58e-14 \
        ad=3.44e-14 ps=6.7e-07 pd=7.5e-07 nrd=1.16667 nrs=1.16667 \
        sa=5.7e-07 sb=5.40465e-07 sd=160n sca=21.1782 scb=0.0203295 \
        scc=0.00208843 m=(1)
mp13 (n4 \3\:SI1 \33\:VDD VDD) g45p1svt w=(2.15e-07) l=4.5e-08 nf=1 \
        as=1.001e-13 ad=2.58e-14 ps=1.75e-06 pd=6.7e-07 nrd=1.16667 \
        nrs=1.16667 sa=4.05e-07 sb=7.05465e-07 sd=160n sca=21.1782 \
        scb=0.0203295 scc=0.00208843 m=(1)
mp10 (\6\:SEb \5\:SE \33\:VDD VDD) g45p1svt w=(2.15e-07) l=4.5e-08 nf=1 \
        as=3.01e-14 ad=1.001e-13 ps=7.1e-07 pd=1.75e-06 nrd=1.16667 \
        nrs=1.16667 sa=9.70465e-07 sb=1.4e-07 sd=160n sca=21.1782 \
        scb=0.0203295 scc=0.00208843 m=(1)
PM14 (\16\:qbint_2 n30_2 \5\:VDD VDD) g45p1svt w=(3.1e-07) l=4.5e-08 \
        nf=1 as=1.4765e-13 ad=4.96e-14 ps=2.19e-06 pd=9.4e-07 nrd=1.16667 \
        nrs=1.16667 sa=1.28081e-06 sb=7.65e-07 sd=160n sca=35.6995 \
        scb=0.0234062 scc=0.00420468 m=(1)
PM13 (\16\:qbint_2 \13\:RN \14\:VDD VDD) g45p1svt w=(3.1e-07) l=4.5e-08 \
        nf=1 as=1.1192e-13 ad=4.96e-14 ps=1.9e-06 pd=9.4e-07 nrd=1.16667 \
        nrs=1.16667 sa=1.07581e-06 sb=9.7e-07 sd=160n sca=35.6995 \
        scb=0.0234062 scc=0.00420468 m=(1)
mp46 (\15\:qbint \3\:n30 \48\:VDD VDD) g45p1svt w=(3.1e-07) l=4.5e-08 \
        nf=1 as=1.4765e-13 ad=4.96e-14 ps=2.19e-06 pd=9.4e-07 nrd=1.16667 \
        nrs=1.16667 sa=1.28081e-06 sb=7.65e-07 sd=160n sca=35.6995 \
        scb=0.0234062 scc=0.00420468 m=(1)
mp45 (\15\:qbint \3\:RN \46\:VDD VDD) g45p1svt w=(3.1e-07) l=4.5e-08 \
        nf=1 as=1.1192e-13 ad=4.96e-14 ps=1.9e-06 pd=9.4e-07 nrd=1.16667 \
        nrs=1.16667 sa=1.07581e-06 sb=9.7e-07 sd=160n sca=35.6995 \
        scb=0.0234062 scc=0.00420468 m=(1)
ends SPDFF2RX2
// End of subcircuit definition.
