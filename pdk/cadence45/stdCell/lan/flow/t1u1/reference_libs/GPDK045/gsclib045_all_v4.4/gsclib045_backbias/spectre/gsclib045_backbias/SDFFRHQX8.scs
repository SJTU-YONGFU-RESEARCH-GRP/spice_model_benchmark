// gsclib045_backbias/SDFFRHQX8/schematic

simulator lang=spectre

subckt SDFFRHQX8 CK D Q RN SE SI VDD NW VSS
mn36 (net422 mout net426 VSS) g45n1svt w=(205n) l=45n nf=1 m=(1)
mn35 (net426 RN VSS VSS) g45n1svt w=(205n) l=45n nf=1 m=(1)
mn37 (n20 CKbb net422 VSS) g45n1svt w=(205n) l=45n nf=1 m=(1)
mn13 (net442 SI VSS VSS) g45n1svt w=(260n) l=45n nf=1 m=(1)
mn14 (Db SE net442 VSS) g45n1svt w=(260n) l=45n nf=1 m=(1)
mn12 (Db SEb net450 VSS) g45n1svt w=(260n) l=45n nf=1 m=(1)
mn11 (net450 D VSS VSS) g45n1svt w=(260n) l=45n nf=1 m=(1)
mn55 (Q qbint VSS VSS) g45n1svt w=(2.065u) l=45n nf=1 m=(1)
mn45 (net337 RN VSS VSS) g45n1svt w=(780n) l=45n nf=1 m=(1)
mn46 (qbint n30 net337 VSS) g45n1svt w=(780n) l=45n nf=1 m=(1)
mn51 (n30 CKb net405 VSS) g45n1svt w=(205n) l=45n nf=1 m=(1)
mn50 (net405 qbint VSS VSS) g45n1svt w=(205n) l=45n nf=1 m=(1)
mn20 (CKb CK VSS VSS) g45n1svt w=(145n) l=45n nf=1 m=(1)
mn40 (n30 CKbb mout VSS) g45n1svt w=(205n) l=45n nf=1 m=(1)
mn30 (mout n20 VSS VSS) g45n1svt w=(205n) l=45n nf=1 m=(1)
mn21 (CKbb CKb VSS VSS) g45n1svt w=(145n) l=45n nf=1 m=(1)
mn10 (SEb SE VSS VSS) g45n1svt w=(145n) l=45n nf=1 m=(1)
mn25 (n20 CKb Db VSS) g45n1svt w=(205n) l=45n nf=1 m=(1)
mp14 (Db SEb net373 NW) g45p1svt w=(390n) l=45n nf=1 m=(1)
mp13 (net373 SI VDD NW) g45p1svt w=(390n) l=45n nf=1 m=(1)
mp12 (Db SE net381 NW) g45p1svt w=(390n) l=45n nf=1 m=(1)
mp11 (net381 D VDD NW) g45p1svt w=(390n) l=45n nf=1 m=(1)
mp51 (n30 CKbb net326 NW) g45p1svt w=(310n) l=45n nf=1 m=(1)
mp50 (net326 qbint VDD NW) g45p1svt w=(310n) l=45n nf=1 m=(1)
mp55 (Q qbint VDD NW) g45p1svt w=(3.115u) l=45n nf=1 m=(1)
mp20 (CKb CK VDD NW) g45p1svt w=(215n) l=45n nf=1 m=(1)
mp46 (qbint n30 VDD NW) g45p1svt w=(1.17u) l=45n nf=1 m=(1)
mp45 (VDD RN qbint NW) g45p1svt w=(1.17u) l=45n nf=1 m=(1)
mp35 (net349 RN VDD NW) g45p1svt w=(310n) l=45n nf=1 m=(1)
mp36 (net349 mout VDD NW) g45p1svt w=(310n) l=45n nf=1 m=(1)
mp37 (n20 CKb net349 NW) g45p1svt w=(310n) l=45n nf=1 m=(1)
mp40 (n30 CKb mout NW) g45p1svt w=(310n) l=45n nf=1 m=(1)
mp30 (mout n20 VDD NW) g45p1svt w=(310n) l=45n nf=1 m=(1)
mp21 (CKbb CKb VDD NW) g45p1svt w=(215n) l=45n nf=1 m=(1)
mp25 (n20 CKbb Db NW) g45p1svt w=(310n) l=45n nf=1 m=(1)
mp10 (SEb SE VDD NW) g45p1svt w=(215n) l=45n nf=1 m=(1)
ends SDFFRHQX8
