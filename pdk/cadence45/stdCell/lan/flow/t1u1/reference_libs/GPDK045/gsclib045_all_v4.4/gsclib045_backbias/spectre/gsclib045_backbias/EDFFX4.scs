// gsclib045_backbias/EDFFX4/schematic

simulator lang=spectre

subckt EDFFX4 CK D E Q QN NW VSS VDD
mn3 (Db E n0 VSS) g45n1svt w=(145n) l=45n nf=1 m=(1)
mn2 (n0 D VSS VSS) g45n1svt w=(145n) l=45n nf=1 m=(1)
mn57 (QN qint VSS VSS) g45n1svt w=(1.04u) l=45n nf=1 m=(1)
mn55 (Q qbint VSS VSS) g45n1svt w=(1.04u) l=45n nf=1 m=(1)
mn51 (n30 Ckb net415 VSS) g45n1svt w=(145n) l=45n nf=1 m=(1)
mn50 (net415 qbint VSS VSS) g45n1svt w=(145n) l=45n nf=1 m=(1)
mn35 (net411 mout VSS VSS) g45n1svt w=(145n) l=45n nf=1 m=(1)
mn36 (n20 CKbb net411 VSS) g45n1svt w=(145n) l=45n nf=1 m=(1)
mn20 (Ckb CK VSS VSS) g45n1svt w=(145n) l=45n nf=1 m=(1)
mn45 (qbint n30 VSS VSS) g45n1svt w=(410n) l=45n nf=1 m=(1)
mn56 (qint qbint VSS VSS) g45n1svt w=(260n) l=45n nf=1 m=(1)
mn0 (Eb E VSS VSS) g45n1svt w=(145n) l=45n nf=1 m=(1)
mn30 (mout n20 VSS VSS) g45n1svt w=(145n) l=45n nf=1 m=(1)
mn21 (CKbb Ckb VSS VSS) g45n1svt w=(145n) l=45n nf=1 m=(1)
mn40 (mout CKbb n30 VSS) g45n1svt w=(145n) l=45n nf=1 m=(1)
mn1 (qbint Eb Db VSS) g45n1svt w=(145n) l=45n nf=1 m=(1)
mn25 (Db Ckb n20 VSS) g45n1svt w=(145n) l=45n nf=1 m=(1)
mp3 (Db Eb n1 NW) g45p1svt w=(215n) l=45n nf=1 m=(1)
mp2 (n1 D VDD NW) g45p1svt w=(215n) l=45n nf=1 m=(1)
mp51 (n30 CKbb net362 NW) g45p1svt w=(215n) l=45n nf=1 m=(1)
mp50 (net362 qbint VDD NW) g45p1svt w=(215n) l=45n nf=1 m=(1)
mp57 (QN qint VDD NW) g45p1svt w=(1.56u) l=45n nf=1 m=(1)
mp55 (Q qbint VDD NW) g45p1svt w=(1.56u) l=45n nf=1 m=(1)
mp35 (net342 mout VDD NW) g45p1svt w=(215n) l=45n nf=1 m=(1)
mp36 (n20 Ckb net342 NW) g45p1svt w=(215n) l=45n nf=1 m=(1)
mp20 (Ckb CK VDD NW) g45p1svt w=(215n) l=45n nf=1 m=(1)
mp45 (qbint n30 VDD NW) g45p1svt w=(620n) l=45n nf=1 m=(1)
mp56 (qint qbint VDD NW) g45p1svt w=(390n) l=45n nf=1 m=(1)
mp21 (CKbb Ckb VDD NW) g45p1svt w=(215n) l=45n nf=1 m=(1)
mp40 (n30 Ckb mout NW) g45p1svt w=(215n) l=45n nf=1 m=(1)
mp30 (mout n20 VDD NW) g45p1svt w=(215n) l=45n nf=1 m=(1)
mp25 (n20 CKbb Db NW) g45p1svt w=(215n) l=45n nf=1 m=(1)
mp0 (Eb E VDD NW) g45p1svt w=(215n) l=45n nf=1 m=(1)
mp1 (qbint E Db NW) g45p1svt w=(215n) l=45n nf=1 m=(1)
ends EDFFX4
