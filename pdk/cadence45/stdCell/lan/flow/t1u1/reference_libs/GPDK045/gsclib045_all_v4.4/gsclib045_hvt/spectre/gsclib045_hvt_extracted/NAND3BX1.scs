// Generated for: spectre (May  1 09:17:29 2013 )
// Library name: gsclib045_hvt
// Cell name: NAND3BX1
// View name: extracted

simulator lang=spectre

subckt NAND3BX1 AN B C VDD VSS Y
mp3 (\6\:Y \3\:C \6\:VDD VDD) g45p1hvt w=(3.9e-07) l=4.5e-08 nf=1 \
        as=6.24e-14 ad=5.46e-14 ps=1.1e-06 pd=1.06e-06 nrd=1.16667 \
        nrs=1.16667 sa=1.4e-07 sb=6.82308e-07 sd=160n sca=19.3275 \
        scb=0.0211052 scc=0.000636468 m=(1)
mp2 (\1\:Y \1\:B \6\:VDD VDD) g45p1hvt w=(3.9e-07) l=4.5e-08 nf=1 \
        as=6.24e-14 ad=6.24e-14 ps=1.1e-06 pd=1.1e-06 nrd=1.16667 \
        nrs=1.16667 sa=3.45e-07 sb=4.77308e-07 sd=160n sca=14.532 \
        scb=0.0121946 scc=0.000242813 m=(1)
mp1 (\1\:Y n0 \1\:VDD VDD) g45p1hvt w=(3.9e-07) l=4.5e-08 nf=1 \
        as=6.643e-14 ad=6.24e-14 ps=1.17e-06 pd=1.1e-06 nrd=1.16667 \
        nrs=1.16667 sa=5.5e-07 sb=2.72308e-07 sd=160n sca=14.3198 \
        scb=0.0117685 scc=0.000238368 m=(1)
C1 (B VSS) capacitor c=5.06123e-17
C2 (VDD VSS) capacitor c=1.11069e-16
C3 (C VSS) capacitor c=3.96815e-17
C4 (AN VSS) capacitor c=4.34374e-17
C5 (Y VSS) capacitor c=1.02925e-16
C6 (n0 VSS) capacitor c=6.3207e-17
C7 (\1\:AN VSS) capacitor c=3.87081e-17
C8 (\1\:B VSS) capacitor c=5.58066e-17
C9 (\3\:C VSS) capacitor c=4.58767e-17
C10 (\3\:AN VSS) capacitor c=3.67102e-17
C11 (\3\:n0 VSS) capacitor c=5.19753e-17
C12 (\3\:B VSS) capacitor c=6.3295e-17
C13 (\1\:C VSS) capacitor c=4.79944e-17
C14 (\2\:AN VSS) capacitor c=4.52453e-17
C15 (\2\:n0 VSS) capacitor c=5.75085e-17
C16 (\2\:B VSS) capacitor c=5.39973e-17
C17 (\2\:C VSS) capacitor c=4.44899e-17
C18 (\4\:n0 VSS) capacitor c=5.34934e-17
C19 (\1\:VDD VSS) capacitor c=4.26698e-17
C20 (\1\:Y VSS) capacitor c=9.75933e-17
C21 (\6\:VDD VSS) capacitor c=6.76605e-17
C22 (\6\:Y VSS) capacitor c=2.99206e-17
C23 (\8\:n0 VSS) capacitor c=1.56914e-17
C24 (\4\:Y VSS) capacitor c=7.6031e-17
C25 (\4\:C VSS) capacitor c=8.69528e-17
C26 (\5\:B VSS) capacitor c=4.69598e-17
C27 (\4\:AN VSS) capacitor c=4.82935e-17
C28 (\6\:n0 VSS) capacitor c=6.21414e-17
C29 (\7\:n0 VSS) capacitor c=5.73776e-17
C30 (\4\:VDD VSS) capacitor c=2.46216e-17
C31 (\5\:VDD VSS) capacitor c=8.29943e-18
Rk18 (\4\:VSS VSS) resistor r=0.2503 c=0
Rk17 (\2\:VSS \4\:VSS) resistor r=0.3462 c=0
Rk4 (B \5\:B) resistor r=0.02394 c=0
Rk13 (\2\:VDD \4\:VDD) resistor r=0.3331 c=0
Rk15 (\5\:VDD VDD) resistor r=0.1399 c=0
Rk14 (\4\:VDD \5\:VDD) resistor r=0.1101 c=0
Rk16 (\5\:VDD \7\:VDD) resistor r=0.2492 c=0
Rk1 (C \4\:C) resistor r=0.1137 c=0
Rk9 (AN \4\:AN) resistor r=0.09311 c=0
Rk6 (\3\:Y Y) resistor r=0.04558 c=0
Rk5 (\2\:Y \3\:Y) resistor r=0.4817 c=0
Rk7 (\3\:Y \5\:Y) resistor r=0.4932 c=0
Rk8 (Y \7\:Y) resistor r=0.1337 c=0
Rk10 (\5\:n0 \6\:n0) resistor r=0.4199 c=0
Rk11 (\6\:n0 \7\:n0) resistor r=0.2802 c=0
Rk12 (\6\:n0 \9\:n0) resistor r=0.08538 c=0
Rl3 (\1\:B \2\:B) resistor r=75.6918 c=0
Rl4 (\2\:B \3\:B) resistor r=94.9225 c=0
Rl2 (\2\:C \3\:C) resistor r=79.9451 c=0
Rl1 (\1\:C \2\:C) resistor r=92.3077 c=0
Rl7 (\1\:AN \2\:AN) resistor r=84.6154 c=0
Rl8 (\2\:AN \3\:AN) resistor r=87.5194 c=0
Rl5 (n0 \2\:n0) resistor r=103.378 c=0
Rl6 (\2\:n0 \3\:n0) resistor r=68.5619 c=0
Rz4 (\1\:VSS \2\:VSS) resistor r=37.5 c=0
Rz1 (\4\:Y \5\:Y) resistor r=37.5 c=0
Rz2 (\8\:n0 \9\:n0) resistor r=75 c=0
Ry4 (\1\:VDD \2\:VDD) resistor r=31 c=0
Ry5 (\6\:VDD \7\:VDD) resistor r=31 c=0
Ry1 (\1\:Y \2\:Y) resistor r=31 c=0
Ry2 (\6\:Y \7\:Y) resistor r=31 c=0
Ry3 (\4\:n0 \5\:n0) resistor r=62 c=0
Rx2 (\2\:B \5\:B) resistor r=45 c=0
Rx1 (\2\:C \4\:C) resistor r=45 c=0
Rx3 (\2\:AN \4\:AN) resistor r=45 c=0
Rx4 (\2\:n0 \7\:n0) resistor r=45 c=0
mn3 (\4\:Y \1\:C n1 VSS) g45n1hvt w=(2.6e-07) l=4.5e-08 nf=1 as=2.73e-14 \
        ad=3.64e-14 ps=7.3e-07 pd=8e-07 nrd=1.16667 nrs=1.16667 sa=1.4e-07 \
        sb=5.81058e-07 sd=160n sca=11.0409 scb=0.0104003 scc=0.000454168 \
        m=(1)
mn2 (n1 \3\:B n2 VSS) g45n1hvt w=(2.6e-07) l=4.5e-08 nf=1 as=2.99e-14 \
        ad=2.73e-14 ps=7.5e-07 pd=7.3e-07 nrd=1.16667 nrs=1.16667 \
        sa=2.9e-07 sb=4.31058e-07 sd=160n sca=11.0409 scb=0.0104003 \
        scc=0.000454168 m=(1)
mn1 (n2 \3\:n0 \1\:VSS VSS) g45n1hvt w=(2.6e-07) l=4.5e-08 nf=1 \
        as=4.365e-14 ad=2.99e-14 ps=9e-07 pd=7.5e-07 nrd=1.16667 \
        nrs=1.16667 sa=4.5e-07 sb=2.71058e-07 sd=160n sca=11.0409 \
        scb=0.0104003 scc=0.000454168 m=(1)
mn0 (\8\:n0 \3\:AN \1\:VSS VSS) g45n1hvt w=(1.45e-07) l=4.5e-08 nf=1 \
        as=4.365e-14 ad=2.03e-14 ps=9e-07 pd=5.7e-07 nrd=1.16667 \
        nrs=1.16667 sa=6.85e-07 sb=1.4e-07 sd=160n sca=13.6097 \
        scb=0.014254 scc=0.000755054 m=(1)
mp0 (\4\:n0 \1\:AN \1\:VDD VDD) g45p1hvt w=(2.15e-07) l=4.5e-08 nf=1 \
        as=6.643e-14 ad=3.01e-14 ps=1.17e-06 pd=7.1e-07 nrd=1.16667 \
        nrs=1.16667 sa=7.9e-07 sb=1.4e-07 sd=160n sca=20.3233 \
        scb=0.0227744 scc=0.000772584 m=(1)
ends NAND3BX1
// End of subcircuit definition.
