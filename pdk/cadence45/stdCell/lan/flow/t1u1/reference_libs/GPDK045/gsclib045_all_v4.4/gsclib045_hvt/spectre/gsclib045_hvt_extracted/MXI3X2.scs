// Generated for: spectre (May  1 09:17:09 2013 )
// Library name: gsclib045_hvt
// Cell name: MXI3X2
// View name: extracted

simulator lang=spectre

subckt MXI3X2 A B C S0 S1 VDD VSS Y
mp6 (\4\:Cp \1\:C \16\:VDD VDD) g45p1hvt w=(2.15e-07) l=4.5e-08 nf=1 \
        as=3.01e-14 ad=3.44e-14 ps=7.1e-07 pd=7.5e-07 nrd=1.16667 \
        nrs=1.16667 sa=1.4e-07 sb=1.6e-07 sd=160n sca=19.7685 \
        scb=0.0219319 scc=0.000700056 m=(1)
mp1 (\9\:S1b \4\:S1 \14\:VDD VDD) g45p1hvt w=(2.15e-07) l=4.5e-08 nf=1 \
        as=9.23e-14 ad=3.01e-14 ps=1.62e-06 pd=7.1e-07 nrd=1.16667 \
        nrs=1.16667 sa=1.4e-07 sb=1.87349e-06 sd=160n sca=15.3753 \
        scb=0.0145715 scc=0.000753786 m=(1)
mp9 (n9 \3\:Cp \14\:VDD VDD) g45p1hvt w=(2.15e-07) l=4.5e-08 nf=1 \
        as=9.23e-14 ad=2.472e-14 ps=1.62e-06 pd=6.6e-07 nrd=1.16667 \
        nrs=1.16667 sa=4.05e-07 sb=1.77488e-06 sd=160n sca=14.5741 \
        scb=0.0142021 scc=0.000753562 m=(1)
mp10 (\8\:n1 \4\:S1b n9 VDD) g45p1hvt w=(2.15e-07) l=4.5e-08 nf=1 \
        as=2.472e-14 ad=8.17e-14 ps=6.6e-07 pd=1.19e-06 nrd=1.16667 \
        nrs=1.16667 sa=5.65e-07 sb=1.71535e-06 sd=160n sca=14.5646 \
        scb=0.0142004 scc=0.000753562 m=(1)
mp8 (\8\:n1 \7\:S1 n7 VDD) g45p1hvt w=(2.15e-07) l=4.5e-08 nf=1 \
        as=2.257e-14 ad=8.17e-14 ps=6.4e-07 pd=1.19e-06 nrd=1.16667 \
        nrs=1.16667 sa=9.9e-07 sb=1.5007e-06 sd=160n sca=14.5646 \
        scb=0.0142004 scc=0.000753562 m=(1)
mp7 (n7 n0 \5\:VDD VDD) g45p1hvt w=(2.15e-07) l=4.5e-08 nf=1 \
        as=7.875e-14 ad=2.258e-14 ps=1.32e-06 pd=6.4e-07 nrd=1.16667 \
        nrs=1.16667 sa=1.14e-06 sb=1.3507e-06 sd=160n sca=14.5646 \
        scb=0.0142004 scc=0.000753562 m=(1)
mp2 (n3 \1\:A \5\:VDD VDD) g45p1hvt w=(2.15e-07) l=4.5e-08 nf=1 \
        as=7.18e-14 ad=2.472e-14 ps=1.22e-06 pd=6.6e-07 nrd=1.16667 \
        nrs=1.16667 sa=1.4357e-06 sb=9.75e-07 sd=160n sca=11.2317 \
        scb=0.00932789 scc=0.000203581 m=(1)
mp3 (\4\:n0 \1\:S0 n3 VDD) g45p1hvt w=(2.15e-07) l=4.5e-08 nf=1 \
        as=2.473e-14 ad=3.44e-14 ps=6.6e-07 pd=7.5e-07 nrd=1.16667 \
        nrs=1.16667 sa=1.54233e-06 sb=8.15e-07 sd=160n sca=11.2317 \
        scb=0.00932789 scc=0.000203581 m=(1)
mp5 (\4\:n0 S0b n5 VDD) g45p1hvt w=(2.15e-07) l=4.5e-08 nf=1 as=4.73e-14 \
        ad=3.44e-14 ps=8.7e-07 pd=7.5e-07 nrd=1.16667 nrs=1.16667 \
        sa=1.6186e-06 sb=6.1e-07 sd=160n sca=11.2412 scb=0.00932961 \
        scc=0.000203582 m=(1)
mp4 (n5 \1\:B \1\:VDD VDD) g45p1hvt w=(2.15e-07) l=4.5e-08 nf=1 \
        as=3.44e-14 ad=4.73e-14 ps=7.5e-07 pd=8.7e-07 nrd=1.16667 \
        nrs=1.16667 sa=1.71721e-06 sb=3.45e-07 sd=160n sca=12.0423 \
        scb=0.00969901 scc=0.000203806 m=(1)
mp0 (\8\:S0b \7\:S0 \1\:VDD VDD) g45p1hvt w=(2.15e-07) l=4.5e-08 nf=1 \
        as=3.44e-14 ad=3.01e-14 ps=7.5e-07 pd=7.1e-07 nrd=1.16667 \
        nrs=1.16667 sa=1.79349e-06 sb=1.4e-07 sd=160n sca=13.6165 \
        scb=0.011597 scc=0.00021346 m=(1)
C1 (A VSS) capacitor c=3.59441e-17
C2 (S0 VSS) capacitor c=3.73906e-17
C3 (VDD VSS) capacitor c=2.38235e-16
C4 (S1 VSS) capacitor c=3.85272e-17
C5 (Y VSS) capacitor c=3.64478e-17
C6 (C VSS) capacitor c=5.33199e-17
C7 (Cp VSS) capacitor c=2.75724e-17
C8 (S1b VSS) capacitor c=7.73254e-17
C9 (n1 VSS) capacitor c=1.75203e-16
C10 (n0 VSS) capacitor c=6.60631e-17
C11 (n2 VSS) capacitor c=7.72649e-18
C12 (S0b VSS) capacitor c=3.19964e-17
C13 (n9 VSS) capacitor c=2.57998e-18
C14 (n7 VSS) capacitor c=5.16138e-18
C15 (n3 VSS) capacitor c=4.46733e-18
C16 (\7\:S0 VSS) capacitor c=6.4509e-17
C17 (\1\:B VSS) capacitor c=4.43511e-17
C18 (\1\:S0 VSS) capacitor c=4.83228e-17
C19 (\1\:A VSS) capacitor c=5.39435e-17
C20 (\7\:S1 VSS) capacitor c=4.8061e-17
C21 (\4\:S1b VSS) capacitor c=3.69558e-17
C22 (\3\:Cp VSS) capacitor c=7.51112e-17
C23 (\4\:S1 VSS) capacitor c=3.53023e-17
C24 (\1\:C VSS) capacitor c=3.5655e-17
C25 (\5\:S0 VSS) capacitor c=2.26516e-17
C26 (\3\:B VSS) capacitor c=7.47866e-17
C27 (\3\:S0 VSS) capacitor c=6.21359e-17
C28 (\3\:S0b VSS) capacitor c=6.93956e-17
C29 (\4\:A VSS) capacitor c=4.44509e-17
C30 (\2\:n0 VSS) capacitor c=4.78841e-17
C31 (\5\:S1 VSS) capacitor c=5.05635e-17
C32 (\2\:Cp VSS) capacitor c=4.35343e-17
C33 (\3\:S1 VSS) capacitor c=4.84206e-17
C34 (\3\:C VSS) capacitor c=2.55401e-17
C35 (\6\:S0 VSS) capacitor c=5.28874e-17
C36 (\2\:B VSS) capacitor c=6.25876e-17
C37 (\4\:S0 VSS) capacitor c=6.10427e-17
C38 (\2\:S0b VSS) capacitor c=7.22851e-17
C39 (\2\:S0 VSS) capacitor c=4.5254e-17
C40 (\3\:A VSS) capacitor c=2.88375e-17
C41 (\4\:n1 VSS) capacitor c=1.62052e-17
C42 (\3\:n0 VSS) capacitor c=2.94282e-17
C43 (\8\:S1 VSS) capacitor c=4.09468e-17
C44 (\6\:S1 VSS) capacitor c=4.74851e-17
C45 (\3\:S1b VSS) capacitor c=3.08981e-17
C46 (\1\:S1 VSS) capacitor c=1.90381e-17
C47 (\2\:C VSS) capacitor c=2.57752e-17
C48 (\8\:S0b VSS) capacitor c=1.18287e-17
C49 (\1\:VDD VSS) capacitor c=3.09448e-17
C50 (\4\:n0 VSS) capacitor c=1.03386e-16
C51 (\3\:Y VSS) capacitor c=8.43376e-17
C52 (\8\:n1 VSS) capacitor c=7.2416e-17
C53 (\14\:VDD VSS) capacitor c=1.01451e-17
C54 (\9\:S1b VSS) capacitor c=4.971e-17
C55 (\4\:Cp VSS) capacitor c=7.04356e-17
C56 (\16\:VDD VSS) capacitor c=2.26538e-17
C57 (\3\:VDD VSS) capacitor c=5.69407e-17
C58 (\4\:S0b VSS) capacitor c=8.77301e-17
C59 (\8\:n0 VSS) capacitor c=5.49003e-17
C60 (\1\:Y VSS) capacitor c=4.81583e-17
C61 (\11\:n1 VSS) capacitor c=3.74024e-17
C62 (\7\:S1b VSS) capacitor c=2.84225e-17
C63 (\6\:Cp VSS) capacitor c=1.13654e-16
C64 (\2\:S1 VSS) capacitor c=2.04562e-17
C65 (\2\:S1b VSS) capacitor c=5.51012e-17
C66 (\2\:A VSS) capacitor c=4.23629e-17
C67 (\4\:C VSS) capacitor c=3.49625e-17
C68 (\8\:Cp VSS) capacitor c=5.63348e-17
C69 (\5\:S1b VSS) capacitor c=7.06684e-17
C70 (\6\:S1b VSS) capacitor c=6.67255e-17
C71 (\9\:S1 VSS) capacitor c=5.41968e-17
C72 (\10\:S1 VSS) capacitor c=3.64545e-17
C73 (\11\:S1 VSS) capacitor c=4.82166e-17
C74 (\12\:S1 VSS) capacitor c=4.24454e-17
C75 (\10\:n1 VSS) capacitor c=6.70733e-17
C76 (\13\:n1 VSS) capacitor c=4.15572e-17
C77 (\5\:A VSS) capacitor c=9.58299e-17
C78 (\6\:n0 VSS) capacitor c=1.79878e-16
C79 (\7\:n0 VSS) capacitor c=7.61067e-17
C80 (\4\:B VSS) capacitor c=1.05268e-16
C81 (\8\:S0 VSS) capacitor c=1.17965e-17
C82 (\9\:S0 VSS) capacitor c=7.64572e-17
C83 (\10\:S0 VSS) capacitor c=5.75236e-17
C84 (\11\:S0 VSS) capacitor c=5.92737e-17
C85 (\6\:S0b VSS) capacitor c=9.20347e-17
C86 (\7\:S0b VSS) capacitor c=5.07503e-17
C87 (\5\:VDD VSS) capacitor c=1.77991e-16
C88 (\8\:VDD VSS) capacitor c=1.1423e-17
C89 (\9\:VDD VSS) capacitor c=8.83105e-18
Rk16 (\5\:A A) resistor r=0.04353 c=0
Rk21 (\8\:S0 \9\:S0) resistor r=0.05586 c=0
Rk24 (\10\:S0 S0) resistor r=0.06973 c=0
Rk22 (\9\:S0 \10\:S0) resistor r=0.4053 c=0
Rk23 (\9\:S0 \11\:S0) resistor r=0.4552 c=0
Rk28 (\2\:VDD \4\:VDD) resistor r=0.3253 c=0
Rk29 (\4\:VDD \5\:VDD) resistor r=0.393 c=0
Rk31 (\5\:VDD \7\:VDD) resistor r=0.3529 c=0
Rk32 (\7\:VDD \8\:VDD) resistor r=0.1876 c=0
Rk34 (\9\:VDD VDD) resistor r=0.03211 c=0
Rk33 (\8\:VDD \9\:VDD) resistor r=0.3302 c=0
Rk37 (\8\:VDD \15\:VDD) resistor r=0.07323 c=0
Rk38 (\9\:VDD \17\:VDD) resistor r=0.272 c=0
Rk8 (\10\:S1 S1) resistor r=0.2464 c=0
Rk7 (\9\:S1 \10\:S1) resistor r=0.2684 c=0
Rk9 (S1 \11\:S1) resistor r=0.1675 c=0
Rk10 (\10\:S1 \12\:S1) resistor r=0.17 c=0
Rk14 (Y \2\:Y) resistor r=0.1477 c=0
Rk15 (Y \4\:Y) resistor r=0.1705 c=0
Rk39 (\2\:VSS \4\:VSS) resistor r=0.2557 c=0
Rk40 (\4\:VSS \5\:VSS) resistor r=0.377 c=0
Rk42 (\5\:VSS \7\:VSS) resistor r=0.337 c=0
Rk44 (\8\:VSS VSS) resistor r=0.3632 c=0
Rk43 (\7\:VSS \8\:VSS) resistor r=0.1876 c=0
Rk45 (VSS \10\:VSS) resistor r=0.362 c=0
Rk48 (\8\:VSS \16\:VSS) resistor r=0.07323 c=0
Rk1 (\4\:C C) resistor r=0.1907 c=0
Rk20 (\4\:B B) resistor r=0.01192 c=0
Rk2 (\5\:Cp \7\:Cp) resistor r=0.4443 c=0
Rk3 (\7\:Cp \8\:Cp) resistor r=0.5282 c=0
Rk4 (\5\:S1b \6\:S1b) resistor r=0.3871 c=0
Rk5 (\6\:S1b \8\:S1b) resistor r=0.1189 c=0
Rk6 (\6\:S1b \10\:S1b) resistor r=0.2832 c=0
Rk11 (\9\:n1 \10\:n1) resistor r=0.469 c=0
Rk12 (\10\:n1 \12\:n1) resistor r=0.2827 c=0
Rk13 (\10\:n1 \13\:n1) resistor r=0.1751 c=0
Rk17 (\5\:n0 \6\:n0) resistor r=0.8156 c=0
Rk18 (\6\:n0 \7\:n0) resistor r=0.599 c=0
Rk19 (\6\:n0 \9\:n0) resistor r=0.2811 c=0
Rk25 (\5\:S0b \6\:S0b) resistor r=0.7703 c=0
Rk26 (\6\:S0b \7\:S0b) resistor r=0.4323 c=0
Rk27 (\6\:S0b \9\:S0b) resistor r=0.0474 c=0
Rl21 (\1\:A \2\:A) resistor r=129.649 c=0
Rl23 (\2\:A \4\:A) resistor r=131.572 c=0
Rl22 (\2\:A \3\:A) resistor r=10.9341 c=0
Rl31 (\6\:S0 \7\:S0) resistor r=261.516 c=0
Rl30 (\5\:S0 \6\:S0) resistor r=24.7951 c=0
Rl27 (\3\:S0 \4\:S0) resistor r=69.4451 c=0
Rl24 (\1\:S0 \2\:S0) resistor r=71.8456 c=0
Rl12 (\7\:S1 \8\:S1) resistor r=29.5379 c=0
Rl8 (\5\:S1 \6\:S1) resistor r=29.5379 c=0
Rl5 (\2\:S1 \4\:S1) resistor r=34.3295 c=0
Rl4 (\2\:S1 \3\:S1) resistor r=103.56 c=0
Rl3 (\1\:S1 \2\:S1) resistor r=1.2713 c=0
Rl1 (\1\:C \2\:C) resistor r=110.771 c=0
Rl2 (\2\:C \3\:C) resistor r=37.6944 c=0
Rl28 (\1\:B \2\:B) resistor r=91.0764 c=0
Rl29 (\2\:B \3\:B) resistor r=154.538 c=0
Rl7 (\2\:Cp \3\:Cp) resistor r=146.154 c=0
Rl6 (Cp \2\:Cp) resistor r=31.0981 c=0
Rl11 (\2\:S1b \4\:S1b) resistor r=51.8781 c=0
Rl9 (S1b \2\:S1b) resistor r=217.124 c=0
Rl10 (\2\:S1b \3\:S1b) resistor r=8.9152 c=0
Rl17 (n1 \4\:n1) resistor r=7.924 c=0
Rl13 (n0 \2\:n0) resistor r=146.154 c=0
Rl14 (\2\:n0 \3\:n0) resistor r=68.4636 c=0
Rl25 (S0b \2\:S0b) resistor r=24.2328 c=0
Rl26 (\2\:S0b \3\:S0b) resistor r=228.4 c=0
Rz7 (\4\:VDD \3\:VDD) resistor r=10.7143 c=0
Rz8 (\7\:VDD \3\:VDD) resistor r=6.25 c=0
Rz4 (\2\:Y \1\:Y) resistor r=75 c=0
Rz9 (\2\:VSS \1\:VSS) resistor r=75 c=0
Rz10 (\10\:VSS \9\:VSS) resistor r=75 c=0
Rz13 (\16\:VSS \15\:VSS) resistor r=75 c=0
Rz1 (\6\:Cp \7\:Cp) resistor r=75 c=0
Rz2 (\7\:S1b \8\:S1b) resistor r=75 c=0
Rz3 (\12\:n1 \11\:n1) resistor r=75 c=0
Rz5 (\8\:n0 \9\:n0) resistor r=75 c=0
Rz6 (\4\:S0b \5\:S0b) resistor r=75 c=0
Ry7 (\2\:VDD \1\:VDD) resistor r=62 c=0
Ry10 (\15\:VDD \14\:VDD) resistor r=62 c=0
Ry11 (\17\:VDD \16\:VDD) resistor r=62 c=0
Ry4 (\4\:Y \3\:Y) resistor r=20.6667 c=0
Ry12 (\4\:VSS \3\:VSS) resistor r=8.8571 c=0
Ry13 (\7\:VSS \3\:VSS) resistor r=5.1667 c=0
Ry1 (\4\:Cp \5\:Cp) resistor r=62 c=0
Ry2 (\9\:S1b \10\:S1b) resistor r=62 c=0
Ry3 (\9\:n1 \8\:n1) resistor r=62 c=0
Ry5 (\4\:n0 \5\:n0) resistor r=62 c=0
Ry6 (\8\:S0b \9\:S0b) resistor r=62 c=0
Rx8 (\3\:A \5\:A) resistor r=45 c=0
Rx11 (\4\:S0 \8\:S0) resistor r=45 c=0
Rx12 (\6\:S0 \10\:S0) resistor r=45 c=0
Rx13 (\2\:S0 \11\:S0) resistor r=45 c=0
Rx4 (\8\:S1 \9\:S1) resistor r=45 c=0
Rx5 (\1\:S1 \11\:S1) resistor r=45 c=0
Rx6 (\6\:S1 \12\:S1) resistor r=45 c=0
Rx1 (\2\:C \4\:C) resistor r=45 c=0
Rx10 (\2\:B \4\:B) resistor r=45 c=0
Rx2 (Cp \8\:Cp) resistor r=45 c=0
Rx3 (\3\:S1b \5\:S1b) resistor r=45 c=0
Rx7 (\13\:n1 \4\:n1) resistor r=45 c=0
Rx9 (\3\:n0 \7\:n0) resistor r=45 c=0
Rx14 (\2\:S0b \7\:S0b) resistor r=45 c=0
mn6 (\6\:Cp \3\:C \9\:VSS VSS) g45n1hvt w=(1.45e-07) l=4.5e-08 nf=1 \
        as=2.682e-14 ad=2.32e-14 ps=6.6e-07 pd=6.1e-07 nrd=1.16667 \
        nrs=1.16667 sa=1.85e-07 sb=1.6e-07 sd=160n sca=22.3376 \
        scb=0.0224607 scc=0.00248252 m=(1)
mn1 (\7\:S1b \3\:S1 \15\:VSS VSS) g45n1hvt w=(1.45e-07) l=4.5e-08 nf=1 \
        as=8.41e-14 ad=2.03e-14 ps=1.6e-06 pd=5.7e-07 nrd=1.16667 \
        nrs=1.16667 sa=1.4e-07 sb=1.62e-06 sd=160n sca=23.279 \
        scb=0.0230742 scc=0.00267719 m=(1)
mn9 (n8 \2\:Cp \15\:VSS VSS) g45n1hvt w=(1.45e-07) l=4.5e-08 nf=1 \
        as=8.41e-14 ad=3.19e-14 ps=1.6e-06 pd=7.3e-07 nrd=1.16667 \
        nrs=1.16667 sa=4.05e-07 sb=1.355e-06 sd=160n sca=23.279 \
        scb=0.0230742 scc=0.00267719 m=(1)
mn10 (\11\:n1 \5\:S1 n8 VSS) g45n1hvt w=(1.45e-07) l=4.5e-08 nf=1 \
        as=3.19e-14 ad=3.553e-14 ps=7.3e-07 pd=7.8e-07 nrd=1.16667 \
        nrs=1.16667 sa=6.7e-07 sb=1.09e-06 sd=160n sca=23.279 \
        scb=0.0230742 scc=0.00267719 m=(1)
mn8 (\11\:n1 S1b n6 VSS) g45n1hvt w=(1.45e-07) l=4.5e-08 nf=1 \
        as=1.957e-14 ad=3.553e-14 ps=5.6e-07 pd=7.8e-07 nrd=1.16667 \
        nrs=1.16667 sa=9.6e-07 sb=8e-07 sd=160n sca=23.279 scb=0.0230742 \
        scc=0.00267719 m=(1)
mn7 (n6 \2\:n0 \5\:VSS VSS) g45n1hvt w=(1.45e-07) l=4.5e-08 nf=1 \
        as=9.71e-14 ad=1.958e-14 ps=1.7e-06 pd=5.6e-07 nrd=1.16667 \
        nrs=1.16667 sa=1.14e-06 sb=6.2e-07 sd=160n sca=23.279 \
        scb=0.0230742 scc=0.00267719 m=(1)
mn2 (n2 \4\:A \5\:VSS VSS) g45n1hvt w=(1.45e-07) l=4.5e-08 nf=1 \
        as=7.27e-14 ad=3.988e-14 ps=1.6e-06 pd=8.4e-07 nrd=1.16667 \
        nrs=1.16667 sa=2.18621e-07 sb=1.13e-06 sd=160n sca=7.27658 \
        scb=0.00433573 scc=4.41722e-05 m=(1)
mn3 (\8\:n0 \3\:S0b n2 VSS) g45n1hvt w=(1.45e-07) l=4.5e-08 nf=1 \
        as=3.988e-14 ad=2.32e-14 ps=8.4e-07 pd=6.1e-07 nrd=1.16667 \
        nrs=1.16667 sa=5.38621e-07 sb=8.1e-07 sd=160n sca=7.27658 \
        scb=0.00433573 scc=4.41722e-05 m=(1)
mn5 (\8\:n0 \3\:S0 n4 VSS) g45n1hvt w=(1.45e-07) l=4.5e-08 nf=1 \
        as=8.7e-15 ad=2.32e-14 ps=4.1e-07 pd=6.1e-07 nrd=1.16667 \
        nrs=1.16667 sa=7.43621e-07 sb=6.05e-07 sd=160n sca=7.27658 \
        scb=0.00433573 scc=4.41722e-05 m=(1)
mn4 (n4 \3\:B \1\:VSS VSS) g45n1hvt w=(1.45e-07) l=4.5e-08 nf=1 \
        as=4.568e-14 ad=8.7e-15 ps=9.2e-07 pd=4.1e-07 nrd=1.16667 \
        nrs=1.16667 sa=8.48621e-07 sb=5e-07 sd=160n sca=7.27658 \
        scb=0.00433573 scc=4.41722e-05 m=(1)
mn0 (\4\:S0b \5\:S0 \1\:VSS VSS) g45n1hvt w=(1.45e-07) l=4.5e-08 nf=1 \
        as=4.568e-14 ad=2.03e-14 ps=9.2e-07 pd=5.7e-07 nrd=1.16667 \
        nrs=1.16667 sa=1.20862e-06 sb=1.4e-07 sd=160n sca=7.27658 \
        scb=0.00433573 scc=4.41722e-05 m=(1)
mn11 (\1\:Y n1 \5\:VSS VSS) g45n1hvt w=(2.6e-07) l=4.5e-08 nf=1 \
        as=8.49e-14 ad=4.16e-14 ps=1.65e-06 pd=8.4e-07 nrd=1.16667 \
        nrs=1.16667 sa=8.86635e-07 sb=3.79712e-07 sd=160n sca=17.5885 \
        scb=0.0172826 scc=0.00162584 m=(2)
mp11_1__rcx (\3\:Y n1 \5\:VDD VDD) g45p1hvt w=(3.9e-07) l=4.5e-08 nf=1 \
        as=7.528e-14 ad=6.24e-14 ps=1.27e-06 pd=1.1e-06 nrd=1.16667 \
        nrs=1.16667 sa=8.55192e-07 sb=9.5141e-07 sd=160n sca=19.7306 \
        scb=0.0167337 scc=0.00184272 m=(2)
ends MXI3X2
// End of subcircuit definition.
