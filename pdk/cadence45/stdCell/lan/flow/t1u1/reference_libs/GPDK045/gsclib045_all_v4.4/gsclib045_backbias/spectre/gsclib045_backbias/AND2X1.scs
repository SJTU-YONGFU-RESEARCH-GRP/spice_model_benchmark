// gsclib045_backbias/AND2X1/schematic

simulator lang=spectre

subckt AND2X1 A B Y VDD VSS NW
mn2 (Y n0 VSS VSS) g45n1svt w=(260n) l=45n nf=1 m=(1)
mn0 (net127 B VSS VSS) g45n1svt w=(145n) l=45n nf=1 m=(1)
mn1 (n0 A net127 VSS) g45n1svt w=(145n) l=45n nf=1 m=(1)
mp1 (n0 B VDD NW) g45p1svt w=(215n) l=45n nf=1 m=(1)
mp0 (n0 A VDD NW) g45p1svt w=(215n) l=45n nf=1 m=(1)
mp2 (Y n0 VDD NW) g45p1svt w=(390n) l=45n nf=1 m=(1)
ends AND2X1
