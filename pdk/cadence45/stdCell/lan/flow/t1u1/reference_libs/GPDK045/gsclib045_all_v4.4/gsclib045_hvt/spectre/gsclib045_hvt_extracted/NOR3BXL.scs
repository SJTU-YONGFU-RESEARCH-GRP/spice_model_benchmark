// Generated for: spectre (May  1 09:18:11 2013 )
// Library name: gsclib045_hvt
// Cell name: NOR3BXL
// View name: extracted

simulator lang=spectre

subckt NOR3BXL AN B C VDD VSS Y
mp3 (\6\:Y \1\:C net90 VDD) g45p1hvt w=(2.15e-07) l=4.5e-08 nf=1 \
        as=1.828e-14 ad=3.01e-14 ps=6e-07 pd=7.1e-07 nrd=1.16667 \
        nrs=1.16667 sa=1.4e-07 sb=6.65e-07 sd=160n sca=16.2296 \
        scb=0.0157286 scc=0.000281388 m=(1)
mp2 (net90 \1\:B net86 VDD) g45p1hvt w=(2.15e-07) l=4.5e-08 nf=1 \
        as=3.118e-14 ad=1.828e-14 ps=7.2e-07 pd=6e-07 nrd=1.16667 \
        nrs=1.16667 sa=2.7e-07 sb=5.35e-07 sd=160n sca=14.0893 \
        scb=0.0114914 scc=0.000172675 m=(1)
mp1 (net86 \3\:net91 \1\:VDD VDD) g45p1hvt w=(2.15e-07) l=4.5e-08 nf=1 \
        as=3.44e-14 ad=3.118e-14 ps=7.5e-07 pd=7.2e-07 nrd=1.16667 \
        nrs=1.16667 sa=4.6e-07 sb=3.45e-07 sd=160n sca=13.7313 \
        scb=0.0107733 scc=0.000165409 m=(1)
mp0 (\8\:net91 \3\:AN \1\:VDD VDD) g45p1hvt w=(2.15e-07) l=4.5e-08 nf=1 \
        as=3.44e-14 ad=3.01e-14 ps=7.5e-07 pd=7.1e-07 nrd=1.16667 \
        nrs=1.16667 sa=6.65e-07 sb=1.4e-07 sd=160n sca=16.8204 \
        scb=0.0168333 scc=0.000331828 m=(1)
C1 (VDD VSS) capacitor c=1.29796e-16
C2 (C VSS) capacitor c=8.06676e-17
C3 (Y VSS) capacitor c=6.58493e-17
C4 (net91 VSS) capacitor c=3.40099e-17
C5 (\3\:AN VSS) capacitor c=3.90656e-17
C6 (\3\:net91 VSS) capacitor c=7.1931e-17
C7 (\1\:B VSS) capacitor c=4.62914e-17
C8 (\1\:C VSS) capacitor c=6.29865e-17
C9 (\1\:AN VSS) capacitor c=4.7883e-17
C10 (\3\:B VSS) capacitor c=6.85908e-17
C11 (\3\:C VSS) capacitor c=3.87726e-17
C12 (\2\:AN VSS) capacitor c=5.12079e-17
C13 (\2\:net91 VSS) capacitor c=6.13051e-17
C14 (\2\:B VSS) capacitor c=7.59842e-17
C15 (\2\:C VSS) capacitor c=6.25368e-17
C16 (\8\:net91 VSS) capacitor c=5.72533e-17
C17 (\1\:VDD VSS) capacitor c=3.07535e-17
C18 (\6\:Y VSS) capacitor c=5.72353e-17
C19 (\4\:net91 VSS) capacitor c=3.44302e-17
C20 (\4\:Y VSS) capacitor c=7.42728e-17
C21 (\1\:Y VSS) capacitor c=2.08145e-17
C22 (\4\:C VSS) capacitor c=4.52273e-17
C23 (\4\:B VSS) capacitor c=9.90428e-17
C24 (\3\:Y VSS) capacitor c=4.52412e-17
C25 (\4\:AN VSS) capacitor c=9.40873e-17
C26 (\6\:net91 VSS) capacitor c=4.82261e-17
C27 (\7\:net91 VSS) capacitor c=4.54465e-17
C28 (\4\:VDD VSS) capacitor c=2.59831e-17
Rk16 (\4\:VDD VDD) resistor r=0.2504 c=0
Rk15 (\2\:VDD \4\:VDD) resistor r=0.3465 c=0
Rk1 (C \4\:C) resistor r=0.09895 c=0
Rk7 (AN \4\:AN) resistor r=0.02603 c=0
Rk11 (\2\:VSS \4\:VSS) resistor r=0.2843 c=0
Rk13 (\5\:VSS VSS) resistor r=0.1374 c=0
Rk12 (\4\:VSS \5\:VSS) resistor r=0.1126 c=0
Rk14 (\5\:VSS \7\:VSS) resistor r=0.19 c=0
Rk4 (\3\:Y Y) resistor r=0.1536 c=0
Rk3 (\2\:Y \3\:Y) resistor r=0.097 c=0
Rk5 (\3\:Y \5\:Y) resistor r=0.3711 c=0
Rk6 (Y \7\:Y) resistor r=0.5063 c=0
Rk2 (\4\:B B) resistor r=0.01199 c=0
Rk8 (\5\:net91 \6\:net91) resistor r=0.1853 c=0
Rk9 (\6\:net91 \7\:net91) resistor r=0.2586 c=0
Rk10 (\6\:net91 \9\:net91) resistor r=0.5225 c=0
Rl1 (\1\:C \2\:C) resistor r=159.615 c=0
Rl2 (\2\:C \3\:C) resistor r=101.374 c=0
Rl8 (\2\:AN \3\:AN) resistor r=101.156 c=0
Rl7 (\1\:AN \2\:AN) resistor r=155.002 c=0
Rl3 (\1\:B \2\:B) resistor r=29.5379 c=0
Rl4 (\2\:B \3\:B) resistor r=229.538 c=0
Rl6 (\2\:net91 \3\:net91) resistor r=206.867 c=0
Rl5 (net91 \2\:net91) resistor r=45.3288 c=0
Rz4 (\1\:VSS \2\:VSS) resistor r=75 c=0
Rz5 (\6\:VSS \7\:VSS) resistor r=75 c=0
Rz1 (\1\:Y \2\:Y) resistor r=75 c=0
Rz2 (\4\:Y \5\:Y) resistor r=75 c=0
Rz3 (\4\:net91 \5\:net91) resistor r=75 c=0
Ry4 (\1\:VDD \2\:VDD) resistor r=62 c=0
Ry1 (\6\:Y \7\:Y) resistor r=62 c=0
Ry2 (\8\:net91 \9\:net91) resistor r=62 c=0
Rx1 (\2\:C \4\:C) resistor r=45 c=0
Rx3 (\2\:AN \4\:AN) resistor r=45 c=0
Rx2 (\2\:B \4\:B) resistor r=45 c=0
Rx4 (\2\:net91 \7\:net91) resistor r=45 c=0
mn3 (\1\:Y \3\:C \6\:VSS VSS) g45n1hvt w=(1.45e-07) l=4.5e-08 nf=1 \
        as=2.32e-14 ad=2.03e-14 ps=6.1e-07 pd=5.7e-07 nrd=1.16667 \
        nrs=1.16667 sa=1.4e-07 sb=7.55e-07 sd=160n sca=6.91521 \
        scb=0.00371851 scc=3.09367e-05 m=(1)
mn2 (\4\:Y \3\:B \6\:VSS VSS) g45n1hvt w=(1.45e-07) l=4.5e-08 nf=1 \
        as=2.32e-14 ad=2.32e-14 ps=6.1e-07 pd=6.1e-07 nrd=1.16667 \
        nrs=1.16667 sa=3.45e-07 sb=5.5e-07 sd=160n sca=6.91521 \
        scb=0.00371851 scc=3.09367e-05 m=(1)
mn1 (\4\:Y net91 \1\:VSS VSS) g45n1hvt w=(1.45e-07) l=4.5e-08 nf=1 \
        as=2.32e-14 ad=2.32e-14 ps=6.1e-07 pd=6.1e-07 nrd=1.16667 \
        nrs=1.16667 sa=5.5e-07 sb=3.45e-07 sd=160n sca=6.91521 \
        scb=0.00371851 scc=3.09367e-05 m=(1)
mn0 (\4\:net91 \1\:AN \1\:VSS VSS) g45n1hvt w=(1.45e-07) l=4.5e-08 nf=1 \
        as=2.32e-14 ad=2.03e-14 ps=6.1e-07 pd=5.7e-07 nrd=1.16667 \
        nrs=1.16667 sa=7.55e-07 sb=1.4e-07 sd=160n sca=6.91521 \
        scb=0.00371851 scc=3.09367e-05 m=(1)
ends NOR3BXL
// End of subcircuit definition.
