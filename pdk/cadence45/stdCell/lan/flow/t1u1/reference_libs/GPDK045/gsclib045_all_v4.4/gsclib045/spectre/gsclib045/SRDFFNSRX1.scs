// gsclib045/SRDFFNSRX1/schematic

simulator lang=spectre

subckt SRDFFNSRX1 CKN D Q QN RN RT SE SI SN VDD ExtVDD VSS
NM3 (net0134 qbint VSS VSS) g45n1svt w=(145n) l=45n nf=1 m=(1)
NM2 (n35g RT net0134 VSS) g45n1svt w=(145n) l=45n nf=1 m=(1)
NM1 (RTb RT VSS VSS) g45n1svt w=(145n) l=45n nf=1 m=(1)
NM0 (n35g RTb n35 VSS) g45n1svt w=(145n) l=45n nf=1 m=(1)
mn13 (n2 SI VSS VSS) g45n1svt w=(145n) l=45n nf=1 m=(1)
mn14 (Db SE n2 VSS) g45n1svt w=(145n) l=45n nf=1 m=(1)
mn12 (Db SEb n0 VSS) g45n1svt w=(145n) l=45n nf=1 m=(1)
mn11 (n0 D VSS VSS) g45n1svt w=(145n) l=45n nf=1 m=(1)
mn57 (QN net573 VSS VSS) g45n1svt w=(260n) l=45n nf=1 m=(1)
mn55 (Q qbint VSS VSS) g45n1svt w=(260n) l=45n nf=1 m=(1)
mn35 (n6 mout VSS VSS) g45n1svt w=(145n) l=45n nf=1 m=(1)
mn36 (n20 CKNb n6 VSS) g45n1svt w=(145n) l=45n nf=1 m=(1)
mn22 (RNb RN VSS VSS) g45n1svt w=(145n) l=45n nf=1 m=(1)
mn20 (CKNb CKN VSS VSS) g45n1svt w=(145n) l=45n nf=1 m=(1)
mn10 (SEb SE VSS VSS) g45n1svt w=(145n) l=45n nf=1 m=(1)
mn56 (net573 qbint VSS VSS) g45n1svt w=(145n) l=45n nf=1 m=(1)
mn25 (Db CKNbb n20 VSS) g45n1svt w=(145n) l=45n nf=1 m=(1)
mn32 (mout n20 n4 VSS) g45n1svt w=(145n) l=45n nf=1 m=(1)
mn53 (n35 CKNbb n10 VSS) g45n1svt w=(145n) l=45n nf=1 m=(1)
mn30 (n4 SN VSS VSS) g45n1svt w=(145n) l=45n nf=1 m=(1)
mn50 (n8 SN VSS VSS) g45n1svt w=(145n) l=45n nf=1 m=(1)
mn51 (n10 RNb n8 VSS) g45n1svt w=(145n) l=45n nf=1 m=(1)
mn40 (n35 CKNb mout VSS) g45n1svt w=(145n) l=45n nf=1 m=(1)
mn31 (mout RNb n4 VSS) g45n1svt w=(145n) l=45n nf=1 m=(1)
mn21 (CKNbb CKNb VSS VSS) g45n1svt w=(145n) l=45n nf=1 m=(1)
mn52 (n10 qbint n8 VSS) g45n1svt w=(145n) l=45n nf=1 m=(1)
mn45 (qbint n35g VSS VSS) g45n1svt w=(145n) l=45n nf=1 m=(1)
PM3 (n35g RTb net234 ExtVDD) g45p1svt w=(215n) l=45n nf=1 m=(1)
PM2 (net234 qbint ExtVDD ExtVDD) g45p1svt w=(215n) l=45n nf=1 m=(1)
PM1 (RTb RT ExtVDD ExtVDD) g45p1svt w=(215n) l=45n nf=1 m=(1)
PM0 (n35g RT n35 ExtVDD) g45p1svt w=(215n) l=45n nf=1 m=(1)
mp14 (Db SEb n3 VDD) g45p1svt w=(215n) l=45n nf=1 m=(1)
mp13 (n3 SI VDD VDD) g45p1svt w=(215n) l=45n nf=1 m=(1)
mp12 (Db SE n1 VDD) g45p1svt w=(215n) l=45n nf=1 m=(1)
mp11 (n1 D VDD VDD) g45p1svt w=(215n) l=45n nf=1 m=(1)
mp52 (n11 qbint n9 VDD) g45p1svt w=(215n) l=45n nf=1 m=(1)
mp51 (n9 RNb VDD VDD) g45p1svt w=(215n) l=45n nf=1 m=(1)
mp57 (QN net573 VDD VDD) g45p1svt w=(390n) l=45n nf=1 m=(1)
mp55 (Q qbint VDD VDD) g45p1svt w=(390n) l=45n nf=1 m=(1)
mp36 (n20 CKNbb n7 VDD) g45p1svt w=(215n) l=45n nf=1 m=(1)
mp35 (n7 mout VDD VDD) g45p1svt w=(215n) l=45n nf=1 m=(1)
mp32 (mout n20 n5 VDD) g45p1svt w=(215n) l=45n nf=1 m=(1)
mp31 (n5 RNb VDD VDD) g45p1svt w=(215n) l=45n nf=1 m=(1)
mp22 (RNb RN VDD VDD) g45p1svt w=(215n) l=45n nf=1 m=(1)
mp20 (CKNb CKN VDD VDD) g45p1svt w=(215n) l=45n nf=1 m=(1)
mp21 (CKNbb CKNb VDD VDD) g45p1svt w=(215n) l=45n nf=1 m=(1)
mp45 (qbint n35g ExtVDD ExtVDD) g45p1svt w=(215n) l=45n nf=1 m=(1)
mp30 (mout SN VDD VDD) g45p1svt w=(215n) l=45n nf=1 m=(1)
mp25 (n20 CKNb Db VDD) g45p1svt w=(215n) l=45n nf=1 m=(1)
mp56 (net573 qbint VDD VDD) g45p1svt w=(215n) l=45n nf=1 m=(1)
mp40 (n35 CKNbb mout VDD) g45p1svt w=(215n) l=45n nf=1 m=(1)
mp53 (n35 CKNb n11 VDD) g45p1svt w=(215n) l=45n nf=1 m=(1)
mp50 (n11 SN VDD VDD) g45p1svt w=(215n) l=45n nf=1 m=(1)
mp10 (SEb SE VDD VDD) g45p1svt w=(215n) l=45n nf=1 m=(1)
ends SRDFFNSRX1
