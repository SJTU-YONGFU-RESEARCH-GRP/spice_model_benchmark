// Generated for: spectre (May  1 09:13:55 2013 )
// Library name: gsclib045_lvt
// Cell name: DFFSRHQX1
// View name: extracted

simulator lang=spectre

subckt DFFSRHQX1 CK D Q RN SN VDD VSS
mp55 (\1\:Q \4\:qbint \21\:VDD VDD) g45p1lvt w=(3.9e-07) l=4.5e-08 nf=1 \
        as=6.38e-14 ad=5.46e-14 ps=1.14e-06 pd=1.06e-06 nrd=1.16667 \
        nrs=1.16667 sa=1.4e-07 sb=2.91154e-07 sd=160n sca=43.1032 \
        scb=0.0380646 scc=0.00455683 m=(1)
C1 (SN VSS) capacitor c=2.72964e-16
C2 (RN VSS) capacitor c=7.28237e-17
C3 (CK VSS) capacitor c=3.97628e-17
C4 (D VSS) capacitor c=6.54213e-17
C5 (VDD VSS) capacitor c=4.20451e-16
C6 (qbint VSS) capacitor c=1.96808e-17
C7 (n35 VSS) capacitor c=4.80096e-17
C8 (RNb VSS) capacitor c=1.36905e-16
C9 (n42 VSS) capacitor c=7.9225e-17
C10 (n40 VSS) capacitor c=9.23847e-17
C11 (CKb VSS) capacitor c=3.48521e-17
C12 (mout VSS) capacitor c=3.92855e-17
C13 (CKbb VSS) capacitor c=4.27884e-17
C14 (n25 VSS) capacitor c=8.32722e-17
C15 (n20 VSS) capacitor c=2.83194e-17
C16 (n30 VSS) capacitor c=2.79728e-18
C17 (n41 VSS) capacitor c=8.71827e-17
C18 (n43 VSS) capacitor c=1.70491e-18
C19 (n26 VSS) capacitor c=2.74119e-18
C20 (n31 VSS) capacitor c=3.53739e-18
C21 (n22 VSS) capacitor c=4.66065e-18
C22 (\3\:CK VSS) capacitor c=2.47438e-17
C23 (\9\:CKb VSS) capacitor c=5.75469e-17
C24 (\1\:D VSS) capacitor c=5.62034e-17
C25 (\5\:CKbb VSS) capacitor c=4.05899e-17
C26 (\5\:CKb VSS) capacitor c=5.78313e-17
C27 (\4\:SN VSS) capacitor c=6.14063e-17
C28 (\3\:n20 VSS) capacitor c=6.36224e-17
C29 (\4\:CKb VSS) capacitor c=4.1424e-17
C30 (\3\:RNb VSS) capacitor c=8.07873e-17
C31 (\6\:qbint VSS) capacitor c=1.50523e-16
C32 (\1\:SN VSS) capacitor c=5.3972e-17
C33 (\1\:RN VSS) capacitor c=3.06179e-17
C34 (\4\:qbint VSS) capacitor c=4.39177e-17
C35 (\1\:CK VSS) capacitor c=1.7919e-17
C36 (\10\:CKb VSS) capacitor c=3.71105e-17
C37 (\3\:D VSS) capacitor c=7.55065e-17
C38 (\7\:CKb VSS) capacitor c=6.33403e-17
C39 (\7\:CKbb VSS) capacitor c=6.37466e-17
C40 (\4\:mout VSS) capacitor c=3.8554e-17
C41 (\6\:SN VSS) capacitor c=5.35501e-17
C42 (\4\:n20 VSS) capacitor c=4.09095e-17
C43 (\5\:RNb VSS) capacitor c=4.68022e-17
C44 (\3\:CKbb VSS) capacitor c=3.77053e-17
C45 (\3\:CKb VSS) capacitor c=4.94994e-17
C46 (\4\:RNb VSS) capacitor c=6.35425e-17
C47 (\5\:qbint VSS) capacitor c=7.91377e-17
C48 (\3\:SN VSS) capacitor c=3.52398e-17
C49 (\3\:RN VSS) capacitor c=3.21057e-17
C50 (\3\:n35 VSS) capacitor c=3.59149e-17
C51 (\3\:qbint VSS) capacitor c=3.94658e-17
C52 (\2\:CK VSS) capacitor c=1.71585e-17
C53 (\11\:CKb VSS) capacitor c=1.7621e-17
C54 (\2\:D VSS) capacitor c=4.90693e-17
C55 (\8\:CKb VSS) capacitor c=4.45382e-17
C56 (\6\:CKbb VSS) capacitor c=5.63084e-17
C57 (\6\:CKb VSS) capacitor c=4.33615e-17
C58 (\3\:mout VSS) capacitor c=3.38972e-17
C59 (\5\:SN VSS) capacitor c=2.16993e-17
C60 (\4\:CKbb VSS) capacitor c=4.12195e-17
C61 (\2\:CKbb VSS) capacitor c=3.37275e-17
C62 (\2\:RNb VSS) capacitor c=9.07472e-17
C63 (\2\:SN VSS) capacitor c=3.17035e-17
C64 (\2\:RN VSS) capacitor c=2.80623e-17
C65 (\7\:qbint VSS) capacitor c=4.42667e-17
C66 (\2\:n35 VSS) capacitor c=3.68485e-17
C67 (\1\:VDD VSS) capacitor c=4.17504e-17
C68 (\19\:CKb VSS) capacitor c=5.49356e-17
C69 (\16\:CKbb VSS) capacitor c=2.39364e-17
C70 (\8\:VDD VSS) capacitor c=2.99345e-17
C71 (\5\:n20 VSS) capacitor c=4.52183e-17
C72 (\10\:VDD VSS) capacitor c=5.31811e-17
C73 (\12\:mout VSS) capacitor c=3.68047e-17
C74 (\12\:VDD VSS) capacitor c=4.05503e-17
C75 (\7\:mout VSS) capacitor c=1.70905e-16
C76 (\4\:n35 VSS) capacitor c=7.08566e-17
C77 (\15\:VDD VSS) capacitor c=4.8471e-17
C78 (\3\:n41 VSS) capacitor c=1.04891e-16
C79 (\18\:VDD VSS) capacitor c=7.482e-17
C80 (\7\:RNb VSS) capacitor c=2.20635e-16
C81 (\9\:qbint VSS) capacitor c=5.5022e-17
C82 (\21\:VDD VSS) capacitor c=6.61397e-17
C83 (\1\:Q VSS) capacitor c=5.42181e-17
C84 (\3\:VDD VSS) capacitor c=1.68153e-16
C85 (\17\:CKb VSS) capacitor c=9.5956e-17
C86 (\13\:CKbb VSS) capacitor c=8.25655e-17
C87 (\9\:n20 VSS) capacitor c=7.40102e-17
C88 (\14\:mout VSS) capacitor c=1.12812e-16
C89 (\3\:n25 VSS) capacitor c=7.87703e-17
C90 (\10\:mout VSS) capacitor c=1.27707e-17
C91 (\8\:n35 VSS) capacitor c=2.09486e-17
C92 (\3\:n42 VSS) capacitor c=8.02637e-17
C93 (\3\:n40 VSS) capacitor c=1.11079e-16
C94 (\9\:RNb VSS) capacitor c=8.56663e-17
C95 (\12\:qbint VSS) capacitor c=6.37138e-17
C96 (\3\:Q VSS) capacitor c=4.22675e-17
C97 (\2\:qbint VSS) capacitor c=1.33331e-17
C98 (\2\:CKb VSS) capacitor c=6.20072e-17
C99 (\2\:n20 VSS) capacitor c=2.7332e-17
C100 (\2\:mout VSS) capacitor c=4.06332e-17
C101 (\8\:qbint VSS) capacitor c=4.79979e-17
C102 (\11\:qbint VSS) capacitor c=6.53632e-17
C103 (\14\:qbint VSS) capacitor c=6.82954e-17
C104 (\4\:RN VSS) capacitor c=4.82964e-17
C105 (\6\:RNb VSS) capacitor c=1.57867e-16
C106 (\6\:n35 VSS) capacitor c=3.00162e-16
C107 (\7\:n35 VSS) capacitor c=2.96277e-16
C108 (\7\:SN VSS) capacitor c=2.95247e-16
C109 (\8\:SN VSS) capacitor c=2.49209e-17
C110 (\5\:mout VSS) capacitor c=4.11905e-17
C111 (\6\:mout VSS) capacitor c=1.35805e-16
C112 (\9\:mout VSS) capacitor c=7.21954e-17
C113 (\7\:n20 VSS) capacitor c=1.22038e-16
C114 (\8\:n20 VSS) capacitor c=1.41819e-16
C115 (\4\:D VSS) capacitor c=5.74225e-17
C116 (\8\:CKbb VSS) capacitor c=3.48417e-17
C117 (\9\:CKbb VSS) capacitor c=2.56223e-16
C118 (\10\:CKbb VSS) capacitor c=3.91518e-16
C119 (\11\:CKbb VSS) capacitor c=7.21905e-17
C120 (\12\:CKbb VSS) capacitor c=6.58366e-17
C121 (\15\:CKbb VSS) capacitor c=8.03718e-17
C122 (\12\:CKb VSS) capacitor c=1.87532e-16
C123 (\13\:CKb VSS) capacitor c=1.96475e-16
C124 (\14\:CKb VSS) capacitor c=4.17567e-17
C125 (\15\:CKb VSS) capacitor c=1.2419e-16
C126 (\16\:CKb VSS) capacitor c=8.16661e-17
C127 (\4\:CK VSS) capacitor c=8.55084e-17
C128 (\5\:VDD VSS) capacitor c=2.26122e-17
C129 (\6\:VDD VSS) capacitor c=3.43783e-17
C130 (\14\:VDD VSS) capacitor c=8.55816e-17
C131 (\20\:VDD VSS) capacitor c=2.28991e-17
Rk16 (\7\:SN SN) resistor r=2.333 c=0
Rk17 (SN \8\:SN) resistor r=0.02742 c=0
Rk43 (\2\:VSS \4\:VSS) resistor r=0.7014 c=0
Rk44 (\4\:VSS \5\:VSS) resistor r=0.1504 c=0
Rk45 (\5\:VSS \6\:VSS) resistor r=0.5192 c=0
Rk46 (\6\:VSS \7\:VSS) resistor r=0.3336 c=0
Rk47 (\7\:VSS \8\:VSS) resistor r=1.2054 c=0
Rk48 (\5\:VSS \10\:VSS) resistor r=0.2741 c=0
Rk49 (\6\:VSS \12\:VSS) resistor r=0.263 c=0
Rk51 (\13\:VSS VSS) resistor r=0.1075 c=0
Rk50 (\8\:VSS \13\:VSS) resistor r=0.4441 c=0
Rk52 (\8\:VSS \15\:VSS) resistor r=0.3018 c=0
Rk53 (\13\:VSS \17\:VSS) resistor r=0.3486 c=0
Rk7 (\4\:RN RN) resistor r=0.04987 c=0
Rk1 (\2\:Q Q) resistor r=0.3194 c=0
Rk2 (Q \4\:Q) resistor r=0.05469 c=0
Rk42 (\4\:CK CK) resistor r=0.05249 c=0
Rk28 (D \4\:D) resistor r=0.04223 c=0
Rk54 (\2\:VDD \4\:VDD) resistor r=0.6926 c=0
Rk55 (\4\:VDD \5\:VDD) resistor r=0.1504 c=0
Rk56 (\5\:VDD \6\:VDD) resistor r=0.4163 c=0
Rk57 (\6\:VDD \7\:VDD) resistor r=0.4365 c=0
Rk58 (\5\:VDD \9\:VDD) resistor r=0.2394 c=0
Rk59 (\6\:VDD \11\:VDD) resistor r=0.2653 c=0
Rk60 (\7\:VDD \13\:VDD) resistor r=0.224 c=0
Rk61 (\7\:VDD \14\:VDD) resistor r=0.7509 c=0
Rk62 (\14\:VDD \16\:VDD) resistor r=0.2312 c=0
Rk63 (\14\:VDD \17\:VDD) resistor r=0.4541 c=0
Rk64 (\17\:VDD \19\:VDD) resistor r=0.405 c=0
Rk67 (\20\:VDD VDD) resistor r=0.1075 c=0
Rk65 (\17\:VDD \20\:VDD) resistor r=0.4447 c=0
Rk66 (\20\:VDD \22\:VDD) resistor r=0.3578 c=0
Rk3 (\8\:qbint \10\:qbint) resistor r=0.4183 c=0
Rk4 (\10\:qbint \11\:qbint) resistor r=0.2556 c=0
Rk5 (\11\:qbint \13\:qbint) resistor r=0.2909 c=0
Rk6 (\11\:qbint \14\:qbint) resistor r=0.349 c=0
Rk13 (\5\:n35 \6\:n35) resistor r=0.2994 c=0
Rk14 (\6\:n35 \7\:n35) resistor r=2.3509 c=0
Rk15 (\6\:n35 \9\:n35) resistor r=0.08492 c=0
Rk8 (\6\:RNb \8\:RNb) resistor r=1.2267 c=0
Rk9 (\8\:RNb \10\:RNb) resistor r=0.4554 c=0
Rk10 (\2\:n42 \4\:n42) resistor r=0.3862 c=0
Rk12 (\2\:n40 \4\:n40) resistor r=0.6353 c=0
Rk36 (\12\:CKb \13\:CKb) resistor r=1.214 c=0
Rk37 (\13\:CKb \14\:CKb) resistor r=0.1465 c=0
Rk38 (\13\:CKb \15\:CKb) resistor r=0.7366 c=0
Rk39 (\15\:CKb \16\:CKb) resistor r=0.4596 c=0
Rk40 (\16\:CKb \18\:CKb) resistor r=0.3808 c=0
Rk41 (\18\:CKb \20\:CKb) resistor r=0.329 c=0
Rk19 (\5\:mout \6\:mout) resistor r=0.1774 c=0
Rk20 (\6\:mout \8\:mout) resistor r=0.876 c=0
Rk21 (\8\:mout \9\:mout) resistor r=0.2977 c=0
Rk22 (\9\:mout \11\:mout) resistor r=0.06809 c=0
Rk23 (\6\:mout \13\:mout) resistor r=0.08734 c=0
Rk24 (\9\:mout \15\:mout) resistor r=0.6226 c=0
Rk29 (\8\:CKbb \9\:CKbb) resistor r=0.1395 c=0
Rk30 (\9\:CKbb \10\:CKbb) resistor r=2.1725 c=0
Rk31 (\10\:CKbb \11\:CKbb) resistor r=0.509 c=0
Rk32 (\9\:CKbb \12\:CKbb) resistor r=0.3496 c=0
Rk33 (\12\:CKbb \14\:CKbb) resistor r=0.3403 c=0
Rk34 (\10\:CKbb \15\:CKbb) resistor r=0.3748 c=0
Rk35 (\12\:CKbb \17\:CKbb) resistor r=0.03495 c=0
Rk18 (\2\:n25 \4\:n25) resistor r=0.4103 c=0
Rk25 (\6\:n20 \7\:n20) resistor r=0.1437 c=0
Rk26 (\7\:n20 \8\:n20) resistor r=0.782 c=0
Rk27 (\7\:n20 \10\:n20) resistor r=0.3476 c=0
Rk11 (\2\:n41 \4\:n41) resistor r=0.4243 c=0
Rl25 (\4\:SN \6\:SN) resistor r=178.846 c=0
Rl24 (\4\:SN \5\:SN) resistor r=105.282 c=0
Rl8 (\1\:SN \2\:SN) resistor r=26.9231 c=0
Rl9 (\2\:SN \3\:SN) resistor r=91.7582 c=0
Rl6 (\1\:RN \2\:RN) resistor r=49.2328 c=0
Rl7 (\2\:RN \3\:RN) resistor r=87.6944 c=0
Rl38 (\2\:CK \3\:CK) resistor r=41.0521 c=0
Rl37 (\1\:CK \2\:CK) resistor r=26.9231 c=0
Rl33 (\1\:D \2\:D) resistor r=64.1533 c=0
Rl34 (\2\:D \3\:D) resistor r=106.461 c=0
Rl10 (\5\:qbint \6\:qbint) resistor r=203.412 c=0
Rl11 (\6\:qbint \7\:qbint) resistor r=324.513 c=0
Rl3 (\2\:qbint \4\:qbint) resistor r=34.3295 c=0
Rl2 (\2\:qbint \3\:qbint) resistor r=49.7141 c=0
Rl1 (qbint \2\:qbint) resistor r=1.2713 c=0
Rl4 (n35 \2\:n35) resistor r=70.3867 c=0
Rl5 (\2\:n35 \3\:n35) resistor r=24.2328 c=0
Rl20 (RNb \5\:RNb) resistor r=128.846 c=0
Rl19 (\3\:RNb \4\:RNb) resistor r=182.692 c=0
Rl17 (RNb \2\:RNb) resistor r=773.054 c=0
Rl18 (\2\:RNb \3\:RNb) resistor r=53.6412 c=0
Rl35 (\9\:CKb \10\:CKb) resistor r=196.154 c=0
Rl36 (\10\:CKb \11\:CKb) resistor r=24.2328 c=0
Rl32 (\7\:CKb \8\:CKb) resistor r=29.5379 c=0
Rl29 (\5\:CKb \6\:CKb) resistor r=74.2328 c=0
Rl16 (\2\:CKb \4\:CKb) resistor r=30.4507 c=0
Rl15 (\2\:CKb \3\:CKb) resistor r=147.62 c=0
Rl14 (CKb \2\:CKb) resistor r=140.774 c=0
Rl26 (mout \2\:mout) resistor r=47.3105 c=0
Rl28 (\2\:mout \4\:mout) resistor r=128.08 c=0
Rl27 (\2\:mout \3\:mout) resistor r=71.5271 c=0
Rl30 (\5\:CKbb \6\:CKbb) resistor r=24.7951 c=0
Rl31 (\6\:CKbb \7\:CKbb) resistor r=188.004 c=0
Rl13 (\3\:CKbb \4\:CKbb) resistor r=29.5379 c=0
Rl12 (CKbb \2\:CKbb) resistor r=29.5379 c=0
Rl22 (\2\:n20 \3\:n20) resistor r=55.7471 c=0
Rl23 (\2\:n20 \4\:n20) resistor r=82.3738 c=0
Rl21 (n20 \2\:n20) resistor r=48.0022 c=0
Rz16 (\1\:VSS \2\:VSS) resistor r=75 c=0
Rz17 (\9\:VSS \10\:VSS) resistor r=75 c=0
Rz18 (\11\:VSS \12\:VSS) resistor r=75 c=0
Rz19 (\14\:VSS \15\:VSS) resistor r=75 c=0
Rz20 (\16\:VSS \17\:VSS) resistor r=75 c=0
Rz1 (\3\:Q \4\:Q) resistor r=75 c=0
Rz21 (\3\:VDD \4\:VDD) resistor r=9.375 c=0
Rz22 (\3\:VDD \7\:VDD) resistor r=6.25 c=0
Rz23 (\3\:VDD \17\:VDD) resistor r=6.25 c=0
Rz2 (\12\:qbint \13\:qbint) resistor r=75 c=0
Rz8 (\8\:n35 \9\:n35) resistor r=75 c=0
Rz3 (\9\:RNb \10\:RNb) resistor r=75 c=0
Rz4 (n42 \2\:n42) resistor r=75 c=0
Rz5 (\3\:n42 \4\:n42) resistor r=75 c=0
Rz6 (n40 \2\:n40) resistor r=75 c=0
Rz7 (\3\:n40 \4\:n40) resistor r=75 c=0
Rz15 (\17\:CKb \18\:CKb) resistor r=75 c=0
Rz11 (\10\:mout \11\:mout) resistor r=75 c=0
Rz12 (\14\:mout \15\:mout) resistor r=75 c=0
Rz14 (\13\:CKbb \14\:CKbb) resistor r=75 c=0
Rz9 (n25 \2\:n25) resistor r=75 c=0
Rz10 (\3\:n25 \4\:n25) resistor r=75 c=0
Rz13 (\9\:n20 \10\:n20) resistor r=75 c=0
Ry12 (\3\:VSS \4\:VSS) resistor r=7.75 c=0
Ry13 (\3\:VSS \7\:VSS) resistor r=5.1667 c=0
Ry14 (\3\:VSS \8\:VSS) resistor r=5.1667 c=0
Ry1 (\1\:Q \2\:Q) resistor r=20.6667 c=0
Ry15 (\1\:VDD \2\:VDD) resistor r=62 c=0
Ry16 (\8\:VDD \9\:VDD) resistor r=62 c=0
Ry17 (\10\:VDD \11\:VDD) resistor r=62 c=0
Ry18 (\12\:VDD \13\:VDD) resistor r=62 c=0
Ry19 (\15\:VDD \16\:VDD) resistor r=62 c=0
Ry20 (\18\:VDD \19\:VDD) resistor r=62 c=0
Ry21 (\21\:VDD \22\:VDD) resistor r=62 c=0
Ry2 (\9\:qbint \10\:qbint) resistor r=62 c=0
Ry6 (\4\:n35 \5\:n35) resistor r=62 c=0
Ry3 (\7\:RNb \8\:RNb) resistor r=62 c=0
Ry11 (\19\:CKb \20\:CKb) resistor r=62 c=0
Ry7 (\7\:mout \8\:mout) resistor r=62 c=0
Ry8 (\12\:mout \13\:mout) resistor r=62 c=0
Ry10 (\16\:CKbb \17\:CKbb) resistor r=62 c=0
Ry9 (\5\:n20 \6\:n20) resistor r=62 c=0
Ry4 (n41 \2\:n41) resistor r=62 c=0
Ry5 (\3\:n41 \4\:n41) resistor r=62 c=0
Rx6 (\5\:SN \7\:SN) resistor r=45 c=0
Rx7 (\2\:SN \8\:SN) resistor r=45 c=0
Rx3 (\2\:RN \4\:RN) resistor r=45 c=0
Rx18 (\2\:CK \4\:CK) resistor r=45 c=0
Rx10 (\2\:D \4\:D) resistor r=45 c=0
Rx1 (\7\:qbint \8\:qbint) resistor r=45 c=0
Rx2 (qbint \14\:qbint) resistor r=45 c=0
Rx5 (\2\:n35 \7\:n35) resistor r=45 c=0
Rx4 (\2\:RNb \6\:RNb) resistor r=45 c=0
Rx14 (CKb \12\:CKb) resistor r=45 c=0
Rx15 (\6\:CKb \14\:CKb) resistor r=45 c=0
Rx16 (\8\:CKb \15\:CKb) resistor r=45 c=0
Rx17 (\11\:CKb \16\:CKb) resistor r=45 c=0
Rx8 (\3\:mout \5\:mout) resistor r=45 c=0
Rx11 (\6\:CKbb \8\:CKbb) resistor r=45 c=0
Rx12 (\2\:CKbb \11\:CKbb) resistor r=45 c=0
Rx13 (\4\:CKbb \15\:CKbb) resistor r=45 c=0
Rx9 (n20 \8\:n20) resistor r=45 c=0
mn55 (\3\:Q \3\:qbint \16\:VSS VSS) g45n1lvt w=(2.6e-07) l=4.5e-08 nf=1 \
        as=4.24e-14 ad=3.64e-14 ps=8.8e-07 pd=8e-07 nrd=1.16667 \
        nrs=1.16667 sa=1.4e-07 sb=3.83846e-07 sd=160n sca=17.5885 \
        scb=0.0172826 scc=0.00162584 m=(1)
mn45 (\12\:qbint \3\:n35 \16\:VSS VSS) g45n1lvt w=(2.05e-07) l=4.5e-08 \
        nf=1 as=4.24e-14 ad=4.817e-14 ps=8.8e-07 pd=8.8e-07 nrd=1.16667 \
        nrs=1.16667 sa=3.65e-07 sb=2.35e-07 sd=160n sca=19.867 \
        scb=0.0198061 scc=0.00201945 m=(1)
mn50 (n42 \3\:SN \14\:VSS VSS) g45n1lvt w=(2.05e-07) l=4.5e-08 nf=1 \
        as=6.255e-14 ad=3.997e-14 ps=1.19e-06 pd=8e-07 nrd=1.16667 \
        nrs=1.16667 sa=4.35976e-07 sb=6.15e-07 sd=160n sca=9.90451 \
        scb=0.00881556 scc=0.00026609 m=(1)
mn52 (\3\:n40 \5\:qbint n42 VSS) g45n1lvt w=(2.05e-07) l=4.5e-08 nf=1 \
        as=3.997e-14 ad=3.28e-14 ps=8e-07 pd=7.3e-07 nrd=1.16667 \
        nrs=1.16667 sa=6.75976e-07 sb=3.75e-07 sd=160n sca=9.90451 \
        scb=0.00881556 scc=0.00026609 m=(1)
mn51 (\3\:n40 \4\:RNb \3\:n42 VSS) g45n1lvt w=(2.05e-07) l=4.5e-08 nf=1 \
        as=3.485e-14 ad=3.28e-14 ps=7.5e-07 pd=7.3e-07 nrd=1.16667 \
        nrs=1.16667 sa=8.80976e-07 sb=1.7e-07 sd=160n sca=9.90451 \
        scb=0.00881556 scc=0.00026609 m=(1)
mn53 (\8\:n35 \3\:CKb n40 VSS) g45n1lvt w=(2.05e-07) l=4.5e-08 nf=1 \
        as=2.87e-14 ad=3.895e-14 ps=6.9e-07 pd=7.9e-07 nrd=1.16667 \
        nrs=1.16667 sa=1.4e-07 sb=4.6e-07 sd=160n sca=10.7727 \
        scb=0.0101457 scc=0.000373012 m=(1)
mn40 (\8\:n35 \3\:CKbb \10\:mout VSS) g45n1lvt w=(2.05e-07) l=4.5e-08 \
        nf=1 as=4.612e-14 ad=3.895e-14 ps=8.6e-07 pd=7.9e-07 nrd=1.16667 \
        nrs=1.16667 sa=3.75e-07 sb=2.25e-07 sd=160n sca=10.7727 \
        scb=0.0101457 scc=0.000373012 m=(1)
mn31 (\14\:mout \5\:RNb \3\:n25 VSS) g45n1lvt w=(2.05e-07) l=4.5e-08 nf=1 \
        as=4.305e-14 ad=3.28e-14 ps=8.3e-07 pd=7.3e-07 nrd=1.16667 \
        nrs=1.16667 sa=2.1e-07 sb=1.76183e-06 sd=160n sca=11.2689 \
        scb=0.0108709 scc=0.000440973 m=(1)
mn32 (\14\:mout \4\:n20 n25 VSS) g45n1lvt w=(2.05e-07) l=4.5e-08 nf=1 \
        as=5.33e-14 ad=3.28e-14 ps=9.3e-07 pd=7.3e-07 nrd=1.16667 \
        nrs=1.16667 sa=4.15e-07 sb=1.57878e-06 sd=160n sca=11.2689 \
        scb=0.0108709 scc=0.000440973 m=(1)
mn30 (n25 \6\:SN \11\:VSS VSS) g45n1lvt w=(2.05e-07) l=4.5e-08 nf=1 \
        as=6.867e-14 ad=5.33e-14 ps=1.08e-06 pd=9.3e-07 nrd=1.16667 \
        nrs=1.16667 sa=7.2e-07 sb=1.27378e-06 sd=160n sca=11.2689 \
        scb=0.0108709 scc=0.000440973 m=(1)
mn35 (n30 \4\:mout \11\:VSS VSS) g45n1lvt w=(2.05e-07) l=4.5e-08 nf=1 \
        as=6.867e-14 ad=4.407e-14 ps=1.08e-06 pd=8.4e-07 nrd=1.16667 \
        nrs=1.16667 sa=1.1e-06 sb=8.9378e-07 sd=160n sca=11.2689 \
        scb=0.0108709 scc=0.000440973 m=(1)
mn36 (\9\:n20 \7\:CKbb n30 VSS) g45n1lvt w=(2.05e-07) l=4.5e-08 nf=1 \
        as=4.407e-14 ad=5.022e-14 ps=8.4e-07 pd=9e-07 nrd=1.16667 \
        nrs=1.16667 sa=1.36e-06 sb=6.3378e-07 sd=160n sca=11.2689 \
        scb=0.0108709 scc=0.000440973 m=(1)
mn26 (\9\:n20 \7\:CKb n21 VSS) g45n1lvt w=(2.05e-07) l=4.5e-08 nf=1 \
        as=1.23e-14 ad=5.022e-14 ps=5.3e-07 pd=9e-07 nrd=1.16667 \
        nrs=1.16667 sa=1.65e-06 sb=3.4378e-07 sd=160n sca=11.2689 \
        scb=0.0108709 scc=0.000440973 m=(1)
mn25 (n21 \3\:D \9\:VSS VSS) g45n1lvt w=(2.05e-07) l=4.5e-08 nf=1 \
        as=4.17e-14 ad=1.23e-14 ps=1.02e-06 pd=5.3e-07 nrd=1.16667 \
        nrs=1.16667 sa=1.755e-06 sb=2.3878e-07 sd=160n sca=11.2689 \
        scb=0.0108709 scc=0.000440973 m=(1)
mn22 (\9\:RNb \3\:RN \14\:VSS VSS) g45n1lvt w=(1.45e-07) l=4.5e-08 nf=1 \
        as=6.255e-14 ad=2.03e-14 ps=1.19e-06 pd=5.7e-07 nrd=1.16667 \
        nrs=1.16667 sa=1.4e-07 sb=1.05e-06 sd=160n sca=8.70265 \
        scb=0.00681258 scc=0.000126945 m=(1)
mn21 (\13\:CKbb \10\:CKb \9\:VSS VSS) g45n1lvt w=(1.45e-07) l=4.5e-08 \
        nf=1 as=4.17e-14 ad=4.205e-14 ps=1.02e-06 pd=8.7e-07 nrd=1.16667 \
        nrs=1.16667 sa=7.55172e-07 sb=2.9e-07 sd=160n sca=23.279 \
        scb=0.0230742 scc=0.00267719 m=(1)
mn20 (\17\:CKb \1\:CK \1\:VSS VSS) g45n1lvt w=(1.45e-07) l=4.5e-08 nf=1 \
        as=2.61e-14 ad=3.407e-14 ps=6.5e-07 pd=7.6e-07 nrd=1.16667 \
        nrs=1.16667 sa=2.35e-07 sb=1.8e-07 sd=160n sca=23.279 \
        scb=0.0230742 scc=0.00267719 m=(1)
mp45 (\9\:qbint n35 \21\:VDD VDD) g45p1lvt w=(3.1e-07) l=4.5e-08 nf=1 \
        as=6.38e-14 ad=3.58e-14 ps=1.14e-06 pd=9e-07 nrd=1.16667 \
        nrs=1.16667 sa=3.65e-07 sb=1.15484e-07 sd=160n sca=20.482 \
        scb=0.0196227 scc=0.00140004 m=(1)
mp50 (\3\:n41 \1\:SN \18\:VDD VDD) g45p1lvt w=(3.1e-07) l=4.5e-08 nf=1 \
        as=9.23e-14 ad=6.61e-14 ps=2.13e-06 pd=1.27e-06 nrd=1.16667 \
        nrs=1.16667 sa=2.06452e-07 sb=3.44677e-07 sd=160n sca=33.4558 \
        scb=0.0229674 scc=0.00395167 m=(1)
mp52 (n43 \6\:qbint \3\:n41 VDD) g45p1lvt w=(3.1e-07) l=4.5e-08 nf=1 \
        as=6.61e-14 ad=1.86e-14 ps=1.27e-06 pd=7.4e-07 nrd=1.16667 \
        nrs=1.16667 sa=2.75242e-07 sb=2.34839e-07 sd=160n sca=14.8314 \
        scb=0.0138806 scc=0.000865287 m=(1)
mp51 (n43 \3\:RNb \15\:VDD VDD) g45p1lvt w=(3.1e-07) l=4.5e-08 nf=1 \
        as=4.865e-14 ad=1.86e-14 ps=1.33e-06 pd=7.4e-07 nrd=1.16667 \
        nrs=1.16667 sa=3.80242e-07 sb=1.29839e-07 sd=160n sca=14.8314 \
        scb=0.0138806 scc=0.000865287 m=(1)
mp53 (\4\:n35 CKbb n41 VDD) g45p1lvt w=(3.1e-07) l=4.5e-08 nf=1 \
        as=4.96e-14 ad=5.89e-14 ps=1.13e-06 pd=1e-06 nrd=1.16667 \
        nrs=1.16667 sa=1.6e-07 sb=4.9e-07 sd=160n sca=33.4558 \
        scb=0.0229674 scc=0.00395167 m=(1)
mp40 (\4\:n35 \4\:CKb \7\:mout VDD) g45p1lvt w=(3.1e-07) l=4.5e-08 nf=1 \
        as=7.905e-14 ad=5.89e-14 ps=1.13e-06 pd=1e-06 nrd=1.16667 \
        nrs=1.16667 sa=3.95e-07 sb=2.55e-07 sd=160n sca=33.4558 \
        scb=0.0229674 scc=0.00395167 m=(1)
mp31 (n26 RNb \12\:VDD VDD) g45p1lvt w=(3.1e-07) l=4.5e-08 nf=1 \
        as=8.39e-14 ad=2.79e-14 ps=1.48e-06 pd=8e-07 nrd=1.16667 \
        nrs=1.16667 sa=1.7e-07 sb=1.02282e-06 sd=160n sca=35.6995 \
        scb=0.0234062 scc=0.00420468 m=(1)
mp32 (\12\:mout \3\:n20 n26 VDD) g45p1lvt w=(3.1e-07) l=4.5e-08 nf=1 \
        as=2.79e-14 ad=8.54e-14 ps=8e-07 pd=1.54e-06 nrd=1.16667 \
        nrs=1.16667 sa=3.05e-07 sb=8.87823e-07 sd=160n sca=35.6995 \
        scb=0.0234062 scc=0.00420468 m=(1)
mp30 (\12\:mout \4\:SN \10\:VDD VDD) g45p1lvt w=(3.1e-07) l=4.5e-08 nf=1 \
        as=1.0385e-13 ad=8.54e-14 ps=1.29e-06 pd=1.54e-06 nrd=1.16667 \
        nrs=1.16667 sa=4.36774e-07 sb=1.22782e-06 sd=160n sca=13.6224 \
        scb=0.0125368 scc=0.000630866 m=(1)
mp35 (n31 mout \10\:VDD VDD) g45p1lvt w=(3.1e-07) l=4.5e-08 nf=1 \
        as=1.0385e-13 ad=4.185e-14 ps=1.29e-06 pd=8.9e-07 nrd=1.16667 \
        nrs=1.16667 sa=8.16774e-07 sb=8.47823e-07 sd=160n sca=13.6224 \
        scb=0.0125368 scc=0.000630866 m=(1)
mp36 (\5\:n20 \5\:CKb n31 VDD) g45p1lvt w=(3.1e-07) l=4.5e-08 nf=1 \
        as=4.185e-14 ad=7.26e-14 ps=8.9e-07 pd=1.19e-06 nrd=1.16667 \
        nrs=1.16667 sa=9.96774e-07 sb=6.67823e-07 sd=160n sca=13.6224 \
        scb=0.0125368 scc=0.000630866 m=(1)
mp26 (\5\:n20 \5\:CKbb n22 VDD) g45p1lvt w=(3.1e-07) l=4.5e-08 nf=1 \
        as=4.495e-14 ad=7.26e-14 ps=9.1e-07 pd=1.19e-06 nrd=1.16667 \
        nrs=1.16667 sa=1.07492e-06 sb=4.94597e-07 sd=160n sca=11.8311 \
        scb=0.0101697 scc=0.000309549 m=(1)
mp25 (n22 \1\:D \8\:VDD VDD) g45p1lvt w=(3.1e-07) l=4.5e-08 nf=1 \
        as=5.465e-14 ad=4.495e-14 ps=1.04e-06 pd=9.1e-07 nrd=1.16667 \
        nrs=1.16667 sa=1.26492e-06 sb=3.04597e-07 sd=160n sca=11.8311 \
        scb=0.0101697 scc=0.000309549 m=(1)
mp22 (\7\:RNb \1\:RN \18\:VDD VDD) g45p1lvt w=(2.15e-07) l=4.5e-08 nf=1 \
        as=9.23e-14 ad=3.95e-14 ps=2.13e-06 pd=9.3e-07 nrd=1.16667 \
        nrs=1.16667 sa=1.83721e-07 sb=2.72326e-07 sd=160n sca=42.6522 \
        scb=0.0278545 scc=0.00553378 m=(1)
mp21 (\16\:CKbb \9\:CKb \8\:VDD VDD) g45p1lvt w=(2.15e-07) l=4.5e-08 \
        nf=1 as=5.465e-14 ad=3.01e-14 ps=1.04e-06 pd=7.1e-07 nrd=1.16667 \
        nrs=1.16667 sa=1.32105e-06 sb=1.4e-07 sd=160n sca=10.4043 \
        scb=0.00779196 scc=9.84549e-05 m=(1)
mp20 (\19\:CKb \3\:CK \1\:VDD VDD) g45p1lvt w=(2.15e-07) l=4.5e-08 nf=1 \
        as=3.01e-14 ad=3.01e-14 ps=7.1e-07 pd=7.1e-07 nrd=1.16667 \
        nrs=1.16667 sa=1.4e-07 sb=1.4e-07 sd=160n sca=50.4517 scb=0.0345 \
        scc=0.00597688 m=(1)
ends DFFSRHQX1
// End of subcircuit definition.
