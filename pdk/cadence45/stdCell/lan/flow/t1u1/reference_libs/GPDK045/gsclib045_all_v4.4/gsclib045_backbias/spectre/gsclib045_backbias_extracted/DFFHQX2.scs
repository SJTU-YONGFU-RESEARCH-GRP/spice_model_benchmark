// Generated for: spectre (May  1 11:28:36 2013 )
// Library name: gsclib045_backbias
// Cell name: DFFHQX2
// View name: extracted

simulator lang=spectre

subckt DFFHQX2 CK D NW Q VDD VSS
mp20 (\22\:CKb \1\:CK \13\:VDD NW) g45p1svt w=(2.15e-07) l=4.5e-08 nf=1 \
        as=3.01e-14 ad=3.01e-14 ps=7.1e-07 pd=7.1e-07 nrd=1.16667 \
        nrs=1.16667 sa=1.4e-07 sb=1.4e-07 sd=160n sca=52.067 scb=0.0373106 \
        scc=0.00610613 m=(1)
mp21 (\13\:CKbb CKb \11\:VDD NW) g45p1svt w=(2.15e-07) l=4.5e-08 nf=1 \
        as=5.895e-14 ad=3.01e-14 ps=1.08e-06 pd=7.1e-07 nrd=1.16667 \
        nrs=1.16667 sa=1.4e-07 sb=2e-06 sd=160n sca=10.8597 scb=0.00777428 \
        scc=8.41005e-05 m=(1)
C1 (NW VSS) capacitor c=5.4972e-16
C2 (D VSS) capacitor c=5.0243e-17
C3 (VDD VSS) capacitor c=2.74145e-17
C4 (Q VSS) capacitor c=6.3355e-17
C5 (CK VSS) capacitor c=2.98281e-17
C6 (CKb VSS) capacitor c=6.1857e-17
C7 (CKbb VSS) capacitor c=4.81325e-17
C8 (n21 VSS) capacitor c=7.79438e-19
C9 (n20 VSS) capacitor c=4.08417e-17
C10 (net192 VSS) capacitor c=4.92035e-18
C11 (mout VSS) capacitor c=8.49133e-17
C12 (n30 VSS) capacitor c=2.71079e-17
C13 (net172 VSS) capacitor c=1.57933e-18
C14 (qbint VSS) capacitor c=1.72863e-16
C15 (n22 VSS) capacitor c=8.34168e-18
C16 (net147 VSS) capacitor c=3.32808e-18
C17 (net123 VSS) capacitor c=2.18543e-18
C18 (\3\:n30 VSS) capacitor c=5.37738e-17
C19 (\11\:qbint VSS) capacitor c=6.41336e-17
C20 (\4\:CKbb VSS) capacitor c=7.82009e-17
C21 (\8\:CKb VSS) capacitor c=2.80116e-17
C22 (\6\:CKb VSS) capacitor c=5.61819e-17
C23 (\3\:CKbb VSS) capacitor c=2.36264e-17
C24 (\3\:D VSS) capacitor c=5.08739e-17
C25 (\1\:CK VSS) capacitor c=2.78503e-17
C26 (\7\:qbint VSS) capacitor c=6.1296e-17
C27 (\10\:CKb VSS) capacitor c=6.71639e-17
C28 (\6\:CKbb VSS) capacitor c=4.08737e-17
C29 (\3\:n20 VSS) capacitor c=3.46995e-17
C30 (\3\:mout VSS) capacitor c=2.96267e-17
C31 (\4\:CKb VSS) capacitor c=5.11172e-17
C32 (\1\:D VSS) capacitor c=5.18683e-17
C33 (\2\:CKb VSS) capacitor c=3.48916e-17
C34 (\4\:CK VSS) capacitor c=2.34424e-17
C35 (\2\:n30 VSS) capacitor c=4.69975e-17
C36 (\11\:CKb VSS) capacitor c=4.79121e-17
C37 (\5\:CKbb VSS) capacitor c=4.85954e-17
C38 (\9\:CKb VSS) capacitor c=2.77891e-17
C39 (\2\:n20 VSS) capacitor c=3.7802e-17
C40 (\2\:mout VSS) capacitor c=5.36433e-17
C41 (\7\:CKb VSS) capacitor c=3.72744e-17
C42 (\2\:CKbb VSS) capacitor c=4.40002e-17
C43 (\5\:CKb VSS) capacitor c=3.97846e-17
C44 (\2\:D VSS) capacitor c=6.04886e-17
C45 (\3\:CKb VSS) capacitor c=1.83853e-17
C46 (\3\:CK VSS) capacitor c=1.04457e-17
C47 (\16\:qbint VSS) capacitor c=3.48474e-17
C48 (\1\:VDD VSS) capacitor c=3.02659e-16
C49 (\3\:Q VSS) capacitor c=5.68561e-17
C50 (\4\:n30 VSS) capacitor c=1.14031e-16
C51 (\8\:mout VSS) capacitor c=6.99217e-17
C52 (\9\:VDD VSS) capacitor c=3.62499e-17
C53 (\5\:n20 VSS) capacitor c=1.28236e-16
C54 (\11\:VDD VSS) capacitor c=3.18511e-17
C55 (\13\:CKbb VSS) capacitor c=2.35908e-17
C56 (\22\:CKb VSS) capacitor c=5.96888e-17
C57 (\13\:VDD VSS) capacitor c=4.82398e-17
C58 (\12\:qbint VSS) capacitor c=3.57488e-17
C59 (\1\:Q VSS) capacitor c=6.51809e-17
C60 (\7\:n30 VSS) capacitor c=3.92332e-17
C61 (\4\:mout VSS) capacitor c=5.46679e-17
C62 (\7\:n20 VSS) capacitor c=9.74757e-17
C63 (\10\:CKbb VSS) capacitor c=8.65465e-17
C64 (\17\:CKb VSS) capacitor c=6.37679e-17
C65 (\2\:CK VSS) capacitor c=9.27046e-18
C66 (\6\:qbint VSS) capacitor c=4.49316e-17
C67 (\5\:CK VSS) capacitor c=6.14497e-17
C68 (\4\:D VSS) capacitor c=7.67965e-17
C69 (\4\:n20 VSS) capacitor c=7.54808e-17
C70 (\6\:mout VSS) capacitor c=6.58002e-17
C71 (\7\:mout VSS) capacitor c=5.31975e-17
C72 (\7\:CKbb VSS) capacitor c=1.67893e-16
C73 (\8\:CKbb VSS) capacitor c=1.75126e-16
C74 (\9\:CKbb VSS) capacitor c=1.03541e-16
C75 (\12\:CKbb VSS) capacitor c=2.59358e-17
C76 (\12\:CKb VSS) capacitor c=5.34661e-17
C77 (\13\:CKb VSS) capacitor c=1.14949e-16
C78 (\14\:CKb VSS) capacitor c=2.13426e-16
C79 (\15\:CKb VSS) capacitor c=1.17547e-16
C80 (\16\:CKb VSS) capacitor c=9.29408e-17
C81 (\19\:CKb VSS) capacitor c=4.20462e-17
C82 (\20\:CKb VSS) capacitor c=4.98742e-17
C83 (\21\:CKb VSS) capacitor c=3.90768e-17
C84 (\6\:n30 VSS) capacitor c=1.48705e-16
C85 (\9\:n30 VSS) capacitor c=1.4087e-16
C86 (\14\:qbint VSS) capacitor c=3.82292e-17
C87 (\15\:qbint VSS) capacitor c=4.29003e-17
C88 (\4\:VDD VSS) capacitor c=1.31001e-16
C89 (\5\:VDD VSS) capacitor c=8.91546e-17
C90 (\6\:VDD VSS) capacitor c=4.45626e-17
Rk2 (D \4\:D) resistor r=0.05798 c=0
Rk42 (\1\:VDD \4\:VDD) resistor r=0.583 c=0
Rk43 (\4\:VDD \5\:VDD) resistor r=0.5504 c=0
Rk45 (\6\:VDD VDD) resistor r=0.05473 c=0
Rk44 (\5\:VDD \6\:VDD) resistor r=0.3156 c=0
Rk47 (\4\:VDD \10\:VDD) resistor r=0.04331 c=0
Rk48 (\5\:VDD \12\:VDD) resistor r=0.1842 c=0
Rk49 (\6\:VDD \14\:VDD) resistor r=0.4181 c=0
Rk22 (\2\:Q Q) resistor r=0.3653 c=0
Rk23 (Q \4\:Q) resistor r=0.1634 c=0
Rk32 (\1\:VSS \6\:VSS) resistor r=0.5714 c=0
Rk33 (\6\:VSS \7\:VSS) resistor r=0.3133 c=0
Rk34 (\7\:VSS \8\:VSS) resistor r=0.08758 c=0
Rk36 (\9\:VSS VSS) resistor r=0.07479 c=0
Rk35 (\8\:VSS \9\:VSS) resistor r=0.3883 c=0
Rk38 (\6\:VSS \13\:VSS) resistor r=0.3346 c=0
Rk39 (\8\:VSS \15\:VSS) resistor r=0.3342 c=0
Rk40 (\9\:VSS \17\:VSS) resistor r=0.07393 c=0
Rk1 (\5\:CK CK) resistor r=0.1128 c=0
Rk13 (\12\:CKb \13\:CKb) resistor r=0.2579 c=0
Rk14 (\13\:CKb \14\:CKb) resistor r=0.9845 c=0
Rk15 (\14\:CKb \15\:CKb) resistor r=0.688 c=0
Rk16 (\15\:CKb \16\:CKb) resistor r=0.4308 c=0
Rk17 (\16\:CKb \18\:CKb) resistor r=0.3377 c=0
Rk18 (\13\:CKb \19\:CKb) resistor r=0.1497 c=0
Rk19 (\14\:CKb \20\:CKb) resistor r=0.2518 c=0
Rk20 (\15\:CKb \21\:CKb) resistor r=0.1462 c=0
Rk21 (\18\:CKb \23\:CKb) resistor r=0.2859 c=0
Rk8 (\7\:CKbb \8\:CKbb) resistor r=1.2992 c=0
Rk9 (\8\:CKbb \9\:CKbb) resistor r=0.4755 c=0
Rk10 (\9\:CKbb \11\:CKbb) resistor r=0.4315 c=0
Rk11 (\8\:CKbb \12\:CKbb) resistor r=0.1348 c=0
Rk12 (\9\:CKbb \14\:CKbb) resistor r=0.05277 c=0
Rk3 (\4\:n20 \6\:n20) resistor r=0.5132 c=0
Rk4 (\6\:n20 \8\:n20) resistor r=0.549 c=0
Rk5 (\5\:mout \6\:mout) resistor r=0.1928 c=0
Rk6 (\6\:mout \7\:mout) resistor r=0.2403 c=0
Rk7 (\6\:mout \9\:mout) resistor r=0.2949 c=0
Rk24 (\5\:n30 \6\:n30) resistor r=0.5981 c=0
Rk25 (\6\:n30 \8\:n30) resistor r=0.2352 c=0
Rk26 (\6\:n30 \9\:n30) resistor r=0.9167 c=0
Rk27 (\13\:qbint \14\:qbint) resistor r=0.3349 c=0
Rk28 (\14\:qbint \15\:qbint) resistor r=0.1763 c=0
Rk29 (\14\:qbint \17\:qbint) resistor r=0.1769 c=0
Rl7 (\2\:D \3\:D) resistor r=110.307 c=0
Rl6 (\1\:D \2\:D) resistor r=66.7194 c=0
Rl1 (\1\:CK \2\:CK) resistor r=49.7141 c=0
Rl3 (\2\:CK \4\:CK) resistor r=34.3295 c=0
Rl2 (\2\:CK \3\:CK) resistor r=1.2666 c=0
Rl4 (CKb \2\:CKb) resistor r=226.923 c=0
Rl19 (\10\:CKb \11\:CKb) resistor r=53.079 c=0
Rl16 (\8\:CKb \9\:CKb) resistor r=35.7713 c=0
Rl11 (\6\:CKb \7\:CKb) resistor r=48.7687 c=0
Rl8 (\4\:CKb \5\:CKb) resistor r=74.2328 c=0
Rl5 (\2\:CKb \3\:CKb) resistor r=24.2328 c=0
Rl17 (\4\:CKbb \5\:CKbb) resistor r=77.4625 c=0
Rl18 (\5\:CKbb \6\:CKbb) resistor r=126.156 c=0
Rl10 (\2\:CKbb \3\:CKbb) resistor r=24.7951 c=0
Rl9 (CKbb \2\:CKbb) resistor r=161.516 c=0
Rl14 (n20 \2\:n20) resistor r=37.2302 c=0
Rl15 (\2\:n20 \3\:n20) resistor r=127.615 c=0
Rl12 (mout \2\:mout) resistor r=108.848 c=0
Rl13 (\2\:mout \3\:mout) resistor r=68.3618 c=0
Rl31 (\2\:n30 \3\:n30) resistor r=109.066 c=0
Rl30 (n30 \2\:n30) resistor r=34.2718 c=0
Rl29 (\6\:qbint \11\:qbint) resistor r=78.0797 c=0
Rl24 (\6\:qbint qbint) resistor r=112.377 c=0
Rl25 (\6\:qbint \7\:qbint) resistor r=108.849 c=0
Rz5 (\2\:Q \1\:Q) resistor r=75 c=0
Rz10 (\13\:VSS \12\:VSS) resistor r=75 c=0
Rz11 (\15\:VSS \14\:VSS) resistor r=75 c=0
Rz12 (\17\:VSS \16\:VSS) resistor r=75 c=0
Rz4 (\17\:CKb \18\:CKb) resistor r=75 c=0
Rz3 (\10\:CKbb \11\:CKbb) resistor r=75 c=0
Rz1 (\7\:n20 \8\:n20) resistor r=75 c=0
Rz2 (\4\:mout \5\:mout) resistor r=75 c=0
Rz6 (\7\:n30 \8\:n30) resistor r=75 c=0
Rz7 (\13\:qbint \12\:qbint) resistor r=75 c=0
Ry12 (\10\:VDD \9\:VDD) resistor r=62 c=0
Ry13 (\12\:VDD \11\:VDD) resistor r=62 c=0
Ry14 (\14\:VDD \13\:VDD) resistor r=62 c=0
Ry5 (\4\:Q \3\:Q) resistor r=20.6667 c=0
Ry8 (\1\:VSS \3\:VSS) resistor r=7.75 c=0
Ry9 (\7\:VSS \3\:VSS) resistor r=5.1667 c=0
Ry4 (\22\:CKb \23\:CKb) resistor r=62 c=0
Ry3 (\13\:CKbb \14\:CKbb) resistor r=62 c=0
Ry1 (\5\:n20 \6\:n20) resistor r=62 c=0
Ry2 (\8\:mout \9\:mout) resistor r=62 c=0
Ry6 (\4\:n30 \5\:n30) resistor r=31 c=0
Ry7 (\17\:qbint \16\:qbint) resistor r=31 c=0
Rx2 (\2\:D \4\:D) resistor r=45 c=0
Rx1 (\3\:CK \5\:CK) resistor r=45 c=0
Rx7 (\11\:CKb \12\:CKb) resistor r=45 c=0
Rx8 (\3\:CKb \16\:CKb) resistor r=45 c=0
Rx9 (\9\:CKb \19\:CKb) resistor r=45 c=0
Rx10 (\7\:CKb \20\:CKb) resistor r=45 c=0
Rx11 (\5\:CKb \21\:CKb) resistor r=45 c=0
Rx5 (\5\:CKbb \7\:CKbb) resistor r=45 c=0
Rx6 (\2\:CKbb \12\:CKbb) resistor r=45 c=0
Rx3 (\2\:n20 \4\:n20) resistor r=45 c=0
Rx4 (\2\:mout \7\:mout) resistor r=45 c=0
Rx12 (\2\:n30 \9\:n30) resistor r=45 c=0
Rx13 (\15\:qbint qbint) resistor r=45 c=0
mn20 (\17\:CKb \4\:CK \16\:VSS VSS) g45n1svt w=(1.45e-07) l=4.5e-08 nf=1 \
        as=4.465e-14 ad=2.03e-14 ps=1.5e-06 pd=5.7e-07 nrd=1.16667 \
        nrs=1.16667 sa=1e-07 sb=1.4e-07 sd=160n sca=23.279 scb=0.0230742 \
        scc=0.00267719 m=(1)
mn21 (\10\:CKbb \2\:CKb \14\:VSS VSS) g45n1svt w=(1.45e-07) l=4.5e-08 \
        nf=1 as=5.407e-14 ad=2.32e-14 ps=1.04e-06 pd=6.1e-07 nrd=1.16667 \
        nrs=1.16667 sa=1.6e-07 sb=2e-06 sd=160n sca=23.279 scb=0.0230742 \
        scc=0.00267719 m=(1)
mn25 (n21 \1\:D \14\:VSS VSS) g45n1svt w=(2.05e-07) l=4.5e-08 nf=1 \
        as=5.407e-14 ad=1.435e-14 ps=1.04e-06 pd=5.5e-07 nrd=1.16667 \
        nrs=1.16667 sa=4.0878e-07 sb=2e-06 sd=160n sca=19.867 \
        scb=0.0198061 scc=0.00201945 m=(1)
mn26 (\7\:n20 \4\:CKb n21 VSS) g45n1svt w=(2.05e-07) l=4.5e-08 nf=1 \
        as=1.435e-14 ad=4.51e-14 ps=5.5e-07 pd=8.5e-07 nrd=1.16667 \
        nrs=1.16667 sa=5.2378e-07 sb=2e-06 sd=160n sca=19.867 \
        scb=0.0198061 scc=0.00201945 m=(1)
mn36 (\7\:n20 CKbb net192 VSS) g45n1svt w=(2.05e-07) l=4.5e-08 nf=1 \
        as=4.715e-14 ad=4.51e-14 ps=8.7e-07 pd=8.5e-07 nrd=1.16667 \
        nrs=1.16667 sa=7.8878e-07 sb=2e-06 sd=160n sca=19.867 \
        scb=0.0198061 scc=0.00201945 m=(1)
mn35 (net192 \3\:mout \12\:VSS VSS) g45n1svt w=(2.05e-07) l=4.5e-08 nf=1 \
        as=5.638e-14 ad=4.715e-14 ps=9.6e-07 pd=8.7e-07 nrd=1.16667 \
        nrs=1.16667 sa=1.06378e-06 sb=2e-06 sd=160n sca=19.867 \
        scb=0.0198061 scc=0.00201945 m=(1)
mn30 (\4\:mout \3\:n20 \12\:VSS VSS) g45n1svt w=(2.05e-07) l=4.5e-08 \
        nf=1 as=5.638e-14 ad=9.533e-14 ps=9.6e-07 pd=1.34e-06 nrd=1.16667 \
        nrs=1.16667 sa=1.38378e-06 sb=1.835e-06 sd=160n sca=19.867 \
        scb=0.0198061 scc=0.00201945 m=(1)
mn40 (\4\:mout \6\:CKbb \7\:n30 VSS) g45n1svt w=(2.05e-07) l=4.5e-08 nf=1 \
        as=3.28e-14 ad=9.533e-14 ps=7.3e-07 pd=1.34e-06 nrd=1.16667 \
        nrs=1.16667 sa=1.89024e-06 sb=1.325e-06 sd=160n sca=19.867 \
        scb=0.0198061 scc=0.00201945 m=(1)
mn51 (\7\:n30 \10\:CKb net172 VSS) g45n1svt w=(2.05e-07) l=4.5e-08 nf=1 \
        as=1.23e-14 ad=3.28e-14 ps=5.3e-07 pd=7.3e-07 nrd=1.16667 \
        nrs=1.16667 sa=1.95024e-06 sb=1.12e-06 sd=160n sca=19.867 \
        scb=0.0198061 scc=0.00201945 m=(1)
mn50 (net172 \7\:qbint \1\:VSS VSS) g45n1svt w=(2.05e-07) l=4.5e-08 nf=1 \
        as=6.803e-14 ad=1.23e-14 ps=1.13e-06 pd=5.3e-07 nrd=1.16667 \
        nrs=1.16667 sa=1.98098e-06 sb=1.015e-06 sd=160n sca=19.867 \
        scb=0.0198061 scc=0.00201945 m=(1)
mn45 (\12\:qbint n30 \1\:VSS VSS) g45n1svt w=(2.05e-07) l=4.5e-08 nf=1 \
        as=5.777e-14 ad=2.87e-14 ps=1.03e-06 pd=6.9e-07 nrd=1.16667 \
        nrs=1.16667 sa=2e-06 sb=1.4e-07 sd=160n sca=19.867 scb=0.0198061 \
        scc=0.00201945 m=(1)
mn55 (\1\:Q qbint \1\:VSS VSS) g45n1svt w=(2.6e-07) l=4.5e-08 nf=1 \
        as=6.29e-14 ad=4.68e-14 ps=1.08e-06 pd=8.8e-07 nrd=1.16667 \
        nrs=1.16667 sa=1.59808e-06 sb=5.93077e-07 sd=160n sca=17.5885 \
        scb=0.0172826 scc=0.00162584 m=(2)
mp25 (n22 \3\:D \11\:VDD NW) g45p1svt w=(3.1e-07) l=4.5e-08 nf=1 \
        as=5.895e-14 ad=8.06e-14 ps=1.08e-06 pd=1.14e-06 nrd=1.16667 \
        nrs=1.16667 sa=3.18468e-07 sb=2e-06 sd=160n sca=10.6008 \
        scb=0.00822388 scc=0.000121216 m=(1)
mp26 (\5\:n20 \3\:CKbb n22 NW) g45p1svt w=(3.1e-07) l=4.5e-08 nf=1 \
        as=8.06e-14 ad=1.023e-13 ps=1.14e-06 pd=1.28e-06 nrd=1.16667 \
        nrs=1.16667 sa=6.23468e-07 sb=2e-06 sd=160n sca=10.6008 \
        scb=0.00822388 scc=0.000121216 m=(1)
mp36 (\5\:n20 \6\:CKb net147 NW) g45p1svt w=(3.1e-07) l=4.5e-08 nf=1 \
        as=2.17e-14 ad=1.023e-13 ps=7.6e-07 pd=1.28e-06 nrd=1.16667 \
        nrs=1.16667 sa=9.98468e-07 sb=1.96387e-06 sd=160n sca=10.6008 \
        scb=0.00822388 scc=0.000121216 m=(1)
mp35 (net147 mout \9\:VDD NW) g45p1svt w=(3.1e-07) l=4.5e-08 nf=1 \
        as=8.8e-14 ad=2.17e-14 ps=1.39e-06 pd=7.6e-07 nrd=1.16667 \
        nrs=1.16667 sa=1.11347e-06 sb=1.91935e-06 sd=160n sca=10.6008 \
        scb=0.00822388 scc=0.000121216 m=(1)
mp30 (\8\:mout n20 \9\:VDD NW) g45p1svt w=(3.1e-07) l=4.5e-08 nf=1 \
        as=8.8e-14 ad=8.835e-14 ps=1.39e-06 pd=1.19e-06 nrd=1.16667 \
        nrs=1.16667 sa=1.37847e-06 sb=1.65435e-06 sd=160n sca=10.6008 \
        scb=0.00822388 scc=0.000121216 m=(1)
mp40 (\8\:mout \8\:CKb \4\:n30 NW) g45p1svt w=(3.1e-07) l=4.5e-08 nf=1 \
        as=1.054e-13 ad=8.835e-14 ps=1.3e-06 pd=1.19e-06 nrd=1.16667 \
        nrs=1.16667 sa=1.70847e-06 sb=1.32435e-06 sd=160n sca=10.6008 \
        scb=0.00822388 scc=0.000121216 m=(1)
mp51 (\4\:n30 \4\:CKbb net123 NW) g45p1svt w=(3.1e-07) l=4.5e-08 nf=1 \
        as=1.86e-14 ad=1.054e-13 ps=7.4e-07 pd=1.3e-06 nrd=1.16667 \
        nrs=1.16667 sa=1.96169e-06 sb=9.39355e-07 sd=160n sca=10.6008 \
        scb=0.00822388 scc=0.000121216 m=(1)
mp50 (net123 \11\:qbint \1\:VDD NW) g45p1svt w=(3.1e-07) l=4.5e-08 nf=1 \
        as=9.49e-14 ad=1.86e-14 ps=1.32e-06 pd=7.4e-07 nrd=1.16667 \
        nrs=1.16667 sa=1.99387e-06 sb=8.34355e-07 sd=160n sca=10.6008 \
        scb=0.00822388 scc=0.000121216 m=(1)
mp45 (\16\:qbint \3\:n30 \1\:VDD NW) g45p1svt w=(3.1e-07) l=4.5e-08 nf=1 \
        as=7.01e-14 ad=4.34e-14 ps=1.16e-06 pd=9e-07 nrd=1.16667 \
        nrs=1.16667 sa=1.63355e-06 sb=1.4e-07 sd=160n sca=16.7687 \
        scb=0.0168289 scc=0.000420091 m=(1)
mp55_1__rcx (\3\:Q qbint \1\:VDD NW) g45p1svt w=(3.9e-07) l=4.5e-08 nf=1 \
        as=8.25e-14 ad=6.24e-14 ps=1.24e-06 pd=1.1e-06 nrd=1.16667 \
        nrs=1.16667 sa=1.61846e-06 sb=5.31795e-07 sd=160n sca=12.0426 \
        scb=0.00999671 scc=0.000274125 m=(2)
ends DFFHQX2
// End of subcircuit definition.
