// Generated for: spectre (May  1 11:33:20 2013 )
// Library name: gsclib045_backbias
// Cell name: TLATNCAX6
// View name: extracted

simulator lang=spectre

subckt TLATNCAX6 CK E ECK NW VDD VSS
mp0 (\15\:CKb \1\:CK \19\:VDD NW) g45p1svt w=(2.15e-07) l=4.5e-08 nf=1 \
        as=3.44e-14 ad=3.01e-14 ps=7.5e-07 pd=7.1e-07 nrd=1.16667 \
        nrs=1.16667 sa=1.4e-07 sb=1.225e-06 sd=160n sca=14.9821 \
        scb=0.0138226 scc=0.000350725 m=(1)
mp5 (net217 \1\:E \19\:VDD NW) g45p1svt w=(2.15e-07) l=4.5e-08 nf=1 \
        as=3.44e-14 ad=3.762e-14 ps=7.5e-07 pd=7.8e-07 nrd=1.16667 \
        nrs=1.16667 sa=3.45e-07 sb=1.02e-06 sd=160n sca=13.1118 \
        scb=0.0113121 scc=0.000332541 m=(1)
mp6 (\6\:n0 \3\:CKbb net217 NW) g45p1svt w=(2.15e-07) l=4.5e-08 nf=1 \
        as=3.762e-14 ad=3.44e-14 ps=7.8e-07 pd=7.5e-07 nrd=1.16667 \
        nrs=1.16667 sa=5.65e-07 sb=8e-07 sd=160n sca=12.3059 scb=0.0108395 \
        scc=0.000332115 m=(1)
mp16 (\6\:n0 \3\:CKb net205 NW) g45p1svt w=(2.15e-07) l=4.5e-08 nf=1 \
        as=3.118e-14 ad=3.44e-14 ps=7.2e-07 pd=7.5e-07 nrd=1.16667 \
        nrs=1.16667 sa=7.7e-07 sb=5.95e-07 sd=160n sca=12.1244 \
        scb=0.0107968 scc=0.000332109 m=(1)
mp15 (net205 \3\:Eint \17\:VDD NW) g45p1svt w=(2.15e-07) l=4.5e-08 nf=1 \
        as=8.63e-14 ad=3.118e-14 ps=1.52e-06 pd=7.2e-07 nrd=1.16667 \
        nrs=1.16667 sa=9.6e-07 sb=4.05e-07 sd=160n sca=12.1244 \
        scb=0.0107968 scc=0.000332109 m=(1)
mp1 (\10\:CKbb \5\:CKb \17\:VDD NW) g45p1svt w=(2.15e-07) l=4.5e-08 nf=1 \
        as=8.63e-14 ad=3.01e-14 ps=1.52e-06 pd=7.1e-07 nrd=1.16667 \
        nrs=1.16667 sa=1.225e-06 sb=1.4e-07 sd=160n sca=12.1244 \
        scb=0.0107968 scc=0.000332109 m=(1)
C1 (CK VSS) capacitor c=3.32117e-17
C2 (NW VSS) capacitor c=5.63029e-16
C3 (VDD VSS) capacitor c=4.60271e-17
C4 (ECK VSS) capacitor c=5.18498e-16
C5 (E VSS) capacitor c=8.82598e-17
C6 (CKb VSS) capacitor c=5.46301e-17
C7 (net254 VSS) capacitor c=1.62207e-18
C8 (n0 VSS) capacitor c=5.30277e-17
C9 (CKbb VSS) capacitor c=3.00693e-17
C10 (Eint VSS) capacitor c=5.73069e-17
C11 (16 VSS) capacitor c=1.85061e-18
C12 (ECKb VSS) capacitor c=2.83656e-16
C13 (17 VSS) capacitor c=2.06853e-18
C14 (net217 VSS) capacitor c=2.37411e-18
C15 (net205 VSS) capacitor c=2.10638e-18
C16 (\3\:n0 VSS) capacitor c=4.52477e-17
C17 (\5\:CKb VSS) capacitor c=6.25273e-17
C18 (\3\:Eint VSS) capacitor c=4.98901e-17
C19 (\3\:CKb VSS) capacitor c=4.85937e-17
C20 (\3\:CKbb VSS) capacitor c=7.54592e-17
C21 (\1\:E VSS) capacitor c=3.15158e-17
C22 (\1\:CK VSS) capacitor c=3.9071e-17
C23 (\10\:Eint VSS) capacitor c=7.76803e-17
C24 (\4\:CKbb VSS) capacitor c=5.01042e-17
C25 (\9\:CKbb VSS) capacitor c=4.3543e-17
C26 (\5\:Eint VSS) capacitor c=6.84359e-17
C27 (\6\:CKb VSS) capacitor c=4.36052e-17
C28 (\3\:E VSS) capacitor c=7.47316e-17
C29 (\3\:CK VSS) capacitor c=3.4925e-17
C30 (\8\:ECKb VSS) capacitor c=2.49707e-17
C31 (\6\:Eint VSS) capacitor c=4.02058e-16
C32 (\2\:n0 VSS) capacitor c=3.80802e-17
C33 (\7\:CKb VSS) capacitor c=2.12574e-17
C34 (\4\:Eint VSS) capacitor c=2.63984e-17
C35 (\2\:CKbb VSS) capacitor c=6.16171e-17
C36 (\4\:CKb VSS) capacitor c=4.67195e-17
C37 (\2\:CKb VSS) capacitor c=2.78802e-17
C38 (\2\:E VSS) capacitor c=4.47339e-17
C39 (\2\:CK VSS) capacitor c=3.60503e-17
C40 (\1\:VDD VSS) capacitor c=5.18026e-16
C41 (\18\:ECKb VSS) capacitor c=1.9371e-16
C42 (\13\:VDD VSS) capacitor c=4.52249e-17
C43 (\18\:Eint VSS) capacitor c=2.93994e-17
C44 (\10\:CKbb VSS) capacitor c=8.97697e-17
C45 (\17\:VDD VSS) capacitor c=1.92286e-17
C46 (\6\:n0 VSS) capacitor c=2.14211e-16
C47 (\19\:VDD VSS) capacitor c=5.47538e-17
C48 (\15\:CKb VSS) capacitor c=7.18442e-17
C49 (\25\:ECKb VSS) capacitor c=6.55413e-17
C50 (\14\:Eint VSS) capacitor c=3.91693e-17
C51 (\13\:CKbb VSS) capacitor c=1.50074e-16
C52 (\4\:n0 VSS) capacitor c=9.4807e-17
C53 (\11\:CKb VSS) capacitor c=8.84489e-17
C54 (\2\:Eint VSS) capacitor c=3.78941e-17
C55 (\5\:CKbb VSS) capacitor c=1.4451e-16
C56 (\4\:CK VSS) capacitor c=7.89832e-17
C57 (\4\:E VSS) capacitor c=4.09632e-17
C58 (\8\:CKb VSS) capacitor c=8.86134e-17
C59 (\9\:CKb VSS) capacitor c=7.80087e-17
C60 (\10\:CKb VSS) capacitor c=5.06266e-17
C61 (\13\:CKb VSS) capacitor c=6.19289e-17
C62 (\14\:CKb VSS) capacitor c=3.52018e-17
C63 (\8\:n0 VSS) capacitor c=1.31815e-16
C64 (\12\:CKbb VSS) capacitor c=1.20376e-16
C65 (\15\:CKbb VSS) capacitor c=1.46108e-16
C66 (\13\:Eint VSS) capacitor c=2.84056e-17
C67 (\16\:Eint VSS) capacitor c=4.34237e-17
C68 (\17\:Eint VSS) capacitor c=7.80449e-17
C69 (\24\:ECKb VSS) capacitor c=8.78224e-17
C70 (\7\:VDD VSS) capacitor c=8.34359e-17
C71 (\8\:VDD VSS) capacitor c=7.46835e-17
Rk1 (\4\:CK CK) resistor r=0.06253 c=0
Rk38 (\1\:VDD \7\:VDD) resistor r=0.4098 c=0
Rk40 (\8\:VDD VDD) resistor r=0.2277 c=0
Rk39 (\7\:VDD \8\:VDD) resistor r=0.4248 c=0
Rk43 (\1\:VDD \14\:VDD) resistor r=0.2503 c=0
Rk45 (\7\:VDD \18\:VDD) resistor r=0.04329 c=0
Rk46 (\8\:VDD \20\:VDD) resistor r=0.2983 c=0
Rk2 (\4\:E E) resistor r=0.03231 c=0
Rk50 (\1\:VSS \7\:VSS) resistor r=0.2954 c=0
Rk51 (\7\:VSS \8\:VSS) resistor r=0.5336 c=0
Rk52 (\8\:VSS \9\:VSS) resistor r=0.09006 c=0
Rk54 (\10\:VSS VSS) resistor r=0.2152 c=0
Rk53 (\9\:VSS \10\:VSS) resistor r=0.3357 c=0
Rk57 (\7\:VSS \16\:VSS) resistor r=0.2504 c=0
Rk58 (\8\:VSS \18\:VSS) resistor r=0.07369 c=0
Rk59 (\10\:VSS \20\:VSS) resistor r=0.07369 c=0
Rk3 (\8\:CKb \9\:CKb) resistor r=0.3969 c=0
Rk4 (\9\:CKb \10\:CKb) resistor r=0.371 c=0
Rk5 (\10\:CKb \12\:CKb) resistor r=0.286 c=0
Rk6 (\9\:CKb \13\:CKb) resistor r=0.3772 c=0
Rk7 (\10\:CKb \14\:CKb) resistor r=0.1307 c=0
Rk8 (\12\:CKb \16\:CKb) resistor r=0.6733 c=0
Rk9 (\5\:n0 \7\:n0) resistor r=0.4581 c=0
Rk10 (\7\:n0 \8\:n0) resistor r=1.223 c=0
Rk11 (\11\:CKbb \12\:CKbb) resistor r=0.576 c=0
Rk12 (\12\:CKbb \14\:CKbb) resistor r=0.4481 c=0
Rk13 (\14\:CKbb \15\:CKbb) resistor r=0.9734 c=0
Rk15 (\6\:Eint \13\:Eint) resistor r=0.2725 c=0
Rk16 (\13\:Eint \15\:Eint) resistor r=0.1276 c=0
Rk17 (\13\:Eint \16\:Eint) resistor r=0.1282 c=0
Rk18 (\16\:Eint \17\:Eint) resistor r=0.4083 c=0
Rk19 (\16\:Eint \19\:Eint) resistor r=0.127 c=0
Rk23 (\18\:ECKb \24\:ECKb) resistor r=0.422 c=0
Rk24 (\24\:ECKb \26\:ECKb) resistor r=0.4254 c=0
Rl1 (\1\:CK \2\:CK) resistor r=86.5385 c=0
Rl2 (\2\:CK \3\:CK) resistor r=58.7912 c=0
Rl3 (\1\:E \2\:E) resistor r=30.7692 c=0
Rl4 (\2\:E \3\:E) resistor r=114.56 c=0
Rl12 (\5\:CKb \6\:CKb) resistor r=167.678 c=0
Rl13 (\6\:CKb \7\:CKb) resistor r=29.5379 c=0
Rl6 (\3\:CKb \4\:CKb) resistor r=44.9225 c=0
Rl5 (CKb \2\:CKb) resistor r=29.5379 c=0
Rl15 (\2\:n0 \3\:n0) resistor r=26.3736 c=0
Rl14 (n0 \2\:n0) resistor r=96.1538 c=0
Rl8 (\2\:CKbb \3\:CKbb) resistor r=201.466 c=0
Rl7 (\2\:CKbb CKbb) resistor r=24.7951 c=0
Rl18 (\5\:CKbb \4\:CKbb) resistor r=65.3625 c=0
Rl22 (\5\:CKbb \9\:CKbb) resistor r=24.7951 c=0
Rl24 (\6\:Eint \10\:Eint) resistor r=91.4835 c=0
Rl16 (\6\:Eint \5\:Eint) resistor r=71.131 c=0
Rl10 (\2\:Eint \3\:Eint) resistor r=84.125 c=0
Rl9 (\2\:Eint Eint) resistor r=74.4619 c=0
Rl11 (\2\:Eint \4\:Eint) resistor r=4.5402 c=0
Rl31 (ECKb \8\:ECKb) resistor r=3.3229 c=0
Rz12 (\16\:VSS \15\:VSS) resistor r=75 c=0
Rz13 (\18\:VSS \17\:VSS) resistor r=75 c=0
Rz14 (\20\:VSS \19\:VSS) resistor r=75 c=0
Rz1 (\11\:CKb \12\:CKb) resistor r=75 c=0
Rz2 (\4\:n0 \5\:n0) resistor r=75 c=0
Rz3 (\14\:CKbb \13\:CKbb) resistor r=75 c=0
Rz4 (\15\:Eint \14\:Eint) resistor r=75 c=0
Rz5 (\26\:ECKb \25\:ECKb) resistor r=75 c=0
Ry15 (\14\:VDD \13\:VDD) resistor r=62 c=0
Ry17 (\18\:VDD \17\:VDD) resistor r=62 c=0
Ry18 (\20\:VDD \19\:VDD) resistor r=62 c=0
Ry19 (\1\:VSS \4\:VSS) resistor r=6.2 c=0
Ry20 (\9\:VSS \4\:VSS) resistor r=5.1667 c=0
Ry1 (\15\:CKb \16\:CKb) resistor r=62 c=0
Ry2 (\6\:n0 \7\:n0) resistor r=62 c=0
Ry3 (\11\:CKbb \10\:CKbb) resistor r=62 c=0
Ry4 (\19\:Eint \18\:Eint) resistor r=62 c=0
Rx1 (\2\:CK \4\:CK) resistor r=45 c=0
Rx2 (\2\:E \4\:E) resistor r=45 c=0
Rx3 (\4\:CKb \8\:CKb) resistor r=45 c=0
Rx4 (\7\:CKb \13\:CKb) resistor r=45 c=0
Rx5 (\2\:CKb \14\:CKb) resistor r=45 c=0
Rx6 (\2\:n0 \8\:n0) resistor r=45 c=0
Rx7 (\12\:CKbb \2\:CKbb) resistor r=45 c=0
Rx8 (\15\:CKbb \5\:CKbb) resistor r=45 c=0
Rx11 (\17\:Eint \4\:Eint) resistor r=45 c=0
Rx12 (\24\:ECKb \8\:ECKb) resistor r=45 c=0
mn0 (\11\:CKb \3\:CK \19\:VSS VSS) g45n1svt w=(1.45e-07) l=4.5e-08 nf=1 \
        as=5.285e-14 ad=2.03e-14 ps=1.6e-06 pd=5.7e-07 nrd=1.16667 \
        nrs=1.16667 sa=1.4e-07 sb=1.34e-06 sd=160n sca=21.4614 \
        scb=0.0218523 scc=0.00230065 m=(1)
mn5 (net254 \3\:E \19\:VSS VSS) g45n1svt w=(1.45e-07) l=4.5e-08 nf=1 \
        as=5.285e-14 ad=8.7e-15 ps=1.6e-06 pd=4.1e-07 nrd=1.16667 \
        nrs=1.16667 sa=3.45e-07 sb=1.135e-06 sd=160n sca=21.4614 \
        scb=0.0218523 scc=0.00230065 m=(1)
mn6 (\4\:n0 CKb net254 VSS) g45n1svt w=(1.45e-07) l=4.5e-08 nf=1 \
        as=8.7e-15 ad=6.307e-14 ps=4.1e-07 pd=1.16e-06 nrd=1.16667 \
        nrs=1.16667 sa=4.5e-07 sb=1.03e-06 sd=160n sca=21.4614 \
        scb=0.0218523 scc=0.00230065 m=(1)
mn16 (\4\:n0 CKbb net230 VSS) g45n1svt w=(1.45e-07) l=4.5e-08 nf=1 \
        as=1.667e-14 ad=6.307e-14 ps=5.2e-07 pd=1.16e-06 nrd=1.16667 \
        nrs=1.16667 sa=9.3e-07 sb=5.5e-07 sd=160n sca=21.4614 \
        scb=0.0218523 scc=0.00230065 m=(1)
mn15 (net230 Eint \17\:VSS VSS) g45n1svt w=(1.45e-07) l=4.5e-08 nf=1 \
        as=5.5e-14 ad=1.667e-14 ps=1.64e-06 pd=5.2e-07 nrd=1.16667 \
        nrs=1.16667 sa=1.09e-06 sb=3.9e-07 sd=160n sca=21.4614 \
        scb=0.0218523 scc=0.00230065 m=(1)
mn1 (\13\:CKbb \6\:CKb \17\:VSS VSS) g45n1svt w=(1.45e-07) l=4.5e-08 \
        nf=1 as=5.5e-14 ad=2.827e-14 ps=1.64e-06 pd=6.8e-07 nrd=1.16667 \
        nrs=1.16667 sa=1.285e-06 sb=1.95e-07 sd=160n sca=21.4614 \
        scb=0.0218523 scc=0.00230065 m=(1)
mn10 (\14\:Eint n0 \15\:VSS VSS) g45n1svt w=(2.05e-07) l=4.5e-08 nf=1 \
        as=5.69e-14 ad=4.817e-14 ps=1e-06 pd=8.8e-07 nrd=1.16667 \
        nrs=1.16667 sa=2.35e-07 sb=1.915e-06 sd=160n sca=14.2182 \
        scb=0.0146528 scc=0.000922757 m=(1)
mn20_1__rcx (16 \5\:Eint \15\:VSS VSS) g45n1svt w=(2.6e-07) l=4.5e-08 \
        nf=1 as=5.69e-14 ad=1.56e-14 ps=1e-06 pd=6.4e-07 nrd=1.16667 \
        nrs=1.16667 sa=4.39615e-07 sb=1.63e-06 sd=160n sca=12.8392 \
        scb=0.0126987 scc=0.00074151 m=(1)
mn21_1__rcx (\25\:ECKb \9\:CKbb 16 VSS) g45n1svt w=(2.6e-07) l=4.5e-08 \
        nf=1 as=1.56e-14 ad=4.16e-14 ps=6.4e-07 pd=8.4e-07 nrd=1.16667 \
        nrs=1.16667 sa=5.44615e-07 sb=1.525e-06 sd=160n sca=12.8392 \
        scb=0.0126987 scc=0.00074151 m=(1)
mn21 (\25\:ECKb \4\:CKbb 17 VSS) g45n1svt w=(2.6e-07) l=4.5e-08 nf=1 \
        as=1.56e-14 ad=4.16e-14 ps=6.4e-07 pd=8.4e-07 nrd=1.16667 \
        nrs=1.16667 sa=7.49615e-07 sb=1.32e-06 sd=160n sca=12.8392 \
        scb=0.0126987 scc=0.00074151 m=(1)
mn20 (17 \10\:Eint \1\:VSS VSS) g45n1svt w=(2.6e-07) l=4.5e-08 nf=1 \
        as=5.44e-14 ad=1.56e-14 ps=1e-06 pd=6.4e-07 nrd=1.16667 \
        nrs=1.16667 sa=8.54615e-07 sb=1.215e-06 sd=160n sca=12.8392 \
        scb=0.0126987 scc=0.00074151 m=(1)
mn22_1__rcx (ECK ECKb \1\:VSS VSS) g45n1svt w=(3.1e-07) l=4.5e-08 nf=1 \
        as=5.056e-14 ad=5.084e-14 ps=9.52e-07 pd=9.48e-07 nrd=1.16667 \
        nrs=1.16667 sa=9.3e-07 sb=9.8e-07 sd=160n sca=15.9751 \
        scb=0.0153507 scc=0.00137372 m=(5)
mp10 (\18\:Eint \3\:n0 \1\:VDD NW) g45p1svt w=(3.1e-07) l=4.5e-08 nf=1 \
        as=7.695e-14 ad=5.89e-14 ps=1.73e-06 pd=1e-06 nrd=1.16667 \
        nrs=1.16667 sa=1.9e-07 sb=1.99e-06 sd=160n sca=16.415 \
        scb=0.0153923 scc=0.00118075 m=(1)
mp20 (\18\:ECKb \6\:Eint \1\:VDD NW) g45p1svt w=(3.9e-07) l=4.5e-08 nf=1 \
        as=7.367e-14 ad=6.435e-14 ps=1.495e-06 pd=1.11e-06 nrd=1.16667 \
        nrs=1.16667 sa=3.30513e-07 sb=1.79e-06 sd=160n sca=15.0636 \
        scb=0.0136086 scc=0.000948136 m=(2)
mp21_1__rcx (\18\:ECKb \5\:CKbb \13\:VDD NW) g45p1svt w=(3.9e-07) \
        l=4.5e-08 nf=1 as=6.24e-14 ad=6.435e-14 ps=1.1e-06 pd=1.11e-06 \
        nrd=1.16667 nrs=1.16667 sa=5.45513e-07 sb=1.575e-06 sd=160n \
        sca=15.0636 scb=0.0136086 scc=0.000948136 m=(2)
mp22_1__rcx (ECK ECKb \1\:VDD NW) g45p1svt w=(4.7e-07) l=4.5e-08 nf=1 \
        as=7.424e-14 ad=7.332e-14 ps=1.26e-06 pd=1.252e-06 nrd=1.16667 \
        nrs=1.16667 sa=9.8e-07 sb=9.6e-07 sd=160n sca=24.1706 \
        scb=0.0172692 scc=0.00246758 m=(5)
ends TLATNCAX6
// End of subcircuit definition.
