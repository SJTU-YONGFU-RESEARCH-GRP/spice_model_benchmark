// gsclib045_backbias/AO21X1/schematic

simulator lang=spectre

subckt AO21X1 A0 A1 B0 Y NW VSS VDD
mn1 (net049 A1 net104 VSS) g45n1svt w=(145n) l=45n nf=1 m=(1)
mn0 (net104 A0 VSS VSS) g45n1svt w=(145n) l=45n nf=1 m=(1)
mn3 (Y net049 VSS VSS) g45n1svt w=(260n) l=45n nf=1 m=(1)
mn2 (net049 B0 VSS VSS) g45n1svt w=(145n) l=45n nf=1 m=(1)
mp1 (net96 A1 VDD NW) g45p1svt w=(215n) l=45n nf=1 m=(1)
mp0 (net96 A0 VDD NW) g45p1svt w=(215n) l=45n nf=1 m=(1)
mp3 (Y net049 VDD NW) g45p1svt w=(390n) l=45n nf=1 m=(1)
mp2 (net049 B0 net96 NW) g45p1svt w=(215n) l=45n nf=1 m=(1)
ends AO21X1
