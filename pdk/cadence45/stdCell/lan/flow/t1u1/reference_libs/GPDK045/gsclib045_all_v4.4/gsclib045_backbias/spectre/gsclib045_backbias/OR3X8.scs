// gsclib045_backbias/OR3X8/schematic

simulator lang=spectre

subckt OR3X8 A B C Y VDD NW VSS
mn3 (Y n0 VSS VSS) g45n1svt w=(2.065u) l=45n nf=1 m=(1)
mn0 (n0 A VSS VSS) g45n1svt w=(520n) l=45n nf=1 m=(1)
mn1 (n0 B VSS VSS) g45n1svt w=(520n) l=45n nf=1 m=(1)
mn2 (n0 C VSS VSS) g45n1svt w=(520n) l=45n nf=1 m=(1)
mp3 (Y n0 VDD NW) g45p1svt w=(3.115u) l=45n nf=1 m=(1)
mp1 (n2 B n1 NW) g45p1svt w=(780n) l=45n nf=1 m=(1)
mp2 (n0 C n2 NW) g45p1svt w=(780n) l=45n nf=1 m=(1)
mp0 (n1 A VDD NW) g45p1svt w=(780n) l=45n nf=1 m=(1)
ends OR3X8
