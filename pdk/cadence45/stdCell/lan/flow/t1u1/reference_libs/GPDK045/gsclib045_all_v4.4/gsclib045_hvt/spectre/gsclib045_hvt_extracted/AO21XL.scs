// Generated for: spectre (May  1 09:12:29 2013 )
// Library name: gsclib045_hvt
// Cell name: AO21XL
// View name: extracted

simulator lang=spectre

subckt AO21XL A0 A1 B0 VDD VSS Y
mp0 (n2 \4\:A0 \6\:VDD VDD) g45p1hvt w=(2.15e-07) l=4.5e-08 nf=1 \
        as=3.44e-14 ad=3.01e-14 ps=7.5e-07 pd=7.1e-07 nrd=1.16667 \
        nrs=1.16667 sa=1.4e-07 sb=6.6e-07 sd=160n sca=20.0513 \
        scb=0.0219943 scc=0.000769518 m=(1)
mp1 (\3\:n2 \1\:A1 \6\:VDD VDD) g45p1hvt w=(2.15e-07) l=4.5e-08 nf=1 \
        as=3.44e-14 ad=3.44e-14 ps=7.5e-07 pd=7.5e-07 nrd=1.16667 \
        nrs=1.16667 sa=3.45e-07 sb=4.55e-07 sd=160n sca=13.262 \
        scb=0.0108178 scc=0.00011707 m=(1)
mp2 (\4\:n0 \3\:B0 \3\:n2 VDD) g45p1hvt w=(2.15e-07) l=4.5e-08 nf=1 \
        as=3.44e-14 ad=5.375e-14 ps=7.5e-07 pd=9.3e-07 nrd=1.16667 \
        nrs=1.16667 sa=5.5e-07 sb=2.5e-07 sd=160n sca=11.9601 \
        scb=0.00852872 scc=9.89728e-05 m=(1)
mp3 (\1\:Y n0 \1\:VDD VDD) g45p1hvt w=(2.15e-07) l=4.5e-08 nf=1 \
        as=4.44e-14 ad=3.01e-14 ps=1.35e-06 pd=7.1e-07 nrd=1.16667 \
        nrs=1.16667 sa=1e-07 sb=1.4e-07 sd=160n sca=54.2014 scb=0.040719 \
        scc=0.00636357 m=(1)
C1 (B0 VSS) capacitor c=5.89732e-17
C2 (Y VSS) capacitor c=3.61469e-17
C3 (A1 VSS) capacitor c=6.83626e-17
C4 (VDD VSS) capacitor c=1.32332e-16
C5 (A0 VSS) capacitor c=8.58403e-17
C6 (n0 VSS) capacitor c=3.5474e-17
C7 (n2 VSS) capacitor c=5.71238e-17
C8 (\3\:B0 VSS) capacitor c=5.10734e-17
C9 (\1\:A1 VSS) capacitor c=6.85758e-17
C10 (\4\:A0 VSS) capacitor c=4.75694e-17
C11 (\3\:n0 VSS) capacitor c=2.69532e-17
C12 (\1\:B0 VSS) capacitor c=3.5666e-17
C13 (\3\:A1 VSS) capacitor c=4.42464e-17
C14 (\1\:A0 VSS) capacitor c=6.72524e-17
C15 (\2\:n0 VSS) capacitor c=3.83836e-17
C16 (\2\:B0 VSS) capacitor c=5.86422e-17
C17 (\2\:A1 VSS) capacitor c=8.14821e-17
C18 (\3\:A0 VSS) capacitor c=1.66822e-17
C19 (\1\:Y VSS) capacitor c=3.54509e-17
C20 (\1\:VDD VSS) capacitor c=3.19967e-17
C21 (\4\:n0 VSS) capacitor c=6.9637e-17
C22 (\3\:n2 VSS) capacitor c=6.49777e-17
C23 (\6\:VDD VSS) capacitor c=2.68021e-17
C24 (\3\:Y VSS) capacitor c=2.58273e-17
C25 (\7\:n0 VSS) capacitor c=5.48241e-17
C26 (\2\:A0 VSS) capacitor c=5.41085e-17
C27 (\4\:A1 VSS) capacitor c=4.1198e-17
C28 (\4\:B0 VSS) capacitor c=6.31732e-17
C29 (\9\:n0 VSS) capacitor c=1.09171e-16
C30 (\4\:VDD VSS) capacitor c=2.22991e-17
C31 (\5\:VDD VSS) capacitor c=1.23638e-17
Rk4 (B0 \4\:B0) resistor r=0.166 c=0
Rk8 (\2\:Y Y) resistor r=0.2372 c=0
Rk9 (Y \4\:Y) resistor r=0.1196 c=0
Rk2 (\4\:A1 A1) resistor r=0.1905 c=0
Rk10 (\2\:VDD \4\:VDD) resistor r=0.4115 c=0
Rk12 (\5\:VDD VDD) resistor r=0.1247 c=0
Rk11 (\4\:VDD \5\:VDD) resistor r=0.175 c=0
Rk13 (\5\:VDD \7\:VDD) resistor r=0.1724 c=0
Rk1 (\5\:A0 A0) resistor r=0.003674 c=0
Rk15 (\3\:VSS VSS) resistor r=0.07212 c=0
Rk14 (\2\:VSS \3\:VSS) resistor r=0.2716 c=0
Rk16 (\3\:VSS \5\:VSS) resistor r=0.2275 c=0
Rk17 (\5\:VSS \7\:VSS) resistor r=0.3546 c=0
Rk5 (\5\:n0 \6\:n0) resistor r=0.4613 c=0
Rk6 (\6\:n0 \8\:n0) resistor r=0.2556 c=0
Rk7 (\6\:n0 \9\:n0) resistor r=0.03268 c=0
Rk3 (\2\:n2 \4\:n2) resistor r=0.307 c=0
Rl7 (\2\:B0 \3\:B0) resistor r=181.446 c=0
Rl6 (\1\:B0 \2\:B0) resistor r=84.1579 c=0
Rl4 (\1\:A1 \2\:A1) resistor r=218.464 c=0
Rl5 (\2\:A1 \3\:A1) resistor r=37.6944 c=0
Rl3 (\2\:A0 \4\:A0) resistor r=138.143 c=0
Rl1 (\1\:A0 \2\:A0) resistor r=167.286 c=0
Rl2 (\2\:A0 \3\:A0) resistor r=29.2356 c=0
Rl8 (n0 \2\:n0) resistor r=145.708 c=0
Rl9 (\2\:n0 \3\:n0) resistor r=26.1559 c=0
Rz2 (\3\:Y \4\:Y) resistor r=75 c=0
Rz4 (\1\:VSS \2\:VSS) resistor r=75 c=0
Rz5 (\6\:VSS \7\:VSS) resistor r=75 c=0
Rz1 (\7\:n0 \8\:n0) resistor r=75 c=0
Ry4 (\1\:Y \2\:Y) resistor r=62 c=0
Ry5 (\1\:VDD \2\:VDD) resistor r=62 c=0
Ry6 (\6\:VDD \7\:VDD) resistor r=62 c=0
Ry3 (\4\:n0 \5\:n0) resistor r=62 c=0
Ry1 (n2 \2\:n2) resistor r=62 c=0
Ry2 (\3\:n2 \4\:n2) resistor r=62 c=0
Rx3 (\2\:B0 \4\:B0) resistor r=45 c=0
Rx2 (\2\:A1 \4\:A1) resistor r=45 c=0
Rx1 (\3\:A0 \5\:A0) resistor r=45 c=0
Rx4 (\2\:n0 \9\:n0) resistor r=45 c=0
mn0 (n1 \1\:A0 \1\:VSS VSS) g45n1hvt w=(1.45e-07) l=4.5e-08 nf=1 \
        as=2.03e-14 ad=8.7e-15 ps=5.7e-07 pd=4.1e-07 nrd=1.16667 \
        nrs=1.16667 sa=1.4e-07 sb=7.8e-07 sd=160n sca=10.4914 \
        scb=0.00978575 scc=0.000300434 m=(1)
mn1 (\7\:n0 \3\:A1 n1 VSS) g45n1hvt w=(1.45e-07) l=4.5e-08 nf=1 \
        as=8.7e-15 ad=3.698e-14 ps=4.1e-07 pd=8e-07 nrd=1.16667 \
        nrs=1.16667 sa=2.45e-07 sb=6.75e-07 sd=160n sca=10.4914 \
        scb=0.00978575 scc=0.000300434 m=(1)
mn2 (\7\:n0 \1\:B0 \6\:VSS VSS) g45n1hvt w=(1.45e-07) l=4.5e-08 nf=1 \
        as=2.465e-14 ad=3.698e-14 ps=6.3e-07 pd=8e-07 nrd=1.16667 \
        nrs=1.16667 sa=5.45e-07 sb=3.75e-07 sd=160n sca=10.4914 \
        scb=0.00978575 scc=0.000300434 m=(1)
mn3 (\3\:Y \3\:n0 \6\:VSS VSS) g45n1hvt w=(1.45e-07) l=4.5e-08 nf=1 \
        as=2.465e-14 ad=2.32e-14 ps=6.3e-07 pd=6.1e-07 nrd=1.16667 \
        nrs=1.16667 sa=7.6e-07 sb=1.6e-07 sd=160n sca=10.4914 \
        scb=0.00978575 scc=0.000300434 m=(1)
ends AO21XL
// End of subcircuit definition.
