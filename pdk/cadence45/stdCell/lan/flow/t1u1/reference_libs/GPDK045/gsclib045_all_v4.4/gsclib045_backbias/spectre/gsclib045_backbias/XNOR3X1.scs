// gsclib045_backbias/XNOR3X1/schematic

simulator lang=spectre

subckt XNOR3X1 A B C Y NW VDD VSS
mn8 (Y n11 VSS VSS) g45n1svt w=(205n) l=45n nf=1 m=(1)
mn10 (n12 n61 n8 VSS) g45n1svt w=(205n) l=45n nf=1 m=(1)
mn2 (n9 n61 n62 VSS) g45n1svt w=(205n) l=45n nf=1 m=(1)
mn1 (n9 B n8 VSS) g45n1svt w=(190n) l=45n nf=1 m=(1)
mn9 (n8 n62 VSS VSS) g45n1svt w=(190n) l=45n nf=1 m=(1)
mn11 (n12 B n62 VSS) g45n1svt w=(205n) l=45n nf=1 m=(1)
mn6 (n11 C n9 VSS) g45n1svt w=(190n) l=45n nf=1 m=(1)
mn5 (n11 n60 n12 VSS) g45n1svt w=(190n) l=45n nf=1 m=(1)
mn7 (n60 C VSS VSS) g45n1svt w=(190n) l=45n nf=1 m=(1)
mn4 (n61 B VSS VSS) g45n1svt w=(190n) l=45n nf=1 m=(1)
mn3 (n62 A VSS VSS) g45n1svt w=(205n) l=45n nf=1 m=(1)
mp8 (Y n11 VDD NW) g45p1svt w=(390n) l=45n nf=1 m=(1)
mp3 (n62 A VDD NW) g45p1svt w=(390n) l=45n nf=1 m=(1)
mp6 (n9 n60 n11 NW) g45p1svt w=(310n) l=45n nf=1 m=(1)
mp11 (n62 n61 n12 NW) g45p1svt w=(390n) l=45n nf=1 m=(1)
mp2 (n62 B n9 NW) g45p1svt w=(390n) l=45n nf=1 m=(1)
mp5 (n12 C n11 NW) g45p1svt w=(310n) l=45n nf=1 m=(1)
mp1 (n8 n61 n9 NW) g45p1svt w=(310n) l=45n nf=1 m=(1)
mp10 (n8 B n12 NW) g45p1svt w=(310n) l=45n nf=1 m=(1)
mp4 (n61 B VDD NW) g45p1svt w=(310n) l=45n nf=1 m=(1)
mp9 (n8 n62 VDD NW) g45p1svt w=(310n) l=45n nf=1 m=(1)
mp7 (n60 C VDD NW) g45p1svt w=(310n) l=45n nf=1 m=(1)
ends XNOR3X1
