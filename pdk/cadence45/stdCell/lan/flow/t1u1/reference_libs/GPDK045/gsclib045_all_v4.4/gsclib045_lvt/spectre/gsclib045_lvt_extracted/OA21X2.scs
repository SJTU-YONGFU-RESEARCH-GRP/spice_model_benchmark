// Generated for: spectre (May  1 09:17:47 2013 )
// Library name: gsclib045_lvt
// Cell name: OA21X2
// View name: extracted

simulator lang=spectre

subckt OA21X2 A0 A1 B0 VDD VSS Y
mp0 (net98 \1\:A0 \10\:VDD VDD) g45p1lvt w=(2.15e-07) l=4.5e-08 nf=1 \
        as=3.01e-14 ad=3.225e-14 ps=7.1e-07 pd=7.3e-07 nrd=1.16667 \
        nrs=1.16667 sa=1.4e-07 sb=1.04e-06 sd=160n sca=16.3381 \
        scb=0.0159051 scc=0.000527857 m=(1)
mp1 (\12\:net95 \1\:A1 net98 VDD) g45p1lvt w=(2.15e-07) l=4.5e-08 nf=1 \
        as=3.225e-14 ad=4.3e-14 ps=7.3e-07 pd=8.3e-07 nrd=1.16667 \
        nrs=1.16667 sa=3.35e-07 sb=8.45e-07 sd=160n sca=14.3247 \
        scb=0.0130249 scc=0.000501931 m=(1)
mp2 (\12\:net95 \1\:B0 \1\:VDD VDD) g45p1lvt w=(2.15e-07) l=4.5e-08 nf=1 \
        as=6.965e-14 ad=4.3e-14 ps=1.2e-06 pd=8.3e-07 nrd=1.16667 \
        nrs=1.16667 sa=5.8e-07 sb=6e-07 sd=160n sca=13.4265 scb=0.0124078 \
        scc=0.000501184 m=(1)
C1 (B0 VSS) capacitor c=4.52772e-17
C2 (A1 VSS) capacitor c=5.28147e-17
C3 (VDD VSS) capacitor c=9.49695e-17
C4 (A0 VSS) capacitor c=5.7874e-17
C5 (Y VSS) capacitor c=6.38028e-17
C6 (net107 VSS) capacitor c=4.06689e-17
C7 (net95 VSS) capacitor c=5.72391e-17
C8 (\1\:B0 VSS) capacitor c=5.85137e-17
C9 (\1\:A1 VSS) capacitor c=5.24188e-17
C10 (\1\:A0 VSS) capacitor c=4.45718e-17
C11 (\3\:B0 VSS) capacitor c=2.76433e-17
C12 (\3\:A1 VSS) capacitor c=3.60741e-17
C13 (\4\:A0 VSS) capacitor c=3.17701e-17
C14 (\5\:net95 VSS) capacitor c=1.75362e-17
C15 (\2\:B0 VSS) capacitor c=3.70883e-17
C16 (\2\:A1 VSS) capacitor c=4.48959e-17
C17 (\3\:A0 VSS) capacitor c=1.44158e-17
C18 (\1\:VDD VSS) capacitor c=1.16061e-16
C19 (\1\:Y VSS) capacitor c=9.79563e-17
C20 (\12\:net95 VSS) capacitor c=3.75985e-17
C21 (\10\:VDD VSS) capacitor c=2.4557e-17
C22 (\3\:Y VSS) capacitor c=1.1608e-17
C23 (\10\:net95 VSS) capacitor c=7.22655e-17
C24 (\3\:net107 VSS) capacitor c=6.20631e-17
C25 (\2\:A0 VSS) capacitor c=2.85585e-17
C26 (\3\:net95 VSS) capacitor c=7.97491e-17
C27 (\5\:A0 VSS) capacitor c=3.7272e-17
C28 (\4\:A1 VSS) capacitor c=3.82583e-17
C29 (\4\:B0 VSS) capacitor c=6.72328e-17
C30 (\9\:net95 VSS) capacitor c=7.51081e-17
C31 (\5\:VDD VSS) capacitor c=1.46617e-17
C32 (\6\:VDD VSS) capacitor c=1.01047e-17
Rk4 (B0 \4\:B0) resistor r=0.2022 c=0
Rk2 (\4\:A1 A1) resistor r=0.1814 c=0
Rk16 (\1\:VDD \5\:VDD) resistor r=0.06195 c=0
Rk18 (\6\:VDD VDD) resistor r=0.1139 c=0
Rk17 (\5\:VDD \6\:VDD) resistor r=0.2832 c=0
Rk21 (\6\:VDD \11\:VDD) resistor r=0.3012 c=0
Rk1 (A0 \5\:A0) resistor r=0.1398 c=0
Rk7 (\2\:Y Y) resistor r=0.4606 c=0
Rk8 (Y \4\:Y) resistor r=0.119 c=0
Rk10 (\1\:VSS \5\:VSS) resistor r=0.149 c=0
Rk12 (\6\:VSS VSS) resistor r=0.2307 c=0
Rk11 (\5\:VSS \6\:VSS) resistor r=0.1664 c=0
Rk14 (\6\:VSS \10\:VSS) resistor r=0.0722 c=0
Rk3 (\2\:net107 \4\:net107) resistor r=0.233 c=0
Rk5 (\9\:net95 \11\:net95) resistor r=0.3825 c=0
Rk6 (\9\:net95 \13\:net95) resistor r=0.2905 c=0
Rl6 (\1\:B0 \2\:B0) resistor r=156.461 c=0
Rl7 (\2\:B0 \3\:B0) resistor r=29.5379 c=0
Rl4 (\1\:A1 \2\:A1) resistor r=146.846 c=0
Rl5 (\2\:A1 \3\:A1) resistor r=39.1533 c=0
Rl1 (\1\:A0 \2\:A0) resistor r=167.022 c=0
Rl3 (\2\:A0 \4\:A0) resistor r=36.2526 c=0
Rl2 (\2\:A0 \3\:A0) resistor r=11.4953 c=0
Rl9 (\3\:net95 net95) resistor r=70.2199 c=0
Rl11 (\3\:net95 \5\:net95) resistor r=4.6885 c=0
Rz4 (\4\:Y \3\:Y) resistor r=75 c=0
Rz7 (\10\:VSS \9\:VSS) resistor r=75 c=0
Rz1 (net107 \2\:net107) resistor r=75 c=0
Rz2 (\3\:net107 \4\:net107) resistor r=75 c=0
Rz3 (\11\:net95 \10\:net95) resistor r=75 c=0
Ry7 (\11\:VDD \10\:VDD) resistor r=62 c=0
Ry2 (\2\:Y \1\:Y) resistor r=20.6667 c=0
Ry1 (\13\:net95 \12\:net95) resistor r=62 c=0
Rx3 (\2\:B0 \4\:B0) resistor r=45 c=0
Rx2 (\2\:A1 \4\:A1) resistor r=45 c=0
Rx1 (\3\:A0 \5\:A0) resistor r=45 c=0
Rx4 (\9\:net95 \5\:net95) resistor r=45 c=0
mn0 (net107 \4\:A0 \9\:VSS VSS) g45n1lvt w=(1.45e-07) l=4.5e-08 nf=1 \
        as=4.465e-14 ad=2.03e-14 ps=1.31e-06 pd=5.7e-07 nrd=1.16667 \
        nrs=1.16667 sa=1.4e-07 sb=6.75e-07 sd=160n sca=10.0732 \
        scb=0.00911402 scc=0.000253284 m=(1)
mn1 (\3\:net107 \3\:A1 \9\:VSS VSS) g45n1lvt w=(1.45e-07) l=4.5e-08 nf=1 \
        as=4.465e-14 ad=2.9e-14 ps=1.31e-06 pd=6.9e-07 nrd=1.16667 \
        nrs=1.16667 sa=3.35e-07 sb=4.8e-07 sd=160n sca=10.0732 \
        scb=0.00911402 scc=0.000253284 m=(1)
mn2 (\10\:net95 \3\:B0 \3\:net107 VSS) g45n1lvt w=(1.45e-07) l=4.5e-08 \
        nf=1 as=2.9e-14 ad=3.407e-14 ps=6.9e-07 pd=7.6e-07 nrd=1.16667 \
        nrs=1.16667 sa=5.8e-07 sb=2.35e-07 sd=160n sca=10.0732 \
        scb=0.00911402 scc=0.000253284 m=(1)
mn3 (\3\:Y net95 \1\:VSS VSS) g45n1lvt w=(2.6e-07) l=4.5e-08 nf=1 \
        as=4.34e-14 ad=4.16e-14 ps=1.15e-06 pd=8.4e-07 nrd=1.16667 \
        nrs=1.16667 sa=1e-07 sb=3.45e-07 sd=160n sca=17.5885 scb=0.0172826 \
        scc=0.00162584 m=(2)
mp3 (\1\:Y \3\:net95 \1\:VDD VDD) g45p1lvt w=(3.9e-07) l=4.5e-08 nf=1 \
        as=6.213e-14 ad=6.24e-14 ps=1.13e-06 pd=1.1e-06 nrd=1.16667 \
        nrs=1.16667 sa=5.23141e-07 sb=3.45e-07 sd=160n sca=12.736 \
        scb=0.0105861 scc=0.000311807 m=(2)
ends OA21X2
// End of subcircuit definition.
