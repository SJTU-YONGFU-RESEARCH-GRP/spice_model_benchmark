// Generated for: spectre (May  1 09:13:58 2013 )
// Library name: gsclib045_hvt
// Cell name: CLKINVX6
// View name: extracted

simulator lang=spectre

subckt CLKINVX6 A VDD VSS Y
mp0 (\1\:Y A VDD VDD) g45p1hvt w=(4.7e-07) l=4.5e-08 nf=1 as=7.52e-14 \
        ad=7.332e-14 ps=1.26e-06 pd=1.252e-06 nrd=1.16667 nrs=1.16667 \
        sa=1.4e-07 sb=9.7e-07 sd=160n sca=40.6416 scb=0.0369115 \
        scc=0.00420297 m=(5)
C1 (A VSS) capacitor c=3.59417e-16
C2 (Y VSS) capacitor c=1.65583e-17
C3 (VDD VSS) capacitor c=2.16501e-16
C4 (\1\:Y VSS) capacitor c=2.03369e-16
C5 (\6\:Y VSS) capacitor c=2.07227e-16
Rk5 (\1\:Y Y) resistor r=0.02733 c=0
Rk6 (Y \6\:Y) resistor r=0.2233 c=0
mn0 (\6\:Y A VSS VSS) g45n1hvt w=(3.1e-07) l=4.5e-08 nf=1 as=4.836e-14 \
        ad=4.96e-14 ps=9.32e-07 pd=9.4e-07 nrd=1.16667 nrs=1.16667 \
        sa=1.4e-07 sb=9.7e-07 sd=160n sca=9.23999 scb=0.00771541 \
        scc=0.000252587 m=(5)
ends CLKINVX6
// End of subcircuit definition.
