// gsclib045_backbias/AND4XL/schematic

simulator lang=spectre

subckt AND4XL A B C D Y NW VDD VSS
mn3 (net100 D net136 VSS) g45n1svt w=(145n) l=45n nf=1 m=(1)
mn2 (net136 C net128 VSS) g45n1svt w=(145n) l=45n nf=1 m=(1)
mn4 (Y net100 VSS VSS) g45n1svt w=(145n) l=45n nf=1 m=(1)
mn1 (net128 B net124 VSS) g45n1svt w=(145n) l=45n nf=1 m=(1)
mn0 (net124 A VSS VSS) g45n1svt w=(145n) l=45n nf=1 m=(1)
mp3 (net100 D VDD NW) g45p1svt w=(215n) l=45n nf=1 m=(1)
mp2 (net100 C VDD NW) g45p1svt w=(215n) l=45n nf=1 m=(1)
mp1 (net100 B VDD NW) g45p1svt w=(215n) l=45n nf=1 m=(1)
mp4 (Y net100 VDD NW) g45p1svt w=(215n) l=45n nf=1 m=(1)
mp0 (net100 A VDD NW) g45p1svt w=(215n) l=45n nf=1 m=(1)
ends AND4XL
