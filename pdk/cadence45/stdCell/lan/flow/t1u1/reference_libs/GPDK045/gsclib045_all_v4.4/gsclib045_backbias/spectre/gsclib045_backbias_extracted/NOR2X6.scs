// Generated for: spectre (May  1 11:30:46 2013 )
// Library name: gsclib045_backbias
// Cell name: NOR2X6
// View name: extracted

simulator lang=spectre

subckt NOR2X6 A B NW VDD VSS Y
mp0_1__rcx (1 \1\:A \10\:VDD NW) g45p1svt w=(3.9e-07) l=4.5e-08 nf=1 \
        as=5.46e-14 ad=2.34e-14 ps=1.06e-06 pd=9e-07 nrd=1.16667 \
        nrs=1.16667 sa=1.4e-07 sb=1.82e-06 sd=160n sca=17.8302 \
        scb=0.0172414 scc=0.000800052 m=(1)
mp1_1__rcx (\16\:Y \5\:B 1 NW) g45p1svt w=(3.9e-07) l=4.5e-08 nf=1 \
        as=2.34e-14 ad=6.24e-14 ps=9e-07 pd=1.1e-06 nrd=1.16667 \
        nrs=1.16667 sa=2.45e-07 sb=1.715e-06 sd=160n sca=16.2541 \
        scb=0.014643 scc=0.000761282 m=(1)
mp1_2__rcx (\16\:Y \1\:B 3 NW) g45p1svt w=(3.9e-07) l=4.5e-08 nf=1 \
        as=2.34e-14 ad=6.24e-14 ps=9e-07 pd=1.1e-06 nrd=1.16667 \
        nrs=1.16667 sa=4.5e-07 sb=1.51e-06 sd=160n sca=14.8213 \
        scb=0.0130288 scc=0.000754571 m=(1)
mp0_2__rcx (3 \10\:A \8\:VDD NW) g45p1svt w=(3.9e-07) l=4.5e-08 nf=1 \
        as=6.24e-14 ad=2.34e-14 ps=1.1e-06 pd=9e-07 nrd=1.16667 \
        nrs=1.16667 sa=5.55e-07 sb=1.405e-06 sd=160n sca=14.4437 \
        scb=0.0128219 scc=0.000754437 m=(1)
mp0_3__rcx (2 \4\:A \8\:VDD NW) g45p1svt w=(3.9e-07) l=4.5e-08 nf=1 \
        as=6.24e-14 ad=2.34e-14 ps=1.1e-06 pd=9e-07 nrd=1.16667 \
        nrs=1.16667 sa=7.6e-07 sb=1.2e-06 sd=160n sca=14.1011 \
        scb=0.0127228 scc=0.000754417 m=(1)
mp1_3__rcx (\19\:Y \11\:B 2 NW) g45p1svt w=(3.9e-07) l=4.5e-08 nf=1 \
        as=2.34e-14 ad=6.24e-14 ps=9e-07 pd=1.1e-06 nrd=1.16667 \
        nrs=1.16667 sa=8.65e-07 sb=1.095e-06 sd=160n sca=14.1011 \
        scb=0.0127228 scc=0.000754417 m=(1)
mp1_4__rcx (\19\:Y \12\:B 5 NW) g45p1svt w=(3.9e-07) l=4.5e-08 nf=1 \
        as=2.34e-14 ad=6.24e-14 ps=9e-07 pd=1.1e-06 nrd=1.16667 \
        nrs=1.16667 sa=1.07e-06 sb=8.9e-07 sd=160n sca=14.1011 \
        scb=0.0127228 scc=0.000754417 m=(1)
mp0_4__rcx (5 \14\:A \6\:VDD NW) g45p1svt w=(3.9e-07) l=4.5e-08 nf=1 \
        as=6.435e-14 ad=2.34e-14 ps=1.11e-06 pd=9e-07 nrd=1.16667 \
        nrs=1.16667 sa=1.175e-06 sb=7.85e-07 sd=160n sca=14.1011 \
        scb=0.0127228 scc=0.000754417 m=(1)
mp0_5__rcx (4 \16\:A \6\:VDD NW) g45p1svt w=(3.9e-07) l=4.5e-08 nf=1 \
        as=6.435e-14 ad=2.34e-14 ps=1.11e-06 pd=9e-07 nrd=1.16667 \
        nrs=1.16667 sa=1.385e-06 sb=5.75e-07 sd=160n sca=14.6601 \
        scb=0.0129275 scc=0.000754489 m=(1)
mp1_5__rcx (\21\:Y \16\:B 4 NW) g45p1svt w=(3.9e-07) l=4.5e-08 nf=1 \
        as=2.34e-14 ad=6.24e-14 ps=9e-07 pd=1.1e-06 nrd=1.16667 \
        nrs=1.16667 sa=1.49e-06 sb=4.7e-07 sd=160n sca=15.1439 \
        scb=0.0132876 scc=0.000754937 m=(1)
mp1 (\21\:Y \17\:B 6 NW) g45p1svt w=(3.9e-07) l=4.5e-08 nf=1 as=2.34e-14 \
        ad=6.24e-14 ps=9e-07 pd=1.1e-06 nrd=1.16667 nrs=1.16667 \
        sa=1.695e-06 sb=2.65e-07 sd=160n sca=17.1124 scb=0.0160045 \
        scc=0.000776708 m=(1)
mp0 (6 \17\:A \1\:VDD NW) g45p1svt w=(3.9e-07) l=4.5e-08 nf=1 \
        as=6.24e-14 ad=2.34e-14 ps=1.1e-06 pd=9e-07 nrd=1.16667 \
        nrs=1.16667 sa=1.8e-06 sb=1.6e-07 sd=160n sca=19.4933 \
        scb=0.0201815 scc=0.000898164 m=(1)
C1 (NW VSS) capacitor c=3.21339e-16
C2 (A VSS) capacitor c=8.51181e-16
C3 (VDD VSS) capacitor c=3.23765e-17
C4 (Y VSS) capacitor c=6.9023e-17
C5 (B VSS) capacitor c=7.95113e-16
C6 (1 VSS) capacitor c=1.86356e-18
C7 (3 VSS) capacitor c=1.9638e-18
C8 (2 VSS) capacitor c=1.87598e-18
C9 (5 VSS) capacitor c=1.9638e-18
C10 (4 VSS) capacitor c=1.9638e-18
C11 (\17\:A VSS) capacitor c=6.80891e-17
C12 (\17\:B VSS) capacitor c=6.03974e-17
C13 (\16\:B VSS) capacitor c=6.13717e-17
C14 (\16\:A VSS) capacitor c=6.80376e-17
C15 (\14\:A VSS) capacitor c=7.21656e-17
C16 (\12\:B VSS) capacitor c=6.39555e-17
C17 (\11\:B VSS) capacitor c=6.08068e-17
C18 (\4\:A VSS) capacitor c=6.75586e-17
C19 (\10\:A VSS) capacitor c=6.7827e-17
C20 (\1\:B VSS) capacitor c=6.08603e-17
C21 (\5\:B VSS) capacitor c=6.50813e-17
C22 (\1\:A VSS) capacitor c=7.88815e-17
C23 (\18\:A VSS) capacitor c=4.69218e-17
C24 (\1\:VDD VSS) capacitor c=9.35415e-17
C25 (\21\:Y VSS) capacitor c=3.78579e-17
C26 (\6\:VDD VSS) capacitor c=5.13253e-17
C27 (\19\:Y VSS) capacitor c=3.7623e-17
C28 (\8\:VDD VSS) capacitor c=5.13857e-17
C29 (\16\:Y VSS) capacitor c=3.76738e-17
C30 (\10\:VDD VSS) capacitor c=5.90043e-17
C31 (\1\:Y VSS) capacitor c=7.11587e-16
C32 (\15\:Y VSS) capacitor c=1.52051e-16
C33 (\18\:Y VSS) capacitor c=9.75645e-17
C34 (\19\:A VSS) capacitor c=7.29989e-17
C35 (\3\:VDD VSS) capacitor c=8.15876e-17
C36 (\4\:VDD VSS) capacitor c=6.51224e-17
C37 (\5\:VDD VSS) capacitor c=4.17342e-17
Rk18 (\19\:A A) resistor r=0.5677 c=0
Rk22 (\2\:VDD \3\:VDD) resistor r=0.6282 c=0
Rk23 (\3\:VDD \4\:VDD) resistor r=0.3133 c=0
Rk25 (\5\:VDD VDD) resistor r=0.09995 c=0
Rk24 (\4\:VDD \5\:VDD) resistor r=0.3108 c=0
Rk26 (\3\:VDD \7\:VDD) resistor r=0.2731 c=0
Rk27 (\4\:VDD \9\:VDD) resistor r=0.2731 c=0
Rk28 (\5\:VDD \11\:VDD) resistor r=0.3135 c=0
Rk12 (\1\:Y \15\:Y) resistor r=0.8098 c=0
Rk13 (\15\:Y \17\:Y) resistor r=0.09073 c=0
Rk16 (\18\:Y Y) resistor r=0.4478 c=0
Rk14 (\15\:Y \18\:Y) resistor r=0.46 c=0
Rk15 (\18\:Y \20\:Y) resistor r=0.09073 c=0
Rk17 (Y \22\:Y) resistor r=0.1144 c=0
Rl23 (A \16\:A) resistor r=93.9956 c=0
Rl21 (A \14\:A) resistor r=109.535 c=0
Rl8 (A \4\:A) resistor r=89.2642 c=0
Rl13 (A \10\:A) resistor r=89.2642 c=0
Rl1 (A \1\:A) resistor r=107.281 c=0
Rl28 (\18\:A \17\:A) resistor r=51.098 c=0
Rl27 (B \17\:B) resistor r=45.1626 c=0
Rl26 (B \16\:B) resistor r=48.0781 c=0
Rl18 (B \12\:B) resistor r=52.5659 c=0
Rl17 (B \11\:B) resistor r=46.2322 c=0
Rl3 (B \1\:B) resistor r=45.369 c=0
Rl6 (B \5\:B) resistor r=52.5659 c=0
Ry4 (\1\:VDD \2\:VDD) resistor r=20.6667 c=0
Ry5 (\6\:VDD \7\:VDD) resistor r=31 c=0
Ry6 (\8\:VDD \9\:VDD) resistor r=31 c=0
Ry7 (\10\:VDD \11\:VDD) resistor r=20.6667 c=0
Ry1 (\17\:Y \16\:Y) resistor r=20.6667 c=0
Ry2 (\20\:Y \19\:Y) resistor r=20.6667 c=0
Ry3 (\22\:Y \21\:Y) resistor r=20.6667 c=0
Rx4 (\19\:A \18\:A) resistor r=45 c=0
mn0_1__rcx (\1\:Y A VSS VSS) g45n1svt w=(3.1e-07) l=4.5e-08 nf=1 \
        as=4.898e-14 ad=4.96e-14 ps=9.36e-07 pd=9.4e-07 nrd=1.16667 \
        nrs=1.16667 sa=1.4e-07 sb=2e-06 sd=160n sca=11.8347 scb=0.0112322 \
        scc=0.000626052 m=(5)
mn1_1__rcx (\1\:Y B VSS VSS) g45n1svt w=(3.1e-07) l=4.5e-08 nf=1 \
        as=4.96e-14 ad=4.96e-14 ps=9.4e-07 pd=9.4e-07 nrd=1.16667 \
        nrs=1.16667 sa=3.45e-07 sb=1.805e-06 sd=160n sca=11.8347 \
        scb=0.0112322 scc=0.000626052 m=(5)
ends NOR2X6
// End of subcircuit definition.
