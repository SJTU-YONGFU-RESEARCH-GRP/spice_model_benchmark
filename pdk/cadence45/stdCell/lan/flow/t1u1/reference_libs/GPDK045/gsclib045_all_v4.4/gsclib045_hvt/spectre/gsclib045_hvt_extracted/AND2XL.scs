// Generated for: spectre (May  1 09:12:11 2013 )
// Library name: gsclib045_hvt
// Cell name: AND2XL
// View name: extracted

simulator lang=spectre

subckt AND2XL A B VDD VSS Y
mp1 (\9\:net57 \4\:B \5\:VDD VDD) g45p1hvt w=(2.15e-07) l=4.5e-08 nf=1 \
        as=5.16e-14 ad=3.44e-14 ps=1.47e-06 pd=7.5e-07 nrd=1.16667 \
        nrs=1.16667 sa=1e-07 sb=5.5e-07 sd=160n sca=31.2881 scb=0.0351388 \
        scc=0.00259704 m=(1)
mp0 (\9\:net57 \4\:A \1\:VDD VDD) g45p1hvt w=(2.15e-07) l=4.5e-08 nf=1 \
        as=3.44e-14 ad=3.44e-14 ps=7.5e-07 pd=7.5e-07 nrd=1.16667 \
        nrs=1.16667 sa=3.05e-07 sb=3.45e-07 sd=160n sca=20.7658 \
        scb=0.021645 scc=0.000601202 m=(1)
mp2 (\1\:Y net57 \1\:VDD VDD) g45p1hvt w=(2.15e-07) l=4.5e-08 nf=1 \
        as=3.44e-14 ad=3.01e-14 ps=7.5e-07 pd=7.1e-07 nrd=1.16667 \
        nrs=1.16667 sa=5.1e-07 sb=1.4e-07 sd=160n sca=27.1972 \
        scb=0.0311782 scc=0.00169862 m=(1)
C1 (Y VSS) capacitor c=4.81311e-17
C2 (VDD VSS) capacitor c=7.41524e-17
C3 (A VSS) capacitor c=3.65295e-17
C4 (net73 VSS) capacitor c=1.08081e-18
C5 (net57 VSS) capacitor c=4.70951e-17
C6 (\4\:A VSS) capacitor c=3.60618e-17
C7 (\4\:B VSS) capacitor c=3.97775e-17
C8 (\4\:net57 VSS) capacitor c=2.8702e-17
C9 (\3\:A VSS) capacitor c=6.82603e-17
C10 (\1\:B VSS) capacitor c=4.67036e-17
C11 (\3\:net57 VSS) capacitor c=2.66671e-17
C12 (\1\:A VSS) capacitor c=2.66418e-17
C13 (\3\:B VSS) capacitor c=1.04529e-17
C14 (\1\:Y VSS) capacitor c=4.3802e-17
C15 (\1\:VDD VSS) capacitor c=3.13807e-17
C16 (\9\:net57 VSS) capacitor c=4.68833e-17
C17 (\5\:VDD VSS) capacitor c=4.48543e-18
C18 (\3\:Y VSS) capacitor c=1.79893e-17
C19 (\7\:net57 VSS) capacitor c=3.41293e-17
C20 (\2\:B VSS) capacitor c=3.43263e-17
C21 (\2\:A VSS) capacitor c=4.16506e-17
C22 (\2\:net57 VSS) capacitor c=2.93658e-17
C23 (\5\:B VSS) capacitor c=2.04077e-17
C24 (\7\:B VSS) capacitor c=3.62259e-17
C25 (\5\:A VSS) capacitor c=4.76732e-17
C26 (\5\:net57 VSS) capacitor c=4.72528e-17
C27 (\6\:net57 VSS) capacitor c=5.29676e-17
C28 (\4\:VDD VSS) capacitor c=1.60022e-17
Rk14 (\4\:VSS VSS) resistor r=0.1499 c=0
Rk13 (\2\:VSS \4\:VSS) resistor r=0.3677 c=0
Rk1 (\5\:B \6\:B) resistor r=0.001154 c=0
Rk2 (B \7\:B) resistor r=0.001038 c=0
Rk3 (\5\:B \7\:B) resistor r=0.0269 c=0
Rk8 (\2\:Y Y) resistor r=0.3123 c=0
Rk9 (Y \4\:Y) resistor r=0.06276 c=0
Rk11 (\4\:VDD VDD) resistor r=0.1503 c=0
Rk10 (\2\:VDD \4\:VDD) resistor r=0.3481 c=0
Rk12 (VDD \6\:VDD) resistor r=0.1178 c=0
Rk4 (A \5\:A) resistor r=0.05388 c=0
Rk5 (\5\:net57 \6\:net57) resistor r=0.1568 c=0
Rk6 (\6\:net57 \8\:net57) resistor r=0.1877 c=0
Rk7 (\6\:net57 \10\:net57) resistor r=0.3018 c=0
Rl3 (\2\:B \4\:B) resistor r=99.4619 c=0
Rl1 (\1\:B \2\:B) resistor r=76.4327 c=0
Rl2 (\2\:B \3\:B) resistor r=4.5402 c=0
Rl6 (\2\:A \4\:A) resistor r=52.7257 c=0
Rl5 (\2\:A \3\:A) resistor r=116.187 c=0
Rl4 (\1\:A \2\:A) resistor r=1.2334 c=0
Rl7 (net57 \2\:net57) resistor r=121.957 c=0
Rl9 (\2\:net57 \4\:net57) resistor r=46.9565 c=0
Rl8 (\2\:net57 \3\:net57) resistor r=2.4801 c=0
Rz4 (\1\:VSS \2\:VSS) resistor r=75 c=0
Rz2 (\3\:Y \4\:Y) resistor r=75 c=0
Rz1 (\7\:net57 \8\:net57) resistor r=75 c=0
Ry2 (\1\:Y \2\:Y) resistor r=62 c=0
Ry3 (\1\:VDD \2\:VDD) resistor r=62 c=0
Ry4 (\5\:VDD \6\:VDD) resistor r=62 c=0
Ry1 (\9\:net57 \10\:net57) resistor r=62 c=0
Rx1 (\3\:B \6\:B) resistor r=45 c=0
Rx2 (\1\:A \5\:A) resistor r=45 c=0
Rx3 (\3\:net57 \5\:net57) resistor r=45 c=0
mn1 (\7\:net57 \1\:B net73 VSS) g45n1hvt w=(1.45e-07) l=4.5e-08 nf=1 \
        as=9.43e-15 ad=2.03e-14 ps=4.2e-07 pd=5.7e-07 nrd=1.16667 \
        nrs=1.16667 sa=1.4e-07 sb=4.55e-07 sd=160n sca=15.2405 \
        scb=0.016218 scc=0.00104639 m=(1)
mn0 (net73 \3\:A \1\:VSS VSS) g45n1hvt w=(1.45e-07) l=4.5e-08 nf=1 \
        as=2.32e-14 ad=9.43e-15 ps=6.1e-07 pd=4.2e-07 nrd=1.16667 \
        nrs=1.16667 sa=2.5e-07 sb=3.45e-07 sd=160n sca=15.2405 \
        scb=0.016218 scc=0.00104639 m=(1)
mn2 (\3\:Y \4\:net57 \1\:VSS VSS) g45n1hvt w=(1.45e-07) l=4.5e-08 nf=1 \
        as=2.32e-14 ad=2.03e-14 ps=6.1e-07 pd=5.7e-07 nrd=1.16667 \
        nrs=1.16667 sa=4.55e-07 sb=1.4e-07 sd=160n sca=15.2405 \
        scb=0.016218 scc=0.00104639 m=(1)
ends AND2XL
// End of subcircuit definition.
