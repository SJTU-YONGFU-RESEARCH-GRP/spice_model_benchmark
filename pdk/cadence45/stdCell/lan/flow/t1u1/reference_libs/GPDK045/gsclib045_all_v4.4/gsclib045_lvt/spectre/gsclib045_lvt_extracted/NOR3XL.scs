// Generated for: spectre (May  1 09:17:28 2013 )
// Library name: gsclib045_lvt
// Cell name: NOR3XL
// View name: extracted

simulator lang=spectre

subckt NOR3XL A B C VDD VSS Y
mp0 (n0 \1\:A \4\:VDD VDD) g45p1lvt w=(2.15e-07) l=4.5e-08 nf=1 \
        as=3.01e-14 ad=2.688e-14 ps=7.1e-07 pd=6.8e-07 nrd=1.16667 \
        nrs=1.16667 sa=1.4e-07 sb=5.4e-07 sd=160n sca=17.0184 \
        scb=0.0161278 scc=0.000306233 m=(1)
mp1 (n1 \1\:B n0 VDD) g45p1lvt w=(2.15e-07) l=4.5e-08 nf=1 as=2.688e-14 \
        ad=2.258e-14 ps=6.8e-07 pd=6.4e-07 nrd=1.16667 nrs=1.16667 \
        sa=3.1e-07 sb=3.7e-07 sd=160n sca=15.9187 scb=0.0138219 \
        scc=0.000240159 m=(1)
mp2 (\4\:Y \3\:C n1 VDD) g45p1lvt w=(2.15e-07) l=4.5e-08 nf=1 \
        as=2.258e-14 ad=4.73e-14 ps=6.4e-07 pd=8.7e-07 nrd=1.16667 \
        nrs=1.16667 sa=4.6e-07 sb=2.2e-07 sd=160n sca=18.4685 \
        scb=0.0189127 scc=0.000442866 m=(1)
C1 (C VSS) capacitor c=6.73779e-17
C2 (Y VSS) capacitor c=3.21459e-18
C3 (B VSS) capacitor c=9.01567e-17
C4 (A VSS) capacitor c=3.43691e-17
C5 (VDD VSS) capacitor c=9.77856e-17
C6 (n0 VSS) capacitor c=5.17527e-18
C7 (n1 VSS) capacitor c=1.68211e-19
C8 (\3\:C VSS) capacitor c=3.63796e-17
C9 (\1\:B VSS) capacitor c=4.12912e-17
C10 (\1\:A VSS) capacitor c=3.03439e-17
C11 (\1\:C VSS) capacitor c=3.74171e-17
C12 (\3\:B VSS) capacitor c=4.8412e-17
C13 (\3\:A VSS) capacitor c=4.20301e-17
C14 (\2\:C VSS) capacitor c=4.04674e-17
C15 (\2\:B VSS) capacitor c=5.53934e-17
C16 (\2\:A VSS) capacitor c=4.29101e-17
C17 (\4\:Y VSS) capacitor c=6.06935e-17
C18 (\4\:VDD VSS) capacitor c=3.88796e-17
C19 (\6\:Y VSS) capacitor c=1.52114e-17
C20 (\1\:Y VSS) capacitor c=4.44177e-17
C21 (\4\:A VSS) capacitor c=4.62723e-17
C22 (\4\:B VSS) capacitor c=2.92269e-17
C23 (\4\:C VSS) capacitor c=5.90765e-17
C24 (\3\:Y VSS) capacitor c=5.77758e-17
C25 (\3\:VDD VSS) capacitor c=3.46482e-17
Rk5 (C \4\:C) resistor r=0.1866 c=0
Rk8 (\3\:Y Y) resistor r=0.04375 c=0
Rk6 (\2\:Y \3\:Y) resistor r=0.4284 c=0
Rk7 (\3\:Y \5\:Y) resistor r=0.3569 c=0
Rk9 (Y \7\:Y) resistor r=0.05974 c=0
Rk10 (\2\:VSS \4\:VSS) resistor r=0.4114 c=0
Rk12 (\5\:VSS VSS) resistor r=0.08457 c=0
Rk11 (\4\:VSS \5\:VSS) resistor r=0.1148 c=0
Rk13 (\5\:VSS \7\:VSS) resistor r=0.073 c=0
Rk4 (\4\:B B) resistor r=0.0239 c=0
Rk1 (\4\:A A) resistor r=0.08564 c=0
Rk15 (\3\:VDD VDD) resistor r=0.08206 c=0
Rk16 (\3\:VDD \5\:VDD) resistor r=0.282 c=0
Rl6 (\2\:C \3\:C) resistor r=62.6374 c=0
Rl5 (\1\:C \2\:C) resistor r=101.923 c=0
Rl3 (\1\:B \2\:B) resistor r=29.5379 c=0
Rl4 (\2\:B \3\:B) resistor r=133.384 c=0
Rl1 (\1\:A \2\:A) resistor r=24.2328 c=0
Rl2 (\2\:A \3\:A) resistor r=135.771 c=0
Rz1 (\1\:Y \2\:Y) resistor r=75 c=0
Rz2 (\6\:Y \7\:Y) resistor r=75 c=0
Rz3 (\1\:VSS \2\:VSS) resistor r=75 c=0
Rz4 (\6\:VSS \7\:VSS) resistor r=75 c=0
Ry1 (\4\:Y \5\:Y) resistor r=62 c=0
Ry3 (\4\:VDD \5\:VDD) resistor r=62 c=0
Rx3 (\2\:C \4\:C) resistor r=45 c=0
Rx2 (\2\:B \4\:B) resistor r=45 c=0
Rx1 (\2\:A \4\:A) resistor r=45 c=0
mn0 (\1\:Y \3\:A \6\:VSS VSS) g45n1lvt w=(1.45e-07) l=4.5e-08 nf=1 \
        as=4.29e-14 ad=2.32e-14 ps=1.43e-06 pd=6.1e-07 nrd=1.16667 \
        nrs=1.16667 sa=1e-07 sb=5.95e-07 sd=160n sca=17.8702 scb=0.0189183 \
        scc=0.00156031 m=(1)
mn1 (\1\:Y \3\:B \1\:VSS VSS) g45n1lvt w=(1.45e-07) l=4.5e-08 nf=1 \
        as=2.32e-14 ad=2.32e-14 ps=6.1e-07 pd=6.1e-07 nrd=1.16667 \
        nrs=1.16667 sa=3.05e-07 sb=3.9e-07 sd=160n sca=17.8702 \
        scb=0.0189183 scc=0.00156031 m=(1)
mn2 (\6\:Y \1\:C \1\:VSS VSS) g45n1lvt w=(1.45e-07) l=4.5e-08 nf=1 \
        as=2.32e-14 ad=2.682e-14 ps=6.1e-07 pd=6.6e-07 nrd=1.16667 \
        nrs=1.16667 sa=5.1e-07 sb=1.85e-07 sd=160n sca=17.8702 \
        scb=0.0189183 scc=0.00156031 m=(1)
ends NOR3XL
// End of subcircuit definition.
