// gsclib045_backbias/CLKXOR2X8/schematic

simulator lang=spectre

subckt CLKXOR2X8 A B Y NW VDD VSS
mn1 (n2 B VSS VSS) g45n1svt w=(145n) l=45n nf=1 m=(1)
mn0 (n1 A VSS VSS) g45n1svt w=(145n) l=45n nf=1 m=(1)
mn5 (Y n0 VSS VSS) g45n1svt w=(2.065u) l=45n nf=1 m=(1)
mn3 (n0 B net139 VSS) g45n1svt w=(205n) l=45n nf=1 m=(1)
mn4 (n0 n2 n1 VSS) g45n1svt w=(205n) l=45n nf=1 m=(1)
mn2 (net139 n1 VSS VSS) g45n1svt w=(205n) l=45n nf=1 m=(1)
mp3 (n0 n2 net130 NW) g45p1svt w=(310n) l=45n nf=1 m=(1)
mp1 (n2 B VDD NW) g45p1svt w=(215n) l=45n nf=1 m=(1)
mp4 (n0 B n1 NW) g45p1svt w=(310n) l=45n nf=1 m=(1)
mp0 (n1 A VDD NW) g45p1svt w=(215n) l=45n nf=1 m=(1)
mp5 (Y n0 VDD NW) g45p1svt w=(3.115u) l=45n nf=1 m=(1)
mp2 (net130 n1 VDD NW) g45p1svt w=(310n) l=45n nf=1 m=(1)
ends CLKXOR2X8
