// Generated for: spectre (May  1 09:12:05 2013 )
// Library name: gsclib045_lvt
// Cell name: AOI2BB1X4
// View name: extracted

simulator lang=spectre

subckt AOI2BB1X4 A0N A1N B0 VDD VSS Y
mp2_1__rcx (1 \1\:B0 \9\:VDD VDD) g45p1lvt w=(3.9e-07) l=4.5e-08 nf=1 \
        as=6.63e-14 ad=2.34e-14 ps=1.12e-06 pd=9e-07 nrd=1.16667 \
        nrs=1.16667 sa=1.7e-07 sb=1.685e-06 sd=160n sca=14.6306 \
        scb=0.0131928 scc=0.00027089 m=(1)
mp3_1__rcx (\10\:Y \5\:net104 1 VDD) g45p1lvt w=(3.9e-07) l=4.5e-08 nf=1 \
        as=2.34e-14 ad=6.24e-14 ps=9e-07 pd=1.1e-06 nrd=1.16667 \
        nrs=1.16667 sa=2.75e-07 sb=1.58e-06 sd=160n sca=13.3043 \
        scb=0.011125 scc=0.000248176 m=(1)
mp3_2__rcx (\10\:Y net104 3 VDD) g45p1lvt w=(3.9e-07) l=4.5e-08 nf=1 \
        as=2.34e-14 ad=6.24e-14 ps=9e-07 pd=1.1e-06 nrd=1.16667 \
        nrs=1.16667 sa=4.8e-07 sb=1.375e-06 sd=160n sca=12.0532 \
        scb=0.00986215 scc=0.000244296 m=(1)
mp2_2__rcx (3 \8\:B0 \7\:VDD VDD) g45p1lvt w=(3.9e-07) l=4.5e-08 nf=1 \
        as=6.24e-14 ad=2.34e-14 ps=1.1e-06 pd=9e-07 nrd=1.16667 \
        nrs=1.16667 sa=5.85e-07 sb=1.27e-06 sd=160n sca=11.7142 \
        scb=0.00970251 scc=0.00024422 m=(1)
mp2_3__rcx (2 \9\:B0 \7\:VDD VDD) g45p1lvt w=(3.9e-07) l=4.5e-08 nf=1 \
        as=6.24e-14 ad=2.34e-14 ps=1.1e-06 pd=9e-07 nrd=1.16667 \
        nrs=1.16667 sa=7.9e-07 sb=1.065e-06 sd=160n sca=11.4561 \
        scb=0.00963524 scc=0.000244209 m=(1)
mp3_3__rcx (\12\:Y \11\:net104 2 VDD) g45p1lvt w=(3.9e-07) l=4.5e-08 nf=1 \
        as=2.34e-14 ad=6.24e-14 ps=9e-07 pd=1.1e-06 nrd=1.16667 \
        nrs=1.16667 sa=8.95e-07 sb=9.6e-07 sd=160n sca=11.4561 \
        scb=0.00963524 scc=0.000244209 m=(1)
mp3 (\12\:Y \12\:net104 7 VDD) g45p1lvt w=(3.9e-07) l=4.5e-08 nf=1 \
        as=1.014e-13 ad=6.24e-14 ps=1.3e-06 pd=1.1e-06 nrd=1.16667 \
        nrs=1.16667 sa=1.1e-06 sb=7.55e-07 sd=160n sca=11.4561 \
        scb=0.00963524 scc=0.000244209 m=(1)
mp2 (7 \12\:B0 \1\:VDD VDD) g45p1lvt w=(3.9e-07) l=4.5e-08 nf=1 \
        as=6.24e-14 ad=1.014e-13 ps=1.1e-06 pd=1.3e-06 nrd=1.16667 \
        nrs=1.16667 sa=1.405e-06 sb=4.5e-07 sd=160n sca=12.0927 \
        scb=0.00988629 scc=0.000244314 m=(1)
mp0 (net87 \3\:A0N \1\:VDD VDD) g45p1lvt w=(3.9e-07) l=4.5e-08 nf=1 \
        as=6.24e-14 ad=2.34e-14 ps=1.1e-06 pd=9e-07 nrd=1.16667 \
        nrs=1.16667 sa=1.61e-06 sb=2.45e-07 sd=160n sca=13.4007 \
        scb=0.0112573 scc=0.000248973 m=(1)
mp1 (\13\:net104 \3\:A1N net87 VDD) g45p1lvt w=(3.9e-07) l=4.5e-08 nf=1 \
        as=2.34e-14 ad=5.46e-14 ps=9e-07 pd=1.06e-06 nrd=1.16667 \
        nrs=1.16667 sa=1.715e-06 sb=1.4e-07 sd=160n sca=14.804 \
        scb=0.0134899 scc=0.000276131 m=(1)
C1 (B0 VSS) capacitor c=1.61255e-17
C2 (Y VSS) capacitor c=9.73985e-17
C3 (A1N VSS) capacitor c=5.93942e-17
C4 (VDD VSS) capacitor c=1.71889e-16
C5 (A0N VSS) capacitor c=2.3695e-17
C6 (net104 VSS) capacitor c=5.9521e-17
C7 (1 VSS) capacitor c=1.93443e-18
C8 (3 VSS) capacitor c=1.95976e-18
C9 (2 VSS) capacitor c=2.1037e-18
C10 (7 VSS) capacitor c=5.84337e-18
C11 (net87 VSS) capacitor c=1.35348e-18
C12 (\3\:A1N VSS) capacitor c=9.267e-17
C13 (\3\:A0N VSS) capacitor c=8.78752e-17
C14 (\12\:B0 VSS) capacitor c=5.11438e-17
C15 (\12\:net104 VSS) capacitor c=2.19824e-17
C16 (\11\:net104 VSS) capacitor c=7.35988e-17
C17 (\9\:B0 VSS) capacitor c=6.86436e-17
C18 (\8\:B0 VSS) capacitor c=7.57378e-17
C19 (\5\:net104 VSS) capacitor c=7.51115e-17
C20 (\1\:B0 VSS) capacitor c=7.65714e-17
C21 (\1\:A1N VSS) capacitor c=4.65749e-17
C22 (\1\:A0N VSS) capacitor c=5.53653e-17
C23 (\4\:A1N VSS) capacitor c=1.1237e-17
C24 (\2\:A0N VSS) capacitor c=6.68141e-17
C25 (\2\:net104 VSS) capacitor c=5.1164e-16
C26 (\2\:B0 VSS) capacitor c=5.59504e-16
C27 (\13\:net104 VSS) capacitor c=2.84966e-17
C28 (\1\:VDD VSS) capacitor c=8.1052e-17
C29 (\12\:Y VSS) capacitor c=8.44584e-17
C30 (\7\:VDD VSS) capacitor c=3.36247e-17
C31 (\10\:Y VSS) capacitor c=2.66724e-17
C32 (\9\:VDD VSS) capacitor c=3.686e-17
C33 (\18\:net104 VSS) capacitor c=7.56548e-17
C34 (\1\:Y VSS) capacitor c=2.54815e-16
C35 (\7\:B0 VSS) capacitor c=3.39322e-17
C36 (\2\:A1N VSS) capacitor c=3.06834e-17
C37 (\9\:Y VSS) capacitor c=5.72413e-17
C38 (\4\:A0N VSS) capacitor c=9.65623e-17
C39 (\15\:net104 VSS) capacitor c=9.41623e-17
C40 (\6\:A1N VSS) capacitor c=1.39016e-17
C41 (\4\:VDD VSS) capacitor c=2.69296e-17
C42 (\5\:VDD VSS) capacitor c=2.44381e-17
C43 (\6\:VDD VSS) capacitor c=1.57317e-17
Rk11 (\2\:B0 B0) resistor r=0.006364 c=0
Rk4 (\1\:Y Y) resistor r=0.6989 c=0
Rk5 (Y \9\:Y) resistor r=0.236 c=0
Rk6 (\9\:Y \11\:Y) resistor r=0.05755 c=0
Rk7 (\9\:Y \13\:Y) resistor r=0.5091 c=0
Rk22 (A1N \6\:A1N) resistor r=0.05091 c=0
Rk29 (\3\:VSS VSS) resistor r=0.06471 c=0
Rk23 (\2\:VSS \3\:VSS) resistor r=0.3877 c=0
Rk35 (\2\:VDD \4\:VDD) resistor r=0.5168 c=0
Rk36 (\4\:VDD \5\:VDD) resistor r=0.1251 c=0
Rk38 (\6\:VDD VDD) resistor r=0.08476 c=0
Rk37 (\5\:VDD \6\:VDD) resistor r=0.3404 c=0
Rk39 (\5\:VDD \8\:VDD) resistor r=0.1765 c=0
Rk40 (\6\:VDD \10\:VDD) resistor r=0.1719 c=0
Rk14 (\4\:A0N A0N) resistor r=0.005989 c=0
Rk16 (\15\:net104 \2\:net104) resistor r=0.5356 c=0
Rk15 (\14\:net104 \15\:net104) resistor r=0.1408 c=0
Rk18 (\15\:net104 \19\:net104) resistor r=0.5113 c=0
Rl19 (\2\:B0 \12\:B0) resistor r=86.3335 c=0
Rl1 (\2\:B0 \1\:B0) resistor r=89.6174 c=0
Rl12 (\7\:B0 \9\:B0) resistor r=78.4102 c=0
Rl11 (\7\:B0 \8\:B0) resistor r=122.561 c=0
Rl10 (\7\:B0 \2\:B0) resistor r=6.3032 c=0
Rl23 (\2\:A1N \3\:A1N) resistor r=111.048 c=0
Rl22 (\1\:A1N \2\:A1N) resistor r=149.462 c=0
Rl24 (\2\:A1N \4\:A1N) resistor r=11.6126 c=0
Rl21 (\2\:A0N \3\:A0N) resistor r=78.079 c=0
Rl20 (\1\:A0N \2\:A0N) resistor r=134.331 c=0
Rl17 (\2\:net104 \12\:net104) resistor r=21.8511 c=0
Rl16 (\2\:net104 \11\:net104) resistor r=76.7238 c=0
Rl3 (\2\:net104 net104) resistor r=25.3355 c=0
Rl6 (\2\:net104 \5\:net104) resistor r=84.3341 c=0
Rz6 (\2\:VSS \1\:VSS) resistor r=75 c=0
Rz5 (\19\:net104 \18\:net104) resistor r=75 c=0
Ry1 (\11\:Y \10\:Y) resistor r=31 c=0
Ry2 (\13\:Y \12\:Y) resistor r=31 c=0
Ry5 (\1\:VDD \2\:VDD) resistor r=31 c=0
Ry6 (\7\:VDD \8\:VDD) resistor r=62 c=0
Ry7 (\9\:VDD \10\:VDD) resistor r=62 c=0
Ry3 (\14\:net104 \13\:net104) resistor r=20.6667 c=0
Rx7 (\4\:A1N \6\:A1N) resistor r=45 c=0
Rx4 (\2\:A0N \4\:A0N) resistor r=45 c=0
mn0 (\18\:net104 \1\:A0N \3\:VSS VSS) g45n1lvt w=(2.6e-07) l=4.5e-08 \
        nf=1 as=4.16e-14 ad=4.16e-14 ps=8.4e-07 pd=8.4e-07 nrd=1.16667 \
        nrs=1.16667 sa=1.78e-06 sb=3.45e-07 sd=160n sca=8.22858 \
        scb=0.00610564 scc=0.00012768 m=(1)
mn1 (\18\:net104 \1\:A1N \1\:VSS VSS) g45n1lvt w=(2.6e-07) l=4.5e-08 \
        nf=1 as=3.64e-14 ad=4.16e-14 ps=8e-07 pd=8.4e-07 nrd=1.16667 \
        nrs=1.16667 sa=1.985e-06 sb=1.4e-07 sd=160n sca=8.22858 \
        scb=0.00610564 scc=0.00012768 m=(1)
mn2_1__rcx (\1\:Y \2\:B0 \3\:VSS VSS) g45n1lvt w=(2.6e-07) l=4.5e-08 \
        nf=1 as=4.03e-14 ad=4.16e-14 ps=8.3e-07 pd=8.4e-07 nrd=1.16667 \
        nrs=1.16667 sa=1.4e-07 sb=1.985e-06 sd=160n sca=8.22858 \
        scb=0.00610564 scc=0.00012768 m=(4)
mn3_1__rcx (\1\:Y \2\:net104 \3\:VSS VSS) g45n1lvt w=(2.6e-07) l=4.5e-08 \
        nf=1 as=4.16e-14 ad=4.16e-14 ps=8.4e-07 pd=8.4e-07 nrd=1.16667 \
        nrs=1.16667 sa=3.45e-07 sb=1.78e-06 sd=160n sca=8.22858 \
        scb=0.00610564 scc=0.00012768 m=(4)
ends AOI2BB1X4
// End of subcircuit definition.
