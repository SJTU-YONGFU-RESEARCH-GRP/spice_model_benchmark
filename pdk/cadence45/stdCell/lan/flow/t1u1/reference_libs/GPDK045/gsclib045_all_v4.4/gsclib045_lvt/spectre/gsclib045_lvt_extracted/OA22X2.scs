// Generated for: spectre (May  1 09:17:51 2013 )
// Library name: gsclib045_lvt
// Cell name: OA22X2
// View name: extracted

simulator lang=spectre

subckt OA22X2 A0 A1 B0 B1 VDD VSS Y
mp0 (net119 \1\:A0 \9\:VDD VDD) g45p1lvt w=(2.15e-07) l=4.5e-08 nf=1 \
        as=3.01e-14 ad=3.225e-14 ps=7.1e-07 pd=7.3e-07 nrd=1.16667 \
        nrs=1.16667 sa=1.4e-07 sb=1.375e-06 sd=160n sca=15.6738 \
        scb=0.0150674 scc=0.000231884 m=(1)
mp1 (\10\:net128 \1\:A1 net119 VDD) g45p1lvt w=(2.15e-07) l=4.5e-08 nf=1 \
        as=3.225e-14 ad=3.44e-14 ps=7.3e-07 pd=7.5e-07 nrd=1.16667 \
        nrs=1.16667 sa=3.35e-07 sb=1.18e-06 sd=160n sca=12.1772 \
        scb=0.00916323 scc=9.24857e-05 m=(1)
mp3 (\10\:net128 \1\:B1 net115 VDD) g45p1lvt w=(2.15e-07) l=4.5e-08 nf=1 \
        as=4.73e-14 ad=3.44e-14 ps=8.7e-07 pd=7.5e-07 nrd=1.16667 \
        nrs=1.16667 sa=5.4e-07 sb=9.75e-07 sd=160n sca=10.8981 \
        scb=0.00784736 scc=8.82336e-05 m=(1)
mp2 (net115 \3\:B0 \1\:VDD VDD) g45p1lvt w=(2.15e-07) l=4.5e-08 nf=1 \
        as=8.63e-14 ad=4.73e-14 ps=1.42e-06 pd=8.7e-07 nrd=1.16667 \
        nrs=1.16667 sa=8.05e-07 sb=7.1e-07 sd=160n sca=10.2815 \
        scb=0.00760864 scc=8.81378e-05 m=(1)
C1 (A1 VSS) capacitor c=1.17496e-16
C2 (Y VSS) capacitor c=2.45254e-17
C3 (B0 VSS) capacitor c=5.70107e-17
C4 (A0 VSS) capacitor c=5.97471e-17
C5 (VDD VSS) capacitor c=1.14874e-16
C6 (B1 VSS) capacitor c=7.10877e-17
C7 (net124 VSS) capacitor c=7.79451e-17
C8 (net128 VSS) capacitor c=6.21283e-17
C9 (net115 VSS) capacitor c=6.48807e-18
C10 (\3\:B0 VSS) capacitor c=3.1687e-17
C11 (\1\:B1 VSS) capacitor c=5.11134e-17
C12 (\1\:A1 VSS) capacitor c=3.91316e-17
C13 (\1\:A0 VSS) capacitor c=4.88685e-17
C14 (\1\:B0 VSS) capacitor c=5.06724e-17
C15 (\3\:B1 VSS) capacitor c=4.29566e-17
C16 (\3\:A1 VSS) capacitor c=6.64799e-17
C17 (\3\:A0 VSS) capacitor c=3.74197e-17
C18 (\4\:net128 VSS) capacitor c=1.85557e-17
C19 (\2\:B0 VSS) capacitor c=5.17613e-17
C20 (\2\:B1 VSS) capacitor c=5.23349e-17
C21 (\2\:A1 VSS) capacitor c=6.33863e-17
C22 (\2\:A0 VSS) capacitor c=4.81144e-17
C23 (\1\:VDD VSS) capacitor c=1.00851e-16
C24 (\1\:Y VSS) capacitor c=9.12678e-17
C25 (\10\:net128 VSS) capacitor c=6.5072e-17
C26 (\9\:VDD VSS) capacitor c=2.09546e-17
C27 (\3\:Y VSS) capacitor c=1.3776e-17
C28 (\12\:net128 VSS) capacitor c=4.71448e-17
C29 (\3\:net124 VSS) capacitor c=1.29316e-16
C30 (\5\:net124 VSS) capacitor c=5.96592e-17
C31 (\3\:net128 VSS) capacitor c=7.64289e-17
C32 (\4\:A0 VSS) capacitor c=3.00948e-17
C33 (\4\:B1 VSS) capacitor c=5.9259e-17
C34 (\4\:B0 VSS) capacitor c=6.06306e-17
C35 (\8\:net128 VSS) capacitor c=4.65249e-17
C36 (\9\:net128 VSS) capacitor c=1.14208e-16
C37 (\5\:VDD VSS) capacitor c=2.37893e-17
C38 (\6\:VDD VSS) capacitor c=1.60159e-17
Rk2 (\4\:A1 A1) resistor r=0.002985 c=0
Rk10 (\2\:Y Y) resistor r=0.3671 c=0
Rk11 (Y \4\:Y) resistor r=0.03241 c=0
Rk6 (B0 \4\:B0) resistor r=0.1526 c=0
Rk1 (A0 \4\:A0) resistor r=0.07164 c=0
Rk19 (\1\:VDD \5\:VDD) resistor r=0.07725 c=0
Rk21 (\6\:VDD VDD) resistor r=0.06701 c=0
Rk20 (\5\:VDD \6\:VDD) resistor r=0.382 c=0
Rk23 (\6\:VDD \10\:VDD) resistor r=0.2279 c=0
Rk13 (\1\:VSS \5\:VSS) resistor r=0.1597 c=0
Rk15 (\6\:VSS VSS) resistor r=0.1644 c=0
Rk14 (\5\:VSS \6\:VSS) resistor r=0.2846 c=0
Rk17 (\6\:VSS \10\:VSS) resistor r=0.2295 c=0
Rk3 (B1 \4\:B1) resistor r=0.1851 c=0
Rk4 (\2\:net124 \4\:net124) resistor r=0.6137 c=0
Rk5 (\4\:net124 \6\:net124) resistor r=0.503 c=0
Rk7 (\8\:net128 \9\:net128) resistor r=0.2755 c=0
Rk8 (\9\:net128 \11\:net128) resistor r=0.5091 c=0
Rk9 (\9\:net128 \13\:net128) resistor r=0.3314 c=0
Rl3 (\1\:A1 \2\:A1) resistor r=41.0764 c=0
Rl4 (\2\:A1 \3\:A1) resistor r=218 c=0
Rl8 (\2\:B0 \3\:B0) resistor r=41.4835 c=0
Rl7 (\1\:B0 \2\:B0) resistor r=219.231 c=0
Rl1 (\1\:A0 \2\:A0) resistor r=154.944 c=0
Rl2 (\2\:A0 \3\:A0) resistor r=97.2519 c=0
Rl5 (\1\:B1 \2\:B1) resistor r=158.384 c=0
Rl6 (\2\:B1 \3\:B1) resistor r=100.692 c=0
Rl10 (\3\:net128 net128) resistor r=57.0886 c=0
Rl11 (\3\:net128 \4\:net128) resistor r=10.0647 c=0
Rz5 (\4\:Y \3\:Y) resistor r=75 c=0
Rz8 (\10\:VSS \9\:VSS) resistor r=75 c=0
Rz1 (net124 \2\:net124) resistor r=75 c=0
Rz2 (\3\:net124 \4\:net124) resistor r=75 c=0
Rz3 (\5\:net124 \6\:net124) resistor r=75 c=0
Rz4 (\13\:net128 \12\:net128) resistor r=75 c=0
Ry2 (\2\:Y \1\:Y) resistor r=20.6667 c=0
Ry6 (\10\:VDD \9\:VDD) resistor r=62 c=0
Ry1 (\11\:net128 \10\:net128) resistor r=62 c=0
Rx2 (\2\:A1 \4\:A1) resistor r=45 c=0
Rx4 (\2\:B0 \4\:B0) resistor r=45 c=0
Rx1 (\2\:A0 \4\:A0) resistor r=45 c=0
Rx3 (\2\:B1 \4\:B1) resistor r=45 c=0
Rx5 (\8\:net128 \4\:net128) resistor r=45 c=0
mn0 (\5\:net124 \3\:A0 \9\:VSS VSS) g45n1lvt w=(1.45e-07) l=4.5e-08 nf=1 \
        as=2.32e-14 ad=2.03e-14 ps=6.1e-07 pd=5.7e-07 nrd=1.16667 \
        nrs=1.16667 sa=1.4e-07 sb=8.7e-07 sd=160n sca=7.79977 \
        scb=0.00524357 scc=6.87485e-05 m=(1)
mn1 (\3\:net124 \3\:A1 \9\:VSS VSS) g45n1lvt w=(1.45e-07) l=4.5e-08 nf=1 \
        as=2.32e-14 ad=2.32e-14 ps=6.1e-07 pd=6.1e-07 nrd=1.16667 \
        nrs=1.16667 sa=3.45e-07 sb=6.65e-07 sd=160n sca=7.79977 \
        scb=0.00524357 scc=6.87485e-05 m=(1)
mn3 (\12\:net128 \3\:B1 \3\:net124 VSS) g45n1lvt w=(1.45e-07) l=4.5e-08 \
        nf=1 as=2.32e-14 ad=3.988e-14 ps=6.1e-07 pd=8.4e-07 nrd=1.16667 \
        nrs=1.16667 sa=5.5e-07 sb=4.6e-07 sd=160n sca=7.79977 \
        scb=0.00524357 scc=6.87485e-05 m=(1)
mn2 (\12\:net128 \1\:B0 net124 VSS) g45n1lvt w=(1.45e-07) l=4.5e-08 nf=1 \
        as=2.03e-14 ad=3.988e-14 ps=5.7e-07 pd=8.4e-07 nrd=1.16667 \
        nrs=1.16667 sa=8.7e-07 sb=1.4e-07 sd=160n sca=7.79977 \
        scb=0.00524357 scc=6.87485e-05 m=(1)
mn4 (\3\:Y net128 \1\:VSS VSS) g45n1lvt w=(2.6e-07) l=4.5e-08 nf=1 \
        as=4.34e-14 ad=4.16e-14 ps=1.15e-06 pd=8.4e-07 nrd=1.16667 \
        nrs=1.16667 sa=1e-07 sb=3.45e-07 sd=160n sca=17.5885 scb=0.0172826 \
        scc=0.00162584 m=(2)
mp4 (\1\:Y \3\:net128 \1\:VDD VDD) g45p1lvt w=(3.9e-07) l=4.5e-08 nf=1 \
        as=7.045e-14 ad=6.24e-14 ps=1.24e-06 pd=1.1e-06 nrd=1.16667 \
        nrs=1.16667 sa=6.89872e-07 sb=3.45e-07 sd=160n sca=15.2316 \
        scb=0.0133702 scc=0.000755104 m=(2)
ends OA22X2
// End of subcircuit definition.
