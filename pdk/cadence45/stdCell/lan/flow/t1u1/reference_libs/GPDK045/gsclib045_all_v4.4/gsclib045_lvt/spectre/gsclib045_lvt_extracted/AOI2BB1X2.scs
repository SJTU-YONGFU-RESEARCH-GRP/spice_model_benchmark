// Generated for: spectre (May  1 09:12:04 2013 )
// Library name: gsclib045_lvt
// Cell name: AOI2BB1X2
// View name: extracted

simulator lang=spectre

subckt AOI2BB1X2 A0N A1N B0 VDD VSS Y
mp2_1__rcx (2 \1\:B0 \6\:VDD VDD) g45p1lvt w=(3.9e-07) l=4.5e-08 nf=1 \
        as=5.46e-14 ad=2.34e-14 ps=1.06e-06 pd=9e-07 nrd=1.16667 \
        nrs=1.16667 sa=1.4e-07 sb=7.56218e-07 sd=160n sca=15.3142 \
        scb=0.0139264 scc=0.00046091 m=(1)
mp3_1__rcx (\5\:Y \5\:net104 2 VDD) g45p1lvt w=(3.9e-07) l=4.5e-08 nf=1 \
        as=2.34e-14 ad=6.24e-14 ps=9e-07 pd=1.1e-06 nrd=1.16667 \
        nrs=1.16667 sa=2.45e-07 sb=6.51218e-07 sd=160n sca=14.157 \
        scb=0.0122233 scc=0.000446408 m=(1)
mp3 (\5\:Y net104 3 VDD) g45p1lvt w=(3.9e-07) l=4.5e-08 nf=1 as=2.34e-14 \
        ad=6.24e-14 ps=9e-07 pd=1.1e-06 nrd=1.16667 nrs=1.16667 sa=4.5e-07 \
        sb=4.46218e-07 sd=160n sca=13.0345 scb=0.0111963 scc=0.000443955 \
        m=(1)
mp2 (3 \6\:B0 \1\:VDD VDD) g45p1lvt w=(3.9e-07) l=4.5e-08 nf=1 \
        as=7.073e-14 ad=2.34e-14 ps=1.21e-06 pd=9e-07 nrd=1.16667 \
        nrs=1.16667 sa=5.55e-07 sb=3.41218e-07 sd=160n sca=12.7928 \
        scb=0.0110816 scc=0.000443908 m=(1)
C1 (A0N VSS) capacitor c=4.6595e-17
C2 (B0 VSS) capacitor c=2.13308e-17
C3 (Y VSS) capacitor c=8.3799e-17
C4 (VDD VSS) capacitor c=1.06558e-16
C5 (A1N VSS) capacitor c=5.79162e-17
C6 (net104 VSS) capacitor c=5.88782e-17
C7 (2 VSS) capacitor c=1.82166e-18
C8 (net87 VSS) capacitor c=1.42137e-18
C9 (\3\:A1N VSS) capacitor c=7.03466e-17
C10 (\3\:A0N VSS) capacitor c=7.63289e-17
C11 (\6\:B0 VSS) capacitor c=9.16005e-17
C12 (\5\:net104 VSS) capacitor c=7.41357e-17
C13 (\1\:B0 VSS) capacitor c=8.00549e-17
C14 (\1\:A1N VSS) capacitor c=3.43302e-17
C15 (\1\:A0N VSS) capacitor c=3.2795e-17
C16 (\2\:A1N VSS) capacitor c=3.34695e-17
C17 (\2\:A0N VSS) capacitor c=4.48847e-17
C18 (\2\:net104 VSS) capacitor c=2.27051e-17
C19 (\2\:B0 VSS) capacitor c=3.30068e-16
C20 (\11\:net104 VSS) capacitor c=1.61603e-17
C21 (\1\:VDD VSS) capacitor c=4.62956e-17
C22 (\5\:Y VSS) capacitor c=9.77387e-17
C23 (\6\:VDD VSS) capacitor c=2.44652e-17
C24 (\7\:net104 VSS) capacitor c=8.01181e-17
C25 (\1\:Y VSS) capacitor c=1.11679e-16
C26 (\3\:net104 VSS) capacitor c=1.46255e-16
C27 (\4\:A0N VSS) capacitor c=6.4642e-17
C28 (\9\:net104 VSS) capacitor c=1.00686e-16
C29 (\10\:net104 VSS) capacitor c=8.39063e-17
C30 (\5\:A1N VSS) capacitor c=3.81459e-17
C31 (\4\:VDD VSS) capacitor c=3.78813e-17
C32 (\5\:VDD VSS) capacitor c=1.29221e-17
Rk7 (\4\:A0N A0N) resistor r=0.02184 c=0
Rk6 (\2\:B0 B0) resistor r=0.04405 c=0
Rk2 (\1\:Y Y) resistor r=0.3463 c=0
Rk3 (Y \6\:Y) resistor r=0.7463 c=0
Rk22 (\2\:VDD \4\:VDD) resistor r=0.2975 c=0
Rk24 (\5\:VDD VDD) resistor r=0.1271 c=0
Rk23 (\4\:VDD \5\:VDD) resistor r=0.2723 c=0
Rk25 (\5\:VDD \7\:VDD) resistor r=0.2051 c=0
Rk18 (\3\:VSS VSS) resistor r=0.07706 c=0
Rk14 (\2\:VSS \3\:VSS) resistor r=0.5258 c=0
Rk20 (\3\:VSS \11\:VSS) resistor r=0.1721 c=0
Rk13 (A1N \5\:A1N) resistor r=0.03585 c=0
Rk8 (\8\:net104 \9\:net104) resistor r=0.4788 c=0
Rk9 (\9\:net104 \10\:net104) resistor r=0.4618 c=0
Rk10 (\9\:net104 \12\:net104) resistor r=0.1068 c=0
Rl11 (\2\:A0N \3\:A0N) resistor r=134.066 c=0
Rl10 (\1\:A0N \2\:A0N) resistor r=53.8462 c=0
Rl9 (\2\:B0 \6\:B0) resistor r=99.7951 c=0
Rl1 (\2\:B0 \1\:B0) resistor r=103.079 c=0
Rl13 (\2\:A1N \3\:A1N) resistor r=108.232 c=0
Rl12 (\1\:A1N \2\:A1N) resistor r=149.233 c=0
Rl3 (\2\:net104 net104) resistor r=38.4089 c=0
Rl6 (\2\:net104 \5\:net104) resistor r=79.9751 c=0
Rl4 (\3\:net104 \2\:net104) resistor r=6.662 c=0
Rz4 (\2\:VSS \1\:VSS) resistor r=75 c=0
Rz6 (\11\:VSS \10\:VSS) resistor r=75 c=0
Rz3 (\8\:net104 \7\:net104) resistor r=75 c=0
Ry1 (\6\:Y \5\:Y) resistor r=20.6667 c=0
Ry4 (\1\:VDD \2\:VDD) resistor r=31 c=0
Ry5 (\6\:VDD \7\:VDD) resistor r=62 c=0
Ry2 (\12\:net104 \11\:net104) resistor r=62 c=0
Rx3 (\2\:A0N \4\:A0N) resistor r=45 c=0
Rx5 (\2\:A1N \5\:A1N) resistor r=45 c=0
Rx4 (\10\:net104 \2\:net104) resistor r=45 c=0
mn2 (\1\:Y \2\:B0 \3\:VSS VSS) g45n1lvt w=(2.6e-07) l=4.5e-08 nf=1 \
        as=4.003e-14 ad=4.16e-14 ps=8.5e-07 pd=8.4e-07 nrd=1.16667 \
        nrs=1.16667 sa=1.4e-07 sb=1.06452e-06 sd=160n sca=7.84363 \
        scb=0.00546499 scc=9.84911e-05 m=(2)
mn3 (\1\:Y \3\:net104 \10\:VSS VSS) g45n1lvt w=(2.6e-07) l=4.5e-08 nf=1 \
        as=4.16e-14 ad=4.16e-14 ps=8.4e-07 pd=8.4e-07 nrd=1.16667 \
        nrs=1.16667 sa=3.45e-07 sb=8.59519e-07 sd=160n sca=7.84363 \
        scb=0.00546499 scc=9.84911e-05 m=(2)
mn0 (\7\:net104 \1\:A0N \3\:VSS VSS) g45n1lvt w=(1.45e-07) l=4.5e-08 \
        nf=1 as=4.365e-14 ad=3.988e-14 ps=9e-07 pd=8.4e-07 nrd=1.16667 \
        nrs=1.16667 sa=9.9e-07 sb=4.6e-07 sd=160n sca=9.16682 \
        scb=0.00760686 scc=0.000164708 m=(1)
mn1 (\7\:net104 \1\:A1N \1\:VSS VSS) g45n1lvt w=(1.45e-07) l=4.5e-08 \
        nf=1 as=2.03e-14 ad=3.988e-14 ps=5.7e-07 pd=8.4e-07 nrd=1.16667 \
        nrs=1.16667 sa=1.31e-06 sb=1.4e-07 sd=160n sca=9.16682 \
        scb=0.00760686 scc=0.000164708 m=(1)
mp0 (net87 \3\:A0N \1\:VDD VDD) g45p1lvt w=(2.15e-07) l=4.5e-08 nf=1 \
        as=7.073e-14 ad=1.29e-14 ps=1.21e-06 pd=5.5e-07 nrd=1.16667 \
        nrs=1.16667 sa=8.15e-07 sb=2.45e-07 sd=160n sca=15.4989 \
        scb=0.01467 scc=0.00075392 m=(1)
mp1 (\11\:net104 \3\:A1N net87 VDD) g45p1lvt w=(2.15e-07) l=4.5e-08 nf=1 \
        as=1.29e-14 ad=3.01e-14 ps=5.5e-07 pd=7.1e-07 nrd=1.16667 \
        nrs=1.16667 sa=9.2e-07 sb=1.4e-07 sd=160n sca=16.1917 \
        scb=0.0154022 scc=0.000756069 m=(1)
ends AOI2BB1X2
// End of subcircuit definition.
