// Generated for: spectre (May  1 09:11:45 2013 )
// Library name: gsclib045_lvt
// Cell name: AOI211X2
// View name: extracted

simulator lang=spectre

subckt AOI211X2 A0 A1 B0 C0 VDD VSS Y
mp0 (net91 \2\:A0 VDD VDD) g45p1lvt w=(3.9e-07) l=4.5e-08 nf=1 \
        as=5.712e-14 ad=6.24e-14 ps=1.335e-06 pd=1.1e-06 nrd=1.16667 \
        nrs=1.16667 sa=1.4e-07 sb=7.15e-07 sd=160n sca=28.3818 \
        scb=0.0323196 scc=0.00228512 m=(2)
mp3 (\1\:Y \1\:C0 net82 VDD) g45p1lvt w=(3.9e-07) l=4.5e-08 nf=1 \
        as=5.85e-14 ad=6.24e-14 ps=1.08e-06 pd=1.1e-06 nrd=1.16667 \
        nrs=1.16667 sa=5.5e-07 sb=3.45e-07 sd=160n sca=20.8676 \
        scb=0.019613 scc=0.00142067 m=(2)
mp2 (net82 \1\:B0 \6\:net91 VDD) g45p1lvt w=(3.9e-07) l=4.5e-08 nf=1 \
        as=6.24e-14 ad=5.85e-14 ps=1.1e-06 pd=1.08e-06 nrd=1.16667 \
        nrs=1.16667 sa=1.4e-07 sb=7.55e-07 sd=160n sca=17.5811 \
        scb=0.0153688 scc=0.00137895 m=(2)
mp1_1__rcx (net91 \3\:A1 \6\:VDD VDD) g45p1lvt w=(3.9e-07) l=4.5e-08 \
        nf=1 as=6.24e-14 ad=6.24e-14 ps=1.1e-06 pd=1.1e-06 nrd=1.16667 \
        nrs=1.16667 sa=3.45e-07 sb=5.1e-07 sd=160n sca=18.3481 \
        scb=0.0176469 scc=0.000920496 m=(2)
C1 (C0 VSS) capacitor c=3.23584e-17
C2 (B0 VSS) capacitor c=7.81757e-17
C3 (Y VSS) capacitor c=9.07934e-17
C4 (VDD VSS) capacitor c=2.49934e-16
C5 (A0 VSS) capacitor c=1.70158e-17
C6 (11 VSS) capacitor c=1.71309e-18
C7 (net91 VSS) capacitor c=1.61889e-16
C8 (net82 VSS) capacitor c=1.96601e-16
C9 (\1\:C0 VSS) capacitor c=1.51599e-16
C10 (\1\:B0 VSS) capacitor c=1.69855e-16
C11 (\6\:A0 VSS) capacitor c=5.37235e-17
C12 (\1\:A1 VSS) capacitor c=4.91087e-17
C13 (\4\:A1 VSS) capacitor c=4.26646e-17
C14 (\1\:A0 VSS) capacitor c=4.80516e-17
C15 (\3\:A1 VSS) capacitor c=1.10667e-16
C16 (\2\:A0 VSS) capacitor c=3.35101e-16
C17 (\1\:Y VSS) capacitor c=1.14439e-16
C18 (\6\:net91 VSS) capacitor c=9.37511e-17
C19 (\6\:VDD VSS) capacitor c=4.48313e-17
C20 (\8\:Y VSS) capacitor c=5.26868e-17
C21 (\6\:Y VSS) capacitor c=5.26484e-17
C22 (\4\:Y VSS) capacitor c=6.52784e-17
C23 (\2\:A1 VSS) capacitor c=4.35268e-17
C24 (\8\:A1 VSS) capacitor c=3.21928e-17
C25 (\9\:A1 VSS) capacitor c=6.73711e-17
C26 (\7\:B0 VSS) capacitor c=3.79136e-17
C27 (\3\:Y VSS) capacitor c=4.30019e-17
C28 (\7\:C0 VSS) capacitor c=4.26276e-17
Rk18 (C0 \7\:C0) resistor r=0.04844 c=0
Rk1 (\7\:A1 \8\:A1) resistor r=0.001734 c=0
Rk2 (\9\:A1 A1) resistor r=0.001734 c=0
Rk3 (\8\:A1 \9\:A1) resistor r=0.06012 c=0
Rk9 (\7\:B0 B0) resistor r=0.1081 c=0
Rk10 (\2\:Y Y) resistor r=0.7072 c=0
Rk11 (Y \3\:Y) resistor r=0.08439 c=0
Rk12 (\3\:Y \5\:Y) resistor r=0.3749 c=0
Rk13 (\3\:Y \7\:Y) resistor r=0.1174 c=0
Rk14 (\7\:Y \9\:Y) resistor r=0.3374 c=0
Rk29 (VDD \7\:VDD) resistor r=0.2473 c=0
Rk5 (\2\:A0 A0) resistor r=0.03871 c=0
Rk23 (\7\:VSS VSS) resistor r=0.09483 c=0
Rk22 (\1\:VSS \7\:VSS) resistor r=0.3005 c=0
Rk26 (\7\:VSS \13\:VSS) resistor r=0.2039 c=0
Rk8 (net91 \7\:net91) resistor r=0.4201 c=0
Rl3 (\2\:A1 \1\:A1) resistor r=73.5354 c=0
Rl5 (\2\:A1 \4\:A1) resistor r=54.3046 c=0
Rl4 (\2\:A1 \3\:A1) resistor r=24.0112 c=0
Rl9 (\2\:A0 \6\:A0) resistor r=33.3841 c=0
Rl1 (\2\:A0 \1\:A0) resistor r=28.6412 c=0
Rz1 (\5\:Y \4\:Y) resistor r=75 c=0
Rz2 (\7\:Y \6\:Y) resistor r=75 c=0
Rz3 (\9\:Y \8\:Y) resistor r=75 c=0
Rz7 (\13\:VSS \12\:VSS) resistor r=75 c=0
Ry4 (\2\:Y \1\:Y) resistor r=31 c=0
Ry10 (\7\:VDD \6\:VDD) resistor r=62 c=0
Ry3 (\7\:net91 \6\:net91) resistor r=62 c=0
Rx5 (\7\:C0 \1\:C0) resistor r=45 c=0
Rx1 (\7\:A1 \3\:A1) resistor r=45 c=0
Rx4 (\7\:B0 \1\:B0) resistor r=45 c=0
mn0_1__rcx (10 \1\:A0 \12\:VSS VSS) g45n1lvt w=(2.6e-07) l=4.5e-08 nf=1 \
        as=3.64e-14 ad=1.82e-14 ps=8e-07 pd=6.6e-07 nrd=1.16667 \
        nrs=1.16667 sa=1.4e-07 sb=1.545e-06 sd=160n sca=9.14564 \
        scb=0.00759168 scc=0.000213449 m=(1)
mn1_1__rcx (\4\:Y \4\:A1 10 VSS) g45n1lvt w=(2.6e-07) l=4.5e-08 nf=1 \
        as=1.82e-14 ad=4.16e-14 ps=6.6e-07 pd=8.4e-07 nrd=1.16667 \
        nrs=1.16667 sa=2.55e-07 sb=1.43e-06 sd=160n sca=9.14564 \
        scb=0.00759168 scc=0.000213449 m=(1)
mn1 (\4\:Y \1\:A1 11 VSS) g45n1lvt w=(2.6e-07) l=4.5e-08 nf=1 as=1.56e-14 \
        ad=4.16e-14 ps=6.4e-07 pd=8.4e-07 nrd=1.16667 nrs=1.16667 \
        sa=4.6e-07 sb=1.225e-06 sd=160n sca=9.14564 scb=0.00759168 \
        scc=0.000213449 m=(1)
mn0 (11 \6\:A0 \1\:VSS VSS) g45n1lvt w=(2.6e-07) l=4.5e-08 nf=1 \
        as=7.54e-14 ad=1.56e-14 ps=1.1e-06 pd=6.4e-07 nrd=1.16667 \
        nrs=1.16667 sa=5.65e-07 sb=1.12e-06 sd=160n sca=9.14564 \
        scb=0.00759168 scc=0.000213449 m=(1)
mn3_1__rcx (\8\:Y \1\:C0 \1\:VSS VSS) g45n1lvt w=(2.6e-07) l=4.5e-08 \
        nf=1 as=4.29e-14 ad=4.16e-14 ps=8.5e-07 pd=8.4e-07 nrd=1.16667 \
        nrs=1.16667 sa=1.34e-06 sb=3.45e-07 sd=160n sca=9.14564 \
        scb=0.00759168 scc=0.000213449 m=(2)
mn2_1__rcx (\6\:Y \1\:B0 \1\:VSS VSS) g45n1lvt w=(2.6e-07) l=4.5e-08 \
        nf=1 as=6.24e-14 ad=4.16e-14 ps=1e-06 pd=8.4e-07 nrd=1.16667 \
        nrs=1.16667 sa=9e-07 sb=7.85e-07 sd=160n sca=9.14564 \
        scb=0.00759168 scc=0.000213449 m=(2)
ends AOI211X2
// End of subcircuit definition.
