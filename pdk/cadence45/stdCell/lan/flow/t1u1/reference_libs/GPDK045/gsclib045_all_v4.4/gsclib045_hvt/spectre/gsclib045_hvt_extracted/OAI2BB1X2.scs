// Generated for: spectre (May  1 09:19:07 2013 )
// Library name: gsclib045_hvt
// Cell name: OAI2BB1X2
// View name: extracted

simulator lang=spectre

subckt OAI2BB1X2 A0N A1N B0 VDD VSS Y
mp2 (\1\:Y \2\:B0 \3\:VDD VDD) g45p1hvt w=(3.9e-07) l=4.5e-08 nf=1 \
        as=6.496e-14 ad=6.24e-14 ps=1.335e-06 pd=1.1e-06 nrd=1.16667 \
        nrs=1.16667 sa=1.4e-07 sb=9.90641e-07 sd=160n sca=17.4719 \
        scb=0.0181939 scc=0.00043542 m=(2)
mp3 (\1\:Y n0 \10\:VDD VDD) g45p1hvt w=(3.9e-07) l=4.5e-08 nf=1 \
        as=6.24e-14 ad=6.24e-14 ps=1.1e-06 pd=1.1e-06 nrd=1.16667 \
        nrs=1.16667 sa=3.45e-07 sb=7.85641e-07 sd=160n sca=13.3812 \
        scb=0.0112303 scc=0.000237076 m=(2)
C1 (A0N VSS) capacitor c=2.66574e-17
C2 (B0 VSS) capacitor c=1.71276e-17
C3 (VDD VSS) capacitor c=1.64429e-16
C4 (Y VSS) capacitor c=1.94359e-17
C5 (A1N VSS) capacitor c=3.36761e-17
C6 (8 VSS) capacitor c=1.49756e-18
C7 (n0 VSS) capacitor c=8.79837e-17
C8 (\4\:A1N VSS) capacitor c=3.00066e-17
C9 (\1\:A0N VSS) capacitor c=4.96636e-17
C10 (\3\:A1N VSS) capacitor c=2.94001e-17
C11 (\3\:A0N VSS) capacitor c=2.85989e-17
C12 (\6\:B0 VSS) capacitor c=6.18272e-17
C13 (\4\:n0 VSS) capacitor c=5.57581e-17
C14 (\6\:n0 VSS) capacitor c=6.38255e-17
C15 (\1\:B0 VSS) capacitor c=5.43613e-17
C16 (\1\:A1N VSS) capacitor c=1.46313e-17
C17 (\2\:A0N VSS) capacitor c=3.75982e-17
C18 (\2\:B0 VSS) capacitor c=3.40143e-16
C19 (\1\:VDD VSS) capacitor c=1.80669e-17
C20 (\7\:n0 VSS) capacitor c=1.98354e-17
C21 (\1\:Y VSS) capacitor c=1.44785e-16
C22 (\10\:VDD VSS) capacitor c=3.50617e-17
C23 (\11\:n0 VSS) capacitor c=4.43448e-17
C24 (\7\:Y VSS) capacitor c=8.67361e-17
C25 (\3\:n0 VSS) capacitor c=4.40243e-17
C26 (\2\:A1N VSS) capacitor c=3.1025e-17
C27 (\4\:Y VSS) capacitor c=6.69238e-17
C28 (\4\:A0N VSS) capacitor c=7.18065e-17
C29 (\9\:n0 VSS) capacitor c=1.01128e-16
C30 (\10\:n0 VSS) capacitor c=8.7895e-17
C31 (\5\:A1N VSS) capacitor c=4.60803e-17
C32 (\3\:VDD VSS) capacitor c=7.92567e-17
Rk22 (\2\:VSS \4\:VSS) resistor r=0.3579 c=0
Rk24 (\5\:VSS VSS) resistor r=0.1068 c=0
Rk23 (\4\:VSS \5\:VSS) resistor r=0.2916 c=0
Rk25 (\5\:VSS \7\:VSS) resistor r=0.2766 c=0
Rk9 (\4\:A0N A0N) resistor r=0.07481 c=0
Rk8 (\2\:B0 B0) resistor r=0.005177 c=0
Rk18 (\3\:VDD VDD) resistor r=0.05692 c=0
Rk14 (\2\:VDD \3\:VDD) resistor r=0.2879 c=0
Rk20 (\3\:VDD \11\:VDD) resistor r=0.1812 c=0
Rk3 (\4\:Y Y) resistor r=0.03517 c=0
Rk2 (\1\:Y \4\:Y) resistor r=0.1798 c=0
Rk5 (\4\:Y \8\:Y) resistor r=0.5502 c=0
Rk13 (A1N \5\:A1N) resistor r=0.2077 c=0
Rk10 (\8\:n0 \9\:n0) resistor r=0.09629 c=0
Rk11 (\9\:n0 \10\:n0) resistor r=0.4716 c=0
Rk12 (\9\:n0 \12\:n0) resistor r=0.3874 c=0
Rl10 (\1\:A0N \2\:A0N) resistor r=98.7687 c=0
Rl11 (\2\:A0N \3\:A0N) resistor r=44.9225 c=0
Rl9 (\2\:B0 \6\:B0) resistor r=40.1797 c=0
Rl1 (\2\:B0 \1\:B0) resistor r=40.1797 c=0
Rl14 (\2\:A1N \4\:A1N) resistor r=74.7141 c=0
Rl13 (\2\:A1N \3\:A1N) resistor r=86.2526 c=0
Rl12 (\1\:A1N \2\:A1N) resistor r=29.0533 c=0
Rl4 (\3\:n0 n0) resistor r=10.2925 c=0
Rl5 (\3\:n0 \4\:n0) resistor r=86.6019 c=0
Rl7 (\3\:n0 \6\:n0) resistor r=136.023 c=0
Rz4 (\1\:VSS \2\:VSS) resistor r=75 c=0
Rz5 (\6\:VSS \7\:VSS) resistor r=75 c=0
Rz1 (\8\:Y \7\:Y) resistor r=75 c=0
Rz2 (\12\:n0 \11\:n0) resistor r=75 c=0
Ry4 (\2\:VDD \1\:VDD) resistor r=62 c=0
Ry6 (\11\:VDD \10\:VDD) resistor r=62 c=0
Ry3 (\8\:n0 \7\:n0) resistor r=62 c=0
Rx3 (\2\:A0N \4\:A0N) resistor r=45 c=0
Rx5 (\1\:A1N \5\:A1N) resistor r=45 c=0
Rx4 (\10\:n0 n0) resistor r=45 c=0
mn2_1__rcx (8 \1\:B0 \6\:VSS VSS) g45n1hvt w=(2.6e-07) l=4.5e-08 nf=1 \
        as=3.64e-14 ad=1.56e-14 ps=8e-07 pd=6.4e-07 nrd=1.16667 \
        nrs=1.16667 sa=1.4e-07 sb=8.89615e-07 sd=160n sca=16.3874 \
        scb=0.0162972 scc=0.00139495 m=(1)
mn3_1__rcx (\7\:Y \6\:n0 8 VSS) g45n1hvt w=(2.6e-07) l=4.5e-08 nf=1 \
        as=1.56e-14 ad=4.16e-14 ps=6.4e-07 pd=8.4e-07 nrd=1.16667 \
        nrs=1.16667 sa=2.45e-07 sb=7.84615e-07 sd=160n sca=16.3874 \
        scb=0.0162972 scc=0.00139495 m=(1)
mn3 (\7\:Y \4\:n0 9 VSS) g45n1hvt w=(2.6e-07) l=4.5e-08 nf=1 as=1.56e-14 \
        ad=4.16e-14 ps=6.4e-07 pd=8.4e-07 nrd=1.16667 nrs=1.16667 \
        sa=4.5e-07 sb=5.79615e-07 sd=160n sca=16.3874 scb=0.0162972 \
        scc=0.00139495 m=(1)
mn2 (9 \6\:B0 \1\:VSS VSS) g45n1hvt w=(2.6e-07) l=4.5e-08 nf=1 \
        as=5.887e-14 ad=1.56e-14 ps=1.11e-06 pd=6.4e-07 nrd=1.16667 \
        nrs=1.16667 sa=5.55e-07 sb=4.74615e-07 sd=160n sca=16.3874 \
        scb=0.0162972 scc=0.00139495 m=(1)
mn0 (n1 \3\:A0N \1\:VSS VSS) g45n1hvt w=(1.45e-07) l=4.5e-08 nf=1 \
        as=5.887e-14 ad=3.117e-14 ps=1.11e-06 pd=7.2e-07 nrd=1.16667 \
        nrs=1.16667 sa=8.95e-07 sb=4e-07 sd=160n sca=21.4614 scb=0.0218523 \
        scc=0.00230065 m=(1)
mn1 (\11\:n0 \3\:A1N n1 VSS) g45n1hvt w=(1.45e-07) l=4.5e-08 nf=1 \
        as=3.117e-14 ad=2.03e-14 ps=7.2e-07 pd=5.7e-07 nrd=1.16667 \
        nrs=1.16667 sa=1.155e-06 sb=1.4e-07 sd=160n sca=21.4614 \
        scb=0.0218523 scc=0.00230065 m=(1)
mp0 (\7\:n0 \1\:A0N \3\:VDD VDD) g45p1hvt w=(2.15e-07) l=4.5e-08 nf=1 \
        as=7.532e-14 ad=4.622e-14 ps=1.61e-06 pd=8.6e-07 nrd=1.16667 \
        nrs=1.16667 sa=9.95e-07 sb=3.6e-07 sd=160n sca=13.2854 \
        scb=0.0114741 scc=0.000332863 m=(1)
mp1 (\7\:n0 \4\:A1N \1\:VDD VDD) g45p1hvt w=(2.15e-07) l=4.5e-08 nf=1 \
        as=4.615e-14 ad=4.622e-14 ps=1.42e-06 pd=8.6e-07 nrd=1.16667 \
        nrs=1.16667 sa=1.255e-06 sb=1e-07 sd=160n sca=16.6544 \
        scb=0.0167336 scc=0.000417003 m=(1)
ends OAI2BB1X2
// End of subcircuit definition.
