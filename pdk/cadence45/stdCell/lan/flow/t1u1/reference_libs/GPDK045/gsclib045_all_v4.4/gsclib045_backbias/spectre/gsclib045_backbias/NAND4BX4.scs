// gsclib045_backbias/NAND4BX4/schematic

simulator lang=spectre

subckt NAND4BX4 AN B C D Y NW VSS VDD
mn4 (Y D net130 VSS) g45n1svt w=(1.04u) l=45n nf=1 m=(1)
mn2 (net126 B net122 VSS) g45n1svt w=(1.04u) l=45n nf=1 m=(1)
mn1 (net122 net118 VSS VSS) g45n1svt w=(1.04u) l=45n nf=1 m=(1)
mn0 (net118 AN VSS VSS) g45n1svt w=(260n) l=45n nf=1 m=(1)
mn3 (net130 C net126 VSS) g45n1svt w=(1.04u) l=45n nf=1 m=(1)
mp4 (Y D VDD NW) g45p1svt w=(1.56u) l=45n nf=1 m=(1)
mp1 (Y net118 VDD NW) g45p1svt w=(1.56u) l=45n nf=1 m=(1)
mp2 (Y B VDD NW) g45p1svt w=(1.56u) l=45n nf=1 m=(1)
mp0 (net118 AN VDD NW) g45p1svt w=(390n) l=45n nf=1 m=(1)
mp3 (Y C VDD NW) g45p1svt w=(1.56u) l=45n nf=1 m=(1)
ends NAND4BX4
