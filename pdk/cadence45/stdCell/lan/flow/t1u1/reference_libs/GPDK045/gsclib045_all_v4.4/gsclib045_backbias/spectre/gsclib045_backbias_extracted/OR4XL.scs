// Generated for: spectre (May  1 11:32:06 2013 )
// Library name: gsclib045_backbias
// Cell name: OR4XL
// View name: extracted

simulator lang=spectre

subckt OR4XL A B C D NW VDD VSS Y
mp3 (\6\:n0 \1\:D n3 NW) g45p1svt w=(2.15e-07) l=4.5e-08 nf=1 \
        as=2.472e-14 ad=3.01e-14 ps=6.6e-07 pd=7.1e-07 nrd=1.16667 \
        nrs=1.16667 sa=1.4e-07 sb=1.13e-06 sd=160n sca=14.0155 \
        scb=0.0121212 scc=0.000127529 m=(1)
mp2 (n3 \1\:C n2 NW) g45p1svt w=(2.15e-07) l=4.5e-08 nf=1 as=3.225e-14 \
        ad=2.472e-14 ps=7.3e-07 pd=6.6e-07 nrd=1.16667 nrs=1.16667 \
        sa=3e-07 sb=9.7e-07 sd=160n sca=11.8523 scb=0.00867586 \
        scc=8.03921e-05 m=(1)
mp1 (n2 \1\:B n1 NW) g45p1svt w=(2.15e-07) l=4.5e-08 nf=1 as=5.697e-14 \
        ad=3.225e-14 ps=9.6e-07 pd=7.3e-07 nrd=1.16667 nrs=1.16667 \
        sa=4.95e-07 sb=7.75e-07 sd=160n sca=11.0003 scb=0.00769296 \
        scc=7.77264e-05 m=(1)
mp0 (n1 \3\:A \1\:VDD NW) g45p1svt w=(2.15e-07) l=4.5e-08 nf=1 \
        as=4.192e-14 ad=5.697e-14 ps=8.2e-07 pd=9.6e-07 nrd=1.16667 \
        nrs=1.16667 sa=8.05e-07 sb=4.65e-07 sd=160n sca=12.0313 \
        scb=0.00891071 scc=8.16109e-05 m=(1)
mp4 (\3\:Y \3\:n0 \1\:VDD NW) g45p1svt w=(2.15e-07) l=4.5e-08 nf=1 \
        as=4.192e-14 ad=4.837e-14 ps=8.2e-07 pd=8.8e-07 nrd=1.16667 \
        nrs=1.16667 sa=1.045e-06 sb=2.25e-07 sd=160n sca=17.0817 \
        scb=0.0174363 scc=0.000365094 m=(1)
C1 (NW VSS) capacitor c=2.66488e-16
C2 (Y VSS) capacitor c=3.95712e-17
C3 (B VSS) capacitor c=2.69959e-17
C4 (VDD VSS) capacitor c=9.57011e-17
C5 (C VSS) capacitor c=1.24804e-16
C6 (D VSS) capacitor c=8.33664e-17
C7 (A VSS) capacitor c=9.7743e-17
C8 (n0 VSS) capacitor c=4.859e-17
C9 (n3 VSS) capacitor c=3.83579e-18
C10 (n2 VSS) capacitor c=5.6746e-18
C11 (n1 VSS) capacitor c=5.65278e-18
C12 (\3\:n0 VSS) capacitor c=2.66891e-17
C13 (\3\:A VSS) capacitor c=5.01937e-17
C14 (\1\:B VSS) capacitor c=5.23682e-17
C15 (\1\:C VSS) capacitor c=4.42053e-17
C16 (\1\:D VSS) capacitor c=6.48615e-17
C17 (\1\:A VSS) capacitor c=2.46875e-17
C18 (\3\:B VSS) capacitor c=3.86129e-17
C19 (\3\:C VSS) capacitor c=6.97146e-17
C20 (\3\:D VSS) capacitor c=2.80816e-17
C21 (\2\:n0 VSS) capacitor c=4.04584e-17
C22 (\2\:A VSS) capacitor c=4.19635e-17
C23 (\2\:B VSS) capacitor c=5.04384e-17
C24 (\2\:C VSS) capacitor c=6.62215e-17
C25 (\2\:D VSS) capacitor c=5.09372e-17
C26 (\3\:Y VSS) capacitor c=6.89425e-17
C27 (\1\:VDD VSS) capacitor c=1.3498e-16
C28 (\6\:n0 VSS) capacitor c=5.08421e-17
C29 (\1\:Y VSS) capacitor c=1.55332e-17
C30 (\8\:n0 VSS) capacitor c=8.51134e-17
C31 (\10\:n0 VSS) capacitor c=3.39474e-17
C32 (\4\:B VSS) capacitor c=1.00364e-16
C33 (\4\:n0 VSS) capacitor c=7.45597e-17
C34 (\5\:n0 VSS) capacitor c=1.05418e-16
Rk9 (Y \2\:Y) resistor r=0.02687 c=0
Rk10 (Y \4\:Y) resistor r=0.4657 c=0
Rk3 (B \4\:B) resistor r=0.02479 c=0
Rk17 (\2\:VDD VDD) resistor r=0.7511 c=0
Rk11 (\2\:VSS \4\:VSS) resistor r=0.4751 c=0
Rk12 (\4\:VSS \5\:VSS) resistor r=0.05477 c=0
Rk14 (\6\:VSS VSS) resistor r=0.09449 c=0
Rk13 (\5\:VSS \6\:VSS) resistor r=0.1995 c=0
Rk15 (\5\:VSS \8\:VSS) resistor r=0.07288 c=0
Rk16 (\6\:VSS \10\:VSS) resistor r=0.07288 c=0
Rk2 (\4\:C C) resistor r=0.003669 c=0
Rk1 (\4\:D D) resistor r=0.002985 c=0
Rk4 (\4\:A A) resistor r=0.006404 c=0
Rk5 (\4\:n0 \5\:n0) resistor r=0.3414 c=0
Rk6 (\5\:n0 \7\:n0) resistor r=0.4795 c=0
Rk7 (\5\:n0 \9\:n0) resistor r=0.5125 c=0
Rk8 (\9\:n0 \11\:n0) resistor r=0.2875 c=0
Rl5 (\1\:B \2\:B) resistor r=173.769 c=0
Rl6 (\2\:B \3\:B) resistor r=62.2302 c=0
Rl3 (\1\:C \2\:C) resistor r=46.8456 c=0
Rl4 (\2\:C \3\:C) resistor r=189.153 c=0
Rl1 (\1\:D \2\:D) resistor r=202.043 c=0
Rl2 (\2\:D \3\:D) resistor r=41.5405 c=0
Rl8 (\2\:A \3\:A) resistor r=197.253 c=0
Rl7 (\1\:A \2\:A) resistor r=40.3846 c=0
Rl10 (\2\:n0 \3\:n0) resistor r=29.9451 c=0
Rl9 (n0 \2\:n0) resistor r=207.692 c=0
Rz3 (\1\:Y \2\:Y) resistor r=75 c=0
Rz4 (\1\:VSS \2\:VSS) resistor r=75 c=0
Rz5 (\7\:VSS \8\:VSS) resistor r=75 c=0
Rz6 (\9\:VSS \10\:VSS) resistor r=75 c=0
Rz1 (\8\:n0 \9\:n0) resistor r=75 c=0
Rz2 (\10\:n0 \11\:n0) resistor r=75 c=0
Ry2 (\3\:Y \4\:Y) resistor r=62 c=0
Ry4 (\1\:VDD \2\:VDD) resistor r=62 c=0
Ry1 (\6\:n0 \7\:n0) resistor r=62 c=0
Rx3 (\2\:B \4\:B) resistor r=45 c=0
Rx2 (\2\:C \4\:C) resistor r=45 c=0
Rx1 (\2\:D \4\:D) resistor r=45 c=0
Rx4 (\2\:A \4\:A) resistor r=45 c=0
Rx5 (\2\:n0 \4\:n0) resistor r=45 c=0
mn3 (\10\:n0 \3\:D \9\:VSS VSS) g45n1svt w=(1.45e-07) l=4.5e-08 nf=1 \
        as=3.74e-14 ad=2.32e-14 ps=1.21e-06 pd=6.1e-07 nrd=1.16667 \
        nrs=1.16667 sa=1e-07 sb=1.175e-06 sd=160n sca=10.0732 \
        scb=0.00911402 scc=0.000253284 m=(1)
mn2 (\10\:n0 \3\:C \7\:VSS VSS) g45n1svt w=(1.45e-07) l=4.5e-08 nf=1 \
        as=4.465e-14 ad=2.32e-14 ps=1.31e-06 pd=6.1e-07 nrd=1.16667 \
        nrs=1.16667 sa=3.05e-07 sb=9.7e-07 sd=160n sca=10.0732 \
        scb=0.00911402 scc=0.000253284 m=(1)
mn1 (\8\:n0 \3\:B \7\:VSS VSS) g45n1svt w=(1.45e-07) l=4.5e-08 nf=1 \
        as=4.465e-14 ad=4.64e-14 ps=1.31e-06 pd=9.3e-07 nrd=1.16667 \
        nrs=1.16667 sa=5e-07 sb=7.75e-07 sd=160n sca=10.0732 \
        scb=0.00911402 scc=0.000253284 m=(1)
mn0 (\8\:n0 \1\:A \1\:VSS VSS) g45n1svt w=(1.45e-07) l=4.5e-08 nf=1 \
        as=2.827e-14 ad=4.64e-14 ps=6.8e-07 pd=9.3e-07 nrd=1.16667 \
        nrs=1.16667 sa=8.65e-07 sb=4.1e-07 sd=160n sca=10.0732 \
        scb=0.00911402 scc=0.000253284 m=(1)
mn4 (\1\:Y n0 \1\:VSS VSS) g45n1svt w=(1.45e-07) l=4.5e-08 nf=1 \
        as=2.827e-14 ad=2.465e-14 ps=6.8e-07 pd=6.3e-07 nrd=1.16667 \
        nrs=1.16667 sa=1.105e-06 sb=1.7e-07 sd=160n sca=10.0732 \
        scb=0.00911402 scc=0.000253284 m=(1)
ends OR4XL
// End of subcircuit definition.
