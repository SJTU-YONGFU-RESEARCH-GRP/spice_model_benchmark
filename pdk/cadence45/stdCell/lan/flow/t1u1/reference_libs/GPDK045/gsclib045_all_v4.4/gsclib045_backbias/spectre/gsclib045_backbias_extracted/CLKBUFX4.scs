// Generated for: spectre (May  1 11:28:17 2013 )
// Library name: gsclib045_backbias
// Cell name: CLKBUFX4
// View name: extracted

simulator lang=spectre

subckt CLKBUFX4 A NW VDD VSS Y
mp0 (\13\:net44 \1\:A VDD NW) g45p1svt w=(3.9e-07) l=4.5e-08 nf=1 \
        as=6.24e-14 ad=5.46e-14 ps=1.1e-06 pd=1.06e-06 nrd=1.16667 \
        nrs=1.16667 sa=9.75e-07 sb=1.4e-07 sd=160n sca=20.4961 \
        scb=0.0204164 scc=0.00119548 m=(1)
mp1 (\1\:Y net44 VDD NW) g45p1svt w=(3.9e-07) l=4.5e-08 nf=1 \
        as=6.337e-14 ad=6.24e-14 ps=1.105e-06 pd=1.1e-06 nrd=1.16667 \
        nrs=1.16667 sa=1.4e-07 sb=9.75e-07 sd=160n sca=29.498 \
        scb=0.0332632 scc=0.00250913 m=(4)
C1 (NW VSS) capacitor c=2.03539e-16
C2 (Y VSS) capacitor c=2.32191e-17
C3 (A VSS) capacitor c=5.05255e-17
C4 (VDD VSS) capacitor c=3.56112e-16
C5 (net44 VSS) capacitor c=3.62223e-16
C6 (\1\:A VSS) capacitor c=4.31658e-17
C7 (\3\:A VSS) capacitor c=4.52905e-17
C8 (\2\:A VSS) capacitor c=3.92039e-17
C9 (\13\:net44 VSS) capacitor c=6.50883e-17
C10 (\1\:Y VSS) capacitor c=2.01098e-16
C11 (\18\:net44 VSS) capacitor c=3.27427e-17
C12 (\6\:Y VSS) capacitor c=1.79263e-16
C13 (\4\:A VSS) capacitor c=3.46916e-17
C14 (\15\:net44 VSS) capacitor c=5.94674e-17
Rk2 (\1\:Y Y) resistor r=0.09251 c=0
Rk4 (Y \6\:Y) resistor r=0.2245 c=0
Rk7 (\4\:A A) resistor r=0.04123 c=0
Rk9 (\15\:net44 net44) resistor r=0.3253 c=0
Rk8 (\14\:net44 \15\:net44) resistor r=0.3896 c=0
Rk11 (\15\:net44 \19\:net44) resistor r=0.1771 c=0
Rl11 (\1\:A \2\:A) resistor r=55.0021 c=0
Rl12 (\2\:A \3\:A) resistor r=105.002 c=0
Rz3 (\19\:net44 \18\:net44) resistor r=37.5 c=0
Ry3 (\14\:net44 \13\:net44) resistor r=20.6667 c=0
Rx1 (\2\:A \4\:A) resistor r=45 c=0
mn0 (\18\:net44 \3\:A VSS VSS) g45n1svt w=(2.6e-07) l=4.5e-08 nf=1 \
        as=4.16e-14 ad=3.64e-14 ps=8.4e-07 pd=8e-07 nrd=1.16667 \
        nrs=1.16667 sa=9.75e-07 sb=1.4e-07 sd=160n sca=7.84363 \
        scb=0.00546499 scc=9.84911e-05 m=(1)
mn1 (\6\:Y net44 VSS VSS) g45n1svt w=(2.6e-07) l=4.5e-08 nf=1 \
        as=4.225e-14 ad=4.16e-14 ps=8.45e-07 pd=8.4e-07 nrd=1.16667 \
        nrs=1.16667 sa=1.4e-07 sb=9.75e-07 sd=160n sca=7.84363 \
        scb=0.00546499 scc=9.84911e-05 m=(4)
ends CLKBUFX4
// End of subcircuit definition.
