// Generated for: spectre (May  1 09:15:28 2013 )
// Library name: gsclib045_hvt
// Cell name: SDFFNSRX1
// View name: extracted

simulator lang=spectre

subckt SDFFNSRX1 CKN D Q QN RN SE SI SN VDD VSS
mp57 (\1\:QN \4\:qint \30\:VDD VDD) g45p1hvt w=(3.9e-07) l=4.5e-08 nf=1 \
        as=5.728e-14 ad=5.46e-14 ps=1.15e-06 pd=1.06e-06 nrd=1.16667 \
        nrs=1.16667 sa=1.4e-07 sb=2.48846e-07 sd=160n sca=34.3332 \
        scb=0.0249008 scc=0.00341086 m=(1)
mp55 (\1\:Q \5\:qbint \27\:VDD VDD) g45p1hvt w=(3.9e-07) l=4.5e-08 nf=1 \
        as=6.48e-14 ad=5.46e-14 ps=1.22e-06 pd=1.06e-06 nrd=1.16667 \
        nrs=1.16667 sa=1.4e-07 sb=3.01218e-07 sd=160n sca=12.7076 \
        scb=0.0112318 scc=0.000478212 m=(1)
C1 (SE VSS) capacitor c=4.19628e-17
C2 (SN VSS) capacitor c=2.95378e-16
C3 (SI VSS) capacitor c=7.37479e-17
C4 (QN VSS) capacitor c=2.29645e-17
C5 (VDD VSS) capacitor c=5.37872e-16
C6 (RN VSS) capacitor c=9.0983e-17
C7 (D VSS) capacitor c=1.41783e-16
C8 (Q VSS) capacitor c=6.65284e-17
C9 (qint VSS) capacitor c=2.0377e-17
C10 (qbint VSS) capacitor c=2.92086e-17
C11 (RNb VSS) capacitor c=7.56315e-17
C12 (n35 VSS) capacitor c=4.01964e-17
C13 (net498 VSS) capacitor c=9.06534e-17
C14 (net0363 VSS) capacitor c=7.30516e-17
C15 (CKNbb VSS) capacitor c=4.68903e-17
C16 (mout VSS) capacitor c=6.63689e-17
C17 (CKNb VSS) capacitor c=2.7227e-17
C18 (net521 VSS) capacitor c=7.87951e-17
C19 (n20 VSS) capacitor c=5.52088e-17
C20 (Db VSS) capacitor c=1.18954e-16
C21 (SEb VSS) capacitor c=6.11984e-17
C22 (net566 VSS) capacitor c=1.15171e-16
C23 (net414 VSS) capacitor c=1.07971e-18
C24 (net478 VSS) capacitor c=3.56466e-18
C25 (net486 VSS) capacitor c=6.62353e-19
C26 (net461 VSS) capacitor c=1.96861e-18
C27 (net453 VSS) capacitor c=1.92664e-18
C28 (\4\:SE VSS) capacitor c=5.89487e-17
C29 (\3\:SI VSS) capacitor c=7.81982e-17
C30 (\3\:SEb VSS) capacitor c=6.04665e-17
C31 (\3\:SE VSS) capacitor c=7.3531e-17
C32 (\1\:D VSS) capacitor c=3.61837e-17
C33 (\1\:CKN VSS) capacitor c=5.45375e-17
C34 (\8\:CKNb VSS) capacitor c=1.72565e-17
C35 (\9\:CKNb VSS) capacitor c=2.87462e-17
C36 (\6\:CKNbb VSS) capacitor c=6.07165e-17
C37 (\4\:SN VSS) capacitor c=5.84399e-17
C38 (\4\:RNb VSS) capacitor c=6.30609e-17
C39 (\4\:CKNbb VSS) capacitor c=3.59257e-17
C40 (\7\:CKNb VSS) capacitor c=6.08488e-17
C41 (\2\:RNb VSS) capacitor c=7.83253e-17
C42 (\7\:qbint VSS) capacitor c=9.59559e-17
C43 (\1\:SN VSS) capacitor c=3.40714e-17
C44 (\1\:RN VSS) capacitor c=4.09632e-17
C45 (\5\:qbint VSS) capacitor c=4.87568e-17
C46 (\6\:qbint VSS) capacitor c=2.94457e-17
C47 (\4\:qint VSS) capacitor c=4.49963e-17
C48 (\6\:SE VSS) capacitor c=3.46009e-17
C49 (\1\:SI VSS) capacitor c=6.49902e-17
C50 (\1\:SE VSS) capacitor c=3.65266e-17
C51 (\3\:D VSS) capacitor c=9.15627e-17
C52 (\3\:CKN VSS) capacitor c=3.86549e-17
C53 (\8\:CKNbb VSS) capacitor c=5.23156e-17
C54 (\5\:CKNb VSS) capacitor c=1.70034e-16
C55 (\4\:mout VSS) capacitor c=5.30338e-17
C56 (\6\:SN VSS) capacitor c=6.27416e-17
C57 (\3\:n20 VSS) capacitor c=3.82136e-17
C58 (\6\:RNb VSS) capacitor c=5.20989e-17
C59 (\6\:CKNb VSS) capacitor c=1.2463e-16
C60 (\8\:qbint VSS) capacitor c=5.71271e-17
C61 (\3\:SN VSS) capacitor c=5.97005e-17
C62 (\3\:n35 VSS) capacitor c=2.84445e-17
C63 (\3\:RN VSS) capacitor c=4.71581e-17
C64 (\4\:qbint VSS) capacitor c=2.69855e-17
C65 (\3\:qint VSS) capacitor c=3.49122e-17
C66 (\5\:SE VSS) capacitor c=6.03134e-17
C67 (\2\:SI VSS) capacitor c=7.09533e-17
C68 (\2\:SE VSS) capacitor c=7.54309e-17
C69 (\4\:SEb VSS) capacitor c=4.48104e-17
C70 (\2\:SEb VSS) capacitor c=4.72432e-17
C71 (\2\:D VSS) capacitor c=6.12359e-17
C72 (\2\:CKN VSS) capacitor c=4.1341e-17
C73 (\9\:CKNbb VSS) capacitor c=3.42418e-17
C74 (\7\:CKNbb VSS) capacitor c=4.15704e-17
C75 (\3\:mout VSS) capacitor c=2.49659e-17
C76 (\5\:SN VSS) capacitor c=3.56268e-17
C77 (\2\:n20 VSS) capacitor c=3.71833e-17
C78 (\5\:CKNbb VSS) capacitor c=3.26245e-17
C79 (\5\:RNb VSS) capacitor c=1.96892e-17
C80 (\3\:CKNbb VSS) capacitor c=3.41315e-17
C81 (\2\:CKNbb VSS) capacitor c=3.21101e-17
C82 (\3\:RNb VSS) capacitor c=2.72493e-17
C83 (\9\:qbint VSS) capacitor c=2.79955e-17
C84 (\2\:SN VSS) capacitor c=4.30064e-17
C85 (\2\:n35 VSS) capacitor c=2.9378e-17
C86 (\2\:RN VSS) capacitor c=3.90621e-17
C87 (\2\:qbint VSS) capacitor c=3.78229e-17
C88 (\5\:SEb VSS) capacitor c=6.61132e-18
C89 (\13\:VDD VSS) capacitor c=3.54407e-17
C90 (\15\:VDD VSS) capacitor c=4.79952e-17
C91 (\10\:CKNb VSS) capacitor c=7.43328e-17
C92 (\17\:VDD VSS) capacitor c=7.07081e-17
C93 (\17\:CKNbb VSS) capacitor c=8.79104e-17
C94 (\8\:Db VSS) capacitor c=1.00863e-16
C95 (\4\:n20 VSS) capacitor c=7.83963e-17
C96 (\19\:VDD VSS) capacitor c=1.57701e-17
C97 (\11\:mout VSS) capacitor c=3.89186e-17
C98 (\21\:VDD VSS) capacitor c=2.39828e-17
C99 (\9\:mout VSS) capacitor c=8.11302e-17
C100 (\8\:n35 VSS) capacitor c=4.33188e-17
C101 (\23\:VDD VSS) capacitor c=3.8664e-17
C102 (\3\:net566 VSS) capacitor c=1.16554e-16
C103 (\25\:VDD VSS) capacitor c=6.80581e-17
C104 (\14\:qbint VSS) capacitor c=8.15971e-17
C105 (\9\:RNb VSS) capacitor c=1.93784e-16
C106 (\27\:VDD VSS) capacitor c=3.67913e-17
C107 (\1\:Q VSS) capacitor c=4.46882e-17
C108 (\5\:qint VSS) capacitor c=3.56605e-17
C109 (\30\:VDD VSS) capacitor c=5.79745e-17
C110 (\1\:QN VSS) capacitor c=4.79312e-17
C111 (\1\:VDD VSS) capacitor c=8.84738e-17
C112 (\10\:SEb VSS) capacitor c=7.52923e-17
C113 (\6\:Db VSS) capacitor c=2.01113e-17
C114 (\14\:CKNb VSS) capacitor c=4.69219e-17
C115 (\19\:CKNbb VSS) capacitor c=5.7099e-17
C116 (\4\:Db VSS) capacitor c=1.72644e-16
C117 (\7\:n20 VSS) capacitor c=3.66419e-17
C118 (\13\:mout VSS) capacitor c=3.5846e-17
C119 (\3\:net521 VSS) capacitor c=7.16512e-17
C120 (\15\:mout VSS) capacitor c=3.07998e-17
C121 (\4\:n35 VSS) capacitor c=4.075e-17
C122 (\3\:net498 VSS) capacitor c=8.09537e-17
C123 (\3\:net0363 VSS) capacitor c=9.22664e-17
C124 (\11\:qbint VSS) capacitor c=1.52881e-16
C125 (\11\:RNb VSS) capacitor c=9.25158e-17
C126 (\3\:Q VSS) capacitor c=6.87228e-17
C127 (\9\:qint VSS) capacitor c=3.27183e-17
C128 (\3\:QN VSS) capacitor c=3.64168e-17
C129 (\2\:qint VSS) capacitor c=8.29322e-18
C130 (\3\:qbint VSS) capacitor c=3.12911e-17
C131 (\2\:mout VSS) capacitor c=3.76339e-17
C132 (\7\:qint VSS) capacitor c=2.83642e-17
C133 (\8\:qint VSS) capacitor c=2.88464e-17
C134 (\3\:CKNb VSS) capacitor c=2.6036e-17
C135 (\4\:CKNb VSS) capacitor c=6.39705e-17
C136 (\4\:RN VSS) capacitor c=3.87454e-17
C137 (\10\:qbint VSS) capacitor c=7.2917e-17
C138 (\13\:qbint VSS) capacitor c=1.19945e-16
C139 (\6\:n35 VSS) capacitor c=1.70121e-16
C140 (\7\:n35 VSS) capacitor c=1.58674e-16
C141 (\10\:CKNbb VSS) capacitor c=6.89976e-17
C142 (\11\:CKNbb VSS) capacitor c=1.16849e-16
C143 (\7\:RNb VSS) capacitor c=1.37525e-16
C144 (\8\:RNb VSS) capacitor c=3.08792e-16
C145 (\7\:SN VSS) capacitor c=2.62394e-16
C146 (\8\:SN VSS) capacitor c=3.71588e-17
C147 (\5\:mout VSS) capacitor c=4.40426e-17
C148 (\6\:mout VSS) capacitor c=6.22962e-17
C149 (\7\:mout VSS) capacitor c=5.09799e-17
C150 (\8\:mout VSS) capacitor c=5.87382e-17
C151 (\6\:n20 VSS) capacitor c=8.95238e-17
C152 (\9\:n20 VSS) capacitor c=1.01011e-16
C153 (\12\:CKNbb VSS) capacitor c=4.58169e-17
C154 (\13\:CKNbb VSS) capacitor c=1.25533e-16
C155 (\14\:CKNbb VSS) capacitor c=1.49087e-16
C156 (\15\:CKNbb VSS) capacitor c=9.83533e-17
C157 (\16\:CKNbb VSS) capacitor c=9.38172e-17
C158 (\12\:CKNb VSS) capacitor c=6.13384e-17
C159 (\13\:CKNb VSS) capacitor c=3.32995e-17
C160 (\4\:CKN VSS) capacitor c=3.87906e-17
C161 (\6\:CKN VSS) capacitor c=7.83773e-17
C162 (\3\:Db VSS) capacitor c=2.16286e-16
C163 (\7\:SE VSS) capacitor c=3.49437e-17
C164 (\8\:SE VSS) capacitor c=2.69753e-17
C165 (\5\:SI VSS) capacitor c=7.18995e-17
C166 (\7\:SEb VSS) capacitor c=1.08585e-16
C167 (\8\:SEb VSS) capacitor c=1.20851e-16
C168 (\9\:SEb VSS) capacitor c=1.47912e-16
C169 (\12\:SEb VSS) capacitor c=4.11729e-17
C170 (\3\:VDD VSS) capacitor c=2.30328e-17
C171 (\4\:VDD VSS) capacitor c=3.18662e-17
C172 (\6\:VDD VSS) capacitor c=3.08383e-17
C173 (\7\:VDD VSS) capacitor c=5.07725e-17
C174 (\8\:VDD VSS) capacitor c=2.32256e-17
C175 (\10\:VDD VSS) capacitor c=3.86476e-17
C176 (\11\:VDD VSS) capacitor c=3.38959e-17
C177 (\29\:VDD VSS) capacitor c=1.9326e-17
Rk44 (\4\:CKN \5\:CKN) resistor r=0.002026 c=0
Rk45 (CKN \6\:CKN) resistor r=0.001959 c=0
Rk46 (\4\:CKN \6\:CKN) resistor r=0.0678 c=0
Rk62 (\2\:VSS \3\:VSS) resistor r=0.08511 c=0
Rk63 (\3\:VSS \4\:VSS) resistor r=0.4136 c=0
Rk64 (\4\:VSS \5\:VSS) resistor r=0.2532 c=0
Rk65 (\5\:VSS \6\:VSS) resistor r=0.1419 c=0
Rk66 (\6\:VSS \7\:VSS) resistor r=0.5356 c=0
Rk67 (\7\:VSS \8\:VSS) resistor r=0.5242 c=0
Rk68 (\8\:VSS \9\:VSS) resistor r=0.8102 c=0
Rk69 (\9\:VSS \10\:VSS) resistor r=0.3937 c=0
Rk70 (\3\:VSS \12\:VSS) resistor r=0.238 c=0
Rk71 (\4\:VSS \14\:VSS) resistor r=0.2336 c=0
Rk72 (\6\:VSS \16\:VSS) resistor r=0.04334 c=0
Rk73 (\7\:VSS \18\:VSS) resistor r=0.3181 c=0
Rk74 (\9\:VSS \20\:VSS) resistor r=0.07428 c=0
Rk76 (\21\:VSS VSS) resistor r=0.2003 c=0
Rk75 (\10\:VSS \21\:VSS) resistor r=0.3516 c=0
Rk77 (\10\:VSS \23\:VSS) resistor r=0.4344 c=0
Rk78 (\21\:VSS \25\:VSS) resistor r=0.3721 c=0
Rk52 (\7\:SE SE) resistor r=0.09481 c=0
Rk53 (SE \8\:SE) resistor r=0.1194 c=0
Rk23 (\7\:SN SN) resistor r=2.0205 c=0
Rk24 (SN \8\:SN) resistor r=0.07777 c=0
Rk54 (\4\:SI \5\:SI) resistor r=0.004909 c=0
Rk55 (\6\:SI SI) resistor r=0.005032 c=0
Rk56 (\5\:SI \6\:SI) resistor r=0.03605 c=0
Rk2 (\4\:QN QN) resistor r=0.09293 c=0
Rk1 (\2\:QN \4\:QN) resistor r=0.3065 c=0
Rk79 (\2\:VDD \3\:VDD) resistor r=0.09264 c=0
Rk80 (\3\:VDD \4\:VDD) resistor r=0.4236 c=0
Rk81 (\4\:VDD \5\:VDD) resistor r=0.2357 c=0
Rk82 (\5\:VDD \6\:VDD) resistor r=0.07257 c=0
Rk83 (\6\:VDD \7\:VDD) resistor r=0.6068 c=0
Rk84 (\7\:VDD \8\:VDD) resistor r=0.4578 c=0
Rk85 (\8\:VDD \9\:VDD) resistor r=0.06409 c=0
Rk86 (\9\:VDD \10\:VDD) resistor r=0.4163 c=0
Rk87 (\10\:VDD \11\:VDD) resistor r=0.3785 c=0
Rk88 (\11\:VDD \12\:VDD) resistor r=0.4088 c=0
Rk89 (\3\:VDD \14\:VDD) resistor r=0.2004 c=0
Rk90 (\4\:VDD \16\:VDD) resistor r=0.2615 c=0
Rk91 (\6\:VDD \18\:VDD) resistor r=0.4646 c=0
Rk92 (\7\:VDD \20\:VDD) resistor r=0.1031 c=0
Rk93 (\8\:VDD \22\:VDD) resistor r=0.04334 c=0
Rk94 (\10\:VDD \24\:VDD) resistor r=0.1467 c=0
Rk95 (\11\:VDD \26\:VDD) resistor r=0.3354 c=0
Rk96 (\12\:VDD \28\:VDD) resistor r=0.2629 c=0
Rk99 (\29\:VDD VDD) resistor r=0.2003 c=0
Rk97 (\12\:VDD \29\:VDD) resistor r=0.3517 c=0
Rk98 (\29\:VDD \31\:VDD) resistor r=0.4374 c=0
Rk8 (\4\:RN RN) resistor r=0.06442 c=0
Rk47 (\4\:D D) resistor r=0.003698 c=0
Rk6 (\2\:Q Q) resistor r=0.1666 c=0
Rk7 (Q \4\:Q) resistor r=0.3594 c=0
Rk3 (\6\:qint \7\:qint) resistor r=0.115 c=0
Rk4 (\7\:qint \8\:qint) resistor r=0.1197 c=0
Rk5 (\7\:qint \10\:qint) resistor r=0.109 c=0
Rk9 (\10\:qbint \12\:qbint) resistor r=0.5127 c=0
Rk10 (\12\:qbint \13\:qbint) resistor r=0.8441 c=0
Rk11 (\12\:qbint \15\:qbint) resistor r=0.521 c=0
Rk19 (\7\:RNb \8\:RNb) resistor r=1.0744 c=0
Rk20 (\8\:RNb \10\:RNb) resistor r=1.1727 c=0
Rk21 (\10\:RNb \12\:RNb) resistor r=0.4929 c=0
Rk15 (\5\:n35 \6\:n35) resistor r=0.1601 c=0
Rk16 (\6\:n35 \7\:n35) resistor r=1.1429 c=0
Rk17 (\6\:n35 \9\:n35) resistor r=0.1633 c=0
Rk12 (\2\:net498 \4\:net498) resistor r=0.566 c=0
Rk14 (\2\:net0363 \4\:net0363) resistor r=0.362 c=0
Rk18 (\10\:CKNbb \11\:CKNbb) resistor r=0.6298 c=0
Rk35 (\12\:CKNbb \13\:CKNbb) resistor r=0.2124 c=0
Rk36 (\13\:CKNbb \14\:CKNbb) resistor r=0.9087 c=0
Rk37 (\13\:CKNbb \15\:CKNbb) resistor r=0.3464 c=0
Rk38 (\15\:CKNbb \16\:CKNbb) resistor r=0.4627 c=0
Rk39 (\15\:CKNbb \18\:CKNbb) resistor r=0.5214 c=0
Rk40 (\18\:CKNbb \20\:CKNbb) resistor r=0.2704 c=0
Rk25 (\5\:mout \6\:mout) resistor r=0.2305 c=0
Rk26 (\6\:mout \7\:mout) resistor r=0.3334 c=0
Rk27 (\7\:mout \8\:mout) resistor r=0.3185 c=0
Rk28 (\8\:mout \10\:mout) resistor r=0.3831 c=0
Rk29 (\6\:mout \12\:mout) resistor r=0.09453 c=0
Rk30 (\7\:mout \14\:mout) resistor r=0.1023 c=0
Rk31 (\8\:mout \16\:mout) resistor r=0.05885 c=0
Rk41 (\11\:CKNb \12\:CKNb) resistor r=0.5232 c=0
Rk42 (\12\:CKNb \13\:CKNb) resistor r=0.1508 c=0
Rk43 (\12\:CKNb \15\:CKNb) resistor r=0.1836 c=0
Rk22 (\2\:net521 \4\:net521) resistor r=0.4977 c=0
Rk32 (\5\:n20 \6\:n20) resistor r=0.3353 c=0
Rk33 (\6\:n20 \8\:n20) resistor r=0.1457 c=0
Rk34 (\6\:n20 \9\:n20) resistor r=0.5442 c=0
Rk48 (\2\:Db \3\:Db) resistor r=0.52 c=0
Rk49 (\3\:Db \5\:Db) resistor r=1.3689 c=0
Rk50 (\3\:Db \7\:Db) resistor r=0.07507 c=0
Rk51 (\5\:Db \9\:Db) resistor r=0.6202 c=0
Rk57 (\6\:SEb \7\:SEb) resistor r=0.02809 c=0
Rk58 (\7\:SEb \8\:SEb) resistor r=0.3525 c=0
Rk59 (\8\:SEb \9\:SEb) resistor r=0.8647 c=0
Rk60 (\7\:SEb \11\:SEb) resistor r=0.6988 c=0
Rk61 (\8\:SEb \12\:SEb) resistor r=0.1307 c=0
Rk13 (\2\:net566 \4\:net566) resistor r=0.3956 c=0
Rl41 (\1\:CKN \2\:CKN) resistor r=151.923 c=0
Rl42 (\2\:CKN \3\:CKN) resistor r=53.2967 c=0
Rl51 (\4\:SE \5\:SE) resistor r=193.812 c=0
Rl52 (\5\:SE \6\:SE) resistor r=67.9995 c=0
Rl48 (\2\:SE \3\:SE) resistor r=254.568 c=0
Rl47 (\1\:SE \2\:SE) resistor r=74.2328 c=0
Rl27 (\4\:SN \6\:SN) resistor r=157.692 c=0
Rl26 (\4\:SN \5\:SN) resistor r=59.5926 c=0
Rl13 (\1\:SN \2\:SN) resistor r=62.2302 c=0
Rl14 (\2\:SN \3\:SN) resistor r=112.23 c=0
Rl50 (\2\:SI \3\:SI) resistor r=99.2818 c=0
Rl49 (\1\:SI \2\:SI) resistor r=141.668 c=0
Rl9 (\1\:RN \2\:RN) resistor r=96.8456 c=0
Rl10 (\2\:RN \3\:RN) resistor r=89.1533 c=0
Rl43 (\1\:D \2\:D) resistor r=24.2328 c=0
Rl44 (\2\:D \3\:D) resistor r=212.694 c=0
Rl3 (\2\:qint \4\:qint) resistor r=47.791 c=0
Rl2 (\2\:qint \3\:qint) resistor r=36.2526 c=0
Rl1 (qint \2\:qint) resistor r=5.915 c=0
Rl15 (\7\:qbint \8\:qbint) resistor r=200 c=0
Rl16 (\8\:qbint \9\:qbint) resistor r=46.2406 c=0
Rl7 (\2\:qbint \5\:qbint) resistor r=89.9037 c=0
Rl4 (qbint \2\:qbint) resistor r=26.1559 c=0
Rl8 (\3\:qbint \6\:qbint) resistor r=39.6181 c=0
Rl6 (\3\:qbint \4\:qbint) resistor r=49.2335 c=0
Rl5 (\2\:qbint \3\:qbint) resistor r=161.953 c=0
Rl23 (\4\:RNb \6\:RNb) resistor r=157.692 c=0
Rl17 (RNb \2\:RNb) resistor r=264.95 c=0
Rl22 (\4\:RNb \5\:RNb) resistor r=99.5131 c=0
Rl18 (\2\:RNb \3\:RNb) resistor r=24.2328 c=0
Rl11 (n35 \2\:n35) resistor r=119.922 c=0
Rl12 (\2\:n35 \3\:n35) resistor r=39.1533 c=0
Rl32 (\8\:CKNbb \9\:CKNbb) resistor r=49.5519 c=0
Rl31 (\6\:CKNbb \7\:CKNbb) resistor r=24.2328 c=0
Rl20 (\3\:CKNbb \4\:CKNbb) resistor r=53.3592 c=0
Rl21 (\3\:CKNbb \5\:CKNbb) resistor r=97.5374 c=0
Rl19 (CKNbb \2\:CKNbb) resistor r=93.4636 c=0
Rl28 (mout \2\:mout) resistor r=60.4181 c=0
Rl30 (\2\:mout \4\:mout) resistor r=110.418 c=0
Rl29 (\2\:mout \3\:mout) resistor r=7.6446 c=0
Rl38 (\6\:CKNb \7\:CKNb) resistor r=147.208 c=0
Rl37 (\5\:CKNb \6\:CKNb) resistor r=747.643 c=0
Rl33 (CKNb \2\:CKNb) resistor r=30.5643 c=0
Rl39 (\3\:CKNb \8\:CKNb) resistor r=26.0821 c=0
Rl34 (\2\:CKNb \3\:CKNb) resistor r=9.6894 c=0
Rl40 (\4\:CKNb \9\:CKNb) resistor r=57.3738 c=0
Rl36 (\4\:CKNb \5\:CKNb) resistor r=221.132 c=0
Rl35 (\3\:CKNb \4\:CKNb) resistor r=157.767 c=0
Rl24 (n20 \2\:n20) resistor r=102.615 c=0
Rl25 (\2\:n20 \3\:n20) resistor r=29.5379 c=0
Rl46 (\3\:SEb \4\:SEb) resistor r=24.2328 c=0
Rl45 (SEb \2\:SEb) resistor r=78.079 c=0
Rz21 (\11\:VSS \12\:VSS) resistor r=75 c=0
Rz22 (\13\:VSS \14\:VSS) resistor r=75 c=0
Rz23 (\15\:VSS \16\:VSS) resistor r=75 c=0
Rz24 (\17\:VSS \18\:VSS) resistor r=75 c=0
Rz25 (\19\:VSS \20\:VSS) resistor r=75 c=0
Rz26 (\22\:VSS \23\:VSS) resistor r=75 c=0
Rz27 (\24\:VSS \25\:VSS) resistor r=75 c=0
Rz1 (\3\:QN \4\:QN) resistor r=75 c=0
Rz28 (\1\:VDD \2\:VDD) resistor r=25 c=0
Rz29 (\1\:VDD \5\:VDD) resistor r=6.25 c=0
Rz30 (\1\:VDD \9\:VDD) resistor r=6.25 c=0
Rz31 (\1\:VDD \12\:VDD) resistor r=6.25 c=0
Rz3 (\3\:Q \4\:Q) resistor r=75 c=0
Rz2 (\9\:qint \10\:qint) resistor r=75 c=0
Rz4 (\11\:qbint \12\:qbint) resistor r=75 c=0
Rz10 (\11\:RNb \12\:RNb) resistor r=75 c=0
Rz9 (\4\:n35 \5\:n35) resistor r=75 c=0
Rz5 (net498 \2\:net498) resistor r=75 c=0
Rz6 (\3\:net498 \4\:net498) resistor r=75 c=0
Rz7 (net0363 \2\:net0363) resistor r=75 c=0
Rz8 (\3\:net0363 \4\:net0363) resistor r=75 c=0
Rz16 (\19\:CKNbb \20\:CKNbb) resistor r=75 c=0
Rz13 (\13\:mout \14\:mout) resistor r=75 c=0
Rz14 (\15\:mout \16\:mout) resistor r=75 c=0
Rz17 (\14\:CKNb \15\:CKNb) resistor r=75 c=0
Rz11 (net521 \2\:net521) resistor r=75 c=0
Rz12 (\3\:net521 \4\:net521) resistor r=75 c=0
Rz15 (\7\:n20 \8\:n20) resistor r=75 c=0
Rz18 (\4\:Db \5\:Db) resistor r=75 c=0
Rz19 (\6\:Db \7\:Db) resistor r=75 c=0
Rz20 (\10\:SEb \11\:SEb) resistor r=75 c=0
Ry17 (\1\:VSS \2\:VSS) resistor r=20.6667 c=0
Ry18 (\1\:VSS \5\:VSS) resistor r=5.1667 c=0
Ry19 (\1\:VSS \8\:VSS) resistor r=5.1667 c=0
Ry20 (\1\:VSS \10\:VSS) resistor r=5.1667 c=0
Ry1 (\1\:QN \2\:QN) resistor r=20.6667 c=0
Ry21 (\13\:VDD \14\:VDD) resistor r=62 c=0
Ry22 (\15\:VDD \16\:VDD) resistor r=62 c=0
Ry23 (\17\:VDD \18\:VDD) resistor r=62 c=0
Ry24 (\19\:VDD \20\:VDD) resistor r=62 c=0
Ry25 (\21\:VDD \22\:VDD) resistor r=62 c=0
Ry26 (\23\:VDD \24\:VDD) resistor r=62 c=0
Ry27 (\25\:VDD \26\:VDD) resistor r=62 c=0
Ry28 (\27\:VDD \28\:VDD) resistor r=62 c=0
Ry29 (\30\:VDD \31\:VDD) resistor r=62 c=0
Ry3 (\1\:Q \2\:Q) resistor r=20.6667 c=0
Ry2 (\5\:qint \6\:qint) resistor r=62 c=0
Ry4 (\14\:qbint \15\:qbint) resistor r=62 c=0
Ry8 (\9\:RNb \10\:RNb) resistor r=62 c=0
Ry7 (\8\:n35 \9\:n35) resistor r=62 c=0
Ry12 (\17\:CKNbb \18\:CKNbb) resistor r=62 c=0
Ry9 (\9\:mout \10\:mout) resistor r=62 c=0
Ry10 (\11\:mout \12\:mout) resistor r=62 c=0
Ry13 (\10\:CKNb \11\:CKNb) resistor r=62 c=0
Ry11 (\4\:n20 \5\:n20) resistor r=62 c=0
Ry14 (Db \2\:Db) resistor r=62 c=0
Ry15 (\8\:Db \9\:Db) resistor r=62 c=0
Ry16 (\5\:SEb \6\:SEb) resistor r=62 c=0
Ry5 (net566 \2\:net566) resistor r=62 c=0
Ry6 (\3\:net566 \4\:net566) resistor r=62 c=0
Rx18 (\2\:CKN \5\:CKN) resistor r=45 c=0
Rx20 (\5\:SE \7\:SE) resistor r=45 c=0
Rx21 (\2\:SE \8\:SE) resistor r=45 c=0
Rx10 (\5\:SN \7\:SN) resistor r=45 c=0
Rx11 (\2\:SN \8\:SN) resistor r=45 c=0
Rx22 (\2\:SI \4\:SI) resistor r=45 c=0
Rx2 (\2\:RN \4\:RN) resistor r=45 c=0
Rx19 (\2\:D \4\:D) resistor r=45 c=0
Rx1 (qint \8\:qint) resistor r=45 c=0
Rx3 (\9\:qbint \10\:qbint) resistor r=45 c=0
Rx4 (\2\:qbint \13\:qbint) resistor r=45 c=0
Rx8 (\5\:RNb \7\:RNb) resistor r=45 c=0
Rx9 (\3\:RNb \8\:RNb) resistor r=45 c=0
Rx5 (\2\:n35 \7\:n35) resistor r=45 c=0
Rx6 (\2\:CKNbb \10\:CKNbb) resistor r=45 c=0
Rx7 (\3\:CKNbb \11\:CKNbb) resistor r=45 c=0
Rx14 (\7\:CKNbb \12\:CKNbb) resistor r=45 c=0
Rx15 (\5\:CKNbb \14\:CKNbb) resistor r=45 c=0
Rx16 (\9\:CKNbb \16\:CKNbb) resistor r=45 c=0
Rx12 (\3\:mout \5\:mout) resistor r=45 c=0
Rx17 (\2\:CKNb \13\:CKNb) resistor r=45 c=0
Rx13 (\2\:n20 \9\:n20) resistor r=45 c=0
Rx23 (\2\:SEb \9\:SEb) resistor r=45 c=0
Rx24 (\4\:SEb \12\:SEb) resistor r=45 c=0
mn57 (\3\:QN \3\:qint \24\:VSS VSS) g45n1hvt w=(2.6e-07) l=4.5e-08 nf=1 \
        as=3.833e-14 ad=3.64e-14 ps=8.9e-07 pd=8e-07 nrd=1.16667 \
        nrs=1.16667 sa=1.4e-07 sb=2.50577e-07 sd=160n sca=17.5885 \
        scb=0.0172826 scc=0.00162584 m=(1)
mn55 (\3\:Q qbint \22\:VSS VSS) g45n1hvt w=(2.6e-07) l=4.5e-08 nf=1 \
        as=4.267e-14 ad=3.64e-14 ps=9.5e-07 pd=8e-07 nrd=1.16667 \
        nrs=1.16667 sa=1.4e-07 sb=3.00769e-07 sd=160n sca=17.5885 \
        scb=0.0172826 scc=0.00162584 m=(1)
mn56 (\9\:qint \4\:qbint \24\:VSS VSS) g45n1hvt w=(1.45e-07) l=4.5e-08 \
        nf=1 as=3.833e-14 ad=2.03e-14 ps=8.9e-07 pd=5.7e-07 nrd=1.16667 \
        nrs=1.16667 sa=3.7e-07 sb=1.4e-07 sd=160n sca=23.279 scb=0.0230742 \
        scc=0.00267719 m=(1)
mn22 (\11\:RNb \3\:RN \22\:VSS VSS) g45n1hvt w=(1.45e-07) l=4.5e-08 nf=1 \
        as=4.267e-14 ad=2.9e-14 ps=9.5e-07 pd=6.9e-07 nrd=1.16667 \
        nrs=1.16667 sa=4e-07 sb=2e-07 sd=160n sca=23.279 scb=0.0230742 \
        scc=0.00267719 m=(1)
mn45 (\11\:qbint \3\:n35 \19\:VSS VSS) g45n1hvt w=(1.45e-07) l=4.5e-08 \
        nf=1 as=5.548e-14 ad=2.03e-14 ps=1.55e-06 pd=5.7e-07 nrd=1.16667 \
        nrs=1.16667 sa=1.4e-07 sb=7.44483e-07 sd=160n sca=13.6097 \
        scb=0.014254 scc=0.000755054 m=(1)
mn50 (net498 \3\:SN \19\:VSS VSS) g45n1hvt w=(1.45e-07) l=4.5e-08 nf=1 \
        as=5.548e-14 ad=3.335e-14 ps=1.55e-06 pd=7.5e-07 nrd=1.16667 \
        nrs=1.16667 sa=3.22414e-07 sb=7.4e-07 sd=160n sca=11.1906 \
        scb=0.0108717 scc=0.000387468 m=(1)
mn52 (\3\:net0363 \8\:qbint net498 VSS) g45n1hvt w=(1.45e-07) l=4.5e-08 \
        nf=1 as=3.335e-14 ad=3.988e-14 ps=7.5e-07 pd=8.4e-07 nrd=1.16667 \
        nrs=1.16667 sa=5.97414e-07 sb=4.65e-07 sd=160n sca=11.1906 \
        scb=0.0108717 scc=0.000387468 m=(1)
mn51 (\3\:net0363 RNb \3\:net498 VSS) g45n1hvt w=(1.45e-07) l=4.5e-08 \
        nf=1 as=2.103e-14 ad=3.988e-14 ps=5.8e-07 pd=8.4e-07 nrd=1.16667 \
        nrs=1.16667 sa=9.17414e-07 sb=1.45e-07 sd=160n sca=11.1906 \
        scb=0.0108717 scc=0.000387468 m=(1)
mn53 (\4\:n35 CKNbb net0363 VSS) g45n1hvt w=(1.45e-07) l=4.5e-08 nf=1 \
        as=2.03e-14 ad=2.32e-14 ps=5.7e-07 pd=6.1e-07 nrd=1.16667 \
        nrs=1.16667 sa=1.4e-07 sb=4.6e-07 sd=160n sca=23.279 scb=0.0230742 \
        scc=0.00267719 m=(1)
mn40 (\15\:mout \6\:CKNb \4\:n35 VSS) g45n1hvt w=(1.45e-07) l=4.5e-08 \
        nf=1 as=2.32e-14 ad=3.698e-14 ps=6.1e-07 pd=8e-07 nrd=1.16667 \
        nrs=1.16667 sa=3.45e-07 sb=2.55e-07 sd=160n sca=23.279 \
        scb=0.0230742 scc=0.00267719 m=(1)
mn31 (\13\:mout \6\:RNb \3\:net521 VSS) g45n1hvt w=(1.45e-07) l=4.5e-08 \
        nf=1 as=2.03e-14 ad=2.755e-14 ps=5.7e-07 pd=6.7e-07 nrd=1.16667 \
        nrs=1.16667 sa=1.4e-07 sb=1.22e-06 sd=160n sca=13.9854 \
        scb=0.014728 scc=0.000819645 m=(1)
mn32 (\13\:mout \3\:n20 net521 VSS) g45n1hvt w=(1.45e-07) l=4.5e-08 nf=1 \
        as=2.537e-14 ad=2.755e-14 ps=6.4e-07 pd=6.7e-07 nrd=1.16667 \
        nrs=1.16667 sa=3.75e-07 sb=9.85e-07 sd=160n sca=13.9854 \
        scb=0.014728 scc=0.000819645 m=(1)
mn30 (net521 \6\:SN \17\:VSS VSS) g45n1hvt w=(1.45e-07) l=4.5e-08 nf=1 \
        as=3.19e-14 ad=2.537e-14 ps=7.3e-07 pd=6.4e-07 nrd=1.16667 \
        nrs=1.16667 sa=5.95e-07 sb=7.65e-07 sd=160n sca=13.9854 \
        scb=0.014728 scc=0.000819645 m=(1)
mn35 (net582 \4\:mout \17\:VSS VSS) g45n1hvt w=(1.45e-07) l=4.5e-08 nf=1 \
        as=3.19e-14 ad=1.595e-14 ps=7.3e-07 pd=5.1e-07 nrd=1.16667 \
        nrs=1.16667 sa=8.6e-07 sb=5e-07 sd=160n sca=13.9854 scb=0.014728 \
        scc=0.000819645 m=(1)
mn36 (\7\:n20 \5\:CKNb net582 VSS) g45n1hvt w=(1.45e-07) l=4.5e-08 nf=1 \
        as=1.595e-14 ad=2.32e-14 ps=5.1e-07 pd=6.1e-07 nrd=1.16667 \
        nrs=1.16667 sa=1.015e-06 sb=3.45e-07 sd=160n sca=13.9854 \
        scb=0.014728 scc=0.000819645 m=(1)
mn25 (\4\:Db \8\:CKNbb \7\:n20 VSS) g45n1hvt w=(1.45e-07) l=4.5e-08 nf=1 \
        as=2.32e-14 ad=2.03e-14 ps=6.1e-07 pd=5.7e-07 nrd=1.16667 \
        nrs=1.16667 sa=1.22e-06 sb=1.4e-07 sd=160n sca=13.9854 \
        scb=0.014728 scc=0.000819645 m=(1)
mn21 (\19\:CKNbb CKNb \15\:VSS VSS) g45n1hvt w=(1.45e-07) l=4.5e-08 nf=1 \
        as=6.025e-14 ad=2.03e-14 ps=1.76e-06 pd=5.7e-07 nrd=1.16667 \
        nrs=1.16667 sa=1.4e-07 sb=1e-07 sd=160n sca=23.279 scb=0.0230742 \
        scc=0.00267719 m=(1)
mn20 (\14\:CKNb \3\:CKN \13\:VSS VSS) g45n1hvt w=(1.45e-07) l=4.5e-08 \
        nf=1 as=3.48e-14 ad=3.407e-14 ps=9.6e-07 pd=7.6e-07 nrd=1.16667 \
        nrs=1.16667 sa=2.35e-07 sb=5.06897e-07 sd=160n sca=12.2839 \
        scb=0.0124725 scc=0.000542081 m=(1)
mn11 (net546 \3\:D \13\:VSS VSS) g45n1hvt w=(1.45e-07) l=4.5e-08 nf=1 \
        as=3.48e-14 ad=8.7e-15 ps=9.6e-07 pd=4.1e-07 nrd=1.16667 \
        nrs=1.16667 sa=2.71034e-07 sb=9.95e-07 sd=160n sca=8.42104 \
        scb=0.00632542 scc=0.000106623 m=(1)
mn12 (\6\:Db SEb net546 VSS) g45n1hvt w=(1.45e-07) l=4.5e-08 nf=1 \
        as=8.7e-15 ad=4.857e-14 ps=4.1e-07 pd=9.6e-07 nrd=1.16667 \
        nrs=1.16667 sa=3.76034e-07 sb=8.9e-07 sd=160n sca=8.42104 \
        scb=0.00632542 scc=0.000106623 m=(1)
mn14 (\6\:Db \1\:SE net538 VSS) g45n1hvt w=(1.45e-07) l=4.5e-08 nf=1 \
        as=1.74e-14 ad=4.857e-14 ps=5.3e-07 pd=9.6e-07 nrd=1.16667 \
        nrs=1.16667 sa=7.56034e-07 sb=5.1e-07 sd=160n sca=8.42104 \
        scb=0.00632542 scc=0.000106623 m=(1)
mn13 (net538 \1\:SI \11\:VSS VSS) g45n1hvt w=(1.45e-07) l=4.5e-08 nf=1 \
        as=2.32e-14 ad=1.74e-14 ps=6.1e-07 pd=5.3e-07 nrd=1.16667 \
        nrs=1.16667 sa=9.21034e-07 sb=3.45e-07 sd=160n sca=8.42104 \
        scb=0.00632542 scc=0.000106623 m=(1)
mn10 (\10\:SEb \6\:SE \11\:VSS VSS) g45n1hvt w=(1.45e-07) l=4.5e-08 nf=1 \
        as=2.32e-14 ad=2.03e-14 ps=6.1e-07 pd=5.7e-07 nrd=1.16667 \
        nrs=1.16667 sa=1.12603e-06 sb=1.4e-07 sd=160n sca=8.42104 \
        scb=0.00632542 scc=0.000106623 m=(1)
mp56 (\5\:qint \6\:qbint \30\:VDD VDD) g45p1hvt w=(2.15e-07) l=4.5e-08 \
        nf=1 as=5.728e-14 ad=3.01e-14 ps=1.15e-06 pd=7.1e-07 nrd=1.16667 \
        nrs=1.16667 sa=3.7e-07 sb=1.4e-07 sd=160n sca=46.9517 scb=0.029008 \
        scc=0.00588492 m=(1)
mp22 (\9\:RNb \1\:RN \27\:VDD VDD) g45p1hvt w=(2.15e-07) l=4.5e-08 nf=1 \
        as=6.48e-14 ad=4.3e-14 ps=1.22e-06 pd=8.3e-07 nrd=1.16667 \
        nrs=1.16667 sa=4.05e-07 sb=2e-07 sd=160n sca=10.1345 \
        scb=0.00732736 scc=7.25592e-05 m=(1)
mp45 (\14\:qbint n35 \25\:VDD VDD) g45p1hvt w=(2.15e-07) l=4.5e-08 nf=1 \
        as=4.408e-14 ad=5.483e-14 ps=8.4e-07 pd=9.4e-07 nrd=1.16667 \
        nrs=1.16667 sa=2.55e-07 sb=9.25e-07 sd=160n sca=13.4114 \
        scb=0.012694 scc=0.000544005 m=(1)
mp50 (\3\:net566 \1\:SN \25\:VDD VDD) g45p1hvt w=(2.15e-07) l=4.5e-08 \
        nf=1 as=4.407e-14 ad=4.945e-14 ps=8.4e-07 pd=8.9e-07 nrd=1.16667 \
        nrs=1.16667 sa=5.05e-07 sb=6.75e-07 sd=160n sca=13.4114 \
        scb=0.012694 scc=0.000544005 m=(1)
mp52 (\3\:net566 \7\:qbint net414 VDD) g45p1hvt w=(2.15e-07) l=4.5e-08 \
        nf=1 as=1.29e-14 ad=4.945e-14 ps=5.5e-07 pd=8.9e-07 nrd=1.16667 \
        nrs=1.16667 sa=7.8e-07 sb=4e-07 sd=160n sca=13.4114 scb=0.012694 \
        scc=0.000544005 m=(1)
mp51 (net414 \2\:RNb \23\:VDD VDD) g45p1hvt w=(2.15e-07) l=4.5e-08 nf=1 \
        as=9.223e-14 ad=1.29e-14 ps=1.5e-06 pd=5.5e-07 nrd=1.16667 \
        nrs=1.16667 sa=8.85e-07 sb=2.95e-07 sd=160n sca=13.4114 \
        scb=0.012694 scc=0.000544005 m=(1)
mp53 (\8\:n35 \7\:CKNb net566 VDD) g45p1hvt w=(2.15e-07) l=4.5e-08 nf=1 \
        as=6.773e-14 ad=3.762e-14 ps=1.06e-06 pd=7.8e-07 nrd=1.16667 \
        nrs=1.16667 sa=3.15e-07 sb=3.6e-07 sd=160n sca=23.7894 \
        scb=0.0219499 scc=0.00260958 m=(1)
mp40 (\8\:n35 \4\:CKNbb \9\:mout VDD) g45p1hvt w=(2.15e-07) l=4.5e-08 \
        nf=1 as=3.01e-14 ad=3.762e-14 ps=7.1e-07 pd=7.8e-07 nrd=1.16667 \
        nrs=1.16667 sa=5.35e-07 sb=1.4e-07 sd=160n sca=23.7894 \
        scb=0.0219499 scc=0.00260958 m=(1)
mp31 (net478 \4\:RNb \21\:VDD VDD) g45p1hvt w=(2.15e-07) l=4.5e-08 nf=1 \
        as=9.928e-14 ad=4.085e-14 ps=2.06e-06 pd=8.1e-07 nrd=1.16667 \
        nrs=1.16667 sa=3.25e-07 sb=1.13919e-06 sd=160n sca=18.4975 \
        scb=0.0182651 scc=0.0015388 m=(1)
mp32 (\11\:mout n20 net478 VDD) g45p1hvt w=(2.15e-07) l=4.5e-08 nf=1 \
        as=4.085e-14 ad=3.762e-14 ps=8.1e-07 pd=7.8e-07 nrd=1.16667 \
        nrs=1.16667 sa=5.6e-07 sb=9.04186e-07 sd=160n sca=18.4975 \
        scb=0.0182651 scc=0.0015388 m=(1)
mp30 (\11\:mout \4\:SN \19\:VDD VDD) g45p1hvt w=(2.15e-07) l=4.5e-08 \
        nf=1 as=9.35e-14 ad=3.762e-14 ps=1.71e-06 pd=7.8e-07 nrd=1.16667 \
        nrs=1.16667 sa=7.8e-07 sb=6.84186e-07 sd=160n sca=18.4975 \
        scb=0.0182651 scc=0.0015388 m=(1)
mp35 (net486 mout \19\:VDD VDD) g45p1hvt w=(2.15e-07) l=4.5e-08 nf=1 \
        as=9.35e-14 ad=1.29e-14 ps=1.71e-06 pd=5.5e-07 nrd=1.16667 \
        nrs=1.16667 sa=8.00814e-07 sb=5.22442e-07 sd=160n sca=13.6743 \
        scb=0.0130525 scc=0.000590384 m=(1)
mp36 (\4\:n20 \6\:CKNbb net486 VDD) g45p1hvt w=(2.15e-07) l=4.5e-08 nf=1 \
        as=1.29e-14 ad=6.85e-14 ps=5.5e-07 pd=1.3e-06 nrd=1.16667 \
        nrs=1.16667 sa=9.05814e-07 sb=4.17442e-07 sd=160n sca=13.6743 \
        scb=0.0130525 scc=0.000590384 m=(1)
mp25 (\4\:n20 \9\:CKNb \8\:Db VDD) g45p1hvt w=(2.15e-07) l=4.5e-08 nf=1 \
        as=3.01e-14 ad=6.85e-14 ps=7.1e-07 pd=1.3e-06 nrd=1.16667 \
        nrs=1.16667 sa=1.12209e-06 sb=1.4e-07 sd=160n sca=19.0975 \
        scb=0.0187686 scc=0.00166224 m=(1)
mp21 (\17\:CKNbb \8\:CKNb \17\:VDD VDD) g45p1hvt w=(2.15e-07) l=4.5e-08 \
        nf=1 as=3.01e-14 ad=3.01e-14 ps=7.1e-07 pd=7.1e-07 nrd=1.16667 \
        nrs=1.16667 sa=1.4e-07 sb=1.4e-07 sd=160n sca=45.7906 \
        scb=0.0283307 scc=0.00588417 m=(1)
mp20 (\10\:CKNb \1\:CKN \15\:VDD VDD) g45p1hvt w=(2.15e-07) l=4.5e-08 \
        nf=1 as=3.548e-14 ad=3.01e-14 ps=7.6e-07 pd=7.1e-07 nrd=1.16667 \
        nrs=1.16667 sa=1.4e-07 sb=1.13686e-06 sd=160n sca=10.5619 \
        scb=0.00813366 scc=0.000119634 m=(1)
mp11 (net461 \1\:D \15\:VDD VDD) g45p1hvt w=(2.15e-07) l=4.5e-08 nf=1 \
        as=3.548e-14 ad=3.333e-14 ps=7.6e-07 pd=7.4e-07 nrd=1.16667 \
        nrs=1.16667 sa=3.5e-07 sb=9.2686e-07 sd=160n sca=10.5619 \
        scb=0.00813366 scc=0.000119634 m=(1)
mp12 (Db \3\:SE net461 VDD) g45p1hvt w=(2.15e-07) l=4.5e-08 nf=1 \
        as=3.333e-14 ad=6.128e-14 ps=7.4e-07 pd=1e-06 nrd=1.16667 \
        nrs=1.16667 sa=5.5e-07 sb=7.2686e-07 sd=160n sca=10.5619 \
        scb=0.00813366 scc=0.000119634 m=(1)
mp14 (Db \3\:SEb net453 VDD) g45p1hvt w=(2.15e-07) l=4.5e-08 nf=1 \
        as=1.29e-14 ad=6.128e-14 ps=5.5e-07 pd=1e-06 nrd=1.16667 \
        nrs=1.16667 sa=8.8e-07 sb=3.9686e-07 sd=160n sca=11.3725 \
        scb=0.00850478 scc=0.000119858 m=(1)
mp13 (net453 \3\:SI \13\:VDD VDD) g45p1hvt w=(2.15e-07) l=4.5e-08 nf=1 \
        as=4.41e-14 ad=1.29e-14 ps=9.4e-07 pd=5.5e-07 nrd=1.16667 \
        nrs=1.16667 sa=9.85e-07 sb=2.9186e-07 sd=160n sca=11.993 \
        scb=0.00910029 scc=0.000121216 m=(1)
mp10 (\5\:SEb \4\:SE \13\:VDD VDD) g45p1hvt w=(2.15e-07) l=4.5e-08 nf=1 \
        as=4.41e-14 ad=3.01e-14 ps=9.4e-07 pd=7.1e-07 nrd=1.16667 \
        nrs=1.16667 sa=8.93488e-07 sb=1.4e-07 sd=160n sca=15.0667 \
        scb=0.0139761 scc=0.000182543 m=(1)
ends SDFFNSRX1
// End of subcircuit definition.
