// Generated for: spectre (May  1 08:11:51 2013 )
// Library name: gsclib045
// Cell name: LSHL_ISONL_X1_TO_ON
// View name: extracted

simulator lang=spectre

subckt LSHL_ISONL_X1_TO_ON A ISOn VDD VSS Y
PM1 (\9\:n0 \1\:ISOn \1\:VDD VDD) g45p1svt w=(2.15e-07) l=4.5e-08 nf=1 \
        as=6.535e-14 ad=3.01e-14 ps=1.16e-06 pd=7.1e-07 nrd=1.16667 \
        nrs=1.16667 sa=1.4e-07 sb=3.75e-07 sd=160n sca=11.246 \
        scb=0.00796689 scc=7.43059e-05 m=(1)
mp0 (\11\:n0 \1\:A \5\:VDD VDD) g45p1svt w=(2.15e-07) l=4.5e-08 nf=1 \
        as=3.01e-14 ad=3.01e-14 ps=7.1e-07 pd=7.1e-07 nrd=1.16667 \
        nrs=1.16667 sa=1.4e-07 sb=1.4e-07 sd=160n sca=10.7232 \
        scb=0.00756373 scc=7.3759e-05 m=(1)
C1 (VDD VSS) capacitor c=1.36287e-16
C2 (Y VSS) capacitor c=3.1119e-17
C3 (A VSS) capacitor c=4.64784e-17
C4 (ISOn VSS) capacitor c=2.81923e-17
C5 (GatedVSS VSS) capacitor c=1.59813e-16
C6 (n0 VSS) capacitor c=4.8859e-17
C7 (\1\:ISOn VSS) capacitor c=5.03221e-17
C8 (\1\:A VSS) capacitor c=5.31061e-17
C9 (\4\:n0 VSS) capacitor c=2.93309e-17
C10 (\4\:A VSS) capacitor c=3.09982e-17
C11 (\3\:n0 VSS) capacitor c=2.81093e-17
C12 (\3\:A VSS) capacitor c=1.3128e-17
C13 (\3\:Y VSS) capacitor c=5.35587e-17
C14 (\1\:VDD VSS) capacitor c=9.35908e-17
C15 (\9\:n0 VSS) capacitor c=6.03356e-17
C16 (\11\:n0 VSS) capacitor c=4.47953e-17
C17 (\5\:VDD VSS) capacitor c=3.49015e-17
C18 (\1\:Y VSS) capacitor c=5.42466e-17
C19 (\5\:GatedVSS VSS) capacitor c=3.81833e-17
C20 (\7\:n0 VSS) capacitor c=9.19906e-17
C21 (\2\:A VSS) capacitor c=4.31437e-17
C22 (\2\:ISOn VSS) capacitor c=1.33073e-16
C23 (\7\:ISOn VSS) capacitor c=9.48719e-18
C24 (\9\:ISOn VSS) capacitor c=2.66573e-17
C25 (\5\:n0 VSS) capacitor c=4.21799e-17
C26 (\6\:n0 VSS) capacitor c=1.28001e-16
C27 (\4\:VDD VSS) capacitor c=2.64234e-17
Rk17 (\4\:VDD VDD) resistor r=0.05217 c=0
Rk16 (\2\:VDD \4\:VDD) resistor r=0.5223 c=0
Rk18 (VDD \6\:VDD) resistor r=0.355 c=0
Rk20 (\4\:VSS VSS) resistor r=0.02501 c=0
Rk19 (\2\:VSS \4\:VSS) resistor r=0.4635 c=0
Rk21 (VSS \6\:VSS) resistor r=0.2935 c=0
Rk14 (Y \2\:Y) resistor r=0.313 c=0
Rk15 (Y \4\:Y) resistor r=0.2548 c=0
Rk3 (\6\:ISOn ISOn) resistor r=0.002186 c=0
Rk4 (ISOn \7\:ISOn) resistor r=0.002186 c=0
Rk5 (\6\:ISOn \7\:ISOn) resistor r=0.03492 c=0
Rk7 (\7\:ISOn \9\:ISOn) resistor r=0.0454 c=0
Rk6 (\8\:ISOn \9\:ISOn) resistor r=0.002186 c=0
Rk9 (GatedVSS \6\:GatedVSS) resistor r=0.08844 c=0
Rk10 (\5\:n0 \6\:n0) resistor r=0.1995 c=0
Rk11 (\6\:n0 \8\:n0) resistor r=0.8038 c=0
Rk12 (\6\:n0 \10\:n0) resistor r=0.436 c=0
Rk13 (\10\:n0 \12\:n0) resistor r=0.06056 c=0
Rl1 (\1\:A \2\:A) resistor r=245.621 c=0
Rl3 (\2\:A \4\:A) resistor r=117.068 c=0
Rl2 (\2\:A \3\:A) resistor r=1.2666 c=0
Rl4 (\2\:ISOn \1\:ISOn) resistor r=151.871 c=0
Rl8 (n0 \2\:n0) resistor r=120.442 c=0
Rl10 (\2\:n0 \4\:n0) resistor r=47.7469 c=0
Rl9 (\2\:n0 \3\:n0) resistor r=0.6051 c=0
Rz7 (\2\:VSS \1\:VSS) resistor r=37.5 c=0
Rz8 (\6\:VSS \5\:VSS) resistor r=75 c=0
Rz5 (\1\:Y \2\:Y) resistor r=37.5 c=0
Rz3 (\6\:GatedVSS \5\:GatedVSS) resistor r=75 c=0
Rz4 (\7\:n0 \8\:n0) resistor r=75 c=0
Ry4 (\1\:VDD \2\:VDD) resistor r=20.6667 c=0
Ry5 (\5\:VDD \6\:VDD) resistor r=62 c=0
Ry3 (\3\:Y \4\:Y) resistor r=20.6667 c=0
Ry1 (\9\:n0 \10\:n0) resistor r=62 c=0
Ry2 (\11\:n0 \12\:n0) resistor r=62 c=0
Rx1 (\3\:A A) resistor r=45 c=0
Rx2 (\8\:ISOn \2\:ISOn) resistor r=45 c=0
Rx3 (\3\:n0 \5\:n0) resistor r=45 c=0
mn0 (\5\:GatedVSS \4\:A \7\:n0 VSS) g45n1svt w=(1.45e-07) l=4.5e-08 nf=1 \
        as=2.03e-14 ad=2.03e-14 ps=5.7e-07 pd=5.7e-07 nrd=1.16667 \
        nrs=1.16667 sa=1.4e-07 sb=1.4e-07 sd=160n sca=11.1906 \
        scb=0.0108717 scc=0.000387468 m=(1)
NM0 (\1\:Y \4\:n0 \1\:VSS VSS) g45n1svt w=(2.6e-07) l=4.5e-08 nf=1 \
        as=3.64e-14 ad=3.64e-14 ps=8e-07 pd=8e-07 nrd=1.16667 nrs=1.16667 \
        sa=1.4e-07 sb=1.4e-07 sd=160n sca=9.32128 scb=0.00786794 \
        scc=0.000232361 m=(1)
NM3 (GatedVSS \2\:ISOn \5\:VSS VSS) g45n1svt w=(2.6e-07) l=4.5e-08 nf=1 \
        as=3.64e-14 ad=4.16e-14 ps=8e-07 pd=8.4e-07 nrd=1.16667 \
        nrs=1.16667 sa=1.4e-07 sb=3.45e-07 sd=160n sca=9.32128 \
        scb=0.00786794 scc=0.000232361 m=(2)
PM0 (\3\:Y n0 \1\:VDD VDD) g45p1svt w=(3.9e-07) l=4.5e-08 nf=1 \
        as=5.46e-14 ad=6.535e-14 ps=1.06e-06 pd=1.16e-06 nrd=1.16667 \
        nrs=1.16667 sa=2.69551e-07 sb=1.4e-07 sd=160n sca=16.6283 \
        scb=0.0159718 scc=0.000561163 m=(1)
ends LSHL_ISONL_X1_TO_ON
// End of subcircuit definition.
