// Generated for: spectre (May  1 09:16:32 2013 )
// Library name: gsclib045_lvt
// Cell name: NAND2X1
// View name: extracted

simulator lang=spectre

subckt NAND2X1 A B VDD VSS Y
mp0 (\3\:Y \1\:A \5\:VDD VDD) g45p1lvt w=(3.9e-07) l=4.5e-08 nf=1 \
        as=5.46e-14 ad=6.24e-14 ps=1.06e-06 pd=1.1e-06 nrd=1.16667 \
        nrs=1.16667 sa=1.4e-07 sb=3.25e-07 sd=160n sca=36.5212 \
        scb=0.040075 scc=0.00317187 m=(1)
mp1 (\3\:Y \1\:B \1\:VDD VDD) g45p1lvt w=(3.9e-07) l=4.5e-08 nf=1 \
        as=7.31e-14 ad=6.24e-14 ps=1.7e-06 pd=1.1e-06 nrd=1.16667 \
        nrs=1.16667 sa=3.45e-07 sb=1.2e-07 sd=160n sca=37.5084 \
        scb=0.0409147 scc=0.00340882 m=(1)
C1 (Y VSS) capacitor c=5.32179e-17
C2 (VDD VSS) capacitor c=4.20012e-17
C3 (B VSS) capacitor c=2.45699e-17
C4 (\1\:B VSS) capacitor c=4.14367e-17
C5 (\1\:A VSS) capacitor c=3.48823e-17
C6 (\3\:B VSS) capacitor c=4.71311e-17
C7 (\4\:A VSS) capacitor c=6.04062e-17
C8 (\2\:B VSS) capacitor c=3.99212e-17
C9 (\3\:A VSS) capacitor c=1.32967e-17
C10 (\1\:VDD VSS) capacitor c=4.91555e-18
C11 (\3\:Y VSS) capacitor c=8.07507e-17
C12 (\5\:VDD VSS) capacitor c=3.92856e-17
C13 (\1\:Y VSS) capacitor c=5.93624e-17
C14 (\2\:A VSS) capacitor c=2.6342e-17
C15 (\5\:A VSS) capacitor c=5.82932e-17
C16 (\4\:B VSS) capacitor c=6.69072e-17
C17 (\4\:VDD VSS) capacitor c=1.08715e-17
Rk5 (\2\:Y Y) resistor r=0.2303 c=0
Rk6 (Y \4\:Y) resistor r=0.3412 c=0
Rk8 (\4\:VDD VDD) resistor r=0.1003 c=0
Rk7 (\2\:VDD \4\:VDD) resistor r=0.1406 c=0
Rk9 (VDD \6\:VDD) resistor r=0.3286 c=0
Rk4 (\4\:B B) resistor r=0.01 c=0
Rk2 (\4\:B \5\:B) resistor r=0.001047 c=0
Rk1 (\5\:A A) resistor r=0.01023 c=0
Rk11 (VSS \4\:VSS) resistor r=0.2793 c=0
Rl4 (\1\:B \2\:B) resistor r=90.782 c=0
Rl5 (\2\:B \3\:B) resistor r=29.9451 c=0
Rl1 (\1\:A \2\:A) resistor r=37.3411 c=0
Rl3 (\2\:A \4\:A) resistor r=96.9565 c=0
Rl2 (\2\:A \3\:A) resistor r=1.2301 c=0
Rz1 (\1\:Y \2\:Y) resistor r=37.5 c=0
Rz3 (\3\:VSS \4\:VSS) resistor r=37.5 c=0
Ry1 (\3\:Y \4\:Y) resistor r=20.6667 c=0
Ry2 (\1\:VDD \2\:VDD) resistor r=62 c=0
Ry3 (\5\:VDD \6\:VDD) resistor r=31 c=0
Rx2 (\2\:B \5\:B) resistor r=45 c=0
Rx1 (\3\:A \5\:A) resistor r=45 c=0
mn0 (n0 \4\:A \3\:VSS VSS) g45n1lvt w=(2.6e-07) l=4.5e-08 nf=1 \
        as=3.64e-14 ad=1.82e-14 ps=8e-07 pd=6.6e-07 nrd=1.16667 \
        nrs=1.16667 sa=1.4e-07 sb=3e-07 sd=160n sca=10.79 scb=0.0100512 \
        scc=0.000418069 m=(1)
mn1 (\1\:Y \3\:B n0 VSS) g45n1lvt w=(2.6e-07) l=4.5e-08 nf=1 as=1.82e-14 \
        ad=4.81e-14 ps=6.6e-07 pd=8.9e-07 nrd=1.16667 nrs=1.16667 \
        sa=2.55e-07 sb=1.85e-07 sd=160n sca=10.79 scb=0.0100512 \
        scc=0.000418069 m=(1)
ends NAND2X1
// End of subcircuit definition.
