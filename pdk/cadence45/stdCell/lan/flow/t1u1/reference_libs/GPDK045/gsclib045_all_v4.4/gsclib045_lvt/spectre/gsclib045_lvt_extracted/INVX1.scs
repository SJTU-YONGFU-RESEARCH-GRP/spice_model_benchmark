// Generated for: spectre (May  1 09:15:43 2013 )
// Library name: gsclib045_lvt
// Cell name: INVX1
// View name: extracted

simulator lang=spectre

subckt INVX1 A VDD VSS Y
mp0 (\1\:Y \1\:A \3\:VDD VDD) g45p1lvt w=(3.9e-07) l=4.5e-08 nf=1 \
        as=8.84e-14 ad=5.46e-14 ps=1.82e-06 pd=1.06e-06 nrd=1.16667 \
        nrs=1.16667 sa=1.35e-07 sb=1.4e-07 sd=160n sca=58.4044 \
        scb=0.0588257 scc=0.00629162 m=(1)
C1 (Y VSS) capacitor c=3.28574e-17
C2 (A VSS) capacitor c=1.7651e-17
C3 (VDD VSS) capacitor c=2.99386e-17
C4 (\1\:A VSS) capacitor c=2.81441e-17
C5 (\4\:A VSS) capacitor c=2.218e-17
C6 (\3\:A VSS) capacitor c=1.22938e-17
C7 (\1\:Y VSS) capacitor c=1.46563e-17
C8 (\3\:VDD VSS) capacitor c=3.69633e-18
C9 (\3\:Y VSS) capacitor c=2.2502e-17
C10 (\2\:A VSS) capacitor c=1.03435e-17
C11 (\7\:A VSS) capacitor c=3.79958e-17
Rk4 (\2\:Y Y) resistor r=0.2245 c=0
Rk5 (Y \4\:Y) resistor r=0.1802 c=0
Rk1 (\5\:A A) resistor r=0.006551 c=0
Rk3 (\5\:A \7\:A) resistor r=0.01182 c=0
Rk2 (\6\:A \7\:A) resistor r=0.006551 c=0
Rk9 (VSS \4\:VSS) resistor r=0.07884 c=0
Rk7 (VDD \4\:VDD) resistor r=0.1117 c=0
Rl1 (\1\:A \2\:A) resistor r=61.2526 c=0
Rl3 (\2\:A \4\:A) resistor r=34.3295 c=0
Rl2 (\2\:A \3\:A) resistor r=2.7666 c=0
Rz1 (\3\:Y \4\:Y) resistor r=37.5 c=0
Rz3 (\3\:VSS \4\:VSS) resistor r=75 c=0
Ry1 (\1\:Y \2\:Y) resistor r=20.6667 c=0
Ry2 (\3\:VDD \4\:VDD) resistor r=62 c=0
Rx1 (\3\:A \6\:A) resistor r=45 c=0
mn0 (\3\:Y \4\:A \3\:VSS VSS) g45n1lvt w=(2.6e-07) l=4.5e-08 nf=1 \
        as=6.435e-14 ad=3.64e-14 ps=1.46e-06 pd=8e-07 nrd=1.16667 \
        nrs=1.16667 sa=1.35e-07 sb=1.4e-07 sd=160n sca=14.4034 \
        scb=0.0144248 scc=0.00102063 m=(1)
ends INVX1
// End of subcircuit definition.
