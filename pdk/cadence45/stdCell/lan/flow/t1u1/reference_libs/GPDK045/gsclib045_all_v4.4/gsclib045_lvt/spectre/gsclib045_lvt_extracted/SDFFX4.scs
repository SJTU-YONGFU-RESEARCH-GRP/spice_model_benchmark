// Generated for: spectre (May  1 09:15:21 2013 )
// Library name: gsclib045_lvt
// Cell name: SDFFX4
// View name: extracted

simulator lang=spectre

subckt SDFFX4 CK D Q QN SE SI VDD VSS
mp10 (\10\:SEb \1\:SE \31\:VDD VDD) g45p1lvt w=(2.15e-07) l=4.5e-08 nf=1 \
        as=3.44e-14 ad=3.44e-14 ps=7.5e-07 pd=7.5e-07 nrd=1.16667 \
        nrs=1.16667 sa=1.6e-07 sb=1.51e-06 sd=160n sca=13.1833 \
        scb=0.0107181 scc=0.000111559 m=(1)
mp11 (net384 \1\:D \31\:VDD VDD) g45p1lvt w=(2.15e-07) l=4.5e-08 nf=1 \
        as=3.44e-14 ad=2.903e-14 ps=7.5e-07 pd=7e-07 nrd=1.16667 \
        nrs=1.16667 sa=3.65e-07 sb=1.305e-06 sd=160n sca=11.3131 \
        scb=0.00820755 scc=9.33745e-05 m=(1)
mp12 (\8\:Db \6\:SE net384 VDD) g45p1lvt w=(2.15e-07) l=4.5e-08 nf=1 \
        as=2.903e-14 ad=5.16e-14 ps=7e-07 pd=9.1e-07 nrd=1.16667 \
        nrs=1.16667 sa=5.45e-07 sb=1.125e-06 sd=160n sca=10.6109 \
        scb=0.00776928 scc=9.29566e-05 m=(1)
mp14 (\8\:Db \3\:SEb net392 VDD) g45p1lvt w=(2.15e-07) l=4.5e-08 nf=1 \
        as=3.44e-14 ad=5.16e-14 ps=7.5e-07 pd=9.1e-07 nrd=1.16667 \
        nrs=1.16667 sa=8.3e-07 sb=8.4e-07 sd=160n sca=10.3256 \
        scb=0.00769229 scc=9.29431e-05 m=(1)
mp13 (net392 \1\:SI \27\:VDD VDD) g45p1lvt w=(2.15e-07) l=4.5e-08 nf=1 \
        as=4.3e-14 ad=3.44e-14 ps=8.3e-07 pd=7.5e-07 nrd=1.16667 \
        nrs=1.16667 sa=1.035e-06 sb=6.35e-07 sd=160n sca=10.3256 \
        scb=0.00769229 scc=9.29431e-05 m=(1)
mp20 (\14\:CKb \1\:CK \27\:VDD VDD) g45p1lvt w=(2.15e-07) l=4.5e-08 nf=1 \
        as=4.3e-14 ad=8.385e-14 ps=8.3e-07 pd=1.21e-06 nrd=1.16667 \
        nrs=1.16667 sa=1.28e-06 sb=3.9e-07 sd=160n sca=10.3256 \
        scb=0.00769229 scc=9.29431e-05 m=(1)
mp21 (\17\:CKbb \9\:CKb \24\:VDD VDD) g45p1lvt w=(2.15e-07) l=4.5e-08 \
        nf=1 as=6.355e-14 ad=3.01e-14 ps=1.85e-06 pd=7.1e-07 nrd=1.16667 \
        nrs=1.16667 sa=1e-07 sb=1.4e-07 sd=160n sca=21.9815 scb=0.0208641 \
        scc=0.00225088 m=(1)
mp25 (\8\:n20 CKbb \3\:Db VDD) g45p1lvt w=(2.15e-07) l=4.5e-08 nf=1 \
        as=3.01e-14 ad=3.44e-14 ps=7.1e-07 pd=7.5e-07 nrd=1.16667 \
        nrs=1.16667 sa=1.4e-07 sb=2e-06 sd=160n sca=20.4333 scb=0.0198015 \
        scc=0.00193653 m=(1)
mp36 (\8\:n20 \3\:CKb net356 VDD) g45p1lvt w=(2.15e-07) l=4.5e-08 nf=1 \
        as=1.29e-14 ad=3.44e-14 ps=5.5e-07 pd=7.5e-07 nrd=1.16667 \
        nrs=1.16667 sa=3.45e-07 sb=2e-06 sd=160n sca=20.4333 scb=0.0198015 \
        scc=0.00193653 m=(1)
mp35 (net356 mout \21\:VDD VDD) g45p1lvt w=(2.15e-07) l=4.5e-08 nf=1 \
        as=4.73e-14 ad=1.29e-14 ps=8.7e-07 pd=5.5e-07 nrd=1.16667 \
        nrs=1.16667 sa=4.5e-07 sb=2e-06 sd=160n sca=20.4333 scb=0.0198015 \
        scc=0.00193653 m=(1)
mp30 (\4\:mout n20 \21\:VDD VDD) g45p1lvt w=(2.15e-07) l=4.5e-08 nf=1 \
        as=4.73e-14 ad=9.03e-14 ps=8.7e-07 pd=1.27e-06 nrd=1.16667 \
        nrs=1.16667 sa=7.15e-07 sb=2e-06 sd=160n sca=20.4333 scb=0.0198015 \
        scc=0.00193653 m=(1)
mp40 (\10\:n30 \2\:CKb \4\:mout VDD) g45p1lvt w=(2.15e-07) l=4.5e-08 nf=1 \
        as=9.03e-14 ad=3.44e-14 ps=1.27e-06 pd=7.5e-07 nrd=1.16667 \
        nrs=1.16667 sa=1.18e-06 sb=2e-06 sd=160n sca=20.4333 scb=0.0198015 \
        scc=0.00193653 m=(1)
mp51 (\10\:n30 \7\:CKbb net376 VDD) g45p1lvt w=(2.15e-07) l=4.5e-08 nf=1 \
        as=3.118e-14 ad=3.44e-14 ps=7.2e-07 pd=7.5e-07 nrd=1.16667 \
        nrs=1.16667 sa=1.385e-06 sb=2e-06 sd=160n sca=20.4333 \
        scb=0.0198015 scc=0.00193653 m=(1)
mp50 (net376 \4\:qbint \1\:VDD VDD) g45p1lvt w=(2.15e-07) l=4.5e-08 nf=1 \
        as=5.415e-14 ad=3.118e-14 ps=1e-06 pd=7.2e-07 nrd=1.16667 \
        nrs=1.16667 sa=1.575e-06 sb=2e-06 sd=160n sca=20.4333 \
        scb=0.0198015 scc=0.00193653 m=(1)
C1 (D VSS) capacitor c=4.88817e-17
C2 (Q VSS) capacitor c=2.1377e-17
C3 (CK VSS) capacitor c=3.92338e-17
C4 (SI VSS) capacitor c=1.18946e-16
C5 (QN VSS) capacitor c=1.41261e-17
C6 (VDD VSS) capacitor c=3.50826e-16
C7 (SE VSS) capacitor c=4.75392e-17
C8 (SEb VSS) capacitor c=7.96364e-17
C9 (net449 VSS) capacitor c=1.56005e-19
C10 (Db VSS) capacitor c=9.02937e-17
C11 (net461 VSS) capacitor c=2.5028e-18
C12 (CKb VSS) capacitor c=7.86848e-17
C13 (CKbb VSS) capacitor c=3.48339e-17
C14 (n20 VSS) capacitor c=4.96534e-17
C15 (mout VSS) capacitor c=6.02346e-17
C16 (n30 VSS) capacitor c=2.16396e-16
C17 (qbint VSS) capacitor c=3.12049e-17
C18 (net367 VSS) capacitor c=2.77195e-16
C19 (net384 VSS) capacitor c=6.14441e-21
C20 (net392 VSS) capacitor c=3.45998e-18
C21 (net376 VSS) capacitor c=5.44488e-18
C22 (\22\:qbint VSS) capacitor c=4.63026e-17
C23 (\5\:qbint VSS) capacitor c=2.69934e-16
C24 (\4\:qbint VSS) capacitor c=3.89987e-17
C25 (\7\:CKbb VSS) capacitor c=5.0705e-17
C26 (\2\:CKb VSS) capacitor c=1.08704e-16
C27 (\3\:CKb VSS) capacitor c=1.48137e-16
C28 (\9\:CKb VSS) capacitor c=4.25248e-17
C29 (\1\:CK VSS) capacitor c=4.82764e-17
C30 (\1\:SI VSS) capacitor c=6.71498e-17
C31 (\3\:SEb VSS) capacitor c=4.37598e-17
C32 (\6\:SE VSS) capacitor c=4.54112e-17
C33 (\1\:D VSS) capacitor c=4.00885e-17
C34 (\1\:SE VSS) capacitor c=5.7244e-17
C35 (\20\:qbint VSS) capacitor c=3.58732e-17
C36 (\3\:qbint VSS) capacitor c=6.23678e-17
C37 (\5\:CKbb VSS) capacitor c=3.19605e-17
C38 (\3\:n20 VSS) capacitor c=2.86186e-17
C39 (\3\:mout VSS) capacitor c=5.37557e-17
C40 (\3\:CKbb VSS) capacitor c=4.88287e-17
C41 (\8\:CKb VSS) capacitor c=2.53211e-17
C42 (\7\:CKb VSS) capacitor c=2.46296e-17
C43 (\3\:CK VSS) capacitor c=2.57847e-17
C44 (\3\:SI VSS) capacitor c=2.93237e-17
C45 (\4\:SE VSS) capacitor c=5.08702e-17
C46 (\3\:D VSS) capacitor c=8.95322e-17
C47 (\3\:SE VSS) capacitor c=2.64e-17
C48 (\21\:qbint VSS) capacitor c=4.00807e-17
C49 (\8\:CKbb VSS) capacitor c=3.8851e-17
C50 (\6\:CKbb VSS) capacitor c=3.33208e-17
C51 (\2\:n20 VSS) capacitor c=3.23934e-17
C52 (\2\:mout VSS) capacitor c=5.24408e-17
C53 (\4\:CKbb VSS) capacitor c=2.54435e-17
C54 (\2\:CKbb VSS) capacitor c=5.51835e-17
C55 (\6\:CKb VSS) capacitor c=2.25935e-17
C56 (\2\:CK VSS) capacitor c=4.46936e-17
C57 (\2\:SI VSS) capacitor c=4.82997e-17
C58 (\4\:SEb VSS) capacitor c=3.26674e-17
C59 (\5\:SE VSS) capacitor c=5.90378e-17
C60 (\2\:SEb VSS) capacitor c=3.0228e-17
C61 (\2\:D VSS) capacitor c=6.40869e-17
C62 (\2\:SE VSS) capacitor c=4.06142e-17
C63 (\20\:net367 VSS) capacitor c=3.46361e-17
C64 (\1\:VDD VSS) capacitor c=4.55185e-16
C65 (\1\:Q VSS) capacitor c=1.52305e-16
C66 (\30\:qbint VSS) capacitor c=5.96205e-17
C67 (\10\:n30 VSS) capacitor c=5.85272e-17
C68 (\4\:mout VSS) capacitor c=2.1305e-17
C69 (\21\:VDD VSS) capacitor c=3.89064e-17
C70 (\8\:n20 VSS) capacitor c=3.82477e-17
C71 (\3\:Db VSS) capacitor c=2.30264e-16
C72 (\17\:CKbb VSS) capacitor c=1.03364e-16
C73 (\24\:VDD VSS) capacitor c=1.64383e-17
C74 (\14\:CKb VSS) capacitor c=6.9838e-17
C75 (\27\:VDD VSS) capacitor c=3.88764e-17
C76 (\8\:Db VSS) capacitor c=1.182e-17
C77 (\31\:VDD VSS) capacitor c=2.97923e-17
C78 (\10\:SEb VSS) capacitor c=8.57346e-17
C79 (\3\:VDD VSS) capacitor c=6.97059e-17
C80 (\16\:net367 VSS) capacitor c=4.4982e-17
C81 (\1\:QN VSS) capacitor c=1.19766e-16
C82 (\24\:qbint VSS) capacitor c=2.1274e-16
C83 (\8\:n30 VSS) capacitor c=6.45065e-17
C84 (\8\:mout VSS) capacitor c=5.06393e-17
C85 (\6\:n20 VSS) capacitor c=3.93036e-17
C86 (\12\:CKbb VSS) capacitor c=1.04118e-16
C87 (\12\:CKb VSS) capacitor c=5.16019e-17
C88 (\6\:Db VSS) capacitor c=1.09974e-16
C89 (\7\:SEb VSS) capacitor c=1.04749e-16
C90 (\4\:CKb VSS) capacitor c=6.28327e-17
C91 (\5\:CKb VSS) capacitor c=2.14389e-17
C92 (\2\:qbint VSS) capacitor c=3.73103e-17
C93 (\4\:D VSS) capacitor c=6.6694e-17
C94 (\7\:SE VSS) capacitor c=9.17478e-17
C95 (\8\:SE VSS) capacitor c=5.38042e-17
C96 (\5\:SEb VSS) capacitor c=2.32141e-17
C97 (\6\:SEb VSS) capacitor c=1.34479e-16
C98 (\9\:SEb VSS) capacitor c=1.29872e-16
C99 (\4\:CK VSS) capacitor c=6.99577e-17
C100 (\10\:CKb VSS) capacitor c=1.86009e-17
C101 (\11\:CKb VSS) capacitor c=7.31475e-17
C102 (\5\:Db VSS) capacitor c=2.14868e-16
C103 (\4\:n20 VSS) capacitor c=5.91774e-17
C104 (\5\:n20 VSS) capacitor c=5.91043e-17
C105 (\6\:mout VSS) capacitor c=5.46583e-17
C106 (\7\:mout VSS) capacitor c=5.25365e-17
C107 (\9\:CKbb VSS) capacitor c=2.60426e-17
C108 (\10\:CKbb VSS) capacitor c=1.12028e-16
C109 (\11\:CKbb VSS) capacitor c=6.11117e-17
C110 (\14\:CKbb VSS) capacitor c=1.34824e-16
C111 (\15\:CKbb VSS) capacitor c=6.33901e-17
C112 (\16\:CKbb VSS) capacitor c=7.41138e-17
C113 (\6\:n30 VSS) capacitor c=5.53689e-17
C114 (\7\:n30 VSS) capacitor c=8.70457e-17
C115 (\4\:Q VSS) capacitor c=1.21622e-16
C116 (\5\:QN VSS) capacitor c=1.65631e-16
C117 (\23\:qbint VSS) capacitor c=2.42629e-16
C118 (\26\:qbint VSS) capacitor c=3.23315e-17
C119 (\27\:qbint VSS) capacitor c=2.28383e-17
C120 (\28\:qbint VSS) capacitor c=4.73048e-17
C121 (\29\:qbint VSS) capacitor c=2.63562e-17
C122 (\18\:net367 VSS) capacitor c=3.53045e-17
C123 (\19\:net367 VSS) capacitor c=3.84853e-17
C124 (\20\:VDD VSS) capacitor c=2.12752e-17
C125 (\23\:VDD VSS) capacitor c=3.66137e-17
C126 (\26\:VDD VSS) capacitor c=2.1085e-17
C127 (\30\:VDD VSS) capacitor c=2.06204e-17
Rk1 (\4\:D D) resistor r=0.04824 c=0
Rk34 (\1\:Q Q) resistor r=0.04991 c=0
Rk35 (Q \4\:Q) resistor r=0.2087 c=0
Rk9 (CK \4\:CK) resistor r=0.1571 c=0
Rk8 (\4\:SI SI) resistor r=0.002999 c=0
Rk40 (\1\:QN QN) resistor r=0.2139 c=0
Rk41 (QN \5\:QN) resistor r=0.04798 c=0
Rk84 (\1\:VDD \19\:VDD) resistor r=0.3232 c=0
Rk85 (\19\:VDD \20\:VDD) resistor r=0.2555 c=0
Rk86 (\20\:VDD \22\:VDD) resistor r=0.3636 c=0
Rk87 (\20\:VDD \23\:VDD) resistor r=0.3923 c=0
Rk88 (\23\:VDD \25\:VDD) resistor r=0.04329 c=0
Rk89 (\23\:VDD \26\:VDD) resistor r=0.4524 c=0
Rk90 (\26\:VDD \28\:VDD) resistor r=0.229 c=0
Rk91 (\26\:VDD \29\:VDD) resistor r=0.1001 c=0
Rk94 (\30\:VDD VDD) resistor r=0.2277 c=0
Rk92 (\29\:VDD \30\:VDD) resistor r=0.3232 c=0
Rk93 (\30\:VDD \32\:VDD) resistor r=0.2336 c=0
Rk58 (\1\:VSS \9\:VSS) resistor r=0.258 c=0
Rk59 (\9\:VSS \10\:VSS) resistor r=0.2555 c=0
Rk60 (\10\:VSS \11\:VSS) resistor r=0.5913 c=0
Rk61 (\11\:VSS \12\:VSS) resistor r=0.2628 c=0
Rk62 (\12\:VSS \13\:VSS) resistor r=0.09256 c=0
Rk64 (\14\:VSS VSS) resistor r=0.2152 c=0
Rk63 (\13\:VSS \14\:VSS) resistor r=0.3357 c=0
Rk70 (\10\:VSS \26\:VSS) resistor r=0.1224 c=0
Rk71 (\11\:VSS \28\:VSS) resistor r=0.1936 c=0
Rk72 (\12\:VSS \30\:VSS) resistor r=0.127 c=0
Rk73 (\14\:VSS \32\:VSS) resistor r=0.07369 c=0
Rk3 (\8\:SE SE) resistor r=0.06515 c=0
Rk2 (\7\:SE \8\:SE) resistor r=0.3453 c=0
Rk4 (\5\:SEb \6\:SEb) resistor r=0.02032 c=0
Rk5 (\6\:SEb \8\:SEb) resistor r=0.4544 c=0
Rk6 (\6\:SEb \9\:SEb) resistor r=0.8152 c=0
Rk7 (\8\:SEb \11\:SEb) resistor r=0.7816 c=0
Rk13 (\2\:Db \4\:Db) resistor r=0.5362 c=0
Rk14 (\4\:Db \5\:Db) resistor r=1.4895 c=0
Rk15 (\5\:Db \7\:Db) resistor r=0.5994 c=0
Rk16 (\5\:Db \9\:Db) resistor r=0.05409 c=0
Rk10 (\10\:CKb \11\:CKb) resistor r=0.08108 c=0
Rk11 (\11\:CKb \13\:CKb) resistor r=0.3312 c=0
Rk12 (\11\:CKb \15\:CKb) resistor r=0.356 c=0
Rk23 (\9\:CKbb \10\:CKbb) resistor r=0.04789 c=0
Rk24 (\10\:CKbb \11\:CKbb) resistor r=0.1763 c=0
Rk25 (\11\:CKbb \13\:CKbb) resistor r=0.2652 c=0
Rk26 (\10\:CKbb \14\:CKbb) resistor r=0.9706 c=0
Rk27 (\14\:CKbb \15\:CKbb) resistor r=0.3035 c=0
Rk28 (\11\:CKbb \16\:CKbb) resistor r=0.3569 c=0
Rk29 (\13\:CKbb \18\:CKbb) resistor r=0.7036 c=0
Rk17 (\4\:n20 \5\:n20) resistor r=0.3076 c=0
Rk18 (\5\:n20 \7\:n20) resistor r=0.1276 c=0
Rk19 (\5\:n20 \9\:n20) resistor r=0.2579 c=0
Rk20 (\5\:mout \6\:mout) resistor r=0.1341 c=0
Rk21 (\6\:mout \7\:mout) resistor r=0.3002 c=0
Rk22 (\6\:mout \9\:mout) resistor r=0.2658 c=0
Rk30 (\6\:n30 \7\:n30) resistor r=0.2587 c=0
Rk31 (\7\:n30 \9\:n30) resistor r=0.3143 c=0
Rk32 (\7\:n30 \11\:n30) resistor r=0.4203 c=0
Rk44 (\23\:qbint \25\:qbint) resistor r=1.8863 c=0
Rk45 (\25\:qbint \26\:qbint) resistor r=0.431 c=0
Rk46 (\26\:qbint \27\:qbint) resistor r=0.1042 c=0
Rk47 (\27\:qbint \28\:qbint) resistor r=0.1785 c=0
Rk48 (\26\:qbint \29\:qbint) resistor r=0.06889 c=0
Rk49 (\27\:qbint \31\:qbint) resistor r=0.1976 c=0
Rk50 (\17\:net367 \18\:net367) resistor r=0.3545 c=0
Rk51 (\18\:net367 \19\:net367) resistor r=0.2097 c=0
Rk52 (\18\:net367 \21\:net367) resistor r=0.1229 c=0
Rl3 (\1\:D \2\:D) resistor r=39.1533 c=0
Rl4 (\2\:D \3\:D) resistor r=187.23 c=0
Rl11 (\1\:CK \2\:CK) resistor r=182.692 c=0
Rl12 (\2\:CK \3\:CK) resistor r=45.3297 c=0
Rl9 (\1\:SI \2\:SI) resistor r=186.538 c=0
Rl10 (\2\:SI \3\:SI) resistor r=41.7582 c=0
Rl7 (\5\:SE \6\:SE) resistor r=88.2566 c=0
Rl6 (\4\:SE \5\:SE) resistor r=169.208 c=0
Rl1 (\1\:SE \2\:SE) resistor r=198.077 c=0
Rl2 (\2\:SE \3\:SE) resistor r=29.9451 c=0
Rl8 (\3\:SEb \4\:SEb) resistor r=49.2328 c=0
Rl5 (SEb \2\:SEb) resistor r=44.9225 c=0
Rl21 (\2\:CKb \3\:CKb) resistor r=441.439 c=0
Rl20 (CKb \2\:CKb) resistor r=187.593 c=0
Rl25 (\6\:CKb \7\:CKb) resistor r=100.733 c=0
Rl22 (\3\:CKb \4\:CKb) resistor r=239.928 c=0
Rl26 (\4\:CKb \8\:CKb) resistor r=30.4507 c=0
Rl27 (\5\:CKb \9\:CKb) resistor r=107.374 c=0
Rl24 (\5\:CKb \6\:CKb) resistor r=73.4664 c=0
Rl23 (\4\:CKb \5\:CKb) resistor r=81.1594 c=0
Rl28 (\7\:CKbb \8\:CKbb) resistor r=29.5379 c=0
Rl19 (\5\:CKbb \6\:CKbb) resistor r=29.5379 c=0
Rl14 (\3\:CKbb \4\:CKbb) resistor r=87.1289 c=0
Rl13 (CKbb \2\:CKbb) resistor r=58.4139 c=0
Rl17 (n20 \2\:n20) resistor r=100.692 c=0
Rl18 (\2\:n20 \3\:n20) resistor r=29.5379 c=0
Rl15 (mout \2\:mout) resistor r=33.8482 c=0
Rl16 (\2\:mout \3\:mout) resistor r=93.4636 c=0
Rl65 (\21\:qbint \22\:qbint) resistor r=60.7713 c=0
Rl64 (\21\:qbint \20\:qbint) resistor r=69.7702 c=0
Rl31 (\2\:qbint \4\:qbint) resistor r=37.3411 c=0
Rl30 (\2\:qbint \3\:qbint) resistor r=129.214 c=0
Rl29 (\2\:qbint qbint) resistor r=6.99 c=0
Rz25 (\1\:VDD \3\:VDD) resistor r=6.8182 c=0
Rz26 (\19\:VDD \3\:VDD) resistor r=6.25 c=0
Rz27 (\29\:VDD \3\:VDD) resistor r=6.25 c=0
Rz21 (\26\:VSS \25\:VSS) resistor r=75 c=0
Rz22 (\28\:VSS \27\:VSS) resistor r=75 c=0
Rz23 (\30\:VSS \29\:VSS) resistor r=75 c=0
Rz24 (\32\:VSS \31\:VSS) resistor r=75 c=0
Rz1 (\7\:SEb \8\:SEb) resistor r=75 c=0
Rz3 (Db \2\:Db) resistor r=75 c=0
Rz4 (\6\:Db \7\:Db) resistor r=75 c=0
Rz2 (\12\:CKb \13\:CKb) resistor r=75 c=0
Rz7 (\12\:CKbb \13\:CKbb) resistor r=75 c=0
Rz5 (\6\:n20 \7\:n20) resistor r=75 c=0
Rz6 (\8\:mout \9\:mout) resistor r=75 c=0
Rz8 (\9\:n30 \8\:n30) resistor r=75 c=0
Rz13 (\25\:qbint \24\:qbint) resistor r=75 c=0
Rz14 (\17\:net367 \16\:net367) resistor r=75 c=0
Ry24 (\22\:VDD \21\:VDD) resistor r=62 c=0
Ry25 (\25\:VDD \24\:VDD) resistor r=62 c=0
Ry26 (\28\:VDD \27\:VDD) resistor r=62 c=0
Ry27 (\32\:VDD \31\:VDD) resistor r=62 c=0
Ry15 (\1\:VSS \3\:VSS) resistor r=5.6364 c=0
Ry16 (\9\:VSS \3\:VSS) resistor r=5.1667 c=0
Ry17 (\13\:VSS \3\:VSS) resistor r=5.1667 c=0
Ry1 (\10\:SEb \11\:SEb) resistor r=62 c=0
Ry3 (\3\:Db \4\:Db) resistor r=62 c=0
Ry4 (\8\:Db \9\:Db) resistor r=62 c=0
Ry2 (\14\:CKb \15\:CKb) resistor r=62 c=0
Ry7 (\17\:CKbb \18\:CKbb) resistor r=62 c=0
Ry5 (\8\:n20 \9\:n20) resistor r=62 c=0
Ry6 (\4\:mout \5\:mout) resistor r=62 c=0
Ry8 (\11\:n30 \10\:n30) resistor r=62 c=0
Ry13 (\31\:qbint \30\:qbint) resistor r=31 c=0
Ry14 (\21\:net367 \20\:net367) resistor r=20.6667 c=0
Rx1 (\2\:D \4\:D) resistor r=45 c=0
Rx7 (\2\:CK \4\:CK) resistor r=45 c=0
Rx6 (\2\:SI \4\:SI) resistor r=45 c=0
Rx2 (\5\:SE \7\:SE) resistor r=45 c=0
Rx3 (\2\:SE \8\:SE) resistor r=45 c=0
Rx4 (\2\:SEb \5\:SEb) resistor r=45 c=0
Rx5 (\4\:SEb \9\:SEb) resistor r=45 c=0
Rx8 (\6\:CKb \10\:CKb) resistor r=45 c=0
Rx11 (\4\:CKbb \9\:CKbb) resistor r=45 c=0
Rx12 (\6\:CKbb \14\:CKbb) resistor r=45 c=0
Rx13 (\8\:CKbb \15\:CKbb) resistor r=45 c=0
Rx14 (\2\:CKbb \16\:CKbb) resistor r=45 c=0
Rx9 (\2\:n20 \4\:n20) resistor r=45 c=0
Rx10 (\2\:mout \7\:mout) resistor r=45 c=0
Rx15 (\6\:n30 n30) resistor r=45 c=0
Rx16 (\23\:qbint \21\:qbint) resistor r=45 c=0
Rx17 (\28\:qbint qbint) resistor r=45 c=0
Rx18 (\29\:qbint \5\:qbint) resistor r=45 c=0
Rx19 (\19\:net367 net367) resistor r=45 c=0
mn10 (\7\:SEb \3\:SE \31\:VSS VSS) g45n1lvt w=(1.45e-07) l=4.5e-08 nf=1 \
        as=5.432e-14 ad=2.103e-14 ps=1.45e-06 pd=5.8e-07 nrd=1.16667 \
        nrs=1.16667 sa=1.45e-07 sb=1.26e-06 sd=160n sca=10.2779 \
        scb=0.00944477 scc=0.000275883 m=(1)
mn11 (net449 \3\:D \31\:VSS VSS) g45n1lvt w=(1.45e-07) l=4.5e-08 nf=1 \
        as=5.432e-14 ad=8.7e-15 ps=1.45e-06 pd=4.1e-07 nrd=1.16667 \
        nrs=1.16667 sa=4.05e-07 sb=1e-06 sd=160n sca=10.2779 \
        scb=0.00944477 scc=0.000275883 m=(1)
mn12 (\6\:Db SEb net449 VSS) g45n1lvt w=(1.45e-07) l=4.5e-08 nf=1 \
        as=8.7e-15 ad=2.32e-14 ps=4.1e-07 pd=6.1e-07 nrd=1.16667 \
        nrs=1.16667 sa=5.1e-07 sb=8.95e-07 sd=160n sca=10.2779 \
        scb=0.00944477 scc=0.000275883 m=(1)
mn14 (\6\:Db \4\:SE net461 VSS) g45n1lvt w=(1.45e-07) l=4.5e-08 nf=1 \
        as=3.48e-14 ad=2.32e-14 ps=7.7e-07 pd=6.1e-07 nrd=1.16667 \
        nrs=1.16667 sa=7.15e-07 sb=6.9e-07 sd=160n sca=10.2779 \
        scb=0.00944477 scc=0.000275883 m=(1)
mn13 (net461 \3\:SI \29\:VSS VSS) g45n1lvt w=(1.45e-07) l=4.5e-08 nf=1 \
        as=5.77e-14 ad=3.48e-14 ps=1.16e-06 pd=7.7e-07 nrd=1.16667 \
        nrs=1.16667 sa=1e-06 sb=4.05e-07 sd=160n sca=10.2779 \
        scb=0.00944477 scc=0.000275883 m=(1)
mn20 (\12\:CKb \3\:CK \29\:VSS VSS) g45n1lvt w=(1.45e-07) l=4.5e-08 nf=1 \
        as=5.77e-14 ad=2.03e-14 ps=1.16e-06 pd=5.7e-07 nrd=1.16667 \
        nrs=1.16667 sa=1.265e-06 sb=1.4e-07 sd=160n sca=10.2779 \
        scb=0.00944477 scc=0.000275883 m=(1)
mn21 (\12\:CKbb \7\:CKb \27\:VSS VSS) g45n1lvt w=(1.45e-07) l=4.5e-08 \
        nf=1 as=2.03e-14 ad=2.973e-14 ps=5.7e-07 pd=7e-07 nrd=1.16667 \
        nrs=1.16667 sa=1.4e-07 sb=2.05e-07 sd=160n sca=7.09016 \
        scb=0.00401586 scc=3.69756e-05 m=(1)
mn25 (\6\:n20 \8\:CKb Db VSS) g45n1lvt w=(1.45e-07) l=4.5e-08 nf=1 \
        as=2.03e-14 ad=4.422e-14 ps=5.7e-07 pd=9e-07 nrd=1.16667 \
        nrs=1.16667 sa=1.4e-07 sb=2e-06 sd=160n sca=13.253 scb=0.0137915 \
        scc=0.000695334 m=(1)
mn36 (\6\:n20 \3\:CKbb net429 VSS) g45n1lvt w=(1.45e-07) l=4.5e-08 nf=1 \
        as=1.45e-14 ad=4.422e-14 ps=4.9e-07 pd=9e-07 nrd=1.16667 \
        nrs=1.16667 sa=4.9e-07 sb=2e-06 sd=160n sca=13.253 scb=0.0137915 \
        scc=0.000695334 m=(1)
mn35 (net429 \3\:mout \25\:VSS VSS) g45n1lvt w=(1.45e-07) l=4.5e-08 nf=1 \
        as=6.43e-14 ad=1.45e-14 ps=1.27e-06 pd=4.9e-07 nrd=1.16667 \
        nrs=1.16667 sa=6.35e-07 sb=2e-06 sd=160n sca=13.253 scb=0.0137915 \
        scc=0.000695334 m=(1)
mn30 (\8\:mout \3\:n20 \25\:VSS VSS) g45n1lvt w=(1.45e-07) l=4.5e-08 \
        nf=1 as=6.43e-14 ad=4.422e-14 ps=1.27e-06 pd=9e-07 nrd=1.16667 \
        nrs=1.16667 sa=9e-07 sb=2e-06 sd=160n sca=13.253 scb=0.0137915 \
        scc=0.000695334 m=(1)
mn40 (\8\:n30 \5\:CKbb \8\:mout VSS) g45n1lvt w=(1.45e-07) l=4.5e-08 nf=1 \
        as=4.422e-14 ad=3.553e-14 ps=9e-07 pd=7.8e-07 nrd=1.16667 \
        nrs=1.16667 sa=1.25e-06 sb=2e-06 sd=160n sca=13.253 scb=0.0137915 \
        scc=0.000695334 m=(1)
mn51 (\8\:n30 CKb net436 VSS) g45n1lvt w=(1.45e-07) l=4.5e-08 nf=1 \
        as=1.087e-14 ad=3.552e-14 ps=4.4e-07 pd=7.8e-07 nrd=1.16667 \
        nrs=1.16667 sa=1.54e-06 sb=2e-06 sd=160n sca=13.253 scb=0.0137915 \
        scc=0.000695334 m=(1)
mn50 (net436 \3\:qbint \1\:VSS VSS) g45n1lvt w=(1.45e-07) l=4.5e-08 nf=1 \
        as=2.92e-14 ad=1.087e-14 ps=7.3e-07 pd=4.4e-07 nrd=1.16667 \
        nrs=1.16667 sa=1.66e-06 sb=2e-06 sd=160n sca=13.253 scb=0.0137915 \
        scc=0.000695334 m=(1)
mn45_1__rcx (\24\:qbint n30 \1\:VSS VSS) g45n1lvt w=(2.05e-07) l=4.5e-08 \
        nf=1 as=5.622e-14 ad=3.28e-14 ps=1.085e-06 pd=7.3e-07 nrd=1.16667 \
        nrs=1.16667 sa=1.34841e-06 sb=2e-06 sd=160n sca=12.107 \
        scb=0.0120364 scc=0.000565641 m=(2)
mn56 (\16\:net367 \20\:qbint \1\:VSS VSS) g45n1lvt w=(2.6e-07) l=4.5e-08 \
        nf=1 as=6.76e-14 ad=3.64e-14 ps=1.04e-06 pd=8e-07 nrd=1.16667 \
        nrs=1.16667 sa=2e-06 sb=1.4e-07 sd=160n sca=11.0409 scb=0.0104003 \
        scc=0.000454168 m=(1)
mn55_1__rcx (\4\:Q \5\:qbint \1\:VSS VSS) g45n1lvt w=(2.6e-07) l=4.5e-08 \
        nf=1 as=8.531e-14 ad=4.16e-14 ps=1.44e-06 pd=8.4e-07 nrd=1.16667 \
        nrs=1.16667 sa=1.28288e-06 sb=2e-06 sd=160n sca=11.0409 \
        scb=0.0104003 scc=0.000454168 m=(4)
mn57_1__rcx (\1\:QN net367 \1\:VSS VSS) g45n1lvt w=(2.6e-07) l=4.5e-08 \
        nf=1 as=8.14e-14 ad=4.745e-14 ps=1.34e-06 pd=8.85e-07 nrd=1.16667 \
        nrs=1.16667 sa=1.69865e-06 sb=1.165e-06 sd=160n sca=11.0409 \
        scb=0.0104003 scc=0.000454168 m=(4)
mp45 (\30\:qbint n30 \1\:VDD VDD) g45p1lvt w=(3.1e-07) l=4.5e-08 nf=1 \
        as=6.213e-14 ad=4.96e-14 ps=1.08e-06 pd=9.4e-07 nrd=1.16667 \
        nrs=1.16667 sa=1.29823e-06 sb=2e-06 sd=160n sca=17.3904 \
        scb=0.0162056 scc=0.00137566 m=(2)
mp56 (\20\:net367 \22\:qbint \1\:VDD VDD) g45p1lvt w=(3.9e-07) l=4.5e-08 \
        nf=1 as=6.24e-14 ad=5.46e-14 ps=1.1e-06 pd=1.06e-06 nrd=1.16667 \
        nrs=1.16667 sa=1.96e-06 sb=1.4e-07 sd=160n sca=32.2573 \
        scb=0.0215683 scc=0.00336427 m=(1)
mp55 (\1\:Q \5\:qbint \1\:VDD VDD) g45p1lvt w=(3.9e-07) l=4.5e-08 nf=1 \
        as=6.433e-14 ad=6.24e-14 ps=1.115e-06 pd=1.1e-06 nrd=1.16667 \
        nrs=1.16667 sa=1.27256e-06 sb=1.805e-06 sd=160n sca=30.5009 \
        scb=0.0202006 scc=0.00336097 m=(4)
mp57 (\5\:QN net367 \1\:VDD VDD) g45p1lvt w=(3.9e-07) l=4.5e-08 nf=1 \
        as=6.24e-14 ad=6.728e-14 ps=1.1e-06 pd=1.125e-06 nrd=1.16667 \
        nrs=1.16667 sa=1.64051e-06 sb=9.85e-07 sd=160n sca=30.5009 \
        scb=0.0202006 scc=0.00336097 m=(4)
ends SDFFX4
// End of subcircuit definition.
