// gsclib045_backbias/AOI221X2/schematic

simulator lang=spectre

subckt AOI221X2 A0 A1 B0 B1 C0 Y NW VSS VDD
mn2 (Y B0 net116 VSS) g45n1svt w=(520n) l=45n nf=1 m=(1)
mn3 (net116 B1 VSS VSS) g45n1svt w=(520n) l=45n nf=1 m=(1)
mn4 (Y C0 VSS VSS) g45n1svt w=(520n) l=45n nf=1 m=(1)
mn1 (Y A1 net124 VSS) g45n1svt w=(520n) l=45n nf=1 m=(1)
mn0 (net124 A0 VSS VSS) g45n1svt w=(520n) l=45n nf=1 m=(1)
mp3 (net104 B1 net103 NW) g45p1svt w=(780n) l=45n nf=1 m=(1)
mp2 (net104 B0 net103 NW) g45p1svt w=(780n) l=45n nf=1 m=(1)
mp0 (net103 A0 VDD NW) g45p1svt w=(780n) l=45n nf=1 m=(1)
mp1 (net103 A1 VDD NW) g45p1svt w=(780n) l=45n nf=1 m=(1)
mp4 (Y C0 net104 NW) g45p1svt w=(780n) l=45n nf=1 m=(1)
ends AOI221X2
