// gsclib045_hvt/OAI2BB1X4/schematic

simulator lang=spectre

subckt OAI2BB1X4 A0N A1N B0 Y VDD VSS
mp2 (Y B0 VDD VDD) g45p1hvt w=(1.56u) l=45n nf=1 m=(1)
mp1 (n0 A1N VDD VDD) g45p1hvt w=(390n) l=45n nf=1 m=(1)
mp0 (n0 A0N VDD VDD) g45p1hvt w=(390n) l=45n nf=1 m=(1)
mp3 (Y n0 VDD VDD) g45p1hvt w=(1.56u) l=45n nf=1 m=(1)
mn3 (Y n0 n2 VSS) g45n1hvt w=(1.04u) l=45n nf=1 m=(1)
mn2 (n2 B0 VSS VSS) g45n1hvt w=(1.04u) l=45n nf=1 m=(1)
mn0 (n1 A0N VSS VSS) g45n1hvt w=(260n) l=45n nf=1 m=(1)
mn1 (n0 A1N n1 VSS) g45n1hvt w=(260n) l=45n nf=1 m=(1)
ends OAI2BB1X4
