// Generated for: spectre (May  1 09:19:50 2013 )
// Library name: gsclib045_lvt
// Cell name: XOR3X1
// View name: extracted

simulator lang=spectre

subckt XOR3X1 A B C VDD VSS Y
mp10 (\14\:n62 \1\:A \8\:VDD VDD) g45p1lvt w=(3.9e-07) l=4.5e-08 nf=1 \
        as=1.27e-13 ad=6.435e-14 ps=1.91e-06 pd=1.11e-06 nrd=1.16667 \
        nrs=1.16667 sa=1.65e-07 sb=4.48205e-07 sd=160n sca=36.5002 \
        scb=0.0347521 scc=0.00363944 m=(1)
mp1 (n44 \3\:n61 \7\:n62 VDD) g45p1lvt w=(3.9e-07) l=4.5e-08 nf=1 \
        as=6.36e-14 ad=9.58e-14 ps=1.16e-06 pd=1.64e-06 nrd=1.16667 \
        nrs=1.16667 sa=3.46923e-07 sb=4.94359e-07 sd=160n sca=22.2743 \
        scb=0.0178838 scc=0.00227235 m=(1)
mp5 (\8\:n56 \11\:B \7\:n62 VDD) g45p1lvt w=(3.9e-07) l=4.5e-08 nf=1 \
        as=6.36e-14 ad=7.125e-14 ps=1.16e-06 pd=1.31e-06 nrd=1.16667 \
        nrs=1.16667 sa=4.95385e-07 sb=3.05128e-07 sd=160n sca=30.5009 \
        scb=0.0202006 scc=0.00336097 m=(1)
mp7 (\1\:Y n50 \1\:VDD VDD) g45p1lvt w=(3.9e-07) l=4.5e-08 nf=1 \
        as=1.365e-13 ad=6.63e-14 ps=1.88e-06 pd=1.12e-06 nrd=1.16667 \
        nrs=1.16667 sa=4.45513e-07 sb=1.7e-07 sd=160n sca=25.5198 \
        scb=0.0290048 scc=0.00173993 m=(1)
C1 (B VSS) capacitor c=5.49827e-17
C2 (A VSS) capacitor c=7.65449e-17
C3 (VDD VSS) capacitor c=3.32627e-16
C4 (C VSS) capacitor c=4.32068e-17
C5 (n62 VSS) capacitor c=6.88314e-17
C6 (n61 VSS) capacitor c=1.00817e-16
C7 (n11 VSS) capacitor c=6.74615e-17
C8 (n44 VSS) capacitor c=3.10298e-16
C9 (n56 VSS) capacitor c=8.39522e-17
C10 (n50 VSS) capacitor c=3.23358e-17
C11 (n60 VSS) capacitor c=4.58758e-17
C12 (\3\:C VSS) capacitor c=3.06074e-17
C13 (\7\:C VSS) capacitor c=3.47677e-17
C14 (\3\:n60 VSS) capacitor c=6.62554e-17
C15 (\2\:n61 VSS) capacitor c=9.36211e-17
C16 (\11\:B VSS) capacitor c=8.16041e-17
C17 (\3\:n61 VSS) capacitor c=1.33058e-16
C18 (\1\:B VSS) capacitor c=6.28229e-17
C19 (\3\:n62 VSS) capacitor c=4.79943e-17
C20 (\5\:B VSS) capacitor c=4.48206e-17
C21 (\1\:A VSS) capacitor c=4.67925e-17
C22 (\3\:n50 VSS) capacitor c=2.77528e-17
C23 (\6\:C VSS) capacitor c=4.51835e-17
C24 (\4\:n60 VSS) capacitor c=3.67883e-17
C25 (\1\:C VSS) capacitor c=4.2306e-17
C26 (\13\:B VSS) capacitor c=4.936e-17
C27 (\12\:B VSS) capacitor c=2.60663e-17
C28 (\6\:n61 VSS) capacitor c=3.802e-17
C29 (\6\:B VSS) capacitor c=3.71506e-17
C30 (\4\:A VSS) capacitor c=3.27282e-17
C31 (\2\:n50 VSS) capacitor c=2.03874e-17
C32 (\5\:C VSS) capacitor c=5.54428e-17
C33 (\2\:C VSS) capacitor c=2.52333e-17
C34 (\2\:n11 VSS) capacitor c=7.20406e-17
C35 (\14\:B VSS) capacitor c=3.72099e-17
C36 (\7\:B VSS) capacitor c=2.64739e-17
C37 (\10\:B VSS) capacitor c=3.04649e-17
C38 (\2\:B VSS) capacitor c=1.11053e-16
C39 (\4\:n62 VSS) capacitor c=3.37617e-17
C40 (\2\:n62 VSS) capacitor c=5.15526e-17
C41 (\5\:n61 VSS) capacitor c=9.12333e-17
C42 (\4\:B VSS) capacitor c=2.4466e-17
C43 (\3\:A VSS) capacitor c=1.26091e-17
C44 (\1\:Y VSS) capacitor c=3.28678e-17
C45 (\1\:VDD VSS) capacitor c=9.05527e-17
C46 (\5\:n60 VSS) capacitor c=6.49592e-17
C47 (\3\:n56 VSS) capacitor c=1.43421e-16
C48 (\8\:n50 VSS) capacitor c=9.73341e-17
C49 (\5\:n44 VSS) capacitor c=2.54299e-16
C50 (\4\:n11 VSS) capacitor c=1.26926e-16
C51 (\8\:n56 VSS) capacitor c=6.84579e-17
C52 (\7\:n62 VSS) capacitor c=1.54625e-16
C53 (\6\:n11 VSS) capacitor c=9.57844e-17
C54 (\6\:VDD VSS) capacitor c=1.06501e-17
C55 (\10\:n61 VSS) capacitor c=5.94111e-17
C56 (\8\:VDD VSS) capacitor c=3.87579e-17
C57 (\14\:n62 VSS) capacitor c=3.68726e-17
C58 (\3\:VDD VSS) capacitor c=1.63281e-16
C59 (\3\:Y VSS) capacitor c=4.9947e-17
C60 (\8\:n60 VSS) capacitor c=4.82908e-17
C61 (\6\:n50 VSS) capacitor c=9.80419e-17
C62 (\7\:n44 VSS) capacitor c=7.42973e-17
C63 (\9\:n11 VSS) capacitor c=1.39997e-16
C64 (\6\:n56 VSS) capacitor c=1.14989e-16
C65 (\5\:n62 VSS) capacitor c=8.44111e-17
C66 (\3\:n44 VSS) capacitor c=1.12341e-16
C67 (\11\:n11 VSS) capacitor c=1.34799e-16
C68 (\7\:n61 VSS) capacitor c=3.78496e-17
C69 (\11\:n62 VSS) capacitor c=1.30374e-16
C70 (\2\:A VSS) capacitor c=1.71928e-17
C71 (\3\:B VSS) capacitor c=6.31202e-17
C72 (\8\:B VSS) capacitor c=2.4619e-17
C73 (\9\:B VSS) capacitor c=1.33109e-17
C74 (\4\:n61 VSS) capacitor c=1.07801e-16
C75 (\2\:n60 VSS) capacitor c=5.54105e-17
C76 (\4\:C VSS) capacitor c=3.87755e-17
C77 (\5\:A VSS) capacitor c=3.58965e-17
C78 (\15\:B VSS) capacitor c=5.52388e-17
C79 (\9\:n61 VSS) capacitor c=3.55563e-17
C80 (\16\:B VSS) capacitor c=5.86816e-17
C81 (\17\:B VSS) capacitor c=5.7672e-17
C82 (\9\:n62 VSS) capacitor c=1.0217e-16
C83 (\10\:n62 VSS) capacitor c=1.35022e-16
C84 (\13\:n62 VSS) capacitor c=8.80177e-17
C85 (\18\:B VSS) capacitor c=3.66248e-17
C86 (\19\:B VSS) capacitor c=6.33784e-17
C87 (\3\:n11 VSS) capacitor c=5.28411e-17
C88 (\8\:n11 VSS) capacitor c=2.68451e-17
C89 (\8\:C VSS) capacitor c=4.94143e-17
C90 (\9\:C VSS) capacitor c=2.46967e-17
C91 (\5\:n56 VSS) capacitor c=1.79538e-16
C92 (\7\:n60 VSS) capacitor c=4.29869e-17
C93 (\4\:n50 VSS) capacitor c=4.14014e-17
C94 (\5\:n50 VSS) capacitor c=1.90599e-16
Rk38 (\2\:VSS \4\:VSS) resistor r=0.5477 c=0
Rk39 (\4\:VSS \5\:VSS) resistor r=1.1038 c=0
Rk41 (\7\:VSS VSS) resistor r=0.1851 c=0
Rk40 (\5\:VSS \7\:VSS) resistor r=0.04668 c=0
Rk42 (VSS \9\:VSS) resistor r=0.04107 c=0
Rk2 (\15\:B B) resistor r=0.1059 c=0
Rk6 (\16\:B \17\:B) resistor r=0.2407 c=0
Rk13 (\18\:B \19\:B) resistor r=0.1663 c=0
Rk1 (\5\:A A) resistor r=0.1078 c=0
Rk31 (\2\:Y Y) resistor r=0.2712 c=0
Rk32 (Y \4\:Y) resistor r=0.03227 c=0
Rk33 (\2\:VDD \4\:VDD) resistor r=0.556 c=0
Rk35 (\5\:VDD VDD) resistor r=0.453 c=0
Rk34 (\4\:VDD \5\:VDD) resistor r=1.1043 c=0
Rk36 (\5\:VDD \7\:VDD) resistor r=0.0715 c=0
Rk37 (VDD \9\:VDD) resistor r=0.09035 c=0
Rk20 (C \8\:C) resistor r=0.3097 c=0
Rk21 (C \9\:C) resistor r=0.02032 c=0
Rk7 (\6\:n62 \8\:n62) resistor r=0.5324 c=0
Rk8 (\8\:n62 \9\:n62) resistor r=0.6798 c=0
Rk9 (\9\:n62 \10\:n62) resistor r=0.5712 c=0
Rk10 (\10\:n62 \12\:n62) resistor r=0.6965 c=0
Rk11 (\12\:n62 \13\:n62) resistor r=0.6679 c=0
Rk12 (\10\:n62 \15\:n62) resistor r=0.142 c=0
Rk3 (\8\:n61 \9\:n61) resistor r=0.1097 c=0
Rk4 (\9\:n61 \11\:n61) resistor r=0.2038 c=0
Rk14 (\3\:n11 \5\:n11) resistor r=0.2383 c=0
Rk15 (\5\:n11 \7\:n11) resistor r=0.716 c=0
Rk16 (\8\:n11 \10\:n11) resistor r=0.119 c=0
Rk17 (\10\:n11 \12\:n11) resistor r=0.9659 c=0
Rk5 (\2\:n44 \4\:n44) resistor r=0.8235 c=0
Rk18 (\6\:n44 \8\:n44) resistor r=0.5607 c=0
Rk19 (\9\:n44 \10\:n44) resistor r=1.0211 c=0
Rk22 (\2\:n56 \4\:n56) resistor r=0.3916 c=0
Rk23 (\4\:n56 \5\:n56) resistor r=0.6721 c=0
Rk24 (\5\:n56 \7\:n56) resistor r=0.6991 c=0
Rk25 (\5\:n56 \9\:n56) resistor r=0.34 c=0
Rk28 (\4\:n50 \5\:n50) resistor r=0.1551 c=0
Rk29 (\5\:n50 \7\:n50) resistor r=0.8146 c=0
Rk30 (\5\:n50 \9\:n50) resistor r=0.7402 c=0
Rk26 (\6\:n60 \7\:n60) resistor r=0.1819 c=0
Rk27 (\7\:n60 \9\:n60) resistor r=0.09174 c=0
Rl21 (\13\:B \14\:B) resistor r=58.8482 c=0
Rl6 (\1\:B \2\:B) resistor r=135.771 c=0
Rl10 (\4\:B \6\:B) resistor r=24.2328 c=0
Rl9 (\3\:B \5\:B) resistor r=39.6181 c=0
Rl7 (\2\:B \3\:B) resistor r=370.63 c=0
Rl8 (\3\:B \4\:B) resistor r=35.0048 c=0
Rl14 (\8\:B \11\:B) resistor r=55.4507 c=0
Rl11 (\7\:B \8\:B) resistor r=19.1561 c=0
Rl15 (\9\:B \12\:B) resistor r=37.3411 c=0
Rl13 (\9\:B \10\:B) resistor r=10.9341 c=0
Rl12 (\8\:B \9\:B) resistor r=79.6267 c=0
Rl1 (\1\:A \2\:A) resistor r=88.1757 c=0
Rl3 (\2\:A \4\:A) resistor r=34.3295 c=0
Rl2 (\2\:A \3\:A) resistor r=6.708 c=0
Rl30 (\5\:C \7\:C) resistor r=26.1559 c=0
Rl23 (\1\:C \2\:C) resistor r=47.59 c=0
Rl27 (\3\:C \4\:C) resistor r=28.0797 c=0
Rl29 (\4\:C \6\:C) resistor r=103.08 c=0
Rl28 (\4\:C \5\:C) resistor r=172.554 c=0
Rl5 (\3\:n62 \4\:n62) resistor r=124.029 c=0
Rl4 (n62 \2\:n62) resistor r=214.575 c=0
Rl17 (\2\:n61 \3\:n61) resistor r=278.412 c=0
Rl16 (n61 \2\:n61) resistor r=215.318 c=0
Rl18 (\3\:n61 \4\:n61) resistor r=222.62 c=0
Rl20 (\4\:n61 \6\:n61) resistor r=63.143 c=0
Rl19 (\4\:n61 \5\:n61) resistor r=239.768 c=0
Rl22 (n11 \2\:n11) resistor r=420.614 c=0
Rl31 (n50 \2\:n50) resistor r=35.7713 c=0
Rl32 (\2\:n50 \3\:n50) resistor r=64.6174 c=0
Rl25 (\2\:n60 \3\:n60) resistor r=159.593 c=0
Rl26 (\2\:n60 \4\:n60) resistor r=70.8353 c=0
Rl24 (n60 \2\:n60) resistor r=106.101 c=0
Rz15 (\1\:VSS \2\:VSS) resistor r=18.75 c=0
Rz16 (\6\:VSS \7\:VSS) resistor r=75 c=0
Rz17 (\8\:VSS \9\:VSS) resistor r=75 c=0
Rz12 (\3\:Y \4\:Y) resistor r=75 c=0
Rz13 (\3\:VDD \4\:VDD) resistor r=7.5 c=0
Rz14 (\3\:VDD \5\:VDD) resistor r=6.25 c=0
Rz3 (\5\:n62 \6\:n62) resistor r=75 c=0
Rz4 (\11\:n62 \12\:n62) resistor r=75 c=0
Rz1 (\7\:n61 \8\:n61) resistor r=75 c=0
Rz5 (\9\:n11 \10\:n11) resistor r=75 c=0
Rz6 (\11\:n11 \12\:n11) resistor r=75 c=0
Rz2 (\3\:n44 \4\:n44) resistor r=75 c=0
Rz7 (\7\:n44 \8\:n44) resistor r=75 c=0
Rz8 (n56 \2\:n56) resistor r=75 c=0
Rz9 (\6\:n56 \7\:n56) resistor r=75 c=0
Rz11 (\6\:n50 \7\:n50) resistor r=75 c=0
Rz10 (\8\:n60 \9\:n60) resistor r=75 c=0
Ry18 (\3\:VSS \4\:VSS) resistor r=6.2 c=0
Ry19 (\3\:VSS \5\:VSS) resistor r=5.1667 c=0
Ry14 (\1\:Y \2\:Y) resistor r=62 c=0
Ry15 (\1\:VDD \2\:VDD) resistor r=12.4 c=0
Ry16 (\6\:VDD \7\:VDD) resistor r=62 c=0
Ry17 (\8\:VDD \9\:VDD) resistor r=31 c=0
Ry3 (\7\:n62 \8\:n62) resistor r=62 c=0
Ry4 (\14\:n62 \15\:n62) resistor r=62 c=0
Ry1 (\10\:n61 \11\:n61) resistor r=62 c=0
Ry5 (\4\:n11 \5\:n11) resistor r=62 c=0
Ry6 (\6\:n11 \7\:n11) resistor r=62 c=0
Ry2 (n44 \2\:n44) resistor r=62 c=0
Ry7 (\5\:n44 \6\:n44) resistor r=62 c=0
Ry8 (\5\:n44 \9\:n44) resistor r=62 c=0
Ry9 (n44 \10\:n44) resistor r=62 c=0
Ry10 (\3\:n56 \4\:n56) resistor r=62 c=0
Ry11 (\8\:n56 \9\:n56) resistor r=62 c=0
Ry13 (\8\:n50 \9\:n50) resistor r=62 c=0
Ry12 (\5\:n60 \6\:n60) resistor r=62 c=0
Rx2 (\4\:B \15\:B) resistor r=45 c=0
Rx4 (\2\:B \16\:B) resistor r=45 c=0
Rx5 (\10\:B \17\:B) resistor r=45 c=0
Rx8 (\14\:B \18\:B) resistor r=45 c=0
Rx9 (\7\:B \19\:B) resistor r=45 c=0
Rx1 (\3\:A \5\:A) resistor r=45 c=0
Rx12 (\2\:C \8\:C) resistor r=45 c=0
Rx13 (\5\:C \9\:C) resistor r=45 c=0
Rx6 (\4\:n62 \9\:n62) resistor r=45 c=0
Rx7 (\2\:n62 \13\:n62) resistor r=45 c=0
Rx3 (\5\:n61 \9\:n61) resistor r=45 c=0
Rx10 (n11 \3\:n11) resistor r=45 c=0
Rx11 (\2\:n11 \8\:n11) resistor r=45 c=0
Rx15 (\2\:n50 \4\:n50) resistor r=45 c=0
Rx14 (n60 \7\:n60) resistor r=45 c=0
mn10 (\11\:n62 \4\:A \8\:VSS VSS) g45n1lvt w=(2.05e-07) l=4.5e-08 nf=1 \
        as=8.295e-14 ad=3.485e-14 ps=1.47e-06 pd=7.5e-07 nrd=1.16667 \
        nrs=1.16667 sa=1.7e-07 sb=5.08293e-07 sd=160n sca=11.814 \
        scb=0.0116374 scc=0.000520744 m=(1)
mn1 (\5\:n62 \12\:B \3\:n44 VSS) g45n1lvt w=(2.05e-07) l=4.5e-08 nf=1 \
        as=8.74e-14 ad=4.715e-14 ps=1.27e-06 pd=8.7e-07 nrd=1.16667 \
        nrs=1.16667 sa=8.7122e-07 sb=6.6061e-07 sd=160n sca=8.14041 \
        scb=0.00590656 scc=0.000103269 m=(1)
mn5 (\5\:n62 n61 \6\:n56 VSS) g45n1lvt w=(2.05e-07) l=4.5e-08 nf=1 \
        as=3.82e-14 ad=4.715e-14 ps=7.9e-07 pd=8.7e-07 nrd=1.16667 \
        nrs=1.16667 sa=1.14622e-06 sb=3.8561e-07 sd=160n sca=8.14041 \
        scb=0.00590656 scc=0.000103269 m=(1)
mn7 (\3\:Y \3\:n50 \1\:VSS VSS) g45n1lvt w=(2.05e-07) l=4.5e-08 nf=1 \
        as=1.055e-13 ad=3.485e-14 ps=1.77e-06 pd=7.5e-07 nrd=1.16667 \
        nrs=1.16667 sa=4.9439e-07 sb=1.7e-07 sd=160n sca=19.867 \
        scb=0.0198061 scc=0.00201945 m=(1)
mn9 (\7\:n61 \6\:B \8\:VSS VSS) g45n1lvt w=(1.9e-07) l=4.5e-08 nf=1 \
        as=8.295e-14 ad=4.75e-14 ps=1.47e-06 pd=8.8e-07 nrd=1.16667 \
        nrs=1.16667 sa=4.55e-07 sb=2.5e-07 sd=160n sca=12.1373 \
        scb=0.0121311 scc=0.000556832 m=(1)
mn0 (\11\:n11 n62 \6\:VSS VSS) g45n1lvt w=(1.9e-07) l=4.5e-08 nf=1 \
        as=5.57e-14 ad=5.08e-14 ps=1.11e-06 pd=9.7e-07 nrd=1.16667 \
        nrs=1.16667 sa=1.7e-07 sb=1.42e-06 sd=160n sca=7.92284 \
        scb=0.00551663 scc=8.5052e-05 m=(1)
mn2 (\11\:n11 \6\:n61 \3\:n44 VSS) g45n1lvt w=(1.9e-07) l=4.5e-08 nf=1 \
        as=8.74e-14 ad=5.08e-14 ps=1.27e-06 pd=9.7e-07 nrd=1.16667 \
        nrs=1.16667 sa=4.35e-07 sb=1.155e-06 sd=160n sca=7.92284 \
        scb=0.00551663 scc=8.5052e-05 m=(1)
mn6 (\6\:n56 \13\:B \9\:n11 VSS) g45n1lvt w=(1.9e-07) l=4.5e-08 nf=1 \
        as=4.13e-14 ad=3.82e-14 ps=8.7e-07 pd=7.9e-07 nrd=1.16667 \
        nrs=1.16667 sa=1.42e-06 sb=1.7e-07 sd=160n sca=7.92284 \
        scb=0.00551663 scc=8.5052e-05 m=(1)
mn4 (\7\:n44 \1\:C \6\:n50 VSS) g45n1lvt w=(1.9e-07) l=4.5e-08 nf=1 \
        as=4.18e-14 ad=3.23e-14 ps=8.2e-07 pd=7.2e-07 nrd=1.16667 \
        nrs=1.16667 sa=1.7e-07 sb=4.35e-07 sd=160n sca=11.8451 \
        scb=0.0117279 scc=0.00051251 m=(1)
mn3 (n56 \4\:n60 \6\:n50 VSS) g45n1lvt w=(1.9e-07) l=4.5e-08 nf=1 \
        as=4.18e-14 ad=4.31e-14 ps=8.2e-07 pd=9e-07 nrd=1.16667 \
        nrs=1.16667 sa=4.35e-07 sb=1.7e-07 sd=160n sca=11.8451 \
        scb=0.0117279 scc=0.00051251 m=(1)
mn8 (\8\:n60 \6\:C \1\:VSS VSS) g45n1lvt w=(1.9e-07) l=4.5e-08 nf=1 \
        as=1.055e-13 ad=3.23e-14 ps=1.77e-06 pd=7.2e-07 nrd=1.16667 \
        nrs=1.16667 sa=1.7e-07 sb=5.2e-07 sd=160n sca=20.6114 \
        scb=0.0205722 scc=0.00215666 m=(1)
mp9 (\10\:n61 \5\:B \8\:VDD VDD) g45p1lvt w=(3.1e-07) l=4.5e-08 nf=1 \
        as=1.27e-13 ad=7.285e-14 ps=1.91e-06 pd=1.09e-06 nrd=1.16667 \
        nrs=1.16667 sa=4.5e-07 sb=2.35e-07 sd=160n sca=31.7573 \
        scb=0.0238304 scc=0.00348201 m=(1)
mp0 (\6\:n11 \3\:n62 \6\:VDD VDD) g45p1lvt w=(3.1e-07) l=4.5e-08 nf=1 \
        as=5.25e-14 ad=6.82e-14 ps=1.26e-06 pd=1.06e-06 nrd=1.16667 \
        nrs=1.16667 sa=1.1129e-07 sb=6.96452e-07 sd=160n sca=10.5719 \
        scb=0.0081746 scc=0.000117241 m=(1)
mp2 (n44 \1\:B \6\:n11 VDD) g45p1lvt w=(3.1e-07) l=4.5e-08 nf=1 \
        as=6.82e-14 ad=9.58e-14 ps=1.06e-06 pd=1.64e-06 nrd=1.16667 \
        nrs=1.16667 sa=3.7629e-07 sb=4.31452e-07 sd=160n sca=10.5719 \
        scb=0.0081746 scc=0.000117241 m=(1)
mp6 (\4\:n11 \2\:n61 \8\:n56 VDD) g45p1lvt w=(3.1e-07) l=4.5e-08 nf=1 \
        as=7.125e-14 ad=6.83e-14 ps=1.31e-06 pd=1.22e-06 nrd=1.16667 \
        nrs=1.16667 sa=7.01452e-07 sb=1.7e-07 sd=160n sca=13.1273 \
        scb=0.0119313 scc=0.000538101 m=(1)
mp4 (\8\:n50 \3\:n60 \5\:n44 VDD) g45p1lvt w=(3.1e-07) l=4.5e-08 nf=1 \
        as=6.83e-14 ad=4.96e-14 ps=1.22e-06 pd=9.4e-07 nrd=1.16667 \
        nrs=1.16667 sa=1.7e-07 sb=3.75e-07 sd=160n sca=14.8314 \
        scb=0.0138806 scc=0.000865287 m=(1)
mp3 (\8\:n50 \7\:C \3\:n56 VDD) g45p1lvt w=(3.1e-07) l=4.5e-08 nf=1 \
        as=5.27e-14 ad=4.96e-14 ps=9.6e-07 pd=9.4e-07 nrd=1.16667 \
        nrs=1.16667 sa=3.75e-07 sb=1.7e-07 sd=160n sca=14.8314 \
        scb=0.0138806 scc=0.000865287 m=(1)
mp8 (\5\:n60 \3\:C \1\:VDD VDD) g45p1lvt w=(3.1e-07) l=4.5e-08 nf=1 \
        as=1.365e-13 ad=5.27e-14 ps=1.88e-06 pd=9.6e-07 nrd=1.16667 \
        nrs=1.16667 sa=1.7e-07 sb=5.2e-07 sd=160n sca=16.2999 \
        scb=0.0148905 scc=0.000867022 m=(1)
ends XOR3X1
// End of subcircuit definition.
