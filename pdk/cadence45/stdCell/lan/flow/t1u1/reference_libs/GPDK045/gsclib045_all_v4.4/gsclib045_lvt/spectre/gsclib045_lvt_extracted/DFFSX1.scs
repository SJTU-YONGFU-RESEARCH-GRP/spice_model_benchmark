// Generated for: spectre (May  1 09:14:03 2013 )
// Library name: gsclib045_lvt
// Cell name: DFFSX1
// View name: extracted

simulator lang=spectre

subckt DFFSX1 CK D Q QN SN VDD VSS
mp57 (\3\:QN \4\:net331 \22\:VDD VDD) g45p1lvt w=(3.9e-07) l=4.5e-08 \
        nf=1 as=6.39e-14 ad=5.46e-14 ps=1.45e-06 pd=1.06e-06 nrd=1.16667 \
        nrs=1.16667 sa=1.4e-07 sb=2.30449e-07 sd=160n sca=44.1638 \
        scb=0.0392167 scc=0.00476734 m=(1)
mp55 (\3\:Q qbint \20\:VDD VDD) g45p1lvt w=(3.9e-07) l=4.5e-08 nf=1 \
        as=5.19e-14 ad=5.46e-14 ps=1.1e-06 pd=1.06e-06 nrd=1.16667 \
        nrs=1.16667 sa=1.4e-07 sb=2.25321e-07 sd=160n sca=30.8891 \
        scb=0.0203192 scc=0.003361 m=(1)
C1 (CK VSS) capacitor c=1.22501e-16
C2 (QN VSS) capacitor c=2.47227e-17
C3 (VDD VSS) capacitor c=2.6578e-16
C4 (SN VSS) capacitor c=4.24398e-17
C5 (Q VSS) capacitor c=4.07919e-17
C6 (net331 VSS) capacitor c=2.00669e-17
C7 (qbint VSS) capacitor c=4.07417e-17
C8 (n35 VSS) capacitor c=1.73266e-17
C9 (n42 VSS) capacitor c=1.60102e-18
C10 (n40 VSS) capacitor c=1.86397e-16
C11 (mout VSS) capacitor c=3.7294e-17
C12 (n20 VSS) capacitor c=2.44413e-17
C13 (CKb VSS) capacitor c=2.16148e-17
C14 (CKbb VSS) capacitor c=3.60703e-17
C15 (n30 VSS) capacitor c=1.87475e-18
C16 (n21 VSS) capacitor c=4.20568e-19
C17 (n41 VSS) capacitor c=1.3175e-16
C18 (\3\:CK VSS) capacitor c=3.20954e-17
C19 (\3\:D VSS) capacitor c=4.54736e-17
C20 (\5\:CKbb VSS) capacitor c=6.33788e-17
C21 (\8\:CKb VSS) capacitor c=3.33015e-17
C22 (\5\:CKb VSS) capacitor c=6.67673e-17
C23 (\3\:CKb VSS) capacitor c=2.83361e-17
C24 (\3\:CKbb VSS) capacitor c=7.3333e-17
C25 (\2\:n20 VSS) capacitor c=4.66786e-17
C26 (\1\:SN VSS) capacitor c=3.20353e-17
C27 (\6\:SN VSS) capacitor c=2.47657e-17
C28 (\7\:qbint VSS) capacitor c=3.03025e-17
C29 (\4\:n35 VSS) capacitor c=4.57315e-17
C30 (\6\:qbint VSS) capacitor c=3.55988e-17
C31 (\4\:net331 VSS) capacitor c=4.78065e-17
C32 (\1\:CK VSS) capacitor c=3.50337e-17
C33 (\1\:D VSS) capacitor c=6.67605e-17
C34 (\10\:CKb VSS) capacitor c=5.05418e-17
C35 (\8\:CKbb VSS) capacitor c=3.33039e-17
C36 (\4\:mout VSS) capacitor c=4.45052e-17
C37 (\6\:CKb VSS) capacitor c=4.54472e-17
C38 (\2\:CKb VSS) capacitor c=3.25561e-17
C39 (\3\:n20 VSS) capacitor c=6.69876e-17
C40 (\4\:SN VSS) capacitor c=4.08588e-17
C41 (\5\:SN VSS) capacitor c=3.13677e-17
C42 (\10\:qbint VSS) capacitor c=4.1363e-17
C43 (\3\:n35 VSS) capacitor c=3.4578e-17
C44 (\5\:qbint VSS) capacitor c=3.37797e-17
C45 (\4\:qbint VSS) capacitor c=2.70521e-17
C46 (\3\:net331 VSS) capacitor c=3.90302e-17
C47 (\2\:CK VSS) capacitor c=3.46454e-17
C48 (\2\:D VSS) capacitor c=4.35315e-17
C49 (\11\:CKb VSS) capacitor c=3.41532e-17
C50 (\9\:CKb VSS) capacitor c=5.24629e-17
C51 (\7\:CKbb VSS) capacitor c=5.92415e-17
C52 (\3\:mout VSS) capacitor c=2.49689e-17
C53 (\7\:CKb VSS) capacitor c=1.94788e-17
C54 (\4\:CKbb VSS) capacitor c=4.38105e-17
C55 (\4\:CKb VSS) capacitor c=4.15014e-17
C56 (\3\:SN VSS) capacitor c=3.61627e-17
C57 (\9\:qbint VSS) capacitor c=3.80581e-17
C58 (\2\:qbint VSS) capacitor c=3.48933e-17
C59 (\20\:CKb VSS) capacitor c=7.08381e-17
C60 (\1\:VDD VSS) capacitor c=5.41854e-17
C61 (\6\:n20 VSS) capacitor c=2.22804e-16
C62 (\12\:VDD VSS) capacitor c=3.47225e-17
C63 (\13\:CKbb VSS) capacitor c=5.13024e-17
C64 (\7\:mout VSS) capacitor c=6.54982e-17
C65 (\5\:n35 VSS) capacitor c=6.02624e-17
C66 (\14\:VDD VSS) capacitor c=3.3261e-17
C67 (\14\:mout VSS) capacitor c=4.31597e-17
C68 (\16\:VDD VSS) capacitor c=1.4527e-17
C69 (\3\:n41 VSS) capacitor c=9.10695e-17
C70 (\18\:VDD VSS) capacitor c=3.46044e-17
C71 (\14\:qbint VSS) capacitor c=5.32918e-17
C72 (\20\:VDD VSS) capacitor c=5.43429e-17
C73 (\3\:Q VSS) capacitor c=8.87965e-17
C74 (\5\:net331 VSS) capacitor c=3.02788e-17
C75 (\22\:VDD VSS) capacitor c=1.74993e-17
C76 (\3\:QN VSS) capacitor c=4.50711e-17
C77 (\3\:VDD VSS) capacitor c=3.74046e-17
C78 (\18\:CKb VSS) capacitor c=8.6156e-17
C79 (\4\:n20 VSS) capacitor c=8.94727e-17
C80 (\11\:CKbb VSS) capacitor c=4.13336e-17
C81 (\5\:mout VSS) capacitor c=8.77293e-17
C82 (\9\:n35 VSS) capacitor c=4.14436e-17
C83 (\11\:mout VSS) capacitor c=7.44148e-17
C84 (\3\:n40 VSS) capacitor c=1.82125e-16
C85 (\11\:qbint VSS) capacitor c=4.97037e-17
C86 (\1\:Q VSS) capacitor c=4.34701e-17
C87 (\9\:net331 VSS) capacitor c=2.96058e-17
C88 (\1\:QN VSS) capacitor c=1.84125e-17
C89 (\2\:net331 VSS) capacitor c=1.25231e-17
C90 (\3\:qbint VSS) capacitor c=3.70196e-17
C91 (\2\:n35 VSS) capacitor c=2.40468e-17
C92 (\2\:SN VSS) capacitor c=2.33387e-17
C93 (\2\:CKbb VSS) capacitor c=4.73681e-17
C94 (\2\:mout VSS) capacitor c=3.61808e-17
C95 (\6\:CKbb VSS) capacitor c=5.85752e-17
C96 (\7\:net331 VSS) capacitor c=2.95022e-17
C97 (\8\:net331 VSS) capacitor c=3.56323e-17
C98 (\13\:qbint VSS) capacitor c=3.19036e-17
C99 (\16\:qbint VSS) capacitor c=4.39995e-17
C100 (\17\:qbint VSS) capacitor c=2.08057e-17
C101 (\7\:SN VSS) capacitor c=4.74029e-17
C102 (\7\:n35 VSS) capacitor c=2.57331e-16
C103 (\8\:n35 VSS) capacitor c=2.15254e-16
C104 (\9\:mout VSS) capacitor c=1.6462e-16
C105 (\10\:mout VSS) capacitor c=1.10869e-16
C106 (\13\:mout VSS) capacitor c=8.80239e-17
C107 (\9\:CKbb VSS) capacitor c=7.02874e-17
C108 (\10\:CKbb VSS) capacitor c=6.4365e-17
C109 (\8\:n20 VSS) capacitor c=2.13553e-16
C110 (\4\:D VSS) capacitor c=1.14269e-16
C111 (\12\:CKb VSS) capacitor c=7.36659e-17
C112 (\13\:CKb VSS) capacitor c=6.03489e-17
C113 (\14\:CKb VSS) capacitor c=7.481e-17
C114 (\15\:CKb VSS) capacitor c=7.47835e-17
C115 (\16\:CKb VSS) capacitor c=4.10096e-17
C116 (\17\:CKb VSS) capacitor c=5.62102e-17
C117 (\22\:CKb VSS) capacitor c=9.26154e-17
C118 (\5\:VDD VSS) capacitor c=2.54638e-17
C119 (\6\:VDD VSS) capacitor c=3.35984e-17
C120 (\7\:VDD VSS) capacitor c=1.45407e-17
C121 (\8\:VDD VSS) capacitor c=7.47578e-18
C122 (\10\:VDD VSS) capacitor c=1.42176e-17
C123 (\11\:VDD VSS) capacitor c=7.41206e-18
Rk39 (\2\:VSS \4\:VSS) resistor r=0.4432 c=0
Rk40 (\4\:VSS \5\:VSS) resistor r=0.08418 c=0
Rk41 (\5\:VSS \6\:VSS) resistor r=0.739 c=0
Rk42 (\6\:VSS \7\:VSS) resistor r=0.2784 c=0
Rk43 (\7\:VSS \8\:VSS) resistor r=0.1303 c=0
Rk45 (\9\:VSS VSS) resistor r=0.1175 c=0
Rk44 (\8\:VSS \9\:VSS) resistor r=0.3033 c=0
Rk46 (\5\:VSS \11\:VSS) resistor r=0.08852 c=0
Rk47 (\6\:VSS \13\:VSS) resistor r=0.0744 c=0
Rk48 (\8\:VSS \15\:VSS) resistor r=0.1282 c=0
Rk49 (\9\:VSS \17\:VSS) resistor r=0.1618 c=0
Rk30 (\4\:CK CK) resistor r=0.003169 c=0
Rk29 (D \4\:D) resistor r=0.01204 c=0
Rk1 (QN \2\:QN) resistor r=0.07525 c=0
Rk2 (QN \4\:QN) resistor r=0.2628 c=0
Rk50 (\2\:VDD \4\:VDD) resistor r=0.6639 c=0
Rk51 (\4\:VDD \5\:VDD) resistor r=0.08032 c=0
Rk52 (\5\:VDD \6\:VDD) resistor r=0.5384 c=0
Rk53 (\6\:VDD \7\:VDD) resistor r=0.2035 c=0
Rk54 (\7\:VDD \8\:VDD) resistor r=0.2346 c=0
Rk55 (\8\:VDD \9\:VDD) resistor r=0.03996 c=0
Rk56 (\9\:VDD \10\:VDD) resistor r=0.1479 c=0
Rk58 (\11\:VDD VDD) resistor r=0.1175 c=0
Rk57 (\10\:VDD \11\:VDD) resistor r=0.2857 c=0
Rk59 (\5\:VDD \13\:VDD) resistor r=0.06359 c=0
Rk60 (\6\:VDD \15\:VDD) resistor r=0.06593 c=0
Rk61 (\7\:VDD \17\:VDD) resistor r=0.06593 c=0
Rk62 (\8\:VDD \19\:VDD) resistor r=0.36 c=0
Rk63 (\10\:VDD \21\:VDD) resistor r=0.4381 c=0
Rk64 (\11\:VDD \23\:VDD) resistor r=0.2256 c=0
Rk12 (SN \7\:SN) resistor r=0.01366 c=0
Rk6 (Q \2\:Q) resistor r=0.1069 c=0
Rk7 (Q \4\:Q) resistor r=0.2629 c=0
Rk3 (\6\:net331 \7\:net331) resistor r=0.1181 c=0
Rk4 (\7\:net331 \8\:net331) resistor r=0.1198 c=0
Rk5 (\7\:net331 \10\:net331) resistor r=0.1061 c=0
Rk8 (\12\:qbint \13\:qbint) resistor r=0.2573 c=0
Rk9 (\13\:qbint \15\:qbint) resistor r=0.2542 c=0
Rk10 (\15\:qbint \16\:qbint) resistor r=0.1884 c=0
Rk11 (\13\:qbint \17\:qbint) resistor r=0.04496 c=0
Rk15 (\6\:n35 \7\:n35) resistor r=0.2348 c=0
Rk16 (\7\:n35 \8\:n35) resistor r=1.6377 c=0
Rk17 (\7\:n35 \10\:n35) resistor r=0.1341 c=0
Rk14 (\2\:n40 \4\:n40) resistor r=1.1561 c=0
Rk18 (\6\:mout \8\:mout) resistor r=0.4925 c=0
Rk19 (\8\:mout \9\:mout) resistor r=0.07259 c=0
Rk20 (\9\:mout \10\:mout) resistor r=0.7369 c=0
Rk21 (\10\:mout \12\:mout) resistor r=0.2201 c=0
Rk22 (\9\:mout \13\:mout) resistor r=0.5706 c=0
Rk23 (\10\:mout \15\:mout) resistor r=0.1237 c=0
Rk27 (\5\:n20 \7\:n20) resistor r=0.4536 c=0
Rk28 (\7\:n20 \8\:n20) resistor r=1.4343 c=0
Rk31 (\12\:CKb \13\:CKb) resistor r=0.3575 c=0
Rk32 (\13\:CKb \14\:CKb) resistor r=0.376 c=0
Rk33 (\14\:CKb \15\:CKb) resistor r=0.2856 c=0
Rk34 (\15\:CKb \16\:CKb) resistor r=0.164 c=0
Rk35 (\13\:CKb \17\:CKb) resistor r=0.1666 c=0
Rk36 (\17\:CKb \19\:CKb) resistor r=0.4254 c=0
Rk37 (\19\:CKb \21\:CKb) resistor r=0.4455 c=0
Rk38 (\15\:CKb \22\:CKb) resistor r=0.4279 c=0
Rk24 (\9\:CKbb \10\:CKbb) resistor r=0.4481 c=0
Rk25 (\10\:CKbb \12\:CKbb) resistor r=0.1232 c=0
Rk26 (\10\:CKbb \14\:CKbb) resistor r=0.2133 c=0
Rk13 (\2\:n41 \4\:n41) resistor r=0.6791 c=0
Rl40 (\2\:CK \3\:CK) resistor r=39.5604 c=0
Rl39 (\1\:CK \2\:CK) resistor r=71.1538 c=0
Rl38 (\2\:D \3\:D) resistor r=29.0109 c=0
Rl37 (\1\:D \2\:D) resistor r=75.6797 c=0
Rl19 (\3\:SN \6\:SN) resistor r=43.4636 c=0
Rl18 (\3\:SN \5\:SN) resistor r=66.5405 c=0
Rl15 (\1\:SN \2\:SN) resistor r=66.5412 c=0
Rl17 (\2\:SN \4\:SN) resistor r=68.4643 c=0
Rl16 (\2\:SN \3\:SN) resistor r=67.722 c=0
Rl3 (\2\:net331 \4\:net331) resistor r=49.7141 c=0
Rl2 (\2\:net331 \3\:net331) resistor r=34.3295 c=0
Rl1 (net331 \2\:net331) resistor r=0.5213 c=0
Rl4 (qbint \2\:qbint) resistor r=58.8482 c=0
Rl7 (\2\:qbint \5\:qbint) resistor r=24.2328 c=0
Rl8 (\3\:qbint \6\:qbint) resistor r=60.772 c=0
Rl6 (\3\:qbint \4\:qbint) resistor r=28.0797 c=0
Rl5 (\2\:qbint \3\:qbint) resistor r=148.068 c=0
Rl12 (\7\:qbint \8\:qbint) resistor r=34.3295 c=0
Rl14 (\8\:qbint \10\:qbint) resistor r=95.868 c=0
Rl13 (\8\:qbint \9\:qbint) resistor r=0.5166 c=0
Rl11 (\2\:n35 \4\:n35) resistor r=67.0218 c=0
Rl10 (\2\:n35 \3\:n35) resistor r=36.2526 c=0
Rl9 (n35 \2\:n35) resistor r=5.915 c=0
Rl29 (mout \2\:mout) resistor r=34.3295 c=0
Rl31 (\2\:mout \4\:mout) resistor r=92.0218 c=0
Rl30 (\2\:mout \3\:mout) resistor r=1.2666 c=0
Rl21 (\2\:n20 \3\:n20) resistor r=153.412 c=0
Rl20 (n20 \2\:n20) resistor r=50.6918 c=0
Rl27 (\5\:CKb \6\:CKb) resistor r=134.615 c=0
Rl36 (\10\:CKb \11\:CKb) resistor r=26.1559 c=0
Rl32 (\8\:CKb \9\:CKb) resistor r=29.5379 c=0
Rl28 (\6\:CKb \7\:CKb) resistor r=26.1559 c=0
Rl23 (\3\:CKb \4\:CKb) resistor r=24.2328 c=0
Rl22 (CKb \2\:CKb) resistor r=32.2712 c=0
Rl25 (\2\:CKbb \3\:CKbb) resistor r=149.543 c=0
Rl24 (CKbb \2\:CKbb) resistor r=30.4507 c=0
Rl26 (\2\:CKbb \4\:CKbb) resistor r=98.4664 c=0
Rl33 (\5\:CKbb \6\:CKbb) resistor r=114.928 c=0
Rl35 (\6\:CKbb \8\:CKbb) resistor r=30.4507 c=0
Rl34 (\6\:CKbb \7\:CKbb) resistor r=104.516 c=0
Rz13 (\1\:VSS \2\:VSS) resistor r=75 c=0
Rz14 (\10\:VSS \11\:VSS) resistor r=75 c=0
Rz15 (\12\:VSS \13\:VSS) resistor r=75 c=0
Rz16 (\14\:VSS \15\:VSS) resistor r=75 c=0
Rz17 (\16\:VSS \17\:VSS) resistor r=75 c=0
Rz1 (\1\:QN \2\:QN) resistor r=37.5 c=0
Rz18 (\3\:VDD \4\:VDD) resistor r=7.5 c=0
Rz19 (\3\:VDD \9\:VDD) resistor r=6.25 c=0
Rz3 (\1\:Q \2\:Q) resistor r=37.5 c=0
Rz2 (\9\:net331 \10\:net331) resistor r=75 c=0
Rz4 (\11\:qbint \12\:qbint) resistor r=75 c=0
Rz7 (\9\:n35 \10\:n35) resistor r=75 c=0
Rz5 (n40 \2\:n40) resistor r=75 c=0
Rz6 (\3\:n40 \4\:n40) resistor r=75 c=0
Rz8 (\5\:mout \6\:mout) resistor r=75 c=0
Rz9 (\11\:mout \12\:mout) resistor r=75 c=0
Rz11 (\4\:n20 \5\:n20) resistor r=75 c=0
Rz12 (\18\:CKb \19\:CKb) resistor r=75 c=0
Rz10 (\11\:CKbb \12\:CKbb) resistor r=75 c=0
Ry13 (\3\:VSS \4\:VSS) resistor r=6.2 c=0
Ry14 (\3\:VSS \7\:VSS) resistor r=5.1667 c=0
Ry1 (\3\:QN \4\:QN) resistor r=20.6667 c=0
Ry15 (\1\:VDD \2\:VDD) resistor r=62 c=0
Ry16 (\12\:VDD \13\:VDD) resistor r=62 c=0
Ry17 (\14\:VDD \15\:VDD) resistor r=62 c=0
Ry18 (\16\:VDD \17\:VDD) resistor r=62 c=0
Ry19 (\18\:VDD \19\:VDD) resistor r=62 c=0
Ry20 (\20\:VDD \21\:VDD) resistor r=62 c=0
Ry21 (\22\:VDD \23\:VDD) resistor r=62 c=0
Ry3 (\3\:Q \4\:Q) resistor r=20.6667 c=0
Ry2 (\5\:net331 \6\:net331) resistor r=62 c=0
Ry4 (\14\:qbint \15\:qbint) resistor r=62 c=0
Ry7 (\5\:n35 \6\:n35) resistor r=62 c=0
Ry8 (\7\:mout \8\:mout) resistor r=62 c=0
Ry9 (\14\:mout \15\:mout) resistor r=62 c=0
Ry11 (\6\:n20 \7\:n20) resistor r=62 c=0
Ry12 (\20\:CKb \21\:CKb) resistor r=62 c=0
Ry10 (\13\:CKbb \14\:CKbb) resistor r=62 c=0
Ry5 (n41 \2\:n41) resistor r=62 c=0
Ry6 (\3\:n41 \4\:n41) resistor r=62 c=0
Rx11 (\2\:CK \4\:CK) resistor r=45 c=0
Rx10 (\2\:D \4\:D) resistor r=45 c=0
Rx4 (\3\:SN \7\:SN) resistor r=45 c=0
Rx1 (net331 \8\:net331) resistor r=45 c=0
Rx2 (\9\:qbint \16\:qbint) resistor r=45 c=0
Rx3 (\2\:qbint \17\:qbint) resistor r=45 c=0
Rx5 (n35 \8\:n35) resistor r=45 c=0
Rx6 (\3\:mout \13\:mout) resistor r=45 c=0
Rx9 (n20 \8\:n20) resistor r=45 c=0
Rx12 (\9\:CKb \12\:CKb) resistor r=45 c=0
Rx13 (\7\:CKb \14\:CKb) resistor r=45 c=0
Rx14 (CKb \16\:CKb) resistor r=45 c=0
Rx15 (\11\:CKb \17\:CKb) resistor r=45 c=0
Rx16 (\4\:CKb \22\:CKb) resistor r=45 c=0
Rx7 (\7\:CKbb \9\:CKbb) resistor r=45 c=0
Rx8 (\4\:CKbb \10\:CKbb) resistor r=45 c=0
mn57 (\1\:QN \3\:net331 \16\:VSS VSS) g45n1lvt w=(2.6e-07) l=4.5e-08 \
        nf=1 as=6.675e-14 ad=3.64e-14 ps=1.6e-06 pd=8e-07 nrd=1.16667 \
        nrs=1.16667 sa=1.4e-07 sb=2.31058e-07 sd=160n sca=17.5885 \
        scb=0.0172826 scc=0.00162584 m=(1)
mn55 (\1\:Q \5\:qbint \14\:VSS VSS) g45n1lvt w=(2.6e-07) l=4.5e-08 nf=1 \
        as=6.505e-14 ad=3.64e-14 ps=1.51e-06 pd=8e-07 nrd=1.16667 \
        nrs=1.16667 sa=1.4e-07 sb=2.41058e-07 sd=160n sca=12.8392 \
        scb=0.0126987 scc=0.00074151 m=(1)
mn56 (\9\:net331 \4\:qbint \16\:VSS VSS) g45n1lvt w=(1.45e-07) l=4.5e-08 \
        nf=1 as=6.675e-14 ad=2.03e-14 ps=1.6e-06 pd=5.7e-07 nrd=1.16667 \
        nrs=1.16667 sa=3.35e-07 sb=1.4e-07 sd=160n sca=23.279 \
        scb=0.0230742 scc=0.00267719 m=(1)
mn45 (\11\:qbint \3\:n35 \14\:VSS VSS) g45n1lvt w=(1.45e-07) l=4.5e-08 \
        nf=1 as=6.505e-14 ad=2.03e-14 ps=1.51e-06 pd=5.7e-07 nrd=1.16667 \
        nrs=1.16667 sa=3.45e-07 sb=1.4e-07 sd=160n sca=16.2011 \
        scb=0.0172667 scc=0.0012292 m=(1)
mn51 (\3\:n40 \10\:qbint n42 VSS) g45n1lvt w=(1.45e-07) l=4.5e-08 nf=1 \
        as=2.32e-14 ad=2.03e-14 ps=6.1e-07 pd=5.7e-07 nrd=1.16667 \
        nrs=1.16667 sa=1.4e-07 sb=6.7e-07 sd=160n sca=19.1673 \
        scb=0.0200674 scc=0.00182521 m=(1)
mn50 (n42 \5\:SN \12\:VSS VSS) g45n1lvt w=(1.45e-07) l=4.5e-08 nf=1 \
        as=5.137e-14 ad=2.32e-14 ps=1.56e-06 pd=6.1e-07 nrd=1.16667 \
        nrs=1.16667 sa=3.45e-07 sb=4.65e-07 sd=160n sca=19.1673 \
        scb=0.0200674 scc=0.00182521 m=(1)
mn30 (n25 \4\:SN \12\:VSS VSS) g45n1lvt w=(1.45e-07) l=4.5e-08 nf=1 \
        as=5.137e-14 ad=1.16e-14 ps=1.56e-06 pd=4.5e-07 nrd=1.16667 \
        nrs=1.16667 sa=5.45e-07 sb=2.65e-07 sd=160n sca=19.1673 \
        scb=0.0200674 scc=0.00182521 m=(1)
mn31 (\11\:mout \3\:n20 n25 VSS) g45n1lvt w=(1.45e-07) l=4.5e-08 nf=1 \
        as=1.16e-14 ad=2.03e-14 ps=4.5e-07 pd=5.7e-07 nrd=1.16667 \
        nrs=1.16667 sa=6.7e-07 sb=1.4e-07 sd=160n sca=19.1673 \
        scb=0.0200674 scc=0.00182521 m=(1)
mn52 (\9\:n35 \2\:CKb n40 VSS) g45n1lvt w=(1.45e-07) l=4.5e-08 nf=1 \
        as=2.03e-14 ad=3.19e-14 ps=5.7e-07 pd=7.3e-07 nrd=1.16667 \
        nrs=1.16667 sa=1.4e-07 sb=4.25e-07 sd=160n sca=19.1673 \
        scb=0.0200674 scc=0.00182521 m=(1)
mn40 (\9\:n35 CKbb \5\:mout VSS) g45n1lvt w=(1.45e-07) l=4.5e-08 nf=1 \
        as=2.32e-14 ad=3.19e-14 ps=6.1e-07 pd=7.3e-07 nrd=1.16667 \
        nrs=1.16667 sa=4.05e-07 sb=1.6e-07 sd=160n sca=19.1673 \
        scb=0.0200674 scc=0.00182521 m=(1)
mn21 (\11\:CKbb \6\:CKb \10\:VSS VSS) g45n1lvt w=(1.45e-07) l=4.5e-08 \
        nf=1 as=6.077e-14 ad=2.102e-14 ps=1.57e-06 pd=5.8e-07 nrd=1.16667 \
        nrs=1.16667 sa=1.45e-07 sb=1.2e-06 sd=160n sca=19.1673 \
        scb=0.0200674 scc=0.00182521 m=(1)
mn36 (n30 \4\:mout \10\:VSS VSS) g45n1lvt w=(1.45e-07) l=4.5e-08 nf=1 \
        as=6.077e-14 ad=4.422e-14 ps=1.57e-06 pd=9e-07 nrd=1.16667 \
        nrs=1.16667 sa=3.45e-07 sb=1e-06 sd=160n sca=19.1673 scb=0.0200674 \
        scc=0.00182521 m=(1)
mn35 (\4\:n20 \8\:CKbb n30 VSS) g45n1lvt w=(1.45e-07) l=4.5e-08 nf=1 \
        as=4.422e-14 ad=2.32e-14 ps=9e-07 pd=6.1e-07 nrd=1.16667 \
        nrs=1.16667 sa=6.95e-07 sb=6.5e-07 sd=160n sca=19.1673 \
        scb=0.0200674 scc=0.00182521 m=(1)
mn26 (\4\:n20 \10\:CKb n21 VSS) g45n1lvt w=(1.45e-07) l=4.5e-08 nf=1 \
        as=8.7e-15 ad=2.32e-14 ps=4.1e-07 pd=6.1e-07 nrd=1.16667 \
        nrs=1.16667 sa=9e-07 sb=4.45e-07 sd=160n sca=19.1673 scb=0.0200674 \
        scc=0.00182521 m=(1)
mn25 (n21 \1\:D \1\:VSS VSS) g45n1lvt w=(1.45e-07) l=4.5e-08 nf=1 \
        as=5.417e-14 ad=8.7e-15 ps=1.56e-06 pd=4.1e-07 nrd=1.16667 \
        nrs=1.16667 sa=1.005e-06 sb=3.4e-07 sd=160n sca=19.1673 \
        scb=0.0200674 scc=0.00182521 m=(1)
mn20 (\18\:CKb \1\:CK \1\:VSS VSS) g45n1lvt w=(1.45e-07) l=4.5e-08 nf=1 \
        as=5.417e-14 ad=2.03e-14 ps=1.56e-06 pd=5.7e-07 nrd=1.16667 \
        nrs=1.16667 sa=1.205e-06 sb=1.4e-07 sd=160n sca=19.1673 \
        scb=0.0200674 scc=0.00182521 m=(1)
mp56 (\5\:net331 \6\:qbint \22\:VDD VDD) g45p1lvt w=(2.15e-07) l=4.5e-08 \
        nf=1 as=6.39e-14 ad=3.01e-14 ps=1.45e-06 pd=7.1e-07 nrd=1.16667 \
        nrs=1.16667 sa=3.35e-07 sb=1.4e-07 sd=160n sca=49.623 \
        scb=0.0330309 scc=0.00593405 m=(1)
mp45 (\14\:qbint \4\:n35 \20\:VDD VDD) g45p1lvt w=(2.15e-07) l=4.5e-08 \
        nf=1 as=5.19e-14 ad=2.63e-14 ps=1.1e-06 pd=7.1e-07 nrd=1.16667 \
        nrs=1.16667 sa=3.45e-07 sb=1.22326e-07 sd=160n sca=45.7906 \
        scb=0.0283307 scc=0.00588417 m=(1)
mp51 (\3\:n41 \7\:qbint \18\:VDD VDD) g45p1lvt w=(2.15e-07) l=4.5e-08 \
        nf=1 as=2.99e-14 ad=3.44e-14 ps=7.7e-07 pd=7.5e-07 nrd=1.16667 \
        nrs=1.16667 sa=1.3907e-07 sb=7.15e-07 sd=160n sca=18.4975 \
        scb=0.0182651 scc=0.0015388 m=(1)
mp50 (\3\:n41 \6\:SN \16\:VDD VDD) g45p1lvt w=(2.15e-07) l=4.5e-08 nf=1 \
        as=6.588e-14 ad=3.44e-14 ps=1.72e-06 pd=7.5e-07 nrd=1.16667 \
        nrs=1.16667 sa=3.4407e-07 sb=5.1e-07 sd=160n sca=18.4975 \
        scb=0.0182651 scc=0.0015388 m=(1)
mp30 (\14\:mout \1\:SN \16\:VDD VDD) g45p1lvt w=(2.15e-07) l=4.5e-08 \
        nf=1 as=6.588e-14 ad=3.548e-14 ps=1.72e-06 pd=7.6e-07 nrd=1.16667 \
        nrs=1.16667 sa=5.4407e-07 sb=3.1e-07 sd=160n sca=18.4975 \
        scb=0.0182651 scc=0.0015388 m=(1)
mp31 (\14\:mout \2\:n20 \14\:VDD VDD) g45p1lvt w=(2.15e-07) l=4.5e-08 \
        nf=1 as=5.405e-14 ad=3.548e-14 ps=1.61e-06 pd=7.6e-07 nrd=1.16667 \
        nrs=1.16667 sa=7.5407e-07 sb=1e-07 sd=160n sca=18.4975 \
        scb=0.0182651 scc=0.0015388 m=(1)
mp52 (\5\:n35 \3\:CKbb n41 VDD) g45p1lvt w=(2.15e-07) l=4.5e-08 nf=1 \
        as=3.763e-14 ad=3.44e-14 ps=7.8e-07 pd=7.5e-07 nrd=1.16667 \
        nrs=1.16667 sa=1.75e-07 sb=3.45e-07 sd=160n sca=22.8495 \
        scb=0.0214046 scc=0.00242442 m=(1)
mp40 (\5\:n35 \3\:CKb \7\:mout VDD) g45p1lvt w=(2.15e-07) l=4.5e-08 nf=1 \
        as=3.01e-14 ad=3.44e-14 ps=7.1e-07 pd=7.5e-07 nrd=1.16667 \
        nrs=1.16667 sa=3.8e-07 sb=1.4e-07 sd=160n sca=22.8495 \
        scb=0.0214046 scc=0.00242442 m=(1)
mp21 (\13\:CKbb \5\:CKb \12\:VDD VDD) g45p1lvt w=(2.15e-07) l=4.5e-08 \
        nf=1 as=6.885e-14 ad=3.01e-14 ps=1.77e-06 pd=7.1e-07 nrd=1.16667 \
        nrs=1.16667 sa=1.4e-07 sb=1.145e-06 sd=160n sca=19.7413 \
        scb=0.019281 scc=0.00179464 m=(1)
mp35 (n31 mout \12\:VDD VDD) g45p1lvt w=(2.15e-07) l=4.5e-08 nf=1 \
        as=6.885e-14 ad=4.73e-14 ps=1.77e-06 pd=8.7e-07 nrd=1.16667 \
        nrs=1.16667 sa=3.4e-07 sb=9.45e-07 sd=160n sca=19.7413 \
        scb=0.019281 scc=0.00179464 m=(1)
mp36 (\6\:n20 \8\:CKb n31 VDD) g45p1lvt w=(2.15e-07) l=4.5e-08 nf=1 \
        as=4.73e-14 ad=3.44e-14 ps=8.7e-07 pd=7.5e-07 nrd=1.16667 \
        nrs=1.16667 sa=6.05e-07 sb=6.8e-07 sd=160n sca=19.9994 \
        scb=0.0193482 scc=0.00179465 m=(1)
mp26 (\6\:n20 \5\:CKbb n22 VDD) g45p1lvt w=(2.15e-07) l=4.5e-08 nf=1 \
        as=1.828e-14 ad=3.44e-14 ps=6e-07 pd=7.5e-07 nrd=1.16667 \
        nrs=1.16667 sa=8.1e-07 sb=4.75e-07 sd=160n sca=20.8128 \
        scb=0.0198722 scc=0.00179521 m=(1)
mp25 (n22 \3\:D \1\:VDD VDD) g45p1lvt w=(2.15e-07) l=4.5e-08 nf=1 \
        as=3.44e-14 ad=1.828e-14 ps=7.5e-07 pd=6e-07 nrd=1.16667 \
        nrs=1.16667 sa=9.4e-07 sb=3.45e-07 sd=160n sca=21.8401 \
        scb=0.0211222 scc=0.00180091 m=(1)
mp20 (\20\:CKb \3\:CK \1\:VDD VDD) g45p1lvt w=(2.15e-07) l=4.5e-08 nf=1 \
        as=3.44e-14 ad=3.01e-14 ps=7.5e-07 pd=7.1e-07 nrd=1.16667 \
        nrs=1.16667 sa=1.145e-06 sb=1.4e-07 sd=160n sca=26.2165 \
        scb=0.0285954 scc=0.00203663 m=(1)
ends DFFSX1
// End of subcircuit definition.
