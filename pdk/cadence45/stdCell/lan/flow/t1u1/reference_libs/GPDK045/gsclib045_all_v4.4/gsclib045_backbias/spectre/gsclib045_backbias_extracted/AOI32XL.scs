// Generated for: spectre (May  1 11:27:55 2013 )
// Library name: gsclib045_backbias
// Cell name: AOI32XL
// View name: extracted

simulator lang=spectre

subckt AOI32XL A0 A1 A2 B0 B1 NW VDD VSS Y
mp0 (net114 \1\:A0 \4\:VDD NW) g45p1svt w=(2.15e-07) l=4.5e-08 nf=1 \
        as=4.44e-14 ad=3.44e-14 ps=1.35e-06 pd=7.5e-07 nrd=1.16667 \
        nrs=1.16667 sa=1e-07 sb=1.12e-06 sd=160n sca=16.0514 scb=0.0157827 \
        scc=0.00029851 m=(1)
mp1 (net114 \1\:A1 \1\:VDD NW) g45p1svt w=(2.15e-07) l=4.5e-08 nf=1 \
        as=5.515e-14 ad=3.44e-14 ps=1.45e-06 pd=7.5e-07 nrd=1.16667 \
        nrs=1.16667 sa=3.05e-07 sb=9.15e-07 sd=160n sca=12.7829 \
        scb=0.0103785 scc=0.000190716 m=(1)
mp2 (\3\:net114 \1\:A2 \1\:VDD NW) g45p1svt w=(2.15e-07) l=4.5e-08 nf=1 \
        as=5.515e-14 ad=7.095e-14 ps=1.45e-06 pd=1.09e-06 nrd=1.16667 \
        nrs=1.16667 sa=5e-07 sb=7.2e-07 sd=160n sca=11.9309 scb=0.00939564 \
        scc=0.00018805 m=(1)
mp4 (\1\:Y \1\:B1 \3\:net114 NW) g45p1svt w=(2.15e-07) l=4.5e-08 nf=1 \
        as=7.095e-14 ad=3.44e-14 ps=1.09e-06 pd=7.5e-07 nrd=1.16667 \
        nrs=1.16667 sa=8.75e-07 sb=3.45e-07 sd=160n sca=13.6898 \
        scb=0.0116924 scc=0.000200935 m=(1)
mp3 (\1\:Y \1\:B0 \5\:net114 NW) g45p1svt w=(2.15e-07) l=4.5e-08 nf=1 \
        as=3.01e-14 ad=3.44e-14 ps=7.1e-07 pd=7.5e-07 nrd=1.16667 \
        nrs=1.16667 sa=1.08e-06 sb=1.4e-07 sd=160n sca=19.5246 \
        scb=0.021512 scc=0.000667372 m=(1)
C1 (A0 VSS) capacitor c=3.50665e-17
C2 (Y VSS) capacitor c=5.69032e-17
C3 (B1 VSS) capacitor c=1.04934e-16
C4 (NW VSS) capacitor c=2.58107e-16
C5 (VDD VSS) capacitor c=2.73018e-17
C6 (A2 VSS) capacitor c=5.04441e-17
C7 (B0 VSS) capacitor c=3.95058e-17
C8 (A1 VSS) capacitor c=4.30914e-17
C9 (net126 VSS) capacitor c=6.03317e-18
C10 (net130 VSS) capacitor c=5.90245e-19
C11 (net114 VSS) capacitor c=2.33689e-17
C12 (\1\:B0 VSS) capacitor c=3.41688e-17
C13 (\1\:B1 VSS) capacitor c=4.68534e-17
C14 (\1\:A2 VSS) capacitor c=5.80089e-17
C15 (\1\:A1 VSS) capacitor c=6.91271e-17
C16 (\1\:A0 VSS) capacitor c=4.45632e-17
C17 (\3\:B0 VSS) capacitor c=6.79433e-17
C18 (\3\:B1 VSS) capacitor c=4.12914e-17
C19 (\3\:A2 VSS) capacitor c=2.38309e-17
C20 (\3\:A1 VSS) capacitor c=2.92105e-17
C21 (\3\:A0 VSS) capacitor c=2.6319e-17
C22 (\4\:B0 VSS) capacitor c=1.21347e-17
C23 (\2\:B1 VSS) capacitor c=6.274e-17
C24 (\2\:A2 VSS) capacitor c=4.89064e-17
C25 (\2\:A1 VSS) capacitor c=5.93025e-17
C26 (\2\:A0 VSS) capacitor c=4.21652e-17
C27 (\5\:net114 VSS) capacitor c=6.87783e-17
C28 (\1\:Y VSS) capacitor c=5.59941e-17
C29 (\3\:net114 VSS) capacitor c=7.22144e-17
C30 (\1\:VDD VSS) capacitor c=1.47338e-16
C31 (\4\:VDD VSS) capacitor c=1.64308e-19
C32 (\3\:Y VSS) capacitor c=8.28505e-17
C33 (\2\:B0 VSS) capacitor c=4.84892e-17
C34 (\4\:A0 VSS) capacitor c=3.1562e-17
C35 (\4\:A1 VSS) capacitor c=7.00457e-17
C36 (\4\:A2 VSS) capacitor c=6.48052e-17
C37 (\5\:B0 VSS) capacitor c=4.61324e-17
C38 (\3\:VDD VSS) capacitor c=2.85763e-17
Rk1 (A0 \4\:A0) resistor r=0.1043 c=0
Rk5 (\2\:Y Y) resistor r=0.2993 c=0
Rk6 (Y \4\:Y) resistor r=0.4062 c=0
Rk4 (\4\:B1 B1) resistor r=0.00298 c=0
Rk10 (\2\:VSS \4\:VSS) resistor r=0.5648 c=0
Rk12 (\5\:VSS VSS) resistor r=0.07432 c=0
Rk11 (\4\:VSS \5\:VSS) resistor r=0.2739 c=0
Rk13 (\5\:VSS \7\:VSS) resistor r=0.284 c=0
Rk15 (\3\:VDD VDD) resistor r=0.05936 c=0
Rk14 (\2\:VDD \3\:VDD) resistor r=0.3088 c=0
Rk16 (\3\:VDD \5\:VDD) resistor r=0.07254 c=0
Rk3 (A2 \4\:A2) resistor r=0.2135 c=0
Rk7 (\5\:B0 B0) resistor r=0.0535 c=0
Rk2 (\4\:A1 A1) resistor r=0.1068 c=0
Rk8 (\2\:net114 \4\:net114) resistor r=0.2677 c=0
Rk9 (\4\:net114 \6\:net114) resistor r=0.4787 c=0
Rl1 (\1\:A0 \2\:A0) resistor r=154.944 c=0
Rl2 (\2\:A0 \3\:A0) resistor r=35.7134 c=0
Rl7 (\1\:B1 \2\:B1) resistor r=164.617 c=0
Rl8 (\2\:B1 \3\:B1) resistor r=30.0021 c=0
Rl5 (\1\:A2 \2\:A2) resistor r=170.387 c=0
Rl6 (\2\:A2 \3\:A2) resistor r=24.2328 c=0
Rl9 (\1\:B0 \2\:B0) resistor r=71.8171 c=0
Rl10 (\2\:B0 \3\:B0) resistor r=156.078 c=0
Rl11 (\2\:B0 \4\:B0) resistor r=5.1011 c=0
Rl3 (\1\:A1 \2\:A1) resistor r=168 c=0
Rl4 (\2\:A1 \3\:A1) resistor r=29.5379 c=0
Rz1 (\3\:Y \4\:Y) resistor r=75 c=0
Rz2 (\1\:VSS \2\:VSS) resistor r=75 c=0
Rz3 (\6\:VSS \7\:VSS) resistor r=75 c=0
Ry1 (\1\:Y \2\:Y) resistor r=62 c=0
Ry6 (\1\:VDD \2\:VDD) resistor r=62 c=0
Ry7 (\4\:VDD \5\:VDD) resistor r=62 c=0
Ry2 (net114 \2\:net114) resistor r=62 c=0
Ry3 (\3\:net114 \4\:net114) resistor r=62 c=0
Ry4 (\5\:net114 \6\:net114) resistor r=62 c=0
Rx1 (\2\:A0 \4\:A0) resistor r=45 c=0
Rx4 (\2\:B1 \4\:B1) resistor r=45 c=0
Rx3 (\2\:A2 \4\:A2) resistor r=45 c=0
Rx5 (\4\:B0 \5\:B0) resistor r=45 c=0
Rx2 (\2\:A1 \4\:A1) resistor r=45 c=0
mn0 (net126 \3\:A0 \6\:VSS VSS) g45n1svt w=(1.45e-07) l=4.5e-08 nf=1 \
        as=2.03e-14 ad=2.32e-14 ps=5.7e-07 pd=6.1e-07 nrd=1.16667 \
        nrs=1.16667 sa=1.4e-07 sb=1.02e-06 sd=160n sca=11.4452 \
        scb=0.0112553 scc=0.00042156 m=(1)
mn1 (net130 \3\:A1 net126 VSS) g45n1svt w=(1.45e-07) l=4.5e-08 nf=1 \
        as=2.32e-14 ad=2.175e-14 ps=6.1e-07 pd=5.9e-07 nrd=1.16667 \
        nrs=1.16667 sa=3.45e-07 sb=8.15e-07 sd=160n sca=11.4452 \
        scb=0.0112553 scc=0.00042156 m=(1)
mn2 (\3\:Y \3\:A2 net130 VSS) g45n1svt w=(1.45e-07) l=4.5e-08 nf=1 \
        as=2.175e-14 ad=4.785e-14 ps=5.9e-07 pd=9.5e-07 nrd=1.16667 \
        nrs=1.16667 sa=5.4e-07 sb=6.2e-07 sd=160n sca=11.4452 \
        scb=0.0112553 scc=0.00042156 m=(1)
mn4 (\3\:Y \3\:B1 net118 VSS) g45n1svt w=(1.45e-07) l=4.5e-08 nf=1 \
        as=8.7e-15 ad=4.785e-14 ps=4.1e-07 pd=9.5e-07 nrd=1.16667 \
        nrs=1.16667 sa=9.15e-07 sb=2.45e-07 sd=160n sca=11.4452 \
        scb=0.0112553 scc=0.00042156 m=(1)
mn3 (net118 \3\:B0 \1\:VSS VSS) g45n1svt w=(1.45e-07) l=4.5e-08 nf=1 \
        as=2.03e-14 ad=8.7e-15 ps=5.7e-07 pd=4.1e-07 nrd=1.16667 \
        nrs=1.16667 sa=1.02e-06 sb=1.4e-07 sd=160n sca=11.4452 \
        scb=0.0112553 scc=0.00042156 m=(1)
ends AOI32XL
// End of subcircuit definition.
