// Generated for: spectre (May  1 11:27:28 2013 )
// Library name: gsclib045_backbias
// Cell name: AOI21X2
// View name: extracted

simulator lang=spectre

subckt AOI21X2 A0 A1 B0 NW VDD VSS Y
mp0 (net70 A0 \1\:VDD NW) g45p1svt w=(3.9e-07) l=4.5e-08 nf=1 \
        as=6.24e-14 ad=6.922e-14 ps=1.1e-06 pd=1.135e-06 nrd=1.16667 \
        nrs=1.16667 sa=1.4e-07 sb=1.22e-06 sd=160n sca=39.514 \
        scb=0.0334743 scc=0.00392846 m=(2)
mp1 (\8\:net70 \1\:A1 \1\:VDD NW) g45p1svt w=(3.9e-07) l=4.5e-08 nf=1 \
        as=6.24e-14 ad=6.24e-14 ps=1.1e-06 pd=1.1e-06 nrd=1.16667 \
        nrs=1.16667 sa=3.45e-07 sb=1.015e-06 sd=160n sca=33.2136 \
        scb=0.0229892 scc=0.00337651 m=(2)
mp2 (\1\:Y \1\:B0 net70 NW) g45p1svt w=(3.9e-07) l=4.5e-08 nf=1 \
        as=6.922e-14 ad=6.24e-14 ps=1.135e-06 pd=1.1e-06 nrd=1.16667 \
        nrs=1.16667 sa=1.015e-06 sb=3.45e-07 sd=160n sca=33.1443 \
        scb=0.0228772 scc=0.00337517 m=(2)
C1 (A0 VSS) capacitor c=3.23956e-16
C2 (Y VSS) capacitor c=3.75193e-17
C3 (NW VSS) capacitor c=2.00994e-16
C4 (A1 VSS) capacitor c=4.76384e-17
C5 (VDD VSS) capacitor c=3.70059e-17
C6 (B0 VSS) capacitor c=3.98842e-17
C7 (9 VSS) capacitor c=2.32326e-18
C8 (net70 VSS) capacitor c=2.1166e-16
C9 (\1\:B0 VSS) capacitor c=8.56094e-17
C10 (\1\:A1 VSS) capacitor c=8.51734e-17
C11 (\6\:A0 VSS) capacitor c=5.3629e-17
C12 (\6\:A1 VSS) capacitor c=4.73042e-17
C13 (\4\:A1 VSS) capacitor c=5.3509e-17
C14 (\1\:A0 VSS) capacitor c=5.27991e-17
C15 (\1\:Y VSS) capacitor c=5.85529e-17
C16 (\1\:VDD VSS) capacitor c=2.56635e-16
C17 (\8\:net70 VSS) capacitor c=3.40443e-17
C18 (\3\:Y VSS) capacitor c=5.27524e-17
C19 (\5\:Y VSS) capacitor c=6.79386e-17
C20 (\3\:A1 VSS) capacitor c=3.95375e-17
C21 (\4\:B0 VSS) capacitor c=6.71e-17
C22 (\9\:A1 VSS) capacitor c=4.64945e-17
C23 (\8\:B0 VSS) capacitor c=4.04119e-17
Rk6 (\2\:Y Y) resistor r=0.2816 c=0
Rk7 (Y \4\:Y) resistor r=0.1446 c=0
Rk8 (\4\:Y \6\:Y) resistor r=0.4409 c=0
Rk1 (\7\:A1 A1) resistor r=0.005392 c=0
Rk3 (\7\:A1 \9\:A1) resistor r=0.0965 c=0
Rk2 (\8\:A1 \9\:A1) resistor r=0.005392 c=0
Rk15 (\1\:VSS \5\:VSS) resistor r=0.03487 c=0
Rk17 (\6\:VSS VSS) resistor r=0.07719 c=0
Rk16 (\5\:VSS \6\:VSS) resistor r=0.2728 c=0
Rk19 (\6\:VSS \10\:VSS) resistor r=0.1792 c=0
Rk21 (\1\:VDD VDD) resistor r=0.1298 c=0
Rk13 (B0 \8\:B0) resistor r=0.1159 c=0
Rk12 (net70 \9\:net70) resistor r=0.06065 c=0
Rl9 (A0 \6\:A0) resistor r=45.6044 c=0
Rl1 (A0 \1\:A0) resistor r=31.9251 c=0
Rl4 (\3\:A1 \1\:A1) resistor r=9.9515 c=0
Rl7 (\3\:A1 \6\:A1) resistor r=113.668 c=0
Rl5 (\3\:A1 \4\:A1) resistor r=70.6802 c=0
Rl12 (\4\:B0 \1\:B0) resistor r=26.8198 c=0
Rz1 (\4\:Y \3\:Y) resistor r=75 c=0
Rz2 (\6\:Y \5\:Y) resistor r=75 c=0
Rz5 (\10\:VSS \9\:VSS) resistor r=75 c=0
Ry1 (\2\:Y \1\:Y) resistor r=62 c=0
Ry5 (\9\:net70 \8\:net70) resistor r=31 c=0
Rx1 (\8\:A1 \1\:A1) resistor r=45 c=0
Rx4 (\8\:B0 \1\:B0) resistor r=45 c=0
mn0_1__rcx (8 \1\:A0 \9\:VSS VSS) g45n1svt w=(2.6e-07) l=4.5e-08 nf=1 \
        as=3.64e-14 ad=1.56e-14 ps=8e-07 pd=6.4e-07 nrd=1.16667 \
        nrs=1.16667 sa=1.4e-07 sb=9.95e-07 sd=160n sca=8.09546 \
        scb=0.00588493 scc=0.000117119 m=(1)
mn1_1__rcx (\5\:Y \4\:A1 8 VSS) g45n1svt w=(2.6e-07) l=4.5e-08 nf=1 \
        as=1.56e-14 ad=4.16e-14 ps=6.4e-07 pd=8.4e-07 nrd=1.16667 \
        nrs=1.16667 sa=2.45e-07 sb=8.9e-07 sd=160n sca=8.09546 \
        scb=0.00588493 scc=0.000117119 m=(1)
mn1 (\5\:Y \6\:A1 9 VSS) g45n1svt w=(2.6e-07) l=4.5e-08 nf=1 as=2.21e-14 \
        ad=4.16e-14 ps=6.9e-07 pd=8.4e-07 nrd=1.16667 nrs=1.16667 \
        sa=4.5e-07 sb=6.85e-07 sd=160n sca=8.09546 scb=0.00588493 \
        scc=0.000117119 m=(1)
mn0 (9 \6\:A0 \1\:VSS VSS) g45n1svt w=(2.6e-07) l=4.5e-08 nf=1 \
        as=4.29e-14 ad=2.21e-14 ps=8.5e-07 pd=6.9e-07 nrd=1.16667 \
        nrs=1.16667 sa=5.8e-07 sb=5.55e-07 sd=160n sca=8.09546 \
        scb=0.00588493 scc=0.000117119 m=(1)
mn2 (\3\:Y \4\:B0 \1\:VSS VSS) g45n1svt w=(2.6e-07) l=4.5e-08 nf=1 \
        as=3.965e-14 ad=4.16e-14 ps=8.25e-07 pd=8.4e-07 nrd=1.16667 \
        nrs=1.16667 sa=7.9e-07 sb=3.45e-07 sd=160n sca=8.09546 \
        scb=0.00588493 scc=0.000117119 m=(2)
ends AOI21X2
// End of subcircuit definition.
