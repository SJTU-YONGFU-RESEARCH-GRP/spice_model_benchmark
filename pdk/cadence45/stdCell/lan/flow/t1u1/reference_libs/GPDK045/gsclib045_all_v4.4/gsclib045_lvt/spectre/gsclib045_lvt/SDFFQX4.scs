// gsclib045_lvt/SDFFQX4/schematic

simulator lang=spectre

subckt SDFFQX4 CK D Q SE SI VSS VDD
mp14 (Db SEb n4 VDD) g45p1lvt w=(215n) l=45n nf=1 m=(1)
mp13 (n4 SI VDD VDD) g45p1lvt w=(215n) l=45n nf=1 m=(1)
mp12 (Db SE n2 VDD) g45p1lvt w=(215n) l=45n nf=1 m=(1)
mp11 (n2 D VDD VDD) g45p1lvt w=(215n) l=45n nf=1 m=(1)
mp51 (n30 CKbb n8 VDD) g45p1lvt w=(215n) l=45n nf=1 m=(1)
mp50 (n8 qbint VDD VDD) g45p1lvt w=(215n) l=45n nf=1 m=(1)
mp55 (Q qbint VDD VDD) g45p1lvt w=(1.56u) l=45n nf=1 m=(1)
mp35 (n6 mout VDD VDD) g45p1lvt w=(215n) l=45n nf=1 m=(1)
mp25 (n20 CKbb Db VDD) g45p1lvt w=(215n) l=45n nf=1 m=(1)
mp21 (CKbb CKb VDD VDD) g45p1lvt w=(215n) l=45n nf=1 m=(1)
mp30 (mout n20 VDD VDD) g45p1lvt w=(215n) l=45n nf=1 m=(1)
mp36 (n20 CKb n6 VDD) g45p1lvt w=(215n) l=45n nf=1 m=(1)
mp40 (n30 CKb mout VDD) g45p1lvt w=(215n) l=45n nf=1 m=(1)
mp10 (SEb SE VDD VDD) g45p1lvt w=(215n) l=45n nf=1 m=(1)
mp45 (qbint n30 VDD VDD) g45p1lvt w=(620n) l=45n nf=1 m=(1)
mp20 (CKb CK VDD VDD) g45p1lvt w=(215n) l=45n nf=1 m=(1)
mn13 (n3 SI VSS VSS) g45n1lvt w=(145n) l=45n nf=1 m=(1)
mn14 (Db SE n3 VSS) g45n1lvt w=(145n) l=45n nf=1 m=(1)
mn12 (Db SEb n1 VSS) g45n1lvt w=(145n) l=45n nf=1 m=(1)
mn11 (n1 D VSS VSS) g45n1lvt w=(145n) l=45n nf=1 m=(1)
mn55 (Q qbint VSS VSS) g45n1lvt w=(1.04u) l=45n nf=1 m=(1)
mn50 (n7 qbint VSS VSS) g45n1lvt w=(145n) l=45n nf=1 m=(1)
mn10 (SEb SE VSS VSS) g45n1lvt w=(145n) l=45n nf=1 m=(1)
mn40 (mout CKbb n30 VSS) g45n1lvt w=(145n) l=45n nf=1 m=(1)
mn35 (n20 CKbb n5 VSS) g45n1lvt w=(145n) l=45n nf=1 m=(1)
mn36 (n5 mout VSS VSS) g45n1lvt w=(145n) l=45n nf=1 m=(1)
mn20 (CKb CK VSS VSS) g45n1lvt w=(145n) l=45n nf=1 m=(1)
mn51 (n30 CKb n7 VSS) g45n1lvt w=(145n) l=45n nf=1 m=(1)
mn21 (CKbb CKb VSS VSS) g45n1lvt w=(145n) l=45n nf=1 m=(1)
mn45 (qbint n30 VSS VSS) g45n1lvt w=(410n) l=45n nf=1 m=(1)
mn25 (Db CKb n20 VSS) g45n1lvt w=(145n) l=45n nf=1 m=(1)
mn30 (mout n20 VSS VSS) g45n1lvt w=(145n) l=45n nf=1 m=(1)
ends SDFFQX4
