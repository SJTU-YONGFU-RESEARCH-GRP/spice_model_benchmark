// Generated for: spectre (May  1 09:17:13 2013 )
// Library name: gsclib045_lvt
// Cell name: NOR2X4
// View name: extracted

simulator lang=spectre

subckt NOR2X4 A B VDD VSS Y
mp0_1__rcx (2 \1\:A \8\:VDD VDD) g45p1lvt w=(3.9e-07) l=4.5e-08 nf=1 \
        as=5.46e-14 ad=2.34e-14 ps=1.06e-06 pd=9e-07 nrd=1.16667 \
        nrs=1.16667 sa=1.4e-07 sb=1.275e-06 sd=160n sca=17.191 \
        scb=0.0171908 scc=0.000536617 m=(1)
mp1_1__rcx (\9\:Y \5\:B 2 VDD) g45p1lvt w=(3.9e-07) l=4.5e-08 nf=1 \
        as=2.34e-14 ad=6.24e-14 ps=9e-07 pd=1.1e-06 nrd=1.16667 \
        nrs=1.16667 sa=2.45e-07 sb=1.17e-06 sd=160n sca=15.1734 \
        scb=0.013698 scc=0.000458097 m=(1)
mp1_2__rcx (\9\:Y \1\:B 3 VDD) g45p1lvt w=(3.9e-07) l=4.5e-08 nf=1 \
        as=2.34e-14 ad=6.24e-14 ps=9e-07 pd=1.1e-06 nrd=1.16667 \
        nrs=1.16667 sa=4.5e-07 sb=9.65e-07 sd=160n sca=13.4386 \
        scb=0.0114697 scc=0.000444227 m=(1)
mp0_2__rcx (3 \10\:A \5\:VDD VDD) g45p1lvt w=(3.9e-07) l=4.5e-08 nf=1 \
        as=6.24e-14 ad=2.34e-14 ps=1.1e-06 pd=9e-07 nrd=1.16667 \
        nrs=1.16667 sa=5.55e-07 sb=8.6e-07 sd=160n sca=12.9998 \
        scb=0.0111784 scc=0.000443945 m=(1)
mp0_3__rcx (6 \4\:A \5\:VDD VDD) g45p1lvt w=(3.9e-07) l=4.5e-08 nf=1 \
        as=6.24e-14 ad=4.095e-14 ps=1.1e-06 pd=9.9e-07 nrd=1.16667 \
        nrs=1.16667 sa=7.6e-07 sb=6.55e-07 sd=160n sca=12.8726 \
        scb=0.0111206 scc=0.000443921 m=(1)
mp1_3__rcx (\15\:Y \10\:B 6 VDD) g45p1lvt w=(3.9e-07) l=4.5e-08 nf=1 \
        as=4.095e-14 ad=6.24e-14 ps=9.9e-07 pd=1.1e-06 nrd=1.16667 \
        nrs=1.16667 sa=9.1e-07 sb=5.05e-07 sd=160n sca=13.4643 \
        scb=0.0114911 scc=0.000444259 m=(1)
mp1 (\15\:Y \12\:B 7 VDD) g45p1lvt w=(3.9e-07) l=4.5e-08 nf=1 \
        as=4.485e-14 ad=6.24e-14 ps=1.01e-06 pd=1.1e-06 nrd=1.16667 \
        nrs=1.16667 sa=1.115e-06 sb=3e-07 sd=160n sca=15.2428 scb=0.01381 \
        scc=0.000459441 m=(1)
mp0 (7 \13\:A \1\:VDD VDD) g45p1lvt w=(3.9e-07) l=4.5e-08 nf=1 \
        as=5.46e-14 ad=4.485e-14 ps=1.06e-06 pd=1.01e-06 nrd=1.16667 \
        nrs=1.16667 sa=1.275e-06 sb=1.4e-07 sd=160n sca=19.2125 \
        scb=0.0206809 scc=0.000707669 m=(1)
C1 (B VSS) capacitor c=4.93373e-16
C2 (VDD VSS) capacitor c=1.11449e-16
C3 (A VSS) capacitor c=6.82108e-16
C4 (Y VSS) capacitor c=7.73261e-17
C5 (3 VSS) capacitor c=1.85973e-18
C6 (6 VSS) capacitor c=3.10844e-18
C7 (7 VSS) capacitor c=4.10496e-18
C8 (\13\:A VSS) capacitor c=5.03832e-17
C9 (\12\:B VSS) capacitor c=3.9746e-17
C10 (\10\:B VSS) capacitor c=4.01408e-17
C11 (\4\:A VSS) capacitor c=4.59148e-17
C12 (\10\:A VSS) capacitor c=6.65597e-17
C13 (\1\:B VSS) capacitor c=5.91799e-17
C14 (\5\:B VSS) capacitor c=7.34376e-17
C15 (\1\:A VSS) capacitor c=7.86499e-17
C16 (\1\:VDD VSS) capacitor c=5.65791e-17
C17 (\15\:Y VSS) capacitor c=3.60566e-17
C18 (\5\:VDD VSS) capacitor c=5.30514e-17
C19 (\9\:Y VSS) capacitor c=1.08677e-16
C20 (\8\:VDD VSS) capacitor c=3.98543e-17
C21 (\1\:Y VSS) capacitor c=5.0529e-16
C22 (\8\:Y VSS) capacitor c=1.40404e-16
C23 (\4\:VDD VSS) capacitor c=3.84244e-17
C24 (\7\:VDD VSS) capacitor c=1.42271e-17
Rk24 (\2\:VDD \4\:VDD) resistor r=0.641 c=0
Rk25 (\4\:VDD \6\:VDD) resistor r=0.2957 c=0
Rk28 (\7\:VDD VDD) resistor r=0.07986 c=0
Rk26 (\4\:VDD \7\:VDD) resistor r=0.3215 c=0
Rk27 (\7\:VDD \9\:VDD) resistor r=0.2895 c=0
Rk10 (\1\:Y Y) resistor r=0.3389 c=0
Rk11 (Y \8\:Y) resistor r=0.3891 c=0
Rk12 (\8\:Y \10\:Y) resistor r=0.5878 c=0
Rk15 (\8\:Y \16\:Y) resistor r=0.09058 c=0
Rl18 (B \12\:B) resistor r=43.4713 c=0
Rl16 (B \10\:B) resistor r=37.3423 c=0
Rl3 (B \1\:B) resistor r=34.766 c=0
Rl6 (B \5\:B) resistor r=57.3425 c=0
Rl20 (A \13\:A) resistor r=72.2527 c=0
Rl8 (A \4\:A) resistor r=77.7258 c=0
Rl13 (A \10\:A) resistor r=77.7258 c=0
Rl1 (A \1\:A) resistor r=100.988 c=0
Ry4 (\1\:VDD \2\:VDD) resistor r=20.6667 c=0
Ry5 (\5\:VDD \6\:VDD) resistor r=31 c=0
Ry6 (\8\:VDD \9\:VDD) resistor r=20.6667 c=0
Ry1 (\10\:Y \9\:Y) resistor r=20.6667 c=0
Ry2 (\16\:Y \15\:Y) resistor r=20.6667 c=0
mn0_1__rcx (\1\:Y A VSS VSS) g45n1lvt w=(2.6e-07) l=4.5e-08 nf=1 \
        as=4.223e-14 ad=4.16e-14 ps=9.85e-07 pd=8.4e-07 nrd=1.16667 \
        nrs=1.16667 sa=1e-07 sb=1.575e-06 sd=160n sca=14.4034 \
        scb=0.0144248 scc=0.00102063 m=(4)
mn1_1__rcx (\1\:Y B VSS VSS) g45n1lvt w=(2.6e-07) l=4.5e-08 nf=1 \
        as=4.16e-14 ad=4.16e-14 ps=8.4e-07 pd=8.4e-07 nrd=1.16667 \
        nrs=1.16667 sa=3.05e-07 sb=1.37e-06 sd=160n sca=14.4034 \
        scb=0.0144248 scc=0.00102063 m=(4)
ends NOR2X4
// End of subcircuit definition.
