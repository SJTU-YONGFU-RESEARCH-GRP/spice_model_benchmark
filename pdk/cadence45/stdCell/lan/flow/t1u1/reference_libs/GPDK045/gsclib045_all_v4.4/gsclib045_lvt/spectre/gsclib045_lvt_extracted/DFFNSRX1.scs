// Generated for: spectre (May  1 09:13:33 2013 )
// Library name: gsclib045_lvt
// Cell name: DFFNSRX1
// View name: extracted

simulator lang=spectre

subckt DFFNSRX1 CKN D Q QN RN SN VDD VSS
mp57 (\1\:QN qint \26\:VDD VDD) g45p1lvt w=(3.9e-07) l=4.5e-08 nf=1 \
        as=5.19e-14 ad=5.46e-14 ps=1.1e-06 pd=1.06e-06 nrd=1.16667 \
        nrs=1.16667 sa=1.4e-07 sb=2.35064e-07 sd=160n sca=44.1638 \
        scb=0.0392167 scc=0.00476734 m=(1)
mp55 (\3\:Q qbint \24\:VDD VDD) g45p1lvt w=(3.9e-07) l=4.5e-08 nf=1 \
        as=5.19e-14 ad=5.46e-14 ps=1.1e-06 pd=1.06e-06 nrd=1.16667 \
        nrs=1.16667 sa=1.4e-07 sb=2.54359e-07 sd=160n sca=18.7372 \
        scb=0.0160946 scc=0.00159617 m=(1)
C1 (RN VSS) capacitor c=3.33204e-17
C2 (CKN VSS) capacitor c=8.42887e-17
C3 (QN VSS) capacitor c=4.04962e-17
C4 (D VSS) capacitor c=1.16797e-16
C5 (Q VSS) capacitor c=8.77591e-17
C6 (VDD VSS) capacitor c=3.58782e-16
C7 (SN VSS) capacitor c=2.41033e-16
C8 (qint VSS) capacitor c=4.60795e-17
C9 (qbint VSS) capacitor c=5.22954e-17
C10 (RNb VSS) capacitor c=5.98e-17
C11 (n35 VSS) capacitor c=3.53398e-17
C12 (n42 VSS) capacitor c=6.0511e-17
C13 (n40 VSS) capacitor c=6.96351e-17
C14 (CKNbb VSS) capacitor c=3.70705e-17
C15 (mout VSS) capacitor c=5.73141e-17
C16 (CKNb VSS) capacitor c=7.6384e-17
C17 (n25 VSS) capacitor c=1.01605e-16
C18 (n20 VSS) capacitor c=4.47875e-17
C19 (n30 VSS) capacitor c=2.36337e-18
C20 (n21 VSS) capacitor c=1.26516e-20
C21 (n41 VSS) capacitor c=8.81546e-17
C22 (n43 VSS) capacitor c=9.19802e-19
C23 (n26 VSS) capacitor c=4.56963e-18
C24 (n31 VSS) capacitor c=1.09643e-18
C25 (n22 VSS) capacitor c=2.59562e-18
C26 (\1\:CKN VSS) capacitor c=2.86123e-17
C27 (\7\:CKNb VSS) capacitor c=6.36738e-17
C28 (\3\:D VSS) capacitor c=6.04575e-17
C29 (\4\:CKNb VSS) capacitor c=7.84979e-17
C30 (\7\:CKNbb VSS) capacitor c=4.85804e-17
C31 (\4\:SN VSS) capacitor c=5.54097e-17
C32 (\4\:RNb VSS) capacitor c=5.65225e-17
C33 (\3\:CKNbb VSS) capacitor c=3.64962e-17
C34 (\2\:RNb VSS) capacitor c=6.94632e-17
C35 (\8\:qbint VSS) capacitor c=7.71487e-17
C36 (\1\:SN VSS) capacitor c=3.68297e-17
C37 (\1\:RN VSS) capacitor c=4.65793e-17
C38 (\7\:qbint VSS) capacitor c=3.37686e-17
C39 (\3\:CKN VSS) capacitor c=2.40292e-17
C40 (\8\:CKNb VSS) capacitor c=4.55466e-17
C41 (\1\:D VSS) capacitor c=4.4871e-17
C42 (\8\:CKNbb VSS) capacitor c=5.6864e-17
C43 (\5\:CKNb VSS) capacitor c=6.55901e-17
C44 (\4\:mout VSS) capacitor c=4.74131e-17
C45 (\6\:SN VSS) capacitor c=6.45235e-17
C46 (\3\:n20 VSS) capacitor c=3.29172e-17
C47 (\5\:RNb VSS) capacitor c=4.83039e-17
C48 (\2\:CKNb VSS) capacitor c=7.46597e-17
C49 (\9\:qbint VSS) capacitor c=5.04638e-17
C50 (\3\:SN VSS) capacitor c=4.41521e-17
C51 (\3\:n35 VSS) capacitor c=3.82014e-17
C52 (\3\:RN VSS) capacitor c=5.01044e-17
C53 (\6\:qbint VSS) capacitor c=3.62744e-17
C54 (\4\:qbint VSS) capacitor c=2.54035e-17
C55 (\3\:qint VSS) capacitor c=3.73312e-17
C56 (\2\:CKN VSS) capacitor c=2.07436e-17
C57 (\9\:CKNb VSS) capacitor c=1.86016e-17
C58 (\2\:D VSS) capacitor c=6.49778e-17
C59 (\9\:CKNbb VSS) capacitor c=5.36174e-17
C60 (\6\:CKNb VSS) capacitor c=2.20703e-17
C61 (\6\:CKNbb VSS) capacitor c=5.1891e-17
C62 (\3\:mout VSS) capacitor c=2.06599e-17
C63 (\5\:SN VSS) capacitor c=2.89651e-17
C64 (\2\:n20 VSS) capacitor c=3.93026e-17
C65 (\6\:RNb VSS) capacitor c=2.68447e-17
C66 (\5\:CKNbb VSS) capacitor c=3.68641e-17
C67 (\3\:CKNb VSS) capacitor c=2.58548e-17
C68 (\4\:CKNbb VSS) capacitor c=3.64561e-17
C69 (\2\:CKNbb VSS) capacitor c=2.79e-17
C70 (\3\:RNb VSS) capacitor c=2.81498e-17
C71 (\10\:qbint VSS) capacitor c=2.44619e-17
C72 (\2\:SN VSS) capacitor c=3.36773e-17
C73 (\2\:n35 VSS) capacitor c=2.87359e-17
C74 (\2\:RN VSS) capacitor c=4.32981e-17
C75 (\5\:qbint VSS) capacitor c=3.92281e-17
C76 (\2\:qint VSS) capacitor c=2.64055e-17
C77 (\1\:VDD VSS) capacitor c=3.78214e-17
C78 (\10\:CKNb VSS) capacitor c=1.1221e-16
C79 (\12\:CKNbb VSS) capacitor c=2.01052e-17
C80 (\14\:VDD VSS) capacitor c=4.73406e-17
C81 (\8\:n20 VSS) capacitor c=7.36337e-17
C82 (\16\:VDD VSS) capacitor c=1.22765e-17
C83 (\11\:mout VSS) capacitor c=4.33913e-17
C84 (\18\:VDD VSS) capacitor c=3.10725e-17
C85 (\9\:mout VSS) capacitor c=7.4448e-17
C86 (\4\:n35 VSS) capacitor c=4.04372e-17
C87 (\20\:VDD VSS) capacitor c=2.91996e-17
C88 (\3\:n41 VSS) capacitor c=9.59159e-17
C89 (\22\:VDD VSS) capacitor c=1.5608e-17
C90 (\11\:qbint VSS) capacitor c=7.04702e-17
C91 (\9\:RNb VSS) capacitor c=1.30682e-16
C92 (\24\:VDD VSS) capacitor c=3.91137e-17
C93 (\3\:Q VSS) capacitor c=3.96148e-17
C94 (\4\:qint VSS) capacitor c=3.77758e-17
C95 (\26\:VDD VSS) capacitor c=6.20029e-17
C96 (\1\:QN VSS) capacitor c=6.98021e-17
C97 (\3\:VDD VSS) capacitor c=5.24404e-17
C98 (\12\:CKNb VSS) capacitor c=1.18652e-16
C99 (\17\:CKNbb VSS) capacitor c=7.34029e-17
C100 (\4\:n20 VSS) capacitor c=4.33334e-17
C101 (\13\:mout VSS) capacitor c=3.88754e-17
C102 (\3\:n25 VSS) capacitor c=9.0551e-17
C103 (\15\:mout VSS) capacitor c=4.23582e-17
C104 (\8\:n35 VSS) capacitor c=6.34182e-17
C105 (\3\:n40 VSS) capacitor c=8.50744e-17
C106 (\3\:n42 VSS) capacitor c=9.55e-17
C107 (\13\:qbint VSS) capacitor c=5.83639e-17
C108 (\11\:RNb VSS) capacitor c=1.02454e-16
C109 (\1\:Q VSS) capacitor c=8.21704e-17
C110 (\8\:qint VSS) capacitor c=4.18492e-17
C111 (\3\:qbint VSS) capacitor c=2.98071e-17
C112 (\2\:mout VSS) capacitor c=3.34135e-17
C113 (\6\:qint VSS) capacitor c=3.35634e-17
C114 (\7\:qint VSS) capacitor c=3.82394e-17
C115 (\4\:RN VSS) capacitor c=7.39411e-17
C116 (\15\:qbint VSS) capacitor c=1.15914e-16
C117 (\16\:qbint VSS) capacitor c=1.29522e-16
C118 (\17\:qbint VSS) capacitor c=8.23543e-17
C119 (\6\:n35 VSS) capacitor c=1.68817e-16
C120 (\7\:n35 VSS) capacitor c=1.85724e-16
C121 (\10\:CKNbb VSS) capacitor c=7.21042e-17
C122 (\11\:CKNbb VSS) capacitor c=1.25044e-16
C123 (\7\:RNb VSS) capacitor c=1.58533e-16
C124 (\8\:RNb VSS) capacitor c=2.08842e-16
C125 (\7\:SN VSS) capacitor c=2.90016e-16
C126 (\8\:SN VSS) capacitor c=3.89425e-17
C127 (\5\:mout VSS) capacitor c=4.4258e-17
C128 (\6\:mout VSS) capacitor c=5.00409e-17
C129 (\7\:mout VSS) capacitor c=5.5912e-17
C130 (\8\:mout VSS) capacitor c=6.98796e-17
C131 (\6\:n20 VSS) capacitor c=9.59323e-17
C132 (\7\:n20 VSS) capacitor c=7.06673e-17
C133 (\14\:CKNbb VSS) capacitor c=6.57435e-17
C134 (\15\:CKNbb VSS) capacitor c=1.46828e-16
C135 (\16\:CKNbb VSS) capacitor c=2.53577e-16
C136 (\19\:CKNbb VSS) capacitor c=3.08784e-17
C137 (\20\:CKNbb VSS) capacitor c=3.91699e-17
C138 (\14\:CKNb VSS) capacitor c=7.53557e-17
C139 (\15\:CKNb VSS) capacitor c=1.41752e-16
C140 (\16\:CKNb VSS) capacitor c=1.34193e-16
C141 (\5\:VDD VSS) capacitor c=2.85016e-17
C142 (\6\:VDD VSS) capacitor c=1.93013e-17
C143 (\8\:VDD VSS) capacitor c=3.58515e-17
C144 (\9\:VDD VSS) capacitor c=3.30826e-17
C145 (\10\:VDD VSS) capacitor c=1.83091e-17
C146 (\12\:VDD VSS) capacitor c=1.90476e-17
C147 (\13\:VDD VSS) capacitor c=1.04661e-17
Rk8 (RN \4\:RN) resistor r=0.03453 c=0
Rk1 (\2\:QN QN) resistor r=0.3779 c=0
Rk2 (QN \4\:QN) resistor r=0.002835 c=0
Rk36 (D \4\:D) resistor r=0.007525 c=0
Rk6 (Q \2\:Q) resistor r=0.4289 c=0
Rk7 (Q \4\:Q) resistor r=0.07434 c=0
Rk48 (\2\:VDD \4\:VDD) resistor r=0.3974 c=0
Rk49 (\4\:VDD \5\:VDD) resistor r=0.281 c=0
Rk50 (\5\:VDD \6\:VDD) resistor r=0.3963 c=0
Rk51 (\6\:VDD \7\:VDD) resistor r=0.07513 c=0
Rk52 (\7\:VDD \8\:VDD) resistor r=0.2775 c=0
Rk53 (\8\:VDD \9\:VDD) resistor r=0.4355 c=0
Rk54 (\9\:VDD \10\:VDD) resistor r=0.2924 c=0
Rk55 (\10\:VDD \11\:VDD) resistor r=0.1947 c=0
Rk56 (\11\:VDD \12\:VDD) resistor r=0.1429 c=0
Rk58 (\13\:VDD VDD) resistor r=0.1025 c=0
Rk57 (\12\:VDD \13\:VDD) resistor r=0.3059 c=0
Rk59 (\5\:VDD \15\:VDD) resistor r=0.2878 c=0
Rk60 (\6\:VDD \17\:VDD) resistor r=0.07476 c=0
Rk61 (\8\:VDD \19\:VDD) resistor r=0.04338 c=0
Rk62 (\9\:VDD \21\:VDD) resistor r=0.1036 c=0
Rk63 (\10\:VDD \23\:VDD) resistor r=0.04338 c=0
Rk64 (\12\:VDD \25\:VDD) resistor r=0.2746 c=0
Rk65 (\13\:VDD \27\:VDD) resistor r=0.44 c=0
Rk24 (\7\:SN SN) resistor r=1.9301 c=0
Rk25 (SN \8\:SN) resistor r=0.04356 c=0
Rk66 (\2\:VSS \4\:VSS) resistor r=0.4075 c=0
Rk67 (\4\:VSS \5\:VSS) resistor r=0.281 c=0
Rk68 (\5\:VSS \6\:VSS) resistor r=0.3954 c=0
Rk69 (\6\:VSS \7\:VSS) resistor r=0.07418 c=0
Rk70 (\7\:VSS \8\:VSS) resistor r=1.0082 c=0
Rk71 (\8\:VSS \9\:VSS) resistor r=0.1947 c=0
Rk72 (\9\:VSS \10\:VSS) resistor r=0.1429 c=0
Rk74 (\11\:VSS VSS) resistor r=0.1025 c=0
Rk73 (\10\:VSS \11\:VSS) resistor r=0.3059 c=0
Rk75 (\5\:VSS \13\:VSS) resistor r=0.07476 c=0
Rk76 (\6\:VSS \15\:VSS) resistor r=0.04338 c=0
Rk77 (\8\:VSS \17\:VSS) resistor r=0.04338 c=0
Rk78 (\10\:VSS \19\:VSS) resistor r=0.3419 c=0
Rk79 (\11\:VSS \21\:VSS) resistor r=0.3844 c=0
Rk3 (\5\:qint \6\:qint) resistor r=0.1153 c=0
Rk4 (\6\:qint \7\:qint) resistor r=0.1291 c=0
Rk5 (\6\:qint \9\:qint) resistor r=0.1093 c=0
Rk9 (\12\:qbint \14\:qbint) resistor r=0.3691 c=0
Rk10 (\14\:qbint \15\:qbint) resistor r=0.1151 c=0
Rk11 (\15\:qbint \16\:qbint) resistor r=0.7243 c=0
Rk12 (\15\:qbint \17\:qbint) resistor r=0.3637 c=0
Rk20 (\7\:RNb \8\:RNb) resistor r=0.9657 c=0
Rk21 (\8\:RNb \10\:RNb) resistor r=0.7251 c=0
Rk22 (\10\:RNb \12\:RNb) resistor r=0.5107 c=0
Rk16 (\5\:n35 \6\:n35) resistor r=0.1257 c=0
Rk17 (\6\:n35 \7\:n35) resistor r=1.1889 c=0
Rk18 (\6\:n35 \9\:n35) resistor r=0.2867 c=0
Rk13 (\2\:n42 \4\:n42) resistor r=0.4286 c=0
Rk14 (\2\:n40 \4\:n40) resistor r=0.5071 c=0
Rk19 (\10\:CKNbb \11\:CKNbb) resistor r=0.5711 c=0
Rk37 (\13\:CKNbb \14\:CKNbb) resistor r=0.07809 c=0
Rk38 (\14\:CKNbb \15\:CKNbb) resistor r=0.254 c=0
Rk39 (\15\:CKNbb \16\:CKNbb) resistor r=1.4769 c=0
Rk40 (\14\:CKNbb \18\:CKNbb) resistor r=0.3983 c=0
Rk41 (\15\:CKNbb \19\:CKNbb) resistor r=0.1667 c=0
Rk42 (\19\:CKNbb \20\:CKNbb) resistor r=0.1701 c=0
Rk26 (\5\:mout \6\:mout) resistor r=0.2543 c=0
Rk27 (\6\:mout \7\:mout) resistor r=0.2923 c=0
Rk28 (\7\:mout \8\:mout) resistor r=0.2401 c=0
Rk29 (\8\:mout \10\:mout) resistor r=0.2616 c=0
Rk30 (\6\:mout \12\:mout) resistor r=0.0876 c=0
Rk31 (\7\:mout \14\:mout) resistor r=0.1206 c=0
Rk32 (\8\:mout \16\:mout) resistor r=0.133 c=0
Rk43 (\11\:CKNb \13\:CKNb) resistor r=0.5735 c=0
Rk44 (\13\:CKNb \14\:CKNb) resistor r=0.3472 c=0
Rk45 (\14\:CKNb \15\:CKNb) resistor r=0.3974 c=0
Rk46 (\15\:CKNb \16\:CKNb) resistor r=0.9578 c=0
Rk23 (\2\:n25 \4\:n25) resistor r=0.5661 c=0
Rk33 (\5\:n20 \6\:n20) resistor r=0.2999 c=0
Rk34 (\6\:n20 \7\:n20) resistor r=0.3682 c=0
Rk35 (\6\:n20 \9\:n20) resistor r=0.4464 c=0
Rk15 (\2\:n41 \4\:n41) resistor r=0.502 c=0
Rl9 (\1\:RN \2\:RN) resistor r=96.8456 c=0
Rl10 (\2\:RN \3\:RN) resistor r=98.7687 c=0
Rl41 (\1\:CKN \2\:CKN) resistor r=87.2302 c=0
Rl42 (\2\:CKN \3\:CKN) resistor r=39.1533 c=0
Rl38 (\2\:D \3\:D) resistor r=125.722 c=0
Rl37 (\1\:D \2\:D) resistor r=43.7849 c=0
Rl29 (\4\:SN \6\:SN) resistor r=140.385 c=0
Rl28 (\4\:SN \5\:SN) resistor r=73.7687 c=0
Rl13 (\1\:SN \2\:SN) resistor r=29.5379 c=0
Rl14 (\2\:SN \3\:SN) resistor r=69.9225 c=0
Rl1 (qint \2\:qint) resistor r=37.6944 c=0
Rl2 (\2\:qint \3\:qint) resistor r=26.1559 c=0
Rl15 (\8\:qbint \9\:qbint) resistor r=125.584 c=0
Rl16 (\9\:qbint \10\:qbint) resistor r=56.9251 c=0
Rl7 (\5\:qbint \6\:qbint) resistor r=24.848 c=0
Rl3 (qbint \2\:qbint) resistor r=81.4873 c=0
Rl6 (\2\:qbint \5\:qbint) resistor r=11.259 c=0
Rl8 (\3\:qbint \7\:qbint) resistor r=60.772 c=0
Rl5 (\3\:qbint \4\:qbint) resistor r=28.0797 c=0
Rl4 (\2\:qbint \3\:qbint) resistor r=133.209 c=0
Rl24 (\4\:RNb \5\:RNb) resistor r=140.385 c=0
Rl17 (RNb \2\:RNb) resistor r=132.258 c=0
Rl25 (\4\:RNb \6\:RNb) resistor r=72.3097 c=0
Rl18 (\2\:RNb \3\:RNb) resistor r=94.48 c=0
Rl11 (n35 \2\:n35) resistor r=39.1533 c=0
Rl12 (\2\:n35 \3\:n35) resistor r=71.8456 c=0
Rl36 (\8\:CKNbb \9\:CKNbb) resistor r=79.5379 c=0
Rl33 (\6\:CKNbb \7\:CKNbb) resistor r=61.4557 c=0
Rl22 (\3\:CKNbb \4\:CKNbb) resistor r=24.2328 c=0
Rl23 (\4\:CKNbb \5\:CKNbb) resistor r=67.7945 c=0
Rl19 (CKNbb \2\:CKNbb) resistor r=24.2328 c=0
Rl30 (mout \2\:mout) resistor r=78.5603 c=0
Rl32 (\2\:mout \4\:mout) resistor r=97.7911 c=0
Rl31 (\2\:mout \3\:mout) resistor r=4.3144 c=0
Rl39 (\7\:CKNb \8\:CKNb) resistor r=187.381 c=0
Rl34 (\4\:CKNb \5\:CKNb) resistor r=202.895 c=0
Rl20 (CKNb \2\:CKNb) resistor r=170.285 c=0
Rl40 (\8\:CKNb \9\:CKNb) resistor r=46.8456 c=0
Rl35 (\5\:CKNb \6\:CKNb) resistor r=46.8456 c=0
Rl21 (\2\:CKNb \3\:CKNb) resistor r=126.436 c=0
Rl26 (n20 \2\:n20) resistor r=85.7713 c=0
Rl27 (\2\:n20 \3\:n20) resistor r=26.1559 c=0
Rz1 (\3\:QN \4\:QN) resistor r=75 c=0
Rz3 (\1\:Q \2\:Q) resistor r=75 c=0
Rz18 (\3\:VDD \4\:VDD) resistor r=25 c=0
Rz19 (\3\:VDD \7\:VDD) resistor r=6.25 c=0
Rz20 (\3\:VDD \11\:VDD) resistor r=6.25 c=0
Rz21 (\1\:VSS \2\:VSS) resistor r=75 c=0
Rz22 (\12\:VSS \13\:VSS) resistor r=75 c=0
Rz23 (\14\:VSS \15\:VSS) resistor r=75 c=0
Rz24 (\16\:VSS \17\:VSS) resistor r=75 c=0
Rz25 (\18\:VSS \19\:VSS) resistor r=75 c=0
Rz26 (\20\:VSS \21\:VSS) resistor r=75 c=0
Rz2 (\8\:qint \9\:qint) resistor r=75 c=0
Rz4 (\13\:qbint \14\:qbint) resistor r=75 c=0
Rz10 (\11\:RNb \12\:RNb) resistor r=75 c=0
Rz9 (\8\:n35 \9\:n35) resistor r=75 c=0
Rz5 (n42 \2\:n42) resistor r=75 c=0
Rz6 (\3\:n42 \4\:n42) resistor r=75 c=0
Rz7 (n40 \2\:n40) resistor r=75 c=0
Rz8 (\3\:n40 \4\:n40) resistor r=75 c=0
Rz16 (\17\:CKNbb \18\:CKNbb) resistor r=75 c=0
Rz13 (\13\:mout \14\:mout) resistor r=75 c=0
Rz14 (\15\:mout \16\:mout) resistor r=75 c=0
Rz17 (\12\:CKNb \13\:CKNb) resistor r=75 c=0
Rz11 (n25 \2\:n25) resistor r=75 c=0
Rz12 (\3\:n25 \4\:n25) resistor r=75 c=0
Rz15 (\4\:n20 \5\:n20) resistor r=75 c=0
Ry1 (\1\:QN \2\:QN) resistor r=20.6667 c=0
Ry3 (\3\:Q \4\:Q) resistor r=20.6667 c=0
Ry14 (\1\:VDD \2\:VDD) resistor r=62 c=0
Ry15 (\14\:VDD \15\:VDD) resistor r=62 c=0
Ry16 (\16\:VDD \17\:VDD) resistor r=62 c=0
Ry17 (\18\:VDD \19\:VDD) resistor r=62 c=0
Ry18 (\20\:VDD \21\:VDD) resistor r=62 c=0
Ry19 (\22\:VDD \23\:VDD) resistor r=62 c=0
Ry20 (\24\:VDD \25\:VDD) resistor r=62 c=0
Ry21 (\26\:VDD \27\:VDD) resistor r=62 c=0
Ry22 (\3\:VSS \4\:VSS) resistor r=20.6667 c=0
Ry23 (\3\:VSS \7\:VSS) resistor r=5.1667 c=0
Ry24 (\3\:VSS \9\:VSS) resistor r=5.1667 c=0
Ry2 (\4\:qint \5\:qint) resistor r=62 c=0
Ry4 (\11\:qbint \12\:qbint) resistor r=62 c=0
Ry8 (\9\:RNb \10\:RNb) resistor r=62 c=0
Ry7 (\4\:n35 \5\:n35) resistor r=62 c=0
Ry12 (\12\:CKNbb \13\:CKNbb) resistor r=62 c=0
Ry9 (\9\:mout \10\:mout) resistor r=62 c=0
Ry10 (\11\:mout \12\:mout) resistor r=62 c=0
Ry13 (\10\:CKNb \11\:CKNb) resistor r=62 c=0
Ry11 (\8\:n20 \9\:n20) resistor r=62 c=0
Ry5 (n41 \2\:n41) resistor r=62 c=0
Ry6 (\3\:n41 \4\:n41) resistor r=62 c=0
Rx2 (\2\:RN \4\:RN) resistor r=45 c=0
Rx21 (\2\:CKN CKN) resistor r=45 c=0
Rx14 (\2\:D \4\:D) resistor r=45 c=0
Rx10 (\5\:SN \7\:SN) resistor r=45 c=0
Rx11 (\2\:SN \8\:SN) resistor r=45 c=0
Rx1 (\2\:qint \7\:qint) resistor r=45 c=0
Rx3 (\5\:qbint \16\:qbint) resistor r=45 c=0
Rx4 (\10\:qbint \17\:qbint) resistor r=45 c=0
Rx8 (\6\:RNb \7\:RNb) resistor r=45 c=0
Rx9 (\3\:RNb \8\:RNb) resistor r=45 c=0
Rx5 (\2\:n35 \7\:n35) resistor r=45 c=0
Rx6 (\2\:CKNbb \10\:CKNbb) resistor r=45 c=0
Rx7 (\4\:CKNbb \11\:CKNbb) resistor r=45 c=0
Rx15 (\5\:CKNbb \16\:CKNbb) resistor r=45 c=0
Rx16 (\9\:CKNbb \19\:CKNbb) resistor r=45 c=0
Rx17 (\6\:CKNbb \20\:CKNbb) resistor r=45 c=0
Rx12 (\3\:mout \5\:mout) resistor r=45 c=0
Rx18 (\9\:CKNb \14\:CKNb) resistor r=45 c=0
Rx19 (\6\:CKNb \15\:CKNb) resistor r=45 c=0
Rx20 (\3\:CKNb \16\:CKNb) resistor r=45 c=0
Rx13 (\2\:n20 \7\:n20) resistor r=45 c=0
mn57 (\3\:QN \3\:qint \20\:VSS VSS) g45n1lvt w=(2.6e-07) l=4.5e-08 nf=1 \
        as=3.47e-14 ad=3.64e-14 ps=8.4e-07 pd=8e-07 nrd=1.16667 \
        nrs=1.16667 sa=1.4e-07 sb=2.36635e-07 sd=160n sca=17.5885 \
        scb=0.0172826 scc=0.00162584 m=(1)
mn55 (\1\:Q \6\:qbint \18\:VSS VSS) g45n1lvt w=(2.6e-07) l=4.5e-08 nf=1 \
        as=3.47e-14 ad=3.64e-14 ps=8.4e-07 pd=8e-07 nrd=1.16667 \
        nrs=1.16667 sa=1.4e-07 sb=2.56154e-07 sd=160n sca=9.89531 \
        scb=0.00874901 scc=0.000299334 m=(1)
mn56 (\8\:qint \4\:qbint \20\:VSS VSS) g45n1lvt w=(1.45e-07) l=4.5e-08 \
        nf=1 as=3.47e-14 ad=2.03e-14 ps=8.4e-07 pd=5.7e-07 nrd=1.16667 \
        nrs=1.16667 sa=3.45e-07 sb=1.4e-07 sd=160n sca=23.279 \
        scb=0.0230742 scc=0.00267719 m=(1)
mn22 (\11\:RNb \3\:RN \18\:VSS VSS) g45n1lvt w=(1.45e-07) l=4.5e-08 nf=1 \
        as=3.47e-14 ad=2.537e-14 ps=8.4e-07 pd=6.4e-07 nrd=1.16667 \
        nrs=1.16667 sa=3.45e-07 sb=1.75e-07 sd=160n sca=11.9911 \
        scb=0.0120555 scc=0.000498628 m=(1)
mn45 (\13\:qbint \3\:n35 \16\:VSS VSS) g45n1lvt w=(1.45e-07) l=4.5e-08 \
        nf=1 as=7.39e-14 ad=2.03e-14 ps=1.43e-06 pd=5.7e-07 nrd=1.16667 \
        nrs=1.16667 sa=1.4e-07 sb=8.2e-07 sd=160n sca=13.253 scb=0.0137915 \
        scc=0.000695334 m=(1)
mn50 (\3\:n42 \3\:SN \16\:VSS VSS) g45n1lvt w=(1.45e-07) l=4.5e-08 nf=1 \
        as=7.39e-14 ad=2.392e-14 ps=1.43e-06 pd=6.2e-07 nrd=1.16667 \
        nrs=1.16667 sa=4.05e-07 sb=5.55e-07 sd=160n sca=13.253 \
        scb=0.0137915 scc=0.000695334 m=(1)
mn52 (\3\:n40 \9\:qbint \3\:n42 VSS) g45n1lvt w=(1.45e-07) l=4.5e-08 nf=1 \
        as=2.392e-14 ad=2.32e-14 ps=6.2e-07 pd=6.1e-07 nrd=1.16667 \
        nrs=1.16667 sa=6.15e-07 sb=3.45e-07 sd=160n sca=13.253 \
        scb=0.0137915 scc=0.000695334 m=(1)
mn51 (\3\:n40 RNb n42 VSS) g45n1lvt w=(1.45e-07) l=4.5e-08 nf=1 \
        as=2.03e-14 ad=2.32e-14 ps=5.7e-07 pd=6.1e-07 nrd=1.16667 \
        nrs=1.16667 sa=8.2e-07 sb=1.4e-07 sd=160n sca=13.253 scb=0.0137915 \
        scc=0.000695334 m=(1)
mn53 (n40 CKNbb \8\:n35 VSS) g45n1lvt w=(1.45e-07) l=4.5e-08 nf=1 \
        as=2.32e-14 ad=2.03e-14 ps=6.1e-07 pd=5.7e-07 nrd=1.16667 \
        nrs=1.16667 sa=1.4e-07 sb=3.8e-07 sd=160n sca=16.2011 \
        scb=0.0172667 scc=0.0012292 m=(1)
mn40 (\8\:n35 \2\:CKNb \15\:mout VSS) g45n1lvt w=(1.45e-07) l=4.5e-08 \
        nf=1 as=2.537e-14 ad=2.32e-14 ps=6.4e-07 pd=6.1e-07 nrd=1.16667 \
        nrs=1.16667 sa=3.45e-07 sb=1.75e-07 sd=160n sca=16.2011 \
        scb=0.0172667 scc=0.0012292 m=(1)
mn31 (\3\:n25 \5\:RNb \13\:mout VSS) g45n1lvt w=(1.45e-07) l=4.5e-08 nf=1 \
        as=2.61e-14 ad=2.03e-14 ps=6.5e-07 pd=5.7e-07 nrd=1.16667 \
        nrs=1.16667 sa=1.4e-07 sb=1.625e-06 sd=160n sca=18.4982 \
        scb=0.0194884 scc=0.00168796 m=(1)
mn32 (\13\:mout \3\:n20 n25 VSS) g45n1lvt w=(1.45e-07) l=4.5e-08 nf=1 \
        as=2.32e-14 ad=2.61e-14 ps=6.1e-07 pd=6.5e-07 nrd=1.16667 \
        nrs=1.16667 sa=3.65e-07 sb=1.4e-06 sd=160n sca=18.4982 \
        scb=0.0194884 scc=0.00168796 m=(1)
mn30 (n25 \6\:SN \14\:VSS VSS) g45n1lvt w=(1.45e-07) l=4.5e-08 nf=1 \
        as=8.05e-14 ad=2.32e-14 ps=1.54e-06 pd=6.1e-07 nrd=1.16667 \
        nrs=1.16667 sa=5.7e-07 sb=1.195e-06 sd=160n sca=18.4982 \
        scb=0.0194884 scc=0.00168796 m=(1)
mn35 (n30 \4\:mout \14\:VSS VSS) g45n1lvt w=(1.45e-07) l=4.5e-08 nf=1 \
        as=8.05e-14 ad=2.61e-14 ps=1.54e-06 pd=6.5e-07 nrd=1.16667 \
        nrs=1.16667 sa=8.35e-07 sb=9.3e-07 sd=160n sca=18.4982 \
        scb=0.0194884 scc=0.00168796 m=(1)
mn36 (\4\:n20 \5\:CKNb n30 VSS) g45n1lvt w=(1.45e-07) l=4.5e-08 nf=1 \
        as=2.61e-14 ad=2.32e-14 ps=6.5e-07 pd=6.1e-07 nrd=1.16667 \
        nrs=1.16667 sa=1.06e-06 sb=7.05e-07 sd=160n sca=18.4982 \
        scb=0.0194884 scc=0.00168796 m=(1)
mn26 (\4\:n20 \8\:CKNbb n21 VSS) g45n1lvt w=(1.45e-07) l=4.5e-08 nf=1 \
        as=1.305e-14 ad=2.32e-14 ps=4.7e-07 pd=6.1e-07 nrd=1.16667 \
        nrs=1.16667 sa=1.265e-06 sb=5e-07 sd=160n sca=18.4982 \
        scb=0.0194884 scc=0.00168796 m=(1)
mn25 (n21 \1\:D \12\:VSS VSS) g45n1lvt w=(1.45e-07) l=4.5e-08 nf=1 \
        as=6.33e-14 ad=1.305e-14 ps=1.54e-06 pd=4.7e-07 nrd=1.16667 \
        nrs=1.16667 sa=1.4e-06 sb=3.65e-07 sd=160n sca=18.4982 \
        scb=0.0194884 scc=0.00168796 m=(1)
mn21 (\17\:CKNbb \8\:CKNb \12\:VSS VSS) g45n1lvt w=(1.45e-07) l=4.5e-08 \
        nf=1 as=6.33e-14 ad=2.03e-14 ps=1.54e-06 pd=5.7e-07 nrd=1.16667 \
        nrs=1.16667 sa=1.625e-06 sb=1.4e-07 sd=160n sca=18.4982 \
        scb=0.0194884 scc=0.00168796 m=(1)
mn20 (\12\:CKNb \3\:CKN \1\:VSS VSS) g45n1lvt w=(1.45e-07) l=4.5e-08 \
        nf=1 as=2.03e-14 ad=2.03e-14 ps=5.7e-07 pd=5.7e-07 nrd=1.16667 \
        nrs=1.16667 sa=1.4e-07 sb=1.4e-07 sd=160n sca=18.4982 \
        scb=0.0194884 scc=0.00168796 m=(1)
mp56 (\4\:qint \7\:qbint \26\:VDD VDD) g45p1lvt w=(2.15e-07) l=4.5e-08 \
        nf=1 as=5.19e-14 ad=3.01e-14 ps=1.1e-06 pd=7.1e-07 nrd=1.16667 \
        nrs=1.16667 sa=3.45e-07 sb=1.4e-07 sd=160n sca=49.4198 \
        scb=0.0326741 scc=0.00592591 m=(1)
mp22 (\9\:RNb \1\:RN \24\:VDD VDD) g45p1lvt w=(2.15e-07) l=4.5e-08 nf=1 \
        as=5.19e-14 ad=3.762e-14 ps=1.1e-06 pd=7.8e-07 nrd=1.16667 \
        nrs=1.16667 sa=3.45e-07 sb=1.75e-07 sd=160n sca=11.0038 \
        scb=0.00893072 scc=0.000173706 m=(1)
mp45 (\11\:qbint n35 \22\:VDD VDD) g45p1lvt w=(2.15e-07) l=4.5e-08 nf=1 \
        as=1.07e-13 ad=3.01e-14 ps=1.9e-06 pd=7.1e-07 nrd=1.16667 \
        nrs=1.16667 sa=1.4e-07 sb=6.99186e-07 sd=160n sca=31.508 \
        scb=0.0252524 scc=0.00399199 m=(1)
mp50 (\3\:n41 \1\:SN \22\:VDD VDD) g45p1lvt w=(2.15e-07) l=4.5e-08 nf=1 \
        as=1.07e-13 ad=4.3e-14 ps=1.9e-06 pd=8.3e-07 nrd=1.16667 \
        nrs=1.16667 sa=3.62442e-07 sb=5.2e-07 sd=160n sca=45.7906 \
        scb=0.0283307 scc=0.00588417 m=(1)
mp52 (\3\:n41 \8\:qbint n43 VDD) g45p1lvt w=(2.15e-07) l=4.5e-08 nf=1 \
        as=1.29e-14 ad=4.3e-14 ps=5.5e-07 pd=8.3e-07 nrd=1.16667 \
        nrs=1.16667 sa=6.07442e-07 sb=2.75e-07 sd=160n sca=45.7906 \
        scb=0.0283307 scc=0.00588417 m=(1)
mp51 (n43 \2\:RNb \20\:VDD VDD) g45p1lvt w=(2.15e-07) l=4.5e-08 nf=1 \
        as=9.835e-14 ad=1.29e-14 ps=1.8e-06 pd=5.5e-07 nrd=1.16667 \
        nrs=1.16667 sa=7.12442e-07 sb=1.7e-07 sd=160n sca=45.7906 \
        scb=0.0283307 scc=0.00588417 m=(1)
mp53 (n41 CKNb \4\:n35 VDD) g45p1lvt w=(2.15e-07) l=4.5e-08 nf=1 \
        as=3.548e-14 ad=3.01e-14 ps=7.6e-07 pd=7.1e-07 nrd=1.16667 \
        nrs=1.16667 sa=1.4e-07 sb=3.5e-07 sd=160n sca=28.4541 \
        scb=0.0241553 scc=0.00347654 m=(1)
mp40 (\4\:n35 \3\:CKNbb \9\:mout VDD) g45p1lvt w=(2.15e-07) l=4.5e-08 \
        nf=1 as=3.01e-14 ad=3.548e-14 ps=7.1e-07 pd=7.6e-07 nrd=1.16667 \
        nrs=1.16667 sa=3.5e-07 sb=1.4e-07 sd=160n sca=28.4541 \
        scb=0.0241553 scc=0.00347654 m=(1)
mp31 (n26 \4\:RNb \18\:VDD VDD) g45p1lvt w=(2.15e-07) l=4.5e-08 nf=1 \
        as=6.078e-14 ad=3.87e-14 ps=1.63e-06 pd=7.9e-07 nrd=1.16667 \
        nrs=1.16667 sa=1.25e-07 sb=1.02535e-06 sd=160n sca=18.4975 \
        scb=0.0182651 scc=0.0015388 m=(1)
mp32 (\11\:mout n20 n26 VDD) g45p1lvt w=(2.15e-07) l=4.5e-08 nf=1 \
        as=3.87e-14 ad=3.44e-14 ps=7.9e-07 pd=7.5e-07 nrd=1.16667 \
        nrs=1.16667 sa=3.5e-07 sb=8.00349e-07 sd=160n sca=18.4975 \
        scb=0.0182651 scc=0.0015388 m=(1)
mp30 (\11\:mout \4\:SN \16\:VDD VDD) g45p1lvt w=(2.15e-07) l=4.5e-08 \
        nf=1 as=8.965e-14 ad=3.44e-14 ps=1.71e-06 pd=7.5e-07 nrd=1.16667 \
        nrs=1.16667 sa=5.55e-07 sb=5.95349e-07 sd=160n sca=18.4975 \
        scb=0.0182651 scc=0.0015388 m=(1)
mp35 (n31 mout \16\:VDD VDD) g45p1lvt w=(2.15e-07) l=4.5e-08 nf=1 \
        as=8.965e-14 ad=1.827e-14 ps=1.71e-06 pd=6e-07 nrd=1.16667 \
        nrs=1.16667 sa=4.72326e-07 sb=9e-07 sd=160n sca=11.4924 \
        scb=0.00977085 scc=0.000239291 m=(1)
mp36 (\8\:n20 \7\:CKNbb n31 VDD) g45p1lvt w=(2.15e-07) l=4.5e-08 nf=1 \
        as=1.827e-14 ad=3.44e-14 ps=6e-07 pd=7.5e-07 nrd=1.16667 \
        nrs=1.16667 sa=6.02326e-07 sb=7.7e-07 sd=160n sca=11.4924 \
        scb=0.00977085 scc=0.000239291 m=(1)
mp26 (\8\:n20 \4\:CKNb n22 VDD) g45p1lvt w=(2.15e-07) l=4.5e-08 nf=1 \
        as=3.762e-14 ad=3.44e-14 ps=7.8e-07 pd=7.5e-07 nrd=1.16667 \
        nrs=1.16667 sa=8.07326e-07 sb=5.65e-07 sd=160n sca=11.4924 \
        scb=0.00977085 scc=0.000239291 m=(1)
mp25 (n22 \3\:D \14\:VDD VDD) g45p1lvt w=(2.15e-07) l=4.5e-08 nf=1 \
        as=3.44e-14 ad=3.762e-14 ps=7.5e-07 pd=7.8e-07 nrd=1.16667 \
        nrs=1.16667 sa=1.02733e-06 sb=3.45e-07 sd=160n sca=11.4924 \
        scb=0.00977085 scc=0.000239291 m=(1)
mp21 (\12\:CKNbb \7\:CKNb \14\:VDD VDD) g45p1lvt w=(2.15e-07) l=4.5e-08 \
        nf=1 as=3.44e-14 ad=3.01e-14 ps=7.5e-07 pd=7.1e-07 nrd=1.16667 \
        nrs=1.16667 sa=1.23233e-06 sb=1.4e-07 sd=160n sca=12.0329 \
        scb=0.00996522 scc=0.000239356 m=(1)
mp20 (\10\:CKNb \1\:CKN \1\:VDD VDD) g45p1lvt w=(2.15e-07) l=4.5e-08 \
        nf=1 as=3.01e-14 ad=3.01e-14 ps=7.1e-07 pd=7.1e-07 nrd=1.16667 \
        nrs=1.16667 sa=1.4e-07 sb=1.4e-07 sd=160n sca=21.5355 \
        scb=0.0237969 scc=0.00114597 m=(1)
ends DFFNSRX1
// End of subcircuit definition.
