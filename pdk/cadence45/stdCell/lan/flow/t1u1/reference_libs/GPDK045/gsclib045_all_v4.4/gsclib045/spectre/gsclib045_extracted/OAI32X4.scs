// Generated for: spectre (May  1 08:17:33 2013 )
// Library name: gsclib045
// Cell name: OAI32X4
// View name: extracted

simulator lang=spectre

subckt OAI32X4 A0 A1 A2 B0 B1 VDD VSS Y
mp0_1__rcx (3 \1\:A0 \15\:VDD VDD) g45p1svt w=(3.9e-07) l=4.5e-08 nf=1 \
        as=5.46e-14 ad=2.34e-14 ps=1.06e-06 pd=9e-07 nrd=1.16667 \
        nrs=1.16667 sa=1.4e-07 sb=2e-06 sd=160n sca=17.1962 scb=0.0165264 \
        scc=0.000689254 m=(1)
mp1_1__rcx (3 \1\:A1 9 VDD) g45p1svt w=(3.9e-07) l=4.5e-08 nf=1 \
        as=1.0725e-13 ad=2.34e-14 ps=1.33e-06 pd=9e-07 nrd=1.16667 \
        nrs=1.16667 sa=2.45e-07 sb=2e-06 sd=160n sca=15.6659 scb=0.0140242 \
        scc=0.000653779 m=(1)
mp2_1__rcx (\13\:Y \5\:A2 9 VDD) g45p1svt w=(3.9e-07) l=4.5e-08 nf=1 \
        as=1.0725e-13 ad=6.24e-14 ps=1.33e-06 pd=1.1e-06 nrd=1.16667 \
        nrs=1.16667 sa=5.65e-07 sb=2e-06 sd=160n sca=13.8663 scb=0.0122652 \
        scc=0.000647528 m=(1)
mp2_2__rcx (\13\:Y \1\:A2 4 VDD) g45p1svt w=(3.9e-07) l=4.5e-08 nf=1 \
        as=2.34e-14 ad=6.24e-14 ps=9e-07 pd=1.1e-06 nrd=1.16667 \
        nrs=1.16667 sa=7.7e-07 sb=2e-06 sd=160n sca=13.5671 scb=0.012183 \
        scc=0.000647513 m=(1)
mp1_2__rcx (4 \4\:A1 11 VDD) g45p1svt w=(3.9e-07) l=4.5e-08 nf=1 \
        as=1.3065e-13 ad=2.34e-14 ps=1.45e-06 pd=9e-07 nrd=1.16667 \
        nrs=1.16667 sa=8.75e-07 sb=2e-06 sd=160n sca=13.5671 scb=0.012183 \
        scc=0.000647513 m=(1)
mp0_2__rcx (11 \8\:A0 \11\:VDD VDD) g45p1svt w=(3.9e-07) l=4.5e-08 nf=1 \
        as=6.24e-14 ad=1.3065e-13 ps=1.1e-06 pd=1.45e-06 nrd=1.16667 \
        nrs=1.16667 sa=1.255e-06 sb=2e-06 sd=160n sca=13.5671 scb=0.012183 \
        scc=0.000647513 m=(1)
mp0_3__rcx (5 \4\:A0 \11\:VDD VDD) g45p1svt w=(3.9e-07) l=4.5e-08 nf=1 \
        as=6.24e-14 ad=2.34e-14 ps=1.1e-06 pd=9e-07 nrd=1.16667 \
        nrs=1.16667 sa=1.46e-06 sb=2e-06 sd=160n sca=13.5671 scb=0.012183 \
        scc=0.000647513 m=(1)
mp1_3__rcx (5 \9\:A1 12 VDD) g45p1svt w=(3.9e-07) l=4.5e-08 nf=1 \
        as=7.995e-14 ad=2.34e-14 ps=1.19e-06 pd=9e-07 nrd=1.16667 \
        nrs=1.16667 sa=1.565e-06 sb=2e-06 sd=160n sca=13.5671 scb=0.012183 \
        scc=0.000647513 m=(1)
mp2_3__rcx (\11\:Y \11\:A2 12 VDD) g45p1svt w=(3.9e-07) l=4.5e-08 nf=1 \
        as=7.995e-14 ad=6.24e-14 ps=1.19e-06 pd=1.1e-06 nrd=1.16667 \
        nrs=1.16667 sa=1.815e-06 sb=2e-06 sd=160n sca=13.5671 scb=0.012183 \
        scc=0.000647513 m=(1)
mp2 (\11\:Y \12\:A2 13 VDD) g45p1svt w=(3.9e-07) l=4.5e-08 nf=1 \
        as=8.58e-14 ad=6.24e-14 ps=1.22e-06 pd=1.1e-06 nrd=1.16667 \
        nrs=1.16667 sa=2e-06 sb=1.96e-06 sd=160n sca=13.5671 scb=0.012183 \
        scc=0.000647513 m=(1)
mp1 (13 \10\:A1 14 VDD) g45p1svt w=(3.9e-07) l=4.5e-08 nf=1 as=6.435e-14 \
        ad=8.58e-14 ps=1.11e-06 pd=1.22e-06 nrd=1.16667 nrs=1.16667 \
        sa=2e-06 sb=1.695e-06 sd=160n sca=13.5671 scb=0.012183 \
        scc=0.000647513 m=(1)
mp0 (14 \12\:A0 \8\:VDD VDD) g45p1svt w=(3.9e-07) l=4.5e-08 nf=1 \
        as=9.3e-14 ad=6.435e-14 ps=1.34e-06 pd=1.11e-06 nrd=1.16667 \
        nrs=1.16667 sa=2e-06 sb=1.485e-06 sd=160n sca=13.5671 scb=0.012183 \
        scc=0.000647513 m=(1)
mp3_1__rcx (15 \1\:B0 \8\:VDD VDD) g45p1svt w=(3.9e-07) l=4.5e-08 nf=1 \
        as=9.3e-14 ad=4.095e-14 ps=1.34e-06 pd=9.9e-07 nrd=1.16667 \
        nrs=1.16667 sa=2e-06 sb=1.22e-06 sd=160n sca=13.5671 scb=0.012183 \
        scc=0.000647513 m=(1)
mp4_1__rcx (\15\:Y \5\:B1 15 VDD) g45p1svt w=(3.9e-07) l=4.5e-08 nf=1 \
        as=4.095e-14 ad=6.24e-14 ps=9.9e-07 pd=1.1e-06 nrd=1.16667 \
        nrs=1.16667 sa=2e-06 sb=1.07e-06 sd=160n sca=13.5671 scb=0.012183 \
        scc=0.000647513 m=(1)
mp4_2__rcx (\15\:Y \6\:B1 6 VDD) g45p1svt w=(3.9e-07) l=4.5e-08 nf=1 \
        as=2.34e-14 ad=6.24e-14 ps=9e-07 pd=1.1e-06 nrd=1.16667 \
        nrs=1.16667 sa=2e-06 sb=8.65e-07 sd=160n sca=13.5671 scb=0.012183 \
        scc=0.000647513 m=(1)
mp3_2__rcx (6 \7\:B0 \5\:VDD VDD) g45p1svt w=(3.9e-07) l=4.5e-08 nf=1 \
        as=6.24e-14 ad=2.34e-14 ps=1.1e-06 pd=9e-07 nrd=1.16667 \
        nrs=1.16667 sa=2e-06 sb=7.6e-07 sd=160n sca=13.5671 scb=0.012183 \
        scc=0.000647513 m=(1)
mp3_3__rcx (8 \9\:B0 \5\:VDD VDD) g45p1svt w=(3.9e-07) l=4.5e-08 nf=1 \
        as=6.24e-14 ad=2.34e-14 ps=1.1e-06 pd=9e-07 nrd=1.16667 \
        nrs=1.16667 sa=2e-06 sb=5.55e-07 sd=160n sca=13.5671 scb=0.012183 \
        scc=0.000647513 m=(1)
mp4_3__rcx (\17\:Y \10\:B1 8 VDD) g45p1svt w=(3.9e-07) l=4.5e-08 nf=1 \
        as=2.34e-14 ad=6.24e-14 ps=9e-07 pd=1.1e-06 nrd=1.16667 \
        nrs=1.16667 sa=2e-06 sb=4.5e-07 sd=160n sca=13.5671 scb=0.012183 \
        scc=0.000647513 m=(1)
mp4 (\17\:Y \12\:B1 7 VDD) g45p1svt w=(3.9e-07) l=4.5e-08 nf=1 \
        as=2.34e-14 ad=6.24e-14 ps=9e-07 pd=1.1e-06 nrd=1.16667 \
        nrs=1.16667 sa=2e-06 sb=2.45e-07 sd=160n sca=13.9711 scb=0.0123086 \
        scc=0.000647543 m=(1)
mp3 (7 \12\:B0 \1\:VDD VDD) g45p1svt w=(3.9e-07) l=4.5e-08 nf=1 \
        as=5.46e-14 ad=2.34e-14 ps=1.06e-06 pd=9e-07 nrd=1.16667 \
        nrs=1.16667 sa=2e-06 sb=1.4e-07 sd=160n sca=14.3777 scb=0.0125541 \
        scc=0.000647737 m=(1)
C1 (A0 VSS) capacitor c=1.51173e-17
C2 (B0 VSS) capacitor c=2.39396e-17
C3 (A1 VSS) capacitor c=8.37949e-16
C4 (Y VSS) capacitor c=1.08349e-17
C5 (VDD VSS) capacitor c=2.62445e-16
C6 (A2 VSS) capacitor c=4.62414e-16
C7 (B1 VSS) capacitor c=4.01046e-16
C8 (n0 VSS) capacitor c=6.6856e-16
C9 (3 VSS) capacitor c=1.56659e-18
C10 (9 VSS) capacitor c=7.85867e-18
C11 (4 VSS) capacitor c=2.44041e-18
C12 (11 VSS) capacitor c=1.61022e-17
C13 (5 VSS) capacitor c=2.44041e-18
C14 (12 VSS) capacitor c=1.01999e-17
C15 (13 VSS) capacitor c=9.28055e-18
C16 (14 VSS) capacitor c=6.77142e-18
C17 (15 VSS) capacitor c=4.03715e-18
C18 (6 VSS) capacitor c=2.44041e-18
C19 (8 VSS) capacitor c=2.44041e-18
C20 (7 VSS) capacitor c=1.54387e-18
C21 (\12\:B0 VSS) capacitor c=6.0889e-17
C22 (\12\:B1 VSS) capacitor c=6.30944e-17
C23 (\10\:B1 VSS) capacitor c=6.94515e-17
C24 (\9\:B0 VSS) capacitor c=5.72403e-17
C25 (\7\:B0 VSS) capacitor c=7.66e-17
C26 (\6\:B1 VSS) capacitor c=6.5913e-17
C27 (\5\:B1 VSS) capacitor c=5.54868e-17
C28 (\1\:B0 VSS) capacitor c=6.01206e-17
C29 (\12\:A0 VSS) capacitor c=4.95393e-17
C30 (\10\:A1 VSS) capacitor c=4.35032e-17
C31 (\12\:A2 VSS) capacitor c=3.94727e-17
C32 (\11\:A2 VSS) capacitor c=2.65197e-17
C33 (\9\:A1 VSS) capacitor c=7.31081e-17
C34 (\4\:A0 VSS) capacitor c=8.04531e-17
C35 (\8\:A0 VSS) capacitor c=1.94154e-17
C36 (\4\:A1 VSS) capacitor c=7.03788e-17
C37 (\1\:A2 VSS) capacitor c=6.22419e-17
C38 (\5\:A2 VSS) capacitor c=2.49487e-17
C39 (\1\:A1 VSS) capacitor c=7.18736e-17
C40 (\1\:A0 VSS) capacitor c=6.30375e-17
C41 (\2\:B0 VSS) capacitor c=6.17093e-16
C42 (\2\:A0 VSS) capacitor c=8.921e-16
C43 (\1\:VDD VSS) capacitor c=3.0514e-17
C44 (\17\:Y VSS) capacitor c=7.61515e-17
C45 (\5\:VDD VSS) capacitor c=3.48646e-17
C46 (\15\:Y VSS) capacitor c=9.312e-17
C47 (\8\:VDD VSS) capacitor c=2.96607e-17
C48 (\11\:Y VSS) capacitor c=1.47108e-16
C49 (\11\:VDD VSS) capacitor c=3.90083e-17
C50 (\13\:Y VSS) capacitor c=1.21399e-16
C51 (\15\:VDD VSS) capacitor c=2.14923e-17
C52 (\3\:VDD VSS) capacitor c=6.04981e-17
C53 (\1\:Y VSS) capacitor c=3.47072e-16
C54 (\2\:A2 VSS) capacitor c=3.74675e-17
C55 (\10\:A2 VSS) capacitor c=2.28659e-17
C56 (\4\:B1 VSS) capacitor c=3.23407e-17
C57 (\9\:Y VSS) capacitor c=1.0803e-16
C58 (\10\:Y VSS) capacitor c=5.56901e-17
C59 (\7\:VDD VSS) capacitor c=3.48672e-17
C60 (\10\:VDD VSS) capacitor c=3.24465e-17
C61 (\14\:VDD VSS) capacitor c=1.66496e-17
Rk10 (\2\:A0 A0) resistor r=0.03156 c=0
Rk13 (B0 \2\:B0) resistor r=0.1123 c=0
Rk20 (\1\:Y \9\:Y) resistor r=0.5732 c=0
Rk25 (\10\:Y Y) resistor r=0.009903 c=0
Rk21 (\9\:Y \10\:Y) resistor r=0.3024 c=0
Rk22 (\10\:Y \12\:Y) resistor r=0.2417 c=0
Rk23 (\12\:Y \14\:Y) resistor r=0.9153 c=0
Rk24 (\9\:Y \16\:Y) resistor r=0.2873 c=0
Rk26 (\16\:Y \18\:Y) resistor r=0.4527 c=0
Rk37 (\2\:VDD \4\:VDD) resistor r=0.5283 c=0
Rk38 (\4\:VDD \6\:VDD) resistor r=0.2631 c=0
Rk39 (\4\:VDD \7\:VDD) resistor r=0.368 c=0
Rk40 (\7\:VDD \9\:VDD) resistor r=0.1775 c=0
Rk41 (\7\:VDD \10\:VDD) resistor r=0.6347 c=0
Rk42 (\10\:VDD \12\:VDD) resistor r=0.2171 c=0
Rk43 (\10\:VDD \13\:VDD) resistor r=0.1973 c=0
Rk46 (\14\:VDD VDD) resistor r=0.1021 c=0
Rk44 (\13\:VDD \14\:VDD) resistor r=0.4474 c=0
Rk45 (\14\:VDD \16\:VDD) resistor r=0.2217 c=0
Rk56 (\3\:VSS VSS) resistor r=0.1021 c=0
Rk47 (\2\:VSS \3\:VSS) resistor r=0.4724 c=0
Rl27 (\2\:A0 \12\:A0) resistor r=24.2328 c=0
Rl12 (\2\:A0 \4\:A0) resistor r=105.323 c=0
Rl15 (\2\:A0 \8\:A0) resistor r=24.2328 c=0
Rl1 (\2\:A0 \1\:A0) resistor r=45.6195 c=0
Rl46 (\2\:B0 \12\:B0) resistor r=24.2328 c=0
Rl39 (\2\:B0 \9\:B0) resistor r=24.2328 c=0
Rl37 (\2\:B0 \7\:B0) resistor r=75.6352 c=0
Rl28 (\2\:B0 \1\:B0) resistor r=26.098 c=0
Rl24 (A1 \10\:A1) resistor r=44.9225 c=0
Rl18 (A1 \9\:A1) resistor r=41.4826 c=0
Rl10 (A1 \4\:A1) resistor r=52.6149 c=0
Rl3 (A1 \1\:A1) resistor r=52.6149 c=0
Rl6 (\2\:A2 A2) resistor r=71.9912 c=0
Rl5 (\2\:A2 \1\:A2) resistor r=65.3625 c=0
Rl8 (\2\:A2 \5\:A2) resistor r=67.2856 c=0
Rl21 (\10\:A2 A2) resistor r=77.3125 c=0
Rl23 (\10\:A2 \12\:A2) resistor r=100.426 c=0
Rl22 (\10\:A2 \11\:A2) resistor r=35.772 c=0
Rl44 (B1 \12\:B1) resistor r=52.6559 c=0
Rl42 (B1 \10\:B1) resistor r=99.9772 c=0
Rl32 (\4\:B1 B1) resistor r=6.3032 c=0
Rl34 (\4\:B1 \6\:B1) resistor r=74.564 c=0
Rl33 (\4\:B1 \5\:B1) resistor r=118.715 c=0
Rz16 (\3\:VDD \4\:VDD) resistor r=6.25 c=0
Rz17 (\3\:VDD \13\:VDD) resistor r=6.25 c=0
Ry1 (\12\:Y \11\:Y) resistor r=62 c=0
Ry2 (\14\:Y \13\:Y) resistor r=62 c=0
Ry3 (\16\:Y \15\:Y) resistor r=62 c=0
Ry4 (\18\:Y \17\:Y) resistor r=62 c=0
Ry5 (\1\:VDD \2\:VDD) resistor r=62 c=0
Ry6 (\5\:VDD \6\:VDD) resistor r=62 c=0
Ry7 (\8\:VDD \9\:VDD) resistor r=62 c=0
Ry8 (\11\:VDD \12\:VDD) resistor r=62 c=0
Ry9 (\15\:VDD \16\:VDD) resistor r=62 c=0
Ry10 (\2\:VSS \1\:VSS) resistor r=5.1667 c=0
Ry11 (\3\:VSS \1\:VSS) resistor r=5.1667 c=0
mn3_1__rcx (\1\:Y \2\:B0 n0 VSS) g45n1svt w=(2.6e-07) l=4.5e-08 nf=1 \
        as=4.03e-14 ad=4.16e-14 ps=8.3e-07 pd=8.4e-07 nrd=1.16667 \
        nrs=1.16667 sa=2e-06 sb=1.575e-06 sd=160n sca=10.79 scb=0.0100512 \
        scc=0.000418069 m=(4)
mn4_1__rcx (\1\:Y B1 n0 VSS) g45n1svt w=(2.6e-07) l=4.5e-08 nf=1 \
        as=4.16e-14 ad=4.16e-14 ps=8.4e-07 pd=8.4e-07 nrd=1.16667 \
        nrs=1.16667 sa=2e-06 sb=1.37e-06 sd=160n sca=10.79 scb=0.0100512 \
        scc=0.000418069 m=(4)
mn0_1__rcx (n0 \2\:A0 \3\:VSS VSS) g45n1svt w=(2.6e-07) l=4.5e-08 nf=1 \
        as=8.54e-14 ad=4.03e-14 ps=1.43e-06 pd=8.3e-07 nrd=1.16667 \
        nrs=1.16667 sa=1.4e-07 sb=2e-06 sd=160n sca=10.79 scb=0.0100512 \
        scc=0.000418069 m=(4)
mn1_1__rcx (n0 A1 \3\:VSS VSS) g45n1svt w=(2.6e-07) l=4.5e-08 nf=1 \
        as=8.54e-14 ad=4.16e-14 ps=1.43e-06 pd=8.4e-07 nrd=1.16667 \
        nrs=1.16667 sa=4.05e-07 sb=2e-06 sd=160n sca=10.79 scb=0.0100512 \
        scc=0.000418069 m=(4)
mn2_1__rcx (n0 A2 \3\:VSS VSS) g45n1svt w=(2.6e-07) l=4.5e-08 nf=1 \
        as=8.54e-14 ad=4.16e-14 ps=1.43e-06 pd=8.4e-07 nrd=1.16667 \
        nrs=1.16667 sa=6.1e-07 sb=2e-06 sd=160n sca=10.79 scb=0.0100512 \
        scc=0.000418069 m=(4)
ends OAI32X4
// End of subcircuit definition.
