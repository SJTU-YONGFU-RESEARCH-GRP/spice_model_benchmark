// gsclib045_backbias/AO21XL/schematic

simulator lang=spectre

subckt AO21XL A0 A1 B0 Y VDD VSS NW
mn1 (n0 A1 n1 VSS) g45n1svt w=(145n) l=45n nf=1 m=(1)
mn0 (n1 A0 VSS VSS) g45n1svt w=(145n) l=45n nf=1 m=(1)
mn3 (Y n0 VSS VSS) g45n1svt w=(145n) l=45n nf=1 m=(1)
mn2 (n0 B0 VSS VSS) g45n1svt w=(145n) l=45n nf=1 m=(1)
mp1 (n2 A1 VDD NW) g45p1svt w=(215n) l=45n nf=1 m=(1)
mp0 (n2 A0 VDD NW) g45p1svt w=(215n) l=45n nf=1 m=(1)
mp3 (Y n0 VDD NW) g45p1svt w=(215n) l=45n nf=1 m=(1)
mp2 (n0 B0 n2 NW) g45p1svt w=(215n) l=45n nf=1 m=(1)
ends AO21XL
