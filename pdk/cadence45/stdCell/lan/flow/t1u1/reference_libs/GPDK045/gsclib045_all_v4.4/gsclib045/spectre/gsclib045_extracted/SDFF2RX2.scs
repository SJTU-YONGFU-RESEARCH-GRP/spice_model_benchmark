// Generated for: spectre (May  1 08:13:08 2013 )
// Library name: gsclib045
// Cell name: SDFF2RX2
// View name: extracted

simulator lang=spectre

subckt SDFF2RX2 CK D1 D2 Q1 Q1N Q2 Q2N RN SE SI VDD VSS
mp55 (\6\:Q1 qbint \48\:VDD VDD) g45p1svt w=(3.9e-07) l=4.5e-08 nf=1 \
        as=1.1475e-13 ad=1.1287e-13 ps=1.68e-06 pd=1.995e-06 nrd=1.16667 \
        nrs=1.16667 sa=1.2e-07 sb=1.43019e-06 sd=160n sca=30.5009 \
        scb=0.0202006 scc=0.00336097 m=(2)
PM19 (\3\:Q2N qint_2 \1\:VDD VDD) g45p1svt w=(3.9e-07) l=4.5e-08 nf=1 \
        as=6.24e-14 ad=8.951e-14 ps=1.1e-06 pd=1.885e-06 nrd=1.16667 \
        nrs=1.16667 sa=1.2e-07 sb=4.55e-07 sd=160n sca=34.6642 \
        scb=0.0254864 scc=0.00342609 m=(2)
PM17_1__rcx (\5\:Q2 \6\:qbint_2 \5\:VDD VDD) g45p1svt w=(3.9e-07) \
        l=4.5e-08 nf=1 as=1.1475e-13 ad=1.1287e-13 ps=1.68e-06 \
        pd=1.995e-06 nrd=1.16667 nrs=1.16667 sa=1.2e-07 sb=1.43019e-06 \
        sd=160n sca=30.5009 scb=0.0202006 scc=0.00336097 m=(2)
mp57 (\3\:Q1N qint \54\:VDD VDD) g45p1svt w=(3.9e-07) l=4.5e-08 nf=1 \
        as=6.24e-14 ad=8.951e-14 ps=1.1e-06 pd=1.885e-06 nrd=1.16667 \
        nrs=1.16667 sa=1.2e-07 sb=4.55e-07 sd=160n sca=34.6642 \
        scb=0.0254864 scc=0.00342609 m=(2)
C1 (D1 VSS) capacitor c=2.03183e-17
C2 (Q1N VSS) capacitor c=2.43848e-17
C3 (Q2 VSS) capacitor c=2.92276e-17
C4 (CK VSS) capacitor c=4.63929e-17
C5 (SE VSS) capacitor c=2.73606e-17
C6 (RN VSS) capacitor c=3.29467e-17
C7 (D2 VSS) capacitor c=2.09196e-17
C8 (Q2N VSS) capacitor c=2.46702e-17
C9 (VDD VSS) capacitor c=8.92747e-16
C10 (Ckbb VSS) capacitor c=2.22894e-17
C11 (CKb VSS) capacitor c=3.43291e-17
C12 (Db VSS) capacitor c=5.07282e-17
C13 (qint VSS) capacitor c=1.21904e-16
C14 (n8 VSS) capacitor c=1.76436e-18
C15 (n6 VSS) capacitor c=6.73654e-17
C16 (SEb VSS) capacitor c=4.42623e-17
C17 (qbint VSS) capacitor c=1.32882e-16
C18 (n30 VSS) capacitor c=4.09537e-17
C19 (mout VSS) capacitor c=5.23033e-17
C20 (n20 VSS) capacitor c=2.55525e-17
C21 (n2 VSS) capacitor c=3.96884e-18
C22 (n4 VSS) capacitor c=1.50783e-18
C23 (n9 VSS) capacitor c=1.21856e-18
C24 (n11 VSS) capacitor c=3.08858e-18
C25 (n5 VSS) capacitor c=2.3104e-19
C26 (n1 VSS) capacitor c=2.88673e-18
C27 (Db_2 VSS) capacitor c=1.03139e-16
C28 (qint_2 VSS) capacitor c=1.21921e-16
C29 (n8_2 VSS) capacitor c=1.76436e-18
C30 (n6_2 VSS) capacitor c=7.50609e-17
C31 (SEb_2 VSS) capacitor c=5.67971e-17
C32 (qbint_2 VSS) capacitor c=4.7359e-17
C33 (n30_2 VSS) capacitor c=4.93562e-17
C34 (mout_2 VSS) capacitor c=5.25813e-17
C35 (n20_2 VSS) capacitor c=4.67235e-17
C36 (n2_2 VSS) capacitor c=3.95036e-18
C37 (n4_2 VSS) capacitor c=1.50247e-18
C38 (n9_2 VSS) capacitor c=1.18302e-18
C39 (n11_2 VSS) capacitor c=3.08858e-18
C40 (n5_2 VSS) capacitor c=2.3104e-19
C41 (n1_2 VSS) capacitor c=2.88673e-18
C42 (\4\:qbint_2 VSS) capacitor c=3.52654e-17
C43 (\13\:RN VSS) capacitor c=3.27082e-17
C44 (\12\:Ckbb VSS) capacitor c=7.65213e-17
C45 (\15\:CKb VSS) capacitor c=2.87157e-17
C46 (\9\:RN VSS) capacitor c=6.5104e-17
C47 (\13\:CKb VSS) capacitor c=3.75016e-17
C48 (\8\:Ckbb VSS) capacitor c=9.0908e-17
C49 (\1\:D2 VSS) capacitor c=4.76337e-17
C50 (\13\:SE VSS) capacitor c=4.04104e-17
C51 (\3\:SEb_2 VSS) capacitor c=4.27191e-17
C52 (\10\:Q1 VSS) capacitor c=4.92458e-17
C53 (\8\:SE VSS) capacitor c=4.64209e-17
C54 (\1\:CK VSS) capacitor c=4.04082e-17
C55 (\11\:CKb VSS) capacitor c=3.52278e-17
C56 (\5\:SE VSS) capacitor c=4.42216e-17
C57 (\3\:SI VSS) capacitor c=8.27883e-17
C58 (\1\:SE VSS) capacitor c=4.23879e-17
C59 (\1\:D1 VSS) capacitor c=4.67535e-17
C60 (\6\:Ckbb VSS) capacitor c=9.02335e-17
C61 (\6\:CKb VSS) capacitor c=3.66746e-17
C62 (\6\:RN VSS) capacitor c=6.54428e-17
C63 (\4\:n20 VSS) capacitor c=4.61513e-17
C64 (\3\:CKb VSS) capacitor c=2.85099e-17
C65 (\3\:Ckbb VSS) capacitor c=7.66848e-17
C66 (\11\:qbint VSS) capacitor c=4.83329e-17
C67 (\3\:RN VSS) capacitor c=3.28447e-17
C68 (\3\:n30 VSS) capacitor c=4.79899e-17
C69 (\10\:qbint VSS) capacitor c=3.51339e-17
C70 (\9\:qbint_2 VSS) capacitor c=3.04938e-17
C71 (\3\:n30_2 VSS) capacitor c=4.16089e-17
C72 (\11\:RN VSS) capacitor c=5.15561e-17
C73 (\3\:qbint_2 VSS) capacitor c=4.03738e-17
C74 (\17\:CKb VSS) capacitor c=3.408e-17
C75 (\13\:Ckbb VSS) capacitor c=6.02149e-17
C76 (\4\:n20_2 VSS) capacitor c=4.02749e-17
C77 (\10\:RN VSS) capacitor c=8.268e-17
C78 (\3\:mout_2 VSS) capacitor c=4.93331e-17
C79 (\10\:Ckbb VSS) capacitor c=5.7909e-17
C80 (\12\:CKb VSS) capacitor c=5.7991e-17
C81 (\3\:D2 VSS) capacitor c=4.06457e-17
C82 (\11\:SE VSS) capacitor c=4.33001e-17
C83 (\8\:Q1 VSS) capacitor c=5.68102e-17
C84 (\10\:SE VSS) capacitor c=4.06432e-17
C85 (\3\:CK VSS) capacitor c=4.14933e-17
C86 (\10\:CKb VSS) capacitor c=3.06741e-17
C87 (\7\:SE VSS) capacitor c=4.05028e-17
C88 (\1\:SI VSS) capacitor c=5.48548e-17
C89 (\3\:SE VSS) capacitor c=4.33001e-17
C90 (\3\:SEb VSS) capacitor c=5.72182e-17
C91 (\3\:D1 VSS) capacitor c=4.06724e-17
C92 (\7\:CKb VSS) capacitor c=5.81133e-17
C93 (\4\:Ckbb VSS) capacitor c=5.79348e-17
C94 (\3\:mout VSS) capacitor c=4.93391e-17
C95 (\5\:RN VSS) capacitor c=8.27341e-17
C96 (\3\:n20 VSS) capacitor c=3.9835e-17
C97 (\2\:Ckbb VSS) capacitor c=6.03049e-17
C98 (\13\:qbint VSS) capacitor c=4.03738e-17
C99 (\1\:RN VSS) capacitor c=5.13394e-17
C100 (\5\:qbint VSS) capacitor c=3.04921e-17
C101 (\4\:qint_2 VSS) capacitor c=2.31475e-17
C102 (\8\:qbint_2 VSS) capacitor c=1.78944e-17
C103 (\2\:n30_2 VSS) capacitor c=4.09833e-17
C104 (\14\:RN VSS) capacitor c=2.88166e-17
C105 (\12\:RN VSS) capacitor c=1.37026e-16
C106 (\2\:qbint_2 VSS) capacitor c=4.34308e-17
C107 (\18\:CKb VSS) capacitor c=5.054e-17
C108 (\14\:Ckbb VSS) capacitor c=2.22781e-17
C109 (\16\:CKb VSS) capacitor c=3.92472e-17
C110 (\3\:n20_2 VSS) capacitor c=2.51718e-17
C111 (\8\:RN VSS) capacitor c=2.88601e-17
C112 (\2\:mout_2 VSS) capacitor c=4.88286e-17
C113 (\11\:Ckbb VSS) capacitor c=2.1772e-17
C114 (\14\:CKb VSS) capacitor c=4.08254e-17
C115 (\9\:Ckbb VSS) capacitor c=4.46128e-17
C116 (\2\:D2 VSS) capacitor c=3.65525e-17
C117 (\14\:SE VSS) capacitor c=5.04695e-17
C118 (\2\:SEb_2 VSS) capacitor c=7.65452e-17
C119 (\12\:SE VSS) capacitor c=5.0187e-17
C120 (\11\:Q1 VSS) capacitor c=3.10633e-17
C121 (\9\:Q1 VSS) capacitor c=1.22295e-16
C122 (\9\:SE VSS) capacitor c=2.5847e-17
C123 (\2\:CK VSS) capacitor c=3.27509e-17
C124 (\8\:CKb VSS) capacitor c=2.08889e-17
C125 (\6\:SE VSS) capacitor c=2.666e-17
C126 (\2\:SI VSS) capacitor c=4.8943e-17
C127 (\4\:SE VSS) capacitor c=5.02371e-17
C128 (\2\:SEb VSS) capacitor c=7.61091e-17
C129 (\2\:SE VSS) capacitor c=5.06267e-17
C130 (\2\:D1 VSS) capacitor c=3.65357e-17
C131 (\7\:Ckbb VSS) capacitor c=4.45399e-17
C132 (\5\:CKb VSS) capacitor c=4.08562e-17
C133 (\5\:Ckbb VSS) capacitor c=2.17721e-17
C134 (\2\:mout VSS) capacitor c=4.88247e-17
C135 (\7\:RN VSS) capacitor c=3.11841e-17
C136 (\4\:CKb VSS) capacitor c=3.97503e-17
C137 (\2\:CKb VSS) capacitor c=5.05461e-17
C138 (\12\:qbint VSS) capacitor c=4.34469e-17
C139 (\2\:RN VSS) capacitor c=1.37143e-16
C140 (\4\:RN VSS) capacitor c=3.04182e-17
C141 (\2\:n30 VSS) capacitor c=4.10104e-17
C142 (\6\:qint VSS) capacitor c=2.3136e-17
C143 (\1\:VDD VSS) capacitor c=1.74609e-17
C144 (\3\:Q2N VSS) capacitor c=4.47278e-17
C145 (\8\:qint_2 VSS) capacitor c=1.90144e-17
C146 (\5\:Q2 VSS) capacitor c=3.28147e-19
C147 (\16\:qbint_2 VSS) capacitor c=1.26136e-16
C148 (\14\:VDD VSS) capacitor c=2.86652e-17
C149 (\4\:n30_2 VSS) capacitor c=8.65687e-17
C150 (\4\:mout_2 VSS) capacitor c=5.65278e-17
C151 (\17\:VDD VSS) capacitor c=1.98009e-17
C152 (\20\:VDD VSS) capacitor c=2.19468e-17
C153 (\3\:n6_2 VSS) capacitor c=6.75985e-17
C154 (\7\:n20_2 VSS) capacitor c=6.90744e-17
C155 (\4\:Db_2 VSS) capacitor c=9.04801e-17
C156 (\24\:VDD VSS) capacitor c=1.93247e-17
C157 (\6\:Db_2 VSS) capacitor c=5.07663e-17
C158 (\27\:VDD VSS) capacitor c=3.78837e-17
C159 (\5\:SEb_2 VSS) capacitor c=1.08741e-16
C160 (\32\:CKb VSS) capacitor c=3.59105e-17
C161 (\30\:VDD VSS) capacitor c=3.68865e-17
C162 (\17\:Ckbb VSS) capacitor c=1.20773e-16
C163 (\6\:SEb VSS) capacitor c=1.0911e-16
C164 (\33\:VDD VSS) capacitor c=3.76802e-17
C165 (\36\:VDD VSS) capacitor c=3.52862e-17
C166 (\4\:Db VSS) capacitor c=8.99444e-17
C167 (\5\:n20 VSS) capacitor c=6.92476e-17
C168 (\40\:VDD VSS) capacitor c=3.49538e-17
C169 (\3\:n6 VSS) capacitor c=7.58426e-17
C170 (\43\:VDD VSS) capacitor c=3.28525e-17
C171 (\8\:mout VSS) capacitor c=5.64507e-17
C172 (\4\:n30 VSS) capacitor c=8.66537e-17
C173 (\46\:VDD VSS) capacitor c=4.17342e-17
C174 (\15\:qbint VSS) capacitor c=1.25666e-16
C175 (\6\:Q1 VSS) capacitor c=7.0796e-16
C176 (\8\:qint VSS) capacitor c=1.90807e-17
C177 (\3\:Q1N VSS) capacitor c=3.89738e-17
C178 (\4\:VDD VSS) capacitor c=1.26092e-16
C179 (\1\:Q2N VSS) capacitor c=1.74475e-17
C180 (\11\:qint_2 VSS) capacitor c=1.80398e-17
C181 (\19\:qbint_2 VSS) capacitor c=4.66544e-17
C182 (\6\:n30_2 VSS) capacitor c=1.41738e-16
C183 (\8\:mout_2 VSS) capacitor c=3.02069e-17
C184 (\9\:n20_2 VSS) capacitor c=4.67851e-17
C185 (\8\:Db_2 VSS) capacitor c=7.37177e-17
C186 (\7\:SEb_2 VSS) capacitor c=7.91113e-17
C187 (\29\:CKb VSS) capacitor c=5.75454e-17
C188 (\15\:Ckbb VSS) capacitor c=5.42722e-16
C189 (\4\:SEb VSS) capacitor c=8.00219e-17
C190 (\6\:Db VSS) capacitor c=1.03376e-16
C191 (\8\:Db VSS) capacitor c=7.39564e-17
C192 (\9\:n20 VSS) capacitor c=4.68033e-17
C193 (\6\:mout VSS) capacitor c=3.02333e-17
C194 (\6\:n30 VSS) capacitor c=1.43203e-16
C195 (\19\:qbint VSS) capacitor c=4.65744e-17
C196 (\12\:qint VSS) capacitor c=1.80398e-17
C197 (\1\:Q1N VSS) capacitor c=1.37566e-17
C198 (\4\:qbint VSS) capacitor c=3.16698e-17
C199 (\2\:n20 VSS) capacitor c=2.37037e-17
C200 (\9\:CKb VSS) capacitor c=1.35609e-17
C201 (\10\:qint VSS) capacitor c=1.72648e-17
C202 (\11\:qint VSS) capacitor c=3.8562e-17
C203 (\1\:Q1 VSS) capacitor c=2.66393e-17
C204 (\4\:Q1 VSS) capacitor c=2.8922e-17
C205 (\5\:Q1 VSS) capacitor c=2.03236e-17
C206 (\14\:qbint VSS) capacitor c=9.66563e-17
C207 (\17\:qbint VSS) capacitor c=5.08295e-17
C208 (\18\:qbint VSS) capacitor c=1.80901e-17
C209 (\8\:n30 VSS) capacitor c=1.33327e-16
C210 (\4\:mout VSS) capacitor c=7.92859e-17
C211 (\5\:mout VSS) capacitor c=7.37733e-17
C212 (\7\:n20 VSS) capacitor c=1.0017e-16
C213 (\8\:n20 VSS) capacitor c=1.03891e-16
C214 (\2\:n20_2 VSS) capacitor c=2.31147e-17
C215 (\4\:D1 VSS) capacitor c=5.26677e-17
C216 (\3\:Db VSS) capacitor c=1.04875e-16
C217 (\4\:SI VSS) capacitor c=3.05823e-17
C218 (\6\:SI VSS) capacitor c=4.23198e-17
C219 (\8\:SEb VSS) capacitor c=9.30828e-17
C220 (\5\:CK VSS) capacitor c=4.94388e-17
C221 (\5\:qbint_2 VSS) capacitor c=3.2019e-17
C222 (\6\:qbint_2 VSS) capacitor c=1.08344e-16
C223 (\12\:Q1 VSS) capacitor c=7.29099e-16
C224 (\4\:SEb_2 VSS) capacitor c=9.29746e-17
C225 (\4\:D2 VSS) capacitor c=5.26792e-17
C226 (\3\:Db_2 VSS) capacitor c=1.05669e-16
C227 (\5\:n20_2 VSS) capacitor c=1.03858e-16
C228 (\6\:n20_2 VSS) capacitor c=1.00759e-16
C229 (\6\:mout_2 VSS) capacitor c=7.38695e-17
C230 (\7\:mout_2 VSS) capacitor c=7.94042e-17
C231 (\8\:n30_2 VSS) capacitor c=1.33641e-16
C232 (\19\:CKb VSS) capacitor c=1.13167e-16
C233 (\20\:CKb VSS) capacitor c=4.05324e-16
C234 (\21\:CKb VSS) capacitor c=4.03326e-16
C235 (\22\:CKb VSS) capacitor c=4.84245e-16
C236 (\23\:CKb VSS) capacitor c=3.86752e-16
C237 (\24\:CKb VSS) capacitor c=4.05075e-16
C238 (\25\:CKb VSS) capacitor c=1.1331e-16
C239 (\26\:CKb VSS) capacitor c=7.23997e-17
C240 (\27\:CKb VSS) capacitor c=3.80224e-17
C241 (\28\:CKb VSS) capacitor c=1.07954e-16
C242 (\31\:CKb VSS) capacitor c=7.32956e-17
C243 (\15\:RN VSS) capacitor c=2.13118e-16
C244 (\16\:RN VSS) capacitor c=2.84289e-16
C245 (\17\:RN VSS) capacitor c=7.40258e-16
C246 (\18\:RN VSS) capacitor c=7.88609e-16
C247 (\19\:RN VSS) capacitor c=2.8521e-16
C248 (\15\:SE VSS) capacitor c=5.57678e-17
C249 (\16\:SE VSS) capacitor c=8.77553e-16
C250 (\17\:SE VSS) capacitor c=2.35511e-16
C251 (\18\:SE VSS) capacitor c=2.50421e-16
C252 (\19\:SE VSS) capacitor c=8.79e-16
C253 (\20\:SE VSS) capacitor c=5.56887e-17
C254 (\21\:SE VSS) capacitor c=8.59373e-17
C255 (\22\:SE VSS) capacitor c=5.81024e-17
C256 (\19\:Ckbb VSS) capacitor c=3.52279e-16
C257 (\20\:Ckbb VSS) capacitor c=1.60022e-16
C258 (\21\:Ckbb VSS) capacitor c=3.31751e-16
C259 (\23\:Ckbb VSS) capacitor c=2.36257e-16
C260 (\24\:Ckbb VSS) capacitor c=1.59958e-16
C261 (\25\:Ckbb VSS) capacitor c=3.52283e-16
C262 (\14\:qbint_2 VSS) capacitor c=1.76619e-17
C263 (\15\:qbint_2 VSS) capacitor c=5.0591e-17
C264 (\18\:qbint_2 VSS) capacitor c=9.67835e-17
C265 (\3\:Q2 VSS) capacitor c=2.66395e-17
C266 (\7\:Q2 VSS) capacitor c=2.39558e-17
C267 (\10\:qint_2 VSS) capacitor c=1.72426e-17
C268 (\13\:qint_2 VSS) capacitor c=3.87795e-17
C269 (\5\:VDD VSS) capacitor c=2.83282e-17
C270 (\13\:VDD VSS) capacitor c=2.57444e-17
C271 (\16\:VDD VSS) capacitor c=2.03442e-17
C272 (\19\:VDD VSS) capacitor c=4.26971e-18
C273 (\23\:VDD VSS) capacitor c=3.17694e-17
C274 (\26\:VDD VSS) capacitor c=4.98574e-17
C275 (\32\:VDD VSS) capacitor c=4.85991e-17
C276 (\35\:VDD VSS) capacitor c=4.53026e-17
C277 (\39\:VDD VSS) capacitor c=6.80309e-18
C278 (\42\:VDD VSS) capacitor c=3.36065e-17
C279 (\45\:VDD VSS) capacitor c=4.25194e-17
C280 (\48\:VDD VSS) capacitor c=6.45334e-17
C281 (\54\:VDD VSS) capacitor c=1.73132e-17
Rk24 (\4\:D1 D1) resistor r=0.0177 c=0
Rk1 (Q1N \2\:Q1N) resistor r=0.02799 c=0
Rk2 (Q1N \4\:Q1N) resistor r=0.1529 c=0
Rk89 (\2\:Q2 \3\:Q2) resistor r=0.001732 c=0
Rk90 (\4\:Q2 Q2) resistor r=0.002944 c=0
Rk91 (\3\:Q2 \4\:Q2) resistor r=0.09516 c=0
Rk93 (\4\:Q2 \7\:Q2) resistor r=0.06083 c=0
Rk92 (\6\:Q2 \7\:Q2) resistor r=0.002886 c=0
Rk36 (CK \5\:CK) resistor r=0.01183 c=0
Rk35 (\4\:CK \5\:CK) resistor r=0.004256 c=0
Rk71 (\15\:SE \16\:SE) resistor r=0.2638 c=0
Rk72 (\16\:SE \17\:SE) resistor r=0.5982 c=0
Rk73 (\17\:SE \18\:SE) resistor r=1.2565 c=0
Rk74 (\18\:SE \19\:SE) resistor r=0.7013 c=0
Rk75 (\19\:SE \20\:SE) resistor r=0.2638 c=0
Rk76 (\17\:SE \21\:SE) resistor r=0.2341 c=0
Rk78 (\22\:SE SE) resistor r=0.03316 c=0
Rk77 (\18\:SE \22\:SE) resistor r=0.2341 c=0
Rk29 (\4\:SI \5\:SI) resistor r=0.007737 c=0
Rk30 (SI \6\:SI) resistor r=0.007737 c=0
Rk31 (\4\:SI \6\:SI) resistor r=0.03322 c=0
Rk139 (\1\:VSS \5\:VSS) resistor r=0.268 c=0
Rk142 (\5\:VSS \9\:VSS) resistor r=0.3136 c=0
Rk143 (\9\:VSS \10\:VSS) resistor r=0.5107 c=0
Rk144 (\10\:VSS \11\:VSS) resistor r=0.1985 c=0
Rk145 (\11\:VSS \12\:VSS) resistor r=0.3577 c=0
Rk146 (\12\:VSS \13\:VSS) resistor r=0.4096 c=0
Rk147 (\13\:VSS \14\:VSS) resistor r=0.4416 c=0
Rk148 (\14\:VSS \15\:VSS) resistor r=0.4419 c=0
Rk149 (\15\:VSS \16\:VSS) resistor r=0.4096 c=0
Rk150 (\16\:VSS \17\:VSS) resistor r=0.3577 c=0
Rk151 (\17\:VSS \18\:VSS) resistor r=0.1985 c=0
Rk152 (\18\:VSS \19\:VSS) resistor r=0.5107 c=0
Rk153 (\19\:VSS \20\:VSS) resistor r=0.3136 c=0
Rk157 (\22\:VSS VSS) resistor r=0.09968 c=0
Rk155 (\20\:VSS \22\:VSS) resistor r=0.268 c=0
Rk160 (\9\:VSS \29\:VSS) resistor r=0.04377 c=0
Rk161 (\10\:VSS \31\:VSS) resistor r=0.04377 c=0
Rk162 (\12\:VSS \33\:VSS) resistor r=0.04377 c=0
Rk163 (\13\:VSS \35\:VSS) resistor r=0.04377 c=0
Rk164 (\14\:VSS \37\:VSS) resistor r=0.06984 c=0
Rk165 (\15\:VSS \39\:VSS) resistor r=0.04377 c=0
Rk166 (\16\:VSS \41\:VSS) resistor r=0.04377 c=0
Rk167 (\18\:VSS \43\:VSS) resistor r=0.04377 c=0
Rk168 (\19\:VSS \45\:VSS) resistor r=0.04377 c=0
Rk6 (\1\:Q1 \3\:Q1) resistor r=0.001732 c=0
Rk7 (Q1 \4\:Q1) resistor r=0.002828 c=0
Rk8 (\1\:Q1 \4\:Q1) resistor r=0.09516 c=0
Rk10 (\4\:Q1 \5\:Q1) resistor r=0.06083 c=0
Rk9 (\5\:Q1 \7\:Q1) resistor r=0.002886 c=0
Rk37 (\12\:Q1 \13\:Q1) resistor r=5.0925 c=0
Rk66 (\15\:RN \16\:RN) resistor r=1.2974 c=0
Rk70 (\17\:RN RN) resistor r=0.02535 c=0
Rk67 (\16\:RN \17\:RN) resistor r=1.4111 c=0
Rk68 (\17\:RN \18\:RN) resistor r=4.239 c=0
Rk69 (\18\:RN \19\:RN) resistor r=1.2974 c=0
Rk40 (\4\:D2 D2) resistor r=0.01749 c=0
Rk97 (Q2N \2\:Q2N) resistor r=0.02799 c=0
Rk98 (Q2N \4\:Q2N) resistor r=0.1529 c=0
Rk100 (\1\:VDD \5\:VDD) resistor r=0.2585 c=0
Rk105 (\5\:VDD \13\:VDD) resistor r=0.2883 c=0
Rk106 (\13\:VDD \15\:VDD) resistor r=0.04377 c=0
Rk107 (\13\:VDD \16\:VDD) resistor r=0.4602 c=0
Rk108 (\16\:VDD \18\:VDD) resistor r=0.04377 c=0
Rk109 (\16\:VDD \19\:VDD) resistor r=0.1746 c=0
Rk110 (\19\:VDD \21\:VDD) resistor r=0.04377 c=0
Rk111 (\19\:VDD \22\:VDD) resistor r=0.07214 c=0
Rk112 (\22\:VDD \23\:VDD) resistor r=0.3704 c=0
Rk113 (\23\:VDD \25\:VDD) resistor r=0.04377 c=0
Rk114 (\23\:VDD \26\:VDD) resistor r=0.397 c=0
Rk115 (\26\:VDD \28\:VDD) resistor r=0.04377 c=0
Rk116 (\26\:VDD \29\:VDD) resistor r=0.4416 c=0
Rk117 (\29\:VDD \31\:VDD) resistor r=0.07203 c=0
Rk118 (\29\:VDD \32\:VDD) resistor r=0.4418 c=0
Rk119 (\32\:VDD \34\:VDD) resistor r=0.04377 c=0
Rk120 (\32\:VDD \35\:VDD) resistor r=0.397 c=0
Rk121 (\35\:VDD \37\:VDD) resistor r=0.04377 c=0
Rk122 (\35\:VDD \38\:VDD) resistor r=0.3704 c=0
Rk123 (\38\:VDD \39\:VDD) resistor r=0.07214 c=0
Rk124 (\39\:VDD \41\:VDD) resistor r=0.04377 c=0
Rk125 (\39\:VDD \42\:VDD) resistor r=0.1746 c=0
Rk126 (\42\:VDD \44\:VDD) resistor r=0.04377 c=0
Rk127 (\42\:VDD \45\:VDD) resistor r=0.4602 c=0
Rk128 (\45\:VDD \47\:VDD) resistor r=0.04377 c=0
Rk129 (\45\:VDD \48\:VDD) resistor r=0.2883 c=0
Rk137 (\54\:VDD VDD) resistor r=0.09968 c=0
Rk133 (\48\:VDD \54\:VDD) resistor r=0.2585 c=0
Rk34 (\16\:Ckbb \18\:Ckbb) resistor r=0.3072 c=0
Rk79 (\19\:Ckbb \20\:Ckbb) resistor r=0.8008 c=0
Rk80 (\20\:Ckbb \21\:Ckbb) resistor r=0.4831 c=0
Rk81 (\21\:Ckbb \22\:Ckbb) resistor r=2.1199 c=0
Rk82 (\22\:Ckbb \23\:Ckbb) resistor r=1.4713 c=0
Rk83 (\23\:Ckbb \24\:Ckbb) resistor r=0.4831 c=0
Rk84 (\24\:Ckbb \25\:Ckbb) resistor r=0.8008 c=0
Rk54 (\19\:CKb \20\:CKb) resistor r=0.6711 c=0
Rk55 (\20\:CKb \21\:CKb) resistor r=0.987 c=0
Rk56 (\21\:CKb \22\:CKb) resistor r=2.0031 c=0
Rk57 (\22\:CKb \23\:CKb) resistor r=1.8709 c=0
Rk58 (\23\:CKb \24\:CKb) resistor r=0.987 c=0
Rk59 (\24\:CKb \25\:CKb) resistor r=0.7267 c=0
Rk60 (\20\:CKb \26\:CKb) resistor r=0.2782 c=0
Rk61 (\22\:CKb \27\:CKb) resistor r=0.102 c=0
Rk62 (\27\:CKb \28\:CKb) resistor r=0.2014 c=0
Rk63 (\28\:CKb \30\:CKb) resistor r=0.2737 c=0
Rk64 (\24\:CKb \31\:CKb) resistor r=0.2782 c=0
Rk65 (\27\:CKb \33\:CKb) resistor r=0.1994 c=0
Rk25 (\2\:Db \3\:Db) resistor r=0.2041 c=0
Rk26 (\3\:Db \5\:Db) resistor r=0.296 c=0
Rk27 (\3\:Db \7\:Db) resistor r=0.5473 c=0
Rk28 (\5\:Db \9\:Db) resistor r=0.4339 c=0
Rk3 (\9\:qint \10\:qint) resistor r=0.1061 c=0
Rk4 (\10\:qint \11\:qint) resistor r=0.1393 c=0
Rk5 (\10\:qint \13\:qint) resistor r=0.1182 c=0
Rk20 (\2\:n6 \4\:n6) resistor r=0.2213 c=0
Rk32 (\5\:SEb \7\:SEb) resistor r=0.4092 c=0
Rk33 (\7\:SEb \8\:SEb) resistor r=0.5361 c=0
Rk11 (\14\:qbint \16\:qbint) resistor r=0.5538 c=0
Rk12 (\16\:qbint \17\:qbint) resistor r=0.3345 c=0
Rk13 (\17\:qbint \18\:qbint) resistor r=0.1552 c=0
Rk14 (\17\:qbint \20\:qbint) resistor r=0.2018 c=0
Rk15 (\5\:n30 \7\:n30) resistor r=0.3646 c=0
Rk16 (\7\:n30 \8\:n30) resistor r=0.5728 c=0
Rk17 (\4\:mout \5\:mout) resistor r=0.446 c=0
Rk18 (\5\:mout \7\:mout) resistor r=0.1184 c=0
Rk19 (\5\:mout \9\:mout) resistor r=0.2102 c=0
Rk21 (\6\:n20 \7\:n20) resistor r=0.2635 c=0
Rk22 (\7\:n20 \8\:n20) resistor r=0.5678 c=0
Rk23 (\7\:n20 \10\:n20) resistor r=0.1905 c=0
Rk41 (\2\:Db_2 \3\:Db_2) resistor r=0.5936 c=0
Rk42 (\3\:Db_2 \5\:Db_2) resistor r=0.296 c=0
Rk43 (\3\:Db_2 \7\:Db_2) resistor r=0.2041 c=0
Rk44 (\5\:Db_2 \9\:Db_2) resistor r=0.4339 c=0
Rk94 (\9\:qint_2 \10\:qint_2) resistor r=0.1061 c=0
Rk95 (\10\:qint_2 \12\:qint_2) resistor r=0.1182 c=0
Rk96 (\10\:qint_2 \13\:qint_2) resistor r=0.1393 c=0
Rk45 (\2\:n6_2 \4\:n6_2) resistor r=0.2213 c=0
Rk38 (\4\:SEb_2 \6\:SEb_2) resistor r=0.5376 c=0
Rk39 (\6\:SEb_2 \8\:SEb_2) resistor r=0.4067 c=0
Rk85 (\14\:qbint_2 \15\:qbint_2) resistor r=0.1552 c=0
Rk86 (\15\:qbint_2 \17\:qbint_2) resistor r=0.3345 c=0
Rk87 (\17\:qbint_2 \18\:qbint_2) resistor r=0.5534 c=0
Rk88 (\15\:qbint_2 \20\:qbint_2) resistor r=0.1976 c=0
Rk52 (\5\:n30_2 \7\:n30_2) resistor r=0.3653 c=0
Rk53 (\7\:n30_2 \8\:n30_2) resistor r=0.5759 c=0
Rk49 (\5\:mout_2 \6\:mout_2) resistor r=0.2398 c=0
Rk50 (\6\:mout_2 \7\:mout_2) resistor r=0.446 c=0
Rk51 (\6\:mout_2 \9\:mout_2) resistor r=0.1184 c=0
Rk46 (\5\:n20_2 \6\:n20_2) resistor r=0.5678 c=0
Rk47 (\6\:n20_2 \8\:n20_2) resistor r=0.2612 c=0
Rk48 (\6\:n20_2 \10\:n20_2) resistor r=0.1905 c=0
Rl38 (\1\:D1 \2\:D1) resistor r=91.5405 c=0
Rl39 (\2\:D1 \3\:D1) resistor r=35.7713 c=0
Rl51 (\1\:CK \2\:CK) resistor r=24.2328 c=0
Rl52 (\2\:CK \3\:CK) resistor r=58.8482 c=0
Rl61 (\13\:SE \14\:SE) resistor r=52.6149 c=0
Rl58 (\11\:SE \12\:SE) resistor r=33.3841 c=0
Rl53 (\8\:SE \9\:SE) resistor r=54.5379 c=0
Rl54 (\9\:SE \10\:SE) resistor r=41.0764 c=0
Rl46 (\5\:SE \6\:SE) resistor r=54.5379 c=0
Rl47 (\6\:SE \7\:SE) resistor r=41.0764 c=0
Rl43 (\3\:SE \4\:SE) resistor r=33.3841 c=0
Rl40 (\1\:SE \2\:SE) resistor r=52.6149 c=0
Rl45 (\2\:SI \3\:SI) resistor r=89.1533 c=0
Rl44 (\1\:SI \2\:SI) resistor r=41.0764 c=0
Rl57 (\11\:Q1 \10\:Q1) resistor r=87.2302 c=0
Rl56 (\9\:Q1 \10\:Q1) resistor r=89.1533 c=0
Rl55 (\9\:Q1 \8\:Q1) resistor r=41.0764 c=0
Rl71 (\9\:RN \10\:RN) resistor r=147.643 c=0
Rl30 (\5\:RN \6\:RN) resistor r=147.643 c=0
Rl83 (\13\:RN \14\:RN) resistor r=29.5379 c=0
Rl82 (\12\:RN \13\:RN) resistor r=37.6944 c=0
Rl81 (\11\:RN \12\:RN) resistor r=47.3097 c=0
Rl70 (\8\:RN \9\:RN) resistor r=52.6149 c=0
Rl31 (\6\:RN \7\:RN) resistor r=52.6149 c=0
Rl19 (\2\:RN \3\:RN) resistor r=37.6944 c=0
Rl18 (\1\:RN \2\:RN) resistor r=47.3097 c=0
Rl20 (\3\:RN \4\:RN) resistor r=29.5379 c=0
Rl62 (\1\:D2 \2\:D2) resistor r=91.5405 c=0
Rl63 (\2\:D2 \3\:D2) resistor r=35.7713 c=0
Rl76 (\12\:Ckbb \13\:Ckbb) resistor r=183.747 c=0
Rl25 (\2\:Ckbb \3\:Ckbb) resistor r=183.747 c=0
Rl77 (\13\:Ckbb \14\:Ckbb) resistor r=62.6944 c=0
Rl67 (\10\:Ckbb \11\:Ckbb) resistor r=62.6944 c=0
Rl64 (\8\:Ckbb \9\:Ckbb) resistor r=230.67 c=0
Rl37 (\6\:Ckbb \7\:Ckbb) resistor r=230.67 c=0
Rl34 (\4\:Ckbb \5\:Ckbb) resistor r=62.6944 c=0
Rl24 (Ckbb \2\:Ckbb) resistor r=62.6944 c=0
Rl65 (\12\:CKb \13\:CKb) resistor r=109.983 c=0
Rl36 (\6\:CKb \7\:CKb) resistor r=109.983 c=0
Rl78 (\17\:CKb \18\:CKb) resistor r=31.9251 c=0
Rl75 (\15\:CKb \16\:CKb) resistor r=24.2328 c=0
Rl66 (\13\:CKb \14\:CKb) resistor r=32.9066 c=0
Rl35 (\5\:CKb \6\:CKb) resistor r=33.8727 c=0
Rl26 (\3\:CKb \4\:CKb) resistor r=24.2328 c=0
Rl23 (CKb \2\:CKb) resistor r=31.9251 c=0
Rl50 (\9\:CKb \11\:CKb) resistor r=64.2642 c=0
Rl49 (\9\:CKb \10\:CKb) resistor r=37.3411 c=0
Rl48 (\8\:CKb \9\:CKb) resistor r=1.2334 c=0
Rl5 (qint \6\:qint) resistor r=6.6351 c=0
Rl41 (SEb \2\:SEb) resistor r=26.9231 c=0
Rl42 (\2\:SEb \3\:SEb) resistor r=148.376 c=0
Rl21 (\12\:qbint \11\:qbint) resistor r=62.2302 c=0
Rl22 (\12\:qbint \13\:qbint) resistor r=39.1533 c=0
Rl12 (qbint \7\:qbint) resistor r=5.8198 c=0
Rl9 (\4\:qbint qbint) resistor r=145.471 c=0
Rl15 (\4\:qbint \10\:qbint) resistor r=37.6951 c=0
Rl10 (\4\:qbint \5\:qbint) resistor r=51.1566 c=0
Rl17 (\2\:n30 \3\:n30) resistor r=44.9638 c=0
Rl16 (n30 \2\:n30) resistor r=49.9532 c=0
Rl32 (mout \2\:mout) resistor r=72.3097 c=0
Rl33 (\2\:mout \3\:mout) resistor r=26.1559 c=0
Rl29 (\2\:n20 \4\:n20) resistor r=36.2526 c=0
Rl28 (\2\:n20 \3\:n20) resistor r=82.4064 c=0
Rl27 (n20 \2\:n20) resistor r=2.7713 c=0
Rl97 (qint_2 \4\:qint_2) resistor r=6.6351 c=0
Rl60 (\2\:SEb_2 \3\:SEb_2) resistor r=26.3736 c=0
Rl59 (SEb_2 \2\:SEb_2) resistor r=147.512 c=0
Rl79 (\2\:qbint_2 qbint_2) resistor r=62.2302 c=0
Rl80 (\2\:qbint_2 \3\:qbint_2) resistor r=39.1533 c=0
Rl86 (\5\:qbint_2 \4\:qbint_2) resistor r=37.6951 c=0
Rl90 (\5\:qbint_2 \9\:qbint_2) resistor r=51.1566 c=0
Rl89 (\6\:qbint_2 \8\:qbint_2) resistor r=5.8198 c=0
Rl87 (\6\:qbint_2 \5\:qbint_2) resistor r=145.471 c=0
Rl84 (n30_2 \2\:n30_2) resistor r=44.1006 c=0
Rl85 (\2\:n30_2 \3\:n30_2) resistor r=49.8142 c=0
Rl68 (mout_2 \2\:mout_2) resistor r=72.3097 c=0
Rl69 (\2\:mout_2 \3\:mout_2) resistor r=26.1559 c=0
Rl72 (n20_2 \2\:n20_2) resistor r=36.2526 c=0
Rl74 (\2\:n20_2 \4\:n20_2) resistor r=82.4064 c=0
Rl73 (\2\:n20_2 \3\:n20_2) resistor r=2.7666 c=0
Rz1 (\2\:Q1N \1\:Q1N) resistor r=75 c=0
Rz21 (\2\:Q2 \1\:Q2) resistor r=75 c=0
Rz33 (\29\:VSS \28\:VSS) resistor r=75 c=0
Rz34 (\31\:VSS \30\:VSS) resistor r=75 c=0
Rz35 (\33\:VSS \32\:VSS) resistor r=75 c=0
Rz36 (\35\:VSS \34\:VSS) resistor r=75 c=0
Rz37 (\37\:VSS \36\:VSS) resistor r=75 c=0
Rz38 (\39\:VSS \38\:VSS) resistor r=75 c=0
Rz39 (\41\:VSS \40\:VSS) resistor r=75 c=0
Rz40 (\43\:VSS \42\:VSS) resistor r=75 c=0
Rz41 (\45\:VSS \44\:VSS) resistor r=75 c=0
Rz3 (\3\:Q1 \2\:Q1) resistor r=75 c=0
Rz23 (\2\:Q2N \1\:Q2N) resistor r=75 c=0
Rz24 (\5\:VDD \4\:VDD) resistor r=6.25 c=0
Rz25 (\22\:VDD \4\:VDD) resistor r=6.25 c=0
Rz26 (\29\:VDD \4\:VDD) resistor r=6.25 c=0
Rz27 (\38\:VDD \4\:VDD) resistor r=6.25 c=0
Rz28 (\48\:VDD \4\:VDD) resistor r=6.25 c=0
Rz11 (\15\:Ckbb \16\:Ckbb) resistor r=75 c=0
Rz19 (\15\:Ckbb \22\:Ckbb) resistor r=37.5 c=0
Rz18 (\29\:CKb \30\:CKb) resistor r=75 c=0
Rz8 (\6\:Db \7\:Db) resistor r=75 c=0
Rz9 (\8\:Db \9\:Db) resistor r=75 c=0
Rz2 (\13\:qint \12\:qint) resistor r=75 c=0
Rz10 (\4\:SEb \5\:SEb) resistor r=75 c=0
Rz4 (\20\:qbint \19\:qbint) resistor r=75 c=0
Rz5 (\6\:n30 \7\:n30) resistor r=75 c=0
Rz6 (\6\:mout \7\:mout) resistor r=75 c=0
Rz7 (\9\:n20 \10\:n20) resistor r=75 c=0
Rz13 (Db_2 \2\:Db_2) resistor r=75 c=0
Rz14 (\8\:Db_2 \9\:Db_2) resistor r=75 c=0
Rz22 (\12\:qint_2 \11\:qint_2) resistor r=75 c=0
Rz12 (\7\:SEb_2 \8\:SEb_2) resistor r=75 c=0
Rz20 (\20\:qbint_2 \19\:qbint_2) resistor r=75 c=0
Rz17 (\6\:n30_2 \7\:n30_2) resistor r=75 c=0
Rz16 (\8\:mout_2 \9\:mout_2) resistor r=75 c=0
Rz15 (\9\:n20_2 \10\:n20_2) resistor r=75 c=0
Ry1 (\4\:Q1N \3\:Q1N) resistor r=31 c=0
Ry25 (\6\:Q2 \5\:Q2) resistor r=31 c=0
Ry47 (\5\:VSS \4\:VSS) resistor r=5.1667 c=0
Ry48 (\11\:VSS \4\:VSS) resistor r=5.1667 c=0
Ry49 (\14\:VSS \4\:VSS) resistor r=5.1667 c=0
Ry50 (\17\:VSS \4\:VSS) resistor r=5.1667 c=0
Ry51 (\20\:VSS \4\:VSS) resistor r=5.1667 c=0
Ry3 (\7\:Q1 \6\:Q1) resistor r=31 c=0
Ry14 (\13\:Q1 \6\:Q1) resistor r=62 c=0
Ry27 (\4\:Q2N \3\:Q2N) resistor r=31 c=0
Ry32 (\15\:VDD \14\:VDD) resistor r=62 c=0
Ry33 (\18\:VDD \17\:VDD) resistor r=62 c=0
Ry34 (\21\:VDD \20\:VDD) resistor r=62 c=0
Ry35 (\25\:VDD \24\:VDD) resistor r=62 c=0
Ry36 (\28\:VDD \27\:VDD) resistor r=62 c=0
Ry37 (\31\:VDD \30\:VDD) resistor r=62 c=0
Ry38 (\34\:VDD \33\:VDD) resistor r=62 c=0
Ry39 (\37\:VDD \36\:VDD) resistor r=62 c=0
Ry40 (\41\:VDD \40\:VDD) resistor r=62 c=0
Ry41 (\44\:VDD \43\:VDD) resistor r=62 c=0
Ry42 (\47\:VDD \46\:VDD) resistor r=62 c=0
Ry13 (\17\:Ckbb \18\:Ckbb) resistor r=62 c=0
Ry23 (\32\:CKb \33\:CKb) resistor r=62 c=0
Ry10 (Db \2\:Db) resistor r=62 c=0
Ry11 (\4\:Db \5\:Db) resistor r=62 c=0
Ry2 (\9\:qint \8\:qint) resistor r=62 c=0
Ry7 (n6 \2\:n6) resistor r=62 c=0
Ry8 (\3\:n6 \4\:n6) resistor r=62 c=0
Ry12 (\6\:SEb \7\:SEb) resistor r=62 c=0
Ry4 (\16\:qbint \15\:qbint) resistor r=62 c=0
Ry5 (\4\:n30 \5\:n30) resistor r=62 c=0
Ry6 (\8\:mout \9\:mout) resistor r=62 c=0
Ry9 (\5\:n20 \6\:n20) resistor r=62 c=0
Ry16 (\4\:Db_2 \5\:Db_2) resistor r=62 c=0
Ry17 (\6\:Db_2 \7\:Db_2) resistor r=62 c=0
Ry26 (\9\:qint_2 \8\:qint_2) resistor r=62 c=0
Ry18 (n6_2 \2\:n6_2) resistor r=62 c=0
Ry19 (\3\:n6_2 \4\:n6_2) resistor r=62 c=0
Ry15 (\5\:SEb_2 \6\:SEb_2) resistor r=62 c=0
Ry24 (\17\:qbint_2 \16\:qbint_2) resistor r=62 c=0
Ry22 (\4\:n30_2 \5\:n30_2) resistor r=62 c=0
Ry21 (\4\:mout_2 \5\:mout_2) resistor r=62 c=0
Ry20 (\7\:n20_2 \8\:n20_2) resistor r=62 c=0
Rx7 (\2\:D1 \4\:D1) resistor r=45 c=0
Rx10 (\2\:CK \4\:CK) resistor r=45 c=0
Rx28 (\14\:SE \15\:SE) resistor r=45 c=0
Rx29 (\12\:SE \16\:SE) resistor r=45 c=0
Rx30 (\4\:SE \19\:SE) resistor r=45 c=0
Rx31 (\2\:SE \20\:SE) resistor r=45 c=0
Rx32 (\9\:SE \21\:SE) resistor r=45 c=0
Rx33 (\6\:SE \22\:SE) resistor r=45 c=0
Rx8 (\2\:SI \5\:SI) resistor r=45 c=0
Rx11 (\12\:Q1 \11\:Q1) resistor r=45 c=0
Rx24 (\14\:RN \15\:RN) resistor r=45 c=0
Rx25 (\8\:RN \16\:RN) resistor r=45 c=0
Rx26 (\7\:RN \18\:RN) resistor r=45 c=0
Rx27 (\4\:RN \19\:RN) resistor r=45 c=0
Rx13 (\2\:D2 \4\:D2) resistor r=45 c=0
Rx34 (\14\:Ckbb \19\:Ckbb) resistor r=45 c=0
Rx35 (\11\:Ckbb \20\:Ckbb) resistor r=45 c=0
Rx36 (\9\:Ckbb \21\:Ckbb) resistor r=45 c=0
Rx37 (\7\:Ckbb \23\:Ckbb) resistor r=45 c=0
Rx38 (\5\:Ckbb \24\:Ckbb) resistor r=45 c=0
Rx39 (Ckbb \25\:Ckbb) resistor r=45 c=0
Rx17 (\18\:CKb \19\:CKb) resistor r=45 c=0
Rx18 (\14\:CKb \21\:CKb) resistor r=45 c=0
Rx19 (\5\:CKb \23\:CKb) resistor r=45 c=0
Rx20 (\2\:CKb \25\:CKb) resistor r=45 c=0
Rx21 (\16\:CKb \26\:CKb) resistor r=45 c=0
Rx22 (\8\:CKb \28\:CKb) resistor r=45 c=0
Rx23 (\4\:CKb \31\:CKb) resistor r=45 c=0
Rx1 (\11\:qint \6\:qint) resistor r=45 c=0
Rx9 (\2\:SEb \8\:SEb) resistor r=45 c=0
Rx2 (\14\:qbint \12\:qbint) resistor r=45 c=0
Rx3 (\18\:qbint \7\:qbint) resistor r=45 c=0
Rx4 (\2\:n30 \8\:n30) resistor r=45 c=0
Rx5 (\2\:mout \4\:mout) resistor r=45 c=0
Rx6 (n20 \8\:n20) resistor r=45 c=0
Rx42 (\13\:qint_2 \4\:qint_2) resistor r=45 c=0
Rx12 (\2\:SEb_2 \4\:SEb_2) resistor r=45 c=0
Rx40 (\14\:qbint_2 \8\:qbint_2) resistor r=45 c=0
Rx41 (\18\:qbint_2 \2\:qbint_2) resistor r=45 c=0
Rx16 (\2\:n30_2 \8\:n30_2) resistor r=45 c=0
Rx15 (\2\:mout_2 \7\:mout_2) resistor r=45 c=0
Rx14 (\3\:n20_2 \5\:n20_2) resistor r=45 c=0
NM17 (\1\:Q2 \6\:qbint_2 \5\:VSS VSS) g45n1svt w=(2.6e-07) l=4.5e-08 \
        nf=1 as=5.46e-14 ad=6.32e-14 ps=9.4e-07 pd=1.52e-06 nrd=1.16667 \
        nrs=1.16667 sa=1.2e-07 sb=3.95e-07 sd=160n sca=17.5885 \
        scb=0.0172826 scc=0.00162584 m=(2)
mn55 (\2\:Q1 qbint \20\:VSS VSS) g45n1svt w=(2.6e-07) l=4.5e-08 nf=1 \
        as=5.46e-14 ad=6.32e-14 ps=9.4e-07 pd=1.52e-06 nrd=1.16667 \
        nrs=1.16667 sa=1.2e-07 sb=3.95e-07 sd=160n sca=17.5885 \
        scb=0.0172826 scc=0.00162584 m=(2)
mn57_1__rcx (\1\:Q1N qint \22\:VSS VSS) g45n1svt w=(2.6e-07) l=4.5e-08 \
        nf=1 as=5.085e-14 ad=5.448e-14 ps=1.17e-06 pd=1.22e-06 nrd=1.16667 \
        nrs=1.16667 sa=4.56058e-07 sb=1.2e-07 sd=160n sca=17.5885 \
        scb=0.0172826 scc=0.00162584 m=(2)
NM19 (\1\:Q2N qint_2 \1\:VSS VSS) g45n1svt w=(2.6e-07) l=4.5e-08 nf=1 \
        as=5.085e-14 ad=5.448e-14 ps=1.17e-06 pd=1.22e-06 nrd=1.16667 \
        nrs=1.16667 sa=4.56058e-07 sb=1.2e-07 sd=160n sca=17.5885 \
        scb=0.0172826 scc=0.00162584 m=(2)
mn21 (\15\:Ckbb \10\:CKb \36\:VSS VSS) g45n1svt w=(1.45e-07) l=4.5e-08 \
        nf=1 as=9.332e-14 ad=6.752e-14 ps=1.56e-06 pd=1.56e-06 nrd=1.16667 \
        nrs=1.16667 sa=1.95e-07 sb=3.6e-07 sd=160n sca=19.8813 \
        scb=0.0206549 scc=0.00197265 m=(1)
mn20 (\29\:CKb \3\:CK \36\:VSS VSS) g45n1svt w=(1.45e-07) l=4.5e-08 nf=1 \
        as=2.03e-14 ad=6.752e-14 ps=5.7e-07 pd=1.56e-06 nrd=1.16667 \
        nrs=1.16667 sa=4.15e-07 sb=1.4e-07 sd=160n sca=19.8813 \
        scb=0.0206549 scc=0.00197265 m=(1)
NM18 (\11\:qint_2 \9\:qbint_2 \1\:VSS VSS) g45n1svt w=(1.45e-07) \
        l=4.5e-08 nf=1 as=6.735e-14 ad=2.03e-14 ps=1.6e-06 pd=5.7e-07 \
        nrd=1.16667 nrs=1.16667 sa=1.4e-07 sb=5.4e-07 sd=160n sca=23.279 \
        scb=0.0230742 scc=0.00267719 m=(1)
NM15 (n11_2 \3\:qbint_2 \28\:VSS VSS) g45n1svt w=(1.45e-07) l=4.5e-08 \
        nf=1 as=1.957e-14 ad=8.05e-14 ps=5.6e-07 pd=1.49e-06 nrd=1.16667 \
        nrs=1.16667 sa=5.75e-07 sb=1.645e-06 sd=160n sca=15.7071 \
        scb=0.0167369 scc=0.00113434 m=(1)
NM16 (\6\:n30_2 \17\:CKb n11_2 VSS) g45n1svt w=(1.45e-07) l=4.5e-08 nf=1 \
        as=1.957e-14 ad=2.9e-14 ps=5.6e-07 pd=6.9e-07 nrd=1.16667 \
        nrs=1.16667 sa=1.465e-06 sb=7.55e-07 sd=160n sca=15.7071 \
        scb=0.0167369 scc=0.00113434 m=(1)
NM12 (\8\:mout_2 \13\:Ckbb \6\:n30_2 VSS) g45n1svt w=(1.45e-07) l=4.5e-08 \
        nf=1 as=3.335e-14 ad=2.9e-14 ps=7.5e-07 pd=6.9e-07 nrd=1.16667 \
        nrs=1.16667 sa=1e-06 sb=1.22e-06 sd=160n sca=15.7071 scb=0.0167369 \
        scc=0.00113434 m=(1)
NM8 (\8\:mout_2 \4\:n20_2 \30\:VSS VSS) g45n1svt w=(1.45e-07) l=4.5e-08 \
        nf=1 as=8.475e-14 ad=3.335e-14 ps=1.59e-06 pd=7.5e-07 nrd=1.16667 \
        nrs=1.16667 sa=9.45e-07 sb=1.275e-06 sd=160n sca=15.7071 \
        scb=0.0167369 scc=0.00113434 m=(1)
NM10 (n7_2 \10\:RN \30\:VSS VSS) g45n1svt w=(1.45e-07) l=4.5e-08 nf=1 \
        as=8.475e-14 ad=8.7e-15 ps=1.59e-06 pd=4.1e-07 nrd=1.16667 \
        nrs=1.16667 sa=6.3e-07 sb=1.59e-06 sd=160n sca=15.7071 \
        scb=0.0167369 scc=0.00113434 m=(1)
NM11 (n5_2 \3\:mout_2 n7_2 VSS) g45n1svt w=(1.45e-07) l=4.5e-08 nf=1 \
        as=8.7e-15 ad=1.957e-14 ps=4.1e-07 pd=5.6e-07 nrd=1.16667 \
        nrs=1.16667 sa=5.25e-07 sb=1.695e-06 sd=160n sca=15.7071 \
        scb=0.0167369 scc=0.00113434 m=(1)
NM9 (\9\:n20_2 \10\:Ckbb n5_2 VSS) g45n1svt w=(1.45e-07) l=4.5e-08 nf=1 \
        as=2.32e-14 ad=1.957e-14 ps=6.1e-07 pd=5.6e-07 nrd=1.16667 \
        nrs=1.16667 sa=1.875e-06 sb=3.45e-07 sd=160n sca=15.7071 \
        scb=0.0167369 scc=0.00113434 m=(1)
NM7 (\8\:Db_2 \12\:CKb \9\:n20_2 VSS) g45n1svt w=(1.45e-07) l=4.5e-08 \
        nf=1 as=2.32e-14 ad=2.03e-14 ps=6.1e-07 pd=5.7e-07 nrd=1.16667 \
        nrs=1.16667 sa=1.4e-07 sb=2e-06 sd=160n sca=15.7071 scb=0.0167369 \
        scc=0.00113434 m=(1)
NM1 (n1_2 \3\:D2 \32\:VSS VSS) g45n1svt w=(1.45e-07) l=4.5e-08 nf=1 \
        as=5.027e-14 ad=2.03e-14 ps=1.33e-06 pd=5.7e-07 nrd=1.16667 \
        nrs=1.16667 sa=8.86379e-07 sb=1.25e-07 sd=160n sca=12.9138 \
        scb=0.0133404 scc=0.000640143 m=(1)
NM2 (Db_2 SEb_2 n1_2 VSS) g45n1svt w=(1.45e-07) l=4.5e-08 nf=1 \
        as=3.77e-14 ad=2.03e-14 ps=8.1e-07 pd=5.7e-07 nrd=1.16667 \
        nrs=1.16667 sa=3.1e-07 sb=7.01379e-07 sd=160n sca=12.9138 \
        scb=0.0133404 scc=0.000640143 m=(1)
NM3 (Db_2 \11\:SE n3_2 VSS) g45n1svt w=(1.45e-07) l=4.5e-08 nf=1 \
        as=8.7e-15 ad=3.77e-14 ps=4.1e-07 pd=8.1e-07 nrd=1.16667 \
        nrs=1.16667 sa=3.96379e-07 sb=6.15e-07 sd=160n sca=12.9138 \
        scb=0.0133404 scc=0.000640143 m=(1)
NM4 (n3_2 \8\:Q1 \34\:VSS VSS) g45n1svt w=(1.45e-07) l=4.5e-08 nf=1 \
        as=7.87e-14 ad=8.7e-15 ps=1.6e-06 pd=4.1e-07 nrd=1.16667 \
        nrs=1.16667 sa=2.91379e-07 sb=7.2e-07 sd=160n sca=12.9138 \
        scb=0.0133404 scc=0.000640143 m=(1)
NM0 (\7\:SEb_2 \10\:SE \34\:VSS VSS) g45n1svt w=(1.45e-07) l=4.5e-08 \
        nf=1 as=3.262e-14 ad=7.87e-14 ps=7.4e-07 pd=1.6e-06 nrd=1.16667 \
        nrs=1.16667 sa=4.41897e-07 sb=2.25e-07 sd=160n sca=23.279 \
        scb=0.0230742 scc=0.00267719 m=(1)
mn56 (\12\:qint \5\:qbint \22\:VSS VSS) g45n1svt w=(1.45e-07) l=4.5e-08 \
        nf=1 as=6.735e-14 ad=2.03e-14 ps=1.6e-06 pd=5.7e-07 nrd=1.16667 \
        nrs=1.16667 sa=1.4e-07 sb=5.4e-07 sd=160n sca=23.279 scb=0.0230742 \
        scc=0.00267719 m=(1)
mn50 (n11 \13\:qbint \44\:VSS VSS) g45n1svt w=(1.45e-07) l=4.5e-08 nf=1 \
        as=1.957e-14 ad=8.05e-14 ps=5.6e-07 pd=1.49e-06 nrd=1.16667 \
        nrs=1.16667 sa=5.75e-07 sb=1.645e-06 sd=160n sca=15.7071 \
        scb=0.0167369 scc=0.00113434 m=(1)
mn51 (\6\:n30 CKb n11 VSS) g45n1svt w=(1.45e-07) l=4.5e-08 nf=1 \
        as=1.957e-14 ad=2.9e-14 ps=5.6e-07 pd=6.9e-07 nrd=1.16667 \
        nrs=1.16667 sa=1.465e-06 sb=7.55e-07 sd=160n sca=15.7071 \
        scb=0.0167369 scc=0.00113434 m=(1)
mn40 (\6\:mout \2\:Ckbb \6\:n30 VSS) g45n1svt w=(1.45e-07) l=4.5e-08 nf=1 \
        as=3.335e-14 ad=2.9e-14 ps=7.5e-07 pd=6.9e-07 nrd=1.16667 \
        nrs=1.16667 sa=1e-06 sb=1.22e-06 sd=160n sca=15.7071 scb=0.0167369 \
        scc=0.00113434 m=(1)
mn30 (\6\:mout \3\:n20 \42\:VSS VSS) g45n1svt w=(1.45e-07) l=4.5e-08 \
        nf=1 as=8.475e-14 ad=3.335e-14 ps=1.59e-06 pd=7.5e-07 nrd=1.16667 \
        nrs=1.16667 sa=9.45e-07 sb=1.275e-06 sd=160n sca=15.7071 \
        scb=0.0167369 scc=0.00113434 m=(1)
mn35 (n7 \5\:RN \42\:VSS VSS) g45n1svt w=(1.45e-07) l=4.5e-08 nf=1 \
        as=8.475e-14 ad=8.7e-15 ps=1.59e-06 pd=4.1e-07 nrd=1.16667 \
        nrs=1.16667 sa=6.3e-07 sb=1.59e-06 sd=160n sca=15.7071 \
        scb=0.0167369 scc=0.00113434 m=(1)
mn36 (n5 \3\:mout n7 VSS) g45n1svt w=(1.45e-07) l=4.5e-08 nf=1 as=8.7e-15 \
        ad=1.957e-14 ps=4.1e-07 pd=5.6e-07 nrd=1.16667 nrs=1.16667 \
        sa=5.25e-07 sb=1.695e-06 sd=160n sca=15.7071 scb=0.0167369 \
        scc=0.00113434 m=(1)
mn37 (\9\:n20 \4\:Ckbb n5 VSS) g45n1svt w=(1.45e-07) l=4.5e-08 nf=1 \
        as=2.32e-14 ad=1.957e-14 ps=6.1e-07 pd=5.6e-07 nrd=1.16667 \
        nrs=1.16667 sa=1.875e-06 sb=3.45e-07 sd=160n sca=15.7071 \
        scb=0.0167369 scc=0.00113434 m=(1)
mn25 (\8\:Db \7\:CKb \9\:n20 VSS) g45n1svt w=(1.45e-07) l=4.5e-08 nf=1 \
        as=2.32e-14 ad=2.03e-14 ps=6.1e-07 pd=5.7e-07 nrd=1.16667 \
        nrs=1.16667 sa=1.4e-07 sb=2e-06 sd=160n sca=15.7071 scb=0.0167369 \
        scc=0.00113434 m=(1)
mn11 (n1 \3\:D1 \40\:VSS VSS) g45n1svt w=(1.45e-07) l=4.5e-08 nf=1 \
        as=5.027e-14 ad=2.03e-14 ps=1.33e-06 pd=5.7e-07 nrd=1.16667 \
        nrs=1.16667 sa=8.86379e-07 sb=1.25e-07 sd=160n sca=12.9138 \
        scb=0.0133404 scc=0.000640143 m=(1)
mn12 (\6\:Db \3\:SEb n1 VSS) g45n1svt w=(1.45e-07) l=4.5e-08 nf=1 \
        as=3.77e-14 ad=2.03e-14 ps=8.1e-07 pd=5.7e-07 nrd=1.16667 \
        nrs=1.16667 sa=3.1e-07 sb=7.01379e-07 sd=160n sca=12.9138 \
        scb=0.0133404 scc=0.000640143 m=(1)
mn14 (\6\:Db \3\:SE n3 VSS) g45n1svt w=(1.45e-07) l=4.5e-08 nf=1 \
        as=8.7e-15 ad=3.77e-14 ps=4.1e-07 pd=8.1e-07 nrd=1.16667 \
        nrs=1.16667 sa=3.96379e-07 sb=6.15e-07 sd=160n sca=12.9138 \
        scb=0.0133404 scc=0.000640143 m=(1)
mn13 (n3 \1\:SI \38\:VSS VSS) g45n1svt w=(1.45e-07) l=4.5e-08 nf=1 \
        as=7.87e-14 ad=8.7e-15 ps=1.6e-06 pd=4.1e-07 nrd=1.16667 \
        nrs=1.16667 sa=2.91379e-07 sb=7.2e-07 sd=160n sca=12.9138 \
        scb=0.0133404 scc=0.000640143 m=(1)
mn10 (\4\:SEb \7\:SE \38\:VSS VSS) g45n1svt w=(1.45e-07) l=4.5e-08 nf=1 \
        as=3.262e-14 ad=7.87e-14 ps=7.4e-07 pd=1.6e-06 nrd=1.16667 \
        nrs=1.16667 sa=4.41897e-07 sb=2.25e-07 sd=160n sca=23.279 \
        scb=0.0230742 scc=0.00267719 m=(1)
NM13 (\19\:qbint_2 \3\:n30_2 n9_2 VSS) g45n1svt w=(2.05e-07) l=4.5e-08 \
        nf=1 as=2.05e-14 ad=3.383e-14 ps=6.1e-07 pd=7.4e-07 nrd=1.16667 \
        nrs=1.16667 sa=1.50683e-06 sb=1.65e-07 sd=160n sca=13.8179 \
        scb=0.0141903 scc=0.000851218 m=(1)
NM14 (n9_2 \11\:RN \28\:VSS VSS) g45n1svt w=(2.05e-07) l=4.5e-08 nf=1 \
        as=8.05e-14 ad=2.05e-14 ps=1.49e-06 pd=6.1e-07 nrd=1.16667 \
        nrs=1.16667 sa=1.40073e-06 sb=3.1e-07 sd=160n sca=13.8179 \
        scb=0.0141903 scc=0.000851218 m=(1)
mn46 (\19\:qbint n30 n9 VSS) g45n1svt w=(2.05e-07) l=4.5e-08 nf=1 \
        as=2.05e-14 ad=3.383e-14 ps=6.1e-07 pd=7.4e-07 nrd=1.16667 \
        nrs=1.16667 sa=1.50683e-06 sb=1.65e-07 sd=160n sca=13.8179 \
        scb=0.0141903 scc=0.000851218 m=(1)
mn45 (n9 \1\:RN \44\:VSS VSS) g45n1svt w=(2.05e-07) l=4.5e-08 nf=1 \
        as=8.05e-14 ad=2.05e-14 ps=1.49e-06 pd=6.1e-07 nrd=1.16667 \
        nrs=1.16667 sa=1.40073e-06 sb=3.1e-07 sd=160n sca=13.8179 \
        scb=0.0141903 scc=0.000851218 m=(1)
mp21 (\17\:Ckbb \11\:CKb \30\:VDD VDD) g45p1svt w=(2.15e-07) l=4.5e-08 \
        nf=1 as=3.01e-14 ad=8.732e-14 ps=7.1e-07 pd=1.85e-06 nrd=1.16667 \
        nrs=1.16667 sa=1.4e-07 sb=3.6e-07 sd=160n sca=31.508 scb=0.0252524 \
        scc=0.00399199 m=(1)
mp20 (\32\:CKb \1\:CK \30\:VDD VDD) g45p1svt w=(2.15e-07) l=4.5e-08 nf=1 \
        as=3.01e-14 ad=8.732e-14 ps=7.1e-07 pd=1.85e-06 nrd=1.16667 \
        nrs=1.16667 sa=3.6e-07 sb=1.4e-07 sd=160n sca=31.508 scb=0.0252524 \
        scc=0.00399199 m=(1)
PM18 (\8\:qint_2 \4\:qbint_2 \1\:VDD VDD) g45p1svt w=(2.15e-07) \
        l=4.5e-08 nf=1 as=3.01e-14 ad=1.0092e-13 ps=7.1e-07 pd=1.97e-06 \
        nrd=1.16667 nrs=1.16667 sa=5.4e-07 sb=1.4e-07 sd=160n sca=46.1789 \
        scb=0.0284493 scc=0.00588419 m=(1)
PM15 (n8_2 qbint_2 \14\:VDD VDD) g45p1svt w=(2.15e-07) l=4.5e-08 nf=1 \
        as=3.01e-14 ad=1.1192e-13 ps=7.1e-07 pd=1.9e-06 nrd=1.16667 \
        nrs=1.16667 sa=1.235e-06 sb=1.22e-06 sd=160n sca=29.9075 \
        scb=0.0247057 scc=0.00372713 m=(1)
PM16 (\4\:n30_2 \12\:Ckbb n8_2 VDD) g45p1svt w=(2.15e-07) l=4.5e-08 nf=1 \
        as=3.01e-14 ad=5.375e-14 ps=7.1e-07 pd=9.3e-07 nrd=1.16667 \
        nrs=1.16667 sa=1.035e-06 sb=1.42e-06 sd=160n sca=29.9075 \
        scb=0.0247057 scc=0.00372713 m=(1)
PM12 (\4\:n30_2 \15\:CKb \4\:mout_2 VDD) g45p1svt w=(2.15e-07) l=4.5e-08 \
        nf=1 as=3.762e-14 ad=5.375e-14 ps=7.8e-07 pd=9.3e-07 nrd=1.16667 \
        nrs=1.16667 sa=7.4e-07 sb=1.715e-06 sd=160n sca=29.9075 \
        scb=0.0247057 scc=0.00372713 m=(1)
PM8 (\4\:mout_2 n20_2 \17\:VDD VDD) g45p1svt w=(2.15e-07) l=4.5e-08 nf=1 \
        as=8.415e-14 ad=3.762e-14 ps=1.83e-06 pd=7.8e-07 nrd=1.16667 \
        nrs=1.16667 sa=5.2e-07 sb=1.935e-06 sd=160n sca=29.9075 \
        scb=0.0247057 scc=0.00372713 m=(1)
PM9 (n6_2 \9\:RN \17\:VDD VDD) g45p1svt w=(2.15e-07) l=4.5e-08 nf=1 \
        as=8.415e-14 ad=3.44e-14 ps=1.83e-06 pd=7.5e-07 nrd=1.16667 \
        nrs=1.16667 sa=3.05e-07 sb=2e-06 sd=160n sca=29.9075 scb=0.0247057 \
        scc=0.00372713 m=(1)
PM11 (n6_2 mout_2 \20\:VDD VDD) g45p1svt w=(2.15e-07) l=4.5e-08 nf=1 \
        as=6.29e-14 ad=3.44e-14 ps=1.83e-06 pd=7.5e-07 nrd=1.16667 \
        nrs=1.16667 sa=1e-07 sb=2e-06 sd=160n sca=29.9075 scb=0.0247057 \
        scc=0.00372713 m=(1)
PM10 (\7\:n20_2 \13\:CKb \3\:n6_2 VDD) g45p1svt w=(2.15e-07) l=4.5e-08 \
        nf=1 as=3.44e-14 ad=3.01e-14 ps=7.5e-07 pd=7.1e-07 nrd=1.16667 \
        nrs=1.16667 sa=1.4e-07 sb=3.31047e-07 sd=160n sca=45.7906 \
        scb=0.0283307 scc=0.00588417 m=(1)
PM7 (\7\:n20_2 \8\:Ckbb \4\:Db_2 VDD) g45p1svt w=(2.15e-07) l=4.5e-08 \
        nf=1 as=2.71e-14 ad=3.44e-14 ps=7.1e-07 pd=7.5e-07 nrd=1.16667 \
        nrs=1.16667 sa=1.26047e-07 sb=3.45e-07 sd=160n sca=45.7906 \
        scb=0.0283307 scc=0.00588417 m=(1)
PM1 (n2_2 \1\:D2 \24\:VDD VDD) g45p1svt w=(2.15e-07) l=4.5e-08 nf=1 \
        as=3.87e-14 ad=7.07e-14 ps=7.9e-07 pd=1.71e-06 nrd=1.16667 \
        nrs=1.16667 sa=1.10465e-07 sb=1e-06 sd=160n sca=21.1782 \
        scb=0.0203295 scc=0.00208843 m=(1)
PM2 (\6\:Db_2 \13\:SE n2_2 VDD) g45p1svt w=(2.15e-07) l=4.5e-08 nf=1 \
        as=3.87e-14 ad=3.44e-14 ps=7.9e-07 pd=7.5e-07 nrd=1.16667 \
        nrs=1.16667 sa=7.75e-07 sb=3.35465e-07 sd=160n sca=21.1782 \
        scb=0.0203295 scc=0.00208843 m=(1)
PM4 (\6\:Db_2 \3\:SEb_2 n4_2 VDD) g45p1svt w=(2.15e-07) l=4.5e-08 nf=1 \
        as=2.58e-14 ad=3.44e-14 ps=6.7e-07 pd=7.5e-07 nrd=1.16667 \
        nrs=1.16667 sa=5.7e-07 sb=5.40465e-07 sd=160n sca=21.1782 \
        scb=0.0203295 scc=0.00208843 m=(1)
PM3 (n4_2 \10\:Q1 \27\:VDD VDD) g45p1svt w=(2.15e-07) l=4.5e-08 nf=1 \
        as=1.001e-13 ad=2.58e-14 ps=1.75e-06 pd=6.7e-07 nrd=1.16667 \
        nrs=1.16667 sa=4.05e-07 sb=7.05465e-07 sd=160n sca=21.1782 \
        scb=0.0203295 scc=0.00208843 m=(1)
PM0 (\5\:SEb_2 \8\:SE \27\:VDD VDD) g45p1svt w=(2.15e-07) l=4.5e-08 nf=1 \
        as=3.01e-14 ad=1.001e-13 ps=7.1e-07 pd=1.75e-06 nrd=1.16667 \
        nrs=1.16667 sa=9.70465e-07 sb=1.4e-07 sd=160n sca=21.1782 \
        scb=0.0203295 scc=0.00208843 m=(1)
mp56 (\8\:qint \10\:qbint \54\:VDD VDD) g45p1svt w=(2.15e-07) l=4.5e-08 \
        nf=1 as=3.01e-14 ad=1.0092e-13 ps=7.1e-07 pd=1.97e-06 nrd=1.16667 \
        nrs=1.16667 sa=5.4e-07 sb=1.4e-07 sd=160n sca=46.1789 \
        scb=0.0284493 scc=0.00588419 m=(1)
mp50 (n8 \11\:qbint \46\:VDD VDD) g45p1svt w=(2.15e-07) l=4.5e-08 nf=1 \
        as=3.01e-14 ad=1.1192e-13 ps=7.1e-07 pd=1.9e-06 nrd=1.16667 \
        nrs=1.16667 sa=1.235e-06 sb=1.22e-06 sd=160n sca=29.9075 \
        scb=0.0247057 scc=0.00372713 m=(1)
mp51 (\4\:n30 \3\:Ckbb n8 VDD) g45p1svt w=(2.15e-07) l=4.5e-08 nf=1 \
        as=3.01e-14 ad=5.375e-14 ps=7.1e-07 pd=9.3e-07 nrd=1.16667 \
        nrs=1.16667 sa=1.035e-06 sb=1.42e-06 sd=160n sca=29.9075 \
        scb=0.0247057 scc=0.00372713 m=(1)
mp40 (\4\:n30 \3\:CKb \8\:mout VDD) g45p1svt w=(2.15e-07) l=4.5e-08 nf=1 \
        as=3.762e-14 ad=5.375e-14 ps=7.8e-07 pd=9.3e-07 nrd=1.16667 \
        nrs=1.16667 sa=7.4e-07 sb=1.715e-06 sd=160n sca=29.9075 \
        scb=0.0247057 scc=0.00372713 m=(1)
mp30 (\8\:mout \4\:n20 \43\:VDD VDD) g45p1svt w=(2.15e-07) l=4.5e-08 \
        nf=1 as=8.415e-14 ad=3.762e-14 ps=1.83e-06 pd=7.8e-07 nrd=1.16667 \
        nrs=1.16667 sa=5.2e-07 sb=1.935e-06 sd=160n sca=29.9075 \
        scb=0.0247057 scc=0.00372713 m=(1)
mp35 (\3\:n6 \6\:RN \43\:VDD VDD) g45p1svt w=(2.15e-07) l=4.5e-08 nf=1 \
        as=8.415e-14 ad=3.44e-14 ps=1.83e-06 pd=7.5e-07 nrd=1.16667 \
        nrs=1.16667 sa=3.05e-07 sb=2e-06 sd=160n sca=29.9075 scb=0.0247057 \
        scc=0.00372713 m=(1)
mp36 (\3\:n6 mout \40\:VDD VDD) g45p1svt w=(2.15e-07) l=4.5e-08 nf=1 \
        as=6.29e-14 ad=3.44e-14 ps=1.83e-06 pd=7.5e-07 nrd=1.16667 \
        nrs=1.16667 sa=1e-07 sb=2e-06 sd=160n sca=29.9075 scb=0.0247057 \
        scc=0.00372713 m=(1)
mp37 (\5\:n20 \6\:CKb n6 VDD) g45p1svt w=(2.15e-07) l=4.5e-08 nf=1 \
        as=3.44e-14 ad=3.01e-14 ps=7.5e-07 pd=7.1e-07 nrd=1.16667 \
        nrs=1.16667 sa=1.4e-07 sb=3.31047e-07 sd=160n sca=45.7906 \
        scb=0.0283307 scc=0.00588417 m=(1)
mp25 (\5\:n20 \6\:Ckbb \4\:Db VDD) g45p1svt w=(2.15e-07) l=4.5e-08 nf=1 \
        as=2.71e-14 ad=3.44e-14 ps=7.1e-07 pd=7.5e-07 nrd=1.16667 \
        nrs=1.16667 sa=1.26047e-07 sb=3.45e-07 sd=160n sca=45.7906 \
        scb=0.0283307 scc=0.00588417 m=(1)
mp11 (n2 \1\:D1 \36\:VDD VDD) g45p1svt w=(2.15e-07) l=4.5e-08 nf=1 \
        as=3.87e-14 ad=7.07e-14 ps=7.9e-07 pd=1.71e-06 nrd=1.16667 \
        nrs=1.16667 sa=1.10465e-07 sb=1e-06 sd=160n sca=21.1782 \
        scb=0.0203295 scc=0.00208843 m=(1)
mp12 (Db \1\:SE n2 VDD) g45p1svt w=(2.15e-07) l=4.5e-08 nf=1 as=3.87e-14 \
        ad=3.44e-14 ps=7.9e-07 pd=7.5e-07 nrd=1.16667 nrs=1.16667 \
        sa=7.75e-07 sb=3.35465e-07 sd=160n sca=21.1782 scb=0.0203295 \
        scc=0.00208843 m=(1)
mp14 (Db SEb n4 VDD) g45p1svt w=(2.15e-07) l=4.5e-08 nf=1 as=2.58e-14 \
        ad=3.44e-14 ps=6.7e-07 pd=7.5e-07 nrd=1.16667 nrs=1.16667 \
        sa=5.7e-07 sb=5.40465e-07 sd=160n sca=21.1782 scb=0.0203295 \
        scc=0.00208843 m=(1)
mp13 (n4 \3\:SI \33\:VDD VDD) g45p1svt w=(2.15e-07) l=4.5e-08 nf=1 \
        as=1.001e-13 ad=2.58e-14 ps=1.75e-06 pd=6.7e-07 nrd=1.16667 \
        nrs=1.16667 sa=4.05e-07 sb=7.05465e-07 sd=160n sca=21.1782 \
        scb=0.0203295 scc=0.00208843 m=(1)
mp10 (\6\:SEb \5\:SE \33\:VDD VDD) g45p1svt w=(2.15e-07) l=4.5e-08 nf=1 \
        as=3.01e-14 ad=1.001e-13 ps=7.1e-07 pd=1.75e-06 nrd=1.16667 \
        nrs=1.16667 sa=9.70465e-07 sb=1.4e-07 sd=160n sca=21.1782 \
        scb=0.0203295 scc=0.00208843 m=(1)
PM14 (\16\:qbint_2 n30_2 \5\:VDD VDD) g45p1svt w=(3.1e-07) l=4.5e-08 \
        nf=1 as=1.4765e-13 ad=4.96e-14 ps=2.19e-06 pd=9.4e-07 nrd=1.16667 \
        nrs=1.16667 sa=1.28081e-06 sb=7.65e-07 sd=160n sca=35.6995 \
        scb=0.0234062 scc=0.00420468 m=(1)
PM13 (\16\:qbint_2 \13\:RN \14\:VDD VDD) g45p1svt w=(3.1e-07) l=4.5e-08 \
        nf=1 as=1.1192e-13 ad=4.96e-14 ps=1.9e-06 pd=9.4e-07 nrd=1.16667 \
        nrs=1.16667 sa=1.07581e-06 sb=9.7e-07 sd=160n sca=35.6995 \
        scb=0.0234062 scc=0.00420468 m=(1)
mp46 (\15\:qbint \3\:n30 \48\:VDD VDD) g45p1svt w=(3.1e-07) l=4.5e-08 \
        nf=1 as=1.4765e-13 ad=4.96e-14 ps=2.19e-06 pd=9.4e-07 nrd=1.16667 \
        nrs=1.16667 sa=1.28081e-06 sb=7.65e-07 sd=160n sca=35.6995 \
        scb=0.0234062 scc=0.00420468 m=(1)
mp45 (\15\:qbint \3\:RN \46\:VDD VDD) g45p1svt w=(3.1e-07) l=4.5e-08 \
        nf=1 as=1.1192e-13 ad=4.96e-14 ps=1.9e-06 pd=9.4e-07 nrd=1.16667 \
        nrs=1.16667 sa=1.07581e-06 sb=9.7e-07 sd=160n sca=35.6995 \
        scb=0.0234062 scc=0.00420468 m=(1)
ends SDFF2RX2
// End of subcircuit definition.
