// Generated for: spectre (May  1 09:15:00 2013 )
// Library name: gsclib045_lvt
// Cell name: SDFFSRHQX1
// View name: extracted

simulator lang=spectre

subckt SDFFSRHQX1 CK D Q RN SE SI SN VDD VSS
mp55 (\1\:Q qbint \27\:VDD VDD) g45p1lvt w=(3.9e-07) l=4.5e-08 nf=1 \
        as=5.76e-14 ad=5.46e-14 ps=1.1e-06 pd=1.06e-06 nrd=1.16667 \
        nrs=1.16667 sa=1.4e-07 sb=2.75256e-07 sd=160n sca=40.5329 \
        scb=0.0348939 scc=0.00409042 m=(1)
mp11 (net445 \1\:D \14\:VDD VDD) g45p1lvt w=(3.9e-07) l=4.5e-08 nf=1 \
        as=5.19e-14 ad=2.34e-14 ps=1.1e-06 pd=9e-07 nrd=1.16667 \
        nrs=1.16667 sa=2.35064e-07 sb=7.25064e-07 sd=160n sca=16.7336 \
        scb=0.0149207 scc=0.00128056 m=(1)
mp12 (Db \1\:SE net445 VDD) g45p1lvt w=(3.9e-07) l=4.5e-08 nf=1 \
        as=2.34e-14 ad=6.24e-14 ps=9e-07 pd=1.1e-06 nrd=1.16667 \
        nrs=1.16667 sa=3.40064e-07 sb=6.20064e-07 sd=160n sca=16.7336 \
        scb=0.0149207 scc=0.00128056 m=(1)
mp14 (Db SEb net453 VDD) g45p1lvt w=(3.9e-07) l=4.5e-08 nf=1 as=5.265e-14 \
        ad=6.24e-14 ps=1.05e-06 pd=1.1e-06 nrd=1.16667 nrs=1.16667 \
        sa=5.45064e-07 sb=4.15064e-07 sd=160n sca=17.1865 scb=0.0150693 \
        scc=0.0012806 m=(1)
mp13 (net453 \3\:SI \12\:VDD VDD) g45p1lvt w=(3.9e-07) l=4.5e-08 nf=1 \
        as=5.19e-14 ad=5.265e-14 ps=1.1e-06 pd=1.05e-06 nrd=1.16667 \
        nrs=1.16667 sa=7.25064e-07 sb=2.35064e-07 sd=160n sca=18.0577 \
        scb=0.0157675 scc=0.00128176 m=(1)
C1 (RN VSS) capacitor c=4.5125e-17
C2 (D VSS) capacitor c=9.43313e-17
C3 (Q VSS) capacitor c=4.05583e-17
C4 (CK VSS) capacitor c=8.17619e-17
C5 (SE VSS) capacitor c=2.75491e-17
C6 (SI VSS) capacitor c=9.1466e-17
C7 (VDD VSS) capacitor c=4.87659e-16
C8 (qbint VSS) capacitor c=4.61499e-17
C9 (n35 VSS) capacitor c=5.11501e-17
C10 (RNb VSS) capacitor c=1.20199e-16
C11 (net486 VSS) capacitor c=8.11926e-17
C12 (net490 VSS) capacitor c=1.02165e-16
C13 (CKb VSS) capacitor c=3.73091e-17
C14 (mout VSS) capacitor c=3.85275e-17
C15 (CKbb VSS) capacitor c=2.79759e-17
C16 (net469 VSS) capacitor c=5.96903e-17
C17 (n20 VSS) capacitor c=6.11724e-17
C18 (net514 VSS) capacitor c=2.26474e-18
C19 (Db VSS) capacitor c=1.30702e-16
C20 (net522 VSS) capacitor c=6.84163e-18
C21 (SEb VSS) capacitor c=4.59874e-17
C22 (net394 VSS) capacitor c=1.09553e-16
C23 (net437 VSS) capacitor c=1.24016e-18
C24 (net417 VSS) capacitor c=5.66081e-18
C25 (net425 VSS) capacitor c=4.17817e-18
C26 (net445 VSS) capacitor c=2.61316e-18
C27 (net453 VSS) capacitor c=4.79661e-18
C28 (\7\:SE VSS) capacitor c=5.58656e-17
C29 (\3\:SI VSS) capacitor c=6.11769e-17
C30 (\1\:SE VSS) capacitor c=7.51667e-17
C31 (\1\:D VSS) capacitor c=1.05664e-16
C32 (\1\:CK VSS) capacitor c=5.1554e-17
C33 (\5\:CKb VSS) capacitor c=3.21884e-17
C34 (\7\:CKbb VSS) capacitor c=2.76137e-17
C35 (\9\:CKb VSS) capacitor c=5.42306e-17
C36 (\5\:SN VSS) capacitor c=7.43119e-17
C37 (\3\:CKb VSS) capacitor c=4.51816e-17
C38 (\3\:CKbb VSS) capacitor c=5.18957e-17
C39 (\3\:RNb VSS) capacitor c=7.30377e-17
C40 (\5\:qbint VSS) capacitor c=1.38789e-16
C41 (\1\:SN VSS) capacitor c=4.71374e-17
C42 (\1\:RN VSS) capacitor c=2.97248e-17
C43 (\5\:SE VSS) capacitor c=3.43751e-17
C44 (\1\:SI VSS) capacitor c=8.80355e-17
C45 (\3\:SE VSS) capacitor c=7.47651e-17
C46 (\3\:SEb VSS) capacitor c=6.98023e-17
C47 (\4\:D VSS) capacitor c=4.25115e-17
C48 (\3\:CK VSS) capacitor c=3.53017e-17
C49 (\10\:CKb VSS) capacitor c=2.88243e-17
C50 (\11\:CKb VSS) capacitor c=3.22056e-17
C51 (\5\:CKbb VSS) capacitor c=5.04275e-17
C52 (\3\:mout VSS) capacitor c=5.60715e-17
C53 (\4\:SN VSS) capacitor c=6.7642e-17
C54 (\3\:n20 VSS) capacitor c=3.4658e-17
C55 (\4\:RNb VSS) capacitor c=4.94467e-17
C56 (\5\:RNb VSS) capacitor c=6.90286e-17
C57 (\7\:qbint VSS) capacitor c=7.32873e-17
C58 (\3\:SN VSS) capacitor c=3.89452e-17
C59 (\3\:RN VSS) capacitor c=2.83511e-17
C60 (\3\:n35 VSS) capacitor c=3.545e-17
C61 (\3\:qbint VSS) capacitor c=4.21758e-17
C62 (\6\:SE VSS) capacitor c=5.21601e-17
C63 (\2\:SI VSS) capacitor c=5.83459e-17
C64 (\4\:SE VSS) capacitor c=4.67702e-17
C65 (\2\:SEb VSS) capacitor c=5.68171e-17
C66 (\2\:SE VSS) capacitor c=4.82859e-17
C67 (\3\:D VSS) capacitor c=2.71577e-17
C68 (\2\:CK VSS) capacitor c=5.53372e-17
C69 (\6\:CKb VSS) capacitor c=2.27701e-17
C70 (\8\:CKbb VSS) capacitor c=4.20031e-17
C71 (\6\:CKbb VSS) capacitor c=3.9443e-17
C72 (\2\:mout VSS) capacitor c=4.16157e-17
C73 (\4\:n20 VSS) capacitor c=4.25167e-17
C74 (\6\:SN VSS) capacitor c=2.22187e-17
C75 (\4\:CKbb VSS) capacitor c=3.17309e-17
C76 (\4\:CKb VSS) capacitor c=3.71901e-17
C77 (\2\:CKb VSS) capacitor c=2.17093e-17
C78 (\2\:RNb VSS) capacitor c=9.49987e-17
C79 (\2\:SN VSS) capacitor c=3.56577e-17
C80 (\2\:RN VSS) capacitor c=2.21768e-17
C81 (\6\:qbint VSS) capacitor c=3.51809e-17
C82 (\2\:n35 VSS) capacitor c=3.48735e-17
C83 (\4\:qbint VSS) capacitor c=2.23038e-17
C84 (\8\:SEb VSS) capacitor c=1.32744e-17
C85 (\12\:VDD VSS) capacitor c=3.57875e-17
C86 (\14\:VDD VSS) capacitor c=2.15807e-17
C87 (\18\:CKb VSS) capacitor c=7.53285e-17
C88 (\16\:VDD VSS) capacitor c=4.5967e-17
C89 (\11\:CKbb VSS) capacitor c=1.0916e-16
C90 (\7\:Db VSS) capacitor c=1.02575e-16
C91 (\5\:n20 VSS) capacitor c=8.91518e-17
C92 (\18\:VDD VSS) capacitor c=5.83003e-17
C93 (\11\:mout VSS) capacitor c=1.93774e-16
C94 (\20\:VDD VSS) capacitor c=6.20201e-17
C95 (\7\:mout VSS) capacitor c=3.76308e-17
C96 (\4\:n35 VSS) capacitor c=7.861e-17
C97 (\22\:VDD VSS) capacitor c=5.43417e-17
C98 (\3\:net394 VSS) capacitor c=8.88414e-17
C99 (\24\:VDD VSS) capacitor c=7.30001e-17
C100 (\7\:RNb VSS) capacitor c=1.57716e-16
C101 (\9\:qbint VSS) capacitor c=6.49974e-17
C102 (\27\:VDD VSS) capacitor c=6.48088e-17
C103 (\1\:Q VSS) capacitor c=4.84648e-17
C104 (\1\:VDD VSS) capacitor c=1.16089e-16
C105 (\4\:SEb VSS) capacitor c=7.52075e-17
C106 (\9\:Db VSS) capacitor c=4.15316e-17
C107 (\12\:CKb VSS) capacitor c=7.80903e-17
C108 (\9\:CKbb VSS) capacitor c=9.45723e-17
C109 (\5\:Db VSS) capacitor c=1.93386e-16
C110 (\9\:n20 VSS) capacitor c=1.93514e-17
C111 (\9\:mout VSS) capacitor c=1.374e-16
C112 (\3\:net469 VSS) capacitor c=7.53415e-17
C113 (\4\:mout VSS) capacitor c=1.11541e-16
C114 (\8\:n35 VSS) capacitor c=6.26283e-17
C115 (\3\:net490 VSS) capacitor c=1.00647e-16
C116 (\3\:net486 VSS) capacitor c=9.37076e-17
C117 (\9\:RNb VSS) capacitor c=6.87253e-17
C118 (\12\:qbint VSS) capacitor c=5.73093e-17
C119 (\3\:Q VSS) capacitor c=1.51432e-17
C120 (\2\:qbint VSS) capacitor c=1.29501e-17
C121 (\2\:CKbb VSS) capacitor c=6.03263e-17
C122 (\2\:n20 VSS) capacitor c=2.87814e-17
C123 (\8\:qbint VSS) capacitor c=5.24355e-17
C124 (\11\:qbint VSS) capacitor c=5.13994e-17
C125 (\14\:qbint VSS) capacitor c=6.04355e-17
C126 (\7\:CKb VSS) capacitor c=2.43186e-17
C127 (\8\:CKb VSS) capacitor c=6.78167e-17
C128 (\4\:RN VSS) capacitor c=6.628e-17
C129 (\2\:D VSS) capacitor c=2.65256e-17
C130 (\6\:RNb VSS) capacitor c=1.14346e-16
C131 (\6\:n35 VSS) capacitor c=3.14645e-16
C132 (\7\:n35 VSS) capacitor c=2.52605e-16
C133 (\7\:SN VSS) capacitor c=3.09834e-16
C134 (\8\:SN VSS) capacitor c=3.49442e-16
C135 (\6\:mout VSS) capacitor c=1.47581e-16
C136 (\13\:mout VSS) capacitor c=8.13404e-17
C137 (\7\:n20 VSS) capacitor c=1.10497e-16
C138 (\8\:n20 VSS) capacitor c=8.81243e-17
C139 (\13\:CKbb VSS) capacitor c=1.32333e-16
C140 (\14\:CKbb VSS) capacitor c=6.72804e-17
C141 (\15\:CKbb VSS) capacitor c=2.52389e-16
C142 (\16\:CKbb VSS) capacitor c=1.99056e-16
C143 (\4\:CK VSS) capacitor c=3.18919e-17
C144 (\14\:CKb VSS) capacitor c=9.32695e-17
C145 (\15\:CKb VSS) capacitor c=4.08881e-16
C146 (\16\:CKb VSS) capacitor c=5.16271e-16
C147 (\17\:CKb VSS) capacitor c=1.21885e-16
C148 (\4\:Db VSS) capacitor c=1.99268e-16
C149 (\8\:SE VSS) capacitor c=6.69825e-17
C150 (\9\:SE VSS) capacitor c=5.0997e-17
C151 (\10\:SE VSS) capacitor c=4.47963e-17
C152 (\4\:SI VSS) capacitor c=4.53681e-17
C153 (\6\:SEb VSS) capacitor c=1.00378e-16
C154 (\7\:SEb VSS) capacitor c=8.27082e-17
C155 (\3\:VDD VSS) capacitor c=1.26775e-17
C156 (\4\:VDD VSS) capacitor c=2.74357e-17
C157 (\6\:VDD VSS) capacitor c=3.44631e-17
C158 (\7\:VDD VSS) capacitor c=5.19608e-17
C159 (\9\:VDD VSS) capacitor c=3.87947e-17
C160 (\10\:VDD VSS) capacitor c=6.524e-17
C161 (\26\:VDD VSS) capacitor c=3.09613e-17
Rk7 (RN \4\:RN) resistor r=0.1074 c=0
Rk38 (D \5\:D) resistor r=0.004839 c=0
Rk1 (\2\:Q Q) resistor r=0.3083 c=0
Rk2 (Q \4\:Q) resistor r=0.0627 c=0
Rk32 (\4\:CK CK) resistor r=0.1038 c=0
Rk44 (\8\:SE \9\:SE) resistor r=0.3182 c=0
Rk46 (\10\:SE SE) resistor r=0.0304 c=0
Rk45 (\9\:SE \10\:SE) resistor r=0.2328 c=0
Rk17 (\7\:SN SN) resistor r=2.5763 c=0
Rk18 (SN \8\:SN) resistor r=0.003345 c=0
Rk47 (\4\:SI SI) resistor r=0.0223 c=0
Rk51 (\2\:VSS \3\:VSS) resistor r=0.06254 c=0
Rk52 (\3\:VSS \4\:VSS) resistor r=0.4002 c=0
Rk53 (\4\:VSS \5\:VSS) resistor r=0.2874 c=0
Rk54 (\5\:VSS \6\:VSS) resistor r=0.1519 c=0
Rk55 (\6\:VSS \7\:VSS) resistor r=0.621 c=0
Rk56 (\7\:VSS \8\:VSS) resistor r=0.4289 c=0
Rk57 (\8\:VSS \9\:VSS) resistor r=1.1432 c=0
Rk58 (\9\:VSS \10\:VSS) resistor r=0.05908 c=0
Rk60 (\11\:VSS VSS) resistor r=0.1075 c=0
Rk59 (\10\:VSS \11\:VSS) resistor r=0.444 c=0
Rk61 (\3\:VSS \13\:VSS) resistor r=0.2932 c=0
Rk62 (\4\:VSS \15\:VSS) resistor r=0.04335 c=0
Rk63 (\6\:VSS \17\:VSS) resistor r=0.04335 c=0
Rk64 (\7\:VSS \19\:VSS) resistor r=0.2208 c=0
Rk65 (\9\:VSS \21\:VSS) resistor r=0.04335 c=0
Rk66 (\11\:VSS \23\:VSS) resistor r=0.3175 c=0
Rk67 (\2\:VDD \3\:VDD) resistor r=0.1002 c=0
Rk68 (\3\:VDD \4\:VDD) resistor r=0.3484 c=0
Rk69 (\4\:VDD \5\:VDD) resistor r=0.3035 c=0
Rk70 (\5\:VDD \6\:VDD) resistor r=0.06003 c=0
Rk71 (\6\:VDD \7\:VDD) resistor r=0.7374 c=0
Rk72 (\7\:VDD \8\:VDD) resistor r=0.4063 c=0
Rk73 (\8\:VDD \9\:VDD) resistor r=0.07509 c=0
Rk74 (\9\:VDD \10\:VDD) resistor r=0.7324 c=0
Rk75 (\10\:VDD \11\:VDD) resistor r=0.3963 c=0
Rk76 (\3\:VDD \13\:VDD) resistor r=0.2559 c=0
Rk77 (\4\:VDD \15\:VDD) resistor r=0.2559 c=0
Rk78 (\6\:VDD \17\:VDD) resistor r=0.3122 c=0
Rk79 (\7\:VDD \19\:VDD) resistor r=0.2365 c=0
Rk80 (\9\:VDD \21\:VDD) resistor r=0.2178 c=0
Rk81 (\10\:VDD \23\:VDD) resistor r=0.2544 c=0
Rk82 (\11\:VDD \25\:VDD) resistor r=0.382 c=0
Rk85 (\26\:VDD VDD) resistor r=0.1225 c=0
Rk83 (\11\:VDD \26\:VDD) resistor r=0.4293 c=0
Rk84 (\26\:VDD \28\:VDD) resistor r=0.373 c=0
Rk3 (\8\:qbint \10\:qbint) resistor r=0.4762 c=0
Rk4 (\10\:qbint \11\:qbint) resistor r=0.2549 c=0
Rk5 (\11\:qbint \13\:qbint) resistor r=0.27 c=0
Rk6 (\11\:qbint \14\:qbint) resistor r=0.3115 c=0
Rk13 (\5\:n35 \6\:n35) resistor r=0.1981 c=0
Rk14 (\6\:n35 \7\:n35) resistor r=2.1301 c=0
Rk15 (\6\:n35 \9\:n35) resistor r=0.2555 c=0
Rk8 (\6\:RNb \8\:RNb) resistor r=0.9706 c=0
Rk9 (\8\:RNb \10\:RNb) resistor r=0.3469 c=0
Rk10 (\2\:net486 \4\:net486) resistor r=0.4085 c=0
Rk12 (\2\:net490 \4\:net490) resistor r=0.414 c=0
Rk33 (\13\:CKb \14\:CKb) resistor r=0.5137 c=0
Rk34 (\14\:CKb \15\:CKb) resistor r=0.2565 c=0
Rk35 (\15\:CKb \16\:CKb) resistor r=3.0628 c=0
Rk36 (\16\:CKb \17\:CKb) resistor r=0.885 c=0
Rk37 (\15\:CKb \19\:CKb) resistor r=0.5675 c=0
Rk19 (\5\:mout \6\:mout) resistor r=0.2728 c=0
Rk20 (\6\:mout \8\:mout) resistor r=0.1246 c=0
Rk21 (\5\:mout \10\:mout) resistor r=0.7108 c=0
Rk22 (\6\:mout \12\:mout) resistor r=1.0055 c=0
Rk23 (\12\:mout \13\:mout) resistor r=0.4847 c=0
Rk27 (\10\:CKbb \12\:CKbb) resistor r=0.4924 c=0
Rk28 (\12\:CKbb \13\:CKbb) resistor r=0.3175 c=0
Rk29 (\13\:CKbb \14\:CKbb) resistor r=0.23 c=0
Rk30 (\13\:CKbb \15\:CKbb) resistor r=0.626 c=0
Rk31 (\15\:CKbb \16\:CKbb) resistor r=1.4759 c=0
Rk16 (\2\:net469 \4\:net469) resistor r=0.3105 c=0
Rk24 (\6\:n20 \7\:n20) resistor r=0.4561 c=0
Rk25 (\7\:n20 \8\:n20) resistor r=0.5572 c=0
Rk26 (\7\:n20 \10\:n20) resistor r=0.03488 c=0
Rk39 (\2\:Db \3\:Db) resistor r=0.1635 c=0
Rk40 (\3\:Db \4\:Db) resistor r=0.619 c=0
Rk41 (\4\:Db \6\:Db) resistor r=1.1229 c=0
Rk42 (\6\:Db \8\:Db) resistor r=0.5998 c=0
Rk43 (\4\:Db \10\:Db) resistor r=0.2581 c=0
Rk48 (\5\:SEb \6\:SEb) resistor r=0.7053 c=0
Rk49 (\6\:SEb \7\:SEb) resistor r=0.4832 c=0
Rk50 (\6\:SEb \9\:SEb) resistor r=0.04832 c=0
Rk11 (\2\:net394 \4\:net394) resistor r=0.5311 c=0
Rl6 (\1\:RN \2\:RN) resistor r=28.079 c=0
Rl7 (\2\:RN \3\:RN) resistor r=78.079 c=0
Rl38 (\1\:D \2\:D) resistor r=101.157 c=0
Rl40 (\2\:D \4\:D) resistor r=47.3105 c=0
Rl39 (\2\:D \3\:D) resistor r=58.0656 c=0
Rl36 (\1\:CK \2\:CK) resistor r=166.862 c=0
Rl37 (\2\:CK \3\:CK) resistor r=89.6174 c=0
Rl48 (\6\:SE \7\:SE) resistor r=179.104 c=0
Rl47 (\5\:SE \6\:SE) resistor r=35.3072 c=0
Rl44 (\3\:SE \4\:SE) resistor r=28.079 c=0
Rl41 (\1\:SE \2\:SE) resistor r=31.8672 c=0
Rl24 (\4\:SN \5\:SN) resistor r=197.643 c=0
Rl25 (\5\:SN \6\:SN) resistor r=24.2328 c=0
Rl8 (\1\:SN \2\:SN) resistor r=28.079 c=0
Rl9 (\2\:SN \3\:SN) resistor r=85.7713 c=0
Rl46 (\2\:SI \3\:SI) resistor r=26.3736 c=0
Rl45 (\1\:SI \2\:SI) resistor r=105.769 c=0
Rl11 (\5\:qbint \7\:qbint) resistor r=175 c=0
Rl10 (\5\:qbint \6\:qbint) resistor r=276.436 c=0
Rl1 (qbint \2\:qbint) resistor r=26.9069 c=0
Rl2 (\2\:qbint \3\:qbint) resistor r=72.5882 c=0
Rl3 (\2\:qbint \4\:qbint) resistor r=4.4012 c=0
Rl4 (n35 \2\:n35) resistor r=79.5379 c=0
Rl5 (\2\:n35 \3\:n35) resistor r=29.5379 c=0
Rl19 (RNb \4\:RNb) resistor r=165.385 c=0
Rl20 (\3\:RNb \5\:RNb) resistor r=197.643 c=0
Rl17 (RNb \2\:RNb) resistor r=821.693 c=0
Rl18 (\2\:RNb \3\:RNb) resistor r=24.2328 c=0
Rl30 (\5\:CKb \6\:CKb) resistor r=122.31 c=0
Rl13 (\3\:CKb \4\:CKb) resistor r=29.5379 c=0
Rl12 (CKb \2\:CKb) resistor r=24.2328 c=0
Rl34 (\7\:CKb \10\:CKb) resistor r=30.4507 c=0
Rl31 (\6\:CKb \7\:CKb) resistor r=14.4132 c=0
Rl33 (\8\:CKb \9\:CKb) resistor r=150.722 c=0
Rl35 (\8\:CKb \11\:CKb) resistor r=68.4643 c=0
Rl32 (\7\:CKb \8\:CKb) resistor r=208.53 c=0
Rl26 (mout \2\:mout) resistor r=24.2328 c=0
Rl27 (\2\:mout \3\:mout) resistor r=114.617 c=0
Rl29 (\7\:CKbb \8\:CKbb) resistor r=29.5379 c=0
Rl28 (\5\:CKbb \6\:CKbb) resistor r=62.2302 c=0
Rl15 (\2\:CKbb \3\:CKbb) resistor r=159.159 c=0
Rl14 (CKbb \2\:CKbb) resistor r=34.2969 c=0
Rl16 (\2\:CKbb \4\:CKbb) resistor r=153.772 c=0
Rl21 (n20 \2\:n20) resistor r=133.849 c=0
Rl22 (\2\:n20 \3\:n20) resistor r=28.0797 c=0
Rl23 (\2\:n20 \4\:n20) resistor r=73.9143 c=0
Rl42 (SEb \2\:SEb) resistor r=26.4372 c=0
Rl43 (\2\:SEb \3\:SEb) resistor r=111.5 c=0
Rz1 (\3\:Q \4\:Q) resistor r=75 c=0
Rz19 (\12\:VSS \13\:VSS) resistor r=75 c=0
Rz20 (\14\:VSS \15\:VSS) resistor r=75 c=0
Rz21 (\16\:VSS \17\:VSS) resistor r=75 c=0
Rz22 (\18\:VSS \19\:VSS) resistor r=75 c=0
Rz23 (\20\:VSS \21\:VSS) resistor r=75 c=0
Rz24 (\22\:VSS \23\:VSS) resistor r=75 c=0
Rz25 (\1\:VDD \2\:VDD) resistor r=25 c=0
Rz26 (\1\:VDD \5\:VDD) resistor r=6.25 c=0
Rz27 (\1\:VDD \8\:VDD) resistor r=6.25 c=0
Rz28 (\1\:VDD \11\:VDD) resistor r=6.25 c=0
Rz2 (\12\:qbint \13\:qbint) resistor r=75 c=0
Rz8 (\8\:n35 \9\:n35) resistor r=75 c=0
Rz3 (\9\:RNb \10\:RNb) resistor r=75 c=0
Rz4 (net486 \2\:net486) resistor r=75 c=0
Rz5 (\3\:net486 \4\:net486) resistor r=75 c=0
Rz6 (net490 \2\:net490) resistor r=75 c=0
Rz7 (\3\:net490 \4\:net490) resistor r=75 c=0
Rz15 (\12\:CKb \13\:CKb) resistor r=75 c=0
Rz11 (\4\:mout \5\:mout) resistor r=75 c=0
Rz12 (\9\:mout \10\:mout) resistor r=75 c=0
Rz14 (\9\:CKbb \10\:CKbb) resistor r=75 c=0
Rz9 (net469 \2\:net469) resistor r=75 c=0
Rz10 (\3\:net469 \4\:net469) resistor r=75 c=0
Rz13 (\9\:n20 \10\:n20) resistor r=75 c=0
Rz16 (\5\:Db \6\:Db) resistor r=75 c=0
Rz17 (\9\:Db \10\:Db) resistor r=75 c=0
Rz18 (\4\:SEb \5\:SEb) resistor r=75 c=0
Ry1 (\1\:Q \2\:Q) resistor r=20.6667 c=0
Ry16 (\1\:VSS \2\:VSS) resistor r=20.6667 c=0
Ry17 (\1\:VSS \5\:VSS) resistor r=5.1667 c=0
Ry18 (\1\:VSS \8\:VSS) resistor r=5.1667 c=0
Ry19 (\1\:VSS \10\:VSS) resistor r=5.1667 c=0
Ry20 (\12\:VDD \13\:VDD) resistor r=62 c=0
Ry21 (\14\:VDD \15\:VDD) resistor r=62 c=0
Ry22 (\16\:VDD \17\:VDD) resistor r=62 c=0
Ry23 (\18\:VDD \19\:VDD) resistor r=62 c=0
Ry24 (\20\:VDD \21\:VDD) resistor r=62 c=0
Ry25 (\22\:VDD \23\:VDD) resistor r=62 c=0
Ry26 (\24\:VDD \25\:VDD) resistor r=62 c=0
Ry27 (\27\:VDD \28\:VDD) resistor r=62 c=0
Ry2 (\9\:qbint \10\:qbint) resistor r=62 c=0
Ry6 (\4\:n35 \5\:n35) resistor r=31 c=0
Ry3 (\7\:RNb \8\:RNb) resistor r=62 c=0
Ry11 (\18\:CKb \19\:CKb) resistor r=62 c=0
Ry7 (\7\:mout \8\:mout) resistor r=62 c=0
Ry8 (\11\:mout \12\:mout) resistor r=62 c=0
Ry10 (\11\:CKbb \12\:CKbb) resistor r=62 c=0
Ry9 (\5\:n20 \6\:n20) resistor r=62 c=0
Ry12 (Db \2\:Db) resistor r=62 c=0
Ry13 (Db \3\:Db) resistor r=62 c=0
Ry14 (\7\:Db \8\:Db) resistor r=62 c=0
Ry15 (\8\:SEb \9\:SEb) resistor r=62 c=0
Ry4 (net394 \2\:net394) resistor r=62 c=0
Ry5 (\3\:net394 \4\:net394) resistor r=62 c=0
Rx3 (\2\:RN \4\:RN) resistor r=45 c=0
Rx17 (\3\:D \5\:D) resistor r=45 c=0
Rx13 (\2\:CK \4\:CK) resistor r=45 c=0
Rx18 (\2\:SE \8\:SE) resistor r=45 c=0
Rx19 (\4\:SE \9\:SE) resistor r=45 c=0
Rx20 (\6\:SE \10\:SE) resistor r=45 c=0
Rx6 (\6\:SN \7\:SN) resistor r=45 c=0
Rx7 (\2\:SN \8\:SN) resistor r=45 c=0
Rx21 (\2\:SI \4\:SI) resistor r=45 c=0
Rx1 (\6\:qbint \8\:qbint) resistor r=45 c=0
Rx2 (\4\:qbint \14\:qbint) resistor r=45 c=0
Rx5 (\2\:n35 \7\:n35) resistor r=45 c=0
Rx4 (\2\:RNb \6\:RNb) resistor r=45 c=0
Rx14 (\6\:CKb \14\:CKb) resistor r=45 c=0
Rx15 (\4\:CKb \16\:CKb) resistor r=45 c=0
Rx16 (\2\:CKb \17\:CKb) resistor r=45 c=0
Rx8 (\2\:mout \13\:mout) resistor r=45 c=0
Rx10 (\8\:CKbb \14\:CKbb) resistor r=45 c=0
Rx11 (\6\:CKbb \15\:CKbb) resistor r=45 c=0
Rx12 (\4\:CKbb \16\:CKbb) resistor r=45 c=0
Rx9 (\4\:n20 \8\:n20) resistor r=45 c=0
Rx22 (\2\:SEb \7\:SEb) resistor r=45 c=0
mn55 (\3\:Q \3\:qbint \22\:VSS VSS) g45n1lvt w=(2.6e-07) l=4.5e-08 nf=1 \
        as=4.445e-14 ad=3.64e-14 ps=9e-07 pd=8e-07 nrd=1.16667 nrs=1.16667 \
        sa=1.4e-07 sb=3.83846e-07 sd=160n sca=14.4034 scb=0.0144248 \
        scc=0.00102063 m=(1)
mn11 (net522 \4\:D \14\:VSS VSS) g45n1lvt w=(2.6e-07) l=4.5e-08 nf=1 \
        as=9.85e-14 ad=5.46e-14 ps=1.69e-06 pd=9.4e-07 nrd=1.16667 \
        nrs=1.16667 sa=3.73558e-07 sb=7.89712e-07 sd=160n sca=10.79 \
        scb=0.0100512 scc=0.000418069 m=(1)
mn12 (\9\:Db \3\:SEb net522 VSS) g45n1lvt w=(2.6e-07) l=4.5e-08 nf=1 \
        as=5.46e-14 ad=4.2e-14 ps=9.4e-07 pd=8.6e-07 nrd=1.16667 \
        nrs=1.16667 sa=6.28558e-07 sb=5.34712e-07 sd=160n sca=10.79 \
        scb=0.0100512 scc=0.000418069 m=(1)
mn14 (\9\:Db \3\:SE net534 VSS) g45n1lvt w=(2.6e-07) l=4.5e-08 nf=1 \
        as=1.56e-14 ad=4.2e-14 ps=6.4e-07 pd=8.6e-07 nrd=1.16667 \
        nrs=1.16667 sa=7.99135e-07 sb=3.41635e-07 sd=160n sca=10.3222 \
        scb=0.00938145 scc=0.000353946 m=(1)
mn13 (net534 \1\:SI \12\:VSS VSS) g45n1lvt w=(2.6e-07) l=4.5e-08 nf=1 \
        as=3.47e-14 ad=1.56e-14 ps=8.4e-07 pd=6.4e-07 nrd=1.16667 \
        nrs=1.16667 sa=9.04135e-07 sb=2.36635e-07 sd=160n sca=10.3222 \
        scb=0.00938145 scc=0.000353946 m=(1)
mn45 (\12\:qbint \3\:n35 \22\:VSS VSS) g45n1lvt w=(2.05e-07) l=4.5e-08 \
        nf=1 as=4.445e-14 ad=4.613e-14 ps=9e-07 pd=8.6e-07 nrd=1.16667 \
        nrs=1.16667 sa=3.75e-07 sb=2.25e-07 sd=160n sca=16.0682 \
        scb=0.0166045 scc=0.00126927 m=(1)
mn50 (\3\:net486 \3\:SN \20\:VSS VSS) g45n1lvt w=(2.05e-07) l=4.5e-08 \
        nf=1 as=8.115e-14 ad=3.28e-14 ps=1.96e-06 pd=7.3e-07 nrd=1.16667 \
        nrs=1.16667 sa=3.83537e-07 sb=5.95e-07 sd=160n sca=12.7388 \
        scb=0.0128661 scc=0.000666764 m=(1)
mn52 (net490 \7\:qbint \3\:net486 VSS) g45n1lvt w=(2.05e-07) l=4.5e-08 \
        nf=1 as=3.28e-14 ad=3.383e-14 ps=7.3e-07 pd=7.4e-07 nrd=1.16667 \
        nrs=1.16667 sa=5.88537e-07 sb=3.9e-07 sd=160n sca=12.7388 \
        scb=0.0128661 scc=0.000666764 m=(1)
mn51 (net490 \5\:RNb net486 VSS) g45n1lvt w=(2.05e-07) l=4.5e-08 nf=1 \
        as=3.69e-14 ad=3.383e-14 ps=7.7e-07 pd=7.4e-07 nrd=1.16667 \
        nrs=1.16667 sa=7.98537e-07 sb=1.8e-07 sd=160n sca=12.7388 \
        scb=0.0128661 scc=0.000666764 m=(1)
mn53 (\8\:n35 CKb \3\:net490 VSS) g45n1lvt w=(2.05e-07) l=4.5e-08 nf=1 \
        as=4.818e-14 ad=4.92e-14 ps=8.8e-07 pd=8.9e-07 nrd=1.16667 \
        nrs=1.16667 sa=2.35e-07 sb=5.7e-07 sd=160n sca=10.7727 \
        scb=0.0101457 scc=0.000373012 m=(1)
mn40 (\8\:n35 CKbb \4\:mout VSS) g45n1lvt w=(2.05e-07) l=4.5e-08 nf=1 \
        as=5.843e-14 ad=4.92e-14 ps=9.8e-07 pd=8.9e-07 nrd=1.16667 \
        nrs=1.16667 sa=5.2e-07 sb=2.85e-07 sd=160n sca=10.7727 \
        scb=0.0101457 scc=0.000373012 m=(1)
mn31 (\9\:mout \4\:RNb \3\:net469 VSS) g45n1lvt w=(2.05e-07) l=4.5e-08 \
        nf=1 as=2.87e-14 ad=3.69e-14 ps=6.9e-07 pd=7.7e-07 nrd=1.16667 \
        nrs=1.16667 sa=1.4e-07 sb=1.40305e-06 sd=160n sca=9.17255 \
        scb=0.0076374 scc=0.000189126 m=(1)
mn32 (\9\:mout \3\:n20 net469 VSS) g45n1lvt w=(2.05e-07) l=4.5e-08 nf=1 \
        as=6.8e-14 ad=3.69e-14 ps=1.09e-06 pd=7.7e-07 nrd=1.16667 \
        nrs=1.16667 sa=3.65e-07 sb=1.17805e-06 sd=160n sca=9.17255 \
        scb=0.0076374 scc=0.000189126 m=(1)
mn30 (net469 \4\:SN \18\:VSS VSS) g45n1lvt w=(2.05e-07) l=4.5e-08 nf=1 \
        as=4.305e-14 ad=6.8e-14 ps=8.3e-07 pd=1.09e-06 nrd=1.16667 \
        nrs=1.16667 sa=7.29268e-07 sb=8.25e-07 sd=160n sca=9.00745 \
        scb=0.0073653 scc=0.000173562 m=(1)
mn35 (net514 \3\:mout \18\:VSS VSS) g45n1lvt w=(2.05e-07) l=4.5e-08 nf=1 \
        as=4.305e-14 ad=2.255e-14 ps=8.3e-07 pd=6.3e-07 nrd=1.16667 \
        nrs=1.16667 sa=9.84268e-07 sb=5.7e-07 sd=160n sca=9.00745 \
        scb=0.0073653 scc=0.000173562 m=(1)
mn36 (\9\:n20 \5\:CKbb net514 VSS) g45n1lvt w=(2.05e-07) l=4.5e-08 nf=1 \
        as=2.255e-14 ad=4.715e-14 ps=6.3e-07 pd=8.7e-07 nrd=1.16667 \
        nrs=1.16667 sa=1.13927e-06 sb=4.15e-07 sd=160n sca=9.00745 \
        scb=0.0073653 scc=0.000173562 m=(1)
mn25 (\5\:Db \11\:CKb \9\:n20 VSS) g45n1lvt w=(2.05e-07) l=4.5e-08 nf=1 \
        as=4.715e-14 ad=2.87e-14 ps=8.7e-07 pd=6.9e-07 nrd=1.16667 \
        nrs=1.16667 sa=1.41427e-06 sb=1.4e-07 sd=160n sca=9.00745 \
        scb=0.0073653 scc=0.000173562 m=(1)
mn22 (\9\:RNb \3\:RN \20\:VSS VSS) g45n1lvt w=(1.45e-07) l=4.5e-08 nf=1 \
        as=8.115e-14 ad=2.03e-14 ps=1.96e-06 pd=5.7e-07 nrd=1.16667 \
        nrs=1.16667 sa=1.4e-07 sb=8.93103e-07 sd=160n sca=16.2011 \
        scb=0.0172667 scc=0.0012292 m=(1)
mn21 (\9\:CKbb \10\:CKb \16\:VSS VSS) g45n1lvt w=(1.45e-07) l=4.5e-08 \
        nf=1 as=4.14e-14 ad=2.03e-14 ps=1.37e-06 pd=5.7e-07 nrd=1.16667 \
        nrs=1.16667 sa=1.4e-07 sb=1e-07 sd=160n sca=14.7993 scb=0.0157101 \
        scc=0.000964917 m=(1)
mn20 (\12\:CKb \3\:CK \14\:VSS VSS) g45n1lvt w=(1.45e-07) l=4.5e-08 nf=1 \
        as=9.85e-14 ad=2.03e-14 ps=1.69e-06 pd=5.7e-07 nrd=1.16667 \
        nrs=1.16667 sa=1.4e-07 sb=1.24138e-06 sd=160n sca=13.253 \
        scb=0.0137915 scc=0.000695334 m=(1)
mn10 (\4\:SEb \5\:SE \12\:VSS VSS) g45n1lvt w=(1.45e-07) l=4.5e-08 nf=1 \
        as=3.47e-14 ad=2.03e-14 ps=8.4e-07 pd=5.7e-07 nrd=1.16667 \
        nrs=1.16667 sa=1.24207e-06 sb=1.4e-07 sd=160n sca=11.7118 \
        scb=0.0116498 scc=0.000458536 m=(1)
mp45 (\9\:qbint n35 \27\:VDD VDD) g45p1lvt w=(3.1e-07) l=4.5e-08 nf=1 \
        as=5.76e-14 ad=3.58e-14 ps=1.1e-06 pd=9e-07 nrd=1.16667 \
        nrs=1.16667 sa=3.45e-07 sb=1.15484e-07 sd=160n sca=20.3238 \
        scb=0.019357 scc=0.00139603 m=(1)
mp50 (\3\:net394 \1\:SN \24\:VDD VDD) g45p1lvt w=(3.1e-07) l=4.5e-08 \
        nf=1 as=1.1305e-13 ad=5.3e-14 ps=1.38e-06 pd=1.11e-06 nrd=1.16667 \
        nrs=1.16667 sa=4.92339e-07 sb=4.66532e-07 sd=160n sca=19.8394 \
        scb=0.0179302 scc=0.00185493 m=(1)
mp52 (\3\:net394 \5\:qbint net437 VDD) g45p1lvt w=(3.1e-07) l=4.5e-08 \
        nf=1 as=1.86e-14 ad=5.3e-14 ps=7.4e-07 pd=1.11e-06 nrd=1.16667 \
        nrs=1.16667 sa=5.05403e-07 sb=4e-07 sd=160n sca=12.9031 \
        scb=0.0116454 scc=0.000496931 m=(1)
mp51 (net437 \3\:RNb \22\:VDD VDD) g45p1lvt w=(3.1e-07) l=4.5e-08 nf=1 \
        as=9.145e-14 ad=1.86e-14 ps=1.21e-06 pd=7.4e-07 nrd=1.16667 \
        nrs=1.16667 sa=6.10403e-07 sb=2.95e-07 sd=160n sca=12.9031 \
        scb=0.0116454 scc=0.000496931 m=(1)
mp53 (\4\:n35 \3\:CKbb net394 VDD) g45p1lvt w=(3.1e-07) l=4.5e-08 nf=1 \
        as=7.905e-14 ad=5.89e-14 ps=1.13e-06 pd=1e-06 nrd=1.16667 \
        nrs=1.16667 sa=2.55e-07 sb=4.6e-07 sd=160n sca=29.7112 \
        scb=0.0220652 scc=0.00347629 m=(1)
mp40 (\4\:n35 \3\:CKb \7\:mout VDD) g45p1lvt w=(3.1e-07) l=4.5e-08 nf=1 \
        as=6.975e-14 ad=5.89e-14 ps=1.07e-06 pd=1e-06 nrd=1.16667 \
        nrs=1.16667 sa=4.9e-07 sb=2.25e-07 sd=160n sca=29.7112 \
        scb=0.0220652 scc=0.00347629 m=(1)
mp31 (net417 RNb \20\:VDD VDD) g45p1lvt w=(3.1e-07) l=4.5e-08 nf=1 \
        as=1.4105e-13 ad=5.58e-14 ps=1.72e-06 pd=9.8e-07 nrd=1.16667 \
        nrs=1.16667 sa=3.95e-07 sb=1.62e-06 sd=160n sca=22.2698 \
        scb=0.0192893 scc=0.0023049 m=(1)
mp32 (\11\:mout n20 net417 VDD) g45p1lvt w=(3.1e-07) l=4.5e-08 nf=1 \
        as=5.58e-14 ad=6.51e-14 ps=9.8e-07 pd=1.04e-06 nrd=1.16667 \
        nrs=1.16667 sa=6.2e-07 sb=1.395e-06 sd=160n sca=22.2698 \
        scb=0.0192893 scc=0.0023049 m=(1)
mp30 (\11\:mout \5\:SN \18\:VDD VDD) g45p1lvt w=(3.1e-07) l=4.5e-08 nf=1 \
        as=1.1945e-13 ad=6.51e-14 ps=1.55e-06 pd=1.04e-06 nrd=1.16667 \
        nrs=1.16667 sa=8.75e-07 sb=1.14e-06 sd=160n sca=22.2698 \
        scb=0.0192893 scc=0.0023049 m=(1)
mp35 (net425 mout \18\:VDD VDD) g45p1lvt w=(3.1e-07) l=4.5e-08 nf=1 \
        as=1.1945e-13 ad=6.045e-14 ps=1.55e-06 pd=1.01e-06 nrd=1.16667 \
        nrs=1.16667 sa=1.255e-06 sb=7.6e-07 sd=160n sca=22.2698 \
        scb=0.0192893 scc=0.0023049 m=(1)
mp36 (\5\:n20 \9\:CKb net425 VDD) g45p1lvt w=(3.1e-07) l=4.5e-08 nf=1 \
        as=6.045e-14 ad=9.455e-14 ps=1.01e-06 pd=1.23e-06 nrd=1.16667 \
        nrs=1.16667 sa=1.495e-06 sb=5.2e-07 sd=160n sca=22.2698 \
        scb=0.0192893 scc=0.0023049 m=(1)
mp25 (\5\:n20 \7\:CKbb \7\:Db VDD) g45p1lvt w=(3.1e-07) l=4.5e-08 nf=1 \
        as=5.27e-14 ad=9.455e-14 ps=9.6e-07 pd=1.23e-06 nrd=1.16667 \
        nrs=1.16667 sa=1.845e-06 sb=1.7e-07 sd=160n sca=22.2698 \
        scb=0.0192893 scc=0.0023049 m=(1)
mp22 (\7\:RNb \1\:RN \24\:VDD VDD) g45p1lvt w=(2.15e-07) l=4.5e-08 nf=1 \
        as=1.1305e-13 ad=2.99e-14 ps=1.38e-06 pd=7.7e-07 nrd=1.16667 \
        nrs=1.16667 sa=1.3907e-07 sb=8.30349e-07 sd=160n sca=23.7894 \
        scb=0.0219499 scc=0.00260958 m=(1)
mp21 (\11\:CKbb \5\:CKb \16\:VDD VDD) g45p1lvt w=(2.15e-07) l=4.5e-08 \
        nf=1 as=3.44e-14 ad=5.052e-14 ps=7.5e-07 pd=9e-07 nrd=1.16667 \
        nrs=1.16667 sa=2.35e-07 sb=1.6e-07 sd=160n sca=12.7104 \
        scb=0.0116911 scc=0.00042519 m=(1)
mp20 (\18\:CKb \1\:CK \14\:VDD VDD) g45p1lvt w=(2.15e-07) l=4.5e-08 nf=1 \
        as=5.19e-14 ad=3.01e-14 ps=1.1e-06 pd=7.1e-07 nrd=1.16667 \
        nrs=1.16667 sa=1.4e-07 sb=1.04e-06 sd=160n sca=10.718 \
        scb=0.00841932 scc=0.00013813 m=(1)
mp10 (\8\:SEb \7\:SE \12\:VDD VDD) g45p1lvt w=(2.15e-07) l=4.5e-08 nf=1 \
        as=5.19e-14 ad=3.01e-14 ps=1.1e-06 pd=7.1e-07 nrd=1.16667 \
        nrs=1.16667 sa=1.04e-06 sb=1.4e-07 sd=160n sca=14.5503 \
        scb=0.0131195 scc=0.000188015 m=(1)
ends SDFFSRHQX1
// End of subcircuit definition.
