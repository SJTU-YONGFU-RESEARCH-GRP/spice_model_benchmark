// Generated for: spectre (May  1 08:12:31 2013 )
// Library name: gsclib045
// Cell name: SRDFFNQX1
// View name: extracted

simulator lang=spectre

subckt SRDFFNQX1 CKN D ExtVDD Q RT SE SI VDD VSS
mp10 (\8\:SEb \3\:SE \12\:VDD VDD) g45p1svt w=(2.15e-07) l=4.5e-08 nf=1 \
        as=3.44e-14 ad=3.01e-14 ps=7.5e-07 pd=7.1e-07 nrd=1.16667 \
        nrs=1.16667 sa=7.9e-07 sb=1.4e-07 sd=160n sca=34.2363 \
        scb=0.0392303 scc=0.00368484 m=(1)
mp21 (\12\:CKNbb \6\:CKNb \19\:VDD VDD) g45p1svt w=(2.15e-07) l=4.5e-08 \
        nf=1 as=1.362e-13 ad=3.01e-14 ps=2.93e-06 pd=7.1e-07 nrd=1.16667 \
        nrs=1.16667 sa=1.4e-07 sb=3.45e-07 sd=160n sca=15.238 \
        scb=0.0153511 scc=0.00103803 m=(1)
mp20 (\22\:CKNb \4\:CKN \19\:VDD VDD) g45p1svt w=(2.15e-07) l=4.5e-08 \
        nf=1 as=3.01e-14 ad=1.362e-13 ps=7.1e-07 pd=2.93e-06 nrd=1.16667 \
        nrs=1.16667 sa=3.45e-07 sb=1.4e-07 sd=160n sca=14.7851 \
        scb=0.0152025 scc=0.00103799 m=(1)
mp11 (n1 \4\:D \19\:VDD VDD) g45p1svt w=(2.15e-07) l=4.5e-08 nf=1 \
        as=1.362e-13 ad=1.29e-14 ps=2.93e-06 pd=5.5e-07 nrd=1.16667 \
        nrs=1.16667 sa=1.7e-07 sb=7.6e-07 sd=160n sca=15.238 scb=0.0153511 \
        scc=0.00103803 m=(1)
mp25 (\9\:n20 \4\:CKNb \5\:Db VDD) g45p1svt w=(2.15e-07) l=4.5e-08 nf=1 \
        as=3.01e-14 ad=3.01e-14 ps=7.1e-07 pd=7.1e-07 nrd=1.16667 \
        nrs=1.16667 sa=1.4e-07 sb=1.4e-07 sd=160n sca=20.1774 \
        scb=0.0226612 scc=0.00118174 m=(1)
mp36 (\12\:n20 \8\:CKNbb n7 VDD) g45p1svt w=(2.15e-07) l=4.5e-08 nf=1 \
        as=1.29e-14 ad=3.01e-14 ps=5.5e-07 pd=7.1e-07 nrd=1.16667 \
        nrs=1.16667 sa=1.4e-07 sb=2.95e-07 sd=160n sca=6.7773 \
        scb=0.0027674 scc=1.42147e-05 m=(1)
mp35 (n7 mout \17\:VDD VDD) g45p1svt w=(2.15e-07) l=4.5e-08 nf=1 \
        as=4.085e-14 ad=1.29e-14 ps=8.1e-07 pd=5.5e-07 nrd=1.16667 \
        nrs=1.16667 sa=2.45e-07 sb=1.9e-07 sd=160n sca=6.40652 \
        scb=0.0025693 scc=1.40931e-05 m=(1)
mp32 (\16\:mout \3\:n20 \14\:VDD VDD) g45p1svt w=(2.15e-07) l=4.5e-08 \
        nf=1 as=3.01e-14 ad=3.01e-14 ps=7.1e-07 pd=7.1e-07 nrd=1.16667 \
        nrs=1.16667 sa=1.4e-07 sb=1.4e-07 sd=160n sca=6.37787 \
        scb=0.00255822 scc=1.40897e-05 m=(1)
mp12 (\3\:Db \4\:SE n1 VDD) g45p1svt w=(2.15e-07) l=4.5e-08 nf=1 \
        as=1.29e-14 ad=3.44e-14 ps=5.5e-07 pd=7.5e-07 nrd=1.16667 \
        nrs=1.16667 sa=2.75e-07 sb=6.55e-07 sd=160n sca=15.6684 \
        scb=0.0156302 scc=0.00103829 m=(1)
mp14 (\3\:Db SEb n3 VDD) g45p1svt w=(2.15e-07) l=4.5e-08 nf=1 as=1.29e-14 \
        ad=3.44e-14 ps=5.5e-07 pd=7.5e-07 nrd=1.16667 nrs=1.16667 \
        sa=4.8e-07 sb=4.5e-07 sd=160n sca=17.3611 scb=0.0177712 \
        scc=0.00105096 m=(1)
mp13 (n3 \3\:SI \12\:VDD VDD) g45p1svt w=(2.15e-07) l=4.5e-08 nf=1 \
        as=3.44e-14 ad=1.29e-14 ps=7.5e-07 pd=5.5e-07 nrd=1.16667 \
        nrs=1.16667 sa=5.85e-07 sb=3.45e-07 sd=160n sca=19.3151 \
        scb=0.0211393 scc=0.00112289 m=(1)
mp40 (\8\:n35 \7\:CKNbb \5\:mout VDD) g45p1svt w=(2.15e-07) l=4.5e-08 \
        nf=1 as=3.01e-14 ad=3.01e-14 ps=7.1e-07 pd=7.1e-07 nrd=1.16667 \
        nrs=1.16667 sa=1.4e-07 sb=1.4e-07 sd=160n sca=25.5298 \
        scb=0.0265038 scc=0.00266093 m=(1)
PM0 (\6\:n35g \6\:RT \10\:n35 ExtVDD) g45p1svt w=(2.15e-07) l=4.5e-08 \
        nf=1 as=3.01e-14 ad=3.01e-14 ps=7.1e-07 pd=7.1e-07 nrd=1.16667 \
        nrs=1.16667 sa=1.4e-07 sb=1.4e-07 sd=160n sca=25.8707 \
        scb=0.0268423 scc=0.00266528 m=(1)
mp45 (\14\:qbint \3\:n35g \1\:ExtVDD ExtVDD) g45p1svt w=(2.15e-07) \
        l=4.5e-08 nf=1 as=3.3457e-13 ad=3.01e-14 ps=3.53e-06 pd=7.1e-07 \
        nrd=1.16667 nrs=1.16667 sa=1.4e-07 sb=8.7e-07 sd=160n sca=25.2796 \
        scb=0.0259458 scc=0.00265434 m=(1)
PM2 (net234 \4\:qbint \1\:ExtVDD ExtVDD) g45p1svt w=(2.15e-07) l=4.5e-08 \
        nf=1 as=3.3457e-13 ad=1.29e-14 ps=3.53e-06 pd=5.5e-07 nrd=1.16667 \
        nrs=1.16667 sa=7.65e-07 sb=2.45e-07 sd=160n sca=14.5295 \
        scb=0.0144143 scc=0.000486924 m=(1)
PM1 (\6\:RTb \8\:RT \1\:ExtVDD ExtVDD) g45p1svt w=(2.15e-07) l=4.5e-08 \
        nf=1 as=3.3457e-13 ad=3.01e-14 ps=3.53e-06 pd=7.1e-07 nrd=1.16667 \
        nrs=1.16667 sa=3.1e-07 sb=1.4e-07 sd=160n sca=24.1603 \
        scb=0.0255449 scc=0.00228436 m=(1)
PM3 (\15\:n35g \4\:RTb net234 ExtVDD) g45p1svt w=(2.15e-07) l=4.5e-08 \
        nf=1 as=1.29e-14 ad=3.01e-14 ps=5.5e-07 pd=7.1e-07 nrd=1.16667 \
        nrs=1.16667 sa=8.7e-07 sb=1.4e-07 sd=160n sca=25.2796 \
        scb=0.0259458 scc=0.00265434 m=(1)
mp53 (\15\:n35 \14\:CKNb net0107 VDD) g45p1svt w=(2.15e-07) l=4.5e-08 \
        nf=1 as=1.29e-14 ad=3.01e-14 ps=5.5e-07 pd=7.1e-07 nrd=1.16667 \
        nrs=1.16667 sa=1.4e-07 sb=2.45e-07 sd=160n sca=30.843 \
        scb=0.0336528 scc=0.00282492 m=(1)
mp52 (net0107 \10\:qbint \10\:VDD VDD) g45p1svt w=(2.15e-07) l=4.5e-08 \
        nf=1 as=3.01e-14 ad=1.29e-14 ps=7.1e-07 pd=5.5e-07 nrd=1.16667 \
        nrs=1.16667 sa=2.45e-07 sb=1.4e-07 sd=160n sca=21.6956 \
        scb=0.0252605 scc=0.000723352 m=(1)
C1 (RT VSS) capacitor c=6.80716e-17
C2 (D VSS) capacitor c=7.22443e-17
C3 (Q VSS) capacitor c=2.0334e-17
C4 (SI VSS) capacitor c=8.17875e-17
C5 (VDD VSS) capacitor c=6.31149e-16
C6 (CKN VSS) capacitor c=4.04338e-17
C7 (ExtVDD VSS) capacitor c=1.78441e-16
C8 (SE VSS) capacitor c=8.86173e-17
C9 (n20 VSS) capacitor c=3.87782e-17
C10 (CKNb VSS) capacitor c=2.32287e-17
C11 (CKNbb VSS) capacitor c=4.63145e-17
C12 (mout VSS) capacitor c=4.77817e-17
C13 (n35 VSS) capacitor c=1.46232e-16
C14 (SEb VSS) capacitor c=7.74542e-17
C15 (n35g VSS) capacitor c=1.8069e-17
C16 (qbint VSS) capacitor c=4.78638e-17
C17 (RTb VSS) capacitor c=4.23098e-17
C18 (Db VSS) capacitor c=9.61384e-17
C19 (n1 VSS) capacitor c=1.39914e-18
C20 (\9\:qbint VSS) capacitor c=2.81469e-17
C21 (\10\:qbint VSS) capacitor c=2.0007e-16
C22 (\14\:CKNb VSS) capacitor c=8.75021e-17
C23 (\4\:RTb VSS) capacitor c=9.89285e-17
C24 (\8\:RT VSS) capacitor c=2.27433e-17
C25 (\4\:qbint VSS) capacitor c=6.90373e-17
C26 (\3\:n35g VSS) capacitor c=5.08916e-17
C27 (\6\:RT VSS) capacitor c=7.81418e-17
C28 (\3\:SE VSS) capacitor c=7.79625e-17
C29 (\7\:CKNbb VSS) capacitor c=2.81119e-17
C30 (\3\:SI VSS) capacitor c=9.50598e-17
C31 (\4\:SE VSS) capacitor c=1.25798e-16
C32 (\4\:D VSS) capacitor c=6.96005e-17
C33 (\3\:n20 VSS) capacitor c=2.87547e-17
C34 (\4\:CKN VSS) capacitor c=4.43038e-17
C35 (\6\:CKNb VSS) capacitor c=4.23091e-17
C36 (\8\:CKNbb VSS) capacitor c=8.32806e-17
C37 (\4\:CKNb VSS) capacitor c=1.06769e-16
C38 (\6\:qbint VSS) capacitor c=3.13902e-17
C39 (\11\:qbint VSS) capacitor c=9.13947e-17
C40 (\3\:CKNbb VSS) capacitor c=3.37229e-16
C41 (\7\:RT VSS) capacitor c=1.68984e-16
C42 (\1\:RT VSS) capacitor c=4.29416e-17
C43 (\5\:qbint VSS) capacitor c=3.91065e-17
C44 (\5\:n35g VSS) capacitor c=2.90763e-17
C45 (\5\:SE VSS) capacitor c=5.74851e-17
C46 (\8\:CKNb VSS) capacitor c=2.46061e-17
C47 (\1\:SI VSS) capacitor c=4.92893e-17
C48 (\6\:SE VSS) capacitor c=8.71616e-17
C49 (\3\:SEb VSS) capacitor c=6.75337e-17
C50 (\1\:D VSS) capacitor c=4.92962e-17
C51 (\6\:n20 VSS) capacitor c=5.28515e-17
C52 (\1\:CKN VSS) capacitor c=4.31895e-17
C53 (\3\:mout VSS) capacitor c=4.56231e-17
C54 (\5\:CKNb VSS) capacitor c=3.00524e-17
C55 (\13\:CKNb VSS) capacitor c=4.98591e-17
C56 (\2\:CKNbb VSS) capacitor c=4.40872e-17
C57 (\15\:CKNb VSS) capacitor c=5.65089e-17
C58 (\12\:CKNb VSS) capacitor c=1.1872e-16
C59 (\8\:qbint VSS) capacitor c=1.09089e-16
C60 (\3\:RT VSS) capacitor c=1.68203e-16
C61 (\3\:RTb VSS) capacitor c=7.33659e-17
C62 (\4\:RT VSS) capacitor c=4.36093e-17
C63 (\2\:RT VSS) capacitor c=3.75524e-17
C64 (\3\:qbint VSS) capacitor c=3.56031e-17
C65 (\2\:RTb VSS) capacitor c=3.74906e-17
C66 (\2\:n35 VSS) capacitor c=1.65625e-16
C67 (\4\:n35g VSS) capacitor c=6.8649e-17
C68 (\3\:n35 VSS) capacitor c=4.1279e-17
C69 (\1\:SE VSS) capacitor c=2.47457e-17
C70 (\2\:SI VSS) capacitor c=7.71868e-17
C71 (\2\:SEb VSS) capacitor c=7.60682e-17
C72 (\3\:D VSS) capacitor c=1.50359e-17
C73 (\3\:CKN VSS) capacitor c=2.60565e-17
C74 (\2\:mout VSS) capacitor c=3.65021e-17
C75 (\4\:mout VSS) capacitor c=3.00583e-17
C76 (\6\:CKNbb VSS) capacitor c=4.12944e-17
C77 (\5\:n20 VSS) capacitor c=6.79248e-17
C78 (\7\:CKNb VSS) capacitor c=7.26232e-17
C79 (\11\:CKNb VSS) capacitor c=2.58816e-17
C80 (\2\:n20 VSS) capacitor c=3.96498e-17
C81 (\1\:VDD VSS) capacitor c=4.42806e-17
C82 (\10\:VDD VSS) capacitor c=2.50347e-17
C83 (\1\:Q VSS) capacitor c=6.12659e-17
C84 (\15\:n35 VSS) capacitor c=4.30044e-17
C85 (\15\:n35g VSS) capacitor c=4.76341e-17
C86 (\6\:RTb VSS) capacitor c=5.91972e-17
C87 (\1\:ExtVDD VSS) capacitor c=2.9035e-16
C88 (\10\:n35 VSS) capacitor c=5.10197e-17
C89 (\14\:qbint VSS) capacitor c=6.94384e-17
C90 (\6\:n35g VSS) capacitor c=8.64132e-17
C91 (\8\:SEb VSS) capacitor c=5.31391e-17
C92 (\8\:n35 VSS) capacitor c=4.55302e-17
C93 (\12\:VDD VSS) capacitor c=6.42149e-17
C94 (\5\:mout VSS) capacitor c=4.36869e-17
C95 (\3\:Db VSS) capacitor c=1.84682e-16
C96 (\14\:VDD VSS) capacitor c=3.6981e-17
C97 (\19\:VDD VSS) capacitor c=3.55509e-17
C98 (\16\:mout VSS) capacitor c=4.21884e-17
C99 (\22\:CKNb VSS) capacitor c=4.61501e-17
C100 (\17\:VDD VSS) capacitor c=4.46807e-17
C101 (\12\:CKNbb VSS) capacitor c=4.26717e-17
C102 (\12\:n20 VSS) capacitor c=6.21367e-17
C103 (\5\:Db VSS) capacitor c=2.09515e-16
C104 (\9\:n20 VSS) capacitor c=6.32054e-17
C105 (\3\:Q VSS) capacitor c=4.60488e-17
C106 (\18\:n35 VSS) capacitor c=6.0336e-17
C107 (\11\:n35g VSS) capacitor c=2.94655e-17
C108 (\10\:RTb VSS) capacitor c=5.24407e-17
C109 (\13\:n35 VSS) capacitor c=5.56444e-17
C110 (\16\:qbint VSS) capacitor c=2.41317e-17
C111 (\9\:n35g VSS) capacitor c=6.72904e-17
C112 (\4\:SEb VSS) capacitor c=3.8295e-17
C113 (\6\:n35 VSS) capacitor c=5.32831e-17
C114 (\12\:mout VSS) capacitor c=4.90368e-17
C115 (\14\:mout VSS) capacitor c=3.68422e-17
C116 (\18\:CKNb VSS) capacitor c=4.30134e-17
C117 (\9\:CKNbb VSS) capacitor c=3.9473e-17
C118 (\16\:n20 VSS) capacitor c=8.771e-17
C119 (\7\:Db VSS) capacitor c=9.05859e-17
C120 (\7\:n20 VSS) capacitor c=5.93608e-17
C121 (\2\:CKNb VSS) capacitor c=3.83832e-17
C122 (\3\:CKNb VSS) capacitor c=5.01055e-17
C123 (\2\:CKN VSS) capacitor c=3.82447e-17
C124 (\4\:n20 VSS) capacitor c=6.55485e-17
C125 (\2\:D VSS) capacitor c=3.55097e-17
C126 (VDD VSS) capacitor c=2.28305e-16
C127 (\2\:SE VSS) capacitor c=2.5864e-17
C128 (\2\:n35g VSS) capacitor c=2.91553e-17
C129 (ExtVDD VSS) capacitor c=3.95139e-17
C130 (\2\:qbint VSS) capacitor c=4.10779e-17
C131 (\5\:RT VSS) capacitor c=5.38707e-17
C132 (\9\:CKNb VSS) capacitor c=1.39878e-16
C133 (\10\:CKNb VSS) capacitor c=7.669e-17
C134 (\4\:CKNbb VSS) capacitor c=3.35182e-16
C135 (\5\:CKNbb VSS) capacitor c=8.64355e-17
C136 (\7\:qbint VSS) capacitor c=2.5873e-17
C137 (\11\:n20 VSS) capacitor c=4.63756e-17
C138 (\16\:CKNb VSS) capacitor c=9.84071e-17
C139 (\17\:CKNb VSS) capacitor c=9.61603e-17
C140 (\14\:n20 VSS) capacitor c=5.22387e-17
C141 (\15\:n20 VSS) capacitor c=9.0494e-17
C142 (\14\:CKNbb VSS) capacitor c=5.59904e-17
C143 (\15\:CKNbb VSS) capacitor c=9.09257e-17
C144 (\6\:CKN VSS) capacitor c=4.16921e-18
C145 (\7\:CKN VSS) capacitor c=3.91272e-17
C146 (\20\:CKNb VSS) capacitor c=6.23293e-17
C147 (\21\:CKNb VSS) capacitor c=5.19315e-17
C148 (\7\:mout VSS) capacitor c=6.47379e-17
C149 (\8\:mout VSS) capacitor c=3.81373e-17
C150 (\9\:mout VSS) capacitor c=2.43216e-17
C151 (\10\:mout VSS) capacitor c=4.23783e-17
C152 (\11\:mout VSS) capacitor c=4.24693e-17
C153 (\18\:mout VSS) capacitor c=2.54297e-17
C154 (\6\:SEb VSS) capacitor c=7.01782e-17
C155 (\7\:SEb VSS) capacitor c=8.00332e-17
C156 (\4\:n35 VSS) capacitor c=4.34536e-17
C157 (\5\:n35 VSS) capacitor c=7.91073e-17
C158 (\8\:n35g VSS) capacitor c=3.42149e-17
C159 (\12\:n35 VSS) capacitor c=6.04137e-17
C160 (\12\:qbint VSS) capacitor c=8.84325e-17
C161 (\13\:qbint VSS) capacitor c=1.11631e-16
C162 (\13\:n35g VSS) capacitor c=1.13975e-16
C163 (\14\:n35g VSS) capacitor c=1.1648e-16
C164 (\9\:RT VSS) capacitor c=6.71625e-17
C165 (\10\:RT VSS) capacitor c=6.12582e-17
C166 (\5\:RTb VSS) capacitor c=3.83582e-17
C167 (\8\:RTb VSS) capacitor c=1.11322e-16
C168 (\9\:RTb VSS) capacitor c=6.89661e-17
C169 (\18\:qbint VSS) capacitor c=1.81684e-17
C170 (\19\:qbint VSS) capacitor c=3.08513e-17
C171 (\24\:CKNb VSS) capacitor c=1.20909e-16
C172 (\25\:CKNb VSS) capacitor c=9.5007e-17
C173 (\17\:n35 VSS) capacitor c=6.15779e-17
C174 (\3\:VDD VSS) capacitor c=1.16028e-17
C175 (\5\:VDD VSS) capacitor c=1.34028e-16
C176 (\6\:VDD VSS) capacitor c=6.8288e-17
C177 (\7\:VDD VSS) capacitor c=2.54789e-17
C178 (\9\:VDD VSS) capacitor c=3.29977e-17
C179 (\16\:VDD VSS) capacitor c=4.73514e-17
Rk55 (\9\:RT \10\:RT) resistor r=0.4452 c=0
Rk60 (RT \11\:RT) resistor r=0.006191 c=0
Rk67 (\2\:VSS \4\:VSS) resistor r=0.3025 c=0
Rk68 (\4\:VSS \5\:VSS) resistor r=0.709 c=0
Rk69 (\5\:VSS \7\:VSS) resistor r=0.1891 c=0
Rk70 (\5\:VSS \8\:VSS) resistor r=0.03452 c=0
Rk73 (\9\:VSS VSS) resistor r=0.2723 c=0
Rk71 (\8\:VSS \9\:VSS) resistor r=0.1734 c=0
Rk72 (\9\:VSS \11\:VSS) resistor r=0.1942 c=0
Rk74 (VSS \12\:VSS) resistor r=0.3695 c=0
Rk75 (\12\:VSS \14\:VSS) resistor r=0.2387 c=0
Rk76 (\12\:VSS \15\:VSS) resistor r=0.3071 c=0
Rk77 (\15\:VSS \17\:VSS) resistor r=0.2488 c=0
Rk79 (\18\:VSS VSS) resistor r=0.1188 c=0
Rk78 (\15\:VSS \18\:VSS) resistor r=0.06676 c=0
Rk80 (VSS \20\:VSS) resistor r=0.3161 c=0
Rk94 (\22\:VSS \24\:VSS) resistor r=0.2773 c=0
Rk95 (\24\:VSS \25\:VSS) resistor r=0.682 c=0
Rk97 (\26\:VSS VSS) resistor r=0.4461 c=0
Rk96 (\25\:VSS \26\:VSS) resistor r=0.0618 c=0
Rk98 (VSS \27\:VSS) resistor r=0.7018 c=0
Rk100 (\28\:VSS VSS) resistor r=0.1188 c=0
Rk99 (\27\:VSS \28\:VSS) resistor r=0.04196 c=0
Rk101 (VSS \30\:VSS) resistor r=0.2919 c=0
Rk102 (\25\:VSS \32\:VSS) resistor r=0.3177 c=0
Rk103 (\27\:VSS \34\:VSS) resistor r=0.2398 c=0
Rk65 (Q \2\:Q) resistor r=0.2845 c=0
Rk66 (Q \4\:Q) resistor r=0.2212 c=0
Rk81 (\2\:VDD \3\:VDD) resistor r=0.4114 c=0
Rk83 (\5\:VDD VDD) resistor r=1.1255 c=0
Rk82 (\3\:VDD \5\:VDD) resistor r=0.07297 c=0
Rk84 (VDD \6\:VDD) resistor r=0.3695 c=0
Rk85 (\6\:VDD \7\:VDD) resistor r=0.2302 c=0
Rk86 (\7\:VDD \9\:VDD) resistor r=0.1095 c=0
Rk87 (\3\:VDD \11\:VDD) resistor r=0.2967 c=0
Rk88 (\6\:VDD \13\:VDD) resistor r=0.3661 c=0
Rk89 (\7\:VDD \15\:VDD) resistor r=0.2069 c=0
Rk93 (\16\:VDD VDD) resistor r=0.1955 c=0
Rk90 (\9\:VDD \16\:VDD) resistor r=0.1635 c=0
Rk91 (\16\:VDD \18\:VDD) resistor r=0.2109 c=0
Rk92 (\9\:VDD \20\:VDD) resistor r=0.2349 c=0
Rk11 (\5\:CKN CKN) resistor r=0.004169 c=0
Rk12 (CKN \6\:CKN) resistor r=0.00402 c=0
Rk13 (\5\:CKN \6\:CKN) resistor r=0.017 c=0
Rk14 (\6\:CKN \7\:CKN) resistor r=0.02162 c=0
Rk45 (ExtVDD ExtVDD) resistor r=0.002061 c=0
Rk43 (\2\:ExtVDD ExtVDD) resistor r=0.02215 c=0
Rk46 (ExtVDD \5\:ExtVDD) resistor r=0.02014 c=0
Rk47 (ExtVDD \6\:ExtVDD) resistor r=0.1496 c=0
Rk48 (\7\:ExtVDD \8\:ExtVDD) resistor r=0.02877 c=0
Rk1 (\8\:n20 \10\:n20) resistor r=0.543 c=0
Rk2 (\10\:n20 \11\:n20) resistor r=0.2541 c=0
Rk4 (\13\:n20 \14\:n20) resistor r=0.3402 c=0
Rk5 (\13\:n20 \15\:n20) resistor r=0.2294 c=0
Rk6 (\15\:n20 \17\:n20) resistor r=0.4962 c=0
Rk3 (\16\:CKNb \17\:CKNb) resistor r=0.7511 c=0
Rk15 (\19\:CKNb \20\:CKNb) resistor r=0.1959 c=0
Rk16 (\20\:CKNb \21\:CKNb) resistor r=0.164 c=0
Rk17 (\20\:CKNb \23\:CKNb) resistor r=0.3045 c=0
Rk62 (\24\:CKNb \25\:CKNb) resistor r=0.865 c=0
Rk7 (\10\:CKNbb \11\:CKNbb) resistor r=0.2047 c=0
Rk8 (\11\:CKNbb \13\:CKNbb) resistor r=0.3459 c=0
Rk9 (\13\:CKNbb \14\:CKNbb) resistor r=0.1876 c=0
Rk10 (\11\:CKNbb \15\:CKNbb) resistor r=0.02352 c=0
Rk22 (\6\:mout \7\:mout) resistor r=0.2473 c=0
Rk23 (\7\:mout \8\:mout) resistor r=0.2979 c=0
Rk24 (\8\:mout \9\:mout) resistor r=0.1546 c=0
Rk25 (\9\:mout \10\:mout) resistor r=0.276 c=0
Rk26 (\10\:mout \11\:mout) resistor r=0.3228 c=0
Rk27 (\7\:mout \13\:mout) resistor r=0.4826 c=0
Rk28 (\8\:mout \15\:mout) resistor r=0.4166 c=0
Rk29 (\9\:mout \17\:mout) resistor r=0.207 c=0
Rk30 (\10\:mout \18\:mout) resistor r=0.08796 c=0
Rk36 (\4\:n35 \5\:n35) resistor r=0.4438 c=0
Rk37 (\5\:n35 \7\:n35) resistor r=0.4427 c=0
Rk38 (\5\:n35 \9\:n35) resistor r=0.2871 c=0
Rk41 (\11\:n35 \12\:n35) resistor r=0.2725 c=0
Rk42 (\12\:n35 \14\:n35) resistor r=0.3277 c=0
Rk63 (\16\:n35 \17\:n35) resistor r=0.1704 c=0
Rk64 (\17\:n35 \19\:n35) resistor r=0.4274 c=0
Rk33 (\5\:SEb \6\:SEb) resistor r=0.202 c=0
Rk34 (\6\:SEb \7\:SEb) resistor r=0.3837 c=0
Rk35 (\6\:SEb \9\:SEb) resistor r=0.2944 c=0
Rk39 (\7\:n35g \8\:n35g) resistor r=0.2295 c=0
Rk40 (\7\:n35g \10\:n35g) resistor r=0.5918 c=0
Rk52 (\12\:n35g \13\:n35g) resistor r=0.2429 c=0
Rk53 (\13\:n35g \14\:n35g) resistor r=0.5654 c=0
Rk54 (\13\:n35g \16\:n35g) resistor r=0.4319 c=0
Rk49 (\12\:qbint \13\:qbint) resistor r=0.4944 c=0
Rk50 (\13\:qbint \15\:qbint) resistor r=0.567 c=0
Rk51 (\13\:qbint \17\:qbint) resistor r=0.1463 c=0
Rk61 (\18\:qbint \19\:qbint) resistor r=0.2118 c=0
Rk56 (\5\:RTb \7\:RTb) resistor r=0.2266 c=0
Rk57 (\7\:RTb \8\:RTb) resistor r=0.2733 c=0
Rk58 (\8\:RTb \9\:RTb) resistor r=0.6753 c=0
Rk59 (\8\:RTb \11\:RTb) resistor r=0.3344 c=0
Rk19 (\2\:Db \4\:Db) resistor r=0.5996 c=0
Rk20 (\4\:Db \6\:Db) resistor r=1.3537 c=0
Rk21 (\6\:Db \8\:Db) resistor r=0.5686 c=0
Rl43 (\3\:RT \7\:RT) resistor r=709.9 c=0
Rl40 (\3\:RT \4\:RT) resistor r=72.2057 c=0
Rl34 (\1\:RT \2\:RT) resistor r=125.877 c=0
Rl44 (\5\:RT \8\:RT) resistor r=30.9873 c=0
Rl42 (\5\:RT \6\:RT) resistor r=273.765 c=0
Rl41 (\4\:RT \5\:RT) resistor r=78.204 c=0
Rl19 (\2\:D \4\:D) resistor r=115.099 c=0
Rl17 (\1\:D \2\:D) resistor r=84.3295 c=0
Rl18 (\2\:D \3\:D) resistor r=5.1123 c=0
Rl23 (\2\:SI \3\:SI) resistor r=155.002 c=0
Rl22 (\1\:SI \2\:SI) resistor r=24.2328 c=0
Rl13 (\2\:CKN \4\:CKN) resistor r=70.868 c=0
Rl11 (\1\:CKN \2\:CKN) resistor r=140.099 c=0
Rl12 (\2\:CKN \3\:CKN) resistor r=2.0166 c=0
Rl26 (\3\:SE \4\:SE) resistor r=294.192 c=0
Rl28 (\5\:SE \6\:SE) resistor r=241.873 c=0
Rl25 (\2\:SE \3\:SE) resistor r=49.6369 c=0
Rl27 (\2\:SE \5\:SE) resistor r=147.714 c=0
Rl24 (\1\:SE \2\:SE) resistor r=0.767 c=0
Rl1 (n20 \2\:n20) resistor r=123.512 c=0
Rl14 (\3\:n20 \4\:n20) resistor r=83.1175 c=0
Rl16 (\4\:n20 \6\:n20) resistor r=197.322 c=0
Rl15 (\4\:n20 \5\:n20) resistor r=244.414 c=0
Rl52 (\14\:CKNb \15\:CKNb) resistor r=115.79 c=0
Rl8 (\4\:CKNb \7\:CKNb) resistor r=330.626 c=0
Rl6 (\2\:CKNb \5\:CKNb) resistor r=73.8796 c=0
Rl3 (CKNb \2\:CKNb) resistor r=0.6084 c=0
Rl7 (\3\:CKNb \6\:CKNb) resistor r=36.5135 c=0
Rl5 (\3\:CKNb \4\:CKNb) resistor r=174.664 c=0
Rl4 (\2\:CKNb \3\:CKNb) resistor r=95.0085 c=0
Rl45 (\8\:CKNb \9\:CKNb) resistor r=66.1349 c=0
Rl48 (\9\:CKNb \12\:CKNb) resistor r=866.299 c=0
Rl49 (\10\:CKNb \13\:CKNb) resistor r=60.7265 c=0
Rl47 (\10\:CKNb \11\:CKNb) resistor r=81.3209 c=0
Rl46 (\9\:CKNb \10\:CKNb) resistor r=462.851 c=0
Rl2 (CKNbb \2\:CKNbb) resistor r=148.93 c=0
Rl56 (\4\:CKNbb \7\:CKNbb) resistor r=127.816 c=0
Rl53 (\3\:CKNbb \4\:CKNbb) resistor r=1432.7 c=0
Rl57 (\5\:CKNbb \8\:CKNbb) resistor r=128.908 c=0
Rl55 (\5\:CKNbb \6\:CKNbb) resistor r=81.3688 c=0
Rl54 (\4\:CKNbb \5\:CKNbb) resistor r=453.624 c=0
Rl9 (mout \2\:mout) resistor r=24.2328 c=0
Rl10 (\3\:mout \4\:mout) resistor r=24.2328 c=0
Rl50 (n35 \2\:n35) resistor r=499.328 c=0
Rl51 (\2\:n35 \3\:n35) resistor r=104.689 c=0
Rl20 (SEb \2\:SEb) resistor r=101.718 c=0
Rl21 (\2\:SEb \3\:SEb) resistor r=132.669 c=0
Rl31 (\3\:n35g \4\:n35g) resistor r=241.174 c=0
Rl30 (\2\:n35g \3\:n35g) resistor r=181.74 c=0
Rl32 (\2\:n35g \5\:n35g) resistor r=94.1963 c=0
Rl29 (n35g \2\:n35g) resistor r=2.4834 c=0
Rl62 (\10\:qbint \11\:qbint) resistor r=235.906 c=0
Rl61 (\8\:qbint \10\:qbint) resistor r=601.135 c=0
Rl39 (\3\:qbint \5\:qbint) resistor r=35.3072 c=0
Rl38 (\2\:qbint \4\:qbint) resistor r=148.502 c=0
Rl36 (qbint \2\:qbint) resistor r=112.732 c=0
Rl37 (\2\:qbint \3\:qbint) resistor r=74.1915 c=0
Rl60 (\7\:qbint \9\:qbint) resistor r=68.607 c=0
Rl58 (\6\:qbint \7\:qbint) resistor r=78.0039 c=0
Rl59 (\7\:qbint \8\:qbint) resistor r=166.462 c=0
Rl35 (\3\:RTb \4\:RTb) resistor r=242.199 c=0
Rl33 (RTb \2\:RTb) resistor r=124.312 c=0
Rz19 (\1\:VSS \2\:VSS) resistor r=37.5 c=0
Rz20 (\6\:VSS \7\:VSS) resistor r=75 c=0
Rz21 (\10\:VSS \11\:VSS) resistor r=75 c=0
Rz22 (\13\:VSS \14\:VSS) resistor r=75 c=0
Rz23 (\16\:VSS \17\:VSS) resistor r=75 c=0
Rz24 (\19\:VSS \20\:VSS) resistor r=75 c=0
Rz27 (\21\:VSS \22\:VSS) resistor r=75 c=0
Rz28 (\29\:VSS \30\:VSS) resistor r=75 c=0
Rz29 (\31\:VSS \32\:VSS) resistor r=75 c=0
Rz30 (\33\:VSS \34\:VSS) resistor r=75 c=0
Rz18 (\3\:Q \4\:Q) resistor r=37.5 c=0
Rz1 (\7\:n20 \8\:n20) resistor r=75 c=0
Rz2 (\16\:n20 \17\:n20) resistor r=75 c=0
Rz4 (\18\:CKNb \19\:CKNb) resistor r=75 c=0
Rz3 (\9\:CKNbb \10\:CKNbb) resistor r=75 c=0
Rz7 (\12\:mout \13\:mout) resistor r=75 c=0
Rz8 (\14\:mout \15\:mout) resistor r=75 c=0
Rz10 (\6\:n35 \7\:n35) resistor r=75 c=0
Rz12 (\13\:n35 \14\:n35) resistor r=75 c=0
Rz17 (\18\:n35 \19\:n35) resistor r=75 c=0
Rz9 (\4\:SEb \5\:SEb) resistor r=75 c=0
Rz11 (\9\:n35g \10\:n35g) resistor r=75 c=0
Rz15 (\11\:n35g \12\:n35g) resistor r=75 c=0
Rz14 (\16\:qbint \17\:qbint) resistor r=75 c=0
Rz16 (\10\:RTb \11\:RTb) resistor r=75 c=0
Rz5 (Db \2\:Db) resistor r=75 c=0
Rz6 (\7\:Db \8\:Db) resistor r=75 c=0
Ry23 (\3\:VSS \4\:VSS) resistor r=20.6667 c=0
Ry24 (\3\:VSS \8\:VSS) resistor r=5.1667 c=0
Ry25 (\3\:VSS \18\:VSS) resistor r=5.1667 c=0
Ry32 (\23\:VSS \24\:VSS) resistor r=20.6667 c=0
Ry33 (\23\:VSS \26\:VSS) resistor r=5.1667 c=0
Ry34 (\23\:VSS \28\:VSS) resistor r=5.1667 c=0
Ry22 (\1\:Q \2\:Q) resistor r=20.6667 c=0
Ry26 (\1\:VDD \2\:VDD) resistor r=20.6667 c=0
Ry27 (\10\:VDD \11\:VDD) resistor r=62 c=0
Ry28 (\12\:VDD \13\:VDD) resistor r=62 c=0
Ry29 (\14\:VDD \15\:VDD) resistor r=62 c=0
Ry30 (\17\:VDD \18\:VDD) resistor r=62 c=0
Ry31 (\19\:VDD \20\:VDD) resistor r=62 c=0
Ry13 (\1\:ExtVDD \2\:ExtVDD) resistor r=62 c=0
Ry14 (\1\:ExtVDD \5\:ExtVDD) resistor r=62 c=0
Ry15 (\1\:ExtVDD \6\:ExtVDD) resistor r=62 c=0
Ry16 (\1\:ExtVDD \7\:ExtVDD) resistor r=62 c=0
Ry17 (\1\:ExtVDD \8\:ExtVDD) resistor r=62 c=0
Ry1 (\9\:n20 \10\:n20) resistor r=62 c=0
Ry2 (\12\:n20 \13\:n20) resistor r=62 c=0
Ry4 (\22\:CKNb \23\:CKNb) resistor r=62 c=0
Ry3 (\12\:CKNbb \13\:CKNbb) resistor r=62 c=0
Ry7 (\5\:mout \6\:mout) resistor r=62 c=0
Ry8 (\16\:mout \17\:mout) resistor r=62 c=0
Ry10 (\8\:n35 \9\:n35) resistor r=62 c=0
Ry12 (\10\:n35 \11\:n35) resistor r=62 c=0
Ry21 (\15\:n35 \16\:n35) resistor r=62 c=0
Ry9 (\8\:SEb \9\:SEb) resistor r=62 c=0
Ry11 (\6\:n35g \7\:n35g) resistor r=62 c=0
Ry19 (\15\:n35g \16\:n35g) resistor r=62 c=0
Ry18 (\14\:qbint \15\:qbint) resistor r=62 c=0
Ry20 (\6\:RTb \7\:RTb) resistor r=62 c=0
Ry5 (\3\:Db \4\:Db) resistor r=62 c=0
Ry6 (\5\:Db \6\:Db) resistor r=62 c=0
Rx21 (\4\:RT \9\:RT) resistor r=45 c=0
Rx22 (\2\:RT \10\:RT) resistor r=45 c=0
Rx25 (\3\:RT \11\:RT) resistor r=45 c=0
Rx10 (\3\:D D) resistor r=45 c=0
Rx13 (\2\:SI SI) resistor r=45 c=0
Rx8 (\3\:CKN \7\:CKN) resistor r=45 c=0
Rx14 (\1\:SE SE) resistor r=45 c=0
Rx1 (n20 \11\:n20) resistor r=45 c=0
Rx4 (\2\:n20 \14\:n20) resistor r=45 c=0
Rx5 (\5\:n20 \15\:n20) resistor r=45 c=0
Rx2 (\7\:CKNb \16\:CKNb) resistor r=45 c=0
Rx3 (\11\:CKNb \17\:CKNb) resistor r=45 c=0
Rx9 (CKNb \21\:CKNb) resistor r=45 c=0
Rx28 (\15\:CKNb \24\:CKNb) resistor r=45 c=0
Rx29 (\12\:CKNb \25\:CKNb) resistor r=45 c=0
Rx6 (\6\:CKNbb \14\:CKNbb) resistor r=45 c=0
Rx7 (CKNbb \15\:CKNbb) resistor r=45 c=0
Rx11 (\4\:mout \11\:mout) resistor r=45 c=0
Rx12 (\2\:mout \18\:mout) resistor r=45 c=0
Rx16 (\3\:n35 \4\:n35) resistor r=45 c=0
Rx18 (\2\:n35 \12\:n35) resistor r=45 c=0
Rx30 (n35 \17\:n35) resistor r=45 c=0
Rx15 (\2\:SEb \7\:SEb) resistor r=45 c=0
Rx17 (\4\:n35g \8\:n35g) resistor r=45 c=0
Rx20 (n35g \14\:n35g) resistor r=45 c=0
Rx19 (\3\:qbint \12\:qbint) resistor r=45 c=0
Rx26 (\8\:qbint \18\:qbint) resistor r=45 c=0
Rx27 (qbint \19\:qbint) resistor r=45 c=0
Rx23 (\3\:RTb \5\:RTb) resistor r=45 c=0
Rx24 (\2\:RTb \9\:RTb) resistor r=45 c=0
mn13 (n2 \1\:SI \13\:VSS VSS) g45n1svt w=(1.45e-07) l=4.5e-08 nf=1 \
        as=2.32e-14 ad=8.7e-15 ps=6.1e-07 pd=4.1e-07 nrd=1.16667 \
        nrs=1.16667 sa=5.55e-07 sb=3.45e-07 sd=160n sca=8.85152 \
        scb=0.00706865 scc=0.000138481 m=(1)
mn21 (\9\:CKNbb \5\:CKNb \19\:VSS VSS) g45n1svt w=(1.45e-07) l=4.5e-08 \
        nf=1 as=2.32e-14 ad=2.03e-14 ps=6.1e-07 pd=5.7e-07 nrd=1.16667 \
        nrs=1.16667 sa=1.4e-07 sb=3.45e-07 sd=160n sca=8.0352 \
        scb=0.00565402 scc=8.19771e-05 m=(1)
mn20 (\18\:CKNb \1\:CKN \19\:VSS VSS) g45n1svt w=(1.45e-07) l=4.5e-08 \
        nf=1 as=2.03e-14 ad=2.32e-14 ps=5.7e-07 pd=6.1e-07 nrd=1.16667 \
        nrs=1.16667 sa=3.45e-07 sb=1.4e-07 sd=160n sca=8.0352 \
        scb=0.00565402 scc=8.19771e-05 m=(1)
mn10 (\4\:SEb \5\:SE \13\:VSS VSS) g45n1svt w=(1.45e-07) l=4.5e-08 nf=1 \
        as=2.32e-14 ad=2.03e-14 ps=6.1e-07 pd=5.7e-07 nrd=1.16667 \
        nrs=1.16667 sa=7.6e-07 sb=1.4e-07 sd=160n sca=8.85152 \
        scb=0.00706865 scc=0.000138481 m=(1)
NM1 (\10\:RTb \1\:RT \31\:VSS VSS) g45n1svt w=(1.45e-07) l=4.5e-08 nf=1 \
        as=2.03e-14 ad=2.97e-14 ps=5.7e-07 pd=7.1e-07 nrd=1.16667 \
        nrs=1.16667 sa=1.8e-07 sb=1.4e-07 sd=160n sca=17.8702 \
        scb=0.0189183 scc=0.00156031 m=(1)
mn12 (Db \3\:SEb n0 VSS) g45n1svt w=(1.45e-07) l=4.5e-08 nf=1 as=2.32e-14 \
        ad=8.7e-15 ps=6.1e-07 pd=4.1e-07 nrd=1.16667 nrs=1.16667 \
        sa=2.45e-07 sb=6.55e-07 sd=160n sca=8.85152 scb=0.00706865 \
        scc=0.000138481 m=(1)
mn25 (\7\:Db \2\:CKNbb \7\:n20 VSS) g45n1svt w=(1.45e-07) l=4.5e-08 nf=1 \
        as=2.03e-14 ad=2.03e-14 ps=5.7e-07 pd=5.7e-07 nrd=1.16667 \
        nrs=1.16667 sa=1.4e-07 sb=1.4e-07 sd=160n sca=8.0352 \
        scb=0.00565402 scc=8.19771e-05 m=(1)
mn36 (\16\:n20 \13\:CKNb n6 VSS) g45n1svt w=(1.45e-07) l=4.5e-08 nf=1 \
        as=8.7e-15 ad=2.03e-14 ps=4.1e-07 pd=5.7e-07 nrd=1.16667 \
        nrs=1.16667 sa=1.4e-07 sb=3.1e-07 sd=160n sca=8.42104 \
        scb=0.00632542 scc=0.000106623 m=(1)
mn35 (n6 \3\:mout \29\:VSS VSS) g45n1svt w=(1.45e-07) l=4.5e-08 nf=1 \
        as=2.973e-14 ad=8.7e-15 ps=7e-07 pd=4.1e-07 nrd=1.16667 \
        nrs=1.16667 sa=2.45e-07 sb=2.05e-07 sd=160n sca=8.42104 \
        scb=0.00632542 scc=0.000106623 m=(1)
mn32 (\14\:mout \6\:n20 \33\:VSS VSS) g45n1svt w=(1.45e-07) l=4.5e-08 \
        nf=1 as=2.03e-14 ad=2.03e-14 ps=5.7e-07 pd=5.7e-07 nrd=1.16667 \
        nrs=1.16667 sa=1.4e-07 sb=1.4e-07 sd=160n sca=8.42104 \
        scb=0.00632542 scc=0.000106623 m=(1)
mn11 (n0 \1\:D \16\:VSS VSS) g45n1svt w=(1.45e-07) l=4.5e-08 nf=1 \
        as=2.03e-14 ad=8.7e-15 ps=5.7e-07 pd=4.1e-07 nrd=1.16667 \
        nrs=1.16667 sa=1.4e-07 sb=7.6e-07 sd=160n sca=8.85152 \
        scb=0.00706865 scc=0.000138481 m=(1)
mn14 (Db \6\:SE n2 VSS) g45n1svt w=(1.45e-07) l=4.5e-08 nf=1 as=8.7e-15 \
        ad=2.32e-14 ps=4.1e-07 pd=6.1e-07 nrd=1.16667 nrs=1.16667 \
        sa=4.5e-07 sb=4.5e-07 sd=160n sca=8.85152 scb=0.00706865 \
        scc=0.000138481 m=(1)
mn40 (\6\:n35 \8\:CKNb \12\:mout VSS) g45n1svt w=(1.45e-07) l=4.5e-08 \
        nf=1 as=2.03e-14 ad=2.03e-14 ps=5.7e-07 pd=5.7e-07 nrd=1.16667 \
        nrs=1.16667 sa=1.4e-07 sb=1.4e-07 sd=160n sca=8.42104 \
        scb=0.00632542 scc=0.000106623 m=(1)
NM0 (\9\:n35g RTb \13\:n35 VSS) g45n1svt w=(1.45e-07) l=4.5e-08 nf=1 \
        as=2.03e-14 ad=2.03e-14 ps=5.7e-07 pd=5.7e-07 nrd=1.16667 \
        nrs=1.16667 sa=1.4e-07 sb=1.4e-07 sd=160n sca=17.8702 \
        scb=0.0189183 scc=0.00156031 m=(1)
mn45 (\16\:qbint \5\:n35g \10\:VSS VSS) g45n1svt w=(1.45e-07) l=4.5e-08 \
        nf=1 as=2.03e-14 ad=2.03e-14 ps=5.7e-07 pd=5.7e-07 nrd=1.16667 \
        nrs=1.16667 sa=1.4e-07 sb=1.4e-07 sd=160n sca=9.33388 \
        scb=0.00788941 scc=0.00017958 m=(1)
NM3 (net0134 \5\:qbint \6\:VSS VSS) g45n1svt w=(1.45e-07) l=4.5e-08 nf=1 \
        as=2.03e-14 ad=8.7e-15 ps=5.7e-07 pd=4.1e-07 nrd=1.16667 \
        nrs=1.16667 sa=1.4e-07 sb=2.45e-07 sd=160n sca=9.33388 \
        scb=0.00788941 scc=0.00017958 m=(1)
NM2 (\11\:n35g \7\:RT net0134 VSS) g45n1svt w=(1.45e-07) l=4.5e-08 nf=1 \
        as=8.7e-15 ad=2.03e-14 ps=4.1e-07 pd=5.7e-07 nrd=1.16667 \
        nrs=1.16667 sa=2.45e-07 sb=1.4e-07 sd=160n sca=9.33388 \
        scb=0.00788941 scc=0.00017958 m=(1)
mn53 (\18\:n35 \3\:CKNbb net0119 VSS) g45n1svt w=(1.45e-07) l=4.5e-08 \
        nf=1 as=8.7e-15 ad=2.03e-14 ps=4.1e-07 pd=5.7e-07 nrd=1.16667 \
        nrs=1.16667 sa=1.4e-07 sb=2.45e-07 sd=160n sca=8.42104 \
        scb=0.00632542 scc=0.000106623 m=(1)
mn52 (net0119 \11\:qbint \21\:VSS VSS) g45n1svt w=(1.45e-07) l=4.5e-08 \
        nf=1 as=2.03e-14 ad=8.7e-15 ps=5.7e-07 pd=4.1e-07 nrd=1.16667 \
        nrs=1.16667 sa=2.45e-07 sb=1.4e-07 sd=160n sca=8.42104 \
        scb=0.00632542 scc=0.000106623 m=(1)
mn55 (\3\:Q \6\:qbint \1\:VSS VSS) g45n1svt w=(2.6e-07) l=4.5e-08 nf=1 \
        as=3.64e-14 ad=3.64e-14 ps=8e-07 pd=8e-07 nrd=1.16667 nrs=1.16667 \
        sa=1.4e-07 sb=1.4e-07 sd=160n sca=9.50447 scb=0.0081528 \
        scc=0.00025289 m=(1)
mp55 (\1\:Q \9\:qbint \1\:VDD VDD) g45p1svt w=(3.9e-07) l=4.5e-08 nf=1 \
        as=5.46e-14 ad=5.46e-14 ps=1.06e-06 pd=1.06e-06 nrd=1.16667 \
        nrs=1.16667 sa=1.4e-07 sb=1.4e-07 sd=160n sca=28.7703 \
        scb=0.0323565 scc=0.00200479 m=(1)
ends SRDFFNQX1
// End of subcircuit definition.
