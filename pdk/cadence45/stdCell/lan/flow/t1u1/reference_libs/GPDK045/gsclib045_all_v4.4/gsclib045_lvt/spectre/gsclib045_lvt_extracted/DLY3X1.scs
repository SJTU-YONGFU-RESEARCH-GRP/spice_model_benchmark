// Generated for: spectre (May  1 09:13:24 2013 )
// Library name: gsclib045_lvt
// Cell name: DLY3X1
// View name: extracted

simulator lang=spectre

subckt DLY3X1 A VDD VSS Y
mp2 (\9\:n1 \1\:VSS n8 VDD) g45p1lvt w=(2.15e-07) l=4.5e-08 nf=1 \
        as=1.29e-14 ad=3.01e-14 ps=5.5e-07 pd=7.1e-07 nrd=1.16667 \
        nrs=1.16667 sa=1.4e-07 sb=8.55e-07 sd=160n sca=22.1455 \
        scb=0.0211116 scc=0.00193954 m=(1)
mp1 (n8 \2\:n0 \29\:VDD VDD) g45p1lvt w=(2.15e-07) l=4.5e-08 nf=1 \
        as=3.44e-14 ad=1.29e-14 ps=7.5e-07 pd=5.5e-07 nrd=1.16667 \
        nrs=1.16667 sa=2.45e-07 sb=7.5e-07 sd=160n sca=21.4207 \
        scb=0.0203168 scc=0.00193696 m=(1)
mp3 (n10 n1 \29\:VDD VDD) g45p1lvt w=(2.15e-07) l=4.5e-08 nf=1 \
        as=3.44e-14 ad=5.913e-14 ps=7.5e-07 pd=9.8e-07 nrd=1.16667 \
        nrs=1.16667 sa=4.5e-07 sb=5.45e-07 sd=160n sca=20.6521 \
        scb=0.0198557 scc=0.00193653 m=(1)
mp4 (\4\:n2 \3\:VSS n10 VDD) g45p1lvt w=(2.15e-07) l=4.5e-08 nf=1 \
        as=5.912e-14 ad=4.837e-14 ps=9.8e-07 pd=8.8e-07 nrd=1.16667 \
        nrs=1.16667 sa=7.7e-07 sb=2.25e-07 sd=160n sca=20.4333 \
        scb=0.0198015 scc=0.00193653 m=(1)
mp0 (\6\:n0 \1\:A \24\:VDD VDD) g45p1lvt w=(2.15e-07) l=4.5e-08 nf=1 \
        as=3.44e-14 ad=3.01e-14 ps=7.5e-07 pd=7.1e-07 nrd=1.16667 \
        nrs=1.16667 sa=1.4e-07 sb=5.15e-07 sd=160n sca=12.9303 \
        scb=0.0120133 scc=0.000461649 m=(1)
mp5 (n12 \3\:n2 \24\:VDD VDD) g45p1lvt w=(2.15e-07) l=4.5e-08 nf=1 \
        as=3.44e-14 ad=2.687e-14 ps=7.5e-07 pd=6.8e-07 nrd=1.16667 \
        nrs=1.16667 sa=3.45e-07 sb=3.1e-07 sd=160n sca=12.9303 \
        scb=0.0120133 scc=0.000461649 m=(1)
mp6 (\7\:n3 \6\:VSS n12 VDD) g45p1lvt w=(2.15e-07) l=4.5e-08 nf=1 \
        as=2.687e-14 ad=3.01e-14 ps=6.8e-07 pd=7.1e-07 nrd=1.16667 \
        nrs=1.16667 sa=5.15e-07 sb=1.4e-07 sd=160n sca=12.9303 \
        scb=0.0120133 scc=0.000461649 m=(1)
mp7 (n14 n3 \17\:VDD VDD) g45p1lvt w=(2.15e-07) l=4.5e-08 nf=1 \
        as=6.535e-14 ad=1.505e-14 ps=1.16e-06 pd=5.7e-07 nrd=1.16667 \
        nrs=1.16667 sa=3.75e-07 sb=2.55e-07 sd=160n sca=45.7906 \
        scb=0.0283307 scc=0.00588417 m=(1)
mp8 (\7\:n4 \7\:VSS n14 VDD) g45p1lvt w=(2.15e-07) l=4.5e-08 nf=1 \
        as=1.505e-14 ad=3.01e-14 ps=5.7e-07 pd=7.1e-07 nrd=1.16667 \
        nrs=1.16667 sa=4.9e-07 sb=1.4e-07 sd=160n sca=45.7906 \
        scb=0.0283307 scc=0.00588417 m=(1)
mp11 (\6\:n6 \3\:n5 \19\:VDD VDD) g45p1lvt w=(2.15e-07) l=4.5e-08 nf=1 \
        as=3.44e-14 ad=7.847e-14 ps=7.5e-07 pd=1.16e-06 nrd=1.16667 \
        nrs=1.16667 sa=3.65e-07 sb=4.5e-07 sd=160n sca=16.5775 \
        scb=0.0160907 scc=0.00103906 m=(1)
mp9 (n16 n4 \19\:VDD VDD) g45p1lvt w=(2.15e-07) l=4.5e-08 nf=1 \
        as=3.44e-14 ad=1.29e-14 ps=7.5e-07 pd=5.5e-07 nrd=1.16667 \
        nrs=1.16667 sa=5.7e-07 sb=2.45e-07 sd=160n sca=17.7492 \
        scb=0.0172065 scc=0.001042 m=(1)
mp10 (\6\:n5 \10\:VSS n16 VDD) g45p1lvt w=(2.15e-07) l=4.5e-08 nf=1 \
        as=1.29e-14 ad=3.01e-14 ps=5.5e-07 pd=7.1e-07 nrd=1.16667 \
        nrs=1.16667 sa=6.75e-07 sb=1.4e-07 sd=160n sca=18.9703 \
        scb=0.0190477 scc=0.00105936 m=(1)
C1 (A VSS) capacitor c=5.10683e-17
C2 (Y VSS) capacitor c=4.08498e-17
C3 (VDD VSS) capacitor c=2.65672e-16
C4 (n1 VSS) capacitor c=3.78854e-17
C5 (n0 VSS) capacitor c=3.6423e-17
C6 (n2 VSS) capacitor c=3.57868e-17
C7 (n11 VSS) capacitor c=1.53359e-18
C8 (n3 VSS) capacitor c=9.49489e-17
C9 (n6 VSS) capacitor c=2.41281e-17
C10 (n13 VSS) capacitor c=4.75455e-18
C11 (n4 VSS) capacitor c=1.03916e-16
C12 (n5 VSS) capacitor c=4.64577e-17
C13 (n15 VSS) capacitor c=1.41579e-18
C14 (n8 VSS) capacitor c=1.53039e-18
C15 (n10 VSS) capacitor c=3.20763e-18
C16 (n12 VSS) capacitor c=2.28512e-18
C17 (n14 VSS) capacitor c=6.09855e-19
C18 (n16 VSS) capacitor c=1.92136e-18
C19 (\3\:n5 VSS) capacitor c=2.82837e-17
C20 (\4\:n6 VSS) capacitor c=4.34896e-17
C21 (\3\:n2 VSS) capacitor c=8.06902e-17
C22 (\1\:A VSS) capacitor c=2.96724e-17
C23 (\2\:n0 VSS) capacitor c=1.33484e-16
C24 (\9\:VDD VSS) capacitor c=5.3239e-17
C25 (\2\:n4 VSS) capacitor c=6.8641e-17
C26 (\7\:VDD VSS) capacitor c=4.07475e-17
C27 (\2\:n3 VSS) capacitor c=2.68294e-17
C28 (\3\:n6 VSS) capacitor c=3.90888e-17
C29 (\5\:VDD VSS) capacitor c=3.96916e-17
C30 (\2\:n2 VSS) capacitor c=4.82767e-17
C31 (\3\:A VSS) capacitor c=4.24412e-17
C32 (\3\:VDD VSS) capacitor c=3.78169e-17
C33 (\4\:n1 VSS) capacitor c=6.13063e-17
C34 (\3\:n0 VSS) capacitor c=1.00287e-16
C35 (\1\:VDD VSS) capacitor c=5.77291e-17
C36 (\10\:VDD VSS) capacitor c=4.81686e-17
C37 (\3\:n4 VSS) capacitor c=3.35552e-17
C38 (\2\:n5 VSS) capacitor c=6.17805e-17
C39 (\8\:VDD VSS) capacitor c=4.68181e-17
C40 (\3\:n3 VSS) capacitor c=2.18895e-17
C41 (\6\:VDD VSS) capacitor c=4.77615e-17
C42 (\2\:A VSS) capacitor c=4.08205e-17
C43 (\4\:VDD VSS) capacitor c=3.99826e-17
C44 (\3\:n1 VSS) capacitor c=2.47185e-17
C45 (\2\:VDD VSS) capacitor c=5.18378e-17
C46 (\6\:n5 VSS) capacitor c=1.0033e-16
C47 (\19\:VDD VSS) capacitor c=2.48577e-17
C48 (\6\:n6 VSS) capacitor c=1.26955e-16
C49 (\7\:n4 VSS) capacitor c=8.8876e-17
C50 (\17\:VDD VSS) capacitor c=3.45881e-17
C51 (\1\:Y VSS) capacitor c=6.68074e-17
C52 (\7\:n3 VSS) capacitor c=8.86815e-17
C53 (\24\:VDD VSS) capacitor c=3.98717e-17
C54 (\6\:n0 VSS) capacitor c=1.25103e-16
C55 (\4\:n2 VSS) capacitor c=8.85893e-17
C56 (\29\:VDD VSS) capacitor c=1.96823e-17
C57 (\9\:n1 VSS) capacitor c=7.71345e-18
C58 (\14\:VDD VSS) capacitor c=4.40064e-17
C59 (\4\:n5 VSS) capacitor c=1.01829e-16
C60 (\8\:n6 VSS) capacitor c=1.15184e-16
C61 (\5\:n4 VSS) capacitor c=2.24042e-16
C62 (\3\:Y VSS) capacitor c=5.69624e-17
C63 (\5\:n3 VSS) capacitor c=1.97677e-16
C64 (\4\:n0 VSS) capacitor c=1.17651e-16
C65 (\6\:n2 VSS) capacitor c=1.94056e-16
C66 (\7\:n1 VSS) capacitor c=8.37319e-17
C67 (\2\:n1 VSS) capacitor c=4.16985e-17
C68 (\2\:n6 VSS) capacitor c=1.16723e-17
C69 (\5\:n1 VSS) capacitor c=5.32974e-17
C70 (\6\:n1 VSS) capacitor c=7.78861e-17
C71 (\8\:n0 VSS) capacitor c=6.02326e-17
C72 (\4\:A VSS) capacitor c=7.89124e-17
C73 (\8\:n2 VSS) capacitor c=1.33409e-16
C74 (\4\:n3 VSS) capacitor c=1.2612e-16
C75 (\5\:n6 VSS) capacitor c=9.56592e-17
C76 (\4\:n4 VSS) capacitor c=1.90517e-16
C77 (\8\:n5 VSS) capacitor c=7.17243e-17
C78 (\11\:VDD VSS) capacitor c=7.16931e-17
C79 (\12\:VDD VSS) capacitor c=1.34386e-16
C80 (\13\:VDD VSS) capacitor c=2.80969e-17
C81 (\16\:VDD VSS) capacitor c=2.29364e-17
C82 (\21\:VDD VSS) capacitor c=2.38704e-17
C83 (\22\:VDD VSS) capacitor c=9.4655e-17
C84 (\23\:VDD VSS) capacitor c=1.57212e-17
C85 (\27\:VDD VSS) capacitor c=1.48544e-17
C86 (\28\:VDD VSS) capacitor c=5.55726e-17
C87 (\31\:VDD VSS) capacitor c=7.99634e-17
C88 (\32\:VDD VSS) capacitor c=5.47297e-17
Rk19 (\11\:VSS \12\:VSS) resistor r=0.9514 c=0
Rk20 (\12\:VSS \14\:VSS) resistor r=0.2607 c=0
Rk21 (\14\:VSS \15\:VSS) resistor r=0.08762 c=0
Rk22 (\15\:VSS \16\:VSS) resistor r=0.1903 c=0
Rk23 (\16\:VSS \17\:VSS) resistor r=0.381 c=0
Rk24 (\17\:VSS \18\:VSS) resistor r=0.2179 c=0
Rk25 (\18\:VSS \19\:VSS) resistor r=0.326 c=0
Rk26 (\12\:VSS \21\:VSS) resistor r=0.2735 c=0
Rk27 (\15\:VSS \22\:VSS) resistor r=0.6302 c=0
Rk28 (\16\:VSS \24\:VSS) resistor r=0.3005 c=0
Rk29 (\17\:VSS \25\:VSS) resistor r=0.6585 c=0
Rk30 (\18\:VSS \27\:VSS) resistor r=0.3079 c=0
Rk31 (\19\:VSS \28\:VSS) resistor r=0.2212 c=0
Rk33 (\29\:VSS VSS) resistor r=0.1125 c=0
Rk32 (\28\:VSS \29\:VSS) resistor r=0.2179 c=0
Rk34 (\19\:VSS \30\:VSS) resistor r=0.6296 c=0
Rk35 (\28\:VSS \32\:VSS) resistor r=0.185 c=0
Rk36 (\29\:VSS \33\:VSS) resistor r=0.7146 c=0
Rk6 (A \4\:A) resistor r=0.0194 c=0
Rk9 (\2\:Y Y) resistor r=0.2502 c=0
Rk10 (Y \4\:Y) resistor r=0.2028 c=0
Rk37 (\11\:VDD \12\:VDD) resistor r=0.3658 c=0
Rk38 (\12\:VDD \13\:VDD) resistor r=0.6978 c=0
Rk39 (\13\:VDD \15\:VDD) resistor r=0.1529 c=0
Rk40 (\15\:VDD \16\:VDD) resistor r=0.2532 c=0
Rk41 (\16\:VDD \18\:VDD) resistor r=0.2988 c=0
Rk42 (\13\:VDD \20\:VDD) resistor r=0.499 c=0
Rk43 (\16\:VDD \21\:VDD) resistor r=0.5165 c=0
Rk44 (\21\:VDD \22\:VDD) resistor r=0.6347 c=0
Rk45 (\21\:VDD \23\:VDD) resistor r=0.1075 c=0
Rk46 (\23\:VDD \25\:VDD) resistor r=0.3538 c=0
Rk47 (\23\:VDD \26\:VDD) resistor r=0.326 c=0
Rk51 (\27\:VDD VDD) resistor r=0.3584 c=0
Rk48 (\26\:VDD \27\:VDD) resistor r=0.193 c=0
Rk49 (\27\:VDD \28\:VDD) resistor r=0.3312 c=0
Rk50 (\28\:VDD \30\:VDD) resistor r=0.05479 c=0
Rk52 (\28\:VDD \31\:VDD) resistor r=0.4901 c=0
Rk53 (\31\:VDD \32\:VDD) resistor r=0.3549 c=0
Rk1 (\5\:n1 \6\:n1) resistor r=0.3194 c=0
Rk2 (\6\:n1 \8\:n1) resistor r=0.6819 c=0
Rk3 (\6\:n1 \10\:n1) resistor r=0.02809 c=0
Rk4 (\5\:n0 \7\:n0) resistor r=0.6105 c=0
Rk5 (\7\:n0 \8\:n0) resistor r=0.5443 c=0
Rk7 (\5\:n2 \7\:n2) resistor r=0.5746 c=0
Rk8 (\7\:n2 \8\:n2) resistor r=0.9837 c=0
Rk11 (\4\:n3 \6\:n3) resistor r=0.9337 c=0
Rk12 (\6\:n3 \8\:n3) resistor r=0.7382 c=0
Rk13 (\5\:n6 \7\:n6) resistor r=0.7079 c=0
Rk14 (\7\:n6 \9\:n6) resistor r=0.6169 c=0
Rk15 (\4\:n4 \6\:n4) resistor r=1.3173 c=0
Rk16 (\6\:n4 \8\:n4) resistor r=0.5008 c=0
Rk17 (\5\:n5 \7\:n5) resistor r=0.7564 c=0
Rk18 (\7\:n5 \8\:n5) resistor r=0.4045 c=0
Rl28 (\9\:VSS \10\:VSS) resistor r=39.7311 c=0
Rl21 (\7\:VSS \8\:VSS) resistor r=31.9251 c=0
Rl15 (\5\:VSS \6\:VSS) resistor r=89.8977 c=0
Rl9 (\3\:VSS \4\:VSS) resistor r=71.8456 c=0
Rl1 (\1\:VSS \2\:VSS) resistor r=49.2328 c=0
Rl10 (\1\:A \2\:A) resistor r=24.2328 c=0
Rl11 (\2\:A \3\:A) resistor r=156.925 c=0
Rl27 (\9\:VDD \10\:VDD) resistor r=91.2131 c=0
Rl22 (\7\:VDD \8\:VDD) resistor r=196.875 c=0
Rl14 (\5\:VDD \6\:VDD) resistor r=103.359 c=0
Rl8 (\3\:VDD \4\:VDD) resistor r=87.6944 c=0
Rl2 (\1\:VDD \2\:VDD) resistor r=87.6944 c=0
Rl3 (n1 \2\:n1) resistor r=34.3295 c=0
Rl5 (\2\:n1 \4\:n1) resistor r=184.329 c=0
Rl4 (\2\:n1 \3\:n1) resistor r=2.0166 c=0
Rl7 (\2\:n0 \3\:n0) resistor r=226.923 c=0
Rl6 (n0 \2\:n0) resistor r=189.898 c=0
Rl13 (\2\:n2 \3\:n2) resistor r=209.615 c=0
Rl12 (n2 \2\:n2) resistor r=36.2715 c=0
Rl19 (n3 \2\:n3) resistor r=134.615 c=0
Rl20 (\2\:n3 \3\:n3) resistor r=24.2328 c=0
Rl18 (\2\:n6 \4\:n6) resistor r=22.3936 c=0
Rl17 (\2\:n6 \3\:n6) resistor r=65.8358 c=0
Rl16 (n6 \2\:n6) resistor r=12.8731 c=0
Rl25 (n4 \2\:n4) resistor r=214.045 c=0
Rl26 (\2\:n4 \3\:n4) resistor r=35.7713 c=0
Rl24 (\2\:n5 \3\:n5) resistor r=51.2624 c=0
Rl23 (n5 \2\:n5) resistor r=152.174 c=0
Rz9 (\20\:VSS \21\:VSS) resistor r=75 c=0
Rz10 (\23\:VSS \24\:VSS) resistor r=75 c=0
Rz11 (\26\:VSS \27\:VSS) resistor r=75 c=0
Rz12 (\31\:VSS \32\:VSS) resistor r=75 c=0
Rz4 (\3\:Y \4\:Y) resistor r=75 c=0
Rz13 (\14\:VDD \15\:VDD) resistor r=6.25 c=0
Rz14 (\14\:VDD \26\:VDD) resistor r=6.25 c=0
Rz1 (\7\:n1 \8\:n1) resistor r=75 c=0
Rz2 (\4\:n0 \5\:n0) resistor r=75 c=0
Rz3 (\6\:n2 \7\:n2) resistor r=75 c=0
Rz5 (\5\:n3 \6\:n3) resistor r=75 c=0
Rz6 (\8\:n6 \9\:n6) resistor r=75 c=0
Rz7 (\5\:n4 \6\:n4) resistor r=75 c=0
Rz8 (\4\:n5 \5\:n5) resistor r=75 c=0
Ry9 (\13\:VSS \14\:VSS) resistor r=5.1667 c=0
Ry10 (\13\:VSS \19\:VSS) resistor r=5.1667 c=0
Ry4 (\1\:Y \2\:Y) resistor r=20.6667 c=0
Ry11 (\17\:VDD \18\:VDD) resistor r=62 c=0
Ry12 (\19\:VDD \20\:VDD) resistor r=62 c=0
Ry13 (\24\:VDD \25\:VDD) resistor r=62 c=0
Ry14 (\29\:VDD \30\:VDD) resistor r=62 c=0
Ry1 (\9\:n1 \10\:n1) resistor r=62 c=0
Ry2 (\6\:n0 \7\:n0) resistor r=62 c=0
Ry3 (\4\:n2 \5\:n2) resistor r=62 c=0
Ry5 (\7\:n3 \8\:n3) resistor r=62 c=0
Ry6 (\6\:n6 \7\:n6) resistor r=62 c=0
Ry7 (\7\:n4 \8\:n4) resistor r=62 c=0
Ry8 (\6\:n5 \7\:n5) resistor r=62 c=0
Rx9 (\9\:VSS \11\:VSS) resistor r=45 c=0
Rx10 (\8\:VSS \22\:VSS) resistor r=45 c=0
Rx11 (\5\:VSS \25\:VSS) resistor r=45 c=0
Rx12 (\4\:VSS \30\:VSS) resistor r=45 c=0
Rx13 (\2\:VSS \33\:VSS) resistor r=45 c=0
Rx3 (\2\:A \4\:A) resistor r=45 c=0
Rx14 (\10\:VDD \11\:VDD) resistor r=45 c=0
Rx15 (\8\:VDD \12\:VDD) resistor r=45 c=0
Rx16 (\6\:VDD \22\:VDD) resistor r=45 c=0
Rx17 (\4\:VDD \31\:VDD) resistor r=45 c=0
Rx18 (\2\:VDD \32\:VDD) resistor r=45 c=0
Rx1 (\3\:n1 \5\:n1) resistor r=45 c=0
Rx2 (n0 \8\:n0) resistor r=45 c=0
Rx4 (n2 \8\:n2) resistor r=45 c=0
Rx5 (\3\:n3 \4\:n3) resistor r=45 c=0
Rx6 (n6 \5\:n6) resistor r=45 c=0
Rx7 (\3\:n4 \4\:n4) resistor r=45 c=0
Rx8 (\2\:n5 \8\:n5) resistor r=45 c=0
mn2 (\7\:n1 \1\:VDD n7 VSS) g45n1lvt w=(1.45e-07) l=4.5e-08 nf=1 \
        as=8.7e-15 ad=6.163e-14 ps=4.1e-07 pd=1.14e-06 nrd=1.16667 \
        nrs=1.16667 sa=4.25e-07 sb=8.15e-07 sd=160n sca=6.83173 \
        scb=0.00357784 scc=2.82929e-05 m=(1)
mn1 (n7 \3\:n0 \31\:VSS VSS) g45n1lvt w=(1.45e-07) l=4.5e-08 nf=1 \
        as=2.32e-14 ad=8.7e-15 ps=6.1e-07 pd=4.1e-07 nrd=1.16667 \
        nrs=1.16667 sa=5.3e-07 sb=7.1e-07 sd=160n sca=6.83173 \
        scb=0.00357784 scc=2.82929e-05 m=(1)
mn3 (n9 \4\:n1 \31\:VSS VSS) g45n1lvt w=(1.45e-07) l=4.5e-08 nf=1 \
        as=2.32e-14 ad=2.175e-14 ps=6.1e-07 pd=5.9e-07 nrd=1.16667 \
        nrs=1.16667 sa=7.35e-07 sb=5.05e-07 sd=160n sca=6.83173 \
        scb=0.00357784 scc=2.82929e-05 m=(1)
mn4 (\6\:n2 \3\:VDD n9 VSS) g45n1lvt w=(1.45e-07) l=4.5e-08 nf=1 \
        as=2.175e-14 ad=4.495e-14 ps=5.9e-07 pd=9.1e-07 nrd=1.16667 \
        nrs=1.16667 sa=9.3e-07 sb=3.1e-07 sd=160n sca=6.83173 \
        scb=0.00357784 scc=2.82929e-05 m=(1)
mn0 (\4\:n0 \3\:A \26\:VSS VSS) g45n1lvt w=(1.45e-07) l=4.5e-08 nf=1 \
        as=2.32e-14 ad=3.698e-14 ps=6.1e-07 pd=8e-07 nrd=1.16667 \
        nrs=1.16667 sa=2.55e-07 sb=7.35e-07 sd=160n sca=10.4914 \
        scb=0.00978575 scc=0.000300434 m=(1)
mn5 (n11 \2\:n2 \26\:VSS VSS) g45n1lvt w=(1.45e-07) l=4.5e-08 nf=1 \
        as=2.32e-14 ad=2.682e-14 ps=6.1e-07 pd=6.6e-07 nrd=1.16667 \
        nrs=1.16667 sa=4.6e-07 sb=5.3e-07 sd=160n sca=10.4914 \
        scb=0.00978575 scc=0.000300434 m=(1)
mn6 (\5\:n3 \5\:VDD n11 VSS) g45n1lvt w=(1.45e-07) l=4.5e-08 nf=1 \
        as=2.682e-14 ad=4.35e-14 ps=6.6e-07 pd=8.9e-07 nrd=1.16667 \
        nrs=1.16667 sa=6.9e-07 sb=3e-07 sd=160n sca=10.4914 scb=0.00978575 \
        scc=0.000300434 m=(1)
mn7 (n13 \2\:n3 \23\:VSS VSS) g45n1lvt w=(1.45e-07) l=4.5e-08 nf=1 \
        as=4.725e-14 ad=3.48e-14 ps=1.01e-06 pd=7.7e-07 nrd=1.16667 \
        nrs=1.16667 sa=5.7e-07 sb=4.25e-07 sd=160n sca=11.7118 \
        scb=0.0116498 scc=0.000458536 m=(1)
mn8 (\5\:n4 \7\:VDD n13 VSS) g45n1lvt w=(1.45e-07) l=4.5e-08 nf=1 \
        as=3.48e-14 ad=2.03e-14 ps=7.7e-07 pd=5.7e-07 nrd=1.16667 \
        nrs=1.16667 sa=8.55e-07 sb=1.4e-07 sd=160n sca=11.7118 \
        scb=0.0116498 scc=0.000458536 m=(1)
mn11 (\8\:n6 n5 \20\:VSS VSS) g45n1lvt w=(1.45e-07) l=4.5e-08 nf=1 \
        as=2.32e-14 ad=4.567e-14 ps=6.1e-07 pd=9.2e-07 nrd=1.16667 \
        nrs=1.16667 sa=3.15e-07 sb=6.2e-07 sd=160n sca=8.42104 \
        scb=0.00632542 scc=0.000106623 m=(1)
mn9 (n15 \2\:n4 \20\:VSS VSS) g45n1lvt w=(1.45e-07) l=4.5e-08 nf=1 \
        as=2.32e-14 ad=1.812e-14 ps=6.1e-07 pd=5.4e-07 nrd=1.16667 \
        nrs=1.16667 sa=5.2e-07 sb=4.15e-07 sd=160n sca=8.42104 \
        scb=0.00632542 scc=0.000106623 m=(1)
mn10 (\4\:n5 \9\:VDD n15 VSS) g45n1lvt w=(1.45e-07) l=4.5e-08 nf=1 \
        as=1.812e-14 ad=3.552e-14 ps=5.4e-07 pd=7.8e-07 nrd=1.16667 \
        nrs=1.16667 sa=6.9e-07 sb=2.45e-07 sd=160n sca=8.42104 \
        scb=0.00632542 scc=0.000106623 m=(1)
mn12 (\3\:Y \3\:n6 \23\:VSS VSS) g45n1lvt w=(2.6e-07) l=4.5e-08 nf=1 \
        as=4.725e-14 ad=7.28e-14 ps=1.01e-06 pd=1.08e-06 nrd=1.16667 \
        nrs=1.16667 sa=2.8e-07 sb=4.43846e-07 sd=160n sca=17.5885 \
        scb=0.0172826 scc=0.00162584 m=(1)
mp12 (\1\:Y \4\:n6 \17\:VDD VDD) g45p1lvt w=(3.9e-07) l=4.5e-08 nf=1 \
        as=6.535e-14 ad=5.46e-14 ps=1.16e-06 pd=1.06e-06 nrd=1.16667 \
        nrs=1.16667 sa=1.4e-07 sb=3.32949e-07 sd=160n sca=30.5009 \
        scb=0.0202006 scc=0.00336097 m=(1)
ends DLY3X1
// End of subcircuit definition.
