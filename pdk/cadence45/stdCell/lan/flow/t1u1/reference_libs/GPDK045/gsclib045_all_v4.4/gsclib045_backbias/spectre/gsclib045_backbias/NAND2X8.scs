// gsclib045_backbias/NAND2X8/schematic

simulator lang=spectre

subckt NAND2X8 A B Y VSS NW VDD
mn1 (Y B n0 VSS) g45n1svt w=(2.065u) l=45n nf=1 m=(1)
mn0 (n0 A VSS VSS) g45n1svt w=(2.065u) l=45n nf=1 m=(1)
mp1 (Y B VDD NW) g45p1svt w=(3.115u) l=45n nf=1 m=(1)
mp0 (Y A VDD NW) g45p1svt w=(3.115u) l=45n nf=1 m=(1)
ends NAND2X8
