// Generated for: spectre (May  1 09:14:54 2013 )
// Library name: gsclib045_lvt
// Cell name: SDFFRXL
// View name: extracted

simulator lang=spectre

subckt SDFFRXL CK D Q QN RN SE SI VDD VSS
mp57 (\1\:QN \4\:qint \26\:VDD VDD) g45p1lvt w=(2.15e-07) l=4.5e-08 nf=1 \
        as=4.73e-14 ad=3.01e-14 ps=8.7e-07 pd=7.1e-07 nrd=1.16667 \
        nrs=1.16667 sa=1.4e-07 sb=4.05e-07 sd=160n sca=50.5874 \
        scb=0.0347407 scc=0.00598541 m=(1)
mp56 (\9\:qint \7\:qbint \26\:VDD VDD) g45p1lvt w=(2.15e-07) l=4.5e-08 \
        nf=1 as=4.73e-14 ad=3.01e-14 ps=8.7e-07 pd=7.1e-07 nrd=1.16667 \
        nrs=1.16667 sa=4.05e-07 sb=1.4e-07 sd=160n sca=46.9828 \
        scb=0.0290392 scc=0.00588499 m=(1)
mp55 (\3\:Q qbint \23\:VDD VDD) g45p1lvt w=(2.15e-07) l=4.5e-08 nf=1 \
        as=3.44e-14 ad=3.01e-14 ps=7.5e-07 pd=7.1e-07 nrd=1.16667 \
        nrs=1.16667 sa=1.4e-07 sb=3.65e-07 sd=160n sca=10.3756 \
        scb=0.00778655 scc=9.84544e-05 m=(1)
mp20 (\20\:CKb \1\:CK \23\:VDD VDD) g45p1lvt w=(2.15e-07) l=4.5e-08 nf=1 \
        as=3.44e-14 ad=3.44e-14 ps=7.5e-07 pd=7.5e-07 nrd=1.16667 \
        nrs=1.16667 sa=3.45e-07 sb=1.6e-07 sd=160n sca=10.3756 \
        scb=0.00778655 scc=9.84544e-05 m=(1)
mp46 (\11\:qbint n30 \19\:VDD VDD) g45p1lvt w=(2.15e-07) l=4.5e-08 nf=1 \
        as=7.315e-14 ad=3.44e-14 ps=1.38e-06 pd=7.5e-07 nrd=1.16667 \
        nrs=1.16667 sa=1.7e-07 sb=1.735e-06 sd=160n sca=25.9192 \
        scb=0.0230503 scc=0.00301683 m=(1)
mp45 (\11\:qbint \2\:RN \16\:VDD VDD) g45p1lvt w=(2.15e-07) l=4.5e-08 \
        nf=1 as=6.39e-14 ad=3.44e-14 ps=1.8e-06 pd=7.5e-07 nrd=1.16667 \
        nrs=1.16667 sa=3.75e-07 sb=1.53e-06 sd=160n sca=25.9192 \
        scb=0.0230503 scc=0.00301683 m=(1)
mp50 (n8 \8\:qbint \16\:VDD VDD) g45p1lvt w=(2.15e-07) l=4.5e-08 nf=1 \
        as=6.39e-14 ad=3.655e-14 ps=1.8e-06 pd=7.7e-07 nrd=1.16667 \
        nrs=1.16667 sa=5.7e-07 sb=1.335e-06 sd=160n sca=25.9192 \
        scb=0.0230503 scc=0.00301683 m=(1)
mp51 (\7\:n30 \3\:Ckbb n8 VDD) g45p1lvt w=(2.15e-07) l=4.5e-08 nf=1 \
        as=3.655e-14 ad=5.483e-14 ps=7.7e-07 pd=9.4e-07 nrd=1.16667 \
        nrs=1.16667 sa=7.85e-07 sb=1.12e-06 sd=160n sca=25.9192 \
        scb=0.0230503 scc=0.00301683 m=(1)
mp40 (\7\:n30 \3\:CKb \6\:mout VDD) g45p1lvt w=(2.15e-07) l=4.5e-08 nf=1 \
        as=5.912e-14 ad=5.483e-14 ps=9.8e-07 pd=9.4e-07 nrd=1.16667 \
        nrs=1.16667 sa=1.085e-06 sb=8.2e-07 sd=160n sca=25.9192 \
        scb=0.0230503 scc=0.00301683 m=(1)
mp30 (\6\:mout \3\:n20 \13\:VDD VDD) g45p1lvt w=(2.15e-07) l=4.5e-08 \
        nf=1 as=6.39e-14 ad=5.913e-14 ps=1.8e-06 pd=9.8e-07 nrd=1.16667 \
        nrs=1.16667 sa=1.405e-06 sb=5e-07 sd=160n sca=25.9192 \
        scb=0.0230503 scc=0.00301683 m=(1)
mp35 (\3\:n6 \6\:RN \13\:VDD VDD) g45p1lvt w=(2.15e-07) l=4.5e-08 nf=1 \
        as=6.39e-14 ad=3.44e-14 ps=1.8e-06 pd=7.5e-07 nrd=1.16667 \
        nrs=1.16667 sa=1.6e-06 sb=3.05e-07 sd=160n sca=25.9192 \
        scb=0.0230503 scc=0.00301683 m=(1)
mp36 (\3\:n6 mout \10\:VDD VDD) g45p1lvt w=(2.15e-07) l=4.5e-08 nf=1 \
        as=5.315e-14 ad=3.44e-14 ps=1.7e-06 pd=7.5e-07 nrd=1.16667 \
        nrs=1.16667 sa=1.805e-06 sb=1e-07 sd=160n sca=25.9192 \
        scb=0.0230503 scc=0.00301683 m=(1)
mp37 (\8\:n20 \6\:CKb n6 VDD) g45p1lvt w=(2.15e-07) l=4.5e-08 nf=1 \
        as=3.118e-14 ad=3.44e-14 ps=7.2e-07 pd=7.5e-07 nrd=1.16667 \
        nrs=1.16667 sa=1.45e-07 sb=3.45e-07 sd=160n sca=45.7906 \
        scb=0.0283307 scc=0.00588417 m=(1)
mp25 (\8\:n20 \8\:Ckbb \4\:Db VDD) g45p1lvt w=(2.15e-07) l=4.5e-08 nf=1 \
        as=3.01e-14 ad=3.44e-14 ps=7.1e-07 pd=7.5e-07 nrd=1.16667 \
        nrs=1.16667 sa=3.5e-07 sb=1.4e-07 sd=160n sca=45.7906 \
        scb=0.0283307 scc=0.00588417 m=(1)
mp21 (\13\:Ckbb \9\:CKb \6\:VDD VDD) g45p1lvt w=(2.15e-07) l=4.5e-08 \
        nf=1 as=5.815e-14 ad=3.01e-14 ps=1.57e-06 pd=7.1e-07 nrd=1.16667 \
        nrs=1.16667 sa=1.4e-07 sb=1.385e-06 sd=160n sca=13.1637 \
        scb=0.0123476 scc=0.000501177 m=(1)
mp11 (n2 \1\:D \6\:VDD VDD) g45p1lvt w=(2.15e-07) l=4.5e-08 nf=1 \
        as=5.815e-14 ad=3.655e-14 ps=1.57e-06 pd=7.7e-07 nrd=1.16667 \
        nrs=1.16667 sa=3.35e-07 sb=1.19e-06 sd=160n sca=13.1637 \
        scb=0.0123476 scc=0.000501177 m=(1)
mp12 (\8\:Db \1\:SE n2 VDD) g45p1lvt w=(2.15e-07) l=4.5e-08 nf=1 \
        as=3.655e-14 ad=3.44e-14 ps=7.7e-07 pd=7.5e-07 nrd=1.16667 \
        nrs=1.16667 sa=5.5e-07 sb=9.75e-07 sd=160n sca=13.1637 \
        scb=0.0123476 scc=0.000501177 m=(1)
mp14 (\8\:Db SEb n4 VDD) g45p1lvt w=(2.15e-07) l=4.5e-08 nf=1 as=4.3e-14 \
        ad=3.44e-14 ps=8.3e-07 pd=7.5e-07 nrd=1.16667 nrs=1.16667 \
        sa=7.55e-07 sb=7.7e-07 sd=160n sca=13.1637 scb=0.0123476 \
        scc=0.000501177 m=(1)
mp13 (n4 \1\:SI \1\:VDD VDD) g45p1lvt w=(2.15e-07) l=4.5e-08 nf=1 \
        as=7.31e-14 ad=4.3e-14 ps=1.11e-06 pd=8.3e-07 nrd=1.16667 \
        nrs=1.16667 sa=1e-06 sb=5.25e-07 sd=160n sca=13.7416 scb=0.0125632 \
        scc=0.000501256 m=(1)
mp10 (\4\:SEb \5\:SE \1\:VDD VDD) g45p1lvt w=(2.15e-07) l=4.5e-08 nf=1 \
        as=7.31e-14 ad=3.01e-14 ps=1.11e-06 pd=7.1e-07 nrd=1.16667 \
        nrs=1.16667 sa=1.385e-06 sb=1.4e-07 sd=160n sca=17.8247 \
        scb=0.018517 scc=0.000593893 m=(1)
C1 (RN VSS) capacitor c=6.22135e-17
C2 (QN VSS) capacitor c=2.11739e-17
C3 (SE VSS) capacitor c=3.88711e-17
C4 (Q VSS) capacitor c=6.8287e-17
C5 (SI VSS) capacitor c=1.1134e-16
C6 (VDD VSS) capacitor c=3.94343e-16
C7 (CK VSS) capacitor c=8.0611e-17
C8 (D VSS) capacitor c=7.04419e-17
C9 (qint VSS) capacitor c=2.16961e-17
C10 (qbint VSS) capacitor c=5.31828e-17
C11 (CKb VSS) capacitor c=6.44791e-17
C12 (n9 VSS) capacitor c=1.2869e-18
C13 (n30 VSS) capacitor c=5.25895e-17
C14 (n11 VSS) capacitor c=2.18491e-18
C15 (mout VSS) capacitor c=5.1578e-17
C16 (Ckbb VSS) capacitor c=2.02301e-17
C17 (n20 VSS) capacitor c=3.03185e-17
C18 (n7 VSS) capacitor c=1.5963e-19
C19 (Db VSS) capacitor c=1.26653e-16
C20 (n1 VSS) capacitor c=7.95439e-18
C21 (SEb VSS) capacitor c=3.20012e-17
C22 (n8 VSS) capacitor c=2.31739e-18
C23 (n6 VSS) capacitor c=6.89818e-17
C24 (n2 VSS) capacitor c=4.29239e-18
C25 (\5\:SE VSS) capacitor c=4.21262e-17
C26 (\1\:SI VSS) capacitor c=4.54474e-17
C27 (\1\:SE VSS) capacitor c=4.10888e-17
C28 (\1\:D VSS) capacitor c=6.89254e-17
C29 (\9\:CKb VSS) capacitor c=5.86838e-17
C30 (\8\:Ckbb VSS) capacitor c=5.15091e-17
C31 (\6\:CKb VSS) capacitor c=3.97177e-17
C32 (\6\:RN VSS) capacitor c=7.47834e-17
C33 (\3\:n20 VSS) capacitor c=5.00033e-17
C34 (\3\:CKb VSS) capacitor c=3.58178e-17
C35 (\3\:Ckbb VSS) capacitor c=5.00348e-17
C36 (\8\:qbint VSS) capacitor c=5.7097e-17
C37 (\2\:RN VSS) capacitor c=3.6388e-17
C38 (\1\:CK VSS) capacitor c=4.43383e-17
C39 (\7\:qbint VSS) capacitor c=2.28989e-17
C40 (\4\:qint VSS) capacitor c=2.73223e-17
C41 (\7\:SE VSS) capacitor c=2.30862e-17
C42 (\3\:SI VSS) capacitor c=4.75845e-17
C43 (\3\:SE VSS) capacitor c=6.10033e-17
C44 (\3\:SEb VSS) capacitor c=5.31917e-17
C45 (\4\:D VSS) capacitor c=3.0365e-17
C46 (\8\:CKb VSS) capacitor c=7.05142e-17
C47 (\5\:CKb VSS) capacitor c=4.65419e-17
C48 (\5\:Ckbb VSS) capacitor c=6.92929e-17
C49 (\3\:mout VSS) capacitor c=5.10086e-17
C50 (\5\:RN VSS) capacitor c=8.4029e-17
C51 (\4\:n20 VSS) capacitor c=2.95436e-17
C52 (\10\:qbint VSS) capacitor c=4.98993e-17
C53 (\4\:RN VSS) capacitor c=6.62054e-17
C54 (\2\:n30 VSS) capacitor c=5.01917e-17
C55 (\3\:CK VSS) capacitor c=4.6974e-17
C56 (\5\:qbint VSS) capacitor c=2.50078e-17
C57 (\4\:qbint VSS) capacitor c=2.48459e-17
C58 (\3\:qint VSS) capacitor c=2.98509e-17
C59 (\6\:SE VSS) capacitor c=3.26014e-17
C60 (\2\:SI VSS) capacitor c=5.38875e-17
C61 (\4\:SE VSS) capacitor c=5.54202e-17
C62 (\2\:SEb VSS) capacitor c=8.66333e-17
C63 (\2\:SE VSS) capacitor c=4.42388e-17
C64 (\3\:D VSS) capacitor c=2.42876e-17
C65 (\10\:CKb VSS) capacitor c=2.57469e-17
C66 (\7\:Ckbb VSS) capacitor c=3.88477e-17
C67 (\7\:CKb VSS) capacitor c=2.24125e-17
C68 (\6\:Ckbb VSS) capacitor c=3.1037e-17
C69 (\2\:mout VSS) capacitor c=6.09499e-17
C70 (\7\:RN VSS) capacitor c=2.40922e-17
C71 (\4\:Ckbb VSS) capacitor c=3.27409e-17
C72 (\4\:CKb VSS) capacitor c=3.8386e-17
C73 (\2\:CKb VSS) capacitor c=4.03104e-17
C74 (\9\:qbint VSS) capacitor c=5.1522e-17
C75 (\1\:RN VSS) capacitor c=2.3317e-17
C76 (\3\:RN VSS) capacitor c=4.86529e-17
C77 (\3\:n30 VSS) capacitor c=2.88071e-17
C78 (\2\:CK VSS) capacitor c=5.19311e-17
C79 (\6\:qbint VSS) capacitor c=2.34924e-17
C80 (\4\:SEb VSS) capacitor c=1.05479e-17
C81 (\1\:VDD VSS) capacitor c=3.27322e-17
C82 (\8\:Db VSS) capacitor c=2.24582e-17
C83 (\6\:VDD VSS) capacitor c=1.03898e-17
C84 (\13\:Ckbb VSS) capacitor c=8.27509e-17
C85 (\4\:Db VSS) capacitor c=1.40326e-16
C86 (\8\:n20 VSS) capacitor c=4.91538e-17
C87 (\10\:VDD VSS) capacitor c=9.88276e-18
C88 (\3\:n6 VSS) capacitor c=6.74509e-17
C89 (\13\:VDD VSS) capacitor c=1.95464e-17
C90 (\6\:mout VSS) capacitor c=6.27959e-17
C91 (\7\:n30 VSS) capacitor c=8.29601e-17
C92 (\16\:VDD VSS) capacitor c=2.01571e-17
C93 (\11\:qbint VSS) capacitor c=1.01338e-16
C94 (\19\:VDD VSS) capacitor c=3.19999e-17
C95 (\20\:CKb VSS) capacitor c=2.30334e-17
C96 (\23\:VDD VSS) capacitor c=2.61499e-17
C97 (\3\:Q VSS) capacitor c=4.2845e-17
C98 (\9\:qint VSS) capacitor c=3.87116e-17
C99 (\26\:VDD VSS) capacitor c=4.45117e-17
C100 (\1\:QN VSS) capacitor c=2.09195e-17
C101 (\3\:VDD VSS) capacitor c=7.91112e-17
C102 (\8\:SEb VSS) capacitor c=7.64033e-17
C103 (\9\:Ckbb VSS) capacitor c=5.11075e-17
C104 (\6\:Db VSS) capacitor c=5.87654e-17
C105 (\5\:n20 VSS) capacitor c=4.02172e-17
C106 (\8\:mout VSS) capacitor c=2.6488e-17
C107 (\4\:n30 VSS) capacitor c=9.12923e-17
C108 (\14\:qbint VSS) capacitor c=8.75402e-17
C109 (\16\:CKb VSS) capacitor c=1.06667e-16
C110 (\1\:Q VSS) capacitor c=6.28915e-17
C111 (\7\:qint VSS) capacitor c=2.56235e-17
C112 (\3\:QN VSS) capacitor c=2.50856e-17
C113 (\2\:qint VSS) capacitor c=7.61862e-18
C114 (\2\:qbint VSS) capacitor c=3.77253e-17
C115 (\3\:qbint VSS) capacitor c=3.51e-17
C116 (\2\:Ckbb VSS) capacitor c=4.99235e-17
C117 (\2\:n20 VSS) capacitor c=3.41332e-17
C118 (\2\:D VSS) capacitor c=3.29022e-17
C119 (\5\:qint VSS) capacitor c=2.5666e-17
C120 (\6\:qint VSS) capacitor c=3.4066e-17
C121 (\4\:CK VSS) capacitor c=3.76495e-17
C122 (\13\:qbint VSS) capacitor c=1.0578e-16
C123 (\16\:qbint VSS) capacitor c=8.61944e-17
C124 (\17\:qbint VSS) capacitor c=8.65998e-17
C125 (\8\:RN VSS) capacitor c=7.67781e-17
C126 (\6\:n30 VSS) capacitor c=1.10756e-16
C127 (\9\:RN VSS) capacitor c=1.47977e-16
C128 (\10\:RN VSS) capacitor c=1.49566e-16
C129 (\4\:mout VSS) capacitor c=7.83737e-17
C130 (\5\:mout VSS) capacitor c=8.73836e-17
C131 (\7\:n20 VSS) capacitor c=8.95382e-17
C132 (\10\:n20 VSS) capacitor c=8.27331e-17
C133 (\11\:Ckbb VSS) capacitor c=1.09307e-17
C134 (\12\:Ckbb VSS) capacitor c=1.88282e-16
C135 (\15\:Ckbb VSS) capacitor c=2.76826e-17
C136 (\16\:Ckbb VSS) capacitor c=1.09283e-16
C137 (\11\:CKb VSS) capacitor c=8.09036e-17
C138 (\12\:CKb VSS) capacitor c=1.6939e-16
C139 (\13\:CKb VSS) capacitor c=1.31946e-16
C140 (\14\:CKb VSS) capacitor c=1.34592e-16
C141 (\15\:CKb VSS) capacitor c=1.31421e-16
C142 (\18\:CKb VSS) capacitor c=4.8027e-17
C143 (\19\:CKb VSS) capacitor c=7.73996e-17
C144 (\5\:D VSS) capacitor c=5.22263e-17
C145 (\3\:Db VSS) capacitor c=1.96302e-16
C146 (\8\:SE VSS) capacitor c=5.05749e-17
C147 (\9\:SE VSS) capacitor c=1.08704e-16
C148 (\10\:SE VSS) capacitor c=5.63534e-17
C149 (\11\:SE VSS) capacitor c=2.53998e-17
C150 (\6\:SEb VSS) capacitor c=8.84453e-17
C151 (\7\:SEb VSS) capacitor c=7.67163e-17
C152 (\5\:VDD VSS) capacitor c=4.5593e-17
C153 (\9\:VDD VSS) capacitor c=8.51111e-18
C154 (\12\:VDD VSS) capacitor c=3.16857e-17
C155 (\15\:VDD VSS) capacitor c=3.51272e-17
C156 (\18\:VDD VSS) capacitor c=1.1838e-17
C157 (\22\:VDD VSS) capacitor c=1.61185e-17
C158 (\25\:VDD VSS) capacitor c=1.63476e-17
Rk13 (\8\:RN RN) resistor r=0.09899 c=0
Rk16 (\9\:RN \10\:RN) resistor r=0.9727 c=0
Rk2 (\4\:QN QN) resistor r=0.07352 c=0
Rk1 (\2\:QN \4\:QN) resistor r=0.2248 c=0
Rk43 (SE \8\:SE) resistor r=0.1056 c=0
Rk44 (\8\:SE \9\:SE) resistor r=0.4136 c=0
Rk45 (\9\:SE \10\:SE) resistor r=0.4637 c=0
Rk46 (\9\:SE \11\:SE) resistor r=0.101 c=0
Rk6 (Q \2\:Q) resistor r=0.3685 c=0
Rk7 (Q \4\:Q) resistor r=0.1681 c=0
Rk42 (\4\:SI SI) resistor r=0.004561 c=0
Rk50 (\2\:VDD \4\:VDD) resistor r=0.3542 c=0
Rk51 (\4\:VDD \5\:VDD) resistor r=0.4393 c=0
Rk52 (\5\:VDD \7\:VDD) resistor r=0.07393 c=0
Rk53 (\5\:VDD \8\:VDD) resistor r=0.4638 c=0
Rk54 (\8\:VDD \9\:VDD) resistor r=0.0951 c=0
Rk55 (\9\:VDD \11\:VDD) resistor r=0.07393 c=0
Rk56 (\9\:VDD \12\:VDD) resistor r=0.1993 c=0
Rk57 (\12\:VDD \14\:VDD) resistor r=0.04331 c=0
Rk58 (\12\:VDD \15\:VDD) resistor r=0.4792 c=0
Rk59 (\15\:VDD \17\:VDD) resistor r=0.04331 c=0
Rk60 (\15\:VDD \18\:VDD) resistor r=0.2344 c=0
Rk61 (\18\:VDD \20\:VDD) resistor r=0.1808 c=0
Rk62 (\18\:VDD \21\:VDD) resistor r=0.1904 c=0
Rk63 (\21\:VDD \22\:VDD) resistor r=0.04244 c=0
Rk64 (\22\:VDD \24\:VDD) resistor r=0.1742 c=0
Rk67 (\25\:VDD VDD) resistor r=0.1952 c=0
Rk65 (\22\:VDD \25\:VDD) resistor r=0.3131 c=0
Rk66 (\25\:VDD \27\:VDD) resistor r=0.4181 c=0
Rk8 (\4\:CK CK) resistor r=0.1052 c=0
Rk37 (D \5\:D) resistor r=0.1792 c=0
Rk68 (\2\:VSS \3\:VSS) resistor r=0.03742 c=0
Rk69 (\3\:VSS \4\:VSS) resistor r=0.4209 c=0
Rk70 (\4\:VSS \5\:VSS) resistor r=0.4437 c=0
Rk71 (\5\:VSS \6\:VSS) resistor r=0.2446 c=0
Rk72 (\6\:VSS \7\:VSS) resistor r=0.588 c=0
Rk73 (\7\:VSS \8\:VSS) resistor r=0.3685 c=0
Rk74 (\8\:VSS \9\:VSS) resistor r=0.09009 c=0
Rk76 (\10\:VSS VSS) resistor r=0.1952 c=0
Rk75 (\9\:VSS \10\:VSS) resistor r=0.2654 c=0
Rk77 (\3\:VSS \12\:VSS) resistor r=0.1995 c=0
Rk78 (\4\:VSS \14\:VSS) resistor r=0.2091 c=0
Rk79 (\6\:VSS \16\:VSS) resistor r=0.04331 c=0
Rk80 (\7\:VSS \18\:VSS) resistor r=0.2222 c=0
Rk81 (\9\:VSS \20\:VSS) resistor r=0.07393 c=0
Rk82 (\10\:VSS \22\:VSS) resistor r=0.07393 c=0
Rk3 (\5\:qint \6\:qint) resistor r=0.1328 c=0
Rk4 (\6\:qint \8\:qint) resistor r=0.09313 c=0
Rk5 (\6\:qint \10\:qint) resistor r=0.1309 c=0
Rk9 (\12\:qbint \13\:qbint) resistor r=0.5286 c=0
Rk10 (\13\:qbint \15\:qbint) resistor r=0.09595 c=0
Rk11 (\13\:qbint \16\:qbint) resistor r=0.3845 c=0
Rk12 (\15\:qbint \17\:qbint) resistor r=0.665 c=0
Rk29 (\11\:CKb \12\:CKb) resistor r=0.5978 c=0
Rk30 (\12\:CKb \13\:CKb) resistor r=0.8991 c=0
Rk31 (\13\:CKb \14\:CKb) resistor r=0.3104 c=0
Rk32 (\14\:CKb \15\:CKb) resistor r=0.661 c=0
Rk33 (\15\:CKb \17\:CKb) resistor r=0.5176 c=0
Rk34 (\13\:CKb \18\:CKb) resistor r=0.2445 c=0
Rk35 (\14\:CKb \19\:CKb) resistor r=0.3498 c=0
Rk36 (\15\:CKb \21\:CKb) resistor r=0.08144 c=0
Rk14 (\5\:n30 \6\:n30) resistor r=0.6214 c=0
Rk15 (\5\:n30 \8\:n30) resistor r=0.3881 c=0
Rk17 (\4\:mout \5\:mout) resistor r=0.4455 c=0
Rk18 (\5\:mout \7\:mout) resistor r=0.405 c=0
Rk19 (\5\:mout \9\:mout) resistor r=0.05684 c=0
Rk24 (\10\:Ckbb \11\:Ckbb) resistor r=0.08701 c=0
Rk25 (\11\:Ckbb \12\:Ckbb) resistor r=0.4681 c=0
Rk26 (\10\:Ckbb \14\:Ckbb) resistor r=0.5517 c=0
Rk27 (\11\:Ckbb \15\:Ckbb) resistor r=0.1831 c=0
Rk28 (\12\:Ckbb \16\:Ckbb) resistor r=0.8746 c=0
Rk21 (\6\:n20 \7\:n20) resistor r=0.2028 c=0
Rk22 (\7\:n20 \9\:n20) resistor r=0.2131 c=0
Rk23 (\7\:n20 \10\:n20) resistor r=0.5012 c=0
Rk38 (\2\:Db \3\:Db) resistor r=0.8212 c=0
Rk39 (\3\:Db \5\:Db) resistor r=0.8111 c=0
Rk40 (\5\:Db \7\:Db) resistor r=0.3734 c=0
Rk41 (\3\:Db \9\:Db) resistor r=0.1388 c=0
Rk47 (\5\:SEb \6\:SEb) resistor r=0.04795 c=0
Rk48 (\6\:SEb \7\:SEb) resistor r=0.5048 c=0
Rk49 (\6\:SEb \9\:SEb) resistor r=0.6954 c=0
Rk20 (\2\:n6 \4\:n6) resistor r=0.2147 c=0
Rl27 (\5\:RN \6\:RN) resistor r=163.027 c=0
Rl28 (\6\:RN \7\:RN) resistor r=69.9225 c=0
Rl14 (\1\:RN \2\:RN) resistor r=69.9225 c=0
Rl15 (\2\:RN \3\:RN) resistor r=26.1806 c=0
Rl16 (\3\:RN \4\:RN) resistor r=87.7867 c=0
Rl46 (\5\:SE \6\:SE) resistor r=193 c=0
Rl47 (\6\:SE \7\:SE) resistor r=29.5379 c=0
Rl43 (\3\:SE \4\:SE) resistor r=81.461 c=0
Rl40 (\1\:SE \2\:SE) resistor r=66.4826 c=0
Rl44 (\1\:SI \2\:SI) resistor r=143.464 c=0
Rl45 (\2\:SI \3\:SI) resistor r=76.1559 c=0
Rl10 (\1\:CK \2\:CK) resistor r=130.002 c=0
Rl11 (\2\:CK \3\:CK) resistor r=101.156 c=0
Rl37 (\1\:D \2\:D) resistor r=191.187 c=0
Rl39 (\2\:D \4\:D) resistor r=46.9565 c=0
Rl38 (\2\:D \3\:D) resistor r=3.1183 c=0
Rl3 (\2\:qint \4\:qint) resistor r=49.7141 c=0
Rl2 (\2\:qint \3\:qint) resistor r=34.3295 c=0
Rl1 (qint \2\:qint) resistor r=5.915 c=0
Rl17 (\8\:qbint \9\:qbint) resistor r=80.7563 c=0
Rl18 (\9\:qbint \10\:qbint) resistor r=26.098 c=0
Rl4 (qbint \2\:qbint) resistor r=205.359 c=0
Rl7 (\2\:qbint \5\:qbint) resistor r=32.4355 c=0
Rl8 (\2\:qbint \6\:qbint) resistor r=7.2648 c=0
Rl9 (\3\:qbint \7\:qbint) resistor r=49.521 c=0
Rl6 (\3\:qbint \4\:qbint) resistor r=48.048 c=0
Rl5 (\2\:qbint \3\:qbint) resistor r=147.001 c=0
Rl35 (\8\:CKb \9\:CKb) resistor r=245.637 c=0
Rl32 (\5\:CKb \6\:CKb) resistor r=120.043 c=0
Rl36 (\9\:CKb \10\:CKb) resistor r=52.1723 c=0
Rl33 (\6\:CKb \7\:CKb) resistor r=29.5379 c=0
Rl20 (\3\:CKb \4\:CKb) resistor r=24.2328 c=0
Rl19 (CKb \2\:CKb) resistor r=39.6174 c=0
Rl12 (n30 \2\:n30) resistor r=139.611 c=0
Rl13 (\2\:n30 \3\:n30) resistor r=26.1559 c=0
Rl29 (mout \2\:mout) resistor r=89.6174 c=0
Rl30 (\2\:mout \3\:mout) resistor r=24.2328 c=0
Rl34 (\7\:Ckbb \8\:Ckbb) resistor r=141.821 c=0
Rl31 (\5\:Ckbb \6\:Ckbb) resistor r=35.7713 c=0
Rl22 (\2\:Ckbb \3\:Ckbb) resistor r=141.851 c=0
Rl21 (Ckbb \2\:Ckbb) resistor r=32.3738 c=0
Rl23 (\2\:Ckbb \4\:Ckbb) resistor r=92.233 c=0
Rl25 (\2\:n20 \3\:n20) resistor r=87.0953 c=0
Rl26 (\2\:n20 \4\:n20) resistor r=49.7141 c=0
Rl24 (n20 \2\:n20) resistor r=11.5001 c=0
Rl41 (SEb \2\:SEb) resistor r=25.0391 c=0
Rl42 (\2\:SEb \3\:SEb) resistor r=195.65 c=0
Rz1 (\3\:QN \4\:QN) resistor r=75 c=0
Rz3 (\1\:Q \2\:Q) resistor r=75 c=0
Rz13 (\3\:VDD \4\:VDD) resistor r=12.5 c=0
Rz14 (\3\:VDD \8\:VDD) resistor r=6.25 c=0
Rz15 (\3\:VDD \21\:VDD) resistor r=6.25 c=0
Rz16 (\11\:VSS \12\:VSS) resistor r=75 c=0
Rz17 (\13\:VSS \14\:VSS) resistor r=75 c=0
Rz18 (\15\:VSS \16\:VSS) resistor r=75 c=0
Rz19 (\17\:VSS \18\:VSS) resistor r=75 c=0
Rz20 (\19\:VSS \20\:VSS) resistor r=75 c=0
Rz21 (\21\:VSS \22\:VSS) resistor r=75 c=0
Rz2 (\7\:qint \8\:qint) resistor r=75 c=0
Rz4 (\14\:qbint \15\:qbint) resistor r=75 c=0
Rz9 (\16\:CKb \17\:CKb) resistor r=75 c=0
Rz5 (\4\:n30 \5\:n30) resistor r=75 c=0
Rz6 (\8\:mout \9\:mout) resistor r=75 c=0
Rz8 (\9\:Ckbb \10\:Ckbb) resistor r=75 c=0
Rz7 (\5\:n20 \6\:n20) resistor r=75 c=0
Rz10 (Db \2\:Db) resistor r=75 c=0
Rz11 (\6\:Db \7\:Db) resistor r=75 c=0
Rz12 (\8\:SEb \9\:SEb) resistor r=75 c=0
Ry1 (\1\:QN \2\:QN) resistor r=62 c=0
Ry3 (\3\:Q \4\:Q) resistor r=62 c=0
Ry15 (\1\:VDD \2\:VDD) resistor r=62 c=0
Ry16 (\6\:VDD \7\:VDD) resistor r=62 c=0
Ry17 (\10\:VDD \11\:VDD) resistor r=62 c=0
Ry18 (\13\:VDD \14\:VDD) resistor r=62 c=0
Ry19 (\16\:VDD \17\:VDD) resistor r=62 c=0
Ry20 (\19\:VDD \20\:VDD) resistor r=62 c=0
Ry21 (\23\:VDD \24\:VDD) resistor r=62 c=0
Ry22 (\26\:VDD \27\:VDD) resistor r=62 c=0
Ry23 (\1\:VSS \2\:VSS) resistor r=10.3333 c=0
Ry24 (\1\:VSS \5\:VSS) resistor r=5.1667 c=0
Ry25 (\1\:VSS \8\:VSS) resistor r=5.1667 c=0
Ry2 (\9\:qint \10\:qint) resistor r=62 c=0
Ry4 (\11\:qbint \12\:qbint) resistor r=62 c=0
Ry11 (\20\:CKb \21\:CKb) resistor r=62 c=0
Ry5 (\7\:n30 \8\:n30) resistor r=62 c=0
Ry6 (\6\:mout \7\:mout) resistor r=62 c=0
Ry10 (\13\:Ckbb \14\:Ckbb) resistor r=62 c=0
Ry9 (\8\:n20 \9\:n20) resistor r=62 c=0
Ry12 (\4\:Db \5\:Db) resistor r=62 c=0
Ry13 (\8\:Db \9\:Db) resistor r=62 c=0
Ry14 (\4\:SEb \5\:SEb) resistor r=62 c=0
Ry7 (n6 \2\:n6) resistor r=62 c=0
Ry8 (\3\:n6 \4\:n6) resistor r=62 c=0
Rx5 (\3\:RN \8\:RN) resistor r=45 c=0
Rx7 (\7\:RN \9\:RN) resistor r=45 c=0
Rx8 (\1\:RN \10\:RN) resistor r=45 c=0
Rx20 (\6\:SE \8\:SE) resistor r=45 c=0
Rx21 (\2\:SE \10\:SE) resistor r=45 c=0
Rx22 (\4\:SE \11\:SE) resistor r=45 c=0
Rx19 (\2\:SI \4\:SI) resistor r=45 c=0
Rx2 (\2\:CK \4\:CK) resistor r=45 c=0
Rx18 (\3\:D \5\:D) resistor r=45 c=0
Rx1 (qint \5\:qint) resistor r=45 c=0
Rx3 (\9\:qbint \16\:qbint) resistor r=45 c=0
Rx4 (\6\:qbint \17\:qbint) resistor r=45 c=0
Rx14 (\10\:CKb \11\:CKb) resistor r=45 c=0
Rx15 (\7\:CKb \12\:CKb) resistor r=45 c=0
Rx16 (\4\:CKb \18\:CKb) resistor r=45 c=0
Rx17 (\2\:CKb \19\:CKb) resistor r=45 c=0
Rx6 (\3\:n30 \6\:n30) resistor r=45 c=0
Rx9 (\2\:mout \4\:mout) resistor r=45 c=0
Rx11 (\6\:Ckbb \12\:Ckbb) resistor r=45 c=0
Rx12 (\7\:Ckbb \15\:Ckbb) resistor r=45 c=0
Rx13 (\4\:Ckbb \16\:Ckbb) resistor r=45 c=0
Rx10 (n20 \10\:n20) resistor r=45 c=0
Rx23 (\2\:SEb \7\:SEb) resistor r=45 c=0
mn57 (\3\:QN \3\:qint \21\:VSS VSS) g45n1lvt w=(1.45e-07) l=4.5e-08 nf=1 \
        as=5.697e-14 ad=2.03e-14 ps=1.67e-06 pd=5.7e-07 nrd=1.16667 \
        nrs=1.16667 sa=1.4e-07 sb=3.7e-07 sd=160n sca=23.279 scb=0.0230742 \
        scc=0.00267719 m=(1)
mn56 (\7\:qint \4\:qbint \21\:VSS VSS) g45n1lvt w=(1.45e-07) l=4.5e-08 \
        nf=1 as=5.697e-14 ad=2.03e-14 ps=1.67e-06 pd=5.7e-07 nrd=1.16667 \
        nrs=1.16667 sa=3.7e-07 sb=1.4e-07 sd=160n sca=23.279 scb=0.0230742 \
        scc=0.00267719 m=(1)
mn55 (\1\:Q \5\:qbint \19\:VSS VSS) g45n1lvt w=(1.45e-07) l=4.5e-08 nf=1 \
        as=5.695e-14 ad=2.03e-14 ps=1.59e-06 pd=5.7e-07 nrd=1.16667 \
        nrs=1.16667 sa=1.4e-07 sb=3.85e-07 sd=160n sca=14.3814 \
        scb=0.0152134 scc=0.00088947 m=(1)
mn20 (\16\:CKb \3\:CK \19\:VSS VSS) g45n1lvt w=(1.45e-07) l=4.5e-08 nf=1 \
        as=5.695e-14 ad=2.32e-14 ps=1.59e-06 pd=6.1e-07 nrd=1.16667 \
        nrs=1.16667 sa=3.65e-07 sb=1.6e-07 sd=160n sca=14.3814 \
        scb=0.0152134 scc=0.00088947 m=(1)
mn46 (\14\:qbint \2\:n30 n9 VSS) g45n1lvt w=(1.45e-07) l=4.5e-08 nf=1 \
        as=8.7e-15 ad=3.263e-14 ps=4.1e-07 pd=7.4e-07 nrd=1.16667 \
        nrs=1.16667 sa=2.25e-07 sb=2e-06 sd=160n sca=13.6097 scb=0.014254 \
        scc=0.000755054 m=(1)
mn45 (n9 \4\:RN \17\:VSS VSS) g45n1lvt w=(1.45e-07) l=4.5e-08 nf=1 \
        as=4.75e-14 ad=8.7e-15 ps=9.9e-07 pd=4.1e-07 nrd=1.16667 \
        nrs=1.16667 sa=3.3e-07 sb=2e-06 sd=160n sca=13.6097 scb=0.014254 \
        scc=0.000755054 m=(1)
mn50 (n11 \10\:qbint \17\:VSS VSS) g45n1lvt w=(1.45e-07) l=4.5e-08 nf=1 \
        as=4.75e-14 ad=8.7e-15 ps=9.9e-07 pd=4.1e-07 nrd=1.16667 \
        nrs=1.16667 sa=5.95e-07 sb=1.87e-06 sd=160n sca=13.6097 \
        scb=0.014254 scc=0.000755054 m=(1)
mn51 (\4\:n30 CKb n11 VSS) g45n1lvt w=(1.45e-07) l=4.5e-08 nf=1 \
        as=8.7e-15 ad=3.698e-14 ps=4.1e-07 pd=8e-07 nrd=1.16667 \
        nrs=1.16667 sa=7e-07 sb=1.765e-06 sd=160n sca=13.6097 scb=0.014254 \
        scc=0.000755054 m=(1)
mn40 (\8\:mout Ckbb \4\:n30 VSS) g45n1lvt w=(1.45e-07) l=4.5e-08 nf=1 \
        as=3.698e-14 ad=6.235e-14 ps=8e-07 pd=1.15e-06 nrd=1.16667 \
        nrs=1.16667 sa=1e-06 sb=1.465e-06 sd=160n sca=13.6097 scb=0.014254 \
        scc=0.000755054 m=(1)
mn30 (\8\:mout \4\:n20 \15\:VSS VSS) g45n1lvt w=(1.45e-07) l=4.5e-08 \
        nf=1 as=7.45e-14 ad=6.235e-14 ps=1.44e-06 pd=1.15e-06 nrd=1.16667 \
        nrs=1.16667 sa=1.475e-06 sb=9.9e-07 sd=160n sca=13.6097 \
        scb=0.014254 scc=0.000755054 m=(1)
mn35 (n7 \5\:RN \15\:VSS VSS) g45n1lvt w=(1.45e-07) l=4.5e-08 nf=1 \
        as=7.45e-14 ad=8.7e-15 ps=1.44e-06 pd=4.1e-07 nrd=1.16667 \
        nrs=1.16667 sa=1.74e-06 sb=7.25e-07 sd=160n sca=13.6097 \
        scb=0.014254 scc=0.000755054 m=(1)
mn36 (n5 \3\:mout n7 VSS) g45n1lvt w=(1.45e-07) l=4.5e-08 nf=1 as=8.7e-15 \
        ad=1.958e-14 ps=4.1e-07 pd=5.6e-07 nrd=1.16667 nrs=1.16667 \
        sa=1.845e-06 sb=6.2e-07 sd=160n sca=13.6097 scb=0.014254 \
        scc=0.000755054 m=(1)
mn37 (\5\:n20 \5\:Ckbb n5 VSS) g45n1lvt w=(1.45e-07) l=4.5e-08 nf=1 \
        as=1.958e-14 ad=2.32e-14 ps=5.6e-07 pd=6.1e-07 nrd=1.16667 \
        nrs=1.16667 sa=2e-06 sb=4.4e-07 sd=160n sca=13.6097 scb=0.014254 \
        scc=0.000755054 m=(1)
mn25 (\6\:Db \5\:CKb \5\:n20 VSS) g45n1lvt w=(1.45e-07) l=4.5e-08 nf=1 \
        as=2.32e-14 ad=3.408e-14 ps=6.1e-07 pd=7.6e-07 nrd=1.16667 \
        nrs=1.16667 sa=2e-06 sb=2.35e-07 sd=160n sca=13.6097 scb=0.014254 \
        scc=0.000755054 m=(1)
mn21 (\9\:Ckbb \8\:CKb \13\:VSS VSS) g45n1lvt w=(1.45e-07) l=4.5e-08 \
        nf=1 as=2.32e-14 ad=2.32e-14 ps=6.1e-07 pd=6.1e-07 nrd=1.16667 \
        nrs=1.16667 sa=1.6e-07 sb=1.395e-06 sd=160n sca=7.37439 \
        scb=0.00450456 scc=4.82709e-05 m=(1)
mn11 (n1 \4\:D \13\:VSS VSS) g45n1lvt w=(1.45e-07) l=4.5e-08 nf=1 \
        as=2.32e-14 ad=4.205e-14 ps=6.1e-07 pd=8.7e-07 nrd=1.16667 \
        nrs=1.16667 sa=3.65e-07 sb=1.19e-06 sd=160n sca=7.37439 \
        scb=0.00450456 scc=4.82709e-05 m=(1)
mn12 (Db \3\:SEb n1 VSS) g45n1lvt w=(1.45e-07) l=4.5e-08 nf=1 \
        as=4.205e-14 ad=2.32e-14 ps=8.7e-07 pd=6.1e-07 nrd=1.16667 \
        nrs=1.16667 sa=7e-07 sb=8.55e-07 sd=160n sca=7.37439 \
        scb=0.00450456 scc=4.82709e-05 m=(1)
mn14 (Db \3\:SE n3 VSS) g45n1lvt w=(1.45e-07) l=4.5e-08 nf=1 as=1.16e-14 \
        ad=2.32e-14 ps=4.5e-07 pd=6.1e-07 nrd=1.16667 nrs=1.16667 \
        sa=9.05e-07 sb=6.5e-07 sd=160n sca=7.37439 scb=0.00450456 \
        scc=4.82709e-05 m=(1)
mn13 (n3 \3\:SI \11\:VSS VSS) g45n1lvt w=(1.45e-07) l=4.5e-08 nf=1 \
        as=4.93e-14 ad=1.16e-14 ps=9.7e-07 pd=4.5e-07 nrd=1.16667 \
        nrs=1.16667 sa=1.03e-06 sb=5.25e-07 sd=160n sca=7.37439 \
        scb=0.00450456 scc=4.82709e-05 m=(1)
mn10 (\8\:SEb \7\:SE \11\:VSS VSS) g45n1lvt w=(1.45e-07) l=4.5e-08 nf=1 \
        as=4.93e-14 ad=2.03e-14 ps=9.7e-07 pd=5.7e-07 nrd=1.16667 \
        nrs=1.16667 sa=1.415e-06 sb=1.4e-07 sd=160n sca=7.37439 \
        scb=0.00450456 scc=4.82709e-05 m=(1)
ends SDFFRXL
// End of subcircuit definition.
