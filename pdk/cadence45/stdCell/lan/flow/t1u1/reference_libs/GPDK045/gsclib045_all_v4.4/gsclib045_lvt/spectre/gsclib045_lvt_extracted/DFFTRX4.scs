// Generated for: spectre (May  1 09:14:11 2013 )
// Library name: gsclib045_lvt
// Cell name: DFFTRX4
// View name: extracted

simulator lang=spectre

subckt DFFTRX4 CK D Q QN RN VDD VSS
mp0 (\4\:Db \3\:RN \31\:VDD VDD) g45p1lvt w=(2.15e-07) l=4.5e-08 nf=1 \
        as=4.915e-14 ad=3.44e-14 ps=1.54e-06 pd=7.5e-07 nrd=1.16667 \
        nrs=1.16667 sa=1e-07 sb=3.05e-07 sd=160n sca=26.9085 scb=0.0317837 \
        scc=0.0019009 m=(1)
mp1 (\4\:Db \1\:D \28\:VDD VDD) g45p1lvt w=(2.15e-07) l=4.5e-08 nf=1 \
        as=3.94e-14 ad=3.44e-14 ps=1.15e-06 pd=7.5e-07 nrd=1.16667 \
        nrs=1.16667 sa=3.05e-07 sb=1e-07 sd=160n sca=18.5149 scb=0.0187285 \
        scc=0.000914624 m=(1)
mp20 (\14\:CKb \1\:CK \24\:VDD VDD) g45p1lvt w=(2.15e-07) l=4.5e-08 nf=1 \
        as=5.665e-14 ad=2.89e-14 ps=1.51e-06 pd=7.1e-07 nrd=1.16667 \
        nrs=1.16667 sa=1.34419e-07 sb=3.35e-07 sd=160n sca=45.7906 \
        scb=0.0283307 scc=0.00588417 m=(1)
mp21 (\16\:CKbb \8\:CKb \24\:VDD VDD) g45p1lvt w=(2.15e-07) l=4.5e-08 \
        nf=1 as=5.665e-14 ad=3.01e-14 ps=1.51e-06 pd=7.1e-07 nrd=1.16667 \
        nrs=1.16667 sa=3.29419e-07 sb=1.4e-07 sd=160n sca=45.7906 \
        scb=0.0283307 scc=0.00588417 m=(1)
mp25 (\8\:n20 CKbb \9\:Db VDD) g45p1lvt w=(2.15e-07) l=4.5e-08 nf=1 \
        as=3.01e-14 ad=4.515e-14 ps=7.1e-07 pd=8.5e-07 nrd=1.16667 \
        nrs=1.16667 sa=1.4e-07 sb=2e-06 sd=160n sca=20.4333 scb=0.0198015 \
        scc=0.00193653 m=(1)
mp36 (\8\:n20 \3\:CKb n26 VDD) g45p1lvt w=(2.15e-07) l=4.5e-08 nf=1 \
        as=1.29e-14 ad=4.515e-14 ps=5.5e-07 pd=8.5e-07 nrd=1.16667 \
        nrs=1.16667 sa=3.95e-07 sb=2e-06 sd=160n sca=20.4333 scb=0.0198015 \
        scc=0.00193653 m=(1)
mp35 (n26 mout \21\:VDD VDD) g45p1lvt w=(2.15e-07) l=4.5e-08 nf=1 \
        as=4.085e-14 ad=1.29e-14 ps=8.1e-07 pd=5.5e-07 nrd=1.16667 \
        nrs=1.16667 sa=5e-07 sb=2e-06 sd=160n sca=20.4333 scb=0.0198015 \
        scc=0.00193653 m=(1)
mp30 (\4\:mout n20 \21\:VDD VDD) g45p1lvt w=(2.15e-07) l=4.5e-08 nf=1 \
        as=4.085e-14 ad=7.848e-14 ps=8.1e-07 pd=1.16e-06 nrd=1.16667 \
        nrs=1.16667 sa=7.35e-07 sb=2e-06 sd=160n sca=20.4333 scb=0.0198015 \
        scc=0.00193653 m=(1)
mp40 (\10\:n30 \2\:CKb \4\:mout VDD) g45p1lvt w=(2.15e-07) l=4.5e-08 nf=1 \
        as=7.848e-14 ad=3.44e-14 ps=1.16e-06 pd=7.5e-07 nrd=1.16667 \
        nrs=1.16667 sa=1.145e-06 sb=2e-06 sd=160n sca=20.4333 \
        scb=0.0198015 scc=0.00193653 m=(1)
mp51 (\10\:n30 \7\:CKbb n36 VDD) g45p1lvt w=(2.15e-07) l=4.5e-08 nf=1 \
        as=3.118e-14 ad=3.44e-14 ps=7.2e-07 pd=7.5e-07 nrd=1.16667 \
        nrs=1.16667 sa=1.35e-06 sb=2e-06 sd=160n sca=20.4333 scb=0.0198015 \
        scc=0.00193653 m=(1)
mp50 (n36 \4\:qbint \1\:VDD VDD) g45p1lvt w=(2.15e-07) l=4.5e-08 nf=1 \
        as=5.415e-14 ad=3.118e-14 ps=1e-06 pd=7.2e-07 nrd=1.16667 \
        nrs=1.16667 sa=1.54e-06 sb=2e-06 sd=160n sca=20.4333 scb=0.0198015 \
        scc=0.00193653 m=(1)
C1 (Q VSS) capacitor c=2.15642e-17
C2 (CK VSS) capacitor c=6.74796e-17
C3 (D VSS) capacitor c=4.88228e-17
C4 (QN VSS) capacitor c=1.56535e-17
C5 (VDD VSS) capacitor c=2.94996e-16
C6 (RN VSS) capacitor c=3.71365e-17
C7 (Db VSS) capacitor c=7.10618e-17
C8 (CKb VSS) capacitor c=7.82222e-17
C9 (CKbb VSS) capacitor c=3.42558e-17
C10 (n20 VSS) capacitor c=5.17181e-17
C11 (mout VSS) capacitor c=6.22572e-17
C12 (n30 VSS) capacitor c=2.18905e-16
C13 (qbint VSS) capacitor c=2.97807e-17
C14 (qint VSS) capacitor c=2.78532e-16
C15 (n36 VSS) capacitor c=5.26647e-18
C16 (\22\:qbint VSS) capacitor c=4.66957e-17
C17 (\5\:qbint VSS) capacitor c=2.69592e-16
C18 (\4\:qbint VSS) capacitor c=3.89633e-17
C19 (\7\:CKbb VSS) capacitor c=5.08373e-17
C20 (\2\:CKb VSS) capacitor c=1.06161e-16
C21 (\3\:CKb VSS) capacitor c=1.20118e-16
C22 (\8\:CKb VSS) capacitor c=4.69292e-17
C23 (\1\:CK VSS) capacitor c=4.2722e-17
C24 (\1\:D VSS) capacitor c=3.41526e-17
C25 (\3\:RN VSS) capacitor c=3.4837e-17
C26 (\20\:qbint VSS) capacitor c=3.58522e-17
C27 (\3\:qbint VSS) capacitor c=6.35178e-17
C28 (\5\:CKbb VSS) capacitor c=3.60264e-17
C29 (\3\:n20 VSS) capacitor c=3.25762e-17
C30 (\3\:mout VSS) capacitor c=6.98256e-17
C31 (\3\:CKbb VSS) capacitor c=8.37436e-17
C32 (\7\:CKb VSS) capacitor c=2.92454e-17
C33 (\9\:CKb VSS) capacitor c=2.80519e-17
C34 (\3\:CK VSS) capacitor c=3.60296e-17
C35 (\3\:D VSS) capacitor c=4.72586e-17
C36 (\1\:RN VSS) capacitor c=4.39296e-17
C37 (\21\:qbint VSS) capacitor c=4.03719e-17
C38 (\8\:CKbb VSS) capacitor c=4.00883e-17
C39 (\6\:CKbb VSS) capacitor c=3.47592e-17
C40 (\2\:n20 VSS) capacitor c=3.65527e-17
C41 (\2\:mout VSS) capacitor c=5.69572e-17
C42 (\4\:CKbb VSS) capacitor c=2.86235e-17
C43 (\2\:CKbb VSS) capacitor c=4.75607e-17
C44 (\6\:CKb VSS) capacitor c=5.2159e-17
C45 (\2\:CK VSS) capacitor c=4.57504e-17
C46 (\2\:D VSS) capacitor c=4.21417e-17
C47 (\2\:RN VSS) capacitor c=4.28307e-17
C48 (\19\:qint VSS) capacitor c=3.50141e-17
C49 (\1\:VDD VSS) capacitor c=4.5124e-16
C50 (\1\:Q VSS) capacitor c=1.52507e-16
C51 (\30\:qbint VSS) capacitor c=5.97187e-17
C52 (\10\:n30 VSS) capacitor c=5.857e-17
C53 (\4\:mout VSS) capacitor c=2.34004e-17
C54 (\21\:VDD VSS) capacitor c=3.6455e-17
C55 (\8\:n20 VSS) capacitor c=3.02932e-17
C56 (\9\:Db VSS) capacitor c=2.53587e-17
C57 (\16\:CKbb VSS) capacitor c=7.72455e-17
C58 (\24\:VDD VSS) capacitor c=1.93894e-17
C59 (\14\:CKb VSS) capacitor c=1.19706e-16
C60 (\28\:VDD VSS) capacitor c=2.07766e-17
C61 (\4\:Db VSS) capacitor c=3.82025e-17
C62 (\31\:VDD VSS) capacitor c=6.79915e-18
C63 (\3\:VDD VSS) capacitor c=6.08129e-17
C64 (\15\:qint VSS) capacitor c=4.45701e-17
C65 (\1\:QN VSS) capacitor c=1.1926e-16
C66 (\24\:qbint VSS) capacitor c=2.20326e-16
C67 (\8\:n30 VSS) capacitor c=6.50926e-17
C68 (\8\:mout VSS) capacitor c=5.06245e-17
C69 (\6\:n20 VSS) capacitor c=3.83399e-17
C70 (\7\:Db VSS) capacitor c=9.88909e-17
C71 (\11\:CKbb VSS) capacitor c=8.87963e-17
C72 (\12\:CKb VSS) capacitor c=1.92135e-17
C73 (\4\:CKb VSS) capacitor c=8.03502e-17
C74 (\2\:qbint VSS) capacitor c=3.37934e-17
C75 (\4\:RN VSS) capacitor c=5.57303e-17
C76 (\4\:D VSS) capacitor c=8.61483e-17
C77 (\4\:CK VSS) capacitor c=6.91582e-17
C78 (\10\:CKb VSS) capacitor c=8.30512e-17
C79 (\11\:CKb VSS) capacitor c=1.01375e-16
C80 (\3\:Db VSS) capacitor c=1.57419e-16
C81 (\6\:Db VSS) capacitor c=1.26681e-16
C82 (\4\:n20 VSS) capacitor c=5.79274e-17
C83 (\5\:n20 VSS) capacitor c=5.5722e-17
C84 (\6\:mout VSS) capacitor c=5.44229e-17
C85 (\7\:mout VSS) capacitor c=4.50696e-17
C86 (\9\:CKbb VSS) capacitor c=1.11445e-16
C87 (\10\:CKbb VSS) capacitor c=6.20574e-17
C88 (\13\:CKbb VSS) capacitor c=1.2723e-16
C89 (\14\:CKbb VSS) capacitor c=6.38531e-17
C90 (\15\:CKbb VSS) capacitor c=7.19645e-17
C91 (\6\:n30 VSS) capacitor c=5.19904e-17
C92 (\7\:n30 VSS) capacitor c=8.55732e-17
C93 (\4\:Q VSS) capacitor c=1.2294e-16
C94 (\5\:QN VSS) capacitor c=1.65636e-16
C95 (\23\:qbint VSS) capacitor c=2.44076e-16
C96 (\26\:qbint VSS) capacitor c=2.8374e-17
C97 (\27\:qbint VSS) capacitor c=2.28967e-17
C98 (\28\:qbint VSS) capacitor c=4.7337e-17
C99 (\29\:qbint VSS) capacitor c=2.63193e-17
C100 (\17\:qint VSS) capacitor c=3.51979e-17
C101 (\18\:qint VSS) capacitor c=3.79257e-17
C102 (\20\:VDD VSS) capacitor c=3.3376e-17
C103 (\23\:VDD VSS) capacitor c=2.17427e-17
C104 (\27\:VDD VSS) capacitor c=1.42764e-17
C105 (\30\:VDD VSS) capacitor c=6.15764e-18
Rk28 (\1\:Q Q) resistor r=0.04985 c=0
Rk29 (Q \4\:Q) resistor r=0.2115 c=0
Rk54 (\1\:VSS \11\:VSS) resistor r=0.4548 c=0
Rk55 (\11\:VSS \12\:VSS) resistor r=0.5751 c=0
Rk56 (\12\:VSS \13\:VSS) resistor r=0.1276 c=0
Rk58 (\14\:VSS VSS) resistor r=0.02211 c=0
Rk57 (\13\:VSS \14\:VSS) resistor r=0.5286 c=0
Rk64 (\11\:VSS \26\:VSS) resistor r=0.04327 c=0
Rk65 (\12\:VSS \28\:VSS) resistor r=0.1835 c=0
Rk66 (\14\:VSS \30\:VSS) resistor r=0.3326 c=0
Rk3 (\4\:CK CK) resistor r=0.03634 c=0
Rk2 (D \4\:D) resistor r=0.02649 c=0
Rk34 (\1\:QN QN) resistor r=0.2166 c=0
Rk35 (QN \5\:QN) resistor r=0.04792 c=0
Rk78 (\1\:VDD \20\:VDD) resistor r=0.5136 c=0
Rk79 (\20\:VDD \22\:VDD) resistor r=0.3625 c=0
Rk80 (\20\:VDD \23\:VDD) resistor r=0.5084 c=0
Rk81 (\23\:VDD \25\:VDD) resistor r=0.203 c=0
Rk82 (\23\:VDD \26\:VDD) resistor r=0.1802 c=0
Rk83 (\26\:VDD \27\:VDD) resistor r=0.3206 c=0
Rk84 (\27\:VDD \29\:VDD) resistor r=0.203 c=0
Rk87 (\30\:VDD VDD) resistor r=0.02963 c=0
Rk85 (\27\:VDD \30\:VDD) resistor r=0.2001 c=0
Rk86 (\30\:VDD \32\:VDD) resistor r=0.07346 c=0
Rk1 (\4\:RN RN) resistor r=0.01719 c=0
Rk7 (\2\:Db \3\:Db) resistor r=0.5579 c=0
Rk8 (\3\:Db \5\:Db) resistor r=0.2605 c=0
Rk9 (\3\:Db \6\:Db) resistor r=0.8671 c=0
Rk10 (\6\:Db \8\:Db) resistor r=0.4629 c=0
Rk11 (\6\:Db \10\:Db) resistor r=0.0619 c=0
Rk4 (\10\:CKb \11\:CKb) resistor r=0.4907 c=0
Rk5 (\11\:CKb \13\:CKb) resistor r=0.1204 c=0
Rk6 (\11\:CKb \15\:CKb) resistor r=0.642 c=0
Rk18 (\9\:CKbb \10\:CKbb) resistor r=0.1842 c=0
Rk19 (\10\:CKbb \12\:CKbb) resistor r=0.2568 c=0
Rk20 (\9\:CKbb \13\:CKbb) resistor r=0.7568 c=0
Rk21 (\13\:CKbb \14\:CKbb) resistor r=0.3027 c=0
Rk22 (\10\:CKbb \15\:CKbb) resistor r=0.3655 c=0
Rk23 (\12\:CKbb \17\:CKbb) resistor r=0.4721 c=0
Rk12 (\4\:n20 \5\:n20) resistor r=0.2794 c=0
Rk13 (\5\:n20 \7\:n20) resistor r=0.1269 c=0
Rk14 (\5\:n20 \9\:n20) resistor r=0.2555 c=0
Rk15 (\5\:mout \6\:mout) resistor r=0.1403 c=0
Rk16 (\6\:mout \7\:mout) resistor r=0.2406 c=0
Rk17 (\6\:mout \9\:mout) resistor r=0.2577 c=0
Rk24 (\6\:n30 \7\:n30) resistor r=0.258 c=0
Rk25 (\7\:n30 \9\:n30) resistor r=0.3134 c=0
Rk26 (\7\:n30 \11\:n30) resistor r=0.419 c=0
Rk38 (\23\:qbint \25\:qbint) resistor r=1.8737 c=0
Rk39 (\25\:qbint \26\:qbint) resistor r=0.433 c=0
Rk40 (\26\:qbint \27\:qbint) resistor r=0.1039 c=0
Rk41 (\27\:qbint \28\:qbint) resistor r=0.178 c=0
Rk42 (\26\:qbint \29\:qbint) resistor r=0.06882 c=0
Rk43 (\27\:qbint \31\:qbint) resistor r=0.197 c=0
Rk44 (\16\:qint \17\:qint) resistor r=0.3535 c=0
Rk45 (\17\:qint \18\:qint) resistor r=0.2067 c=0
Rk46 (\17\:qint \20\:qint) resistor r=0.1262 c=0
Rl5 (\1\:CK \2\:CK) resistor r=71.1538 c=0
Rl6 (\2\:CK \3\:CK) resistor r=101.374 c=0
Rl3 (\1\:D \2\:D) resistor r=57.6923 c=0
Rl4 (\2\:D \3\:D) resistor r=78.2967 c=0
Rl2 (\2\:RN \3\:RN) resistor r=88.2566 c=0
Rl1 (\1\:RN \2\:RN) resistor r=48.161 c=0
Rl15 (\2\:CKb \3\:CKb) resistor r=408.747 c=0
Rl14 (CKb \2\:CKb) resistor r=187.593 c=0
Rl21 (\6\:CKb \9\:CKb) resistor r=80.2255 c=0
Rl16 (\3\:CKb \4\:CKb) resistor r=168.774 c=0
Rl19 (\4\:CKb \7\:CKb) resistor r=30.4507 c=0
Rl20 (\5\:CKb \8\:CKb) resistor r=83.7744 c=0
Rl18 (\5\:CKb \6\:CKb) resistor r=14.7598 c=0
Rl17 (\4\:CKb \5\:CKb) resistor r=201.998 c=0
Rl22 (\7\:CKbb \8\:CKbb) resistor r=29.5379 c=0
Rl13 (\5\:CKbb \6\:CKbb) resistor r=29.5379 c=0
Rl8 (\3\:CKbb \4\:CKbb) resistor r=58.3841 c=0
Rl7 (CKbb \2\:CKbb) resistor r=53.079 c=0
Rl11 (n20 \2\:n20) resistor r=100.692 c=0
Rl12 (\2\:n20 \3\:n20) resistor r=29.5379 c=0
Rl9 (mout \2\:mout) resistor r=37.6944 c=0
Rl10 (\2\:mout \3\:mout) resistor r=89.6174 c=0
Rl58 (\21\:qbint \22\:qbint) resistor r=62.6944 c=0
Rl57 (\21\:qbint \20\:qbint) resistor r=69.7702 c=0
Rl25 (\2\:qbint \4\:qbint) resistor r=37.3411 c=0
Rl24 (\2\:qbint \3\:qbint) resistor r=129.214 c=0
Rl23 (\2\:qbint qbint) resistor r=6.99 c=0
Rz20 (\26\:VSS \25\:VSS) resistor r=75 c=0
Rz21 (\28\:VSS \27\:VSS) resistor r=75 c=0
Rz22 (\30\:VSS \29\:VSS) resistor r=75 c=0
Rz24 (\1\:VDD \3\:VDD) resistor r=3.75 c=0
Rz25 (\26\:VDD \3\:VDD) resistor r=6.25 c=0
Rz2 (Db \2\:Db) resistor r=75 c=0
Rz3 (\7\:Db \8\:Db) resistor r=75 c=0
Rz1 (\12\:CKb \13\:CKb) resistor r=75 c=0
Rz6 (\11\:CKbb \12\:CKbb) resistor r=75 c=0
Rz4 (\6\:n20 \7\:n20) resistor r=75 c=0
Rz5 (\8\:mout \9\:mout) resistor r=75 c=0
Rz7 (\9\:n30 \8\:n30) resistor r=75 c=0
Rz12 (\25\:qbint \24\:qbint) resistor r=75 c=0
Rz13 (\16\:qint \15\:qint) resistor r=75 c=0
Ry14 (\1\:VSS \3\:VSS) resistor r=3.1 c=0
Ry16 (\13\:VSS \3\:VSS) resistor r=5.1667 c=0
Ry23 (\22\:VDD \21\:VDD) resistor r=62 c=0
Ry24 (\25\:VDD \24\:VDD) resistor r=62 c=0
Ry25 (\29\:VDD \28\:VDD) resistor r=62 c=0
Ry26 (\32\:VDD \31\:VDD) resistor r=62 c=0
Ry2 (\4\:Db \5\:Db) resistor r=62 c=0
Ry3 (\9\:Db \10\:Db) resistor r=62 c=0
Ry1 (\14\:CKb \15\:CKb) resistor r=62 c=0
Ry6 (\16\:CKbb \17\:CKbb) resistor r=62 c=0
Ry4 (\8\:n20 \9\:n20) resistor r=62 c=0
Ry5 (\4\:mout \5\:mout) resistor r=62 c=0
Ry7 (\11\:n30 \10\:n30) resistor r=62 c=0
Ry12 (\31\:qbint \30\:qbint) resistor r=31 c=0
Ry13 (\20\:qint \19\:qint) resistor r=20.6667 c=0
Rx3 (\2\:CK \4\:CK) resistor r=45 c=0
Rx2 (\2\:D \4\:D) resistor r=45 c=0
Rx1 (\2\:RN \4\:RN) resistor r=45 c=0
Rx4 (\6\:CKb \10\:CKb) resistor r=45 c=0
Rx7 (\4\:CKbb \9\:CKbb) resistor r=45 c=0
Rx8 (\6\:CKbb \13\:CKbb) resistor r=45 c=0
Rx9 (\8\:CKbb \14\:CKbb) resistor r=45 c=0
Rx10 (\2\:CKbb \15\:CKbb) resistor r=45 c=0
Rx5 (\2\:n20 \4\:n20) resistor r=45 c=0
Rx6 (\2\:mout \7\:mout) resistor r=45 c=0
Rx11 (\6\:n30 n30) resistor r=45 c=0
Rx12 (\23\:qbint \21\:qbint) resistor r=45 c=0
Rx13 (\28\:qbint qbint) resistor r=45 c=0
Rx14 (\29\:qbint \5\:qbint) resistor r=45 c=0
Rx15 (\18\:qint qint) resistor r=45 c=0
mn0 (n0 \1\:RN \29\:VSS VSS) g45n1lvt w=(1.45e-07) l=4.5e-08 nf=1 \
        as=2.03e-14 ad=8.7e-15 ps=5.7e-07 pd=4.1e-07 nrd=1.16667 \
        nrs=1.16667 sa=1.4e-07 sb=2.45e-07 sd=160n sca=16.7245 \
        scb=0.0178071 scc=0.00133148 m=(1)
mn1 (Db \3\:D n0 VSS) g45n1lvt w=(1.45e-07) l=4.5e-08 nf=1 as=8.7e-15 \
        ad=2.03e-14 ps=4.1e-07 pd=5.7e-07 nrd=1.16667 nrs=1.16667 \
        sa=2.45e-07 sb=1.4e-07 sd=160n sca=16.7245 scb=0.0178071 \
        scc=0.00133148 m=(1)
mn20 (\12\:CKb \3\:CK \27\:VSS VSS) g45n1lvt w=(1.45e-07) l=4.5e-08 nf=1 \
        as=2.828e-14 ad=5.728e-14 ps=6.8e-07 pd=1.08e-06 nrd=1.16667 \
        nrs=1.16667 sa=3.95e-07 sb=3.85e-07 sd=160n sca=6.83173 \
        scb=0.00357784 scc=2.82929e-05 m=(1)
mn21 (\11\:CKbb \9\:CKb \27\:VSS VSS) g45n1lvt w=(1.45e-07) l=4.5e-08 \
        nf=1 as=2.827e-14 ad=2.103e-14 ps=6.8e-07 pd=5.8e-07 nrd=1.16667 \
        nrs=1.16667 sa=6.35e-07 sb=1.45e-07 sd=160n sca=6.83173 \
        scb=0.00357784 scc=2.82929e-05 m=(1)
mn25 (\6\:n20 \7\:CKb \7\:Db VSS) g45n1lvt w=(1.45e-07) l=4.5e-08 nf=1 \
        as=4.132e-14 ad=2.32e-14 ps=8.6e-07 pd=6.1e-07 nrd=1.16667 \
        nrs=1.16667 sa=2.85e-07 sb=2e-06 sd=160n sca=13.253 scb=0.0137915 \
        scc=0.000695334 m=(1)
mn36 (\6\:n20 \3\:CKbb n25 VSS) g45n1lvt w=(1.45e-07) l=4.5e-08 nf=1 \
        as=8.7e-15 ad=2.32e-14 ps=4.1e-07 pd=6.1e-07 nrd=1.16667 \
        nrs=1.16667 sa=4.9e-07 sb=2e-06 sd=160n sca=13.253 scb=0.0137915 \
        scc=0.000695334 m=(1)
mn35 (n25 \3\:mout \25\:VSS VSS) g45n1lvt w=(1.45e-07) l=4.5e-08 nf=1 \
        as=5.345e-14 ad=8.7e-15 ps=1.51e-06 pd=4.1e-07 nrd=1.16667 \
        nrs=1.16667 sa=5.95e-07 sb=2e-06 sd=160n sca=13.253 scb=0.0137915 \
        scc=0.000695334 m=(1)
mn30 (\8\:mout \3\:n20 \25\:VSS VSS) g45n1lvt w=(1.45e-07) l=4.5e-08 \
        nf=1 as=5.345e-14 ad=3.625e-14 ps=1.51e-06 pd=7.9e-07 nrd=1.16667 \
        nrs=1.16667 sa=8.3e-07 sb=2e-06 sd=160n sca=13.253 scb=0.0137915 \
        scc=0.000695334 m=(1)
mn40 (\8\:n30 \5\:CKbb \8\:mout VSS) g45n1lvt w=(1.45e-07) l=4.5e-08 nf=1 \
        as=3.625e-14 ad=3.552e-14 ps=7.9e-07 pd=7.8e-07 nrd=1.16667 \
        nrs=1.16667 sa=1.125e-06 sb=2e-06 sd=160n sca=13.253 scb=0.0137915 \
        scc=0.000695334 m=(1)
mn51 (\8\:n30 CKb n35 VSS) g45n1lvt w=(1.45e-07) l=4.5e-08 nf=1 \
        as=1.087e-14 ad=3.552e-14 ps=4.4e-07 pd=7.8e-07 nrd=1.16667 \
        nrs=1.16667 sa=1.415e-06 sb=2e-06 sd=160n sca=13.253 scb=0.0137915 \
        scc=0.000695334 m=(1)
mn50 (n35 \3\:qbint \1\:VSS VSS) g45n1lvt w=(1.45e-07) l=4.5e-08 nf=1 \
        as=2.92e-14 ad=1.087e-14 ps=7.3e-07 pd=4.4e-07 nrd=1.16667 \
        nrs=1.16667 sa=1.535e-06 sb=2e-06 sd=160n sca=13.253 scb=0.0137915 \
        scc=0.000695334 m=(1)
mn45_1__rcx (\24\:qbint n30 \1\:VSS VSS) g45n1lvt w=(2.05e-07) l=4.5e-08 \
        nf=1 as=5.592e-14 ad=3.28e-14 ps=1.08e-06 pd=7.3e-07 nrd=1.16667 \
        nrs=1.16667 sa=1.26e-06 sb=2e-06 sd=160n sca=11.814 scb=0.0116374 \
        scc=0.000520744 m=(2)
mn56 (\15\:qint \20\:qbint \1\:VSS VSS) g45n1lvt w=(2.6e-07) l=4.5e-08 \
        nf=1 as=6.76e-14 ad=3.64e-14 ps=1.04e-06 pd=8e-07 nrd=1.16667 \
        nrs=1.16667 sa=2e-06 sb=1.4e-07 sd=160n sca=10.79 scb=0.0100512 \
        scc=0.000418069 m=(1)
mn57_1__rcx (\1\:QN qint \1\:VSS VSS) g45n1lvt w=(2.6e-07) l=4.5e-08 \
        nf=1 as=8.095e-14 ad=4.745e-14 ps=1.3325e-06 pd=8.85e-07 \
        nrd=1.16667 nrs=1.16667 sa=1.69865e-06 sb=1.165e-06 sd=160n \
        sca=10.79 scb=0.0100512 scc=0.000418069 m=(4)
mn55_1__rcx (\4\:Q \5\:qbint \1\:VSS VSS) g45n1lvt w=(2.6e-07) l=4.5e-08 \
        nf=1 as=8.471e-14 ad=4.16e-14 ps=1.43e-06 pd=8.4e-07 nrd=1.16667 \
        nrs=1.16667 sa=1.28288e-06 sb=2e-06 sd=160n sca=10.79 \
        scb=0.0100512 scc=0.000418069 m=(4)
mp45 (\30\:qbint n30 \1\:VDD VDD) g45p1lvt w=(3.1e-07) l=4.5e-08 nf=1 \
        as=6.213e-14 ad=4.96e-14 ps=1.08e-06 pd=9.4e-07 nrd=1.16667 \
        nrs=1.16667 sa=1.27395e-06 sb=2e-06 sd=160n sca=17.3904 \
        scb=0.0162056 scc=0.00137566 m=(2)
mp56 (\19\:qint \22\:qbint \1\:VDD VDD) g45p1lvt w=(3.9e-07) l=4.5e-08 \
        nf=1 as=6.24e-14 ad=5.46e-14 ps=1.1e-06 pd=1.06e-06 nrd=1.16667 \
        nrs=1.16667 sa=1.96e-06 sb=1.4e-07 sd=160n sca=32.2573 \
        scb=0.0215683 scc=0.00336427 m=(1)
mp55_1__rcx (\1\:Q \5\:qbint \1\:VDD VDD) g45p1lvt w=(3.9e-07) l=4.5e-08 \
        nf=1 as=6.433e-14 ad=6.24e-14 ps=1.115e-06 pd=1.1e-06 nrd=1.16667 \
        nrs=1.16667 sa=1.27256e-06 sb=1.805e-06 sd=160n sca=30.5009 \
        scb=0.0202006 scc=0.00336097 m=(4)
mp57 (\5\:QN qint \1\:VDD VDD) g45p1lvt w=(3.9e-07) l=4.5e-08 nf=1 \
        as=6.24e-14 ad=6.728e-14 ps=1.1e-06 pd=1.125e-06 nrd=1.16667 \
        nrs=1.16667 sa=1.64051e-06 sb=9.85e-07 sd=160n sca=30.5009 \
        scb=0.0202006 scc=0.00336097 m=(4)
ends DFFTRX4
// End of subcircuit definition.
