// Generated for: spectre (May  1 09:13:39 2013 )
// Library name: gsclib045_lvt
// Cell name: DFFQX2
// View name: extracted

simulator lang=spectre

subckt DFFQX2 CK D Q VDD VSS
mp20 (\22\:CKb \3\:CK \16\:VDD VDD) g45p1lvt w=(2.15e-07) l=4.5e-08 nf=1 \
        as=3.01e-14 ad=5.15e-14 ps=7.1e-07 pd=1.13e-06 nrd=1.16667 \
        nrs=1.16667 sa=1.4e-07 sb=2.39535e-07 sd=160n sca=53.3953 \
        scb=0.0394806 scc=0.00625575 m=(1)
mp21 (\13\:CKbb CKb \14\:VDD VDD) g45p1lvt w=(2.15e-07) l=4.5e-08 nf=1 \
        as=3.44e-14 ad=3.01e-14 ps=7.5e-07 pd=7.1e-07 nrd=1.16667 \
        nrs=1.16667 sa=1.4e-07 sb=2e-06 sd=160n sca=11.0642 scb=0.00864592 \
        scc=0.000148882 m=(1)
mp25 (n22 \3\:D \14\:VDD VDD) g45p1lvt w=(2.15e-07) l=4.5e-08 nf=1 \
        as=3.44e-14 ad=2.472e-14 ps=7.5e-07 pd=6.6e-07 nrd=1.16667 \
        nrs=1.16667 sa=3.45e-07 sb=2e-06 sd=160n sca=10.8061 \
        scb=0.00857865 scc=0.000148871 m=(1)
mp26 (\5\:n20 \3\:CKbb n22 VDD) g45p1lvt w=(2.15e-07) l=4.5e-08 nf=1 \
        as=2.472e-14 ad=6.773e-14 ps=6.6e-07 pd=1.06e-06 nrd=1.16667 \
        nrs=1.16667 sa=5.05e-07 sb=2e-06 sd=160n sca=10.8061 \
        scb=0.00857865 scc=0.000148871 m=(1)
mp36 (\5\:n20 \6\:CKb n26 VDD) g45p1lvt w=(2.15e-07) l=4.5e-08 nf=1 \
        as=1.29e-14 ad=6.773e-14 ps=5.5e-07 pd=1.06e-06 nrd=1.16667 \
        nrs=1.16667 sa=8.65e-07 sb=1.88884e-06 sd=160n sca=10.8061 \
        scb=0.00857865 scc=0.000148871 m=(1)
mp35 (n26 \4\:mout \12\:VDD VDD) g45p1lvt w=(2.15e-07) l=4.5e-08 nf=1 \
        as=8.245e-14 ad=1.29e-14 ps=1.44e-06 pd=5.5e-07 nrd=1.16667 \
        nrs=1.16667 sa=9.7e-07 sb=1.78384e-06 sd=160n sca=10.8061 \
        scb=0.00857865 scc=0.000148871 m=(1)
mp30 (\5\:mout n20 \12\:VDD VDD) g45p1lvt w=(2.15e-07) l=4.5e-08 nf=1 \
        as=8.245e-14 ad=6.342e-14 ps=1.44e-06 pd=1.02e-06 nrd=1.16667 \
        nrs=1.16667 sa=1.245e-06 sb=1.50884e-06 sd=160n sca=10.8061 \
        scb=0.00857865 scc=0.000148871 m=(1)
mp40 (\8\:n30 \8\:CKb \5\:mout VDD) g45p1lvt w=(2.15e-07) l=4.5e-08 nf=1 \
        as=6.342e-14 ad=4.622e-14 ps=1.02e-06 pd=8.6e-07 nrd=1.16667 \
        nrs=1.16667 sa=1.585e-06 sb=1.16884e-06 sd=160n sca=10.8061 \
        scb=0.00857865 scc=0.000148871 m=(1)
mp51 (\8\:n30 \4\:CKbb n36 VDD) g45p1lvt w=(2.15e-07) l=4.5e-08 nf=1 \
        as=2.687e-14 ad=4.622e-14 ps=6.8e-07 pd=8.6e-07 nrd=1.16667 \
        nrs=1.16667 sa=1.845e-06 sb=9.08837e-07 sd=160n sca=10.8061 \
        scb=0.00857865 scc=0.000148871 m=(1)
mp50 (n36 \10\:qbint \1\:VDD VDD) g45p1lvt w=(2.15e-07) l=4.5e-08 nf=1 \
        as=6.48e-14 ad=2.687e-14 ps=1.22e-06 pd=6.8e-07 nrd=1.16667 \
        nrs=1.16667 sa=2e-06 sb=7.38837e-07 sd=160n sca=10.8061 \
        scb=0.00857865 scc=0.000148871 m=(1)
C1 (D VSS) capacitor c=3.79553e-17
C2 (Q VSS) capacitor c=4.50906e-17
C3 (VDD VSS) capacitor c=2.17429e-16
C4 (CK VSS) capacitor c=3.46156e-17
C5 (CKb VSS) capacitor c=5.71018e-17
C6 (CKbb VSS) capacitor c=6.95768e-17
C7 (n20 VSS) capacitor c=3.20066e-17
C8 (n25 VSS) capacitor c=1.40643e-18
C9 (mout VSS) capacitor c=2.02994e-17
C10 (n30 VSS) capacitor c=2.59989e-17
C11 (qbint VSS) capacitor c=1.55478e-16
C12 (n22 VSS) capacitor c=2.69733e-19
C13 (n26 VSS) capacitor c=1.67182e-18
C14 (n36 VSS) capacitor c=3.16269e-18
C15 (\3\:n30 VSS) capacitor c=5.83338e-17
C16 (\10\:qbint VSS) capacitor c=4.52251e-17
C17 (\4\:CKbb VSS) capacitor c=3.34139e-17
C18 (\8\:CKb VSS) capacitor c=3.29962e-17
C19 (\4\:mout VSS) capacitor c=7.7391e-17
C20 (\6\:CKb VSS) capacitor c=6.1751e-17
C21 (\3\:CKbb VSS) capacitor c=3.09697e-17
C22 (\3\:D VSS) capacitor c=7.23252e-17
C23 (\3\:CK VSS) capacitor c=2.47714e-17
C24 (\5\:qbint VSS) capacitor c=5.3671e-17
C25 (\10\:CKb VSS) capacitor c=9.1395e-17
C26 (\6\:CKbb VSS) capacitor c=5.21532e-17
C27 (\3\:n20 VSS) capacitor c=4.08263e-17
C28 (\3\:mout VSS) capacitor c=3.60742e-17
C29 (\4\:CKb VSS) capacitor c=5.84018e-17
C30 (\1\:D VSS) capacitor c=4.04106e-17
C31 (\2\:CKb VSS) capacitor c=4.33668e-17
C32 (\1\:CK VSS) capacitor c=2.45498e-17
C33 (\2\:n30 VSS) capacitor c=3.9248e-17
C34 (\5\:CKbb VSS) capacitor c=8.18108e-17
C35 (\11\:CKb VSS) capacitor c=3.35315e-17
C36 (\9\:CKb VSS) capacitor c=2.96759e-17
C37 (\2\:n20 VSS) capacitor c=4.34292e-17
C38 (\7\:CKb VSS) capacitor c=3.59375e-17
C39 (\5\:CKb VSS) capacitor c=2.70358e-17
C40 (\2\:CKbb VSS) capacitor c=7.47365e-17
C41 (\2\:D VSS) capacitor c=5.42191e-17
C42 (\3\:CKb VSS) capacitor c=2.10533e-17
C43 (\2\:CK VSS) capacitor c=2.32306e-17
C44 (\15\:qbint VSS) capacitor c=3.20955e-17
C45 (\1\:VDD VSS) capacitor c=1.44384e-16
C46 (\1\:Q VSS) capacitor c=5.36287e-17
C47 (\8\:n30 VSS) capacitor c=8.79883e-17
C48 (\5\:mout VSS) capacitor c=6.67015e-17
C49 (\12\:VDD VSS) capacitor c=3.28084e-17
C50 (\5\:n20 VSS) capacitor c=1.36616e-16
C51 (\14\:VDD VSS) capacitor c=3.68243e-17
C52 (\13\:CKbb VSS) capacitor c=1.62283e-17
C53 (\22\:CKb VSS) capacitor c=5.99311e-17
C54 (\16\:VDD VSS) capacitor c=2.49099e-17
C55 (\3\:VDD VSS) capacitor c=4.94851e-17
C56 (\11\:qbint VSS) capacitor c=3.72412e-17
C57 (\3\:Q VSS) capacitor c=5.76074e-17
C58 (\6\:n30 VSS) capacitor c=3.48847e-17
C59 (\9\:mout VSS) capacitor c=6.45407e-17
C60 (\7\:n20 VSS) capacitor c=7.49547e-17
C61 (\10\:CKbb VSS) capacitor c=8.28722e-17
C62 (\20\:CKb VSS) capacitor c=7.62102e-17
C63 (\2\:mout VSS) capacitor c=3.71953e-17
C64 (\4\:qbint VSS) capacitor c=4.85441e-17
C65 (\4\:CK VSS) capacitor c=5.73996e-17
C66 (\4\:D VSS) capacitor c=5.47495e-17
C67 (\4\:n20 VSS) capacitor c=7.94588e-17
C68 (\7\:mout VSS) capacitor c=7.25563e-17
C69 (\8\:mout VSS) capacitor c=5.259e-17
C70 (\12\:CKb VSS) capacitor c=9.10613e-17
C71 (\13\:CKb VSS) capacitor c=1.34543e-16
C72 (\14\:CKb VSS) capacitor c=1.41283e-16
C73 (\15\:CKb VSS) capacitor c=8.54915e-17
C74 (\16\:CKb VSS) capacitor c=7.38109e-17
C75 (\17\:CKb VSS) capacitor c=4.10219e-17
C76 (\18\:CKb VSS) capacitor c=5.22818e-17
C77 (\7\:CKbb VSS) capacitor c=1.91929e-16
C78 (\8\:CKbb VSS) capacitor c=2.01052e-16
C79 (\9\:CKbb VSS) capacitor c=5.71957e-17
C80 (\12\:CKbb VSS) capacitor c=2.44665e-17
C81 (\4\:n30 VSS) capacitor c=1.5403e-16
C82 (\5\:n30 VSS) capacitor c=1.46112e-16
C83 (\13\:qbint VSS) capacitor c=4.28456e-17
C84 (\14\:qbint VSS) capacitor c=5.32853e-17
C85 (\6\:VDD VSS) capacitor c=3.97174e-17
C86 (\8\:VDD VSS) capacitor c=1.38834e-17
C87 (\9\:VDD VSS) capacitor c=1.02255e-17
Rk32 (\1\:VSS \6\:VSS) resistor r=0.5061 c=0
Rk33 (\6\:VSS \7\:VSS) resistor r=0.2907 c=0
Rk34 (\7\:VSS \8\:VSS) resistor r=0.08506 c=0
Rk36 (\9\:VSS VSS) resistor r=0.06475 c=0
Rk35 (\8\:VSS \9\:VSS) resistor r=0.4008 c=0
Rk38 (\6\:VSS \13\:VSS) resistor r=0.3394 c=0
Rk39 (\8\:VSS \15\:VSS) resistor r=0.07381 c=0
Rk40 (\9\:VSS \17\:VSS) resistor r=0.274 c=0
Rk2 (\4\:D D) resistor r=0.07782 c=0
Rk22 (\2\:Q Q) resistor r=0.2095 c=0
Rk23 (Q \4\:Q) resistor r=0.181 c=0
Rk43 (\1\:VDD \6\:VDD) resistor r=0.5237 c=0
Rk44 (\6\:VDD \7\:VDD) resistor r=0.2907 c=0
Rk45 (\7\:VDD \8\:VDD) resistor r=0.1252 c=0
Rk47 (\9\:VDD VDD) resistor r=0.03967 c=0
Rk46 (\8\:VDD \9\:VDD) resistor r=0.3857 c=0
Rk49 (\6\:VDD \13\:VDD) resistor r=0.1025 c=0
Rk50 (\8\:VDD \15\:VDD) resistor r=0.2607 c=0
Rk51 (\9\:VDD \17\:VDD) resistor r=0.4175 c=0
Rk1 (\4\:CK CK) resistor r=0.1131 c=0
Rk8 (\12\:CKb \13\:CKb) resistor r=0.4726 c=0
Rk9 (\13\:CKb \14\:CKb) resistor r=0.7688 c=0
Rk10 (\14\:CKb \15\:CKb) resistor r=0.4674 c=0
Rk11 (\15\:CKb \16\:CKb) resistor r=0.338 c=0
Rk12 (\13\:CKb \17\:CKb) resistor r=0.1955 c=0
Rk13 (\14\:CKb \18\:CKb) resistor r=0.2742 c=0
Rk14 (\15\:CKb \19\:CKb) resistor r=0.01531 c=0
Rk15 (\16\:CKb \21\:CKb) resistor r=0.3292 c=0
Rk16 (\21\:CKb \23\:CKb) resistor r=0.3733 c=0
Rk17 (\7\:CKbb \8\:CKbb) resistor r=1.5026 c=0
Rk18 (\8\:CKbb \9\:CKbb) resistor r=0.2767 c=0
Rk19 (\9\:CKbb \11\:CKbb) resistor r=0.4206 c=0
Rk20 (\8\:CKbb \12\:CKbb) resistor r=0.06418 c=0
Rk21 (\9\:CKbb \14\:CKbb) resistor r=0.06451 c=0
Rk3 (\4\:n20 \6\:n20) resistor r=0.5397 c=0
Rk4 (\6\:n20 \8\:n20) resistor r=0.4964 c=0
Rk5 (\6\:mout \7\:mout) resistor r=0.3384 c=0
Rk6 (\7\:mout \8\:mout) resistor r=0.2362 c=0
Rk7 (\7\:mout \10\:mout) resistor r=0.2676 c=0
Rk24 (\4\:n30 \5\:n30) resistor r=1.035 c=0
Rk25 (\5\:n30 \7\:n30) resistor r=0.07036 c=0
Rk26 (\5\:n30 \9\:n30) resistor r=0.392 c=0
Rk27 (\12\:qbint \13\:qbint) resistor r=0.3325 c=0
Rk28 (\13\:qbint \14\:qbint) resistor r=0.187 c=0
Rk29 (\13\:qbint \16\:qbint) resistor r=0.1416 c=0
Rl6 (\2\:D \3\:D) resistor r=147.872 c=0
Rl5 (\1\:D \2\:D) resistor r=42.5711 c=0
Rl2 (\2\:CK \3\:CK) resistor r=70.6044 c=0
Rl1 (\1\:CK \2\:CK) resistor r=49.2678 c=0
Rl3 (CKb \2\:CKb) resistor r=217.308 c=0
Rl17 (\10\:CKb \11\:CKb) resistor r=29.5379 c=0
Rl16 (\8\:CKb \9\:CKb) resistor r=66.0643 c=0
Rl10 (\6\:CKb \7\:CKb) resistor r=24.2328 c=0
Rl7 (\4\:CKb \5\:CKb) resistor r=48.7687 c=0
Rl4 (\2\:CKb \3\:CKb) resistor r=33.7903 c=0
Rl18 (\4\:CKbb \5\:CKbb) resistor r=35.7713 c=0
Rl19 (\5\:CKbb \6\:CKbb) resistor r=202.028 c=0
Rl9 (\2\:CKbb \3\:CKbb) resistor r=29.5379 c=0
Rl8 (CKbb \2\:CKbb) resistor r=246.411 c=0
Rl14 (n20 \2\:n20) resistor r=29.5379 c=0
Rl15 (\2\:n20 \3\:n20) resistor r=162.23 c=0
Rl13 (\2\:mout \4\:mout) resistor r=111.253 c=0
Rl12 (\2\:mout \3\:mout) resistor r=97.7911 c=0
Rl11 (mout \2\:mout) resistor r=4.3192 c=0
Rl30 (\2\:n30 \3\:n30) resistor r=110.031 c=0
Rl29 (n30 \2\:n30) resistor r=30.2349 c=0
Rl25 (\7\:qbint qbint) resistor r=4.7234 c=0
Rl28 (\4\:qbint \10\:qbint) resistor r=109.297 c=0
Rl22 (\4\:qbint qbint) resistor r=102.948 c=0
Rl23 (\4\:qbint \5\:qbint) resistor r=115.362 c=0
Rz10 (\13\:VSS \12\:VSS) resistor r=75 c=0
Rz11 (\15\:VSS \14\:VSS) resistor r=75 c=0
Rz12 (\17\:VSS \16\:VSS) resistor r=75 c=0
Rz5 (\4\:Q \3\:Q) resistor r=75 c=0
Rz13 (\1\:VDD \3\:VDD) resistor r=10.7143 c=0
Rz14 (\7\:VDD \3\:VDD) resistor r=6.25 c=0
Rz3 (\20\:CKb \21\:CKb) resistor r=75 c=0
Rz4 (\10\:CKbb \11\:CKbb) resistor r=75 c=0
Rz1 (\7\:n20 \8\:n20) resistor r=75 c=0
Rz2 (\9\:mout \10\:mout) resistor r=75 c=0
Rz6 (\6\:n30 \7\:n30) resistor r=75 c=0
Rz7 (\12\:qbint \11\:qbint) resistor r=75 c=0
Ry8 (\1\:VSS \3\:VSS) resistor r=8.8571 c=0
Ry9 (\7\:VSS \3\:VSS) resistor r=5.1667 c=0
Ry5 (\2\:Q \1\:Q) resistor r=20.6667 c=0
Ry12 (\13\:VDD \12\:VDD) resistor r=62 c=0
Ry13 (\15\:VDD \14\:VDD) resistor r=62 c=0
Ry14 (\17\:VDD \16\:VDD) resistor r=62 c=0
Ry3 (\22\:CKb \23\:CKb) resistor r=62 c=0
Ry4 (\13\:CKbb \14\:CKbb) resistor r=62 c=0
Ry1 (\5\:n20 \6\:n20) resistor r=62 c=0
Ry2 (\5\:mout \6\:mout) resistor r=62 c=0
Ry6 (\8\:n30 \9\:n30) resistor r=62 c=0
Ry7 (\16\:qbint \15\:qbint) resistor r=31 c=0
Rx2 (\2\:D \4\:D) resistor r=45 c=0
Rx1 (\2\:CK \4\:CK) resistor r=45 c=0
Rx5 (\9\:CKb \12\:CKb) resistor r=45 c=0
Rx6 (\3\:CKb \16\:CKb) resistor r=45 c=0
Rx7 (\11\:CKb \17\:CKb) resistor r=45 c=0
Rx8 (\7\:CKb \18\:CKb) resistor r=45 c=0
Rx9 (\5\:CKb \19\:CKb) resistor r=45 c=0
Rx10 (\5\:CKbb \7\:CKbb) resistor r=45 c=0
Rx11 (\2\:CKbb \12\:CKbb) resistor r=45 c=0
Rx3 (\2\:n20 \4\:n20) resistor r=45 c=0
Rx4 (mout \8\:mout) resistor r=45 c=0
Rx12 (\2\:n30 \4\:n30) resistor r=45 c=0
Rx13 (\14\:qbint \7\:qbint) resistor r=45 c=0
mn20 (\20\:CKb \1\:CK \16\:VSS VSS) g45n1lvt w=(1.45e-07) l=4.5e-08 nf=1 \
        as=2.03e-14 ad=2.973e-14 ps=5.7e-07 pd=7e-07 nrd=1.16667 \
        nrs=1.16667 sa=1.4e-07 sb=2.05e-07 sd=160n sca=10.4914 \
        scb=0.00978575 scc=0.000300434 m=(1)
mn21 (\10\:CKbb \2\:CKb \14\:VSS VSS) g45n1lvt w=(1.45e-07) l=4.5e-08 \
        nf=1 as=5.49e-14 ad=2.683e-14 ps=1.53e-06 pd=6.6e-07 nrd=1.16667 \
        nrs=1.16667 sa=1.85e-07 sb=2e-06 sd=160n sca=13.253 scb=0.0137915 \
        scc=0.000695334 m=(1)
mn25 (n21 \1\:D \14\:VSS VSS) g45n1lvt w=(1.45e-07) l=4.5e-08 nf=1 \
        as=5.49e-14 ad=1.958e-14 ps=1.53e-06 pd=5.6e-07 nrd=1.16667 \
        nrs=1.16667 sa=4.3e-07 sb=2e-06 sd=160n sca=13.253 scb=0.0137915 \
        scc=0.000695334 m=(1)
mn26 (\7\:n20 \4\:CKb n21 VSS) g45n1lvt w=(1.45e-07) l=4.5e-08 nf=1 \
        as=1.958e-14 ad=2.32e-14 ps=5.6e-07 pd=6.1e-07 nrd=1.16667 \
        nrs=1.16667 sa=6.1e-07 sb=2e-06 sd=160n sca=13.253 scb=0.0137915 \
        scc=0.000695334 m=(1)
mn36 (\7\:n20 CKbb n25 VSS) g45n1lvt w=(1.45e-07) l=4.5e-08 nf=1 \
        as=2.248e-14 ad=2.32e-14 ps=6e-07 pd=6.1e-07 nrd=1.16667 \
        nrs=1.16667 sa=8.15e-07 sb=2e-06 sd=160n sca=13.253 scb=0.0137915 \
        scc=0.000695334 m=(1)
mn35 (n25 \3\:mout \12\:VSS VSS) g45n1lvt w=(1.45e-07) l=4.5e-08 nf=1 \
        as=3.335e-14 ad=2.248e-14 ps=7.5e-07 pd=6e-07 nrd=1.16667 \
        nrs=1.16667 sa=1.015e-06 sb=1.995e-06 sd=160n sca=13.253 \
        scb=0.0137915 scc=0.000695334 m=(1)
mn30 (\9\:mout \3\:n20 \12\:VSS VSS) g45n1lvt w=(1.45e-07) l=4.5e-08 \
        nf=1 as=3.335e-14 ad=5.075e-14 ps=7.5e-07 pd=9.9e-07 nrd=1.16667 \
        nrs=1.16667 sa=1.29e-06 sb=1.72e-06 sd=160n sca=13.253 \
        scb=0.0137915 scc=0.000695334 m=(1)
mn40 (\6\:n30 \6\:CKbb \9\:mout VSS) g45n1lvt w=(1.45e-07) l=4.5e-08 nf=1 \
        as=5.075e-14 ad=2.32e-14 ps=9.9e-07 pd=6.1e-07 nrd=1.16667 \
        nrs=1.16667 sa=1.685e-06 sb=1.325e-06 sd=160n sca=13.253 \
        scb=0.0137915 scc=0.000695334 m=(1)
mn51 (\6\:n30 \10\:CKb n35 VSS) g45n1lvt w=(1.45e-07) l=4.5e-08 nf=1 \
        as=8.7e-15 ad=2.32e-14 ps=4.1e-07 pd=6.1e-07 nrd=1.16667 \
        nrs=1.16667 sa=1.89e-06 sb=1.12e-06 sd=160n sca=13.253 \
        scb=0.0137915 scc=0.000695334 m=(1)
mn50 (n35 \5\:qbint \1\:VSS VSS) g45n1lvt w=(1.45e-07) l=4.5e-08 nf=1 \
        as=6.038e-14 ad=8.7e-15 ps=1.13e-06 pd=4.1e-07 nrd=1.16667 \
        nrs=1.16667 sa=1.995e-06 sb=1.015e-06 sd=160n sca=13.253 \
        scb=0.0137915 scc=0.000695334 m=(1)
mn55 (\3\:Q qbint \1\:VSS VSS) g45n1lvt w=(2.6e-07) l=4.5e-08 nf=1 \
        as=6.113e-14 ad=4.16e-14 ps=1.1e-06 pd=8.4e-07 nrd=1.16667 \
        nrs=1.16667 sa=1.1775e-06 sb=5.88846e-07 sd=160n sca=17.5885 \
        scb=0.0172826 scc=0.00162584 m=(2)
mn45 (\11\:qbint n30 \1\:VSS VSS) g45n1lvt w=(2.05e-07) l=4.5e-08 nf=1 \
        as=6.188e-14 ad=2.87e-14 ps=1.07e-06 pd=6.9e-07 nrd=1.16667 \
        nrs=1.16667 sa=1.62024e-06 sb=1.4e-07 sd=160n sca=13.8179 \
        scb=0.0141903 scc=0.000851218 m=(1)
mp55_1__rcx (\1\:Q qbint \1\:VDD VDD) g45p1lvt w=(3.9e-07) l=4.5e-08 \
        nf=1 as=6.12e-14 ad=6.825e-14 ps=1.16e-06 pd=1.13e-06 nrd=1.16667 \
        nrs=1.16667 sa=1.14744e-06 sb=5.14744e-07 sd=160n sca=17.596 \
        scb=0.015375 scc=0.00137895 m=(2)
mp45 (\15\:qbint \3\:n30 \1\:VDD VDD) g45p1lvt w=(3.1e-07) l=4.5e-08 \
        nf=1 as=5.76e-14 ad=4.34e-14 ps=1.1e-06 pd=9e-07 nrd=1.16667 \
        nrs=1.16667 sa=1.16734e-06 sb=1.4e-07 sd=160n sca=23.2035 \
        scb=0.0225719 scc=0.00178254 m=(1)
ends DFFQX2
// End of subcircuit definition.
