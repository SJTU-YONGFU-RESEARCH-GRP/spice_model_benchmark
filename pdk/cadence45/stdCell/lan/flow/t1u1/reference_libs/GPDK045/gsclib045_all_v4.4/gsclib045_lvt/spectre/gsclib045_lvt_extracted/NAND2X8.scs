// Generated for: spectre (May  1 09:16:36 2013 )
// Library name: gsclib045_lvt
// Cell name: NAND2X8
// View name: extracted

simulator lang=spectre

subckt NAND2X8 A B VDD VSS Y
mp0_1__rcx (\4\:Y \2\:A VDD VDD) g45p1lvt w=(4.45e-07) l=4.5e-08 nf=1 \
        as=6.993e-14 ad=7.12e-14 ps=1.20429e-06 pd=1.21e-06 nrd=1.16667 \
        nrs=1.16667 sa=1.4e-07 sb=2e-06 sd=160n sca=27.8642 scb=0.0316804 \
        scc=0.00218972 m=(7)
mp1_1__rcx (\4\:Y \1\:B VDD VDD) g45p1lvt w=(4.45e-07) l=4.5e-08 nf=1 \
        as=6.993e-14 ad=7.12e-14 ps=1.20429e-06 pd=1.21e-06 nrd=1.16667 \
        nrs=1.16667 sa=3.45e-07 sb=2e-06 sd=160n sca=17.8304 scb=0.0170078 \
        scc=0.000825102 m=(7)
C1 (VDD VSS) capacitor c=6.73675e-16
C2 (B VSS) capacitor c=1.51192e-17
C3 (A VSS) capacitor c=2.51424e-17
C4 (Y VSS) capacitor c=4.77584e-17
C5 (7 VSS) capacitor c=1.5146e-18
C6 (8 VSS) capacitor c=4.03895e-18
C7 (9 VSS) capacitor c=3.26021e-18
C8 (10 VSS) capacitor c=3.28164e-18
C9 (11 VSS) capacitor c=2.52434e-18
C10 (12 VSS) capacitor c=1.5146e-18
C11 (\1\:B VSS) capacitor c=1.06918e-15
C12 (\24\:B VSS) capacitor c=6.86429e-17
C13 (\21\:A VSS) capacitor c=5.22717e-17
C14 (\22\:A VSS) capacitor c=3.90063e-17
C15 (\20\:B VSS) capacitor c=4.36467e-17
C16 (\19\:B VSS) capacitor c=3.73818e-17
C17 (\11\:A VSS) capacitor c=3.28359e-17
C18 (\15\:A VSS) capacitor c=3.29605e-17
C19 (\13\:B VSS) capacitor c=3.72543e-17
C20 (\12\:B VSS) capacitor c=3.33867e-17
C21 (\9\:A VSS) capacitor c=2.96419e-17
C22 (\8\:A VSS) capacitor c=7.36646e-17
C23 (\6\:B VSS) capacitor c=5.90065e-17
C24 (\5\:B VSS) capacitor c=6.0671e-17
C25 (\1\:A VSS) capacitor c=5.49782e-17
C26 (\2\:A VSS) capacitor c=1.12905e-15
C27 (\1\:Y VSS) capacitor c=1.97285e-17
C28 (\13\:Y VSS) capacitor c=1.89981e-16
C29 (\28\:Y VSS) capacitor c=1.98234e-16
C30 (\30\:Y VSS) capacitor c=1.3511e-16
C31 (\3\:Y VSS) capacitor c=8.55061e-17
C32 (\4\:Y VSS) capacitor c=8.01132e-16
Rk46 (\2\:VSS \3\:VSS) resistor r=0.1345 c=0
Rk47 (\3\:VSS \4\:VSS) resistor r=0.3947 c=0
Rk48 (\4\:VSS \5\:VSS) resistor r=0.2702 c=0
Rk49 (\5\:VSS \6\:VSS) resistor r=0.1622 c=0
Rk51 (\7\:VSS VSS) resistor r=0.0498 c=0
Rk50 (\6\:VSS \7\:VSS) resistor r=0.3378 c=0
Rk52 (\3\:VSS \9\:VSS) resistor r=0.1866 c=0
Rk53 (\4\:VSS \11\:VSS) resistor r=0.1866 c=0
Rk54 (\6\:VSS \13\:VSS) resistor r=0.1854 c=0
Rk55 (\7\:VSS \15\:VSS) resistor r=0.3013 c=0
Rk9 (\1\:B B) resistor r=0.005605 c=0
Rk4 (\2\:A A) resistor r=0.03147 c=0
Rk11 (\3\:Y Y) resistor r=0.3219 c=0
Rk10 (\2\:Y \3\:Y) resistor r=0.07404 c=0
Rk12 (Y \4\:Y) resistor r=0.1435 c=0
Rk19 (\3\:Y \12\:Y) resistor r=0.5996 c=0
Rk20 (\12\:Y \14\:Y) resistor r=0.07404 c=0
Rk27 (\12\:Y \27\:Y) resistor r=0.7166 c=0
Rk28 (\27\:Y \29\:Y) resistor r=0.07404 c=0
Rk29 (\27\:Y \31\:Y) resistor r=0.7924 c=0
Rl39 (\1\:B \24\:B) resistor r=82.1429 c=0
Rl31 (\1\:B \20\:B) resistor r=90.0987 c=0
Rl30 (\1\:B \19\:B) resistor r=90.0987 c=0
Rl19 (\1\:B \13\:B) resistor r=90.0987 c=0
Rl18 (\1\:B \12\:B) resistor r=90.0987 c=0
Rl7 (\1\:B \6\:B) resistor r=90.0987 c=0
Rl6 (\1\:B \5\:B) resistor r=90.0987 c=0
Rl35 (\2\:A \21\:A) resistor r=37.3411 c=0
Rl36 (\2\:A \22\:A) resistor r=36.6367 c=0
Rl21 (\2\:A \11\:A) resistor r=34.7464 c=0
Rl24 (\2\:A \15\:A) resistor r=32.6324 c=0
Rl13 (\2\:A \9\:A) resistor r=38.5087 c=0
Rl12 (\2\:A \8\:A) resistor r=44.3957 c=0
Rl1 (\2\:A \1\:A) resistor r=24.7951 c=0
Rz7 (\8\:VSS \9\:VSS) resistor r=37.5 c=0
Rz8 (\10\:VSS \11\:VSS) resistor r=37.5 c=0
Rz9 (\12\:VSS \13\:VSS) resistor r=37.5 c=0
Rz10 (\14\:VSS \15\:VSS) resistor r=37.5 c=0
Rz1 (\2\:Y \1\:Y) resistor r=37.5 c=0
Rz2 (\14\:Y \13\:Y) resistor r=37.5 c=0
Rz3 (\29\:Y \28\:Y) resistor r=37.5 c=0
Rz4 (\31\:Y \30\:Y) resistor r=37.5 c=0
Ry16 (\1\:VSS \2\:VSS) resistor r=15.5 c=0
Ry17 (\1\:VSS \5\:VSS) resistor r=5.1667 c=0
mn0_1__rcx (6 \1\:A \14\:VSS VSS) g45n1lvt w=(2.95e-07) l=4.5e-08 nf=1 \
        as=4.13e-14 ad=1.77e-14 ps=8.7e-07 pd=7.1e-07 nrd=1.16667 \
        nrs=1.16667 sa=1.4e-07 sb=2e-06 sd=160n sca=15.3363 scb=0.0149793 \
        scc=0.00123645 m=(1)
mn1_1__rcx (\30\:Y \5\:B 6 VSS) g45n1lvt w=(2.95e-07) l=4.5e-08 nf=1 \
        as=1.77e-14 ad=4.72e-14 ps=7.1e-07 pd=9.1e-07 nrd=1.16667 \
        nrs=1.16667 sa=2.45e-07 sb=2e-06 sd=160n sca=15.3363 scb=0.0149793 \
        scc=0.00123645 m=(1)
mn1_2__rcx (\30\:Y \6\:B 7 VSS) g45n1lvt w=(2.95e-07) l=4.5e-08 nf=1 \
        as=1.77e-14 ad=4.72e-14 ps=7.1e-07 pd=9.1e-07 nrd=1.16667 \
        nrs=1.16667 sa=4.5e-07 sb=2e-06 sd=160n sca=15.3363 scb=0.0149793 \
        scc=0.00123645 m=(1)
mn0_2__rcx (7 \8\:A \12\:VSS VSS) g45n1lvt w=(2.95e-07) l=4.5e-08 nf=1 \
        as=8.45e-14 ad=1.77e-14 ps=1.24e-06 pd=7.1e-07 nrd=1.16667 \
        nrs=1.16667 sa=5.55e-07 sb=2e-06 sd=160n sca=15.3363 scb=0.0149793 \
        scc=0.00123645 m=(1)
mn0_3__rcx (8 \9\:A \12\:VSS VSS) g45n1lvt w=(2.95e-07) l=4.5e-08 nf=1 \
        as=8.45e-14 ad=4.72e-14 ps=1.24e-06 pd=9.1e-07 nrd=1.16667 \
        nrs=1.16667 sa=8.6e-07 sb=1.885e-06 sd=160n sca=15.3363 \
        scb=0.0149793 scc=0.00123645 m=(1)
mn1_3__rcx (\28\:Y \12\:B 8 VSS) g45n1lvt w=(2.95e-07) l=4.5e-08 nf=1 \
        as=4.72e-14 ad=4.72e-14 ps=9.1e-07 pd=9.1e-07 nrd=1.16667 \
        nrs=1.16667 sa=1.065e-06 sb=1.68e-06 sd=160n sca=15.3363 \
        scb=0.0149793 scc=0.00123645 m=(1)
mn1_4__rcx (\28\:Y \13\:B 9 VSS) g45n1lvt w=(2.95e-07) l=4.5e-08 nf=1 \
        as=3.835e-14 ad=4.72e-14 ps=8.5e-07 pd=9.1e-07 nrd=1.16667 \
        nrs=1.16667 sa=1.27e-06 sb=1.475e-06 sd=160n sca=15.3363 \
        scb=0.0149793 scc=0.00123645 m=(1)
mn0_4__rcx (9 \15\:A \10\:VSS VSS) g45n1lvt w=(2.95e-07) l=4.5e-08 nf=1 \
        as=7.27e-14 ad=3.835e-14 ps=1.16e-06 pd=8.5e-07 nrd=1.16667 \
        nrs=1.16667 sa=1.445e-06 sb=1.3e-06 sd=160n sca=15.3363 \
        scb=0.0149793 scc=0.00123645 m=(1)
mn0_5__rcx (10 \11\:A \10\:VSS VSS) g45n1lvt w=(2.95e-07) l=4.5e-08 nf=1 \
        as=7.27e-14 ad=3.835e-14 ps=1.16e-06 pd=8.5e-07 nrd=1.16667 \
        nrs=1.16667 sa=1.71e-06 sb=1.035e-06 sd=160n sca=15.3363 \
        scb=0.0149793 scc=0.00123645 m=(1)
mn1_5__rcx (\13\:Y \19\:B 10 VSS) g45n1lvt w=(2.95e-07) l=4.5e-08 nf=1 \
        as=3.835e-14 ad=4.72e-14 ps=8.5e-07 pd=9.1e-07 nrd=1.16667 \
        nrs=1.16667 sa=1.885e-06 sb=8.6e-07 sd=160n sca=15.3363 \
        scb=0.0149793 scc=0.00123645 m=(1)
mn1_6__rcx (\13\:Y \20\:B 11 VSS) g45n1lvt w=(2.95e-07) l=4.5e-08 nf=1 \
        as=2.95e-14 ad=4.72e-14 ps=7.9e-07 pd=9.1e-07 nrd=1.16667 \
        nrs=1.16667 sa=2e-06 sb=6.55e-07 sd=160n sca=15.3363 scb=0.0149793 \
        scc=0.00123645 m=(1)
mn0_6__rcx (11 \22\:A \8\:VSS VSS) g45n1lvt w=(2.95e-07) l=4.5e-08 nf=1 \
        as=7.27e-14 ad=2.95e-14 ps=1.16e-06 pd=7.9e-07 nrd=1.16667 \
        nrs=1.16667 sa=2e-06 sb=5.1e-07 sd=160n sca=15.3363 scb=0.0149793 \
        scc=0.00123645 m=(1)
mn0 (12 \21\:A \8\:VSS VSS) g45n1lvt w=(2.95e-07) l=4.5e-08 nf=1 \
        as=7.27e-14 ad=1.77e-14 ps=1.16e-06 pd=7.1e-07 nrd=1.16667 \
        nrs=1.16667 sa=2e-06 sb=2.45e-07 sd=160n sca=15.3363 scb=0.0149793 \
        scc=0.00123645 m=(1)
mn1 (\1\:Y \24\:B 12 VSS) g45n1lvt w=(2.95e-07) l=4.5e-08 nf=1 \
        as=1.77e-14 ad=4.13e-14 ps=7.1e-07 pd=8.7e-07 nrd=1.16667 \
        nrs=1.16667 sa=2e-06 sb=1.4e-07 sd=160n sca=15.3363 scb=0.0149793 \
        scc=0.00123645 m=(1)
ends NAND2X8
// End of subcircuit definition.
