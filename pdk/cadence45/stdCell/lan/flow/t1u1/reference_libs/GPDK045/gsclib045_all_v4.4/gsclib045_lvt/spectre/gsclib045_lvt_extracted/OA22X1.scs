// Generated for: spectre (May  1 09:17:50 2013 )
// Library name: gsclib045_lvt
// Cell name: OA22X1
// View name: extracted

simulator lang=spectre

subckt OA22X1 A0 A1 B0 B1 VDD VSS Y
mp0 (net119 \1\:A0 \5\:VDD VDD) g45p1lvt w=(2.15e-07) l=4.5e-08 nf=1 \
        as=3.01e-14 ad=3.225e-14 ps=7.1e-07 pd=7.3e-07 nrd=1.16667 \
        nrs=1.16667 sa=1.4e-07 sb=1.11e-06 sd=160n sca=25.0208 \
        scb=0.0285597 scc=0.00162702 m=(1)
mp1 (\7\:net128 \1\:A1 net119 VDD) g45p1lvt w=(2.15e-07) l=4.5e-08 nf=1 \
        as=3.225e-14 ad=3.44e-14 ps=7.3e-07 pd=7.5e-07 nrd=1.16667 \
        nrs=1.16667 sa=3.35e-07 sb=9.15e-07 sd=160n sca=15.1901 \
        scb=0.0142438 scc=0.000270537 m=(1)
mp3 (\7\:net128 \1\:B1 net115 VDD) g45p1lvt w=(2.15e-07) l=4.5e-08 nf=1 \
        as=3.44e-14 ad=3.44e-14 ps=7.5e-07 pd=7.5e-07 nrd=1.16667 \
        nrs=1.16667 sa=5.4e-07 sb=7.1e-07 sd=160n sca=13.0859 \
        scb=0.0105161 scc=0.000221881 m=(1)
mp2 (net115 \1\:B0 \1\:VDD VDD) g45p1lvt w=(2.15e-07) l=4.5e-08 nf=1 \
        as=8.63e-14 ad=3.44e-14 ps=1.42e-06 pd=7.5e-07 nrd=1.16667 \
        nrs=1.16667 sa=7.45e-07 sb=5.05e-07 sd=160n sca=13.1252 \
        scb=0.0105805 scc=0.000222119 m=(1)
C1 (Y VSS) capacitor c=6.95384e-17
C2 (B0 VSS) capacitor c=2.98063e-17
C3 (A0 VSS) capacitor c=2.51516e-17
C4 (VDD VSS) capacitor c=1.12885e-16
C5 (net124 VSS) capacitor c=6.37762e-17
C6 (net128 VSS) capacitor c=4.32679e-17
C7 (net115 VSS) capacitor c=5.90412e-18
C8 (\1\:B0 VSS) capacitor c=3.38135e-17
C9 (\1\:B1 VSS) capacitor c=3.92109e-17
C10 (\1\:A1 VSS) capacitor c=4.07023e-17
C11 (\1\:A0 VSS) capacitor c=5.22006e-17
C12 (\4\:net128 VSS) capacitor c=3.22948e-17
C13 (\3\:B0 VSS) capacitor c=5.37491e-17
C14 (\4\:B1 VSS) capacitor c=5.11032e-17
C15 (\3\:A1 VSS) capacitor c=5.59806e-17
C16 (\3\:A0 VSS) capacitor c=3.243e-17
C17 (\3\:net128 VSS) capacitor c=1.98439e-17
C18 (\2\:B0 VSS) capacitor c=4.35837e-17
C19 (\3\:B1 VSS) capacitor c=2.67932e-17
C20 (\2\:A1 VSS) capacitor c=6.58407e-17
C21 (\2\:A0 VSS) capacitor c=4.44408e-17
C22 (\1\:Y VSS) capacitor c=4.52399e-17
C23 (\1\:VDD VSS) capacitor c=3.34285e-17
C24 (\7\:net128 VSS) capacitor c=6.97749e-17
C25 (\5\:VDD VSS) capacitor c=1.79755e-17
C26 (\9\:net128 VSS) capacitor c=3.76472e-17
C27 (\3\:net124 VSS) capacitor c=7.58923e-17
C28 (\5\:net124 VSS) capacitor c=4.02099e-17
C29 (\2\:B1 VSS) capacitor c=3.74879e-17
C30 (\4\:A0 VSS) capacitor c=2.13228e-17
C31 (\4\:A1 VSS) capacitor c=2.91494e-17
C32 (\5\:A1 VSS) capacitor c=3.14025e-17
C33 (\5\:B1 VSS) capacitor c=4.72139e-17
C34 (\7\:B1 VSS) capacitor c=4.45613e-17
C35 (\5\:B0 VSS) capacitor c=4.52669e-17
C36 (\5\:net128 VSS) capacitor c=4.82432e-17
C37 (\6\:net128 VSS) capacitor c=1.00969e-16
C38 (\4\:VDD VSS) capacitor c=3.63829e-17
Rk2 (A1 \4\:A1) resistor r=0.008275 c=0
Rk4 (\4\:A1 \5\:A1) resistor r=0.04592 c=0
Rk3 (\5\:A1 \6\:A1) resistor r=0.008415 c=0
Rk17 (\4\:Y Y) resistor r=0.01657 c=0
Rk16 (\2\:Y \4\:Y) resistor r=0.4069 c=0
Rk10 (\4\:B0 \5\:B0) resistor r=0.01028 c=0
Rk11 (\6\:B0 B0) resistor r=0.01028 c=0
Rk12 (\5\:B0 \6\:B0) resistor r=0.0192 c=0
Rk1 (A0 \4\:A0) resistor r=0.02361 c=0
Rk18 (\2\:VSS \4\:VSS) resistor r=0.2791 c=0
Rk20 (\5\:VSS VSS) resistor r=0.1172 c=0
Rk19 (\4\:VSS \5\:VSS) resistor r=0.1825 c=0
Rk21 (\5\:VSS \7\:VSS) resistor r=0.07311 c=0
Rk23 (\4\:VDD VDD) resistor r=0.3003 c=0
Rk22 (\2\:VDD \4\:VDD) resistor r=0.4626 c=0
Rk24 (VDD \6\:VDD) resistor r=0.2804 c=0
Rk5 (\5\:B1 \6\:B1) resistor r=0.005269 c=0
Rk6 (B1 \7\:B1) resistor r=0.005137 c=0
Rk7 (\5\:B1 \7\:B1) resistor r=0.05797 c=0
Rk8 (\2\:net124 \4\:net124) resistor r=0.5039 c=0
Rk9 (\4\:net124 \6\:net124) resistor r=0.2707 c=0
Rk13 (\5\:net128 \6\:net128) resistor r=0.2724 c=0
Rk14 (\6\:net128 \8\:net128) resistor r=0.526 c=0
Rk15 (\6\:net128 \10\:net128) resistor r=0.1688 c=0
Rl3 (\1\:A1 \2\:A1) resistor r=47.2519 c=0
Rl4 (\2\:A1 \3\:A1) resistor r=131.867 c=0
Rl8 (\1\:B0 \2\:B0) resistor r=31.461 c=0
Rl9 (\2\:B0 \3\:B0) resistor r=154.538 c=0
Rl1 (\1\:A0 \2\:A0) resistor r=153.021 c=0
Rl2 (\2\:A0 \3\:A0) resistor r=26.098 c=0
Rl5 (\1\:B1 \2\:B1) resistor r=64.2642 c=0
Rl7 (\2\:B1 \4\:B1) resistor r=137.341 c=0
Rl6 (\2\:B1 \3\:B1) resistor r=1.8551 c=0
Rl10 (net128 \2\:net128) resistor r=72.791 c=0
Rl12 (\2\:net128 \4\:net128) resistor r=38.1757 c=0
Rl11 (\2\:net128 \3\:net128) resistor r=0.5166 c=0
Rz5 (\3\:Y \4\:Y) resistor r=37.5 c=0
Rz6 (\1\:VSS \2\:VSS) resistor r=75 c=0
Rz7 (\6\:VSS \7\:VSS) resistor r=75 c=0
Rz1 (net124 \2\:net124) resistor r=75 c=0
Rz2 (\3\:net124 \4\:net124) resistor r=75 c=0
Rz3 (\5\:net124 \6\:net124) resistor r=75 c=0
Rz4 (\9\:net128 \10\:net128) resistor r=75 c=0
Ry2 (\1\:Y \2\:Y) resistor r=20.6667 c=0
Ry4 (\1\:VDD \2\:VDD) resistor r=62 c=0
Ry5 (\5\:VDD \6\:VDD) resistor r=62 c=0
Ry1 (\7\:net128 \8\:net128) resistor r=62 c=0
Rx2 (\2\:A1 \6\:A1) resistor r=45 c=0
Rx4 (\2\:B0 \4\:B0) resistor r=45 c=0
Rx1 (\2\:A0 \4\:A0) resistor r=45 c=0
Rx3 (\3\:B1 \6\:B1) resistor r=45 c=0
Rx5 (\3\:net128 \5\:net128) resistor r=45 c=0
mn0 (\5\:net124 \3\:A0 \6\:VSS VSS) g45n1lvt w=(1.45e-07) l=4.5e-08 nf=1 \
        as=4.715e-14 ad=2.03e-14 ps=1.41e-06 pd=5.7e-07 nrd=1.16667 \
        nrs=1.16667 sa=1.4e-07 sb=7.45e-07 sd=160n sca=12.5912 \
        scb=0.0129007 scc=0.000589158 m=(1)
mn1 (\3\:net124 \3\:A1 \6\:VSS VSS) g45n1lvt w=(1.45e-07) l=4.5e-08 nf=1 \
        as=4.715e-14 ad=2.32e-14 ps=1.41e-06 pd=6.1e-07 nrd=1.16667 \
        nrs=1.16667 sa=3.35e-07 sb=5.5e-07 sd=160n sca=12.5912 \
        scb=0.0129007 scc=0.000589158 m=(1)
mn3 (\9\:net128 \4\:B1 \3\:net124 VSS) g45n1lvt w=(1.45e-07) l=4.5e-08 \
        nf=1 as=2.32e-14 ad=2.32e-14 ps=6.1e-07 pd=6.1e-07 nrd=1.16667 \
        nrs=1.16667 sa=5.4e-07 sb=3.45e-07 sd=160n sca=12.5912 \
        scb=0.0129007 scc=0.000589158 m=(1)
mn2 (\9\:net128 \3\:B0 net124 VSS) g45n1lvt w=(1.45e-07) l=4.5e-08 nf=1 \
        as=2.03e-14 ad=2.32e-14 ps=5.7e-07 pd=6.1e-07 nrd=1.16667 \
        nrs=1.16667 sa=7.45e-07 sb=1.4e-07 sd=160n sca=12.5912 \
        scb=0.0129007 scc=0.000589158 m=(1)
mn4 (\3\:Y \4\:net128 \1\:VSS VSS) g45n1lvt w=(2.6e-07) l=4.5e-08 nf=1 \
        as=4.89e-14 ad=3.64e-14 ps=1.44e-06 pd=8e-07 nrd=1.16667 \
        nrs=1.16667 sa=1e-07 sb=1.4e-07 sd=160n sca=14.4034 scb=0.0144248 \
        scc=0.00102063 m=(1)
mp4 (\1\:Y net128 \1\:VDD VDD) g45p1lvt w=(3.9e-07) l=4.5e-08 nf=1 \
        as=8.63e-14 ad=5.46e-14 ps=1.42e-06 pd=1.06e-06 nrd=1.16667 \
        nrs=1.16667 sa=6.56795e-07 sb=1.4e-07 sd=160n sca=31.7169 \
        scb=0.0333373 scc=0.002913 m=(1)
ends OA22X1
// End of subcircuit definition.
