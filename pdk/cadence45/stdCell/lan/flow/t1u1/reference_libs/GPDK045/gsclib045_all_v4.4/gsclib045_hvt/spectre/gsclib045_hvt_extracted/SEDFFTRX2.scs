// Generated for: spectre (May  1 09:16:17 2013 )
// Library name: gsclib045_hvt
// Cell name: SEDFFTRX2
// View name: extracted

simulator lang=spectre

subckt SEDFFTRX2 CK D E Q QN RN SE SI VDD VSS
mp10 (\5\:SEb \1\:SE \30\:VDD VDD) g45p1hvt w=(2.15e-07) l=4.5e-08 nf=1 \
        as=5.51e-14 ad=3.01e-14 ps=1e-06 pd=7.1e-07 nrd=1.16667 \
        nrs=1.16667 sa=1.4e-07 sb=1.195e-06 sd=160n sca=26.5786 \
        scb=0.0259232 scc=0.00247005 m=(1)
mp13 (net557 \1\:SI \30\:VDD VDD) g45p1hvt w=(2.15e-07) l=4.5e-08 nf=1 \
        as=5.51e-14 ad=1.29e-14 ps=1e-06 pd=5.5e-07 nrd=1.16667 \
        nrs=1.16667 sa=4.05e-07 sb=9.3e-07 sd=160n sca=23.7838 \
        scb=0.0218743 scc=0.00242478 m=(1)
mp14 (\4\:Dpb \3\:SEb net557 VDD) g45p1hvt w=(2.15e-07) l=4.5e-08 nf=1 \
        as=1.29e-14 ad=6.128e-14 ps=5.5e-07 pd=1e-06 nrd=1.16667 \
        nrs=1.16667 sa=5.1e-07 sb=8.25e-07 sd=160n sca=23.3365 \
        scb=0.0215703 scc=0.00242447 m=(1)
mp12 (\4\:Dpb \6\:SE net549 VDD) g45p1hvt w=(2.15e-07) l=4.5e-08 nf=1 \
        as=2.473e-14 ad=6.128e-14 ps=6.6e-07 pd=1e-06 nrd=1.16667 \
        nrs=1.16667 sa=8.4e-07 sb=4.95e-07 sd=160n sca=22.8495 \
        scb=0.0214046 scc=0.00242442 m=(1)
mp11 (net549 \2\:Dp \28\:VDD VDD) g45p1hvt w=(2.15e-07) l=4.5e-08 nf=1 \
        as=6.315e-14 ad=2.473e-14 ps=1.77e-06 pd=6.6e-07 nrd=1.16667 \
        nrs=1.16667 sa=1e-06 sb=3.35e-07 sd=160n sca=22.8495 scb=0.0214046 \
        scc=0.00242442 m=(1)
mp21 (\15\:CKbb \8\:CKb \28\:VDD VDD) g45p1hvt w=(2.15e-07) l=4.5e-08 \
        nf=1 as=6.315e-14 ad=3.01e-14 ps=1.77e-06 pd=7.1e-07 nrd=1.16667 \
        nrs=1.16667 sa=1.195e-06 sb=1.4e-07 sd=160n sca=22.8495 \
        scb=0.0214046 scc=0.00242442 m=(1)
mp25 (\6\:n20 CKbb \6\:Dpb VDD) g45p1hvt w=(2.15e-07) l=4.5e-08 nf=1 \
        as=3.01e-14 ad=3.87e-14 ps=7.1e-07 pd=7.9e-07 nrd=1.16667 \
        nrs=1.16667 sa=1.4e-07 sb=1.91093e-06 sd=160n sca=13.4114 \
        scb=0.012694 scc=0.000544005 m=(1)
mp36 (\6\:n20 \6\:CKb net521 VDD) g45p1hvt w=(2.15e-07) l=4.5e-08 nf=1 \
        as=3.332e-14 ad=3.87e-14 ps=7.4e-07 pd=7.9e-07 nrd=1.16667 \
        nrs=1.16667 sa=3.65e-07 sb=1.68593e-06 sd=160n sca=13.4114 \
        scb=0.012694 scc=0.000544005 m=(1)
mp35 (net521 mout \26\:VDD VDD) g45p1hvt w=(2.15e-07) l=4.5e-08 nf=1 \
        as=8.547e-14 ad=3.332e-14 ps=1.96e-06 pd=7.4e-07 nrd=1.16667 \
        nrs=1.16667 sa=5.65e-07 sb=1.48593e-06 sd=160n sca=13.4114 \
        scb=0.012694 scc=0.000544005 m=(1)
mp30 (\4\:mout n20 \26\:VDD VDD) g45p1hvt w=(2.15e-07) l=4.5e-08 nf=1 \
        as=8.547e-14 ad=8.6e-14 ps=1.96e-06 pd=1.23e-06 nrd=1.16667 \
        nrs=1.16667 sa=8.05e-07 sb=1.24593e-06 sd=160n sca=13.4114 \
        scb=0.012694 scc=0.000544005 m=(1)
mp40 (\7\:n30 \9\:CKb \4\:mout VDD) g45p1hvt w=(2.15e-07) l=4.5e-08 nf=1 \
        as=8.6e-14 ad=3.87e-14 ps=1.23e-06 pd=7.9e-07 nrd=1.16667 \
        nrs=1.16667 sa=1.25e-06 sb=8.0093e-07 sd=160n sca=13.4114 \
        scb=0.012694 scc=0.000544005 m=(1)
mp51 (\7\:n30 \5\:CKbb net529 VDD) g45p1hvt w=(2.15e-07) l=4.5e-08 nf=1 \
        as=4.192e-14 ad=3.87e-14 ps=8.2e-07 pd=7.9e-07 nrd=1.16667 \
        nrs=1.16667 sa=1.475e-06 sb=5.7593e-07 sd=160n sca=13.4114 \
        scb=0.012694 scc=0.000544005 m=(1)
mp50 (net529 \3\:qbint \24\:VDD VDD) g45p1hvt w=(2.15e-07) l=4.5e-08 \
        nf=1 as=8.663e-14 ad=4.193e-14 ps=2.05e-06 pd=8.2e-07 nrd=1.16667 \
        nrs=1.16667 sa=1.715e-06 sb=3.3593e-07 sd=160n sca=13.4114 \
        scb=0.012694 scc=0.000544005 m=(1)
mp20 (\15\:CKb \3\:CK \7\:VDD VDD) g45p1hvt w=(2.15e-07) l=4.5e-08 nf=1 \
        as=1.1785e-13 ad=3.01e-14 ps=1.9e-06 pd=7.1e-07 nrd=1.16667 \
        nrs=1.16667 sa=1.4e-07 sb=1.29233e-06 sd=160n sca=45.7906 \
        scb=0.0283307 scc=0.00588417 m=(1)
mp56 (\11\:net582 \12\:qbint \7\:VDD VDD) g45p1hvt w=(2.15e-07) \
        l=4.5e-08 nf=1 as=8.268e-14 ad=2.63e-14 ps=1.97e-06 pd=7.1e-07 \
        nrd=1.16667 nrs=1.16667 sa=1.31e-06 sb=1.22326e-07 sd=160n \
        sca=45.7906 scb=0.0283307 scc=0.00588417 m=(1)
mp2 (\7\:RNb \1\:RN \16\:VDD VDD) g45p1hvt w=(2.15e-07) l=4.5e-08 nf=1 \
        as=4.73e-14 ad=5.805e-14 ps=8.7e-07 pd=9.7e-07 nrd=1.16667 \
        nrs=1.16667 sa=2.7e-07 sb=8.15e-07 sd=160n sca=10.3756 \
        scb=0.00778655 scc=9.84544e-05 m=(1)
mp3 (net493 RNb \16\:VDD VDD) g45p1hvt w=(2.15e-07) l=4.5e-08 nf=1 \
        as=4.73e-14 ad=3.44e-14 ps=8.7e-07 pd=7.5e-07 nrd=1.16667 \
        nrs=1.16667 sa=5.35e-07 sb=5.5e-07 sd=160n sca=10.3756 \
        scb=0.00778655 scc=9.84544e-05 m=(1)
mp5 (net505 \13\:qbint net493 VDD) g45p1hvt w=(2.15e-07) l=4.5e-08 nf=1 \
        as=3.44e-14 ad=3.44e-14 ps=7.5e-07 pd=7.5e-07 nrd=1.16667 \
        nrs=1.16667 sa=7.4e-07 sb=3.45e-07 sd=160n sca=10.3756 \
        scb=0.00778655 scc=9.84544e-05 m=(1)
mp4 (net505 Eb \3\:net493 VDD) g45p1hvt w=(2.15e-07) l=4.5e-08 nf=1 \
        as=3.01e-14 ad=3.44e-14 ps=7.1e-07 pd=7.5e-07 nrd=1.16667 \
        nrs=1.16667 sa=9.45e-07 sb=1.4e-07 sd=160n sca=10.3756 \
        scb=0.00778655 scc=9.84544e-05 m=(1)
mp6 (\11\:Dp \3\:E \3\:net505 VDD) g45p1hvt w=(2.15e-07) l=4.5e-08 nf=1 \
        as=3.44e-14 ad=3.01e-14 ps=7.5e-07 pd=7.1e-07 nrd=1.16667 \
        nrs=1.16667 sa=1.4e-07 sb=3.45e-07 sd=160n sca=15.2551 \
        scb=0.0150251 scc=0.000885438 m=(1)
mp7 (\4\:Dp \2\:Db \3\:net505 VDD) g45p1hvt w=(2.15e-07) l=4.5e-08 nf=1 \
        as=3.44e-14 ad=3.01e-14 ps=7.5e-07 pd=7.1e-07 nrd=1.16667 \
        nrs=1.16667 sa=3.45e-07 sb=1.4e-07 sd=160n sca=15.3037 \
        scb=0.0150346 scc=0.000885439 m=(1)
mp0 (\7\:Eb \4\:E \1\:VDD VDD) g45p1hvt w=(2.15e-07) l=4.5e-08 nf=1 \
        as=6.04e-14 ad=3.01e-14 ps=1.66e-06 pd=7.1e-07 nrd=1.16667 \
        nrs=1.16667 sa=1.4e-07 sb=4.05e-07 sd=160n sca=18.613 \
        scb=0.0184651 scc=0.00105196 m=(1)
mp1 (\6\:Db \3\:D \1\:VDD VDD) g45p1hvt w=(2.15e-07) l=4.5e-08 nf=1 \
        as=6.04e-14 ad=4.515e-14 ps=1.66e-06 pd=8.5e-07 nrd=1.16667 \
        nrs=1.16667 sa=3.35e-07 sb=2.1e-07 sd=160n sca=23.8984 \
        scb=0.0274473 scc=0.0014436 m=(1)
C1 (D VSS) capacitor c=8.84096e-17
C2 (CK VSS) capacitor c=5.4137e-17
C3 (E VSS) capacitor c=7.86304e-17
C4 (Q VSS) capacitor c=2.01994e-17
C5 (VDD VSS) capacitor c=5.94373e-16
C6 (SE VSS) capacitor c=4.06855e-17
C7 (SI VSS) capacitor c=1.04552e-16
C8 (QN VSS) capacitor c=2.91019e-17
C9 (SEb VSS) capacitor c=5.06365e-17
C10 (net658 VSS) capacitor c=8.64555e-20
C11 (Dpb VSS) capacitor c=7.32006e-17
C12 (net650 VSS) capacitor c=2.61787e-18
C13 (Dp VSS) capacitor c=3.29499e-17
C14 (CKbb VSS) capacitor c=4.25729e-17
C15 (CKb VSS) capacitor c=3.25989e-17
C16 (n20 VSS) capacitor c=5.20413e-17
C17 (mout VSS) capacitor c=3.86844e-17
C18 (n30 VSS) capacitor c=2.94245e-17
C19 (net618 VSS) capacitor c=1.54832e-18
C20 (qbint VSS) capacitor c=6.84295e-17
C21 (net582 VSS) capacitor c=1.9055e-16
C22 (RNb VSS) capacitor c=5.67567e-17
C23 (Eb VSS) capacitor c=5.24549e-17
C24 (net638 VSS) capacitor c=4.34495e-19
C25 (Db VSS) capacitor c=6.7728e-17
C26 (net557 VSS) capacitor c=2.17167e-18
C27 (net549 VSS) capacitor c=2.63014e-18
C28 (net521 VSS) capacitor c=2.79667e-18
C29 (net529 VSS) capacitor c=4.69748e-18
C30 (net493 VSS) capacitor c=7.0261e-17
C31 (net505 VSS) capacitor c=9.57766e-17
C32 (\3\:D VSS) capacitor c=4.92562e-17
C33 (\4\:E VSS) capacitor c=4.80831e-17
C34 (\2\:Db VSS) capacitor c=4.10213e-17
C35 (\3\:E VSS) capacitor c=3.95181e-17
C36 (\13\:qbint VSS) capacitor c=7.23798e-17
C37 (\1\:RN VSS) capacitor c=3.30585e-17
C38 (\12\:qbint VSS) capacitor c=6.36256e-17
C39 (\3\:CK VSS) capacitor c=2.96654e-17
C40 (\3\:n30 VSS) capacitor c=5.86289e-17
C41 (\3\:qbint VSS) capacitor c=4.11017e-17
C42 (\5\:CKbb VSS) capacitor c=5.80853e-17
C43 (\9\:CKb VSS) capacitor c=3.49942e-17
C44 (\6\:CKb VSS) capacitor c=3.3131e-17
C45 (\8\:CKb VSS) capacitor c=5.38699e-17
C46 (\2\:Dp VSS) capacitor c=6.26113e-17
C47 (\6\:SE VSS) capacitor c=5.51444e-17
C48 (\3\:SEb VSS) capacitor c=4.71858e-17
C49 (\1\:SI VSS) capacitor c=5.9129e-17
C50 (\1\:SE VSS) capacitor c=4.5879e-17
C51 (\1\:D VSS) capacitor c=2.86539e-17
C52 (\7\:E VSS) capacitor c=3.72718e-17
C53 (\1\:E VSS) capacitor c=4.57531e-17
C54 (\3\:Eb VSS) capacitor c=3.12211e-17
C55 (\14\:qbint VSS) capacitor c=6.14257e-17
C56 (\3\:RNb VSS) capacitor c=4.14769e-17
C57 (\3\:RN VSS) capacitor c=5.39684e-17
C58 (\11\:qbint VSS) capacitor c=3.31754e-17
C59 (\4\:qbint VSS) capacitor c=1.72222e-16
C60 (\1\:CK VSS) capacitor c=3.57022e-17
C61 (\11\:CKb VSS) capacitor c=5.78608e-17
C62 (\7\:CKbb VSS) capacitor c=1.83176e-17
C63 (\3\:n20 VSS) capacitor c=2.48722e-17
C64 (\3\:mout VSS) capacitor c=7.79197e-17
C65 (\3\:CKbb VSS) capacitor c=7.50113e-17
C66 (\7\:CKb VSS) capacitor c=2.46198e-17
C67 (\5\:CKb VSS) capacitor c=3.04196e-17
C68 (\3\:Dp VSS) capacitor c=6.49357e-17
C69 (\4\:SE VSS) capacitor c=6.6042e-17
C70 (\4\:SI VSS) capacitor c=6.03179e-17
C71 (\3\:SE VSS) capacitor c=2.5395e-17
C72 (\2\:D VSS) capacitor c=3.93773e-17
C73 (\6\:E VSS) capacitor c=2.61067e-17
C74 (\3\:Db VSS) capacitor c=2.27074e-17
C75 (\2\:E VSS) capacitor c=4.00463e-17
C76 (\2\:Eb VSS) capacitor c=4.95152e-17
C77 (\15\:qbint VSS) capacitor c=2.61892e-17
C78 (\2\:RNb VSS) capacitor c=4.89502e-17
C79 (\2\:RN VSS) capacitor c=3.59121e-17
C80 (\10\:qbint VSS) capacitor c=2.17766e-17
C81 (\2\:CK VSS) capacitor c=3.86184e-17
C82 (\2\:n30 VSS) capacitor c=2.32223e-17
C83 (\2\:qbint VSS) capacitor c=4.2574e-17
C84 (\12\:CKb VSS) capacitor c=3.63909e-17
C85 (\6\:CKbb VSS) capacitor c=5.42603e-17
C86 (\10\:CKb VSS) capacitor c=3.5463e-17
C87 (\2\:n20 VSS) capacitor c=3.49069e-17
C88 (\2\:mout VSS) capacitor c=5.37578e-17
C89 (\4\:CKbb VSS) capacitor c=2.59958e-17
C90 (\2\:CKbb VSS) capacitor c=4.00894e-17
C91 (\7\:SE VSS) capacitor c=4.39112e-17
C92 (\2\:SEb VSS) capacitor c=6.22714e-17
C93 (\5\:SE VSS) capacitor c=4.66353e-17
C94 (\3\:SI VSS) capacitor c=5.83743e-17
C95 (\2\:SE VSS) capacitor c=3.09787e-17
C96 (\6\:Db VSS) capacitor c=1.04604e-16
C97 (\1\:VDD VSS) capacitor c=2.37403e-17
C98 (\7\:Eb VSS) capacitor c=8.23379e-17
C99 (\4\:Dp VSS) capacitor c=7.40365e-17
C100 (\3\:net505 VSS) capacitor c=1.09882e-16
C101 (\3\:net493 VSS) capacitor c=8.90818e-17
C102 (\16\:VDD VSS) capacitor c=4.17482e-17
C103 (\7\:RNb VSS) capacitor c=1.10327e-16
C104 (\11\:net582 VSS) capacitor c=3.03376e-17
C105 (\4\:QN VSS) capacitor c=2.71195e-17
C106 (\2\:Q VSS) capacitor c=2.37262e-17
C107 (\15\:CKb VSS) capacitor c=1.16597e-16
C108 (\21\:qbint VSS) capacitor c=8.36508e-17
C109 (\24\:VDD VSS) capacitor c=2.50528e-17
C110 (\7\:n30 VSS) capacitor c=8.50427e-17
C111 (\4\:mout VSS) capacitor c=4.47461e-17
C112 (\26\:VDD VSS) capacitor c=1.81678e-17
C113 (\6\:n20 VSS) capacitor c=5.77146e-17
C114 (\6\:Dpb VSS) capacitor c=3.00986e-17
C115 (\15\:CKbb VSS) capacitor c=6.33283e-17
C116 (\28\:VDD VSS) capacitor c=1.97714e-17
C117 (\4\:Dpb VSS) capacitor c=1.24621e-16
C118 (\30\:VDD VSS) capacitor c=4.21626e-17
C119 (\5\:SEb VSS) capacitor c=1.26247e-16
C120 (\3\:VDD VSS) capacitor c=1.66684e-16
C121 (\4\:Db VSS) capacitor c=6.97263e-17
C122 (\5\:Eb VSS) capacitor c=1.60197e-16
C123 (\9\:Dp VSS) capacitor c=1.10602e-16
C124 (\13\:Dp VSS) capacitor c=6.09764e-17
C125 (\4\:RNb VSS) capacitor c=2.01236e-17
C126 (\7\:net582 VSS) capacitor c=6.23601e-17
C127 (\1\:QN VSS) capacitor c=3.2644e-17
C128 (\4\:Q VSS) capacitor c=5.25879e-17
C129 (\13\:CKb VSS) capacitor c=6.87082e-17
C130 (\19\:qbint VSS) capacitor c=9.08339e-17
C131 (\5\:n30 VSS) capacitor c=9.52847e-17
C132 (\8\:mout VSS) capacitor c=5.53761e-17
C133 (\8\:n20 VSS) capacitor c=3.53392e-17
C134 (\11\:CKbb VSS) capacitor c=6.72839e-17
C135 (\8\:Dpb VSS) capacitor c=1.01774e-16
C136 (\7\:SEb VSS) capacitor c=8.00507e-17
C137 (\2\:CKb VSS) capacitor c=4.95874e-17
C138 (\3\:CKb VSS) capacitor c=4.47481e-17
C139 (\4\:CKb VSS) capacitor c=3.77119e-17
C140 (\5\:SI VSS) capacitor c=4.14328e-17
C141 (\4\:SEb VSS) capacitor c=8.53594e-17
C142 (\8\:SE VSS) capacitor c=1.22755e-16
C143 (\9\:SE VSS) capacitor c=1.0927e-16
C144 (\10\:SE VSS) capacitor c=3.29268e-17
C145 (\11\:SE VSS) capacitor c=3.13151e-17
C146 (\3\:Dpb VSS) capacitor c=1.24082e-16
C147 (\4\:n20 VSS) capacitor c=5.07986e-17
C148 (\5\:n20 VSS) capacitor c=6.38492e-17
C149 (\5\:E VSS) capacitor c=3.22156e-17
C150 (\6\:mout VSS) capacitor c=4.74091e-17
C151 (\7\:mout VSS) capacitor c=5.19744e-17
C152 (\8\:CKbb VSS) capacitor c=1.18286e-16
C153 (\9\:CKbb VSS) capacitor c=9.23106e-17
C154 (\10\:CKbb VSS) capacitor c=6.39491e-17
C155 (\13\:CKbb VSS) capacitor c=1.98737e-17
C156 (\14\:CKbb VSS) capacitor c=8.12701e-17
C157 (\4\:n30 VSS) capacitor c=8.18117e-17
C158 (\17\:CKb VSS) capacitor c=1.29377e-16
C159 (\18\:CKb VSS) capacitor c=1.57817e-16
C160 (\19\:CKb VSS) capacitor c=1.18599e-16
C161 (\20\:CKb VSS) capacitor c=5.17634e-17
C162 (\21\:CKb VSS) capacitor c=6.16684e-17
C163 (\4\:CK VSS) capacitor c=5.64819e-17
C164 (\1\:Q VSS) capacitor c=3.34692e-17
C165 (\3\:QN VSS) capacitor c=4.02156e-17
C166 (\9\:net582 VSS) capacitor c=4.05088e-17
C167 (\10\:net582 VSS) capacitor c=2.65393e-17
C168 (\4\:RN VSS) capacitor c=6.44601e-17
C169 (\5\:RN VSS) capacitor c=6.30241e-17
C170 (\6\:RNb VSS) capacitor c=1.15255e-16
C171 (\9\:RNb VSS) capacitor c=4.5712e-17
C172 (\16\:qbint VSS) capacitor c=7.65188e-17
C173 (\17\:qbint VSS) capacitor c=1.55595e-16
C174 (\18\:qbint VSS) capacitor c=1.32277e-16
C175 (\23\:qbint VSS) capacitor c=5.98385e-17
C176 (\24\:qbint VSS) capacitor c=5.07822e-17
C177 (\6\:Dp VSS) capacitor c=1.34751e-16
C178 (\7\:Dp VSS) capacitor c=5.17271e-16
C179 (\8\:Dp VSS) capacitor c=5.43669e-16
C180 (\8\:E VSS) capacitor c=5.73422e-17
C181 (\4\:Eb VSS) capacitor c=1.16507e-16
C182 (\4\:D VSS) capacitor c=4.67927e-17
C183 (\8\:Db VSS) capacitor c=6.81924e-17
C184 (\5\:VDD VSS) capacitor c=5.94219e-17
C185 (\7\:VDD VSS) capacitor c=1.45129e-16
C186 (\10\:VDD VSS) capacitor c=1.26652e-17
C187 (\12\:VDD VSS) capacitor c=6.21188e-17
C188 (\13\:VDD VSS) capacitor c=1.75752e-17
C189 (\15\:VDD VSS) capacitor c=1.37087e-17
Rk66 (\4\:D D) resistor r=0.1052 c=0
Rk69 (\2\:VSS \4\:VSS) resistor r=0.3652 c=0
Rk70 (\4\:VSS \5\:VSS) resistor r=0.3988 c=0
Rk71 (\5\:VSS \6\:VSS) resistor r=0.08493 c=0
Rk72 (\6\:VSS \7\:VSS) resistor r=0.3123 c=0
Rk73 (\7\:VSS \8\:VSS) resistor r=0.05406 c=0
Rk74 (\8\:VSS \9\:VSS) resistor r=0.3176 c=0
Rk77 (\9\:VSS \12\:VSS) resistor r=0.4135 c=0
Rk78 (\5\:VSS \14\:VSS) resistor r=0.2414 c=0
Rk79 (\6\:VSS \16\:VSS) resistor r=0.226 c=0
Rk80 (\7\:VSS \18\:VSS) resistor r=0.04335 c=0
Rk84 (\12\:VSS \25\:VSS) resistor r=0.5469 c=0
Rk85 (\25\:VSS \26\:VSS) resistor r=0.5944 c=0
Rk86 (\26\:VSS \27\:VSS) resistor r=0.06254 c=0
Rk88 (\28\:VSS VSS) resistor r=0.2028 c=0
Rk87 (\27\:VSS \28\:VSS) resistor r=0.3486 c=0
Rk89 (\12\:VSS \30\:VSS) resistor r=0.3447 c=0
Rk90 (\25\:VSS \32\:VSS) resistor r=0.1637 c=0
Rk91 (\26\:VSS \34\:VSS) resistor r=0.3131 c=0
Rk92 (\28\:VSS \36\:VSS) resistor r=0.3108 c=0
Rk32 (CK \4\:CK) resistor r=0.1836 c=0
Rk62 (\8\:E E) resistor r=0.2631 c=0
Rk63 (E \9\:E) resistor r=0.003311 c=0
Rk33 (Q \1\:Q) resistor r=0.04369 c=0
Rk34 (\1\:Q \3\:Q) resistor r=0.051 c=0
Rk35 (\1\:Q \5\:Q) resistor r=0.1531 c=0
Rk93 (\2\:VDD \4\:VDD) resistor r=0.1204 c=0
Rk94 (\4\:VDD \5\:VDD) resistor r=0.7752 c=0
Rk95 (\5\:VDD \6\:VDD) resistor r=0.0776 c=0
Rk96 (\6\:VDD \7\:VDD) resistor r=0.3662 c=0
Rk99 (\7\:VDD \10\:VDD) resistor r=0.3048 c=0
Rk100 (\10\:VDD \11\:VDD) resistor r=0.05908 c=0
Rk101 (\11\:VDD \12\:VDD) resistor r=0.6573 c=0
Rk102 (\12\:VDD \13\:VDD) resistor r=0.4479 c=0
Rk103 (\13\:VDD \14\:VDD) resistor r=0.09672 c=0
Rk105 (\15\:VDD VDD) resistor r=0.2028 c=0
Rk104 (\14\:VDD \15\:VDD) resistor r=0.3486 c=0
Rk106 (\5\:VDD \17\:VDD) resistor r=0.1753 c=0
Rk110 (\10\:VDD \25\:VDD) resistor r=0.04335 c=0
Rk111 (\12\:VDD \27\:VDD) resistor r=0.0744 c=0
Rk112 (\13\:VDD \29\:VDD) resistor r=0.04335 c=0
Rk113 (\15\:VDD \31\:VDD) resistor r=0.3284 c=0
Rk4 (\8\:SE \9\:SE) resistor r=0.9059 c=0
Rk6 (\10\:SE SE) resistor r=0.04983 c=0
Rk5 (\9\:SE \10\:SE) resistor r=0.23 c=0
Rk7 (\9\:SE \11\:SE) resistor r=0.08816 c=0
Rk42 (RN \4\:RN) resistor r=0.004987 c=0
Rk44 (\4\:RN \5\:RN) resistor r=0.05906 c=0
Rk43 (\5\:RN \6\:RN) resistor r=0.005088 c=0
Rk1 (\5\:SI SI) resistor r=0.06196 c=0
Rk37 (\3\:QN QN) resistor r=0.04113 c=0
Rk36 (\2\:QN \3\:QN) resistor r=0.1178 c=0
Rk38 (\3\:QN \5\:QN) resistor r=0.183 c=0
Rk2 (\4\:SEb \6\:SEb) resistor r=0.4946 c=0
Rk3 (\6\:SEb \8\:SEb) resistor r=0.6889 c=0
Rk8 (\2\:Dpb \3\:Dpb) resistor r=0.3754 c=0
Rk9 (\3\:Dpb \5\:Dpb) resistor r=0.5903 c=0
Rk10 (\3\:Dpb \7\:Dpb) resistor r=0.05034 c=0
Rk11 (\5\:Dpb \9\:Dpb) resistor r=0.5309 c=0
Rk56 (\5\:Dp \6\:Dp) resistor r=0.4071 c=0
Rk57 (\6\:Dp \7\:Dp) resistor r=0.4312 c=0
Rk58 (\7\:Dp \8\:Dp) resistor r=4.291 c=0
Rk59 (\6\:Dp \10\:Dp) resistor r=0.6038 c=0
Rk60 (\6\:Dp \12\:Dp) resistor r=0.02745 c=0
Rk61 (\7\:Dp \14\:Dp) resistor r=0.2868 c=0
Rk18 (\8\:CKbb \9\:CKbb) resistor r=0.8779 c=0
Rk19 (\9\:CKbb \10\:CKbb) resistor r=0.2701 c=0
Rk20 (\10\:CKbb \12\:CKbb) resistor r=0.2758 c=0
Rk21 (\9\:CKbb \13\:CKbb) resistor r=0.0379 c=0
Rk22 (\10\:CKbb \14\:CKbb) resistor r=0.3631 c=0
Rk23 (\12\:CKbb \16\:CKbb) resistor r=0.4055 c=0
Rk26 (\14\:CKb \16\:CKb) resistor r=0.398 c=0
Rk27 (\16\:CKb \17\:CKb) resistor r=0.625 c=0
Rk28 (\17\:CKb \18\:CKb) resistor r=0.4201 c=0
Rk29 (\18\:CKb \19\:CKb) resistor r=0.8159 c=0
Rk30 (\17\:CKb \20\:CKb) resistor r=0.2462 c=0
Rk31 (\18\:CKb \21\:CKb) resistor r=0.2216 c=0
Rk12 (\4\:n20 \5\:n20) resistor r=0.3489 c=0
Rk13 (\5\:n20 \7\:n20) resistor r=0.2821 c=0
Rk14 (\5\:n20 \9\:n20) resistor r=0.1211 c=0
Rk15 (\5\:mout \6\:mout) resistor r=0.1211 c=0
Rk16 (\6\:mout \7\:mout) resistor r=0.2976 c=0
Rk17 (\6\:mout \9\:mout) resistor r=0.2622 c=0
Rk24 (\4\:n30 \6\:n30) resistor r=0.4793 c=0
Rk25 (\6\:n30 \8\:n30) resistor r=0.398 c=0
Rk48 (\16\:qbint \17\:qbint) resistor r=0.5864 c=0
Rk49 (\17\:qbint \18\:qbint) resistor r=0.8132 c=0
Rk50 (\18\:qbint \20\:qbint) resistor r=0.4957 c=0
Rk51 (\20\:qbint \22\:qbint) resistor r=0.3383 c=0
Rk52 (\18\:qbint \23\:qbint) resistor r=0.2333 c=0
Rk53 (\22\:qbint \24\:qbint) resistor r=0.2558 c=0
Rk39 (\8\:net582 \9\:net582) resistor r=0.2983 c=0
Rk40 (\9\:net582 \10\:net582) resistor r=0.1491 c=0
Rk41 (\9\:net582 \12\:net582) resistor r=0.1281 c=0
Rk45 (\5\:RNb \6\:RNb) resistor r=0.0416 c=0
Rk46 (\6\:RNb \8\:RNb) resistor r=0.7176 c=0
Rk47 (\6\:RNb \9\:RNb) resistor r=0.2684 c=0
Rk64 (\4\:Eb \6\:Eb) resistor r=0.9292 c=0
Rk65 (\6\:Eb \8\:Eb) resistor r=0.5193 c=0
Rk67 (\5\:Db \7\:Db) resistor r=0.5301 c=0
Rk68 (\7\:Db \8\:Db) resistor r=0.6441 c=0
Rk54 (\2\:net493 \4\:net493) resistor r=0.3068 c=0
Rk55 (\2\:net505 \4\:net505) resistor r=0.6555 c=0
Rl63 (\2\:D \3\:D) resistor r=130.002 c=0
Rl62 (\1\:D \2\:D) resistor r=26.1559 c=0
Rl34 (\2\:CK \3\:CK) resistor r=59.5926 c=0
Rl33 (\1\:CK \2\:CK) resistor r=32.2239 c=0
Rl56 (\2\:E \3\:E) resistor r=48.0649 c=0
Rl55 (\1\:E \2\:E) resistor r=74.7951 c=0
Rl59 (\4\:E \5\:E) resistor r=66.1873 c=0
Rl61 (\5\:E \7\:E) resistor r=108.495 c=0
Rl60 (\5\:E \6\:E) resistor r=17.513 c=0
Rl9 (\6\:SE \7\:SE) resistor r=54.5379 c=0
Rl6 (\4\:SE \5\:SE) resistor r=35.3072 c=0
Rl1 (\1\:SE \2\:SE) resistor r=104.538 c=0
Rl2 (\2\:SE \3\:SE) resistor r=29.5379 c=0
Rl47 (\1\:RN \2\:RN) resistor r=50.6918 c=0
Rl48 (\2\:RN \3\:RN) resistor r=156.461 c=0
Rl3 (\1\:SI \2\:SI) resistor r=51.6416 c=0
Rl5 (\2\:SI \4\:SI) resistor r=111.257 c=0
Rl4 (\2\:SI \3\:SI) resistor r=3.3229 c=0
Rl8 (\2\:SEb \3\:SEb) resistor r=26.3736 c=0
Rl7 (SEb \2\:SEb) resistor r=126.895 c=0
Rl11 (\2\:Dp \3\:Dp) resistor r=159.467 c=0
Rl10 (Dp \2\:Dp) resistor r=41.0764 c=0
Rl26 (\5\:CKbb \6\:CKbb) resistor r=151.043 c=0
Rl27 (\6\:CKbb \7\:CKbb) resistor r=24.2328 c=0
Rl13 (\3\:CKbb \4\:CKbb) resistor r=66.5405 c=0
Rl12 (CKbb \2\:CKbb) resistor r=51.1559 c=0
Rl28 (\11\:CKb \12\:CKb) resistor r=39.6174 c=0
Rl25 (\9\:CKb \10\:CKb) resistor r=24.2328 c=0
Rl18 (\2\:CKb \6\:CKb) resistor r=26.0667 c=0
Rl14 (CKb \2\:CKb) resistor r=3.7088 c=0
Rl19 (\3\:CKb \7\:CKb) resistor r=30.4507 c=0
Rl15 (\2\:CKb \3\:CKb) resistor r=170.863 c=0
Rl20 (\4\:CKb \8\:CKb) resistor r=76.0821 c=0
Rl17 (\4\:CKb \5\:CKb) resistor r=84.2779 c=0
Rl16 (\3\:CKb \4\:CKb) resistor r=146.229 c=0
Rl23 (n20 \2\:n20) resistor r=101.156 c=0
Rl24 (\2\:n20 \3\:n20) resistor r=24.2328 c=0
Rl21 (mout \2\:mout) resistor r=24.2328 c=0
Rl22 (\2\:mout \3\:mout) resistor r=106.558 c=0
Rl32 (\2\:n30 \3\:n30) resistor r=32.4874 c=0
Rl31 (n30 \2\:n30) resistor r=28.1965 c=0
Rl51 (\14\:qbint \13\:qbint) resistor r=232.692 c=0
Rl46 (\11\:qbint \12\:qbint) resistor r=143.796 c=0
Rl52 (\15\:qbint \14\:qbint) resistor r=44.9225 c=0
Rl45 (\10\:qbint \11\:qbint) resistor r=35.8844 c=0
Rl30 (\2\:qbint \3\:qbint) resistor r=24.2328 c=0
Rl29 (\2\:qbint qbint) resistor r=101.156 c=0
Rl49 (RNb \2\:RNb) resistor r=170.387 c=0
Rl50 (\2\:RNb \3\:RNb) resistor r=33.8482 c=0
Rl53 (Eb \2\:Eb) resistor r=172.872 c=0
Rl54 (\2\:Eb \3\:Eb) resistor r=33.5406 c=0
Rl57 (Db \2\:Db) resistor r=157.258 c=0
Rl58 (\2\:Db \3\:Db) resistor r=24.2328 c=0
Rz18 (\2\:VSS \1\:VSS) resistor r=75 c=0
Rz19 (\14\:VSS \13\:VSS) resistor r=75 c=0
Rz20 (\16\:VSS \15\:VSS) resistor r=75 c=0
Rz21 (\18\:VSS \17\:VSS) resistor r=75 c=0
Rz25 (\30\:VSS \29\:VSS) resistor r=75 c=0
Rz26 (\32\:VSS \31\:VSS) resistor r=75 c=0
Rz27 (\34\:VSS \33\:VSS) resistor r=75 c=0
Rz28 (\36\:VSS \35\:VSS) resistor r=75 c=0
Rz9 (\5\:Q \4\:Q) resistor r=75 c=0
Rz29 (\4\:VDD \3\:VDD) resistor r=15 c=0
Rz30 (\6\:VDD \3\:VDD) resistor r=6.25 c=0
Rz31 (\11\:VDD \3\:VDD) resistor r=6.25 c=0
Rz32 (\14\:VDD \3\:VDD) resistor r=6.25 c=0
Rz10 (\2\:QN \1\:QN) resistor r=75 c=0
Rz1 (\7\:SEb \8\:SEb) resistor r=75 c=0
Rz2 (Dpb \2\:Dpb) resistor r=75 c=0
Rz3 (\8\:Dpb \9\:Dpb) resistor r=75 c=0
Rz14 (\9\:Dp \10\:Dp) resistor r=75 c=0
Rz15 (\13\:Dp \14\:Dp) resistor r=75 c=0
Rz6 (\11\:CKbb \12\:CKbb) resistor r=75 c=0
Rz8 (\13\:CKb \14\:CKb) resistor r=75 c=0
Rz4 (\8\:n20 \9\:n20) resistor r=75 c=0
Rz5 (\8\:mout \9\:mout) resistor r=75 c=0
Rz7 (\5\:n30 \6\:n30) resistor r=75 c=0
Rz13 (\20\:qbint \19\:qbint) resistor r=75 c=0
Rz11 (\8\:net582 \7\:net582) resistor r=75 c=0
Rz12 (\4\:RNb \5\:RNb) resistor r=75 c=0
Rz16 (\5\:Eb \6\:Eb) resistor r=75 c=0
Rz17 (\4\:Db \5\:Db) resistor r=75 c=0
Ry22 (\4\:VSS \3\:VSS) resistor r=12.4 c=0
Ry23 (\8\:VSS \3\:VSS) resistor r=5.1667 c=0
Ry24 (\12\:VSS \3\:VSS) resistor r=5.1667 c=0
Ry25 (\27\:VSS \3\:VSS) resistor r=5.1667 c=0
Ry9 (\3\:Q \2\:Q) resistor r=62 c=0
Ry26 (\2\:VDD \1\:VDD) resistor r=62 c=0
Ry27 (\17\:VDD \16\:VDD) resistor r=62 c=0
Ry31 (\25\:VDD \24\:VDD) resistor r=62 c=0
Ry32 (\27\:VDD \26\:VDD) resistor r=62 c=0
Ry33 (\29\:VDD \28\:VDD) resistor r=62 c=0
Ry34 (\31\:VDD \30\:VDD) resistor r=62 c=0
Ry10 (\5\:QN \4\:QN) resistor r=62 c=0
Ry1 (\5\:SEb \6\:SEb) resistor r=62 c=0
Ry2 (\4\:Dpb \5\:Dpb) resistor r=62 c=0
Ry3 (\6\:Dpb \7\:Dpb) resistor r=62 c=0
Ry18 (\4\:Dp \5\:Dp) resistor r=62 c=0
Ry19 (\11\:Dp \12\:Dp) resistor r=62 c=0
Ry6 (\15\:CKbb \16\:CKbb) resistor r=62 c=0
Ry8 (\15\:CKb \16\:CKb) resistor r=62 c=0
Ry4 (\6\:n20 \7\:n20) resistor r=62 c=0
Ry5 (\4\:mout \5\:mout) resistor r=62 c=0
Ry7 (\7\:n30 \8\:n30) resistor r=62 c=0
Ry13 (\22\:qbint \21\:qbint) resistor r=62 c=0
Ry11 (\12\:net582 \11\:net582) resistor r=62 c=0
Ry12 (\7\:RNb \8\:RNb) resistor r=62 c=0
Ry20 (\7\:Eb \8\:Eb) resistor r=62 c=0
Ry21 (\6\:Db \7\:Db) resistor r=62 c=0
Ry14 (net493 \2\:net493) resistor r=62 c=0
Ry15 (\3\:net493 \4\:net493) resistor r=62 c=0
Ry16 (net505 \2\:net505) resistor r=62 c=0
Ry17 (\3\:net505 \4\:net505) resistor r=62 c=0
Rx27 (\2\:D \4\:D) resistor r=45 c=0
Rx15 (\2\:CK \4\:CK) resistor r=45 c=0
Rx24 (\6\:E \8\:E) resistor r=45 c=0
Rx25 (\2\:E \9\:E) resistor r=45 c=0
Rx3 (\7\:SE \8\:SE) resistor r=45 c=0
Rx4 (\2\:SE \10\:SE) resistor r=45 c=0
Rx5 (\5\:SE \11\:SE) resistor r=45 c=0
Rx17 (\2\:RN \6\:RN) resistor r=45 c=0
Rx1 (\3\:SI \5\:SI) resistor r=45 c=0
Rx2 (\2\:SEb \4\:SEb) resistor r=45 c=0
Rx23 (Dp \8\:Dp) resistor r=45 c=0
Rx8 (\6\:CKbb \8\:CKbb) resistor r=45 c=0
Rx9 (\4\:CKbb \13\:CKbb) resistor r=45 c=0
Rx10 (\2\:CKbb \14\:CKbb) resistor r=45 c=0
Rx12 (CKb \19\:CKb) resistor r=45 c=0
Rx13 (\12\:CKb \20\:CKb) resistor r=45 c=0
Rx14 (\10\:CKb \21\:CKb) resistor r=45 c=0
Rx6 (\2\:n20 \4\:n20) resistor r=45 c=0
Rx7 (\2\:mout \7\:mout) resistor r=45 c=0
Rx11 (\2\:n30 \4\:n30) resistor r=45 c=0
Rx19 (\16\:qbint \15\:qbint) resistor r=45 c=0
Rx20 (\17\:qbint \10\:qbint) resistor r=45 c=0
Rx21 (\23\:qbint \4\:qbint) resistor r=45 c=0
Rx22 (\24\:qbint \2\:qbint) resistor r=45 c=0
Rx16 (\10\:net582 net582) resistor r=45 c=0
Rx18 (\2\:RNb \9\:RNb) resistor r=45 c=0
Rx26 (\2\:Eb \4\:Eb) resistor r=45 c=0
Rx28 (\3\:Db \8\:Db) resistor r=45 c=0
mn10 (\7\:SEb \3\:SE \35\:VSS VSS) g45n1hvt w=(1.45e-07) l=4.5e-08 nf=1 \
        as=2.9e-14 ad=2.03e-14 ps=6.9e-07 pd=5.7e-07 nrd=1.16667 \
        nrs=1.16667 sa=1.4e-07 sb=1.165e-06 sd=160n sca=11.7118 \
        scb=0.0116498 scc=0.000458536 m=(1)
mn13 (net658 \4\:SI \35\:VSS VSS) g45n1hvt w=(1.45e-07) l=4.5e-08 nf=1 \
        as=2.9e-14 ad=8.7e-15 ps=6.9e-07 pd=4.1e-07 nrd=1.16667 \
        nrs=1.16667 sa=3.85e-07 sb=9.2e-07 sd=160n sca=11.7118 \
        scb=0.0116498 scc=0.000458536 m=(1)
mn14 (\8\:Dpb \4\:SE net658 VSS) g45n1hvt w=(1.45e-07) l=4.5e-08 nf=1 \
        as=8.7e-15 ad=2.32e-14 ps=4.1e-07 pd=6.1e-07 nrd=1.16667 \
        nrs=1.16667 sa=4.9e-07 sb=8.15e-07 sd=160n sca=11.7118 \
        scb=0.0116498 scc=0.000458536 m=(1)
mn12 (\8\:Dpb SEb net650 VSS) g45n1hvt w=(1.45e-07) l=4.5e-08 nf=1 \
        as=3.19e-14 ad=2.32e-14 ps=7.3e-07 pd=6.1e-07 nrd=1.16667 \
        nrs=1.16667 sa=6.95e-07 sb=6.1e-07 sd=160n sca=11.7118 \
        scb=0.0116498 scc=0.000458536 m=(1)
mn11 (net650 \3\:Dp \33\:VSS VSS) g45n1hvt w=(1.45e-07) l=4.5e-08 nf=1 \
        as=2.32e-14 ad=3.19e-14 ps=6.1e-07 pd=7.3e-07 nrd=1.16667 \
        nrs=1.16667 sa=9.6e-07 sb=3.45e-07 sd=160n sca=11.7118 \
        scb=0.0116498 scc=0.000458536 m=(1)
mn21 (\11\:CKbb \5\:CKb \33\:VSS VSS) g45n1hvt w=(1.45e-07) l=4.5e-08 \
        nf=1 as=2.32e-14 ad=2.03e-14 ps=6.1e-07 pd=5.7e-07 nrd=1.16667 \
        nrs=1.16667 sa=1.165e-06 sb=1.4e-07 sd=160n sca=11.7118 \
        scb=0.0116498 scc=0.000458536 m=(1)
mn25 (\8\:n20 \7\:CKb Dpb VSS) g45n1hvt w=(1.45e-07) l=4.5e-08 nf=1 \
        as=2.03e-14 ad=5.003e-14 ps=5.7e-07 pd=9.8e-07 nrd=1.16667 \
        nrs=1.16667 sa=1.4e-07 sb=2e-06 sd=160n sca=23.279 scb=0.0230742 \
        scc=0.00267719 m=(1)
mn36 (\8\:n20 \3\:CKbb net606 VSS) g45n1hvt w=(1.45e-07) l=4.5e-08 nf=1 \
        as=8.7e-15 ad=5.003e-14 ps=4.1e-07 pd=9.8e-07 nrd=1.16667 \
        nrs=1.16667 sa=5.3e-07 sb=1.72e-06 sd=160n sca=23.279 \
        scb=0.0230742 scc=0.00267719 m=(1)
mn35 (net606 \3\:mout \31\:VSS VSS) g45n1hvt w=(1.45e-07) l=4.5e-08 nf=1 \
        as=6.73e-14 ad=8.7e-15 ps=1.32e-06 pd=4.1e-07 nrd=1.16667 \
        nrs=1.16667 sa=6.35e-07 sb=1.615e-06 sd=160n sca=23.279 \
        scb=0.0230742 scc=0.00267719 m=(1)
mn30 (\8\:mout \3\:n20 \31\:VSS VSS) g45n1hvt w=(1.45e-07) l=4.5e-08 \
        nf=1 as=6.73e-14 ad=6.235e-14 ps=1.32e-06 pd=1.15e-06 nrd=1.16667 \
        nrs=1.16667 sa=9e-07 sb=1.35e-06 sd=160n sca=23.279 scb=0.0230742 \
        scc=0.00267719 m=(1)
mn40 (\5\:n30 \7\:CKbb \8\:mout VSS) g45n1hvt w=(1.45e-07) l=4.5e-08 nf=1 \
        as=6.235e-14 ad=4.422e-14 ps=1.15e-06 pd=9e-07 nrd=1.16667 \
        nrs=1.16667 sa=1.375e-06 sb=8.75e-07 sd=160n sca=23.279 \
        scb=0.0230742 scc=0.00267719 m=(1)
mn51 (\5\:n30 \11\:CKb net618 VSS) g45n1hvt w=(1.45e-07) l=4.5e-08 nf=1 \
        as=8.7e-15 ad=4.422e-14 ps=4.1e-07 pd=9e-07 nrd=1.16667 \
        nrs=1.16667 sa=1.725e-06 sb=5.25e-07 sd=160n sca=23.279 \
        scb=0.0230742 scc=0.00267719 m=(1)
mn50 (net618 qbint \29\:VSS VSS) g45n1hvt w=(1.45e-07) l=4.5e-08 nf=1 \
        as=4.63e-14 ad=8.7e-15 ps=9.2e-07 pd=4.1e-07 nrd=1.16667 \
        nrs=1.16667 sa=1.83e-06 sb=4.2e-07 sd=160n sca=23.279 \
        scb=0.0230742 scc=0.00267719 m=(1)
mn20 (\13\:CKb \1\:CK \9\:VSS VSS) g45n1hvt w=(1.45e-07) l=4.5e-08 nf=1 \
        as=8.385e-14 ad=2.03e-14 ps=1.5e-06 pd=5.7e-07 nrd=1.16667 \
        nrs=1.16667 sa=1.4e-07 sb=1.345e-06 sd=160n sca=16.2011 \
        scb=0.0172667 scc=0.0012292 m=(1)
mn56 (\7\:net582 \11\:qbint \9\:VSS VSS) g45n1hvt w=(1.45e-07) l=4.5e-08 \
        nf=1 as=8.385e-14 ad=2.03e-14 ps=1.5e-06 pd=5.7e-07 nrd=1.16667 \
        nrs=1.16667 sa=1.345e-06 sb=1.4e-07 sd=160n sca=16.2011 \
        scb=0.0172667 scc=0.0012292 m=(1)
mn2 (\4\:RNb \3\:RN \17\:VSS VSS) g45n1hvt w=(1.45e-07) l=4.5e-08 nf=1 \
        as=8.41e-14 ad=2.03e-14 ps=1.6e-06 pd=5.7e-07 nrd=1.16667 \
        nrs=1.16667 sa=1.4e-07 sb=7.95e-07 sd=160n sca=23.279 \
        scb=0.0230742 scc=0.00267719 m=(1)
mn3 (\13\:Dp \3\:RNb \17\:VSS VSS) g45n1hvt w=(1.45e-07) l=4.5e-08 nf=1 \
        as=8.41e-14 ad=2.32e-14 ps=1.6e-06 pd=6.1e-07 nrd=1.16667 \
        nrs=1.16667 sa=4.05e-07 sb=5.3e-07 sd=160n sca=23.279 \
        scb=0.0230742 scc=0.00267719 m=(1)
mn5 (\13\:Dp \14\:qbint net634 VSS) g45n1hvt w=(1.45e-07) l=4.5e-08 nf=1 \
        as=1.595e-14 ad=2.32e-14 ps=5.1e-07 pd=6.1e-07 nrd=1.16667 \
        nrs=1.16667 sa=6.1e-07 sb=3.25e-07 sd=160n sca=23.279 \
        scb=0.0230742 scc=0.00267719 m=(1)
mn4 (net634 \3\:Eb \15\:VSS VSS) g45n1hvt w=(1.45e-07) l=4.5e-08 nf=1 \
        as=5.345e-14 ad=1.595e-14 ps=1.11e-06 pd=5.1e-07 nrd=1.16667 \
        nrs=1.16667 sa=7.65e-07 sb=1.7e-07 sd=160n sca=23.279 \
        scb=0.0230742 scc=0.00267719 m=(1)
mn6 (net638 \1\:E \13\:VSS VSS) g45n1hvt w=(1.45e-07) l=4.5e-08 nf=1 \
        as=4.565e-14 ad=1.45e-14 ps=9.8e-07 pd=4.9e-07 nrd=1.16667 \
        nrs=1.16667 sa=1.7e-07 sb=2.85e-07 sd=160n sca=17.8702 \
        scb=0.0189183 scc=0.00156031 m=(1)
mn7 (\9\:Dp Db net638 VSS) g45n1hvt w=(1.45e-07) l=4.5e-08 nf=1 \
        as=1.45e-14 ad=2.03e-14 ps=4.9e-07 pd=5.7e-07 nrd=1.16667 \
        nrs=1.16667 sa=3.15e-07 sb=1.4e-07 sd=160n sca=17.8702 \
        scb=0.0189183 scc=0.00156031 m=(1)
mn0 (\5\:Eb \7\:E \1\:VSS VSS) g45n1hvt w=(1.45e-07) l=4.5e-08 nf=1 \
        as=2.32e-14 ad=2.03e-14 ps=6.1e-07 pd=5.7e-07 nrd=1.16667 \
        nrs=1.16667 sa=1.4e-07 sb=3.45e-07 sd=160n sca=11.1906 \
        scb=0.0108717 scc=0.000387468 m=(1)
mn1 (\4\:Db \1\:D \1\:VSS VSS) g45n1hvt w=(1.45e-07) l=4.5e-08 nf=1 \
        as=2.32e-14 ad=2.03e-14 ps=6.1e-07 pd=5.7e-07 nrd=1.16667 \
        nrs=1.16667 sa=3.45e-07 sb=1.4e-07 sd=160n sca=11.1906 \
        scb=0.0108717 scc=0.000387468 m=(1)
mn45 (\19\:qbint n30 \29\:VSS VSS) g45n1hvt w=(2.05e-07) l=4.5e-08 nf=1 \
        as=4.63e-14 ad=3.178e-14 ps=9.2e-07 pd=7.2e-07 nrd=1.16667 \
        nrs=1.16667 sa=1.46439e-06 sb=1.55e-07 sd=160n sca=19.867 \
        scb=0.0198061 scc=0.00201945 m=(1)
mn55_1__rcx (\4\:Q \4\:qbint \9\:VSS VSS) g45n1hvt w=(2.6e-07) l=4.5e-08 \
        nf=1 as=8.672e-14 ad=4.16e-14 ps=1.5e-06 pd=8.4e-07 nrd=1.16667 \
        nrs=1.16667 sa=3.01058e-07 sb=9.76058e-07 sd=160n sca=12.8392 \
        scb=0.0126987 scc=0.00074151 m=(2)
mn57 (\1\:QN net582 \9\:VSS VSS) g45n1hvt w=(2.6e-07) l=4.5e-08 nf=1 \
        as=8.672e-14 ad=4.16e-14 ps=1.5e-06 pd=8.4e-07 nrd=1.16667 \
        nrs=1.16667 sa=7.71058e-07 sb=5.06058e-07 sd=160n sca=12.8392 \
        scb=0.0126987 scc=0.00074151 m=(2)
mp45 (\21\:qbint \3\:n30 \24\:VDD VDD) g45p1hvt w=(3.1e-07) l=4.5e-08 \
        nf=1 as=8.663e-14 ad=4.34e-14 ps=2.05e-06 pd=9e-07 nrd=1.16667 \
        nrs=1.16667 sa=1.0121e-06 sb=1.4e-07 sd=160n sca=35.6995 \
        scb=0.0234062 scc=0.00420468 m=(1)
mp55_1__rcx (\2\:Q \4\:qbint \7\:VDD VDD) g45p1hvt w=(3.9e-07) l=4.5e-08 \
        nf=1 as=1.1743e-13 ad=6.24e-14 ps=1.82e-06 pd=1.1e-06 nrd=1.16667 \
        nrs=1.16667 sa=2.99551e-07 sb=9.14103e-07 sd=160n sca=30.5009 \
        scb=0.0202006 scc=0.00336097 m=(2)
mp57_1__rcx (\4\:QN net582 \7\:VDD VDD) g45p1hvt w=(3.9e-07) l=4.5e-08 \
        nf=1 as=9.984e-14 ad=6.24e-14 ps=1.855e-06 pd=1.1e-06 nrd=1.16667 \
        nrs=1.16667 sa=7.69551e-07 sb=4.44103e-07 sd=160n sca=30.5009 \
        scb=0.0202006 scc=0.00336097 m=(2)
ends SEDFFTRX2
// End of subcircuit definition.
