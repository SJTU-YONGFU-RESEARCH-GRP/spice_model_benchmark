// Generated for: spectre (May  1 09:17:59 2013 )
// Library name: gsclib045_hvt
// Cell name: NOR2BX4
// View name: extracted

simulator lang=spectre

subckt NOR2BX4 AN B VDD VSS Y
mp1_1__rcx (2 net76 \9\:VDD VDD) g45p1hvt w=(3.9e-07) l=4.5e-08 nf=1 \
        as=5.46e-14 ad=4.485e-14 ps=1.06e-06 pd=1.01e-06 nrd=1.16667 \
        nrs=1.16667 sa=1.4e-07 sb=1.52058e-06 sd=160n sca=23.4161 \
        scb=0.0245802 scc=0.00154433 m=(1)
mp2_1__rcx (\11\:Y \5\:B 2 VDD) g45p1hvt w=(3.9e-07) l=4.5e-08 nf=1 \
        as=4.485e-14 ad=6.24e-14 ps=1.01e-06 pd=1.1e-06 nrd=1.16667 \
        nrs=1.16667 sa=3e-07 sb=1.36058e-06 sd=160n sca=19.4464 \
        scb=0.0177092 scc=0.0012961 m=(1)
mp2_2__rcx (\11\:Y \1\:B 5 VDD) g45p1hvt w=(3.9e-07) l=4.5e-08 nf=1 \
        as=2.34e-14 ad=6.24e-14 ps=9e-07 pd=1.1e-06 nrd=1.16667 \
        nrs=1.16667 sa=5.05e-07 sb=1.15558e-06 sd=160n sca=17.6679 \
        scb=0.0153903 scc=0.00128092 m=(1)
mp1_2__rcx (5 \8\:net76 \7\:VDD VDD) g45p1hvt w=(3.9e-07) l=4.5e-08 nf=1 \
        as=6.24e-14 ad=2.34e-14 ps=1.1e-06 pd=9e-07 nrd=1.16667 \
        nrs=1.16667 sa=6.1e-07 sb=1.05058e-06 sd=160n sca=17.2206 \
        scb=0.0150864 scc=0.00128061 m=(1)
mp1_3__rcx (4 \9\:net76 \7\:VDD VDD) g45p1hvt w=(3.9e-07) l=4.5e-08 nf=1 \
        as=6.24e-14 ad=2.34e-14 ps=1.1e-06 pd=9e-07 nrd=1.16667 \
        nrs=1.16667 sa=8.15e-07 sb=8.45577e-07 sd=160n sca=16.7336 \
        scb=0.0149207 scc=0.00128056 m=(1)
mp2_3__rcx (\13\:Y \10\:B 4 VDD) g45p1hvt w=(3.9e-07) l=4.5e-08 nf=1 \
        as=2.34e-14 ad=6.24e-14 ps=9e-07 pd=1.1e-06 nrd=1.16667 \
        nrs=1.16667 sa=9.2e-07 sb=7.40577e-07 sd=160n sca=16.7336 \
        scb=0.0149207 scc=0.00128056 m=(1)
mp2 (\13\:Y \12\:B 6 VDD) g45p1hvt w=(3.9e-07) l=4.5e-08 nf=1 as=8.19e-14 \
        ad=6.24e-14 ps=1.2e-06 pd=1.1e-06 nrd=1.16667 nrs=1.16667 \
        sa=1.125e-06 sb=5.35577e-07 sd=160n sca=16.8346 scb=0.0149419 \
        scc=0.00128056 m=(1)
mp1 (6 \12\:net76 \1\:VDD VDD) g45p1hvt w=(3.9e-07) l=4.5e-08 nf=1 \
        as=6.535e-14 ad=8.19e-14 ps=1.16e-06 pd=1.2e-06 nrd=1.16667 \
        nrs=1.16667 sa=1.38e-06 sb=2.80577e-07 sd=160n sca=17.721 \
        scb=0.0154359 scc=0.00128099 m=(1)
C1 (AN VSS) capacitor c=4.09176e-17
C2 (Y VSS) capacitor c=7.17236e-18
C3 (VDD VSS) capacitor c=1.0681e-16
C4 (B VSS) capacitor c=4.3874e-16
C5 (net76 VSS) capacitor c=5.44231e-17
C6 (2 VSS) capacitor c=4.48317e-18
C7 (5 VSS) capacitor c=1.94645e-18
C8 (4 VSS) capacitor c=1.94645e-18
C9 (6 VSS) capacitor c=3.77711e-18
C10 (\3\:AN VSS) capacitor c=3.198e-17
C11 (\12\:net76 VSS) capacitor c=6.44655e-17
C12 (\12\:B VSS) capacitor c=2.70266e-17
C13 (\10\:B VSS) capacitor c=6.1707e-17
C14 (\9\:net76 VSS) capacitor c=7.42086e-17
C15 (\8\:net76 VSS) capacitor c=6.74881e-17
C16 (\1\:B VSS) capacitor c=5.922e-17
C17 (\5\:B VSS) capacitor c=4.90423e-17
C18 (\1\:AN VSS) capacitor c=5.26487e-17
C19 (\2\:AN VSS) capacitor c=3.47803e-17
C20 (\2\:net76 VSS) capacitor c=5.50268e-16
C21 (\13\:net76 VSS) capacitor c=3.68902e-17
C22 (\1\:VDD VSS) capacitor c=3.70622e-17
C23 (\13\:Y VSS) capacitor c=8.56498e-17
C24 (\7\:VDD VSS) capacitor c=3.80887e-17
C25 (\11\:Y VSS) capacitor c=2.89097e-17
C26 (\9\:VDD VSS) capacitor c=2.52661e-17
C27 (\16\:net76 VSS) capacitor c=2.66643e-17
C28 (\1\:Y VSS) capacitor c=3.26362e-16
C29 (\7\:net76 VSS) capacitor c=3.8779e-17
C30 (\9\:Y VSS) capacitor c=6.46343e-17
C31 (\10\:Y VSS) capacitor c=9.47407e-17
C32 (\4\:AN VSS) capacitor c=6.17692e-17
C33 (\15\:net76 VSS) capacitor c=3.56085e-17
C34 (\4\:VDD VSS) capacitor c=2.49925e-17
C35 (\5\:VDD VSS) capacitor c=1.49743e-17
C36 (\6\:VDD VSS) capacitor c=1.22083e-17
Rk11 (\4\:AN AN) resistor r=0.2087 c=0
Rk7 (\9\:Y Y) resistor r=0.003666 c=0
Rk6 (\1\:Y \9\:Y) resistor r=0.4045 c=0
Rk8 (\9\:Y \10\:Y) resistor r=0.4753 c=0
Rk9 (\10\:Y \12\:Y) resistor r=0.08564 c=0
Rk10 (\10\:Y \14\:Y) resistor r=0.5644 c=0
Rk26 (\2\:VDD \4\:VDD) resistor r=0.527 c=0
Rk27 (\4\:VDD \5\:VDD) resistor r=0.1126 c=0
Rk29 (\6\:VDD VDD) resistor r=0.04967 c=0
Rk28 (\5\:VDD \6\:VDD) resistor r=0.3379 c=0
Rk30 (\5\:VDD \8\:VDD) resistor r=0.2525 c=0
Rk31 (\6\:VDD \10\:VDD) resistor r=0.2525 c=0
Rk14 (\15\:net76 \2\:net76) resistor r=0.2148 c=0
Rk12 (\14\:net76 \15\:net76) resistor r=0.2592 c=0
Rk13 (\15\:net76 \17\:net76) resistor r=0.1285 c=0
Rl21 (\2\:AN \3\:AN) resistor r=24.2328 c=0
Rl20 (\1\:AN \2\:AN) resistor r=112.26 c=0
Rl17 (B \12\:B) resistor r=49.5541 c=0
Rl15 (B \10\:B) resistor r=52.4625 c=0
Rl3 (B \1\:B) resistor r=30.5643 c=0
Rl6 (B \5\:B) resistor r=82.6695 c=0
Rl19 (\2\:net76 \12\:net76) resistor r=94.0258 c=0
Rl1 (\2\:net76 net76) resistor r=97.3098 c=0
Rl12 (\7\:net76 \9\:net76) resistor r=117.766 c=0
Rl11 (\7\:net76 \8\:net76) resistor r=94.6893 c=0
Rl10 (\7\:net76 \2\:net76) resistor r=4.0691 c=0
Rz5 (\17\:net76 \16\:net76) resistor r=75 c=0
Ry1 (\12\:Y \11\:Y) resistor r=20.6667 c=0
Ry2 (\14\:Y \13\:Y) resistor r=20.6667 c=0
Ry5 (\1\:VDD \2\:VDD) resistor r=62 c=0
Ry6 (\7\:VDD \8\:VDD) resistor r=62 c=0
Ry7 (\9\:VDD \10\:VDD) resistor r=62 c=0
Ry3 (\14\:net76 \13\:net76) resistor r=62 c=0
Rx3 (\2\:AN \4\:AN) resistor r=45 c=0
mn1_1__rcx (\1\:Y \2\:net76 VSS VSS) g45n1hvt w=(2.6e-07) l=4.5e-08 nf=1 \
        as=3.858e-14 ad=4.16e-14 ps=8.3e-07 pd=8.4e-07 nrd=1.16667 \
        nrs=1.16667 sa=1.4e-07 sb=1.67163e-06 sd=160n sca=10.104 \
        scb=0.00906063 scc=0.000325539 m=(4)
mn2_1__rcx (\1\:Y B VSS VSS) g45n1hvt w=(2.6e-07) l=4.5e-08 nf=1 \
        as=4.16e-14 ad=4.16e-14 ps=8.4e-07 pd=8.4e-07 nrd=1.16667 \
        nrs=1.16667 sa=3.45e-07 sb=1.46663e-06 sd=160n sca=10.104 \
        scb=0.00906063 scc=0.000325539 m=(4)
mn0 (\16\:net76 \1\:AN VSS VSS) g45n1hvt w=(1.45e-07) l=4.5e-08 nf=1 \
        as=3.47e-14 ad=2.03e-14 ps=8.4e-07 pd=5.7e-07 nrd=1.16667 \
        nrs=1.16667 sa=1.78e-06 sb=1.4e-07 sd=160n sca=12.2839 \
        scb=0.0124725 scc=0.000542081 m=(1)
mp0 (\13\:net76 \3\:AN \1\:VDD VDD) g45p1hvt w=(2.15e-07) l=4.5e-08 nf=1 \
        as=6.535e-14 ad=3.44e-14 ps=1.16e-06 pd=7.5e-07 nrd=1.16667 \
        nrs=1.16667 sa=1.615e-06 sb=1.6e-07 sd=160n sca=25.3293 \
        scb=0.0247188 scc=0.0022828 m=(1)
ends NOR2BX4
// End of subcircuit definition.
