// Generated for: spectre (May  1 11:30:13 2013 )
// Library name: gsclib045_backbias
// Cell name: NAND2BX4
// View name: extracted

simulator lang=spectre

subckt NAND2BX4 AN B NW VDD VSS Y
mp0 (\14\:n0 \1\:AN VDD NW) g45p1svt w=(3.9e-07) l=4.5e-08 nf=1 \
        as=6.24e-14 ad=5.46e-14 ps=1.1e-06 pd=1.06e-06 nrd=1.16667 \
        nrs=1.16667 sa=1.78e-06 sb=1.4e-07 sd=160n sca=16.1834 \
        scb=0.0159482 scc=0.0003331 m=(1)
mp1_1__rcx (\1\:Y \2\:n0 VDD NW) g45p1svt w=(3.9e-07) l=4.5e-08 nf=1 \
        as=6.045e-14 ad=6.24e-14 ps=1.09e-06 pd=1.1e-06 nrd=1.16667 \
        nrs=1.16667 sa=1.4e-07 sb=1.78e-06 sd=160n sca=25.0495 \
        scb=0.0285542 scc=0.00163822 m=(4)
mp2_1__rcx (\1\:Y \3\:B VDD NW) g45p1svt w=(3.9e-07) l=4.5e-08 nf=1 \
        as=6.24e-14 ad=6.24e-14 ps=1.1e-06 pd=1.1e-06 nrd=1.16667 \
        nrs=1.16667 sa=3.45e-07 sb=1.575e-06 sd=160n sca=15.0157 \
        scb=0.0138815 scc=0.000273597 m=(4)
C1 (B VSS) capacitor c=5.4045e-17
C2 (Y VSS) capacitor c=2.25105e-16
C3 (NW VSS) capacitor c=3.0979e-16
C4 (AN VSS) capacitor c=3.23545e-17
C5 (VDD VSS) capacitor c=5.27307e-16
C6 (n0 VSS) capacitor c=5.9511e-17
C7 (\1\:AN VSS) capacitor c=4.84101e-17
C8 (\3\:AN VSS) capacitor c=4.98638e-17
C9 (\13\:n0 VSS) capacitor c=5.93722e-17
C10 (\7\:B VSS) capacitor c=7.48486e-17
C11 (\11\:B VSS) capacitor c=5.22968e-17
C12 (\4\:n0 VSS) capacitor c=5.3245e-17
C13 (\7\:n0 VSS) capacitor c=5.7331e-17
C14 (\1\:B VSS) capacitor c=7.3561e-17
C15 (\5\:B VSS) capacitor c=5.31517e-17
C16 (\2\:AN VSS) capacitor c=6.15612e-17
C17 (\3\:B VSS) capacitor c=4.62809e-16
C18 (\2\:n0 VSS) capacitor c=8.72853e-16
C19 (\14\:n0 VSS) capacitor c=8.15397e-17
C20 (\1\:Y VSS) capacitor c=6.56232e-16
C21 (\20\:n0 VSS) capacitor c=5.84815e-17
C22 (\15\:Y VSS) capacitor c=1.07766e-16
C23 (\9\:Y VSS) capacitor c=3.95146e-17
C24 (\2\:B VSS) capacitor c=4.34022e-17
C25 (\8\:B VSS) capacitor c=4.0721e-17
C26 (\8\:Y VSS) capacitor c=1.34454e-16
C27 (\5\:AN VSS) capacitor c=5.27492e-17
Rk2 (\3\:B B) resistor r=0.14 c=0
Rk29 (\2\:VSS \4\:VSS) resistor r=0.5225 c=0
Rk30 (\4\:VSS \5\:VSS) resistor r=0.03749 c=0
Rk32 (\6\:VSS VSS) resistor r=0.1528 c=0
Rk31 (\5\:VSS \6\:VSS) resistor r=0.3112 c=0
Rk33 (\5\:VSS \8\:VSS) resistor r=0.2304 c=0
Rk34 (\6\:VSS \10\:VSS) resistor r=0.2304 c=0
Rk4 (\1\:Y Y) resistor r=1.5894 c=0
Rk8 (Y \8\:Y) resistor r=0.4932 c=0
Rk9 (\8\:Y \10\:Y) resistor r=0.1197 c=0
Rk12 (\8\:Y \16\:Y) resistor r=0.674 c=0
Rk18 (\4\:AN \5\:AN) resistor r=0.003261 c=0
Rk19 (\6\:AN AN) resistor r=0.003261 c=0
Rk20 (\5\:AN \6\:AN) resistor r=0.0634 c=0
Rk13 (\15\:n0 \2\:n0) resistor r=0.6816 c=0
Rk17 (\2\:n0 \21\:n0) resistor r=0.3785 c=0
Rl3 (\2\:B \1\:B) resistor r=125.426 c=0
Rl6 (\2\:B \5\:B) resistor r=60.772 c=0
Rl4 (\2\:B \3\:B) resistor r=89.4132 c=0
Rl14 (\8\:B \7\:B) resistor r=125.426 c=0
Rl17 (\8\:B \11\:B) resistor r=60.772 c=0
Rl15 (\8\:B \3\:B) resistor r=90.7162 c=0
Rl21 (\1\:AN \2\:AN) resistor r=96.0237 c=0
Rl22 (\2\:AN \3\:AN) resistor r=106.613 c=0
Rl20 (\2\:n0 \13\:n0) resistor r=33.7912 c=0
Rl8 (\2\:n0 \4\:n0) resistor r=61.5385 c=0
Rl10 (\2\:n0 \7\:n0) resistor r=92.6161 c=0
Rl1 (\2\:n0 n0) resistor r=64.2323 c=0
Rz4 (\1\:VSS \2\:VSS) resistor r=37.5 c=0
Rz5 (\7\:VSS \8\:VSS) resistor r=37.5 c=0
Rz6 (\9\:VSS \10\:VSS) resistor r=37.5 c=0
Rz1 (\10\:Y \9\:Y) resistor r=37.5 c=0
Rz2 (\16\:Y \15\:Y) resistor r=37.5 c=0
Rz3 (\21\:n0 \20\:n0) resistor r=37.5 c=0
Ry5 (\15\:n0 \14\:n0) resistor r=20.6667 c=0
Rx6 (\2\:AN \4\:AN) resistor r=45 c=0
mn1_1__rcx (7 n0 \9\:VSS VSS) g45n1svt w=(2.6e-07) l=4.5e-08 nf=1 \
        as=3.64e-14 ad=1.56e-14 ps=8e-07 pd=6.4e-07 nrd=1.16667 \
        nrs=1.16667 sa=1.4e-07 sb=1.38e-06 sd=160n sca=8.36684 \
        scb=0.00633377 scc=0.000139167 m=(1)
mn2_1__rcx (\9\:Y \5\:B 7 VSS) g45n1svt w=(2.6e-07) l=4.5e-08 nf=1 \
        as=1.56e-14 ad=4.16e-14 ps=6.4e-07 pd=8.4e-07 nrd=1.16667 \
        nrs=1.16667 sa=2.45e-07 sb=1.275e-06 sd=160n sca=8.36684 \
        scb=0.00633377 scc=0.000139167 m=(1)
mn2_2__rcx (\9\:Y \1\:B 8 VSS) g45n1svt w=(2.6e-07) l=4.5e-08 nf=1 \
        as=1.56e-14 ad=4.16e-14 ps=6.4e-07 pd=8.4e-07 nrd=1.16667 \
        nrs=1.16667 sa=4.5e-07 sb=1.07e-06 sd=160n sca=8.36684 \
        scb=0.00633377 scc=0.000139167 m=(1)
mn1_2__rcx (8 \7\:n0 \7\:VSS VSS) g45n1svt w=(2.6e-07) l=4.5e-08 nf=1 \
        as=4.16e-14 ad=1.56e-14 ps=8.4e-07 pd=6.4e-07 nrd=1.16667 \
        nrs=1.16667 sa=5.55e-07 sb=9.65e-07 sd=160n sca=8.36684 \
        scb=0.00633377 scc=0.000139167 m=(1)
mn1_3__rcx (9 \4\:n0 \7\:VSS VSS) g45n1svt w=(2.6e-07) l=4.5e-08 nf=1 \
        as=4.16e-14 ad=1.56e-14 ps=8.4e-07 pd=6.4e-07 nrd=1.16667 \
        nrs=1.16667 sa=7.6e-07 sb=7.6e-07 sd=160n sca=8.36684 \
        scb=0.00633377 scc=0.000139167 m=(1)
mn2_3__rcx (\15\:Y \11\:B 9 VSS) g45n1svt w=(2.6e-07) l=4.5e-08 nf=1 \
        as=1.56e-14 ad=4.16e-14 ps=6.4e-07 pd=8.4e-07 nrd=1.16667 \
        nrs=1.16667 sa=8.65e-07 sb=6.55e-07 sd=160n sca=8.36684 \
        scb=0.00633377 scc=0.000139167 m=(1)
mn2 (\15\:Y \7\:B 10 VSS) g45n1svt w=(2.6e-07) l=4.5e-08 nf=1 as=1.56e-14 \
        ad=4.16e-14 ps=6.4e-07 pd=8.4e-07 nrd=1.16667 nrs=1.16667 \
        sa=1.07e-06 sb=4.5e-07 sd=160n sca=8.36684 scb=0.00633377 \
        scc=0.000139167 m=(1)
mn1 (10 \13\:n0 \1\:VSS VSS) g45n1svt w=(2.6e-07) l=4.5e-08 nf=1 \
        as=4.16e-14 ad=1.56e-14 ps=8.4e-07 pd=6.4e-07 nrd=1.16667 \
        nrs=1.16667 sa=1.175e-06 sb=3.45e-07 sd=160n sca=8.36684 \
        scb=0.00633377 scc=0.000139167 m=(1)
mn0 (\20\:n0 \3\:AN \1\:VSS VSS) g45n1svt w=(2.6e-07) l=4.5e-08 nf=1 \
        as=4.16e-14 ad=3.64e-14 ps=8.4e-07 pd=8e-07 nrd=1.16667 \
        nrs=1.16667 sa=1.38e-06 sb=1.4e-07 sd=160n sca=8.36684 \
        scb=0.00633377 scc=0.000139167 m=(1)
ends NAND2BX4
// End of subcircuit definition.
