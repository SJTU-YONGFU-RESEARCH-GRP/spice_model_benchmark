// Generated for: spectre (May  1 09:20:28 2013 )
// Library name: gsclib045_hvt
// Cell name: XOR2XL
// View name: extracted

simulator lang=spectre

subckt XOR2XL A B VDD VSS Y
mp5 (\1\:Y n0 \6\:VDD VDD) g45p1hvt w=(2.15e-07) l=4.5e-08 nf=1 \
        as=6.56e-14 ad=3.01e-14 ps=1.58e-06 pd=7.1e-07 nrd=1.16667 \
        nrs=1.16667 sa=1.4e-07 sb=1.2e-06 sd=160n sca=25.0648 \
        scb=0.0294525 scc=0.00155947 m=(1)
mp0 (\7\:n1 \1\:A \6\:VDD VDD) g45p1hvt w=(2.15e-07) l=4.5e-08 nf=1 \
        as=6.56e-14 ad=4.515e-14 ps=1.58e-06 pd=8.5e-07 nrd=1.16667 \
        nrs=1.16667 sa=3.45e-07 sb=9.95e-07 sd=160n sca=16.6712 \
        scb=0.0163973 scc=0.000573191 m=(1)
mp4 (\7\:n1 \2\:B \7\:n0 VDD) g45p1hvt w=(2.15e-07) l=4.5e-08 nf=1 \
        as=3.44e-14 ad=4.515e-14 ps=7.5e-07 pd=8.5e-07 nrd=1.16667 \
        nrs=1.16667 sa=6e-07 sb=7.4e-07 sd=160n sca=14.3602 scb=0.0131207 \
        scc=0.000544277 m=(1)
mp3 (\7\:n0 \2\:n2 net130 VDD) g45p1hvt w=(2.15e-07) l=4.5e-08 nf=1 \
        as=3.118e-14 ad=3.44e-14 ps=7.2e-07 pd=7.5e-07 nrd=1.16667 \
        nrs=1.16667 sa=8.05e-07 sb=5.35e-07 sd=160n sca=14.2892 \
        scb=0.0130359 scc=0.000544163 m=(1)
mp2 (net130 \3\:n1 \1\:VDD VDD) g45p1hvt w=(2.15e-07) l=4.5e-08 nf=1 \
        as=3.44e-14 ad=3.118e-14 ps=7.5e-07 pd=7.2e-07 nrd=1.16667 \
        nrs=1.16667 sa=9.95e-07 sb=3.45e-07 sd=160n sca=15.406 \
        scb=0.0143862 scc=0.000549226 m=(1)
mp1 (\8\:n2 \7\:B \1\:VDD VDD) g45p1hvt w=(2.15e-07) l=4.5e-08 nf=1 \
        as=3.44e-14 ad=3.01e-14 ps=7.5e-07 pd=7.1e-07 nrd=1.16667 \
        nrs=1.16667 sa=1.2e-06 sb=1.4e-07 sd=160n sca=19.4967 \
        scb=0.0213498 scc=0.00074757 m=(1)
C1 (A VSS) capacitor c=1.1759e-16
C2 (Y VSS) capacitor c=6.7797e-17
C3 (VDD VSS) capacitor c=1.44225e-16
C4 (B VSS) capacitor c=2.48947e-17
C5 (n0 VSS) capacitor c=4.51386e-17
C6 (n1 VSS) capacitor c=2.65261e-17
C7 (n2 VSS) capacitor c=6.53513e-17
C8 (net130 VSS) capacitor c=5.21894e-19
C9 (\7\:B VSS) capacitor c=3.81569e-17
C10 (\3\:n1 VSS) capacitor c=8.61236e-17
C11 (\2\:n2 VSS) capacitor c=5.88962e-17
C12 (\2\:B VSS) capacitor c=3.69731e-17
C13 (\1\:A VSS) capacitor c=4.05082e-17
C14 (\5\:B VSS) capacitor c=4.44054e-17
C15 (\4\:n1 VSS) capacitor c=4.32183e-17
C16 (\3\:B VSS) capacitor c=6.16461e-17
C17 (\3\:A VSS) capacitor c=4.3037e-17
C18 (\3\:n0 VSS) capacitor c=3.05004e-17
C19 (\6\:B VSS) capacitor c=5.98828e-17
C20 (\4\:B VSS) capacitor c=6.38834e-17
C21 (\3\:n2 VSS) capacitor c=3.31541e-17
C22 (\1\:B VSS) capacitor c=3.92003e-17
C23 (\2\:A VSS) capacitor c=3.99804e-17
C24 (\2\:n0 VSS) capacitor c=3.96009e-17
C25 (\8\:n2 VSS) capacitor c=1.07701e-17
C26 (\1\:VDD VSS) capacitor c=4.35438e-17
C27 (\7\:n0 VSS) capacitor c=1.24258e-16
C28 (\7\:n1 VSS) capacitor c=7.45906e-17
C29 (\6\:VDD VSS) capacitor c=1.40643e-17
C30 (\1\:Y VSS) capacitor c=5.5149e-17
C31 (\4\:n2 VSS) capacitor c=3.99556e-17
C32 (\4\:n0 VSS) capacitor c=1.17617e-16
C33 (\9\:n1 VSS) capacitor c=4.02834e-17
C34 (\3\:Y VSS) capacitor c=2.85293e-17
C35 (\2\:n1 VSS) capacitor c=5.31705e-17
C36 (\4\:A VSS) capacitor c=7.46194e-17
C37 (\6\:n0 VSS) capacitor c=2.79612e-16
C38 (\5\:n1 VSS) capacitor c=7.01948e-17
C39 (\6\:n1 VSS) capacitor c=1.00424e-16
C40 (\8\:B VSS) capacitor c=6.33122e-17
C41 (\9\:B VSS) capacitor c=4.7572e-17
C42 (\10\:B VSS) capacitor c=6.25448e-17
C43 (\6\:n2 VSS) capacitor c=1.08298e-16
C44 (\7\:n2 VSS) capacitor c=9.39191e-17
C45 (\4\:VDD VSS) capacitor c=4.29636e-17
C46 (\5\:VDD VSS) capacitor c=1.06658e-17
Rk3 (A \4\:A) resistor r=0.2701 c=0
Rk1 (\2\:Y Y) resistor r=0.2725 c=0
Rk2 (Y \4\:Y) resistor r=0.0976 c=0
Rk19 (\2\:VDD \4\:VDD) resistor r=0.5051 c=0
Rk21 (\5\:VDD VDD) resistor r=0.1276 c=0
Rk20 (\4\:VDD \5\:VDD) resistor r=0.2232 c=0
Rk22 (\5\:VDD \7\:VDD) resistor r=0.1048 c=0
Rk15 (\2\:VSS \4\:VSS) resistor r=0.5447 c=0
Rk17 (\5\:VSS VSS) resistor r=0.1125 c=0
Rk16 (\4\:VSS \5\:VSS) resistor r=0.2382 c=0
Rk18 (\5\:VSS \7\:VSS) resistor r=0.09135 c=0
Rk10 (\9\:B B) resistor r=0.06653 c=0
Rk9 (\8\:B \9\:B) resistor r=0.1615 c=0
Rk11 (B \10\:B) resistor r=0.1661 c=0
Rk4 (\5\:n0 \6\:n0) resistor r=0.8935 c=0
Rk5 (\6\:n0 \8\:n0) resistor r=0.8779 c=0
Rk6 (\5\:n1 \6\:n1) resistor r=0.4181 c=0
Rk7 (\6\:n1 \8\:n1) resistor r=0.4325 c=0
Rk8 (\6\:n1 \10\:n1) resistor r=0.09515 c=0
Rk12 (\5\:n2 \6\:n2) resistor r=0.445 c=0
Rk13 (\6\:n2 \7\:n2) resistor r=0.5898 c=0
Rk14 (\6\:n2 \9\:n2) resistor r=0.04841 c=0
Rl3 (\1\:A \2\:A) resistor r=54.5379 c=0
Rl4 (\2\:A \3\:A) resistor r=112.23 c=0
Rl13 (\6\:B \7\:B) resistor r=70.3297 c=0
Rl12 (\5\:B \6\:B) resistor r=99.7901 c=0
Rl8 (\3\:B \4\:B) resistor r=89.6174 c=0
Rl5 (\1\:B \2\:B) resistor r=30.3481 c=0
Rl1 (n0 \2\:n0) resistor r=126.156 c=0
Rl2 (\2\:n0 \3\:n0) resistor r=37.6944 c=0
Rl10 (\2\:n1 \3\:n1) resistor r=170.434 c=0
Rl11 (\2\:n1 \4\:n1) resistor r=34.3295 c=0
Rl9 (n1 \2\:n1) resistor r=2.0213 c=0
Rl6 (n2 \2\:n2) resistor r=195.27 c=0
Rl7 (\2\:n2 \3\:n2) resistor r=24.2328 c=0
Rz1 (\3\:Y \4\:Y) resistor r=75 c=0
Rz5 (\1\:VSS \2\:VSS) resistor r=75 c=0
Rz6 (\6\:VSS \7\:VSS) resistor r=75 c=0
Rz2 (\4\:n0 \5\:n0) resistor r=75 c=0
Rz3 (\9\:n1 \10\:n1) resistor r=75 c=0
Rz4 (\4\:n2 \5\:n2) resistor r=75 c=0
Ry1 (\1\:Y \2\:Y) resistor r=62 c=0
Ry6 (\1\:VDD \2\:VDD) resistor r=62 c=0
Ry7 (\6\:VDD \7\:VDD) resistor r=62 c=0
Ry2 (\7\:n0 \8\:n0) resistor r=62 c=0
Ry3 (\7\:n1 \8\:n1) resistor r=62 c=0
Ry4 (\8\:n2 \9\:n2) resistor r=62 c=0
Rx1 (\2\:A \4\:A) resistor r=45 c=0
Rx4 (\6\:B \8\:B) resistor r=45 c=0
Rx5 (\4\:B \9\:B) resistor r=45 c=0
Rx6 (\1\:B \10\:B) resistor r=45 c=0
Rx2 (\2\:n0 \6\:n0) resistor r=45 c=0
Rx3 (n1 \5\:n1) resistor r=45 c=0
Rx7 (\3\:n2 \7\:n2) resistor r=45 c=0
mn5 (\3\:Y \3\:n0 \6\:VSS VSS) g45n1hvt w=(1.45e-07) l=4.5e-08 nf=1 \
        as=5.23e-14 ad=2.03e-14 ps=1.4e-06 pd=5.7e-07 nrd=1.16667 \
        nrs=1.16667 sa=1.4e-07 sb=1.3e-06 sd=160n sca=12.2839 \
        scb=0.0124725 scc=0.000542081 m=(1)
mn0 (\9\:n1 \3\:A \6\:VSS VSS) g45n1hvt w=(1.45e-07) l=4.5e-08 nf=1 \
        as=5.23e-14 ad=5.51e-14 ps=1.4e-06 pd=1.05e-06 nrd=1.16667 \
        nrs=1.16667 sa=3.45e-07 sb=1.095e-06 sd=160n sca=12.2839 \
        scb=0.0124725 scc=0.000542081 m=(1)
mn4 (\4\:n0 n2 \9\:n1 VSS) g45n1hvt w=(1.45e-07) l=4.5e-08 nf=1 \
        as=5.51e-14 ad=2.32e-14 ps=1.05e-06 pd=6.1e-07 nrd=1.16667 \
        nrs=1.16667 sa=7.7e-07 sb=6.7e-07 sd=160n sca=12.2839 \
        scb=0.0124725 scc=0.000542081 m=(1)
mn3 (\4\:n0 \3\:B net131 VSS) g45n1hvt w=(1.45e-07) l=4.5e-08 nf=1 \
        as=1.087e-14 ad=2.32e-14 ps=4.4e-07 pd=6.1e-07 nrd=1.16667 \
        nrs=1.16667 sa=9.75e-07 sb=4.65e-07 sd=160n sca=12.2839 \
        scb=0.0124725 scc=0.000542081 m=(1)
mn2 (net131 \4\:n1 \1\:VSS VSS) g45n1hvt w=(1.45e-07) l=4.5e-08 nf=1 \
        as=2.32e-14 ad=1.087e-14 ps=6.1e-07 pd=4.4e-07 nrd=1.16667 \
        nrs=1.16667 sa=1.095e-06 sb=3.45e-07 sd=160n sca=12.2839 \
        scb=0.0124725 scc=0.000542081 m=(1)
mn1 (\4\:n2 \5\:B \1\:VSS VSS) g45n1hvt w=(1.45e-07) l=4.5e-08 nf=1 \
        as=2.32e-14 ad=2.03e-14 ps=6.1e-07 pd=5.7e-07 nrd=1.16667 \
        nrs=1.16667 sa=1.3e-06 sb=1.4e-07 sd=160n sca=12.2839 \
        scb=0.0124725 scc=0.000542081 m=(1)
ends XOR2XL
// End of subcircuit definition.
