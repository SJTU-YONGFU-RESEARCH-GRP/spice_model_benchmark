// Generated for: spectre (May  1 09:15:15 2013 )
// Library name: gsclib045_hvt
// Cell name: EDFFX2
// View name: extracted

simulator lang=spectre

subckt EDFFX2 CK D E Q QN VDD VSS
mp20 (\17\:Ckb \4\:CK \25\:VDD VDD) g45p1hvt w=(2.15e-07) l=4.5e-08 nf=1 \
        as=3.44e-14 ad=3.01e-14 ps=7.5e-07 pd=7.1e-07 nrd=1.16667 \
        nrs=1.16667 sa=1.4e-07 sb=3.45e-07 sd=160n sca=28.9181 \
        scb=0.0340412 scc=0.0022918 m=(1)
mp21 (\15\:CKbb \8\:Ckb \25\:VDD VDD) g45p1hvt w=(2.15e-07) l=4.5e-08 \
        nf=1 as=3.44e-14 ad=3.01e-14 ps=7.5e-07 pd=7.1e-07 nrd=1.16667 \
        nrs=1.16667 sa=3.45e-07 sb=1.4e-07 sd=160n sca=18.8843 \
        scb=0.0193686 scc=0.00092718 m=(1)
mp25 (\7\:n20 CKbb \5\:Db VDD) g45p1hvt w=(2.15e-07) l=4.5e-08 nf=1 \
        as=3.01e-14 ad=3.44e-14 ps=7.1e-07 pd=7.5e-07 nrd=1.16667 \
        nrs=1.16667 sa=1.4e-07 sb=1.80349e-06 sd=160n sca=45.7906 \
        scb=0.0283307 scc=0.00588417 m=(1)
mp36 (\7\:n20 \2\:Ckb net342 VDD) g45p1hvt w=(2.15e-07) l=4.5e-08 nf=1 \
        as=1.398e-14 ad=3.44e-14 ps=5.6e-07 pd=7.5e-07 nrd=1.16667 \
        nrs=1.16667 sa=3.45e-07 sb=1.67953e-06 sd=160n sca=45.7906 \
        scb=0.0283307 scc=0.00588417 m=(1)
mp35 (net342 mout \23\:VDD VDD) g45p1hvt w=(2.15e-07) l=4.5e-08 nf=1 \
        as=1.091e-13 ad=1.397e-14 ps=1.9e-06 pd=5.6e-07 nrd=1.16667 \
        nrs=1.16667 sa=4.55e-07 sb=1.59721e-06 sd=160n sca=45.7906 \
        scb=0.0283307 scc=0.00588417 m=(1)
mp30 (\8\:mout n20 \23\:VDD VDD) g45p1hvt w=(2.15e-07) l=4.5e-08 nf=1 \
        as=1.091e-13 ad=6.127e-14 ps=1.9e-06 pd=1e-06 nrd=1.16667 \
        nrs=1.16667 sa=7.2e-07 sb=1.33221e-06 sd=160n sca=45.7906 \
        scb=0.0283307 scc=0.00588417 m=(1)
mp40 (\5\:n30 \11\:Ckb \8\:mout VDD) g45p1hvt w=(2.15e-07) l=4.5e-08 nf=1 \
        as=6.127e-14 ad=3.44e-14 ps=1e-06 pd=7.5e-07 nrd=1.16667 \
        nrs=1.16667 sa=1.05e-06 sb=1.00221e-06 sd=160n sca=45.7906 \
        scb=0.0283307 scc=0.00588417 m=(1)
mp51 (\5\:n30 \7\:CKbb net362 VDD) g45p1hvt w=(2.15e-07) l=4.5e-08 nf=1 \
        as=1.29e-14 ad=3.44e-14 ps=5.5e-07 pd=7.5e-07 nrd=1.16667 \
        nrs=1.16667 sa=1.255e-06 sb=7.97209e-07 sd=160n sca=45.7906 \
        scb=0.0283307 scc=0.00588417 m=(1)
mp50 (net362 qbint \21\:VDD VDD) g45p1hvt w=(2.15e-07) l=4.5e-08 nf=1 \
        as=8.412e-14 ad=1.29e-14 ps=1.33e-06 pd=5.5e-07 nrd=1.16667 \
        nrs=1.16667 sa=1.36e-06 sb=6.92209e-07 sd=160n sca=45.7906 \
        scb=0.0283307 scc=0.00588417 m=(1)
mp1 (\23\:qbint \1\:E \3\:Db VDD) g45p1hvt w=(2.15e-07) l=4.5e-08 nf=1 \
        as=3.978e-14 ad=7.908e-14 ps=8e-07 pd=1.25e-06 nrd=1.16667 \
        nrs=1.16667 sa=1.02721e-06 sb=5.05e-07 sd=160n sca=15.2551 \
        scb=0.0150251 scc=0.000885438 m=(1)
mp3 (\3\:Db \4\:Eb n1 VDD) g45p1hvt w=(2.15e-07) l=4.5e-08 nf=1 \
        as=1.29e-14 ad=3.978e-14 ps=5.5e-07 pd=8e-07 nrd=1.16667 \
        nrs=1.16667 sa=1.20186e-06 sb=2.75e-07 sd=160n sca=15.2551 \
        scb=0.0150251 scc=0.000885438 m=(1)
mp2 (n1 \3\:D \19\:VDD VDD) g45p1hvt w=(2.15e-07) l=4.5e-08 nf=1 \
        as=6.715e-14 ad=1.29e-14 ps=1.28e-06 pd=5.5e-07 nrd=1.16667 \
        nrs=1.16667 sa=1.26535e-06 sb=1.7e-07 sd=160n sca=15.2551 \
        scb=0.0150251 scc=0.000885438 m=(1)
mp0 (\9\:Eb \5\:E \3\:VDD VDD) g45p1hvt w=(2.15e-07) l=4.5e-08 nf=1 \
        as=7.18e-14 ad=5.053e-14 ps=1.22e-06 pd=9e-07 nrd=1.16667 \
        nrs=1.16667 sa=2.35e-07 sb=1.29e-06 sd=160n sca=22.8495 \
        scb=0.0214046 scc=0.00242442 m=(1)
mp56 (\11\:qint \13\:qbint \3\:VDD VDD) g45p1hvt w=(2.15e-07) l=4.5e-08 \
        nf=1 as=6.535e-14 ad=3.01e-14 ps=1.16e-06 pd=7.1e-07 nrd=1.16667 \
        nrs=1.16667 sa=1.385e-06 sb=1.4e-07 sd=160n sca=27.7871 \
        scb=0.0280637 scc=0.00253496 m=(1)
C1 (D VSS) capacitor c=4.89768e-17
C2 (Q VSS) capacitor c=6.17462e-17
C3 (QN VSS) capacitor c=5.14574e-17
C4 (VDD VSS) capacitor c=2.99125e-16
C5 (CK VSS) capacitor c=7.75737e-17
C6 (Ckb VSS) capacitor c=3.28592e-17
C7 (CKbb VSS) capacitor c=4.44424e-17
C8 (n20 VSS) capacitor c=3.85206e-17
C9 (Db VSS) capacitor c=9.175e-17
C10 (mout VSS) capacitor c=7.5892e-17
C11 (n30 VSS) capacitor c=5.86032e-17
C12 (net415 VSS) capacitor c=1.90771e-18
C13 (qbint VSS) capacitor c=7.37011e-17
C14 (Eb VSS) capacitor c=5.58861e-17
C15 (n0 VSS) capacitor c=4.08733e-19
C16 (qint VSS) capacitor c=1.90388e-16
C17 (net342 VSS) capacitor c=7.55565e-19
C18 (net362 VSS) capacitor c=2.84036e-18
C19 (n1 VSS) capacitor c=1.5203e-18
C20 (\13\:qbint VSS) capacitor c=4.51214e-17
C21 (\4\:qbint VSS) capacitor c=5.55499e-16
C22 (\5\:E VSS) capacitor c=3.44728e-17
C23 (\3\:D VSS) capacitor c=9.26526e-17
C24 (\4\:Eb VSS) capacitor c=6.41809e-17
C25 (\1\:E VSS) capacitor c=4.2393e-17
C26 (\7\:CKbb VSS) capacitor c=7.12339e-17
C27 (\11\:Ckb VSS) capacitor c=5.27579e-17
C28 (\2\:Ckb VSS) capacitor c=8.57231e-17
C29 (\8\:Ckb VSS) capacitor c=5.26263e-17
C30 (\4\:CK VSS) capacitor c=3.54446e-17
C31 (\12\:qbint VSS) capacitor c=4.23158e-17
C32 (\7\:E VSS) capacitor c=3.91324e-17
C33 (\1\:D VSS) capacitor c=6.54145e-17
C34 (\3\:E VSS) capacitor c=5.66781e-17
C35 (\3\:Eb VSS) capacitor c=5.51961e-17
C36 (\3\:n30 VSS) capacitor c=4.58235e-17
C37 (\3\:qbint VSS) capacitor c=2.75634e-17
C38 (\10\:Ckb VSS) capacitor c=5.67935e-17
C39 (\6\:CKbb VSS) capacitor c=4.5756e-17
C40 (\4\:n20 VSS) capacitor c=4.58757e-17
C41 (\3\:mout VSS) capacitor c=5.33598e-17
C42 (\3\:CKbb VSS) capacitor c=8.50587e-17
C43 (\7\:Ckb VSS) capacitor c=3.3259e-17
C44 (\9\:Ckb VSS) capacitor c=2.58329e-17
C45 (\3\:CK VSS) capacitor c=5.94262e-17
C46 (\11\:qbint VSS) capacitor c=2.18643e-17
C47 (\6\:E VSS) capacitor c=2.99968e-17
C48 (\2\:D VSS) capacitor c=4.96697e-17
C49 (\4\:E VSS) capacitor c=5.3414e-17
C50 (\2\:E VSS) capacitor c=2.54306e-17
C51 (\2\:n30 VSS) capacitor c=2.74391e-17
C52 (\2\:qbint VSS) capacitor c=3.84825e-17
C53 (\8\:CKbb VSS) capacitor c=4.05387e-17
C54 (\12\:Ckb VSS) capacitor c=2.42566e-17
C55 (\5\:CKbb VSS) capacitor c=2.67756e-17
C56 (\3\:n20 VSS) capacitor c=1.97591e-17
C57 (\2\:mout VSS) capacitor c=4.64126e-17
C58 (\4\:CKbb VSS) capacitor c=2.81851e-17
C59 (\2\:CKbb VSS) capacitor c=4.4584e-17
C60 (\6\:Ckb VSS) capacitor c=2.61461e-17
C61 (\1\:CK VSS) capacitor c=2.46484e-17
C62 (\11\:qint VSS) capacitor c=2.53749e-17
C63 (\1\:QN VSS) capacitor c=8.98535e-17
C64 (\1\:Q VSS) capacitor c=9.26727e-17
C65 (\9\:Eb VSS) capacitor c=8.55625e-17
C66 (\19\:VDD VSS) capacitor c=3.18068e-17
C67 (\3\:Db VSS) capacitor c=2.63889e-16
C68 (\23\:qbint VSS) capacitor c=7.21698e-17
C69 (\21\:VDD VSS) capacitor c=4.65098e-17
C70 (\5\:n30 VSS) capacitor c=1.157e-16
C71 (\8\:mout VSS) capacitor c=6.3053e-17
C72 (\23\:VDD VSS) capacitor c=1.69799e-17
C73 (\7\:n20 VSS) capacitor c=3.85281e-17
C74 (\5\:Db VSS) capacitor c=2.53121e-16
C75 (\15\:CKbb VSS) capacitor c=8.04575e-17
C76 (\25\:VDD VSS) capacitor c=3.53807e-17
C77 (\17\:Ckb VSS) capacitor c=5.63668e-17
C78 (\1\:VDD VSS) capacitor c=5.06617e-17
C79 (\7\:qint VSS) capacitor c=2.56789e-17
C80 (\3\:QN VSS) capacitor c=3.35444e-17
C81 (\3\:Q VSS) capacitor c=3.75786e-17
C82 (\5\:Eb VSS) capacitor c=2.63208e-17
C83 (\17\:qbint VSS) capacitor c=1.42311e-16
C84 (\7\:n30 VSS) capacitor c=8.2179e-17
C85 (\6\:mout VSS) capacitor c=3.01222e-17
C86 (\9\:n20 VSS) capacitor c=5.75936e-17
C87 (\7\:Db VSS) capacitor c=7.87079e-17
C88 (\13\:CKbb VSS) capacitor c=1.0077e-16
C89 (\15\:Ckb VSS) capacitor c=1.97294e-17
C90 (\2\:CK VSS) capacitor c=3.01694e-17
C91 (\3\:Ckb VSS) capacitor c=6.08583e-17
C92 (\4\:Ckb VSS) capacitor c=4.30907e-17
C93 (\5\:Ckb VSS) capacitor c=1.01166e-17
C94 (\2\:n20 VSS) capacitor c=1.88959e-17
C95 (\2\:Eb VSS) capacitor c=5.46051e-17
C96 (\5\:CK VSS) capacitor c=4.4729e-17
C97 (\13\:Ckb VSS) capacitor c=4.40522e-17
C98 (\14\:Ckb VSS) capacitor c=3.84277e-17
C99 (\5\:n20 VSS) capacitor c=5.72654e-17
C100 (\6\:n20 VSS) capacitor c=4.68412e-17
C101 (\4\:mout VSS) capacitor c=4.95846e-17
C102 (\5\:mout VSS) capacitor c=4.22804e-17
C103 (\19\:Ckb VSS) capacitor c=8.37903e-17
C104 (\20\:Ckb VSS) capacitor c=8.49002e-17
C105 (\9\:CKbb VSS) capacitor c=2.61102e-17
C106 (\10\:CKbb VSS) capacitor c=1.17317e-16
C107 (\11\:CKbb VSS) capacitor c=6.15255e-17
C108 (\12\:CKbb VSS) capacitor c=5.58201e-17
C109 (\17\:CKbb VSS) capacitor c=8.33248e-17
C110 (\18\:CKbb VSS) capacitor c=7.18095e-17
C111 (\4\:n30 VSS) capacitor c=7.64809e-17
C112 (\4\:D VSS) capacitor c=6.68671e-17
C113 (\7\:Eb VSS) capacitor c=1.13463e-16
C114 (\8\:Eb VSS) capacitor c=1.00715e-16
C115 (\8\:E VSS) capacitor c=7.24044e-17
C116 (\9\:E VSS) capacitor c=1.25452e-16
C117 (\10\:E VSS) capacitor c=4.64372e-17
C118 (\11\:E VSS) capacitor c=1.4226e-16
C119 (\14\:qbint VSS) capacitor c=6.44851e-17
C120 (\19\:qbint VSS) capacitor c=4.18994e-17
C121 (\20\:qbint VSS) capacitor c=5.2874e-17
C122 (\9\:qint VSS) capacitor c=2.54003e-17
C123 (\10\:qint VSS) capacitor c=3.26566e-17
C124 (\3\:VDD VSS) capacitor c=2.61916e-16
C125 (\7\:VDD VSS) capacitor c=2.86871e-17
C126 (\8\:VDD VSS) capacitor c=3.40592e-17
C127 (\9\:VDD VSS) capacitor c=1.90485e-17
C128 (\11\:VDD VSS) capacitor c=1.29938e-17
Rk24 (D \4\:D) resistor r=0.09311 c=0
Rk32 (\2\:Q Q) resistor r=0.3614 c=0
Rk33 (Q \4\:Q) resistor r=0.06696 c=0
Rk47 (\2\:VSS \3\:VSS) resistor r=0.05404 c=0
Rk50 (\3\:VSS \6\:VSS) resistor r=0.2146 c=0
Rk51 (\6\:VSS \7\:VSS) resistor r=0.1218 c=0
Rk52 (\7\:VSS \8\:VSS) resistor r=0.4853 c=0
Rk53 (\8\:VSS \9\:VSS) resistor r=0.4702 c=0
Rk54 (\9\:VSS \10\:VSS) resistor r=0.1218 c=0
Rk56 (\11\:VSS VSS) resistor r=0.08734 c=0
Rk55 (\10\:VSS \11\:VSS) resistor r=0.4638 c=0
Rk60 (\7\:VSS \19\:VSS) resistor r=0.04332 c=0
Rk61 (\8\:VSS \21\:VSS) resistor r=0.2651 c=0
Rk62 (\9\:VSS \23\:VSS) resistor r=0.04332 c=0
Rk63 (\11\:VSS \25\:VSS) resistor r=0.1803 c=0
Rk34 (\2\:QN QN) resistor r=0.3684 c=0
Rk35 (QN \4\:QN) resistor r=0.07892 c=0
Rk64 (\2\:VDD \3\:VDD) resistor r=0.09261 c=0
Rk67 (\3\:VDD \6\:VDD) resistor r=0.2306 c=0
Rk68 (\6\:VDD \7\:VDD) resistor r=0.198 c=0
Rk69 (\7\:VDD \8\:VDD) resistor r=0.4411 c=0
Rk70 (\8\:VDD \9\:VDD) resistor r=0.4401 c=0
Rk71 (\9\:VDD \10\:VDD) resistor r=0.1218 c=0
Rk73 (\11\:VDD VDD) resistor r=0.1024 c=0
Rk72 (\10\:VDD \11\:VDD) resistor r=0.4488 c=0
Rk78 (\7\:VDD \20\:VDD) resistor r=0.1563 c=0
Rk79 (\8\:VDD \22\:VDD) resistor r=0.2634 c=0
Rk80 (\9\:VDD \24\:VDD) resistor r=0.04332 c=0
Rk81 (\11\:VDD \26\:VDD) resistor r=0.3317 c=0
Rk1 (\5\:CK CK) resistor r=0.009896 c=0
Rk30 (\9\:E E) resistor r=0.9201 c=0
Rk28 (\8\:E \9\:E) resistor r=0.4126 c=0
Rk29 (\9\:E \10\:E) resistor r=0.2656 c=0
Rk31 (E \11\:E) resistor r=0.01024 c=0
Rk2 (\13\:Ckb \14\:Ckb) resistor r=0.1577 c=0
Rk3 (\14\:Ckb \16\:Ckb) resistor r=0.1183 c=0
Rk4 (\14\:Ckb \18\:Ckb) resistor r=0.4309 c=0
Rk11 (\19\:Ckb \20\:Ckb) resistor r=0.4206 c=0
Rk12 (\9\:CKbb \10\:CKbb) resistor r=0.03538 c=0
Rk13 (\10\:CKbb \11\:CKbb) resistor r=0.5838 c=0
Rk14 (\11\:CKbb \12\:CKbb) resistor r=0.09782 c=0
Rk15 (\12\:CKbb \14\:CKbb) resistor r=0.2801 c=0
Rk16 (\14\:CKbb \16\:CKbb) resistor r=0.588 c=0
Rk17 (\10\:CKbb \17\:CKbb) resistor r=0.5166 c=0
Rk18 (\12\:CKbb \18\:CKbb) resistor r=0.3366 c=0
Rk5 (\5\:n20 \6\:n20) resistor r=0.2661 c=0
Rk6 (\6\:n20 \8\:n20) resistor r=0.07753 c=0
Rk7 (\6\:n20 \10\:n20) resistor r=0.2567 c=0
Rk21 (\2\:Db \4\:Db) resistor r=0.5172 c=0
Rk22 (\4\:Db \6\:Db) resistor r=1.5614 c=0
Rk23 (\6\:Db \8\:Db) resistor r=0.4526 c=0
Rk8 (\4\:mout \5\:mout) resistor r=0.2397 c=0
Rk9 (\5\:mout \7\:mout) resistor r=0.07152 c=0
Rk10 (\5\:mout \9\:mout) resistor r=0.2656 c=0
Rk19 (\4\:n30 \6\:n30) resistor r=0.4558 c=0
Rk20 (\6\:n30 \8\:n30) resistor r=0.4297 c=0
Rk36 (\14\:qbint \4\:qbint) resistor r=0.5168 c=0
Rk38 (\4\:qbint \18\:qbint) resistor r=1.1352 c=0
Rk39 (\18\:qbint \19\:qbint) resistor r=0.1491 c=0
Rk40 (\19\:qbint \20\:qbint) resistor r=0.2199 c=0
Rk43 (\19\:qbint \24\:qbint) resistor r=0.2879 c=0
Rk25 (\6\:Eb \7\:Eb) resistor r=0.07551 c=0
Rk26 (\7\:Eb \8\:Eb) resistor r=0.5 c=0
Rk27 (\7\:Eb \10\:Eb) resistor r=0.4461 c=0
Rk44 (\8\:qint \9\:qint) resistor r=0.1706 c=0
Rk45 (\9\:qint \10\:qint) resistor r=0.1518 c=0
Rk46 (\9\:qint \12\:qint) resistor r=0.2338 c=0
Rl33 (\2\:D \3\:D) resistor r=218.029 c=0
Rl32 (\1\:D \2\:D) resistor r=101.477 c=0
Rl3 (\2\:CK \4\:CK) resistor r=70.868 c=0
Rl2 (\2\:CK \3\:CK) resistor r=167.022 c=0
Rl1 (\1\:CK \2\:CK) resistor r=1.2713 c=0
Rl34 (\5\:E \6\:E) resistor r=37.2302 c=0
Rl35 (\6\:E \7\:E) resistor r=79.5379 c=0
Rl28 (\3\:E \4\:E) resistor r=47.8762 c=0
Rl27 (\1\:E \2\:E) resistor r=66.5405 c=0
Rl20 (\10\:Ckb \11\:Ckb) resistor r=143.429 c=0
Rl21 (\11\:Ckb \12\:Ckb) resistor r=50.6918 c=0
Rl5 (Ckb \2\:Ckb) resistor r=47.2519 c=0
Rl6 (\2\:Ckb \3\:Ckb) resistor r=184.159 c=0
Rl10 (\3\:Ckb \7\:Ckb) resistor r=30.4507 c=0
Rl11 (\4\:Ckb \8\:Ckb) resistor r=145.387 c=0
Rl7 (\3\:Ckb \4\:Ckb) resistor r=181.607 c=0
Rl12 (\5\:Ckb \9\:Ckb) resistor r=34.3295 c=0
Rl9 (\5\:Ckb \6\:Ckb) resistor r=2.0166 c=0
Rl8 (\4\:Ckb \5\:Ckb) resistor r=54.7169 c=0
Rl22 (\7\:CKbb \8\:CKbb) resistor r=24.2328 c=0
Rl19 (\5\:CKbb \6\:CKbb) resistor r=72.2327 c=0
Rl13 (\3\:CKbb \4\:CKbb) resistor r=48.7697 c=0
Rl4 (CKbb \2\:CKbb) resistor r=31.9251 c=0
Rl16 (n20 \2\:n20) resistor r=37.3411 c=0
Rl18 (\2\:n20 \4\:n20) resistor r=87.3411 c=0
Rl17 (\2\:n20 \3\:n20) resistor r=3.1183 c=0
Rl14 (mout \2\:mout) resistor r=79.5379 c=0
Rl15 (\2\:mout \3\:mout) resistor r=29.5379 c=0
Rl25 (n30 \2\:n30) resistor r=26.098 c=0
Rl26 (\2\:n30 \3\:n30) resistor r=53.0211 c=0
Rl47 (\12\:qbint \13\:qbint) resistor r=153.412 c=0
Rl46 (\11\:qbint \12\:qbint) resistor r=36.2715 c=0
Rl23 (\2\:qbint qbint) resistor r=81.9251 c=0
Rl24 (\2\:qbint \3\:qbint) resistor r=24.2328 c=0
Rl31 (\2\:Eb \4\:Eb) resistor r=70.8353 c=0
Rl30 (\2\:Eb \3\:Eb) resistor r=136.516 c=0
Rl29 (Eb \2\:Eb) resistor r=76.8484 c=0
Rz9 (\4\:Q \3\:Q) resistor r=75 c=0
Rz16 (\19\:VSS \18\:VSS) resistor r=75 c=0
Rz17 (\21\:VSS \20\:VSS) resistor r=75 c=0
Rz18 (\23\:VSS \22\:VSS) resistor r=75 c=0
Rz19 (\25\:VSS \24\:VSS) resistor r=75 c=0
Rz10 (\4\:QN \3\:QN) resistor r=75 c=0
Rz20 (\2\:VDD \1\:VDD) resistor r=25 c=0
Rz21 (\6\:VDD \1\:VDD) resistor r=6.25 c=0
Rz22 (\10\:VDD \1\:VDD) resistor r=6.25 c=0
Rz1 (\15\:Ckb \16\:Ckb) resistor r=75 c=0
Rz4 (\13\:CKbb \14\:CKbb) resistor r=75 c=0
Rz2 (\9\:n20 \10\:n20) resistor r=75 c=0
Rz6 (Db \2\:Db) resistor r=75 c=0
Rz7 (\7\:Db \8\:Db) resistor r=75 c=0
Rz3 (\6\:mout \7\:mout) resistor r=75 c=0
Rz5 (\7\:n30 \8\:n30) resistor r=75 c=0
Rz11 (\18\:qbint \17\:qbint) resistor r=75 c=0
Rz8 (\5\:Eb \6\:Eb) resistor r=75 c=0
Rz12 (\8\:qint \7\:qint) resistor r=75 c=0
Ry9 (\2\:Q \1\:Q) resistor r=20.6667 c=0
Ry13 (\2\:VSS \1\:VSS) resistor r=20.6667 c=0
Ry14 (\6\:VSS \1\:VSS) resistor r=5.1667 c=0
Ry15 (\10\:VSS \1\:VSS) resistor r=5.1667 c=0
Ry10 (\2\:QN \1\:QN) resistor r=20.6667 c=0
Ry20 (\20\:VDD \19\:VDD) resistor r=62 c=0
Ry21 (\22\:VDD \21\:VDD) resistor r=62 c=0
Ry22 (\24\:VDD \23\:VDD) resistor r=62 c=0
Ry23 (\26\:VDD \25\:VDD) resistor r=62 c=0
Ry1 (\17\:Ckb \18\:Ckb) resistor r=62 c=0
Ry4 (\15\:CKbb \16\:CKbb) resistor r=62 c=0
Ry2 (\7\:n20 \8\:n20) resistor r=62 c=0
Ry6 (\3\:Db \4\:Db) resistor r=62 c=0
Ry7 (\5\:Db \6\:Db) resistor r=62 c=0
Ry3 (\8\:mout \9\:mout) resistor r=62 c=0
Ry5 (\5\:n30 \6\:n30) resistor r=62 c=0
Ry11 (\24\:qbint \23\:qbint) resistor r=62 c=0
Ry8 (\9\:Eb \10\:Eb) resistor r=62 c=0
Ry12 (\12\:qint \11\:qint) resistor r=62 c=0
Rx12 (\2\:D \4\:D) resistor r=45 c=0
Rx1 (\1\:CK \5\:CK) resistor r=45 c=0
Rx14 (\4\:E \8\:E) resistor r=45 c=0
Rx15 (\2\:E \10\:E) resistor r=45 c=0
Rx16 (\6\:E \11\:E) resistor r=45 c=0
Rx2 (\6\:Ckb \13\:Ckb) resistor r=45 c=0
Rx5 (\12\:Ckb \19\:Ckb) resistor r=45 c=0
Rx6 (Ckb \20\:Ckb) resistor r=45 c=0
Rx7 (\5\:CKbb \9\:CKbb) resistor r=45 c=0
Rx8 (\4\:CKbb \11\:CKbb) resistor r=45 c=0
Rx9 (\8\:CKbb \17\:CKbb) resistor r=45 c=0
Rx10 (\2\:CKbb \18\:CKbb) resistor r=45 c=0
Rx3 (\3\:n20 \5\:n20) resistor r=45 c=0
Rx4 (\2\:mout \4\:mout) resistor r=45 c=0
Rx11 (\2\:n30 \4\:n30) resistor r=45 c=0
Rx17 (\14\:qbint \11\:qbint) resistor r=45 c=0
Rx18 (\20\:qbint \2\:qbint) resistor r=45 c=0
Rx13 (Eb \8\:Eb) resistor r=45 c=0
Rx21 (\10\:qint qint) resistor r=45 c=0
mn20 (\15\:Ckb \3\:CK \24\:VSS VSS) g45n1hvt w=(1.45e-07) l=4.5e-08 nf=1 \
        as=2.32e-14 ad=2.03e-14 ps=6.1e-07 pd=5.7e-07 nrd=1.16667 \
        nrs=1.16667 sa=1.4e-07 sb=3.5e-07 sd=160n sca=6.83173 \
        scb=0.00357784 scc=2.82929e-05 m=(1)
mn21 (\13\:CKbb \9\:Ckb \24\:VSS VSS) g45n1hvt w=(1.45e-07) l=4.5e-08 \
        nf=1 as=2.32e-14 ad=2.102e-14 ps=6.1e-07 pd=5.8e-07 nrd=1.16667 \
        nrs=1.16667 sa=3.45e-07 sb=1.45e-07 sd=160n sca=6.83173 \
        scb=0.00357784 scc=2.82929e-05 m=(1)
mn25 (\7\:Db \7\:Ckb \9\:n20 VSS) g45n1hvt w=(1.45e-07) l=4.5e-08 nf=1 \
        as=3.77e-14 ad=3.117e-14 ps=8.1e-07 pd=7.2e-07 nrd=1.16667 \
        nrs=1.16667 sa=2.15e-07 sb=1.96414e-06 sd=160n sca=11.7118 \
        scb=0.0116498 scc=0.000458536 m=(1)
mn36 (\9\:n20 \3\:CKbb net411 VSS) g45n1hvt w=(1.45e-07) l=4.5e-08 nf=1 \
        as=8.7e-15 ad=3.77e-14 ps=4.1e-07 pd=8.1e-07 nrd=1.16667 \
        nrs=1.16667 sa=5.2e-07 sb=1.92207e-06 sd=160n sca=11.7118 \
        scb=0.0116498 scc=0.000458536 m=(1)
mn35 (net411 \3\:mout \22\:VSS VSS) g45n1hvt w=(1.45e-07) l=4.5e-08 nf=1 \
        as=7.09e-14 ad=8.7e-15 ps=1.38e-06 pd=4.1e-07 nrd=1.16667 \
        nrs=1.16667 sa=6.25e-07 sb=1.90759e-06 sd=160n sca=11.7118 \
        scb=0.0116498 scc=0.000458536 m=(1)
mn30 (\6\:mout \4\:n20 \22\:VSS VSS) g45n1hvt w=(1.45e-07) l=4.5e-08 \
        nf=1 as=7.09e-14 ad=2.32e-14 ps=1.38e-06 pd=6.1e-07 nrd=1.16667 \
        nrs=1.16667 sa=8.9e-07 sb=1.71155e-06 sd=160n sca=11.7118 \
        scb=0.0116498 scc=0.000458536 m=(1)
mn40 (\6\:mout \6\:CKbb \7\:n30 VSS) g45n1hvt w=(1.45e-07) l=4.5e-08 nf=1 \
        as=2.32e-14 ad=2.32e-14 ps=6.1e-07 pd=6.1e-07 nrd=1.16667 \
        nrs=1.16667 sa=1.095e-06 sb=1.50655e-06 sd=160n sca=11.7118 \
        scb=0.0116498 scc=0.000458536 m=(1)
mn51 (\7\:n30 \10\:Ckb net415 VSS) g45n1hvt w=(1.45e-07) l=4.5e-08 nf=1 \
        as=2.682e-14 ad=2.32e-14 ps=6.6e-07 pd=6.1e-07 nrd=1.16667 \
        nrs=1.16667 sa=1.3e-06 sb=1.30155e-06 sd=160n sca=11.7118 \
        scb=0.0116498 scc=0.000458536 m=(1)
mn50 (net415 \3\:qbint \20\:VSS VSS) g45n1hvt w=(1.45e-07) l=4.5e-08 \
        nf=1 as=4.632e-14 ad=2.682e-14 ps=9.7e-07 pd=6.6e-07 nrd=1.16667 \
        nrs=1.16667 sa=1.53e-06 sb=1.07155e-06 sd=160n sca=11.7118 \
        scb=0.0116498 scc=0.000458536 m=(1)
mn1 (\17\:qbint \3\:Eb Db VSS) g45n1hvt w=(1.45e-07) l=4.5e-08 nf=1 \
        as=2.538e-14 ad=6.493e-14 ps=6.4e-07 pd=1.2e-06 nrd=1.16667 \
        nrs=1.16667 sa=1.79103e-06 sb=5.2e-07 sd=160n sca=12.9138 \
        scb=0.0133404 scc=0.000640143 m=(1)
mn3 (Db \3\:E n0 VSS) g45n1hvt w=(1.45e-07) l=4.5e-08 nf=1 as=1.233e-14 \
        ad=2.537e-14 ps=4.6e-07 pd=6.4e-07 nrd=1.16667 nrs=1.16667 \
        sa=1.82138e-06 sb=3e-07 sd=160n sca=12.9138 scb=0.0133404 \
        scc=0.000640143 m=(1)
mn2 (n0 \1\:D \18\:VSS VSS) g45n1hvt w=(1.45e-07) l=4.5e-08 nf=1 \
        as=6.605e-14 ad=1.233e-14 ps=1.32e-06 pd=4.6e-07 nrd=1.16667 \
        nrs=1.16667 sa=1.83931e-06 sb=1.7e-07 sd=160n sca=12.9138 \
        scb=0.0133404 scc=0.000640143 m=(1)
mn0 (\5\:Eb \7\:E \3\:VSS VSS) g45n1hvt w=(1.45e-07) l=4.5e-08 nf=1 \
        as=8.205e-14 ad=2.03e-14 ps=1.47e-06 pd=5.7e-07 nrd=1.16667 \
        nrs=1.16667 sa=1.4e-07 sb=1.365e-06 sd=160n sca=14.7993 \
        scb=0.0157101 scc=0.000964917 m=(1)
mn56 (\7\:qint \12\:qbint \3\:VSS VSS) g45n1hvt w=(1.45e-07) l=4.5e-08 \
        nf=1 as=8.205e-14 ad=2.03e-14 ps=1.47e-06 pd=5.7e-07 nrd=1.16667 \
        nrs=1.16667 sa=1.365e-06 sb=1.4e-07 sd=160n sca=14.7993 \
        scb=0.0157101 scc=0.000964917 m=(1)
mn45 (\17\:qbint \3\:n30 \20\:VSS VSS) g45n1hvt w=(2.6e-07) l=4.5e-08 \
        nf=1 as=4.633e-14 ad=6.493e-14 ps=9.7e-07 pd=1.2e-06 nrd=1.16667 \
        nrs=1.16667 sa=1.05654e-06 sb=5.64808e-07 sd=160n sca=12.8392 \
        scb=0.0126987 scc=0.00074151 m=(1)
mn55 (\3\:Q \4\:qbint \3\:VSS VSS) g45n1hvt w=(2.6e-07) l=4.5e-08 nf=1 \
        as=8.493e-14 ad=4.68e-14 ps=1.47e-06 pd=8.8e-07 nrd=1.16667 \
        nrs=1.16667 sa=3.01058e-07 sb=9.96058e-07 sd=160n sca=11.8713 \
        scb=0.0115056 scc=0.000581193 m=(2)
mn57 (\3\:QN qint \3\:VSS VSS) g45n1hvt w=(2.6e-07) l=4.5e-08 nf=1 \
        as=8.493e-14 ad=4.16e-14 ps=1.47e-06 pd=8.4e-07 nrd=1.16667 \
        nrs=1.16667 sa=7.91058e-07 sb=5.06058e-07 sd=160n sca=11.8713 \
        scb=0.0115056 scc=0.000581193 m=(2)
mp45 (\23\:qbint n30 \21\:VDD VDD) g45p1hvt w=(3.9e-07) l=4.5e-08 nf=1 \
        as=8.412e-14 ad=7.908e-14 ps=1.33e-06 pd=1.25e-06 nrd=1.16667 \
        nrs=1.16667 sa=9.74872e-07 sb=5.05962e-07 sd=160n sca=30.5009 \
        scb=0.0202006 scc=0.00336097 m=(1)
mp55 (\1\:Q \4\:qbint \3\:VDD VDD) g45p1hvt w=(3.9e-07) l=4.5e-08 nf=1 \
        as=7.002e-14 ad=7.02e-14 ps=1.175e-06 pd=1.14e-06 nrd=1.16667 \
        nrs=1.16667 sa=3.38462e-07 sb=9.19551e-07 sd=160n sca=17.2385 \
        scb=0.0152696 scc=0.00137893 m=(2)
mp57_1__rcx (\1\:QN qint \3\:VDD VDD) g45p1hvt w=(3.9e-07) l=4.5e-08 \
        nf=1 as=6.68e-14 ad=6.24e-14 ps=1.145e-06 pd=1.1e-06 nrd=1.16667 \
        nrs=1.16667 sa=7.83462e-07 sb=4.74551e-07 sd=160n sca=17.6585 \
        scb=0.0154026 scc=0.00137896 m=(2)
ends EDFFX2
// End of subcircuit definition.
