// gsclib045_lvt/AOI2BB1XL/schematic

simulator lang=spectre

subckt AOI2BB1XL A0N A1N B0 Y VDD VSS
mp3 (Y net100 net79 VDD) g45p1lvt w=(215n) l=45n nf=1 m=(1)
mp2 (net79 B0 VDD VDD) g45p1lvt w=(215n) l=45n nf=1 m=(1)
mp1 (net100 A1N net87 VDD) g45p1lvt w=(215n) l=45n nf=1 m=(1)
mp0 (net87 A0N VDD VDD) g45p1lvt w=(215n) l=45n nf=1 m=(1)
mn2 (Y B0 VSS VSS) g45n1lvt w=(145n) l=45n nf=1 m=(1)
mn1 (net100 A1N VSS VSS) g45n1lvt w=(145n) l=45n nf=1 m=(1)
mn3 (Y net100 VSS VSS) g45n1lvt w=(145n) l=45n nf=1 m=(1)
mn0 (net100 A0N VSS VSS) g45n1lvt w=(145n) l=45n nf=1 m=(1)
ends AOI2BB1XL
