// Generated for: spectre (May  1 11:33:51 2013 )
// Library name: gsclib045_backbias
// Cell name: XOR2X4
// View name: extracted

simulator lang=spectre

subckt XOR2X4 A B NW VDD VSS Y
mp4 (\4\:n1 \3\:B \13\:n0 NW) g45p1svt w=(3.9e-07) l=4.5e-08 nf=1 \
        as=6.24e-14 ad=1.25e-13 ps=1.1e-06 pd=1.78e-06 nrd=1.16667 \
        nrs=1.16667 sa=8.9109e-07 sb=5.85064e-07 sd=160n sca=16.6552 \
        scb=0.0146982 scc=0.00118864 m=(1)
mp3 (\13\:n0 \3\:n2 net130 NW) g45p1svt w=(3.9e-07) l=4.5e-08 nf=1 \
        as=3.9e-14 ad=6.24e-14 ps=9.8e-07 pd=1.1e-06 nrd=1.16667 \
        nrs=1.16667 sa=1.09609e-06 sb=3.80064e-07 sd=160n sca=17.6259 \
        scb=0.0154648 scc=0.00118993 m=(1)
mp2 (net130 n1 \1\:VDD NW) g45p1svt w=(3.9e-07) l=4.5e-08 nf=1 \
        as=5.19e-14 ad=3.9e-14 ps=1.1e-06 pd=9.8e-07 nrd=1.16667 \
        nrs=1.16667 sa=1.24109e-06 sb=2.35064e-07 sd=160n sca=19.1246 \
        scb=0.0176055 scc=0.00120723 m=(1)
mp5_1__rcx (\1\:Y n0 VDD NW) g45p1svt w=(3.9e-07) l=4.5e-08 nf=1 \
        as=6.119e-14 ad=6.24e-14 ps=1.105e-06 pd=1.1e-06 nrd=1.16667 \
        nrs=1.16667 sa=1.4e-07 sb=1.42346e-06 sd=160n sca=25.2855 \
        scb=0.0288799 scc=0.00168046 m=(4)
C1 (A VSS) capacitor c=7.36607e-17
C2 (Y VSS) capacitor c=1.89553e-17
C3 (NW VSS) capacitor c=3.4002e-16
C4 (VDD VSS) capacitor c=3.34931e-16
C5 (B VSS) capacitor c=3.64475e-17
C6 (n0 VSS) capacitor c=2.65918e-16
C7 (n1 VSS) capacitor c=6.3182e-17
C8 (n2 VSS) capacitor c=4.0838e-17
C9 (net131 VSS) capacitor c=3.62849e-18
C10 (net130 VSS) capacitor c=2.76348e-18
C11 (\4\:B VSS) capacitor c=5.16867e-17
C12 (\3\:n2 VSS) capacitor c=5.95991e-17
C13 (\3\:B VSS) capacitor c=5.74094e-17
C14 (\1\:A VSS) capacitor c=4.32995e-17
C15 (\6\:B VSS) capacitor c=4.15541e-17
C16 (\3\:n1 VSS) capacitor c=7.03595e-17
C17 (\1\:B VSS) capacitor c=3.98596e-17
C18 (\3\:A VSS) capacitor c=3.70611e-17
C19 (\5\:B VSS) capacitor c=4.5398e-17
C20 (\2\:n1 VSS) capacitor c=5.27772e-17
C21 (\2\:B VSS) capacitor c=6.69396e-17
C22 (\4\:n2 VSS) capacitor c=4.53948e-17
C23 (\2\:n2 VSS) capacitor c=2.93889e-17
C24 (\2\:A VSS) capacitor c=3.87404e-17
C25 (\5\:n2 VSS) capacitor c=4.69377e-17
C26 (\1\:VDD VSS) capacitor c=1.3879e-16
C27 (\13\:n0 VSS) capacitor c=1.19999e-16
C28 (\4\:n1 VSS) capacitor c=3.83162e-17
C29 (\1\:Y VSS) capacitor c=1.77161e-16
C30 (\10\:n2 VSS) capacitor c=1.87211e-17
C31 (\17\:n0 VSS) capacitor c=1.12902e-16
C32 (\7\:n1 VSS) capacitor c=8.75004e-17
C33 (\4\:Y VSS) capacitor c=1.22889e-16
C34 (\5\:A VSS) capacitor c=7.0233e-17
C35 (\15\:n0 VSS) capacitor c=2.06768e-16
C36 (\16\:n0 VSS) capacitor c=2.33121e-17
C37 (\6\:n1 VSS) capacitor c=8.1768e-17
C38 (\9\:n1 VSS) capacitor c=8.43652e-17
C39 (\7\:B VSS) capacitor c=5.47934e-17
C40 (\8\:B VSS) capacitor c=3.12908e-17
C41 (\7\:n2 VSS) capacitor c=1.10629e-16
C42 (\8\:n2 VSS) capacitor c=7.4494e-17
C43 (\9\:n2 VSS) capacitor c=3.18349e-17
C44 (\12\:n2 VSS) capacitor c=5.53143e-17
Rk6 (\4\:A \5\:A) resistor r=0.006435 c=0
Rk7 (\6\:A A) resistor r=0.006521 c=0
Rk8 (\5\:A \6\:A) resistor r=0.0943 c=0
Rk2 (\1\:Y Y) resistor r=0.03962 c=0
Rk3 (Y \4\:Y) resistor r=0.3399 c=0
Rk22 (\2\:VDD VDD) resistor r=0.9153 c=0
Rk32 (VSS \8\:VSS) resistor r=0.1403 c=0
Rk33 (\8\:VSS \10\:VSS) resistor r=0.6263 c=0
Rk15 (B \7\:B) resistor r=0.1778 c=0
Rk16 (B \8\:B) resistor r=0.0301 c=0
Rk9 (\14\:n0 \15\:n0) resistor r=1.0357 c=0
Rk10 (\15\:n0 \16\:n0) resistor r=0.109 c=0
Rk11 (\15\:n0 \18\:n0) resistor r=0.8439 c=0
Rk12 (\5\:n1 \6\:n1) resistor r=0.1048 c=0
Rk13 (\6\:n1 \8\:n1) resistor r=0.364 c=0
Rk14 (\6\:n1 \9\:n1) resistor r=0.5203 c=0
Rk17 (\6\:n2 \7\:n2) resistor r=0.5264 c=0
Rk18 (\7\:n2 \8\:n2) resistor r=0.5889 c=0
Rk19 (\8\:n2 \9\:n2) resistor r=0.08708 c=0
Rk20 (\7\:n2 \11\:n2) resistor r=0.07544 c=0
Rk21 (\8\:n2 \12\:n2) resistor r=0.2588 c=0
Rl12 (\1\:A \2\:A) resistor r=116.076 c=0
Rl13 (\2\:A \3\:A) resistor r=66.0764 c=0
Rl20 (\4\:B \5\:B) resistor r=117.288 c=0
Rl21 (\5\:B \6\:B) resistor r=86.5184 c=0
Rl17 (\2\:B \3\:B) resistor r=166.862 c=0
Rl16 (\1\:B \2\:B) resistor r=31.9251 c=0
Rl18 (n1 \2\:n1) resistor r=24.2328 c=0
Rl19 (\2\:n1 \3\:n1) resistor r=116.54 c=0
Rl15 (\3\:n2 \4\:n2) resistor r=39.6174 c=0
Rl14 (n2 \2\:n2) resistor r=37.2302 c=0
Rz8 (\10\:VSS \9\:VSS) resistor r=75 c=0
Rz3 (\18\:n0 \17\:n0) resistor r=75 c=0
Rz4 (\7\:n1 \8\:n1) resistor r=75 c=0
Rz5 (\10\:n2 \11\:n2) resistor r=75 c=0
Ry6 (\2\:VDD \1\:VDD) resistor r=62 c=0
Ry3 (\14\:n0 \13\:n0) resistor r=62 c=0
Ry4 (\4\:n1 \5\:n1) resistor r=62 c=0
Ry5 (\5\:n2 \6\:n2) resistor r=62 c=0
Rx1 (\2\:A \4\:A) resistor r=45 c=0
Rx4 (\2\:B \7\:B) resistor r=45 c=0
Rx5 (\5\:B \8\:B) resistor r=45 c=0
Rx2 (\16\:n0 n0) resistor r=45 c=0
Rx3 (\2\:n1 \9\:n1) resistor r=45 c=0
Rx6 (\2\:n2 \9\:n2) resistor r=45 c=0
Rx7 (\4\:n2 \12\:n2) resistor r=45 c=0
mn4 (\17\:n0 n2 \7\:n1 VSS) g45n1svt w=(2.6e-07) l=4.5e-08 nf=1 \
        as=6.733e-14 ad=6.24e-14 ps=1.29e-06 pd=1e-06 nrd=1.16667 \
        nrs=1.16667 sa=8.36154e-07 sb=7.01635e-07 sd=160n sca=9.14564 \
        scb=0.00759168 scc=0.000213449 m=(1)
mn3 (\17\:n0 \1\:B net131 VSS) g45n1svt w=(2.6e-07) l=4.5e-08 nf=1 \
        as=3.51e-14 ad=6.24e-14 ps=7.9e-07 pd=1e-06 nrd=1.16667 \
        nrs=1.16667 sa=1.12115e-06 sb=4.16635e-07 sd=160n sca=9.14564 \
        scb=0.00759168 scc=0.000213449 m=(1)
mn2 (net131 \3\:n1 \9\:VSS VSS) g45n1svt w=(2.6e-07) l=4.5e-08 nf=1 \
        as=3.47e-14 ad=3.51e-14 ps=8.4e-07 pd=7.9e-07 nrd=1.16667 \
        nrs=1.16667 sa=1.30115e-06 sb=2.36635e-07 sd=160n sca=9.14564 \
        scb=0.00759168 scc=0.000213449 m=(1)
mn5 (\4\:Y n0 VSS VSS) g45n1svt w=(2.6e-07) l=4.5e-08 nf=1 as=4.026e-14 \
        ad=4.16e-14 ps=8.45e-07 pd=8.4e-07 nrd=1.16667 nrs=1.16667 \
        sa=1.4e-07 sb=1.37231e-06 sd=160n sca=11.5806 scb=0.0111274 \
        scc=0.000535497 m=(4)
mn0 (\7\:n1 \3\:A VSS VSS) g45n1svt w=(1.45e-07) l=4.5e-08 nf=1 \
        as=4.145e-14 ad=6.733e-14 ps=9e-07 pd=1.29e-06 nrd=1.16667 \
        nrs=1.16667 sa=9.9e-07 sb=1.04569e-06 sd=160n sca=10.9472 \
        scb=0.0104991 scc=0.000356047 m=(1)
mn1 (\10\:n2 \6\:B \9\:VSS VSS) g45n1svt w=(1.45e-07) l=4.5e-08 nf=1 \
        as=3.47e-14 ad=2.03e-14 ps=8.4e-07 pd=5.7e-07 nrd=1.16667 \
        nrs=1.16667 sa=1.02448e-06 sb=1.4e-07 sd=160n sca=7.37439 \
        scb=0.00450456 scc=4.82709e-05 m=(1)
mp0 (\4\:n1 \1\:A VDD NW) g45p1svt w=(2.15e-07) l=4.5e-08 nf=1 \
        as=6.535e-14 ad=1.25e-13 ps=1.16e-06 pd=1.78e-06 nrd=1.16667 \
        nrs=1.16667 sa=9.9e-07 sb=1.18872e-06 sd=160n sca=12.7104 \
        scb=0.0116911 scc=0.00042519 m=(1)
mp1 (\5\:n2 \4\:B \1\:VDD NW) g45p1svt w=(2.15e-07) l=4.5e-08 nf=1 \
        as=5.19e-14 ad=3.01e-14 ps=1.1e-06 pd=7.1e-07 nrd=1.16667 \
        nrs=1.16667 sa=1.71849e-06 sb=1.4e-07 sd=160n sca=24.9308 \
        scb=0.0292329 scc=0.0015565 m=(1)
ends XOR2X4
// End of subcircuit definition.
