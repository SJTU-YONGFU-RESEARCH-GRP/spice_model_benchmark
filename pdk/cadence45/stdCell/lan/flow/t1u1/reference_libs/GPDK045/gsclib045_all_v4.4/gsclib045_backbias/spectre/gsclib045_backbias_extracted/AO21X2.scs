// Generated for: spectre (May  1 11:27:17 2013 )
// Library name: gsclib045_backbias
// Cell name: AO21X2
// View name: extracted

simulator lang=spectre

subckt AO21X2 A0 A1 B0 NW VDD VSS Y
mp0 (\3\:net84 \1\:A0 \7\:VDD NW) g45p1svt w=(2.15e-07) l=4.5e-08 nf=1 \
        as=5.815e-14 ad=3.01e-14 ps=1.57e-06 pd=7.1e-07 nrd=1.16667 \
        nrs=1.16667 sa=1.4e-07 sb=5.4e-07 sd=160n sca=16.4235 \
        scb=0.0160509 scc=0.000530362 m=(1)
mp1 (net84 \1\:A1 \7\:VDD NW) g45p1svt w=(2.15e-07) l=4.5e-08 nf=1 \
        as=5.815e-14 ad=3.44e-14 ps=1.57e-06 pd=7.5e-07 nrd=1.16667 \
        nrs=1.16667 sa=3.35e-07 sb=3.45e-07 sd=160n sca=14.3559 \
        scb=0.0130561 scc=0.000502004 m=(1)
mp2 (\11\:net100 \3\:B0 net84 NW) g45p1svt w=(2.15e-07) l=4.5e-08 nf=1 \
        as=3.44e-14 ad=3.01e-14 ps=7.5e-07 pd=7.1e-07 nrd=1.16667 \
        nrs=1.16667 sa=5.4e-07 sb=1.4e-07 sd=160n sca=13.9642 scb=0.012601 \
        scc=0.000501242 m=(1)
C1 (NW VSS) capacitor c=2.36784e-16
C2 (B0 VSS) capacitor c=5.38576e-17
C3 (A1 VSS) capacitor c=5.59366e-17
C4 (VDD VSS) capacitor c=4.5628e-17
C5 (A0 VSS) capacitor c=5.05625e-17
C6 (Y VSS) capacitor c=5.58808e-17
C7 (net104 VSS) capacitor c=3.48915e-18
C8 (net100 VSS) capacitor c=8.90205e-17
C9 (net84 VSS) capacitor c=4.08987e-17
C10 (\3\:B0 VSS) capacitor c=4.79081e-17
C11 (\1\:A1 VSS) capacitor c=6.56769e-17
C12 (\1\:A0 VSS) capacitor c=5.02753e-17
C13 (\1\:B0 VSS) capacitor c=3.28028e-17
C14 (\3\:A1 VSS) capacitor c=3.53785e-17
C15 (\4\:A0 VSS) capacitor c=3.98146e-17
C16 (\4\:net100 VSS) capacitor c=4.12188e-17
C17 (\2\:B0 VSS) capacitor c=5.21886e-17
C18 (\2\:A1 VSS) capacitor c=5.2617e-17
C19 (\3\:A0 VSS) capacitor c=1.26758e-17
C20 (\1\:VDD VSS) capacitor c=1.70692e-16
C21 (\1\:Y VSS) capacitor c=1.0071e-16
C22 (\11\:net100 VSS) capacitor c=7.48339e-17
C23 (\7\:VDD VSS) capacitor c=1.22532e-17
C24 (\3\:net84 VSS) capacitor c=3.82752e-17
C25 (\3\:Y VSS) capacitor c=2.21591e-17
C26 (\8\:net100 VSS) capacitor c=5.81578e-17
C27 (\2\:A0 VSS) capacitor c=3.4707e-17
C28 (\3\:net100 VSS) capacitor c=5.78563e-17
C29 (\5\:A0 VSS) capacitor c=2.80831e-17
C30 (\4\:A1 VSS) capacitor c=4.26788e-17
C31 (\5\:B0 VSS) capacitor c=4.2228e-17
C32 (\10\:net100 VSS) capacitor c=1.02869e-16
C33 (\4\:VDD VSS) capacitor c=4.63778e-17
Rk4 (\4\:B0 \5\:B0) resistor r=0.003877 c=0
Rk5 (\6\:B0 B0) resistor r=0.003963 c=0
Rk6 (\5\:B0 \6\:B0) resistor r=0.08164 c=0
Rk2 (\4\:A1 A1) resistor r=0.09547 c=0
Rk17 (\1\:VSS \5\:VSS) resistor r=0.1121 c=0
Rk19 (\6\:VSS VSS) resistor r=0.1119 c=0
Rk18 (\5\:VSS \6\:VSS) resistor r=0.2369 c=0
Rk21 (\6\:VSS \10\:VSS) resistor r=0.2653 c=0
Rk13 (\4\:VDD VDD) resistor r=0.2292 c=0
Rk12 (\1\:VDD \4\:VDD) resistor r=0.2642 c=0
Rk15 (\4\:VDD \8\:VDD) resistor r=0.07277 c=0
Rk1 (A0 \5\:A0) resistor r=0.1223 c=0
Rk9 (\2\:Y Y) resistor r=0.3867 c=0
Rk10 (Y \4\:Y) resistor r=0.1837 c=0
Rk7 (\9\:net100 \10\:net100) resistor r=0.2925 c=0
Rk8 (\10\:net100 \12\:net100) resistor r=0.4742 c=0
Rk3 (\2\:net84 \4\:net84) resistor r=0.2387 c=0
Rl7 (\2\:B0 \3\:B0) resistor r=129.945 c=0
Rl6 (\1\:B0 \2\:B0) resistor r=57.6923 c=0
Rl4 (\1\:A1 \2\:A1) resistor r=161.538 c=0
Rl5 (\2\:A1 \3\:A1) resistor r=26.3736 c=0
Rl1 (\1\:A0 \2\:A0) resistor r=154.649 c=0
Rl3 (\2\:A0 \4\:A0) resistor r=46.9565 c=0
Rl2 (\2\:A0 \3\:A0) resistor r=8.9604 c=0
Rl9 (\3\:net100 net100) resistor r=159.312 c=0
Rl10 (\3\:net100 \4\:net100) resistor r=3.3229 c=0
Rz5 (\10\:VSS \9\:VSS) resistor r=75 c=0
Rz2 (\4\:Y \3\:Y) resistor r=75 c=0
Rz1 (\9\:net100 \8\:net100) resistor r=75 c=0
Ry7 (\8\:VDD \7\:VDD) resistor r=62 c=0
Ry4 (\2\:Y \1\:Y) resistor r=20.6667 c=0
Ry3 (\12\:net100 \11\:net100) resistor r=62 c=0
Ry1 (net84 \2\:net84) resistor r=62 c=0
Ry2 (\3\:net84 \4\:net84) resistor r=62 c=0
Rx3 (\2\:B0 \4\:B0) resistor r=45 c=0
Rx2 (\2\:A1 \4\:A1) resistor r=45 c=0
Rx1 (\3\:A0 \5\:A0) resistor r=45 c=0
Rx4 (\10\:net100 \4\:net100) resistor r=45 c=0
mn0 (net104 \4\:A0 \9\:VSS VSS) g45n1svt w=(1.45e-07) l=4.5e-08 nf=1 \
        as=2.03e-14 ad=1.087e-14 ps=5.7e-07 pd=4.4e-07 nrd=1.16667 \
        nrs=1.16667 sa=1.4e-07 sb=1.045e-06 sd=160n sca=10.0732 \
        scb=0.00911402 scc=0.000253284 m=(1)
mn1 (\8\:net100 \3\:A1 net104 VSS) g45n1svt w=(1.45e-07) l=4.5e-08 nf=1 \
        as=1.088e-14 ad=4.205e-14 ps=4.4e-07 pd=8.7e-07 nrd=1.16667 \
        nrs=1.16667 sa=2.6e-07 sb=9.25e-07 sd=160n sca=10.0732 \
        scb=0.00911402 scc=0.000253284 m=(1)
mn2 (\8\:net100 \1\:B0 \1\:VSS VSS) g45n1svt w=(1.45e-07) l=4.5e-08 nf=1 \
        as=4.51e-14 ad=4.205e-14 ps=9.2e-07 pd=8.7e-07 nrd=1.16667 \
        nrs=1.16667 sa=5.95e-07 sb=5.9e-07 sd=160n sca=10.0732 \
        scb=0.00911402 scc=0.000253284 m=(1)
mn3 (\3\:Y \3\:net100 \1\:VSS VSS) g45n1svt w=(2.6e-07) l=4.5e-08 nf=1 \
        as=4.075e-14 ad=4.16e-14 ps=8.6e-07 pd=8.4e-07 nrd=1.16667 \
        nrs=1.16667 sa=5.30385e-07 sb=3.45e-07 sd=160n sca=8.51051 \
        scb=0.00656948 scc=0.000151659 m=(2)
mp3 (\1\:Y net100 \1\:VDD NW) g45p1svt w=(3.9e-07) l=4.5e-08 nf=1 \
        as=4.92e-14 ad=6.24e-14 ps=1.06e-06 pd=1.1e-06 nrd=1.16667 \
        nrs=1.16667 sa=1.12308e-07 sb=3.45e-07 sd=160n sca=15.0157 \
        scb=0.0138815 scc=0.000273597 m=(2)
ends AO21X2
// End of subcircuit definition.
