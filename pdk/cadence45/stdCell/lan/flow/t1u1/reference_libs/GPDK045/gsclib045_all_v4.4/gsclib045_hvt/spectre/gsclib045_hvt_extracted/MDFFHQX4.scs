// Generated for: spectre (May  1 09:15:21 2013 )
// Library name: gsclib045_hvt
// Cell name: MDFFHQX4
// View name: extracted

simulator lang=spectre

subckt MDFFHQX4 CK D0 D1 Q S0 VDD VSS
mp20 (\14\:CKb \4\:CK \7\:VDD VDD) g45p1hvt w=(2.15e-07) l=4.5e-08 nf=1 \
        as=7.52e-14 ad=3.01e-14 ps=1.77e-06 pd=7.1e-07 nrd=1.16667 \
        nrs=1.16667 sa=1.4e-07 sb=2e-06 sd=160n sca=31.8563 scb=0.0365862 \
        scc=0.0028968 m=(1)
mp21 (\9\:CKbb \5\:CKb \11\:VDD VDD) g45p1hvt w=(2.15e-07) l=4.5e-08 \
        nf=1 as=5.19e-14 ad=3.01e-14 ps=1.1e-06 pd=7.1e-07 nrd=1.16667 \
        nrs=1.16667 sa=1.4e-07 sb=9.17093e-07 sd=160n sca=10.4315 \
        scb=0.0078915 scc=0.00010471 m=(1)
mp10 (\7\:S0b \5\:S0 \9\:VDD VDD) g45p1hvt w=(2.15e-07) l=4.5e-08 nf=1 \
        as=7.503e-14 ad=3.01e-14 ps=1.25e-06 pd=7.1e-07 nrd=1.16667 \
        nrs=1.16667 sa=9.45581e-07 sb=1.4e-07 sd=160n sca=26.9589 \
        scb=0.0303196 scc=0.00206685 m=(1)
C1 (D0 VSS) capacitor c=5.3443e-17
C2 (Q VSS) capacitor c=1.91576e-16
C3 (S0 VSS) capacitor c=6.29762e-17
C4 (VDD VSS) capacitor c=3.39466e-16
C5 (CK VSS) capacitor c=6.75849e-17
C6 (D1 VSS) capacitor c=1.01565e-16
C7 (CKb VSS) capacitor c=2.27527e-17
C8 (qbint VSS) capacitor c=3.10951e-16
C9 (n30 VSS) capacitor c=1.86821e-16
C10 (n35 VSS) capacitor c=5.33374e-18
C11 (mout VSS) capacitor c=6.83587e-17
C12 (CKbb VSS) capacitor c=4.81422e-17
C13 (n20 VSS) capacitor c=3.7159e-17
C14 (n25 VSS) capacitor c=1.08109e-18
C15 (D0b VSS) capacitor c=9.00921e-17
C16 (n10 VSS) capacitor c=6.92234e-18
C17 (S0b VSS) capacitor c=4.35599e-17
C18 (n36 VSS) capacitor c=5.48591e-18
C19 (n26 VSS) capacitor c=2.64832e-18
C20 (n11 VSS) capacitor c=1.91748e-18
C21 (n13 VSS) capacitor c=4.24869e-18
C22 (\5\:S0 VSS) capacitor c=4.43532e-17
C23 (\3\:D1 VSS) capacitor c=5.41372e-17
C24 (\2\:S0 VSS) capacitor c=7.26427e-17
C25 (\1\:D0 VSS) capacitor c=8.8584e-17
C26 (\5\:CKb VSS) capacitor c=6.58779e-17
C27 (\7\:CKbb VSS) capacitor c=3.97048e-17
C28 (\8\:CKb VSS) capacitor c=5.8083e-17
C29 (\4\:CKb VSS) capacitor c=2.72877e-17
C30 (\15\:qbint VSS) capacitor c=6.36695e-17
C31 (\4\:CK VSS) capacitor c=4.06127e-17
C32 (\7\:S0 VSS) capacitor c=3.39365e-17
C33 (\1\:D1 VSS) capacitor c=8.53288e-17
C34 (\3\:S0 VSS) capacitor c=7.08876e-17
C35 (\3\:S0b VSS) capacitor c=6.01583e-17
C36 (\4\:D0 VSS) capacitor c=4.22705e-17
C37 (\10\:CKb VSS) capacitor c=2.56451e-17
C38 (\11\:CKb VSS) capacitor c=2.53675e-17
C39 (\5\:CKbb VSS) capacitor c=4.39748e-17
C40 (\4\:mout VSS) capacitor c=4.38937e-17
C41 (\3\:n20 VSS) capacitor c=4.3638e-17
C42 (\3\:CKbb VSS) capacitor c=3.08907e-17
C43 (\3\:CKb VSS) capacitor c=5.19528e-17
C44 (\18\:qbint VSS) capacitor c=3.00496e-17
C45 (\3\:CK VSS) capacitor c=3.05327e-17
C46 (\6\:S0 VSS) capacitor c=3.5913e-17
C47 (\2\:D1 VSS) capacitor c=5.79505e-17
C48 (\4\:S0 VSS) capacitor c=4.32969e-17
C49 (\1\:S0 VSS) capacitor c=4.86954e-17
C50 (\3\:D0 VSS) capacitor c=3.15008e-17
C51 (\8\:CKbb VSS) capacitor c=3.79741e-17
C52 (\9\:CKb VSS) capacitor c=2.9056e-17
C53 (\6\:CKbb VSS) capacitor c=3.88791e-17
C54 (\3\:mout VSS) capacitor c=1.73077e-17
C55 (\2\:n20 VSS) capacitor c=3.88755e-17
C56 (\4\:CKbb VSS) capacitor c=3.63133e-17
C57 (\2\:CKbb VSS) capacitor c=4.58211e-17
C58 (\17\:qbint VSS) capacitor c=3.05735e-17
C59 (\1\:CK VSS) capacitor c=2.62933e-17
C60 (\7\:S0b VSS) capacitor c=9.29662e-17
C61 (\9\:VDD VSS) capacitor c=3.23234e-17
C62 (\4\:D0b VSS) capacitor c=6.77058e-17
C63 (\11\:VDD VSS) capacitor c=3.39707e-17
C64 (\9\:CKbb VSS) capacitor c=8.41382e-17
C65 (\6\:D0b VSS) capacitor c=1.25765e-16
C66 (\4\:n20 VSS) capacitor c=5.86714e-17
C67 (\13\:VDD VSS) capacitor c=3.29528e-17
C68 (\9\:mout VSS) capacitor c=6.30858e-17
C69 (\11\:n30 VSS) capacitor c=5.64274e-17
C70 (\19\:qbint VSS) capacitor c=4.8367e-17
C71 (\14\:CKb VSS) capacitor c=2.25241e-16
C72 (\1\:VDD VSS) capacitor c=6.10822e-17
C73 (\5\:S0b VSS) capacitor c=4.88885e-17
C74 (\15\:CKbb VSS) capacitor c=5.66474e-17
C75 (\8\:D0b VSS) capacitor c=7.35497e-17
C76 (\8\:n20 VSS) capacitor c=6.65326e-17
C77 (\7\:mout VSS) capacitor c=4.87515e-17
C78 (\7\:n30 VSS) capacitor c=6.00782e-17
C79 (\24\:qbint VSS) capacitor c=2.42858e-17
C80 (\16\:CKb VSS) capacitor c=4.30079e-17
C81 (\2\:CK VSS) capacitor c=1.81098e-17
C82 (\16\:qbint VSS) capacitor c=2.51358e-17
C83 (\2\:CKb VSS) capacitor c=5.62676e-17
C84 (\2\:mout VSS) capacitor c=3.66725e-17
C85 (\6\:CKb VSS) capacitor c=5.31334e-17
C86 (\7\:CKb VSS) capacitor c=5.46864e-17
C87 (\2\:D0 VSS) capacitor c=3.59182e-17
C88 (\2\:S0b VSS) capacitor c=5.67207e-17
C89 (\5\:CK VSS) capacitor c=5.76949e-17
C90 (\21\:qbint VSS) capacitor c=2.32092e-17
C91 (\22\:qbint VSS) capacitor c=4.10132e-17
C92 (\23\:qbint VSS) capacitor c=1.44032e-17
C93 (\26\:qbint VSS) capacitor c=4.78203e-17
C94 (\9\:n30 VSS) capacitor c=8.16954e-17
C95 (\10\:n30 VSS) capacitor c=4.94205e-17
C96 (\5\:mout VSS) capacitor c=4.98683e-17
C97 (\6\:mout VSS) capacitor c=5.60969e-17
C98 (\12\:CKb VSS) capacitor c=5.1513e-17
C99 (\13\:CKb VSS) capacitor c=2.35216e-16
C100 (\18\:CKb VSS) capacitor c=7.77548e-17
C101 (\6\:n20 VSS) capacitor c=6.58656e-17
C102 (\7\:n20 VSS) capacitor c=6.57828e-17
C103 (\11\:CKbb VSS) capacitor c=1.41509e-16
C104 (\12\:CKbb VSS) capacitor c=7.74418e-17
C105 (\13\:CKbb VSS) capacitor c=1.0955e-16
C106 (\14\:CKbb VSS) capacitor c=1.0236e-16
C107 (\17\:CKbb VSS) capacitor c=5.45041e-17
C108 (\18\:CKbb VSS) capacitor c=6.09077e-17
C109 (\5\:D0 VSS) capacitor c=5.98806e-17
C110 (\3\:D0b VSS) capacitor c=1.2469e-16
C111 (\8\:S0 VSS) capacitor c=7.33504e-17
C112 (\9\:S0 VSS) capacitor c=5.97364e-17
C113 (\9\:S0b VSS) capacitor c=8.48647e-17
C114 (\3\:VDD VSS) capacitor c=1.30053e-17
C115 (\4\:VDD VSS) capacitor c=2.68924e-17
C116 (\6\:VDD VSS) capacitor c=4.07048e-17
C117 (\7\:VDD VSS) capacitor c=1.80594e-16
Rk31 (\5\:D0 D0) resistor r=0.1545 c=0
Rk38 (\8\:S0 \9\:S0) resistor r=0.3401 c=0
Rk40 (\10\:S0 S0) resistor r=0.003095 c=0
Rk39 (\9\:S0 \10\:S0) resistor r=0.2335 c=0
Rk60 (\2\:VDD \3\:VDD) resistor r=0.07749 c=0
Rk61 (\3\:VDD \4\:VDD) resistor r=0.363 c=0
Rk62 (\4\:VDD \5\:VDD) resistor r=0.3106 c=0
Rk63 (\5\:VDD \6\:VDD) resistor r=0.3607 c=0
Rk75 (\7\:VDD VDD) resistor r=0.0998 c=0
Rk64 (\6\:VDD \7\:VDD) resistor r=0.6011 c=0
Rk66 (\3\:VDD \10\:VDD) resistor r=0.2396 c=0
Rk67 (\4\:VDD \12\:VDD) resistor r=0.2396 c=0
Rk68 (\6\:VDD \14\:VDD) resistor r=0.1619 c=0
Rk1 (CK \5\:CK) resistor r=0.1707 c=0
Rk37 (\4\:D1 D1) resistor r=0.007054 c=0
Rk43 (\2\:VSS \3\:VSS) resistor r=0.0399 c=0
Rk44 (\3\:VSS \4\:VSS) resistor r=0.4357 c=0
Rk45 (\4\:VSS \5\:VSS) resistor r=0.2755 c=0
Rk46 (\5\:VSS \6\:VSS) resistor r=0.3306 c=0
Rk52 (\7\:VSS VSS) resistor r=0.1249 c=0
Rk47 (\6\:VSS \7\:VSS) resistor r=0.6312 c=0
Rk53 (\3\:VSS \13\:VSS) resistor r=0.2894 c=0
Rk54 (\4\:VSS \15\:VSS) resistor r=0.316 c=0
Rk55 (\6\:VSS \17\:VSS) resistor r=0.1253 c=0
Rk17 (\12\:CKb \13\:CKb) resistor r=0.2989 c=0
Rk18 (\13\:CKb \15\:CKb) resistor r=1.7741 c=0
Rk19 (\15\:CKb \17\:CKb) resistor r=0.392 c=0
Rk20 (\13\:CKb \18\:CKb) resistor r=0.5387 c=0
Rk6 (\20\:qbint \21\:qbint) resistor r=0.3027 c=0
Rk7 (\21\:qbint \22\:qbint) resistor r=0.2096 c=0
Rk8 (\21\:qbint \23\:qbint) resistor r=0.07797 c=0
Rk9 (\23\:qbint \25\:qbint) resistor r=0.07084 c=0
Rk10 (\23\:qbint \26\:qbint) resistor r=0.1852 c=0
Rk11 (\8\:n30 \9\:n30) resistor r=0.4493 c=0
Rk12 (\9\:n30 \10\:n30) resistor r=0.2117 c=0
Rk13 (\9\:n30 \12\:n30) resistor r=0.3038 c=0
Rk14 (\5\:mout \6\:mout) resistor r=0.2333 c=0
Rk15 (\6\:mout \8\:mout) resistor r=0.1994 c=0
Rk16 (\6\:mout \10\:mout) resistor r=0.2599 c=0
Rk24 (\10\:CKbb \11\:CKbb) resistor r=0.6608 c=0
Rk25 (\11\:CKbb \12\:CKbb) resistor r=0.3715 c=0
Rk26 (\12\:CKbb \13\:CKbb) resistor r=0.2829 c=0
Rk27 (\13\:CKbb \14\:CKbb) resistor r=0.8171 c=0
Rk28 (\12\:CKbb \16\:CKbb) resistor r=0.3533 c=0
Rk29 (\13\:CKbb \17\:CKbb) resistor r=0.2213 c=0
Rk30 (\14\:CKbb \18\:CKbb) resistor r=0.2549 c=0
Rk21 (\5\:n20 \6\:n20) resistor r=0.171 c=0
Rk22 (\6\:n20 \7\:n20) resistor r=0.3369 c=0
Rk23 (\6\:n20 \9\:n20) resistor r=0.286 c=0
Rk32 (\2\:D0b \3\:D0b) resistor r=0.6162 c=0
Rk33 (\3\:D0b \5\:D0b) resistor r=0.1478 c=0
Rk34 (\3\:D0b \7\:D0b) resistor r=0.5202 c=0
Rk35 (\7\:D0b \9\:D0b) resistor r=0.3715 c=0
Rk36 (\5\:D0b \10\:D0b) resistor r=0.1569 c=0
Rk41 (\6\:S0b \8\:S0b) resistor r=0.4631 c=0
Rk42 (\8\:S0b \9\:S0b) resistor r=0.533 c=0
Rl43 (\1\:D0 \2\:D0) resistor r=50.8027 c=0
Rl45 (\2\:D0 \4\:D0) resistor r=98.8796 c=0
Rl44 (\2\:D0 \3\:D0) resistor r=12.2499 c=0
Rl53 (\5\:S0 \6\:S0) resistor r=104.538 c=0
Rl54 (\6\:S0 \7\:S0) resistor r=39.1533 c=0
Rl50 (\3\:S0 \4\:S0) resistor r=28.079 c=0
Rl46 (\1\:S0 \2\:S0) resistor r=37.7189 c=0
Rl3 (\2\:CK \4\:CK) resistor r=82.4064 c=0
Rl2 (\2\:CK \3\:CK) resistor r=34.3295 c=0
Rl1 (\1\:CK \2\:CK) resistor r=3.5213 c=0
Rl52 (\2\:D1 \3\:D1) resistor r=43.6813 c=0
Rl51 (\1\:D1 \2\:D1) resistor r=92.3077 c=0
Rl40 (\8\:CKb \9\:CKb) resistor r=24.2328 c=0
Rl29 (\2\:CKb \4\:CKb) resistor r=30.4507 c=0
Rl28 (\2\:CKb \3\:CKb) resistor r=145.697 c=0
Rl27 (CKb \2\:CKb) resistor r=84.5407 c=0
Rl37 (\5\:CKb \6\:CKb) resistor r=185.338 c=0
Rl41 (\6\:CKb \10\:CKb) resistor r=47.3105 c=0
Rl39 (\7\:CKb \8\:CKb) resistor r=170.697 c=0
Rl42 (\7\:CKb \11\:CKb) resistor r=30.4507 c=0
Rl38 (\6\:CKb \7\:CKb) resistor r=214.3 c=0
Rl22 (\16\:qbint \15\:qbint) resistor r=103.56 c=0
Rl24 (\16\:qbint \18\:qbint) resistor r=34.3295 c=0
Rl23 (\16\:qbint \17\:qbint) resistor r=11.4953 c=0
Rl32 (mout \2\:mout) resistor r=98.8796 c=0
Rl34 (\2\:mout \4\:mout) resistor r=37.3411 c=0
Rl33 (\2\:mout \3\:mout) resistor r=1.2301 c=0
Rl36 (\7\:CKbb \8\:CKbb) resistor r=30.0021 c=0
Rl35 (\5\:CKbb \6\:CKbb) resistor r=29.5379 c=0
Rl26 (\3\:CKbb \4\:CKbb) resistor r=33.3841 c=0
Rl25 (CKbb \2\:CKbb) resistor r=41.0764 c=0
Rl30 (n20 \2\:n20) resistor r=26.098 c=0
Rl31 (\2\:n20 \3\:n20) resistor r=87.6365 c=0
Rl47 (S0b \2\:S0b) resistor r=67.4757 c=0
Rl48 (\2\:S0b \3\:S0b) resistor r=147.664 c=0
Rl49 (\2\:S0b \4\:S0b) resistor r=1.2666 c=0
Rz19 (\2\:VDD \1\:VDD) resistor r=25 c=0
Rz20 (\5\:VDD \1\:VDD) resistor r=6.25 c=0
Rz21 (\7\:VDD \1\:VDD) resistor r=6.25 c=0
Rz12 (\13\:VSS \12\:VSS) resistor r=75 c=0
Rz13 (\15\:VSS \14\:VSS) resistor r=75 c=0
Rz14 (\17\:VSS \16\:VSS) resistor r=75 c=0
Rz6 (\16\:CKb \17\:CKb) resistor r=75 c=0
Rz3 (\25\:qbint \24\:qbint) resistor r=75 c=0
Rz4 (\8\:n30 \7\:n30) resistor r=75 c=0
Rz5 (\7\:mout \8\:mout) resistor r=75 c=0
Rz8 (\15\:CKbb \16\:CKbb) resistor r=75 c=0
Rz7 (\8\:n20 \9\:n20) resistor r=75 c=0
Rz9 (D0b \2\:D0b) resistor r=75 c=0
Rz10 (\8\:D0b \9\:D0b) resistor r=75 c=0
Rz11 (\5\:S0b \6\:S0b) resistor r=75 c=0
Ry16 (\10\:VDD \9\:VDD) resistor r=62 c=0
Ry17 (\12\:VDD \11\:VDD) resistor r=62 c=0
Ry18 (\14\:VDD \13\:VDD) resistor r=62 c=0
Ry13 (\2\:VSS \1\:VSS) resistor r=20.6667 c=0
Ry14 (\5\:VSS \1\:VSS) resistor r=5.1667 c=0
Ry15 (\7\:VSS \1\:VSS) resistor r=5.1667 c=0
Ry6 (\14\:CKb \15\:CKb) resistor r=62 c=0
Ry3 (\20\:qbint \19\:qbint) resistor r=62 c=0
Ry4 (\12\:n30 \11\:n30) resistor r=62 c=0
Ry5 (\9\:mout \10\:mout) resistor r=62 c=0
Ry8 (\9\:CKbb \10\:CKbb) resistor r=62 c=0
Ry7 (\4\:n20 \5\:n20) resistor r=31 c=0
Ry9 (\4\:D0b \5\:D0b) resistor r=62 c=0
Ry10 (\6\:D0b \7\:D0b) resistor r=62 c=0
Ry11 (\4\:D0b \10\:D0b) resistor r=62 c=0
Ry12 (\7\:S0b \8\:S0b) resistor r=62 c=0
Rx13 (\3\:D0 \5\:D0) resistor r=45 c=0
Rx15 (\1\:S0 \8\:S0) resistor r=45 c=0
Rx16 (\4\:S0 \9\:S0) resistor r=45 c=0
Rx17 (\6\:S0 \10\:S0) resistor r=45 c=0
Rx1 (\1\:CK \5\:CK) resistor r=45 c=0
Rx14 (\2\:D1 \4\:D1) resistor r=45 c=0
Rx6 (CKb \12\:CKb) resistor r=45 c=0
Rx7 (\9\:CKb \18\:CKb) resistor r=45 c=0
Rx2 (\22\:qbint qbint) resistor r=45 c=0
Rx3 (\26\:qbint \17\:qbint) resistor r=45 c=0
Rx4 (\10\:n30 n30) resistor r=45 c=0
Rx5 (\3\:mout \5\:mout) resistor r=45 c=0
Rx9 (\8\:CKbb \11\:CKbb) resistor r=45 c=0
Rx10 (\4\:CKbb \14\:CKbb) resistor r=45 c=0
Rx11 (\6\:CKbb \17\:CKbb) resistor r=45 c=0
Rx12 (\2\:CKbb \18\:CKbb) resistor r=45 c=0
Rx8 (\2\:n20 \7\:n20) resistor r=45 c=0
Rx18 (\4\:S0b \9\:S0b) resistor r=45 c=0
mn20 (\16\:CKb \3\:CK \7\:VSS VSS) g45n1hvt w=(1.45e-07) l=4.5e-08 nf=1 \
        as=4.365e-14 ad=2.03e-14 ps=9e-07 pd=5.7e-07 nrd=1.16667 \
        nrs=1.16667 sa=1.4e-07 sb=1.63586e-06 sd=160n sca=23.279 \
        scb=0.0230742 scc=0.00267719 m=(1)
mn21 (\15\:CKbb \10\:CKb \14\:VSS VSS) g45n1hvt w=(1.45e-07) l=4.5e-08 \
        nf=1 as=4.485e-14 ad=2.03e-14 ps=9.8e-07 pd=5.7e-07 nrd=1.16667 \
        nrs=1.16667 sa=1.4e-07 sb=1.23069e-06 sd=160n sca=13.253 \
        scb=0.0137915 scc=0.000695334 m=(1)
mn10 (\5\:S0b \7\:S0 \12\:VSS VSS) g45n1hvt w=(1.45e-07) l=4.5e-08 nf=1 \
        as=3.47e-14 ad=3.045e-14 ps=8.4e-07 pd=7.1e-07 nrd=1.16667 \
        nrs=1.16667 sa=1.16069e-06 sb=2.1e-07 sd=160n sca=11.7118 \
        scb=0.0116498 scc=0.000458536 m=(1)
mn11 (n10 \4\:D0 \14\:VSS VSS) g45n1hvt w=(2.6e-07) l=4.5e-08 nf=1 \
        as=4.485e-14 ad=6.24e-14 ps=9.8e-07 pd=1e-06 nrd=1.16667 \
        nrs=1.16667 sa=2.75673e-07 sb=8.70673e-07 sd=160n sca=10.79 \
        scb=0.0100512 scc=0.000418069 m=(1)
mn12 (D0b \3\:S0b n10 VSS) g45n1hvt w=(2.6e-07) l=4.5e-08 nf=1 \
        as=6.24e-14 ad=4.16e-14 ps=1e-06 pd=8.4e-07 nrd=1.16667 \
        nrs=1.16667 sa=5.60673e-07 sb=5.85673e-07 sd=160n sca=10.79 \
        scb=0.0100512 scc=0.000418069 m=(1)
mn14 (D0b \3\:S0 n12 VSS) g45n1hvt w=(2.6e-07) l=4.5e-08 nf=1 as=1.56e-14 \
        ad=4.16e-14 ps=6.4e-07 pd=8.4e-07 nrd=1.16667 nrs=1.16667 \
        sa=7.65673e-07 sb=3.80673e-07 sd=160n sca=10.79 scb=0.0100512 \
        scc=0.000418069 m=(1)
mn13 (n12 \1\:D1 \12\:VSS VSS) g45n1hvt w=(2.6e-07) l=4.5e-08 nf=1 \
        as=3.47e-14 ad=1.56e-14 ps=8.4e-07 pd=6.4e-07 nrd=1.16667 \
        nrs=1.16667 sa=8.70673e-07 sb=2.75673e-07 sd=160n sca=10.79 \
        scb=0.0100512 scc=0.000418069 m=(1)
mn55_1__rcx (Q qbint \7\:VSS VSS) g45n1hvt w=(2.6e-07) l=4.5e-08 nf=1 \
        as=5.09e-14 ad=4.42e-14 ps=9.3e-07 pd=8.6e-07 nrd=1.16667 \
        nrs=1.16667 sa=2.71058e-07 sb=1.74721e-06 sd=160n sca=17.5885 \
        scb=0.0172826 scc=0.00162584 m=(4)
mn50 (n35 \18\:qbint \7\:VSS VSS) g45n1hvt w=(2.05e-07) l=4.5e-08 nf=1 \
        as=4.51e-14 ad=3.28e-14 ps=8.5e-07 pd=7.3e-07 nrd=1.16667 \
        nrs=1.16667 sa=1.63317e-06 sb=1.94e-06 sd=160n sca=13.8179 \
        scb=0.0141903 scc=0.000851218 m=(1)
mn51 (\7\:n30 \3\:CKb n35 VSS) g45n1hvt w=(2.05e-07) l=4.5e-08 nf=1 \
        as=3.28e-14 ad=4.92e-14 ps=7.3e-07 pd=8.9e-07 nrd=1.16667 \
        nrs=1.16667 sa=1.83817e-06 sb=1.735e-06 sd=160n sca=13.8179 \
        scb=0.0141903 scc=0.000851218 m=(1)
mn40 (\7\:mout \3\:CKbb \7\:n30 VSS) g45n1hvt w=(2.05e-07) l=4.5e-08 nf=1 \
        as=4.92e-14 ad=8.2e-14 ps=8.9e-07 pd=1.21e-06 nrd=1.16667 \
        nrs=1.16667 sa=2e-06 sb=1.45e-06 sd=160n sca=13.8179 scb=0.0141903 \
        scc=0.000851218 m=(1)
mn30 (\7\:mout \3\:n20 \16\:VSS VSS) g45n1hvt w=(2.05e-07) l=4.5e-08 \
        nf=1 as=7.33e-14 ad=8.2e-14 ps=1.32e-06 pd=1.21e-06 nrd=1.16667 \
        nrs=1.16667 sa=2e-06 sb=1.005e-06 sd=160n sca=13.8179 \
        scb=0.0141903 scc=0.000851218 m=(1)
mn35 (n25 \4\:mout \16\:VSS VSS) g45n1hvt w=(2.05e-07) l=4.5e-08 nf=1 \
        as=7.33e-14 ad=2.358e-14 ps=1.32e-06 pd=6.4e-07 nrd=1.16667 \
        nrs=1.16667 sa=2e-06 sb=7.4e-07 sd=160n sca=13.8179 scb=0.0141903 \
        scc=0.000851218 m=(1)
mn36 (\8\:n20 \5\:CKbb n25 VSS) g45n1hvt w=(2.05e-07) l=4.5e-08 nf=1 \
        as=2.358e-14 ad=4.51e-14 ps=6.4e-07 pd=8.5e-07 nrd=1.16667 \
        nrs=1.16667 sa=2e-06 sb=5.8e-07 sd=160n sca=13.8179 scb=0.0141903 \
        scc=0.000851218 m=(1)
mn25 (\8\:D0b \11\:CKb \8\:n20 VSS) g45n1hvt w=(2.05e-07) l=4.5e-08 nf=1 \
        as=4.51e-14 ad=6.458e-14 ps=8.5e-07 pd=1.04e-06 nrd=1.16667 \
        nrs=1.16667 sa=2e-06 sb=3.15e-07 sd=160n sca=13.8179 scb=0.0141903 \
        scc=0.000851218 m=(1)
mn45_1__rcx (\24\:qbint n30 \7\:VSS VSS) g45n1hvt w=(2.05e-07) l=4.5e-08 \
        nf=1 as=4.273e-14 ad=3.28e-14 ps=8.55e-07 pd=7.3e-07 nrd=1.16667 \
        nrs=1.16667 sa=1.16317e-06 sb=2e-06 sd=160n sca=13.8179 \
        scb=0.0141903 scc=0.000851218 m=(2)
mp11 (n11 \1\:D0 \11\:VDD VDD) g45p1hvt w=(3.9e-07) l=4.5e-08 nf=1 \
        as=5.19e-14 ad=2.34e-14 ps=1.1e-06 pd=9e-07 nrd=1.16667 \
        nrs=1.16667 sa=2.35064e-07 sb=8.14359e-07 sd=160n sca=15.0636 \
        scb=0.0136086 scc=0.000948136 m=(1)
mp12 (\4\:D0b \2\:S0 n11 VDD) g45p1hvt w=(3.9e-07) l=4.5e-08 nf=1 \
        as=2.34e-14 ad=7.02e-14 ps=9e-07 pd=1.14e-06 nrd=1.16667 \
        nrs=1.16667 sa=3.40064e-07 sb=7.09359e-07 sd=160n sca=15.0636 \
        scb=0.0136086 scc=0.000948136 m=(1)
mp14 (\4\:D0b S0b n13 VDD) g45p1hvt w=(3.9e-07) l=4.5e-08 nf=1 \
        as=5.655e-14 ad=7.02e-14 ps=1.07e-06 pd=1.14e-06 nrd=1.16667 \
        nrs=1.16667 sa=5.65064e-07 sb=4.84359e-07 sd=160n sca=15.6414 \
        scb=0.0138242 scc=0.000948215 m=(1)
mp13 (n13 \3\:D1 \9\:VDD VDD) g45p1hvt w=(3.9e-07) l=4.5e-08 nf=1 \
        as=7.503e-14 ad=5.655e-14 ps=1.25e-06 pd=1.07e-06 nrd=1.16667 \
        nrs=1.16667 sa=7.55064e-07 sb=2.94359e-07 sd=160n sca=16.7327 \
        scb=0.0148635 scc=0.000950884 m=(1)
mp55_1__rcx (Q qbint \7\:VDD VDD) g45p1hvt w=(3.9e-07) l=4.5e-08 nf=1 \
        as=9.7e-14 ad=6.24e-14 ps=1.605e-06 pd=1.1e-06 nrd=1.16667 \
        nrs=1.16667 sa=2.40577e-07 sb=1.76308e-06 sd=160n sca=18.6093 \
        scb=0.0174808 scc=0.00104939 m=(4)
mp50 (n36 \15\:qbint \7\:VDD VDD) g45p1hvt w=(3.1e-07) l=4.5e-08 nf=1 \
        as=9.76e-14 ad=3.875e-14 ps=1.55e-06 pd=8.7e-07 nrd=1.16667 \
        nrs=1.16667 sa=1.68685e-06 sb=1.78685e-06 sd=160n sca=16.8851 \
        scb=0.0157945 scc=0.0012748 m=(1)
mp51 (\11\:n30 CKbb n36 VDD) g45p1hvt w=(3.1e-07) l=4.5e-08 nf=1 \
        as=3.875e-14 ad=4.96e-14 ps=8.7e-07 pd=9.4e-07 nrd=1.16667 \
        nrs=1.16667 sa=1.85685e-06 sb=1.61685e-06 sd=160n sca=16.8851 \
        scb=0.0157945 scc=0.0012748 m=(1)
mp40 (\11\:n30 \4\:CKb \9\:mout VDD) g45p1hvt w=(3.1e-07) l=4.5e-08 nf=1 \
        as=1.5965e-13 ad=4.96e-14 ps=1.65e-06 pd=9.4e-07 nrd=1.16667 \
        nrs=1.16667 sa=1.96476e-06 sb=1.41185e-06 sd=160n sca=16.8851 \
        scb=0.0157945 scc=0.0012748 m=(1)
mp30 (\9\:mout n20 \13\:VDD VDD) g45p1hvt w=(3.1e-07) l=4.5e-08 nf=1 \
        as=9.16e-14 ad=1.5965e-13 ps=1.45e-06 pd=1.65e-06 nrd=1.16667 \
        nrs=1.16667 sa=2e-06 sb=8.51855e-07 sd=160n sca=16.8851 \
        scb=0.0157945 scc=0.0012748 m=(1)
mp35 (n26 mout \13\:VDD VDD) g45p1hvt w=(3.1e-07) l=4.5e-08 nf=1 \
        as=9.16e-14 ad=4.495e-14 ps=1.45e-06 pd=9.1e-07 nrd=1.16667 \
        nrs=1.16667 sa=2e-06 sb=5.86855e-07 sd=160n sca=16.8851 \
        scb=0.0157945 scc=0.0012748 m=(1)
mp36 (\4\:n20 \8\:CKb n26 VDD) g45p1hvt w=(3.1e-07) l=4.5e-08 nf=1 \
        as=4.495e-14 ad=5.58e-14 ps=9.1e-07 pd=9.8e-07 nrd=1.16667 \
        nrs=1.16667 sa=2e-06 sb=3.96855e-07 sd=160n sca=16.8851 \
        scb=0.0157945 scc=0.0012748 m=(1)
mp25 (\4\:n20 \7\:CKbb \6\:D0b VDD) g45p1hvt w=(3.1e-07) l=4.5e-08 nf=1 \
        as=5.328e-14 ad=5.58e-14 ps=1.15e-06 pd=9.8e-07 nrd=1.16667 \
        nrs=1.16667 sa=2e-06 sb=1.71855e-07 sd=160n sca=16.8851 \
        scb=0.0157945 scc=0.0012748 m=(1)
mp45 (\19\:qbint n30 \7\:VDD VDD) g45p1hvt w=(3.1e-07) l=4.5e-08 nf=1 \
        as=9.96e-14 ad=4.96e-14 ps=1.55e-06 pd=9.4e-07 nrd=1.16667 \
        nrs=1.16667 sa=1.21685e-06 sb=2e-06 sd=160n sca=16.8851 \
        scb=0.0157945 scc=0.0012748 m=(2)
ends MDFFHQX4
// End of subcircuit definition.
