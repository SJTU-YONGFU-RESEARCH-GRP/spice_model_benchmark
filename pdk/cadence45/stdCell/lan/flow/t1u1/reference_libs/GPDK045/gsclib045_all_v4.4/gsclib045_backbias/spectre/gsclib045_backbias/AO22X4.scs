// gsclib045_backbias/AO22X4/schematic

simulator lang=spectre

subckt AO22X4 A0 A1 B0 B1 Y VDD NW VSS
mn3 (n0 B1 n2 VSS) g45n1svt w=(260n) l=45n nf=1 m=(1)
mn2 (n2 B0 VSS VSS) g45n1svt w=(260n) l=45n nf=1 m=(1)
mn1 (n0 A1 n1 VSS) g45n1svt w=(260n) l=45n nf=1 m=(1)
mn0 (n1 A0 VSS VSS) g45n1svt w=(260n) l=45n nf=1 m=(1)
mn4 (Y n0 VSS VSS) g45n1svt w=(1.04u) l=45n nf=1 m=(1)
mp3 (n0 B1 n3 NW) g45p1svt w=(390n) l=45n nf=1 m=(1)
mp2 (n0 B0 n3 NW) g45p1svt w=(390n) l=45n nf=1 m=(1)
mp1 (n3 A1 VDD NW) g45p1svt w=(390n) l=45n nf=1 m=(1)
mp0 (n3 A0 VDD NW) g45p1svt w=(390n) l=45n nf=1 m=(1)
mp4 (Y n0 VDD NW) g45p1svt w=(1.56u) l=45n nf=1 m=(1)
ends AO22X4
