// gsclib045_backbias/NOR2BX1/schematic

simulator lang=spectre

subckt NOR2BX1 AN B Y NW VDD VSS
mn1 (Y net76 VSS VSS) g45n1svt w=(260n) l=45n nf=1 m=(1)
mn2 (Y B VSS VSS) g45n1svt w=(260n) l=45n nf=1 m=(1)
mn0 (net76 AN VSS VSS) g45n1svt w=(145n) l=45n nf=1 m=(1)
mp2 (Y B net59 NW) g45p1svt w=(390n) l=45n nf=1 m=(1)
mp1 (net59 net76 VDD NW) g45p1svt w=(390n) l=45n nf=1 m=(1)
mp0 (net76 AN VDD NW) g45p1svt w=(215n) l=45n nf=1 m=(1)
ends NOR2BX1
