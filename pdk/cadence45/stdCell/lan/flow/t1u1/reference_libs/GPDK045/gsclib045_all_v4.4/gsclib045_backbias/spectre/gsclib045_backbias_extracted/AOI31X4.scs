// Generated for: spectre (May  1 11:27:51 2013 )
// Library name: gsclib045_backbias
// Cell name: AOI31X4
// View name: extracted

simulator lang=spectre

subckt AOI31X4 A0 A1 A2 B0 NW VDD VSS Y
mp2_1__rcx (net89 \1\:A2 \1\:VDD NW) g45p1svt w=(3.9e-07) l=4.5e-08 nf=1 \
        as=6.24e-14 ad=6.24e-14 ps=1.1e-06 pd=1.1e-06 nrd=1.16667 \
        nrs=1.16667 sa=1.78e-06 sb=1.655e-06 sd=160n sca=18.3796 \
        scb=0.0159892 scc=0.00159615 m=(4)
mp1_1__rcx (net89 A1 \4\:VDD NW) g45p1svt w=(3.9e-07) l=4.5e-08 nf=1 \
        as=6.24e-14 ad=6.24e-14 ps=1.1e-06 pd=1.1e-06 nrd=1.16667 \
        nrs=1.16667 sa=9.6e-07 sb=2e-06 sd=160n sca=18.3796 scb=0.0159892 \
        scc=0.00159615 m=(4)
mp3_1__rcx (\4\:Y B0 net89 NW) g45p1svt w=(3.9e-07) l=4.5e-08 nf=1 \
        as=7.361e-14 ad=6.24e-14 ps=1.1575e-06 pd=1.1e-06 nrd=1.16667 \
        nrs=1.16667 sa=2e-06 sb=8.35e-07 sd=160n sca=18.4487 scb=0.016003 \
        scc=0.00159615 m=(4)
mp0_1__rcx (net89 A0 \6\:VDD NW) g45p1svt w=(3.9e-07) l=4.5e-08 nf=1 \
        as=6.24e-14 ad=6.045e-14 ps=1.1e-06 pd=1.09e-06 nrd=1.16667 \
        nrs=1.16667 sa=1.4e-07 sb=2e-06 sd=160n sca=21.912 scb=0.0201637 \
        scc=0.00163433 m=(4)
C1 (A2 VSS) capacitor c=2.86435e-17
C2 (A1 VSS) capacitor c=3.82839e-16
C3 (VDD VSS) capacitor c=4.56508e-17
C4 (NW VSS) capacitor c=4.41877e-16
C5 (B0 VSS) capacitor c=3.52432e-16
C6 (A0 VSS) capacitor c=3.59726e-16
C7 (net97 VSS) capacitor c=3.07341e-16
C8 (net101 VSS) capacitor c=1.48489e-16
C9 (net89 VSS) capacitor c=6.91926e-16
C10 (\1\:A2 VSS) capacitor c=3.28899e-16
C11 (\4\:Y VSS) capacitor c=1.57115e-16
C12 (\1\:VDD VSS) capacitor c=2.99551e-16
C13 (\1\:Y VSS) capacitor c=3.12354e-16
C14 (\4\:net101 VSS) capacitor c=1.53786e-16
C15 (\4\:VDD VSS) capacitor c=1.63831e-16
C16 (\6\:VDD VSS) capacitor c=1.68351e-16
Rk21 (Y \4\:Y) resistor r=0.01331 c=0
Rk20 (\1\:Y Y) resistor r=0.2519 c=0
Rk12 (\1\:A2 A2) resistor r=0.0566 c=0
Rk44 (\1\:VSS \6\:VSS) resistor r=0.8845 c=0
Rk47 (\7\:VSS VSS) resistor r=0.1023 c=0
Rk45 (\6\:VSS \7\:VSS) resistor r=0.2429 c=0
Rk52 (\1\:VDD \4\:VDD) resistor r=0.2051 c=0
Rk56 (\6\:VDD VDD) resistor r=0.2076 c=0
Rk54 (\4\:VDD \6\:VDD) resistor r=0.2051 c=0
Rk14 (net101 \4\:net101) resistor r=0.4187 c=0
Ry19 (\1\:VSS \3\:VSS) resistor r=8.8571 c=0
Ry20 (\6\:VSS \3\:VSS) resistor r=5.1667 c=0
mn2_1__rcx (\1\:Y \1\:A2 net101 VSS) g45n1svt w=(2.6e-07) l=4.5e-08 nf=1 \
        as=4.16e-14 ad=4.03e-14 ps=8.4e-07 pd=8.3e-07 nrd=1.16667 \
        nrs=1.16667 sa=1.4e-07 sb=1.575e-06 sd=160n sca=16.9678 \
        scb=0.0167861 scc=0.00150639 m=(4)
mn3_1__rcx (\1\:Y B0 \1\:VSS VSS) g45n1svt w=(2.6e-07) l=4.5e-08 nf=1 \
        as=4.16e-14 ad=4.03e-14 ps=8.4e-07 pd=8.3e-07 nrd=1.16667 \
        nrs=1.16667 sa=9.6e-07 sb=7.55e-07 sd=160n sca=16.9678 \
        scb=0.0167861 scc=0.00150639 m=(4)
mn0_1__rcx (net97 A0 \7\:VSS VSS) g45n1svt w=(2.6e-07) l=4.5e-08 nf=1 \
        as=4.16e-14 ad=4.03e-14 ps=8.4e-07 pd=8.3e-07 nrd=1.16667 \
        nrs=1.16667 sa=1.4e-07 sb=1.575e-06 sd=160n sca=10.79 \
        scb=0.0100512 scc=0.000418069 m=(4)
mn1_1__rcx (\4\:net101 A1 net97 VSS) g45n1svt w=(2.6e-07) l=4.5e-08 nf=1 \
        as=4.03e-14 ad=4.16e-14 ps=8.3e-07 pd=8.4e-07 nrd=1.16667 \
        nrs=1.16667 sa=9.6e-07 sb=7.55e-07 sd=160n sca=10.79 scb=0.0100512 \
        scc=0.000418069 m=(4)
ends AOI31X4
// End of subcircuit definition.
