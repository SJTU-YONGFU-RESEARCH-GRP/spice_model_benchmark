// gsclib045_hvt/AND2X1/schematic

simulator lang=spectre

subckt AND2X1 A B Y VDD VSS
mp1 (n0 B VDD VDD) g45p1hvt w=(215n) l=45n nf=1 m=(1)
mp0 (n0 A VDD VDD) g45p1hvt w=(215n) l=45n nf=1 m=(1)
mp2 (Y n0 VDD VDD) g45p1hvt w=(390n) l=45n nf=1 m=(1)
mn2 (Y n0 VSS VSS) g45n1hvt w=(260n) l=45n nf=1 m=(1)
mn0 (net127 B VSS VSS) g45n1hvt w=(145n) l=45n nf=1 m=(1)
mn1 (n0 A net127 VSS) g45n1hvt w=(145n) l=45n nf=1 m=(1)
ends AND2X1
