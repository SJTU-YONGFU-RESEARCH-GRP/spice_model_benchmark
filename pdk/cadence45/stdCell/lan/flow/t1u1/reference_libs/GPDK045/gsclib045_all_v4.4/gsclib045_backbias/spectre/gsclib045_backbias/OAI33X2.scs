// gsclib045_backbias/OAI33X2/schematic

simulator lang=spectre

subckt OAI33X2 A0 A1 A2 B0 B1 B2 Y NW VSS VDD
mn0 (n0 A0 VSS VSS) g45n1svt w=(520n) l=45n nf=1 m=(1)
mn4 (Y B0 n0 VSS) g45n1svt w=(520n) l=45n nf=1 m=(1)
mn3 (Y B1 n0 VSS) g45n1svt w=(520n) l=45n nf=1 m=(1)
mn1 (n0 A1 VSS VSS) g45n1svt w=(520n) l=45n nf=1 m=(1)
mn2 (n0 A2 VSS VSS) g45n1svt w=(520n) l=45n nf=1 m=(1)
mn5 (Y B2 n0 VSS) g45n1svt w=(520n) l=45n nf=1 m=(1)
mp1 (n2 A1 n1 NW) g45p1svt w=(790n) l=45n nf=1 m=(1)
mp4 (n4 B0 n3 NW) g45p1svt w=(790n) l=45n nf=1 m=(1)
mp3 (n3 B1 VDD NW) g45p1svt w=(790n) l=45n nf=1 m=(1)
mp5 (Y B2 n4 NW) g45p1svt w=(790n) l=45n nf=1 m=(1)
mp0 (n1 A0 VDD NW) g45p1svt w=(790n) l=45n nf=1 m=(1)
mp2 (Y A2 n2 NW) g45p1svt w=(790n) l=45n nf=1 m=(1)
ends OAI33X2
