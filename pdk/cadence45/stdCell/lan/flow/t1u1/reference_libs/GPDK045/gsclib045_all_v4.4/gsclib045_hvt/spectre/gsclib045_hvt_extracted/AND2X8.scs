// Generated for: spectre (May  1 09:12:10 2013 )
// Library name: gsclib045_hvt
// Cell name: AND2X8
// View name: extracted

simulator lang=spectre

subckt AND2X8 A B VDD VSS Y
mp1_1__rcx (\27\:n0 \1\:B \19\:VDD VDD) g45p1hvt w=(3.9e-07) l=4.5e-08 \
        nf=1 as=6.24e-14 ad=6.24e-14 ps=1.1e-06 pd=1.1e-06 nrd=1.16667 \
        nrs=1.16667 sa=3.45e-07 sb=2e-06 sd=160n sca=16.1462 scb=0.0152434 \
        scc=0.000513123 m=(2)
mp0_1__rcx (\27\:n0 \2\:A VDD VDD) g45p1hvt w=(3.9e-07) l=4.5e-08 nf=1 \
        as=6.612e-14 ad=6.24e-14 ps=1.16e-06 pd=1.1e-06 nrd=1.16667 \
        nrs=1.16667 sa=1.4e-07 sb=2e-06 sd=160n sca=25.31 scb=0.0290957 \
        scc=0.00167407 m=(2)
C1 (Y VSS) capacitor c=1.66113e-17
C2 (B VSS) capacitor c=9.42672e-17
C3 (VDD VSS) capacitor c=5.12501e-16
C4 (A VSS) capacitor c=2.68405e-17
C5 (n0 VSS) capacitor c=5.84613e-16
C6 (8 VSS) capacitor c=1.77389e-18
C7 (\1\:B VSS) capacitor c=1.37391e-16
C8 (\6\:A VSS) capacitor c=6.28277e-17
C9 (\6\:B VSS) capacitor c=5.73994e-17
C10 (\5\:B VSS) capacitor c=5.31912e-17
C11 (\1\:A VSS) capacitor c=4.75057e-17
C12 (\2\:A VSS) capacitor c=3.64373e-16
C13 (\1\:Y VSS) capacitor c=3.78702e-16
C14 (\19\:VDD VSS) capacitor c=6.707e-17
C15 (\1\:VDD VSS) capacitor c=2.21237e-17
C16 (\30\:n0 VSS) capacitor c=8.99072e-17
C17 (\26\:n0 VSS) capacitor c=8.58609e-17
C18 (\27\:n0 VSS) capacitor c=2.18554e-16
C19 (\4\:Y VSS) capacitor c=3.96174e-16
Rk12 (\1\:Y Y) resistor r=0.1251 c=0
Rk13 (Y \4\:Y) resistor r=0.08761 c=0
Rk1 (\8\:B B) resistor r=0.003831 c=0
Rk38 (\2\:VSS \3\:VSS) resistor r=0.1855 c=0
Rk44 (\8\:VSS VSS) resistor r=0.04973 c=0
Rk43 (\3\:VSS \8\:VSS) resistor r=0.3509 c=0
Rk49 (\8\:VSS \18\:VSS) resistor r=0.2689 c=0
Rk25 (\2\:VDD VDD) resistor r=0.1579 c=0
Rk37 (VDD \20\:VDD) resistor r=0.2723 c=0
Rk3 (\2\:A A) resistor r=0.1048 c=0
Rk6 (n0 \26\:n0) resistor r=0.2209 c=0
Rk7 (\26\:n0 \27\:n0) resistor r=0.3448 c=0
Rk9 (\26\:n0 \31\:n0) resistor r=0.532 c=0
Rl7 (\1\:B \6\:B) resistor r=97.7911 c=0
Rl6 (\1\:B \5\:B) resistor r=97.7911 c=0
Rl10 (\2\:A \6\:A) resistor r=32.0055 c=0
Rl1 (\2\:A \1\:A) resistor r=32.6923 c=0
Rz12 (\18\:VSS \17\:VSS) resistor r=37.5 c=0
Rz7 (VDD \1\:VDD) resistor r=6.25 c=0
Rz6 (\2\:VDD \1\:VDD) resistor r=75 c=0
Rz1 (\31\:n0 \30\:n0) resistor r=37.5 c=0
Ry13 (\2\:VSS \1\:VSS) resistor r=62 c=0
Ry14 (\3\:VSS \1\:VSS) resistor r=5.1667 c=0
Ry12 (\20\:VDD \19\:VDD) resistor r=31 c=0
Rx1 (\8\:B \1\:B) resistor r=45 c=0
mn0_1__rcx (7 \1\:A \17\:VSS VSS) g45n1hvt w=(2.6e-07) l=4.5e-08 nf=1 \
        as=3.64e-14 ad=1.82e-14 ps=8e-07 pd=6.6e-07 nrd=1.16667 \
        nrs=1.16667 sa=1.4e-07 sb=2e-06 sd=160n sca=10.5507 scb=0.0097116 \
        scc=0.000384728 m=(1)
mn1_1__rcx (\30\:n0 \5\:B 7 VSS) g45n1hvt w=(2.6e-07) l=4.5e-08 nf=1 \
        as=1.82e-14 ad=4.16e-14 ps=6.6e-07 pd=8.4e-07 nrd=1.16667 \
        nrs=1.16667 sa=2.55e-07 sb=1.955e-06 sd=160n sca=10.5507 \
        scb=0.0097116 scc=0.000384728 m=(1)
mn1 (\30\:n0 \6\:B 8 VSS) g45n1hvt w=(2.6e-07) l=4.5e-08 nf=1 as=1.56e-14 \
        ad=4.16e-14 ps=6.4e-07 pd=8.4e-07 nrd=1.16667 nrs=1.16667 \
        sa=4.6e-07 sb=1.75e-06 sd=160n sca=10.5507 scb=0.0097116 \
        scc=0.000384728 m=(1)
mn0 (8 \6\:A \3\:VSS VSS) g45n1hvt w=(2.6e-07) l=4.5e-08 nf=1 \
        as=6.47e-14 ad=1.56e-14 ps=1.05e-06 pd=6.4e-07 nrd=1.16667 \
        nrs=1.16667 sa=5.65e-07 sb=1.645e-06 sd=160n sca=10.5507 \
        scb=0.0097116 scc=0.000384728 m=(1)
mn2_1__rcx (\4\:Y n0 \3\:VSS VSS) g45n1hvt w=(2.95e-07) l=4.5e-08 nf=1 \
        as=4.97e-14 ad=4.636e-14 ps=9.3e-07 pd=9.0429e-07 nrd=1.16667 \
        nrs=1.16667 sa=7.56949e-07 sb=1.37e-06 sd=160n sca=10.0255 \
        scb=0.00888998 scc=0.000340749 m=(7)
mp2_1__rcx (\1\:Y n0 VDD VDD) g45p1hvt w=(4.45e-07) l=4.5e-08 nf=1 \
        as=7.212e-14 ad=6.993e-14 ps=1.21714e-06 pd=1.20429e-06 \
        nrd=1.16667 nrs=1.16667 sa=8.75618e-07 sb=1.37e-06 sd=160n \
        sca=15.1493 scb=0.013431 scc=0.000976912 m=(7)
ends AND2X8
// End of subcircuit definition.
