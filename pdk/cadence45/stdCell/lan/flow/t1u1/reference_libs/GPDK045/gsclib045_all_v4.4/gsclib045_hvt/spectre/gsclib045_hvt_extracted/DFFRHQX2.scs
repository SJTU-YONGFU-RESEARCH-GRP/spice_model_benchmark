// Generated for: spectre (May  1 09:14:31 2013 )
// Library name: gsclib045_hvt
// Cell name: DFFRHQX2
// View name: extracted

simulator lang=spectre

subckt DFFRHQX2 CK D Q RN VDD VSS
mp55_1__rcx (\3\:Q qbint VDD VDD) g45p1hvt w=(3.9e-07) l=4.5e-08 nf=1 \
        as=5.379e-14 ad=6.24e-14 ps=1.085e-06 pd=1.1e-06 nrd=1.16667 \
        nrs=1.16667 sa=1.4e-07 sb=4.42821e-07 sd=160n sca=38.817 \
        scb=0.037485 scc=0.00407535 m=(2)
C1 (Q VSS) capacitor c=2.67224e-17
C2 (CK VSS) capacitor c=6.04692e-17
C3 (D VSS) capacitor c=7.35457e-17
C4 (VDD VSS) capacitor c=4.02381e-16
C5 (RN VSS) capacitor c=4.90791e-17
C6 (qbint VSS) capacitor c=1.38277e-16
C7 (CKb VSS) capacitor c=4.63368e-17
C8 (n35 VSS) capacitor c=1.73071e-18
C9 (n30 VSS) capacitor c=3.7669e-17
C10 (n40 VSS) capacitor c=3.50006e-18
C11 (mout VSS) capacitor c=4.61242e-17
C12 (CKbb VSS) capacitor c=2.65043e-17
C13 (n20 VSS) capacitor c=4.21675e-17
C14 (n27 VSS) capacitor c=5.23137e-18
C15 (n25 VSS) capacitor c=4.78744e-18
C16 (n21 VSS) capacitor c=1.56139e-18
C17 (n41 VSS) capacitor c=3.90696e-18
C18 (n26 VSS) capacitor c=7.61497e-17
C19 (n22 VSS) capacitor c=1.67153e-18
C20 (\8\:CKb VSS) capacitor c=3.68791e-17
C21 (\1\:D VSS) capacitor c=9.61385e-17
C22 (\6\:CKbb VSS) capacitor c=6.13336e-17
C23 (\7\:CKb VSS) capacitor c=2.93969e-17
C24 (\2\:RN VSS) capacitor c=1.23797e-16
C25 (\3\:n20 VSS) capacitor c=5.33397e-17
C26 (\3\:CKb VSS) capacitor c=3.35718e-17
C27 (\3\:CKbb VSS) capacitor c=6.94947e-17
C28 (\8\:qbint VSS) capacitor c=7.83365e-17
C29 (\3\:RN VSS) capacitor c=8.44483e-17
C30 (\3\:n30 VSS) capacitor c=5.11385e-17
C31 (\3\:CK VSS) capacitor c=4.17663e-17
C32 (\9\:CKb VSS) capacitor c=3.29451e-17
C33 (\3\:D VSS) capacitor c=5.73365e-17
C34 (\5\:CKb VSS) capacitor c=6.54594e-17
C35 (\4\:CKbb VSS) capacitor c=3.88447e-17
C36 (\3\:mout VSS) capacitor c=3.39951e-17
C37 (\1\:RN VSS) capacitor c=7.39762e-17
C38 (\10\:qbint VSS) capacitor c=3.93995e-17
C39 (\5\:RN VSS) capacitor c=9.56038e-17
C40 (\1\:CK VSS) capacitor c=3.11582e-17
C41 (\10\:CKb VSS) capacitor c=2.76559e-17
C42 (\2\:D VSS) capacitor c=4.60671e-17
C43 (\7\:CKbb VSS) capacitor c=3.39369e-17
C44 (\6\:CKb VSS) capacitor c=3.48999e-17
C45 (\5\:CKbb VSS) capacitor c=3.24123e-17
C46 (\2\:mout VSS) capacitor c=3.51573e-17
C47 (\2\:n20 VSS) capacitor c=4.89389e-17
C48 (\4\:CKb VSS) capacitor c=3.47598e-17
C49 (\2\:CKbb VSS) capacitor c=5.05446e-17
C50 (\2\:CKb VSS) capacitor c=4.41405e-17
C51 (\9\:qbint VSS) capacitor c=6.76246e-17
C52 (\4\:RN VSS) capacitor c=4.29336e-17
C53 (\2\:n30 VSS) capacitor c=4.65619e-17
C54 (\2\:CK VSS) capacitor c=4.60174e-17
C55 (\6\:qbint VSS) capacitor c=1.67235e-17
C56 (\10\:CKbb VSS) capacitor c=2.80507e-17
C57 (\1\:VDD VSS) capacitor c=4.19045e-17
C58 (\4\:n20 VSS) capacitor c=7.72332e-17
C59 (\13\:VDD VSS) capacitor c=2.79846e-17
C60 (\3\:n26 VSS) capacitor c=6.50166e-17
C61 (\15\:VDD VSS) capacitor c=4.28146e-17
C62 (\8\:mout VSS) capacitor c=5.71849e-17
C63 (\8\:n30 VSS) capacitor c=9.83476e-17
C64 (\17\:VDD VSS) capacitor c=3.69546e-17
C65 (\16\:qbint VSS) capacitor c=6.86365e-17
C66 (\19\:VDD VSS) capacitor c=3.71577e-17
C67 (\16\:CKb VSS) capacitor c=4.28692e-17
C68 (\3\:Q VSS) capacitor c=9.60914e-17
C69 (\3\:VDD VSS) capacitor c=5.21416e-17
C70 (\8\:CKbb VSS) capacitor c=1.23946e-17
C71 (\8\:n20 VSS) capacitor c=5.57202e-17
C72 (\6\:mout VSS) capacitor c=4.28086e-17
C73 (\4\:n30 VSS) capacitor c=2.44898e-17
C74 (\13\:qbint VSS) capacitor c=1.45063e-16
C75 (\21\:CKb VSS) capacitor c=1.07249e-16
C76 (\1\:Q VSS) capacitor c=1.91387e-17
C77 (\4\:CK VSS) capacitor c=5.21964e-17
C78 (\11\:qbint VSS) capacitor c=4.49686e-17
C79 (\12\:qbint VSS) capacitor c=8.89612e-17
C80 (\15\:qbint VSS) capacitor c=1.43006e-16
C81 (\6\:RN VSS) capacitor c=6.07465e-17
C82 (\6\:n30 VSS) capacitor c=9.08657e-17
C83 (\7\:n30 VSS) capacitor c=1.03742e-16
C84 (\4\:mout VSS) capacitor c=1.11117e-16
C85 (\5\:mout VSS) capacitor c=8.9278e-17
C86 (\6\:n20 VSS) capacitor c=1.27996e-16
C87 (\7\:n20 VSS) capacitor c=1.05304e-16
C88 (\4\:D VSS) capacitor c=4.12362e-17
C89 (\12\:CKbb VSS) capacitor c=1.20044e-16
C90 (\13\:CKbb VSS) capacitor c=2.72705e-16
C91 (\14\:CKbb VSS) capacitor c=1.43734e-16
C92 (\15\:CKbb VSS) capacitor c=4.24751e-17
C93 (\16\:CKbb VSS) capacitor c=4.07531e-17
C94 (\11\:CKb VSS) capacitor c=5.75064e-17
C95 (\12\:CKb VSS) capacitor c=1.94629e-16
C96 (\13\:CKb VSS) capacitor c=1.59537e-16
C97 (\14\:CKb VSS) capacitor c=1.54872e-16
C98 (\15\:CKb VSS) capacitor c=1.43356e-16
C99 (\18\:CKb VSS) capacitor c=9.07164e-17
C100 (\19\:CKb VSS) capacitor c=5.94432e-17
C101 (\20\:CKb VSS) capacitor c=8.27081e-17
C102 (\5\:VDD VSS) capacitor c=1.58222e-17
C103 (\6\:VDD VSS) capacitor c=3.96628e-17
C104 (\7\:VDD VSS) capacitor c=4.02747e-17
C105 (\9\:VDD VSS) capacitor c=9.52135e-18
Rk1 (Q \2\:Q) resistor r=0.04515 c=0
Rk2 (Q \4\:Q) resistor r=0.2679 c=0
Rk3 (\4\:CK CK) resistor r=0.09453 c=0
Rk19 (\4\:D D) resistor r=0.06815 c=0
Rk35 (\2\:VDD \4\:VDD) resistor r=0.4765 c=0
Rk36 (\4\:VDD \5\:VDD) resistor r=0.09171 c=0
Rk37 (\5\:VDD \6\:VDD) resistor r=0.3224 c=0
Rk38 (\6\:VDD \7\:VDD) resistor r=0.4689 c=0
Rk39 (\7\:VDD \8\:VDD) resistor r=0.2683 c=0
Rk41 (\9\:VDD VDD) resistor r=0.2606 c=0
Rk40 (\8\:VDD \9\:VDD) resistor r=0.08262 c=0
Rk44 (\5\:VDD \14\:VDD) resistor r=0.04335 c=0
Rk45 (\6\:VDD \16\:VDD) resistor r=0.2096 c=0
Rk46 (\7\:VDD \18\:VDD) resistor r=0.1805 c=0
Rk47 (\9\:VDD \20\:VDD) resistor r=0.1875 c=0
Rk8 (\6\:RN RN) resistor r=0.1845 c=0
Rk49 (\2\:VSS \3\:VSS) resistor r=0.2155 c=0
Rk50 (\3\:VSS \5\:VSS) resistor r=0.2257 c=0
Rk51 (\5\:VSS \6\:VSS) resistor r=0.3135 c=0
Rk52 (\6\:VSS \7\:VSS) resistor r=0.632 c=0
Rk54 (\8\:VSS VSS) resistor r=0.3587 c=0
Rk53 (\7\:VSS \8\:VSS) resistor r=0.2081 c=0
Rk57 (\3\:VSS \13\:VSS) resistor r=0.1267 c=0
Rk58 (\6\:VSS \15\:VSS) resistor r=0.2275 c=0
Rk59 (\7\:VSS \17\:VSS) resistor r=0.2208 c=0
Rk4 (\11\:qbint \12\:qbint) resistor r=0.2714 c=0
Rk5 (\12\:qbint \14\:qbint) resistor r=0.5122 c=0
Rk6 (\14\:qbint \15\:qbint) resistor r=0.9016 c=0
Rk7 (\12\:qbint \17\:qbint) resistor r=0.2925 c=0
Rk26 (\11\:CKb \12\:CKb) resistor r=0.2599 c=0
Rk27 (\12\:CKb \13\:CKb) resistor r=1.1332 c=0
Rk28 (\13\:CKb \14\:CKb) resistor r=0.33 c=0
Rk29 (\14\:CKb \15\:CKb) resistor r=0.9125 c=0
Rk30 (\15\:CKb \17\:CKb) resistor r=0.1733 c=0
Rk31 (\12\:CKb \18\:CKb) resistor r=0.671 c=0
Rk32 (\13\:CKb \19\:CKb) resistor r=0.2443 c=0
Rk33 (\14\:CKb \20\:CKb) resistor r=0.4177 c=0
Rk34 (\15\:CKb \22\:CKb) resistor r=0.5405 c=0
Rk9 (\5\:n30 \6\:n30) resistor r=0.06464 c=0
Rk10 (\6\:n30 \7\:n30) resistor r=0.5524 c=0
Rk11 (\6\:n30 \9\:n30) resistor r=0.4387 c=0
Rk12 (\4\:mout \5\:mout) resistor r=0.5666 c=0
Rk13 (\5\:mout \7\:mout) resistor r=0.1136 c=0
Rk14 (\5\:mout \9\:mout) resistor r=0.2503 c=0
Rk20 (\9\:CKbb \11\:CKbb) resistor r=0.3278 c=0
Rk21 (\11\:CKbb \12\:CKbb) resistor r=0.1211 c=0
Rk22 (\12\:CKbb \13\:CKbb) resistor r=1.2314 c=0
Rk23 (\13\:CKbb \14\:CKbb) resistor r=1.1897 c=0
Rk24 (\12\:CKbb \15\:CKbb) resistor r=0.2186 c=0
Rk25 (\13\:CKbb \16\:CKbb) resistor r=0.1211 c=0
Rk16 (\5\:n20 \6\:n20) resistor r=0.3851 c=0
Rk17 (\6\:n20 \7\:n20) resistor r=0.6748 c=0
Rk18 (\6\:n20 \9\:n20) resistor r=0.2067 c=0
Rk15 (\2\:n26 \4\:n26) resistor r=0.2574 c=0
Rl8 (\2\:CK \3\:CK) resistor r=110.989 c=0
Rl7 (\1\:CK \2\:CK) resistor r=78.8462 c=0
Rl29 (\1\:D \2\:D) resistor r=122.31 c=0
Rl30 (\2\:D \3\:D) resistor r=135.155 c=0
Rl20 (\2\:RN \3\:RN) resistor r=639.95 c=0
Rl19 (\1\:RN \2\:RN) resistor r=180.335 c=0
Rl21 (\3\:RN \4\:RN) resistor r=24.2328 c=0
Rl22 (\4\:RN \5\:RN) resistor r=198.905 c=0
Rl11 (\9\:qbint \8\:qbint) resistor r=139.125 c=0
Rl12 (\9\:qbint \10\:qbint) resistor r=51.098 c=0
Rl5 (qbint \6\:qbint) resistor r=4.3693 c=0
Rl31 (\8\:CKb \9\:CKb) resistor r=101.923 c=0
Rl32 (\8\:CKb \10\:CKb) resistor r=57.2054 c=0
Rl27 (\6\:CKb \7\:CKb) resistor r=24.2328 c=0
Rl26 (\5\:CKb \6\:CKb) resistor r=143.832 c=0
Rl14 (\3\:CKb \4\:CKb) resistor r=30.0021 c=0
Rl13 (CKb \2\:CKb) resistor r=53.079 c=0
Rl10 (\2\:n30 \3\:n30) resistor r=219.646 c=0
Rl9 (n30 \2\:n30) resistor r=24.2328 c=0
Rl23 (mout \2\:mout) resistor r=97.3098 c=0
Rl24 (\2\:mout \3\:mout) resistor r=24.2328 c=0
Rl28 (\6\:CKbb \7\:CKbb) resistor r=24.2328 c=0
Rl25 (\4\:CKbb \5\:CKbb) resistor r=24.2328 c=0
Rl16 (\2\:CKbb \3\:CKbb) resistor r=147.197 c=0
Rl15 (CKbb \2\:CKbb) resistor r=24.2328 c=0
Rl18 (\2\:n20 \3\:n20) resistor r=78.4003 c=0
Rl17 (n20 \2\:n20) resistor r=97.3098 c=0
Rz1 (\2\:Q \1\:Q) resistor r=75 c=0
Rz8 (\4\:VDD \3\:VDD) resistor r=6.8182 c=0
Rz9 (\8\:VDD \3\:VDD) resistor r=6.25 c=0
Rz10 (\2\:VSS \1\:VSS) resistor r=75 c=0
Rz12 (\13\:VSS \12\:VSS) resistor r=75 c=0
Rz13 (\15\:VSS \14\:VSS) resistor r=75 c=0
Rz14 (\17\:VSS \16\:VSS) resistor r=75 c=0
Rz2 (\14\:qbint \13\:qbint) resistor r=75 c=0
Rz7 (\21\:CKb \22\:CKb) resistor r=75 c=0
Rz3 (\4\:n30 \5\:n30) resistor r=75 c=0
Rz4 (\6\:mout \7\:mout) resistor r=75 c=0
Rz6 (\8\:CKbb \9\:CKbb) resistor r=75 c=0
Rz5 (\8\:n20 \9\:n20) resistor r=75 c=0
Ry1 (\4\:Q \3\:Q) resistor r=20.6667 c=0
Ry10 (\2\:VDD \1\:VDD) resistor r=62 c=0
Ry12 (\14\:VDD \13\:VDD) resistor r=62 c=0
Ry13 (\16\:VDD \15\:VDD) resistor r=62 c=0
Ry14 (\18\:VDD \17\:VDD) resistor r=62 c=0
Ry15 (\20\:VDD \19\:VDD) resistor r=62 c=0
Ry17 (\5\:VSS \4\:VSS) resistor r=5.6364 c=0
Ry18 (\8\:VSS \4\:VSS) resistor r=5.1667 c=0
Ry2 (\17\:qbint \16\:qbint) resistor r=62 c=0
Ry9 (\16\:CKb \17\:CKb) resistor r=62 c=0
Ry3 (\8\:n30 \9\:n30) resistor r=62 c=0
Ry4 (\8\:mout \9\:mout) resistor r=62 c=0
Ry8 (\10\:CKbb \11\:CKbb) resistor r=62 c=0
Ry7 (\4\:n20 \5\:n20) resistor r=62 c=0
Ry5 (n26 \2\:n26) resistor r=62 c=0
Ry6 (\3\:n26 \4\:n26) resistor r=62 c=0
Rx1 (\2\:CK \4\:CK) resistor r=45 c=0
Rx8 (\2\:D \4\:D) resistor r=45 c=0
Rx4 (\4\:RN \6\:RN) resistor r=45 c=0
Rx2 (\11\:qbint \9\:qbint) resistor r=45 c=0
Rx3 (\15\:qbint \6\:qbint) resistor r=45 c=0
Rx12 (\6\:CKb \11\:CKb) resistor r=45 c=0
Rx13 (\10\:CKb \18\:CKb) resistor r=45 c=0
Rx14 (\4\:CKb \19\:CKb) resistor r=45 c=0
Rx15 (\2\:CKb \20\:CKb) resistor r=45 c=0
Rx5 (\2\:n30 \7\:n30) resistor r=45 c=0
Rx6 (\2\:mout \4\:mout) resistor r=45 c=0
Rx9 (\2\:CKbb \14\:CKbb) resistor r=45 c=0
Rx10 (\7\:CKbb \15\:CKbb) resistor r=45 c=0
Rx11 (\5\:CKbb \16\:CKbb) resistor r=45 c=0
Rx7 (\2\:n20 \7\:n20) resistor r=45 c=0
mn55_1__rcx (\1\:Q qbint VSS VSS) g45n1hvt w=(2.6e-07) l=4.5e-08 nf=1 \
        as=4.135e-14 ad=4.16e-14 ps=9e-07 pd=8.4e-07 nrd=1.16667 \
        nrs=1.16667 sa=1.4e-07 sb=5.78269e-07 sd=160n sca=16.3874 \
        scb=0.0162972 scc=0.00139495 m=(2)
mn20 (\21\:CKb \1\:CK VSS VSS) g45n1hvt w=(1.45e-07) l=4.5e-08 nf=1 \
        as=4.63e-14 ad=4.422e-14 ps=1e-06 pd=9e-07 nrd=1.16667 nrs=1.16667 \
        sa=6.3e-07 sb=3.05e-07 sd=160n sca=10.9472 scb=0.0104991 \
        scc=0.000356047 m=(1)
mn21 (\8\:CKbb \9\:CKb \1\:VSS VSS) g45n1hvt w=(1.45e-07) l=4.5e-08 nf=1 \
        as=7.685e-14 ad=2.03e-14 ps=1.5e-06 pd=5.7e-07 nrd=1.16667 \
        nrs=1.16667 sa=1.7e-07 sb=1.4e-07 sd=160n sca=23.279 scb=0.0230742 \
        scc=0.00267719 m=(1)
mn46 (\13\:qbint n30 n35 VSS) g45n1hvt w=(2.05e-07) l=4.5e-08 nf=1 \
        as=1.743e-14 ad=4.202e-14 ps=5.8e-07 pd=8.2e-07 nrd=1.16667 \
        nrs=1.16667 sa=2.05e-07 sb=1.44024e-06 sd=160n sca=9.00745 \
        scb=0.0073653 scc=0.000173562 m=(1)
mn45 (n35 \5\:RN \16\:VSS VSS) g45n1hvt w=(2.05e-07) l=4.5e-08 nf=1 \
        as=3.28e-14 ad=1.743e-14 ps=7.3e-07 pd=5.8e-07 nrd=1.16667 \
        nrs=1.16667 sa=3.35e-07 sb=1.38634e-06 sd=160n sca=9.00745 \
        scb=0.0073653 scc=0.000173562 m=(1)
mn50 (n40 \10\:qbint \16\:VSS VSS) g45n1hvt w=(2.05e-07) l=4.5e-08 nf=1 \
        as=3.28e-14 ad=3.485e-14 ps=7.3e-07 pd=7.5e-07 nrd=1.16667 \
        nrs=1.16667 sa=5.4e-07 sb=1.30134e-06 sd=160n sca=9.00745 \
        scb=0.0073653 scc=0.000173562 m=(1)
mn51 (\4\:n30 CKb n40 VSS) g45n1hvt w=(2.05e-07) l=4.5e-08 nf=1 \
        as=3.485e-14 ad=4.82e-14 ps=7.5e-07 pd=1.1e-06 nrd=1.16667 \
        nrs=1.16667 sa=7.55e-07 sb=1.2122e-06 sd=160n sca=9.00745 \
        scb=0.0073653 scc=0.000173562 m=(1)
mn40 (\4\:n30 CKbb \6\:mout VSS) g45n1hvt w=(2.05e-07) l=4.5e-08 nf=1 \
        as=8.61e-14 ad=4.82e-14 ps=1.25e-06 pd=1.1e-06 nrd=1.16667 \
        nrs=1.16667 sa=6.61951e-07 sb=1.81e-06 sd=160n sca=13.0797 \
        scb=0.0132969 scc=0.000723565 m=(1)
mn30 (\6\:mout n20 \14\:VSS VSS) g45n1hvt w=(2.05e-07) l=4.5e-08 nf=1 \
        as=6.23e-14 ad=8.61e-14 ps=1.08e-06 pd=1.25e-06 nrd=1.16667 \
        nrs=1.16667 sa=1.12695e-06 sb=1.345e-06 sd=160n sca=13.0797 \
        scb=0.0132969 scc=0.000723565 m=(1)
mn35 (n27 \1\:RN \14\:VSS VSS) g45n1hvt w=(2.05e-07) l=4.5e-08 nf=1 \
        as=6.23e-14 ad=3.28e-14 ps=1.08e-06 pd=7.3e-07 nrd=1.16667 \
        nrs=1.16667 sa=1.43195e-06 sb=1.04e-06 sd=160n sca=13.0797 \
        scb=0.0132969 scc=0.000723565 m=(1)
mn36 (n25 \3\:mout n27 VSS) g45n1hvt w=(2.05e-07) l=4.5e-08 nf=1 \
        as=3.28e-14 ad=3.588e-14 ps=7.3e-07 pd=7.6e-07 nrd=1.16667 \
        nrs=1.16667 sa=1.61646e-06 sb=8.35e-07 sd=160n sca=13.0797 \
        scb=0.0132969 scc=0.000723565 m=(1)
mn37 (\8\:n20 \4\:CKbb n25 VSS) g45n1hvt w=(2.05e-07) l=4.5e-08 nf=1 \
        as=3.588e-14 ad=5.228e-14 ps=7.6e-07 pd=9.2e-07 nrd=1.16667 \
        nrs=1.16667 sa=1.70768e-06 sb=6.15e-07 sd=160n sca=13.0797 \
        scb=0.0132969 scc=0.000723565 m=(1)
mn26 (\8\:n20 \5\:CKb n21 VSS) g45n1hvt w=(2.05e-07) l=4.5e-08 nf=1 \
        as=2.05e-14 ad=5.228e-14 ps=6.1e-07 pd=9.2e-07 nrd=1.16667 \
        nrs=1.16667 sa=1.83207e-06 sb=3.15e-07 sd=160n sca=13.0797 \
        scb=0.0132969 scc=0.000723565 m=(1)
mn25 (n21 \3\:D \12\:VSS VSS) g45n1hvt w=(2.05e-07) l=4.5e-08 nf=1 \
        as=6.185e-14 ad=2.05e-14 ps=1.2e-06 pd=6.1e-07 nrd=1.16667 \
        nrs=1.16667 sa=1.8922e-06 sb=1.7e-07 sd=160n sca=13.0797 \
        scb=0.0132969 scc=0.000723565 m=(1)
mp20 (\16\:CKb \3\:CK VDD VDD) g45p1hvt w=(2.15e-07) l=4.5e-08 nf=1 \
        as=5.297e-14 ad=3.01e-14 ps=1.11e-06 pd=7.1e-07 nrd=1.16667 \
        nrs=1.16667 sa=5.55e-07 sb=1.4e-07 sd=160n sca=13.3166 \
        scb=0.0115053 scc=0.000332937 m=(1)
mp21 (\10\:CKbb \8\:CKb \1\:VDD VDD) g45p1hvt w=(2.15e-07) l=4.5e-08 \
        nf=1 as=6.99e-14 ad=3.01e-14 ps=1.85e-06 pd=7.1e-07 nrd=1.16667 \
        nrs=1.16667 sa=1.91279e-07 sb=1.4e-07 sd=160n sca=43.6839 \
        scb=0.0409846 scc=0.00506402 m=(1)
mp46 (\16\:qbint \3\:n30 \19\:VDD VDD) g45p1hvt w=(3.1e-07) l=4.5e-08 \
        nf=1 as=7.905e-14 ad=6.51e-14 ps=1.13e-06 pd=1.04e-06 nrd=1.16667 \
        nrs=1.16667 sa=2.55e-07 sb=1.17194e-06 sd=160n sca=10.6008 \
        scb=0.00822388 scc=0.000121216 m=(1)
mp45 (\16\:qbint \3\:RN \17\:VDD VDD) g45p1hvt w=(3.1e-07) l=4.5e-08 \
        nf=1 as=9.685e-14 ad=6.51e-14 ps=1.53e-06 pd=1.04e-06 nrd=1.16667 \
        nrs=1.16667 sa=5.1e-07 sb=9.62097e-07 sd=160n sca=10.6008 \
        scb=0.00822388 scc=0.000121216 m=(1)
mp50 (n41 \8\:qbint \17\:VDD VDD) g45p1hvt w=(3.1e-07) l=4.5e-08 nf=1 \
        as=9.685e-14 ad=4.03e-14 ps=1.53e-06 pd=8.8e-07 nrd=1.16667 \
        nrs=1.16667 sa=4.34194e-07 sb=1.515e-06 sd=160n sca=16.8851 \
        scb=0.0157945 scc=0.0012748 m=(1)
mp51 (\8\:n30 \3\:CKbb n41 VDD) g45p1hvt w=(3.1e-07) l=4.5e-08 nf=1 \
        as=4.03e-14 ad=6.975e-14 ps=8.8e-07 pd=1.07e-06 nrd=1.16667 \
        nrs=1.16667 sa=6.09194e-07 sb=1.34e-06 sd=160n sca=16.8851 \
        scb=0.0157945 scc=0.0012748 m=(1)
mp40 (\8\:n30 \3\:CKb \8\:mout VDD) g45p1hvt w=(3.1e-07) l=4.5e-08 nf=1 \
        as=7.44e-14 ad=6.975e-14 ps=1.1e-06 pd=1.07e-06 nrd=1.16667 \
        nrs=1.16667 sa=8.79194e-07 sb=1.07e-06 sd=160n sca=16.8851 \
        scb=0.0157945 scc=0.0012748 m=(1)
mp30 (\8\:mout \3\:n20 \15\:VDD VDD) g45p1hvt w=(3.1e-07) l=4.5e-08 nf=1 \
        as=9e-14 ad=7.44e-14 ps=1.36e-06 pd=1.1e-06 nrd=1.16667 \
        nrs=1.16667 sa=1.16419e-06 sb=7.85e-07 sd=160n sca=16.8851 \
        scb=0.0157945 scc=0.0012748 m=(1)
mp35 (\3\:n26 \2\:RN \15\:VDD VDD) g45p1hvt w=(3.1e-07) l=4.5e-08 nf=1 \
        as=9e-14 ad=8.835e-14 ps=1.36e-06 pd=1.19e-06 nrd=1.16667 \
        nrs=1.16667 sa=1.44919e-06 sb=5e-07 sd=160n sca=16.8851 \
        scb=0.0157945 scc=0.0012748 m=(1)
mp36 (\3\:n26 mout \13\:VDD VDD) g45p1hvt w=(3.1e-07) l=4.5e-08 nf=1 \
        as=9.29e-14 ad=8.835e-14 ps=1.63e-06 pd=1.19e-06 nrd=1.16667 \
        nrs=1.16667 sa=1.69565e-06 sb=1.7e-07 sd=160n sca=16.8851 \
        scb=0.0157945 scc=0.0012748 m=(1)
mp37 (\4\:n20 \7\:CKb n26 VDD) g45p1hvt w=(3.1e-07) l=4.5e-08 nf=1 \
        as=6.355e-14 ad=1.0385e-13 ps=1.03e-06 pd=1.29e-06 nrd=1.16667 \
        nrs=1.16667 sa=2.05e-07 sb=6.03952e-07 sd=160n sca=11.0604 \
        scb=0.00885796 scc=0.000174054 m=(1)
mp26 (\4\:n20 \6\:CKbb n22 VDD) g45p1hvt w=(3.1e-07) l=4.5e-08 nf=1 \
        as=1.86e-14 ad=1.0385e-13 ps=7.4e-07 pd=1.29e-06 nrd=1.16667 \
        nrs=1.16667 sa=5.85e-07 sb=2.23952e-07 sd=160n sca=12.8183 \
        scb=0.0103291 scc=0.000178019 m=(1)
mp25 (n22 \1\:D \1\:VDD VDD) g45p1hvt w=(3.1e-07) l=4.5e-08 nf=1 \
        as=6.99e-14 ad=1.86e-14 ps=1.85e-06 pd=7.4e-07 nrd=1.16667 \
        nrs=1.16667 sa=6.9e-07 sb=1.18952e-07 sd=160n sca=14.1447 \
        scb=0.0123968 scc=0.000200733 m=(1)
ends DFFRHQX2
// End of subcircuit definition.
