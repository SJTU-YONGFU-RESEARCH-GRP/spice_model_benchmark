// gsclib045_backbias/AOI21X1/schematic

simulator lang=spectre

subckt AOI21X1 A0 A1 B0 Y VDD VSS NW
mn2 (Y B0 VSS VSS) g45n1svt w=(260n) l=45n nf=1 m=(1)
mn0 (net78 A0 VSS VSS) g45n1svt w=(260n) l=45n nf=1 m=(1)
mn1 (Y A1 net78 VSS) g45n1svt w=(260n) l=45n nf=1 m=(1)
mp2 (Y B0 net62 NW) g45p1svt w=(390n) l=45n nf=1 m=(1)
mp1 (net62 A1 VDD NW) g45p1svt w=(390n) l=45n nf=1 m=(1)
mp0 (net62 A0 VDD NW) g45p1svt w=(390n) l=45n nf=1 m=(1)
ends AOI21X1
