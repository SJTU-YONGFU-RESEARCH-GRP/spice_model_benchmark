// Generated for: spectre (May  1 09:19:57 2013 )
// Library name: gsclib045_hvt
// Cell name: TLATNCAX8
// View name: extracted

simulator lang=spectre

subckt TLATNCAX8 CK E ECK VDD VSS
mp0 (\15\:CKb \1\:CK \24\:VDD VDD) g45p1hvt w=(2.15e-07) l=4.5e-08 nf=1 \
        as=3.44e-14 ad=3.01e-14 ps=7.5e-07 pd=7.1e-07 nrd=1.16667 \
        nrs=1.16667 sa=1.4e-07 sb=1.315e-06 sd=160n sca=13.7363 \
        scb=0.0116912 scc=0.000146315 m=(1)
mp5 (net217 \1\:E \24\:VDD VDD) g45p1hvt w=(2.15e-07) l=4.5e-08 nf=1 \
        as=3.44e-14 ad=4.408e-14 ps=7.5e-07 pd=8.4e-07 nrd=1.16667 \
        nrs=1.16667 sa=3.45e-07 sb=1.11e-06 sd=160n sca=11.6626 \
        scb=0.00875241 scc=0.000120261 m=(1)
mp6 (\6\:n0 \3\:CKbb net217 VDD) g45p1hvt w=(2.15e-07) l=4.5e-08 nf=1 \
        as=4.408e-14 ad=3.44e-14 ps=8.4e-07 pd=7.5e-07 nrd=1.16667 \
        nrs=1.16667 sa=5.95e-07 sb=8.6e-07 sd=160n sca=10.7195 \
        scb=0.00816954 scc=0.000119639 m=(1)
mp16 (\6\:n0 \3\:CKb net205 VDD) g45p1hvt w=(2.15e-07) l=4.5e-08 nf=1 \
        as=4.408e-14 ad=3.44e-14 ps=8.4e-07 pd=7.5e-07 nrd=1.16667 \
        nrs=1.16667 sa=8e-07 sb=6.55e-07 sd=160n sca=10.5619 \
        scb=0.00813366 scc=0.000119634 m=(1)
mp15 (net205 \3\:Eint \20\:VDD VDD) g45p1hvt w=(2.15e-07) l=4.5e-08 nf=1 \
        as=7.85e-14 ad=4.408e-14 ps=1.39e-06 pd=8.4e-07 nrd=1.16667 \
        nrs=1.16667 sa=1.05e-06 sb=4.05e-07 sd=160n sca=10.5619 \
        scb=0.00813366 scc=0.000119634 m=(1)
mp1 (\10\:CKbb \5\:CKb \20\:VDD VDD) g45p1hvt w=(2.15e-07) l=4.5e-08 \
        nf=1 as=7.85e-14 ad=3.01e-14 ps=1.39e-06 pd=7.1e-07 nrd=1.16667 \
        nrs=1.16667 sa=1.315e-06 sb=1.4e-07 sd=160n sca=10.5619 \
        scb=0.00813366 scc=0.000119634 m=(1)
C1 (CK VSS) capacitor c=7.47976e-17
C2 (VDD VSS) capacitor c=2.6828e-16
C3 (ECK VSS) capacitor c=4.80173e-16
C4 (E VSS) capacitor c=7.75267e-17
C5 (CKb VSS) capacitor c=5.20449e-17
C6 (n0 VSS) capacitor c=4.80064e-17
C7 (CKbb VSS) capacitor c=2.79531e-17
C8 (Eint VSS) capacitor c=5.27634e-17
C9 (15 VSS) capacitor c=1.86308e-18
C10 (ECKb VSS) capacitor c=3.46211e-16
C11 (16 VSS) capacitor c=3.42446e-18
C12 (net205 VSS) capacitor c=4.56641e-18
C13 (\3\:n0 VSS) capacitor c=4.67111e-17
C14 (\5\:CKb VSS) capacitor c=6.56652e-17
C15 (\3\:Eint VSS) capacitor c=5.36932e-17
C16 (\3\:CKb VSS) capacitor c=3.73029e-17
C17 (\3\:CKbb VSS) capacitor c=8.28882e-17
C18 (\1\:E VSS) capacitor c=4.1315e-17
C19 (\1\:CK VSS) capacitor c=4.28749e-17
C20 (\10\:Eint VSS) capacitor c=7.88464e-17
C21 (\4\:CKbb VSS) capacitor c=4.99972e-17
C22 (\9\:CKbb VSS) capacitor c=4.34748e-17
C23 (\5\:Eint VSS) capacitor c=6.975e-17
C24 (\6\:CKb VSS) capacitor c=5.82406e-17
C25 (\3\:E VSS) capacitor c=7.18528e-17
C26 (\3\:CK VSS) capacitor c=3.76836e-17
C27 (\10\:ECKb VSS) capacitor c=2.73618e-17
C28 (\6\:Eint VSS) capacitor c=4.14752e-16
C29 (\2\:n0 VSS) capacitor c=3.94056e-17
C30 (\7\:CKb VSS) capacitor c=2.23116e-17
C31 (\4\:Eint VSS) capacitor c=2.65216e-17
C32 (\2\:CKbb VSS) capacitor c=5.98391e-17
C33 (\4\:CKb VSS) capacitor c=3.91044e-17
C34 (\2\:CKb VSS) capacitor c=3.8179e-17
C35 (\2\:E VSS) capacitor c=6.26596e-17
C36 (\2\:CK VSS) capacitor c=5.2618e-17
C37 (\1\:VDD VSS) capacitor c=3.52673e-16
C38 (\24\:ECKb VSS) capacitor c=1.95076e-16
C39 (\14\:VDD VSS) capacitor c=4.18551e-17
C40 (\18\:Eint VSS) capacitor c=4.00717e-17
C41 (\10\:CKbb VSS) capacitor c=1.00776e-16
C42 (\20\:VDD VSS) capacitor c=2.4147e-17
C43 (\6\:n0 VSS) capacitor c=2.0873e-16
C44 (\24\:VDD VSS) capacitor c=4.0368e-17
C45 (\15\:CKb VSS) capacitor c=9.49225e-17
C46 (\4\:VDD VSS) capacitor c=4.73034e-17
C47 (\31\:ECKb VSS) capacitor c=6.54501e-17
C48 (\14\:Eint VSS) capacitor c=4.02482e-17
C49 (\13\:CKbb VSS) capacitor c=1.35904e-16
C50 (\4\:n0 VSS) capacitor c=1.06125e-16
C51 (\12\:CKb VSS) capacitor c=1.86494e-17
C52 (\2\:Eint VSS) capacitor c=4.25477e-17
C53 (\5\:CKbb VSS) capacitor c=1.4975e-16
C54 (\4\:CK VSS) capacitor c=3.73891e-17
C55 (\4\:E VSS) capacitor c=3.46181e-17
C56 (\8\:CKb VSS) capacitor c=8.42233e-17
C57 (\9\:CKb VSS) capacitor c=1.36594e-16
C58 (\10\:CKb VSS) capacitor c=7.93821e-17
C59 (\11\:CKb VSS) capacitor c=8.14287e-17
C60 (\14\:CKb VSS) capacitor c=6.19155e-17
C61 (\8\:n0 VSS) capacitor c=1.52823e-16
C62 (\12\:CKbb VSS) capacitor c=1.13379e-16
C63 (\15\:CKbb VSS) capacitor c=1.27396e-16
C64 (\13\:Eint VSS) capacitor c=6.09657e-17
C65 (\17\:Eint VSS) capacitor c=6.23052e-17
C66 (\27\:ECKb VSS) capacitor c=8.8582e-17
C67 (\19\:VDD VSS) capacitor c=2.17178e-17
C68 (\23\:VDD VSS) capacitor c=1.80994e-17
Rk1 (\4\:CK CK) resistor r=0.1839 c=0
Rk44 (\1\:VDD \15\:VDD) resistor r=0.241 c=0
Rk47 (\1\:VDD \19\:VDD) resistor r=0.3698 c=0
Rk48 (\19\:VDD \21\:VDD) resistor r=0.04331 c=0
Rk49 (\19\:VDD \22\:VDD) resistor r=0.1368 c=0
Rk52 (\23\:VDD VDD) resistor r=0.2177 c=0
Rk50 (\22\:VDD \23\:VDD) resistor r=0.3333 c=0
Rk51 (\23\:VDD \25\:VDD) resistor r=0.2477 c=0
Rk2 (\4\:E E) resistor r=0.1326 c=0
Rk57 (\1\:VSS \9\:VSS) resistor r=0.2955 c=0
Rk58 (\9\:VSS \10\:VSS) resistor r=0.4911 c=0
Rk59 (\10\:VSS \11\:VSS) resistor r=0.1227 c=0
Rk61 (\12\:VSS VSS) resistor r=0.1901 c=0
Rk60 (\11\:VSS \12\:VSS) resistor r=0.3609 c=0
Rk64 (\9\:VSS \18\:VSS) resistor r=0.2612 c=0
Rk65 (\10\:VSS \20\:VSS) resistor r=0.07393 c=0
Rk66 (\12\:VSS \22\:VSS) resistor r=0.2775 c=0
Rk3 (\8\:CKb \9\:CKb) resistor r=0.5087 c=0
Rk4 (\9\:CKb \10\:CKb) resistor r=0.538 c=0
Rk5 (\10\:CKb \11\:CKb) resistor r=0.3165 c=0
Rk6 (\11\:CKb \13\:CKb) resistor r=0.09732 c=0
Rk7 (\9\:CKb \14\:CKb) resistor r=0.4658 c=0
Rk8 (\11\:CKb \16\:CKb) resistor r=0.7415 c=0
Rk9 (\5\:n0 \7\:n0) resistor r=0.589 c=0
Rk10 (\7\:n0 \8\:n0) resistor r=1.2583 c=0
Rk11 (\11\:CKbb \12\:CKbb) resistor r=0.7069 c=0
Rk12 (\12\:CKbb \14\:CKbb) resistor r=0.4952 c=0
Rk13 (\14\:CKbb \15\:CKbb) resistor r=0.8129 c=0
Rk15 (\6\:Eint \13\:Eint) resistor r=0.2885 c=0
Rk16 (\13\:Eint \15\:Eint) resistor r=0.1216 c=0
Rk17 (\13\:Eint \16\:Eint) resistor r=0.05755 c=0
Rk18 (\16\:Eint \17\:Eint) resistor r=0.3649 c=0
Rk19 (\16\:Eint \19\:Eint) resistor r=0.2004 c=0
Rk21 (\24\:ECKb \27\:ECKb) resistor r=0.4344 c=0
Rk24 (\27\:ECKb \32\:ECKb) resistor r=0.3826 c=0
Rl1 (\1\:CK \2\:CK) resistor r=121.154 c=0
Rl2 (\2\:CK \3\:CK) resistor r=101.099 c=0
Rl3 (\1\:E \2\:E) resistor r=98.0769 c=0
Rl4 (\2\:E \3\:E) resistor r=124.176 c=0
Rl12 (\5\:CKb \6\:CKb) resistor r=246.154 c=0
Rl13 (\6\:CKb \7\:CKb) resistor r=29.5379 c=0
Rl6 (\3\:CKb \4\:CKb) resistor r=71.8456 c=0
Rl5 (CKb \2\:CKb) resistor r=39.1533 c=0
Rl15 (\2\:n0 \3\:n0) resistor r=26.3736 c=0
Rl14 (n0 \2\:n0) resistor r=96.1538 c=0
Rl8 (\2\:CKbb \3\:CKbb) resistor r=289.927 c=0
Rl7 (\2\:CKbb CKbb) resistor r=24.7951 c=0
Rl18 (\5\:CKbb \4\:CKbb) resistor r=65.3625 c=0
Rl22 (\5\:CKbb \9\:CKbb) resistor r=24.7951 c=0
Rl24 (\6\:Eint \10\:Eint) resistor r=91.4835 c=0
Rl16 (\6\:Eint \5\:Eint) resistor r=64.001 c=0
Rl10 (\2\:Eint \3\:Eint) resistor r=147.587 c=0
Rl9 (\2\:Eint Eint) resistor r=86.0004 c=0
Rl11 (\2\:Eint \4\:Eint) resistor r=5.1652 c=0
Rl33 (ECKb \10\:ECKb) resistor r=3.3229 c=0
Rz10 (\1\:VDD \4\:VDD) resistor r=6.8182 c=0
Rz11 (\22\:VDD \4\:VDD) resistor r=6.25 c=0
Rz16 (\18\:VSS \17\:VSS) resistor r=75 c=0
Rz17 (\20\:VSS \19\:VSS) resistor r=75 c=0
Rz18 (\22\:VSS \21\:VSS) resistor r=75 c=0
Rz1 (\12\:CKb \13\:CKb) resistor r=75 c=0
Rz2 (\4\:n0 \5\:n0) resistor r=75 c=0
Rz3 (\14\:CKbb \13\:CKbb) resistor r=75 c=0
Rz4 (\15\:Eint \14\:Eint) resistor r=75 c=0
Rz5 (\32\:ECKb \31\:ECKb) resistor r=75 c=0
Ry17 (\15\:VDD \14\:VDD) resistor r=62 c=0
Ry19 (\21\:VDD \20\:VDD) resistor r=62 c=0
Ry20 (\25\:VDD \24\:VDD) resistor r=62 c=0
Ry21 (\1\:VSS \4\:VSS) resistor r=5.6364 c=0
Ry22 (\11\:VSS \4\:VSS) resistor r=5.1667 c=0
Ry1 (\15\:CKb \16\:CKb) resistor r=62 c=0
Ry2 (\6\:n0 \7\:n0) resistor r=62 c=0
Ry3 (\11\:CKbb \10\:CKbb) resistor r=62 c=0
Ry4 (\19\:Eint \18\:Eint) resistor r=62 c=0
Rx1 (\2\:CK \4\:CK) resistor r=45 c=0
Rx2 (\2\:E \4\:E) resistor r=45 c=0
Rx3 (\4\:CKb \8\:CKb) resistor r=45 c=0
Rx4 (\2\:CKb \10\:CKb) resistor r=45 c=0
Rx5 (\7\:CKb \14\:CKb) resistor r=45 c=0
Rx6 (\2\:n0 \8\:n0) resistor r=45 c=0
Rx7 (\12\:CKbb \2\:CKbb) resistor r=45 c=0
Rx8 (\15\:CKbb \5\:CKbb) resistor r=45 c=0
Rx11 (\17\:Eint \4\:Eint) resistor r=45 c=0
Rx12 (\27\:ECKb \10\:ECKb) resistor r=45 c=0
mn0 (\12\:CKb \3\:CK \21\:VSS VSS) g45n1hvt w=(1.45e-07) l=4.5e-08 nf=1 \
        as=2.32e-14 ad=2.03e-14 ps=6.1e-07 pd=5.7e-07 nrd=1.16667 \
        nrs=1.16667 sa=1.4e-07 sb=1.425e-06 sd=160n sca=10.0732 \
        scb=0.00911402 scc=0.000253284 m=(1)
mn5 (net254 \3\:E \21\:VSS VSS) g45n1hvt w=(1.45e-07) l=4.5e-08 nf=1 \
        as=2.32e-14 ad=8.7e-15 ps=6.1e-07 pd=4.1e-07 nrd=1.16667 \
        nrs=1.16667 sa=3.45e-07 sb=1.22e-06 sd=160n sca=10.0732 \
        scb=0.00911402 scc=0.000253284 m=(1)
mn6 (\4\:n0 CKb net254 VSS) g45n1hvt w=(1.45e-07) l=4.5e-08 nf=1 \
        as=8.7e-15 ad=7.177e-14 ps=4.1e-07 pd=1.28e-06 nrd=1.16667 \
        nrs=1.16667 sa=4.5e-07 sb=1.115e-06 sd=160n sca=10.0732 \
        scb=0.00911402 scc=0.000253284 m=(1)
mn16 (\4\:n0 CKbb net230 VSS) g45n1hvt w=(1.45e-07) l=4.5e-08 nf=1 \
        as=2.03e-14 ad=7.177e-14 ps=5.7e-07 pd=1.28e-06 nrd=1.16667 \
        nrs=1.16667 sa=9.9e-07 sb=5.75e-07 sd=160n sca=10.0732 \
        scb=0.00911402 scc=0.000253284 m=(1)
mn15 (net230 Eint \19\:VSS VSS) g45n1hvt w=(1.45e-07) l=4.5e-08 nf=1 \
        as=4.825e-14 ad=2.03e-14 ps=1.37e-06 pd=5.7e-07 nrd=1.16667 \
        nrs=1.16667 sa=1.175e-06 sb=3.9e-07 sd=160n sca=10.0732 \
        scb=0.00911402 scc=0.000253284 m=(1)
mn1 (\13\:CKbb \6\:CKb \19\:VSS VSS) g45n1hvt w=(1.45e-07) l=4.5e-08 \
        nf=1 as=4.825e-14 ad=2.828e-14 ps=1.37e-06 pd=6.8e-07 nrd=1.16667 \
        nrs=1.16667 sa=1.37e-06 sb=1.95e-07 sd=160n sca=10.0732 \
        scb=0.00911402 scc=0.000253284 m=(1)
mn10 (\14\:Eint n0 \17\:VSS VSS) g45n1hvt w=(2.05e-07) l=4.5e-08 nf=1 \
        as=5.383e-14 ad=5.125e-14 ps=9.7e-07 pd=9.1e-07 nrd=1.16667 \
        nrs=1.16667 sa=2.5e-07 sb=2e-06 sd=160n sca=15.5643 scb=0.0161016 \
        scc=0.00117276 m=(1)
mn20_1__rcx (15 \5\:Eint \17\:VSS VSS) g45n1hvt w=(2.6e-07) l=4.5e-08 \
        nf=1 as=5.383e-14 ad=1.56e-14 ps=9.7e-07 pd=6.4e-07 nrd=1.16667 \
        nrs=1.16667 sa=4.39615e-07 sb=2e-06 sd=160n sca=13.9783 \
        scb=0.013979 scc=0.000942864 m=(1)
mn21_1__rcx (\31\:ECKb \9\:CKbb 15 VSS) g45n1hvt w=(2.6e-07) l=4.5e-08 \
        nf=1 as=1.56e-14 ad=4.16e-14 ps=6.4e-07 pd=8.4e-07 nrd=1.16667 \
        nrs=1.16667 sa=5.44615e-07 sb=1.935e-06 sd=160n sca=13.9783 \
        scb=0.013979 scc=0.000942864 m=(1)
mn21 (\31\:ECKb \4\:CKbb 16 VSS) g45n1hvt w=(2.6e-07) l=4.5e-08 nf=1 \
        as=1.56e-14 ad=4.16e-14 ps=6.4e-07 pd=8.4e-07 nrd=1.16667 \
        nrs=1.16667 sa=7.49615e-07 sb=1.73e-06 sd=160n sca=13.9783 \
        scb=0.013979 scc=0.000942864 m=(1)
mn20 (16 \10\:Eint \1\:VSS VSS) g45n1hvt w=(2.6e-07) l=4.5e-08 nf=1 \
        as=5.29e-14 ad=1.56e-14 ps=9.7e-07 pd=6.4e-07 nrd=1.16667 \
        nrs=1.16667 sa=8.54615e-07 sb=1.625e-06 sd=160n sca=13.9783 \
        scb=0.013979 scc=0.000942864 m=(1)
mn22_1__rcx (ECK ECKb \1\:VSS VSS) g45n1hvt w=(2.95e-07) l=4.5e-08 nf=1 \
        as=4.801e-14 ad=4.804e-14 ps=9.1857e-07 pd=9.1571e-07 nrd=1.16667 \
        nrs=1.16667 sa=9.72203e-07 sb=1.39e-06 sd=160n sca=16.4223 \
        scb=0.0158966 scc=0.0014413 m=(7)
mp10 (\18\:Eint \3\:n0 \1\:VDD VDD) g45p1hvt w=(3.1e-07) l=4.5e-08 nf=1 \
        as=7.465e-14 ad=5.89e-14 ps=1.69e-06 pd=1e-06 nrd=1.16667 \
        nrs=1.16667 sa=1.9e-07 sb=2e-06 sd=160n sca=15.1875 scb=0.0142433 \
        scc=0.000935749 m=(1)
mp20_1__rcx (\24\:ECKb \6\:Eint \1\:VDD VDD) g45p1hvt w=(3.9e-07) \
        l=4.5e-08 nf=1 as=7.127e-14 ad=6.24e-14 ps=1.45e-06 pd=1.1e-06 \
        nrd=1.16667 nrs=1.16667 sa=3.26538e-07 sb=2e-06 sd=160n \
        sca=14.1011 scb=0.0127228 scc=0.000754417 m=(2)
mp21 (\24\:ECKb \5\:CKbb \14\:VDD VDD) g45p1hvt w=(3.9e-07) l=4.5e-08 \
        nf=1 as=6.24e-14 ad=6.24e-14 ps=1.1e-06 pd=1.1e-06 nrd=1.16667 \
        nrs=1.16667 sa=5.31538e-07 sb=1.985e-06 sd=160n sca=14.1011 \
        scb=0.0127228 scc=0.000754417 m=(2)
mp22_1__rcx (ECK ECKb \1\:VDD VDD) g45p1hvt w=(4.45e-07) l=4.5e-08 nf=1 \
        as=7.073e-14 ad=6.993e-14 ps=1.21e-06 pd=1.20429e-06 nrd=1.16667 \
        nrs=1.16667 sa=1.01719e-06 sb=1.37e-06 sd=160n sca=17.9041 \
        scb=0.0151963 scc=0.00151053 m=(7)
ends TLATNCAX8
// End of subcircuit definition.
