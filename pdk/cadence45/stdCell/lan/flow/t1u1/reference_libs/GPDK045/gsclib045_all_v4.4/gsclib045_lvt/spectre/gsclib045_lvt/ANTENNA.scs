// Generated for: spectre (Apr 19 14:29:57 2013 )
// Library name: gsclib045_lvt
// Cell name: ANTENNA
// View name: schematic

simulator lang=spectre

subckt ANTENNA A VDD VSS
D1 (A VDD) g45pd1lvt area=188.8f pj=1.82u m=1
D0 (VSS A) g45nd1lvt area=155.1f pj=1.6u m=1
ends ANTENNA
// End of subcircuit definition.
