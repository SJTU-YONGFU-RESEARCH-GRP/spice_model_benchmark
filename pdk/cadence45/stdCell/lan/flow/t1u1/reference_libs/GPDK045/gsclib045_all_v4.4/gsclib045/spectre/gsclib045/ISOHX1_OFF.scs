// gsclib045/ISOHX1_OFF/schematic

simulator lang=spectre

subckt ISOHX1_OFF A ISO Y VDD VSS ExtVDD
mn2 (Y n0 VSS VSS) g45n1svt w=(260n) l=45n nf=1 m=(1)
mn0 (n0 A VSS VSS) g45n1svt w=(145n) l=45n nf=1 m=(1)
mn1 (n0 ISO VSS VSS) g45n1svt w=(145n) l=45n nf=1 m=(1)
mp1 (n0 ISO n1 ExtVDD) g45p1svt w=(215n) l=45n nf=1 m=(1)
mp2 (Y n0 ExtVDD ExtVDD) g45p1svt w=(390n) l=45n nf=1 m=(1)
mp0 (n1 A ExtVDD ExtVDD) g45p1svt w=(215n) l=45n nf=1 m=(1)
ends ISOHX1_OFF
