// gsclib045_backbias/BUFX8/schematic

simulator lang=spectre

subckt BUFX8 A Y NW VSS VDD
mn1 (VSS n0 Y VSS) g45n1svt w=(2.065u) l=45n nf=1 m=(1)
mn0 (VSS A n0 VSS) g45n1svt w=(520n) l=45n nf=1 m=(1)
mp1 (Y n0 VDD NW) g45p1svt w=(3.115u) l=45n nf=1 m=(1)
mp0 (n0 A VDD NW) g45p1svt w=(780n) l=45n nf=1 m=(1)
ends BUFX8
