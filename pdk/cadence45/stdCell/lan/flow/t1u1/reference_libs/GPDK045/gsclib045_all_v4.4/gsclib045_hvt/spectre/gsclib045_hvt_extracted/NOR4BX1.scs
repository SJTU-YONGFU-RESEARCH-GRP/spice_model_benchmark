// Generated for: spectre (May  1 09:18:23 2013 )
// Library name: gsclib045_hvt
// Cell name: NOR4BX1
// View name: extracted

simulator lang=spectre

subckt NOR4BX1 AN B C D VDD VSS Y
mp4 (\6\:Y \1\:D n3 VDD) g45p1hvt w=(3.9e-07) l=4.5e-08 nf=1 as=2.34e-14 \
        ad=5.46e-14 ps=9e-07 pd=1.06e-06 nrd=1.16667 nrs=1.16667 \
        sa=1.4e-07 sb=7.73846e-07 sd=160n sca=17.2376 scb=0.0171686 \
        scc=0.000563105 m=(1)
mp3 (n3 \1\:C n2 VDD) g45p1hvt w=(3.9e-07) l=4.5e-08 nf=1 as=6.825e-14 \
        ad=2.34e-14 ps=1.13e-06 pd=9e-07 nrd=1.16667 nrs=1.16667 \
        sa=2.45e-07 sb=6.68846e-07 sd=160n sca=15.3527 scb=0.0138144 \
        scc=0.000491181 m=(1)
mp2 (n2 \1\:B n1 VDD) g45p1hvt w=(3.9e-07) l=4.5e-08 nf=1 as=4.485e-14 \
        ad=6.825e-14 ps=1.01e-06 pd=1.13e-06 nrd=1.16667 nrs=1.16667 \
        sa=4.65e-07 sb=4.48846e-07 sd=160n sca=14.2604 scb=0.0119242 \
        scc=0.000478605 m=(1)
mp1 (n1 \3\:n0 \1\:VDD VDD) g45p1hvt w=(3.9e-07) l=4.5e-08 nf=1 \
        as=6.535e-14 ad=4.485e-14 ps=1.16e-06 pd=1.01e-06 nrd=1.16667 \
        nrs=1.16667 sa=6.25e-07 sb=2.88846e-07 sd=160n sca=14.7087 \
        scb=0.0126621 scc=0.000481524 m=(1)
C1 (Y VSS) capacitor c=1.26341e-17
C2 (B VSS) capacitor c=8.31429e-17
C3 (VDD VSS) capacitor c=1.14174e-16
C4 (C VSS) capacitor c=2.00009e-17
C5 (AN VSS) capacitor c=3.93306e-17
C6 (n0 VSS) capacitor c=4.26448e-17
C7 (n2 VSS) capacitor c=1.99728e-18
C8 (\3\:AN VSS) capacitor c=4.35936e-17
C9 (\3\:n0 VSS) capacitor c=7.64817e-17
C10 (\1\:B VSS) capacitor c=5.46374e-17
C11 (\1\:C VSS) capacitor c=7.59096e-17
C12 (\1\:D VSS) capacitor c=7.39531e-17
C13 (\1\:AN VSS) capacitor c=3.2864e-17
C14 (\3\:B VSS) capacitor c=5.28659e-17
C15 (\3\:C VSS) capacitor c=5.34318e-17
C16 (\3\:D VSS) capacitor c=3.88424e-17
C17 (\2\:AN VSS) capacitor c=4.32498e-17
C18 (\2\:n0 VSS) capacitor c=5.66721e-17
C19 (\2\:B VSS) capacitor c=5.61017e-17
C20 (\2\:C VSS) capacitor c=5.90679e-17
C21 (\2\:D VSS) capacitor c=5.68318e-17
C22 (\7\:n0 VSS) capacitor c=5.60337e-17
C23 (\1\:VDD VSS) capacitor c=4.70176e-17
C24 (\6\:Y VSS) capacitor c=5.10841e-17
C25 (\5\:n0 VSS) capacitor c=7.83558e-17
C26 (\1\:Y VSS) capacitor c=7.4278e-17
C27 (\3\:Y VSS) capacitor c=4.93178e-17
C28 (\4\:D VSS) capacitor c=7.86768e-17
C29 (\4\:C VSS) capacitor c=4.9241e-17
C30 (\5\:Y VSS) capacitor c=8.34583e-17
C31 (\4\:AN VSS) capacitor c=5.68229e-17
C32 (\4\:n0 VSS) capacitor c=7.44032e-17
C33 (\4\:VDD VSS) capacitor c=2.87413e-17
Rk11 (\2\:VSS \4\:VSS) resistor r=0.3492 c=0
Rk12 (\4\:VSS \5\:VSS) resistor r=0.06226 c=0
Rk14 (\6\:VSS VSS) resistor r=0.03203 c=0
Rk13 (\5\:VSS \6\:VSS) resistor r=0.2045 c=0
Rk15 (\5\:VSS \8\:VSS) resistor r=0.1982 c=0
Rk16 (\6\:VSS \10\:VSS) resistor r=0.1982 c=0
Rk4 (\2\:Y \4\:Y) resistor r=0.3382 c=0
Rk6 (\5\:Y Y) resistor r=0.004828 c=0
Rk5 (\4\:Y \5\:Y) resistor r=0.2692 c=0
Rk7 (\5\:Y \7\:Y) resistor r=0.5372 c=0
Rk3 (B \4\:B) resistor r=0.00406 c=0
Rk18 (\4\:VDD VDD) resistor r=0.2995 c=0
Rk17 (\2\:VDD \4\:VDD) resistor r=0.4258 c=0
Rk2 (C \4\:C) resistor r=0.1134 c=0
Rk1 (\4\:D D) resistor r=0.01679 c=0
Rk8 (AN \4\:AN) resistor r=0.09359 c=0
Rk9 (\4\:n0 \6\:n0) resistor r=0.3044 c=0
Rk10 (\6\:n0 \8\:n0) resistor r=0.5005 c=0
Rl5 (\1\:B \2\:B) resistor r=62.2302 c=0
Rl6 (\2\:B \3\:B) resistor r=106.461 c=0
Rl3 (\1\:C \2\:C) resistor r=56.461 c=0
Rl4 (\2\:C \3\:C) resistor r=112.23 c=0
Rl1 (\1\:D \2\:D) resistor r=70.9439 c=0
Rl2 (\2\:D \3\:D) resistor r=101.099 c=0
Rl10 (\2\:AN \3\:AN) resistor r=116.54 c=0
Rl9 (\1\:AN \2\:AN) resistor r=49.2328 c=0
Rl8 (\2\:n0 \3\:n0) resistor r=128.079 c=0
Rl7 (n0 \2\:n0) resistor r=37.6944 c=0
Rz4 (\1\:VSS \2\:VSS) resistor r=75 c=0
Rz5 (\7\:VSS \8\:VSS) resistor r=75 c=0
Rz6 (\9\:VSS \10\:VSS) resistor r=75 c=0
Rz1 (\1\:Y \2\:Y) resistor r=75 c=0
Rz2 (\3\:Y \4\:Y) resistor r=75 c=0
Rz3 (\5\:n0 \6\:n0) resistor r=75 c=0
Ry1 (\6\:Y \7\:Y) resistor r=31 c=0
Ry4 (\1\:VDD \2\:VDD) resistor r=20.6667 c=0
Ry2 (\7\:n0 \8\:n0) resistor r=62 c=0
Rx3 (\2\:B \4\:B) resistor r=45 c=0
Rx2 (\2\:C \4\:C) resistor r=45 c=0
Rx1 (\2\:D \4\:D) resistor r=45 c=0
Rx4 (\2\:AN \4\:AN) resistor r=45 c=0
Rx5 (\2\:n0 \4\:n0) resistor r=45 c=0
mn4 (\3\:Y \3\:D \9\:VSS VSS) g45n1hvt w=(2.6e-07) l=4.5e-08 nf=1 \
        as=3.64e-14 ad=4.16e-14 ps=8e-07 pd=8.4e-07 nrd=1.16667 \
        nrs=1.16667 sa=1.4e-07 sb=9.01058e-07 sd=160n sca=8.97712 \
        scb=0.00732387 scc=0.000196032 m=(1)
mn3 (\3\:Y \3\:C \7\:VSS VSS) g45n1hvt w=(2.6e-07) l=4.5e-08 nf=1 \
        as=4.55e-14 ad=4.16e-14 ps=8.7e-07 pd=8.4e-07 nrd=1.16667 \
        nrs=1.16667 sa=3.45e-07 sb=6.96058e-07 sd=160n sca=8.97712 \
        scb=0.00732387 scc=0.000196032 m=(1)
mn2 (\1\:Y \3\:B \7\:VSS VSS) g45n1hvt w=(2.6e-07) l=4.5e-08 nf=1 \
        as=4.55e-14 ad=4.16e-14 ps=8.7e-07 pd=8.4e-07 nrd=1.16667 \
        nrs=1.16667 sa=5.65e-07 sb=4.76058e-07 sd=160n sca=8.97712 \
        scb=0.00732387 scc=0.000196032 m=(1)
mn1 (\1\:Y n0 \1\:VSS VSS) g45n1hvt w=(2.6e-07) l=4.5e-08 nf=1 \
        as=4.365e-14 ad=4.16e-14 ps=9e-07 pd=8.4e-07 nrd=1.16667 \
        nrs=1.16667 sa=7.7e-07 sb=2.71058e-07 sd=160n sca=8.97712 \
        scb=0.00732387 scc=0.000196032 m=(1)
mn0 (\5\:n0 \1\:AN \1\:VSS VSS) g45n1hvt w=(1.45e-07) l=4.5e-08 nf=1 \
        as=4.365e-14 ad=2.03e-14 ps=9e-07 pd=5.7e-07 nrd=1.16667 \
        nrs=1.16667 sa=1.005e-06 sb=1.4e-07 sd=160n sca=10.7143 \
        scb=0.0101371 scc=0.000327098 m=(1)
mp0 (\7\:n0 \3\:AN \1\:VDD VDD) g45p1hvt w=(2.15e-07) l=4.5e-08 nf=1 \
        as=6.535e-14 ad=3.762e-14 ps=1.16e-06 pd=7.8e-07 nrd=1.16667 \
        nrs=1.16667 sa=8.6e-07 sb=1.75e-07 sd=160n sca=21.1756 \
        scb=0.0235868 scc=0.00103894 m=(1)
ends NOR4BX1
// End of subcircuit definition.
