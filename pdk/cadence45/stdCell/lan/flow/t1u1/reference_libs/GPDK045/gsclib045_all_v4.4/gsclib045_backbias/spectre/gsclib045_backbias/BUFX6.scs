// gsclib045_backbias/BUFX6/schematic

simulator lang=spectre

subckt BUFX6 A Y VSS NW VDD
mn1 (VSS n0 Y VSS) g45n1svt w=(1.55u) l=45n nf=1 m=(1)
mn0 (VSS A n0 VSS) g45n1svt w=(520n) l=45n nf=1 m=(1)
mp1 (Y n0 VDD NW) g45p1svt w=(2.35u) l=45n nf=1 m=(1)
mp0 (n0 A VDD NW) g45p1svt w=(780n) l=45n nf=1 m=(1)
ends BUFX6
