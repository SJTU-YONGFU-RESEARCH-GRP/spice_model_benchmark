// gsclib045_backbias/CLKBUFX2/schematic

simulator lang=spectre

subckt CLKBUFX2 A Y VSS VDD NW
mn1 (Y net44 VSS VSS) g45n1svt w=(520n) l=45n nf=1 m=(1)
mn0 (net44 A VSS VSS) g45n1svt w=(145n) l=45n nf=1 m=(1)
mp1 (Y net44 VDD NW) g45p1svt w=(780n) l=45n nf=1 m=(1)
mp0 (net44 A VDD NW) g45p1svt w=(215n) l=45n nf=1 m=(1)
ends CLKBUFX2
