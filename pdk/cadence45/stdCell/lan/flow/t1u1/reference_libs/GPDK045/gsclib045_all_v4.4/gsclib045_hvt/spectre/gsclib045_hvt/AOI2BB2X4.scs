// gsclib045_hvt/AOI2BB2X4/schematic

simulator lang=spectre

subckt AOI2BB2X4 A0N A1N B0 B1 Y VSS VDD
mp5 (Y B1 net127 VDD) g45p1hvt w=(1.56u) l=45n nf=1 m=(1)
mp4 (Y B0 net127 VDD) g45p1hvt w=(1.56u) l=45n nf=1 m=(1)
mp2 (net127 net148 VDD VDD) g45p1hvt w=(1.56u) l=45n nf=1 m=(1)
mp0 (net148 A0N VDD VDD) g45p1hvt w=(390n) l=45n nf=1 m=(1)
mp1 (net144 A1N VDD VDD) g45p1hvt w=(390n) l=45n nf=1 m=(1)
mp3 (net127 net144 VDD VDD) g45p1hvt w=(1.56u) l=45n nf=1 m=(1)
mn5 (net152 B1 VSS VSS) g45n1hvt w=(1.04u) l=45n nf=1 m=(1)
mn4 (Y B0 net152 VSS) g45n1hvt w=(1.04u) l=45n nf=1 m=(1)
mn3 (Y net144 net160 VSS) g45n1hvt w=(1.04u) l=45n nf=1 m=(1)
mn2 (net160 net148 VSS VSS) g45n1hvt w=(1.04u) l=45n nf=1 m=(1)
mn0 (net148 A0N VSS VSS) g45n1hvt w=(260n) l=45n nf=1 m=(1)
mn1 (net144 A1N VSS VSS) g45n1hvt w=(260n) l=45n nf=1 m=(1)
ends AOI2BB2X4
