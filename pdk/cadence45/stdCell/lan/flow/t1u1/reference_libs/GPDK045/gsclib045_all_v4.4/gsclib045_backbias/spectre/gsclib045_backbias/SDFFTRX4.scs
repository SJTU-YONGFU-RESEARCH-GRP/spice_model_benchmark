// gsclib045_backbias/SDFFTRX4/schematic

simulator lang=spectre

subckt SDFFTRX4 CK D Q QN RN SE SI VDD VSS NW
mn12 (net484 SI VSS VSS) g45n1svt w=(145n) l=45n nf=1 m=(1)
mn13 (Dbp SE net484 VSS) g45n1svt w=(145n) l=45n nf=1 m=(1)
mn0 (net476 RN VSS VSS) g45n1svt w=(145n) l=45n nf=1 m=(1)
mn1 (Db D net476 VSS) g45n1svt w=(145n) l=45n nf=1 m=(1)
mn57 (QN net436 VSS VSS) g45n1svt w=(1.04u) l=45n nf=1 m=(1)
mn55 (Q qbint VSS VSS) g45n1svt w=(1.04u) l=45n nf=1 m=(1)
mn50 (net460 qbint VSS VSS) g45n1svt w=(145n) l=45n nf=1 m=(1)
mn51 (n30 CKb net460 VSS) g45n1svt w=(145n) l=45n nf=1 m=(1)
mn35 (net452 mout VSS VSS) g45n1svt w=(145n) l=45n nf=1 m=(1)
mn36 (n20 CKbb net452 VSS) g45n1svt w=(145n) l=45n nf=1 m=(1)
mn20 (CKb CK VSS VSS) g45n1svt w=(145n) l=45n nf=1 m=(1)
mn45 (qbint n30 VSS VSS) g45n1svt w=(410n) l=45n nf=1 m=(1)
mn56 (net436 qbint VSS VSS) g45n1svt w=(260n) l=45n nf=1 m=(1)
mn11 (Db SEb Dbp VSS) g45n1svt w=(145n) l=45n nf=1 m=(1)
mn21 (CKbb CKb VSS VSS) g45n1svt w=(145n) l=45n nf=1 m=(1)
mn30 (mout n20 VSS VSS) g45n1svt w=(145n) l=45n nf=1 m=(1)
mn10 (SEb SE VSS VSS) g45n1svt w=(145n) l=45n nf=1 m=(1)
mn25 (Dbp CKb n20 VSS) g45n1svt w=(145n) l=45n nf=1 m=(1)
mn40 (n30 CKbb mout VSS) g45n1svt w=(145n) l=45n nf=1 m=(1)
mp13 (Dbp SEb net411 NW) g45p1svt w=(215n) l=45n nf=1 m=(1)
mp12 (net411 SI VDD NW) g45p1svt w=(215n) l=45n nf=1 m=(1)
mp1 (Db D VDD NW) g45p1svt w=(215n) l=45n nf=1 m=(1)
mp0 (Db RN VDD NW) g45p1svt w=(215n) l=45n nf=1 m=(1)
mp51 (n30 CKbb net395 NW) g45p1svt w=(215n) l=45n nf=1 m=(1)
mp50 (net395 qbint VDD NW) g45p1svt w=(215n) l=45n nf=1 m=(1)
mp57 (QN net436 VDD NW) g45p1svt w=(1.56u) l=45n nf=1 m=(1)
mp55 (Q qbint VDD NW) g45p1svt w=(1.56u) l=45n nf=1 m=(1)
mp35 (net375 mout VDD NW) g45p1svt w=(215n) l=45n nf=1 m=(1)
mp36 (n20 CKb net375 NW) g45p1svt w=(215n) l=45n nf=1 m=(1)
mp20 (CKb CK VDD NW) g45p1svt w=(215n) l=45n nf=1 m=(1)
mp45 (qbint n30 VDD NW) g45p1svt w=(620n) l=45n nf=1 m=(1)
mp56 (net436 qbint VDD NW) g45p1svt w=(390n) l=45n nf=1 m=(1)
mp25 (n20 CKbb Dbp NW) g45p1svt w=(215n) l=45n nf=1 m=(1)
mp11 (Dbp SE Db NW) g45p1svt w=(215n) l=45n nf=1 m=(1)
mp10 (SEb SE VDD NW) g45p1svt w=(215n) l=45n nf=1 m=(1)
mp21 (CKbb CKb VDD NW) g45p1svt w=(215n) l=45n nf=1 m=(1)
mp30 (mout n20 VDD NW) g45p1svt w=(215n) l=45n nf=1 m=(1)
mp40 (n30 CKb mout NW) g45p1svt w=(215n) l=45n nf=1 m=(1)
ends SDFFTRX4
