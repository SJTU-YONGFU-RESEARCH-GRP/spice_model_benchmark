// Generated for: spectre (May  1 09:14:19 2013 )
// Library name: gsclib045_lvt
// Cell name: EDFFHQX4
// View name: extracted

simulator lang=spectre

subckt EDFFHQX4 CK D E Q VDD VSS
mp20 (\12\:CKb \3\:CK \23\:VDD VDD) g45p1lvt w=(2.15e-07) l=4.5e-08 nf=1 \
        as=6.53e-14 ad=3.655e-14 ps=1.17e-06 pd=7.7e-07 nrd=1.16667 \
        nrs=1.16667 sa=1.7e-07 sb=4.05e-07 sd=160n sca=19.0805 \
        scb=0.0206115 scc=0.000620106 m=(1)
mp21 (\18\:CKbb \8\:CKb \23\:VDD VDD) g45p1lvt w=(2.15e-07) l=4.5e-08 \
        nf=1 as=6.53e-14 ad=3.01e-14 ps=1.17e-06 pd=7.1e-07 nrd=1.16667 \
        nrs=1.16667 sa=4.35e-07 sb=1.4e-07 sd=160n sca=12.3202 \
        scb=0.00940859 scc=0.000103219 m=(1)
mp0 (\6\:Eb \5\:E \1\:VDD VDD) g45p1lvt w=(2.15e-07) l=4.5e-08 nf=1 \
        as=9.975e-14 ad=3.01e-14 ps=1.48e-06 pd=7.1e-07 nrd=1.16667 \
        nrs=1.16667 sa=9.7e-07 sb=1.4e-07 sd=160n sca=29.4705 \
        scb=0.0286682 scc=0.00289959 m=(1)
C1 (D VSS) capacitor c=1.21316e-16
C2 (Q VSS) capacitor c=2.86292e-17
C3 (VDD VSS) capacitor c=4.22129e-16
C4 (CK VSS) capacitor c=1.06123e-16
C5 (CKb VSS) capacitor c=9.86221e-17
C6 (CKbb VSS) capacitor c=3.82556e-17
C7 (n20 VSS) capacitor c=5.8824e-17
C8 (Db VSS) capacitor c=1.10863e-16
C9 (net340 VSS) capacitor c=4.79276e-19
C10 (mout VSS) capacitor c=2.89159e-17
C11 (n30 VSS) capacitor c=4.60875e-16
C12 (qbint VSS) capacitor c=2.97914e-16
C13 (Eb VSS) capacitor c=4.11629e-17
C14 (net333 VSS) capacitor c=8.93728e-19
C15 (net309 VSS) capacitor c=6.87608e-18
C16 (net317 VSS) capacitor c=3.19819e-18
C17 (net328 VSS) capacitor c=4.86067e-18
C18 (\5\:E VSS) capacitor c=4.15187e-17
C19 (\1\:D VSS) capacitor c=5.14161e-17
C20 (\1\:E VSS) capacitor c=4.07103e-17
C21 (\17\:qbint VSS) capacitor c=7.70168e-17
C22 (\7\:CKbb VSS) capacitor c=6.94734e-17
C23 (\2\:CKb VSS) capacitor c=1.12726e-16
C24 (\4\:mout VSS) capacitor c=4.64259e-17
C25 (\3\:CKb VSS) capacitor c=1.21694e-16
C26 (\8\:CKb VSS) capacitor c=5.42351e-17
C27 (\3\:CK VSS) capacitor c=3.74297e-17
C28 (\7\:E VSS) capacitor c=2.2921e-17
C29 (\3\:D VSS) capacitor c=8.13383e-17
C30 (\3\:E VSS) capacitor c=6.077e-17
C31 (\3\:Eb VSS) capacitor c=5.83278e-17
C32 (\9\:qbint VSS) capacitor c=4.36677e-17
C33 (\5\:CKbb VSS) capacitor c=3.33706e-17
C34 (\3\:n20 VSS) capacitor c=3.23908e-17
C35 (\3\:mout VSS) capacitor c=7.69729e-17
C36 (\3\:CKbb VSS) capacitor c=5.36096e-17
C37 (\6\:CKb VSS) capacitor c=2.32194e-17
C38 (\7\:CKb VSS) capacitor c=2.2523e-17
C39 (\1\:CK VSS) capacitor c=4.90633e-17
C40 (\6\:E VSS) capacitor c=2.53855e-17
C41 (\2\:D VSS) capacitor c=5.12879e-17
C42 (\2\:Eb VSS) capacitor c=6.26334e-17
C43 (\4\:E VSS) capacitor c=4.84008e-17
C44 (\2\:E VSS) capacitor c=2.4525e-17
C45 (\8\:CKbb VSS) capacitor c=5.35689e-17
C46 (\6\:CKbb VSS) capacitor c=2.92723e-17
C47 (\2\:n20 VSS) capacitor c=3.44271e-17
C48 (\4\:CKbb VSS) capacitor c=3.45265e-17
C49 (\2\:CKbb VSS) capacitor c=4.87089e-17
C50 (\5\:CKb VSS) capacitor c=5.15893e-17
C51 (\2\:CK VSS) capacitor c=4.52205e-17
C52 (\6\:Eb VSS) capacitor c=9.15126e-17
C53 (\1\:VDD VSS) capacitor c=3.71119e-17
C54 (\3\:Db VSS) capacitor c=4.09759e-16
C55 (\26\:qbint VSS) capacitor c=4.5873e-17
C56 (\28\:qbint VSS) capacitor c=2.33078e-17
C57 (\1\:Q VSS) capacitor c=1.31246e-16
C58 (\14\:n30 VSS) capacitor c=7.96274e-17
C59 (\5\:mout VSS) capacitor c=4.75581e-17
C60 (\19\:VDD VSS) capacitor c=5.42962e-17
C61 (\4\:n20 VSS) capacitor c=3.62775e-17
C62 (\5\:Db VSS) capacitor c=4.21322e-16
C63 (\18\:CKbb VSS) capacitor c=5.91265e-17
C64 (\23\:VDD VSS) capacitor c=9.14566e-18
C65 (\12\:CKb VSS) capacitor c=5.99425e-17
C66 (\3\:VDD VSS) capacitor c=8.82461e-17
C67 (\4\:Eb VSS) capacitor c=7.07305e-17
C68 (\18\:qbint VSS) capacitor c=3.60495e-17
C69 (\24\:qbint VSS) capacitor c=2.59535e-17
C70 (\11\:n30 VSS) capacitor c=6.02077e-17
C71 (\9\:mout VSS) capacitor c=6.17745e-17
C72 (\7\:n20 VSS) capacitor c=7.35577e-17
C73 (\7\:Db VSS) capacitor c=9.40353e-17
C74 (\14\:CKbb VSS) capacitor c=2.62545e-17
C75 (\9\:CKb VSS) capacitor c=1.77787e-17
C76 (\2\:mout VSS) capacitor c=2.86064e-17
C77 (\4\:CKb VSS) capacitor c=5.76628e-17
C78 (\8\:qbint VSS) capacitor c=4.39747e-17
C79 (\11\:CKb VSS) capacitor c=7.3962e-17
C80 (\14\:CKb VSS) capacitor c=3.7828e-17
C81 (\6\:n20 VSS) capacitor c=1.08133e-16
C82 (\9\:n20 VSS) capacitor c=9.79031e-17
C83 (\7\:mout VSS) capacitor c=5.16526e-17
C84 (\8\:mout VSS) capacitor c=6.25032e-17
C85 (\9\:CKbb VSS) capacitor c=6.71152e-17
C86 (\10\:CKbb VSS) capacitor c=1.35125e-16
C87 (\11\:CKbb VSS) capacitor c=1.04609e-16
C88 (\12\:CKbb VSS) capacitor c=7.31424e-17
C89 (\13\:CKbb VSS) capacitor c=1.07134e-16
C90 (\16\:CKbb VSS) capacitor c=6.104e-17
C91 (\17\:CKbb VSS) capacitor c=7.01146e-17
C92 (\5\:Q VSS) capacitor c=2.39857e-16
C93 (\10\:n30 VSS) capacitor c=2.19514e-16
C94 (\20\:qbint VSS) capacitor c=3.6119e-17
C95 (\21\:qbint VSS) capacitor c=5.94558e-17
C96 (\22\:qbint VSS) capacitor c=5.99001e-17
C97 (\23\:qbint VSS) capacitor c=7.10732e-17
C98 (\8\:E VSS) capacitor c=9.06115e-17
C99 (\9\:E VSS) capacitor c=1.27493e-16
C100 (\10\:E VSS) capacitor c=1.17197e-16
C101 (\11\:E VSS) capacitor c=3.28188e-17
C102 (\8\:Eb VSS) capacitor c=9.30341e-17
C103 (\5\:VDD VSS) capacitor c=2.01833e-16
C104 (\18\:VDD VSS) capacitor c=4.84287e-17
C105 (\22\:VDD VSS) capacitor c=2.24428e-17
Rk40 (E \8\:E) resistor r=0.02329 c=0
Rk41 (\8\:E \9\:E) resistor r=0.4346 c=0
Rk42 (\9\:E \10\:E) resistor r=0.8663 c=0
Rk43 (\9\:E \11\:E) resistor r=0.1053 c=0
Rk39 (\4\:D D) resistor r=0.003678 c=0
Rk20 (\1\:Q Q) resistor r=0.0613 c=0
Rk21 (Q \5\:Q) resistor r=0.1831 c=0
Rk46 (\2\:VDD \4\:VDD) resistor r=0.3344 c=0
Rk47 (\4\:VDD \5\:VDD) resistor r=0.5589 c=0
Rk56 (\5\:VDD \18\:VDD) resistor r=0.5762 c=0
Rk57 (\18\:VDD \20\:VDD) resistor r=0.2671 c=0
Rk58 (\18\:VDD \21\:VDD) resistor r=0.2906 c=0
Rk61 (\22\:VDD VDD) resistor r=0.1475 c=0
Rk59 (\21\:VDD \22\:VDD) resistor r=0.4034 c=0
Rk60 (\22\:VDD \24\:VDD) resistor r=0.07369 c=0
Rk62 (\2\:VSS \4\:VSS) resistor r=0.2737 c=0
Rk63 (\4\:VSS \5\:VSS) resistor r=0.436 c=0
Rk68 (\5\:VSS \10\:VSS) resistor r=0.506 c=0
Rk69 (\10\:VSS \11\:VSS) resistor r=0.2605 c=0
Rk71 (\12\:VSS VSS) resistor r=0.16 c=0
Rk70 (\11\:VSS \12\:VSS) resistor r=0.3909 c=0
Rk76 (\10\:VSS \22\:VSS) resistor r=0.1357 c=0
Rk77 (\12\:VSS \24\:VSS) resistor r=0.319 c=0
Rk1 (\4\:CK CK) resistor r=0.002999 c=0
Rk2 (\10\:CKb \11\:CKb) resistor r=0.097 c=0
Rk3 (\11\:CKb \13\:CKb) resistor r=0.5979 c=0
Rk4 (\11\:CKb \14\:CKb) resistor r=0.2103 c=0
Rk11 (\9\:CKbb \10\:CKbb) resistor r=0.3005 c=0
Rk12 (\10\:CKbb \11\:CKbb) resistor r=0.8339 c=0
Rk13 (\11\:CKbb \12\:CKbb) resistor r=0.2837 c=0
Rk14 (\12\:CKbb \13\:CKbb) resistor r=0.2959 c=0
Rk15 (\13\:CKbb \15\:CKbb) resistor r=0.02467 c=0
Rk16 (\11\:CKbb \16\:CKbb) resistor r=0.2281 c=0
Rk17 (\12\:CKbb \17\:CKbb) resistor r=0.3608 c=0
Rk18 (\13\:CKbb \19\:CKbb) resistor r=0.6204 c=0
Rk5 (\5\:n20 \6\:n20) resistor r=0.1174 c=0
Rk6 (\6\:n20 \8\:n20) resistor r=0.3034 c=0
Rk7 (\6\:n20 \9\:n20) resistor r=0.6257 c=0
Rk36 (\2\:Db \4\:Db) resistor r=0.5355 c=0
Rk37 (\4\:Db \6\:Db) resistor r=3.306 c=0
Rk38 (\6\:Db \8\:Db) resistor r=0.5391 c=0
Rk8 (\6\:mout \7\:mout) resistor r=0.127 c=0
Rk9 (\7\:mout \8\:mout) resistor r=0.228 c=0
Rk10 (\7\:mout \10\:mout) resistor r=0.2916 c=0
Rk25 (n30 \10\:n30) resistor r=1.6488 c=0
Rk26 (\10\:n30 \12\:n30) resistor r=0.2699 c=0
Rk28 (\10\:n30 \15\:n30) resistor r=0.4527 c=0
Rk29 (\19\:qbint \20\:qbint) resistor r=0.1927 c=0
Rk30 (\20\:qbint \21\:qbint) resistor r=0.3329 c=0
Rk31 (\21\:qbint \22\:qbint) resistor r=0.2351 c=0
Rk32 (\22\:qbint \23\:qbint) resistor r=0.3953 c=0
Rk33 (\20\:qbint \25\:qbint) resistor r=0.08277 c=0
Rk34 (\21\:qbint \27\:qbint) resistor r=0.309 c=0
Rk35 (\22\:qbint \29\:qbint) resistor r=0.05443 c=0
Rk44 (\5\:Eb \7\:Eb) resistor r=0.5406 c=0
Rk45 (\7\:Eb \8\:Eb) resistor r=0.5895 c=0
Rl46 (\5\:E \6\:E) resistor r=110.307 c=0
Rl47 (\6\:E \7\:E) resistor r=29.5379 c=0
Rl41 (\3\:E \4\:E) resistor r=35.7713 c=0
Rl40 (\1\:E \2\:E) resistor r=30.2349 c=0
Rl44 (\1\:D \2\:D) resistor r=26.1559 c=0
Rl45 (\2\:D \3\:D) resistor r=110.771 c=0
Rl2 (\2\:CK \3\:CK) resistor r=74.1758 c=0
Rl1 (\1\:CK \2\:CK) resistor r=167.308 c=0
Rl12 (\2\:CKb \3\:CKb) resistor r=528.412 c=0
Rl11 (CKb \2\:CKb) resistor r=185.67 c=0
Rl17 (\5\:CKb \8\:CKb) resistor r=201.384 c=0
Rl16 (\5\:CKb \7\:CKb) resistor r=31.8672 c=0
Rl13 (\3\:CKb \4\:CKb) resistor r=222.62 c=0
Rl15 (\4\:CKb \6\:CKb) resistor r=30.4507 c=0
Rl14 (\4\:CKb \5\:CKb) resistor r=167.982 c=0
Rl18 (\7\:CKbb \8\:CKbb) resistor r=35.3072 c=0
Rl10 (\5\:CKbb \6\:CKbb) resistor r=29.5379 c=0
Rl4 (\3\:CKbb \4\:CKbb) resistor r=29.5379 c=0
Rl3 (CKbb \2\:CKbb) resistor r=53.3118 c=0
Rl8 (n20 \2\:n20) resistor r=98.7687 c=0
Rl9 (\2\:n20 \3\:n20) resistor r=29.5379 c=0
Rl7 (\2\:mout \4\:mout) resistor r=45.868 c=0
Rl6 (\2\:mout \3\:mout) resistor r=128.126 c=0
Rl5 (mout \2\:mout) resistor r=6.7128 c=0
Rl34 (\8\:qbint \17\:qbint) resistor r=109.439 c=0
Rl25 (\8\:qbint qbint) resistor r=124.455 c=0
Rl26 (\8\:qbint \9\:qbint) resistor r=46.5644 c=0
Rl42 (Eb \2\:Eb) resistor r=24.2328 c=0
Rl43 (\2\:Eb \3\:Eb) resistor r=162.581 c=0
Rz13 (\4\:VDD \3\:VDD) resistor r=10.7143 c=0
Rz14 (\5\:VDD \3\:VDD) resistor r=6.25 c=0
Rz15 (\21\:VDD \3\:VDD) resistor r=6.25 c=0
Rz16 (\2\:VSS \1\:VSS) resistor r=75 c=0
Rz21 (\22\:VSS \21\:VSS) resistor r=75 c=0
Rz22 (\24\:VSS \23\:VSS) resistor r=75 c=0
Rz1 (\9\:CKb \10\:CKb) resistor r=75 c=0
Rz4 (\14\:CKbb \15\:CKbb) resistor r=75 c=0
Rz2 (\7\:n20 \8\:n20) resistor r=75 c=0
Rz10 (Db \2\:Db) resistor r=75 c=0
Rz11 (\7\:Db \8\:Db) resistor r=75 c=0
Rz3 (\9\:mout \10\:mout) resistor r=75 c=0
Rz7 (\12\:n30 \11\:n30) resistor r=75 c=0
Rz8 (\19\:qbint \18\:qbint) resistor r=75 c=0
Rz9 (\25\:qbint \24\:qbint) resistor r=75 c=0
Rz12 (\4\:Eb \5\:Eb) resistor r=75 c=0
Ry13 (\2\:VDD \1\:VDD) resistor r=62 c=0
Ry18 (\20\:VDD \19\:VDD) resistor r=62 c=0
Ry19 (\24\:VDD \23\:VDD) resistor r=62 c=0
Ry20 (\4\:VSS \3\:VSS) resistor r=8.8571 c=0
Ry21 (\5\:VSS \3\:VSS) resistor r=5.1667 c=0
Ry22 (\11\:VSS \3\:VSS) resistor r=5.1667 c=0
Ry1 (\12\:CKb \13\:CKb) resistor r=62 c=0
Ry4 (\18\:CKbb \19\:CKbb) resistor r=62 c=0
Ry2 (\4\:n20 \5\:n20) resistor r=62 c=0
Ry10 (\3\:Db \4\:Db) resistor r=20.6667 c=0
Ry11 (\5\:Db \6\:Db) resistor r=31 c=0
Ry3 (\5\:mout \6\:mout) resistor r=62 c=0
Ry7 (\15\:n30 \14\:n30) resistor r=62 c=0
Ry8 (\27\:qbint \26\:qbint) resistor r=62 c=0
Ry9 (\29\:qbint \28\:qbint) resistor r=62 c=0
Ry12 (\6\:Eb \7\:Eb) resistor r=62 c=0
Rx13 (\6\:E \8\:E) resistor r=45 c=0
Rx14 (\2\:E \10\:E) resistor r=45 c=0
Rx15 (\4\:E \11\:E) resistor r=45 c=0
Rx12 (\2\:D \4\:D) resistor r=45 c=0
Rx1 (\2\:CK \4\:CK) resistor r=45 c=0
Rx2 (\5\:CKb \14\:CKb) resistor r=45 c=0
Rx5 (\8\:CKbb \9\:CKbb) resistor r=45 c=0
Rx6 (\6\:CKbb \10\:CKbb) resistor r=45 c=0
Rx7 (\4\:CKbb \16\:CKbb) resistor r=45 c=0
Rx8 (\2\:CKbb \17\:CKbb) resistor r=45 c=0
Rx3 (\2\:n20 \9\:n20) resistor r=45 c=0
Rx4 (mout \8\:mout) resistor r=45 c=0
Rx11 (\23\:qbint qbint) resistor r=45 c=0
Rx16 (\2\:Eb \8\:Eb) resistor r=45 c=0
mn20 (\9\:CKb \1\:CK \23\:VSS VSS) g45n1lvt w=(1.45e-07) l=4.5e-08 nf=1 \
        as=2.32e-14 ad=2.03e-14 ps=6.1e-07 pd=5.7e-07 nrd=1.16667 \
        nrs=1.16667 sa=1.4e-07 sb=3.45e-07 sd=160n sca=13.253 \
        scb=0.0137915 scc=0.000695334 m=(1)
mn21 (\14\:CKbb \7\:CKb \23\:VSS VSS) g45n1lvt w=(1.45e-07) l=4.5e-08 \
        nf=1 as=2.32e-14 ad=2.03e-14 ps=6.1e-07 pd=5.7e-07 nrd=1.16667 \
        nrs=1.16667 sa=3.45e-07 sb=1.4e-07 sd=160n sca=13.253 \
        scb=0.0137915 scc=0.000695334 m=(1)
mn0 (\4\:Eb \7\:E \1\:VSS VSS) g45n1lvt w=(1.45e-07) l=4.5e-08 nf=1 \
        as=6.685e-14 ad=3.263e-14 ps=1.22e-06 pd=7.4e-07 nrd=1.16667 \
        nrs=1.16667 sa=1.04793e-06 sb=2.25e-07 sd=160n sca=10.4914 \
        scb=0.00978575 scc=0.000300434 m=(1)
mn25 (\7\:n20 \6\:CKb \7\:Db VSS) g45n1lvt w=(2.05e-07) l=4.5e-08 nf=1 \
        as=2.87e-14 ad=8.713e-14 ps=6.9e-07 pd=1.26e-06 nrd=1.16667 \
        nrs=1.16667 sa=1.4e-07 sb=2e-06 sd=160n sca=17.1738 scb=0.0176382 \
        scc=0.00148475 m=(1)
mn36 (\7\:n20 \3\:CKbb net340 VSS) g45n1lvt w=(2.05e-07) l=4.5e-08 nf=1 \
        as=1.23e-14 ad=8.713e-14 ps=5.3e-07 pd=1.26e-06 nrd=1.16667 \
        nrs=1.16667 sa=6.1e-07 sb=2e-06 sd=160n sca=17.1738 scb=0.0176382 \
        scc=0.00148475 m=(1)
mn35 (net340 \3\:mout \21\:VSS VSS) g45n1lvt w=(2.05e-07) l=4.5e-08 nf=1 \
        as=9.415e-14 ad=1.23e-14 ps=1.54e-06 pd=5.3e-07 nrd=1.16667 \
        nrs=1.16667 sa=7.15e-07 sb=2e-06 sd=160n sca=17.1738 scb=0.0176382 \
        scc=0.00148475 m=(1)
mn30 (\9\:mout \3\:n20 \21\:VSS VSS) g45n1lvt w=(2.05e-07) l=4.5e-08 \
        nf=1 as=9.415e-14 ad=5.638e-14 ps=1.54e-06 pd=9.6e-07 nrd=1.16667 \
        nrs=1.16667 sa=1.07e-06 sb=2e-06 sd=160n sca=17.1738 scb=0.0176382 \
        scc=0.00148475 m=(1)
mn40 (\9\:mout \5\:CKbb \11\:n30 VSS) g45n1lvt w=(2.05e-07) l=4.5e-08 \
        nf=1 as=5.023e-14 ad=5.638e-14 ps=9e-07 pd=9.6e-07 nrd=1.16667 \
        nrs=1.16667 sa=1.39e-06 sb=1.96756e-06 sd=160n sca=17.1738 \
        scb=0.0176382 scc=0.00148475 m=(1)
mn51 (\11\:n30 CKb net380 VSS) g45n1lvt w=(2.05e-07) l=4.5e-08 nf=1 \
        as=1.23e-14 ad=5.023e-14 ps=5.3e-07 pd=9e-07 nrd=1.16667 \
        nrs=1.16667 sa=1.68e-06 sb=1.91805e-06 sd=160n sca=17.1738 \
        scb=0.0176382 scc=0.00148475 m=(1)
mn50 (net380 \9\:qbint \5\:VSS VSS) g45n1lvt w=(2.05e-07) l=4.5e-08 nf=1 \
        as=6.803e-14 ad=1.23e-14 ps=1.13e-06 pd=5.3e-07 nrd=1.16667 \
        nrs=1.16667 sa=1.785e-06 sb=1.87524e-06 sd=160n sca=17.1738 \
        scb=0.0176382 scc=0.00148475 m=(1)
mn45_1__rcx (\24\:qbint n30 \5\:VSS VSS) g45n1lvt w=(2.05e-07) l=4.5e-08 \
        nf=1 as=5.646e-14 ad=3.28e-14 ps=1.26e-06 pd=7.3e-07 nrd=1.16667 \
        nrs=1.16667 sa=1.90012e-06 sb=3.05e-07 sd=160n sca=13.8179 \
        scb=0.0141903 scc=0.000851218 m=(2)
mn1 (\18\:qbint \3\:Eb Db VSS) g45n1lvt w=(2.6e-07) l=4.5e-08 nf=1 \
        as=5.85e-14 ad=5.18e-14 ps=9.7e-07 pd=1.15e-06 nrd=1.16667 \
        nrs=1.16667 sa=1.99231e-07 sb=7.82692e-07 sd=160n sca=8.81533 \
        scb=0.00706435 scc=0.000179997 m=(1)
mn3 (Db \3\:E net333 VSS) g45n1lvt w=(2.6e-07) l=4.5e-08 nf=1 as=1.56e-14 \
        ad=5.85e-14 ps=6.4e-07 pd=9.7e-07 nrd=1.16667 nrs=1.16667 \
        sa=4.69231e-07 sb=5.12692e-07 sd=160n sca=8.81533 scb=0.00706435 \
        scc=0.000179997 m=(1)
mn2 (net333 \3\:D \1\:VSS VSS) g45n1lvt w=(2.6e-07) l=4.5e-08 nf=1 \
        as=6.685e-14 ad=1.56e-14 ps=1.22e-06 pd=6.4e-07 nrd=1.16667 \
        nrs=1.16667 sa=5.74231e-07 sb=4.07692e-07 sd=160n sca=8.81533 \
        scb=0.00706435 scc=0.000179997 m=(1)
mn55_1__rcx (\5\:Q qbint \5\:VSS VSS) g45n1lvt w=(2.6e-07) l=4.5e-08 \
        nf=1 as=6.261e-14 ad=7.93e-14 ps=1.045e-06 pd=1.13e-06 nrd=1.16667 \
        nrs=1.16667 sa=1.59808e-06 sb=1.5026e-06 sd=160n sca=17.5885 \
        scb=0.0172826 scc=0.00162584 m=(4)
mp25 (\4\:n20 CKbb \5\:Db VDD) g45p1lvt w=(3.1e-07) l=4.5e-08 nf=1 \
        as=4.34e-14 ad=4.96e-14 ps=9e-07 pd=9.4e-07 nrd=1.16667 \
        nrs=1.16667 sa=1.4e-07 sb=2e-06 sd=160n sca=13.1273 scb=0.0119313 \
        scc=0.000538101 m=(1)
mp36 (\4\:n20 \3\:CKb net309 VDD) g45p1lvt w=(3.1e-07) l=4.5e-08 nf=1 \
        as=9.3e-14 ad=4.96e-14 ps=1.22e-06 pd=9.4e-07 nrd=1.16667 \
        nrs=1.16667 sa=3.45e-07 sb=2e-06 sd=160n sca=13.1273 scb=0.0119313 \
        scc=0.000538101 m=(1)
mp35 (net309 \4\:mout \19\:VDD VDD) g45p1lvt w=(3.1e-07) l=4.5e-08 nf=1 \
        as=5.89e-14 ad=9.3e-14 ps=1e-06 pd=1.22e-06 nrd=1.16667 \
        nrs=1.16667 sa=6.9e-07 sb=2e-06 sd=160n sca=13.1273 scb=0.0119313 \
        scc=0.000538101 m=(1)
mp30 (\5\:mout n20 \19\:VDD VDD) g45p1lvt w=(3.1e-07) l=4.5e-08 nf=1 \
        as=5.89e-14 ad=1.209e-13 ps=1e-06 pd=1.4e-06 nrd=1.16667 \
        nrs=1.16667 sa=9.25e-07 sb=2e-06 sd=160n sca=13.1273 scb=0.0119313 \
        scc=0.000538101 m=(1)
mp40 (\5\:mout \2\:CKb \14\:n30 VDD) g45p1lvt w=(3.1e-07) l=4.5e-08 nf=1 \
        as=4.96e-14 ad=1.209e-13 ps=9.4e-07 pd=1.4e-06 nrd=1.16667 \
        nrs=1.16667 sa=1.36e-06 sb=2e-06 sd=160n sca=13.1273 scb=0.0119313 \
        scc=0.000538101 m=(1)
mp51 (\14\:n30 \7\:CKbb net317 VDD) g45p1lvt w=(3.1e-07) l=4.5e-08 nf=1 \
        as=1.86e-14 ad=4.96e-14 ps=7.4e-07 pd=9.4e-07 nrd=1.16667 \
        nrs=1.16667 sa=1.565e-06 sb=1.87e-06 sd=160n sca=13.1273 \
        scb=0.0119313 scc=0.000538101 m=(1)
mp50 (net317 \17\:qbint \5\:VDD VDD) g45p1lvt w=(3.1e-07) l=4.5e-08 nf=1 \
        as=1.471e-13 ad=1.86e-14 ps=1.77e-06 pd=7.4e-07 nrd=1.16667 \
        nrs=1.16667 sa=1.67e-06 sb=1.765e-06 sd=160n sca=13.1273 \
        scb=0.0119313 scc=0.000538101 m=(1)
mp45_1__rcx (\28\:qbint n30 \5\:VDD VDD) g45p1lvt w=(3.1e-07) l=4.5e-08 \
        nf=1 as=9.838e-14 ad=4.96e-14 ps=1.585e-06 pd=9.4e-07 nrd=1.16667 \
        nrs=1.16667 sa=2e-06 sb=3.75e-07 sd=160n sca=13.1273 scb=0.0119313 \
        scc=0.000538101 m=(2)
mp1 (\26\:qbint \1\:E \3\:Db VDD) g45p1lvt w=(3.9e-07) l=4.5e-08 nf=1 \
        as=8.19e-14 ad=5.46e-14 ps=1.2e-06 pd=1.06e-06 nrd=1.16667 \
        nrs=1.16667 sa=1.4e-07 sb=7.92756e-07 sd=160n sca=18.3796 \
        scb=0.0159892 scc=0.00159615 m=(1)
mp3 (\3\:Db Eb net328 VDD) g45p1lvt w=(3.9e-07) l=4.5e-08 nf=1 \
        as=5.265e-14 ad=8.19e-14 ps=1.05e-06 pd=1.2e-06 nrd=1.16667 \
        nrs=1.16667 sa=3.95e-07 sb=5.37756e-07 sd=160n sca=18.4282 \
        scb=0.0159986 scc=0.00159615 m=(1)
mp2 (net328 \1\:D \1\:VDD VDD) g45p1lvt w=(3.9e-07) l=4.5e-08 nf=1 \
        as=9.975e-14 ad=5.265e-14 ps=1.48e-06 pd=1.05e-06 nrd=1.16667 \
        nrs=1.16667 sa=5.75e-07 sb=3.57756e-07 sd=160n sca=18.9201 \
        scb=0.0161836 scc=0.00159622 m=(1)
mp55 (\1\:Q qbint \5\:VDD VDD) g45p1lvt w=(3.9e-07) l=4.5e-08 nf=1 \
        as=1.1359e-13 ad=6.24e-14 ps=1.57e-06 pd=1.1e-06 nrd=1.16667 \
        nrs=1.16667 sa=1.62462e-06 sb=1.23051e-06 sd=160n sca=12.53 \
        scb=0.0110214 scc=0.000443901 m=(4)
ends EDFFHQX4
// End of subcircuit definition.
