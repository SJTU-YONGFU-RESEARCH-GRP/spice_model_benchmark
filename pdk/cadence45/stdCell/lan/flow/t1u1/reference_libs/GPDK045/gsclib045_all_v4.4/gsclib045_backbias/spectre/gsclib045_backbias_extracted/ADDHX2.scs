// Generated for: spectre (May  1 11:26:56 2013 )
// Library name: gsclib045_backbias
// Cell name: ADDHX2
// View name: extracted

simulator lang=spectre

subckt ADDHX2 A B CO NW S VDD VSS
mp7 (\7\:COb \1\:B \11\:VDD NW) g45p1svt w=(2.15e-07) l=4.5e-08 nf=1 \
        as=3.01e-14 ad=3.762e-14 ps=7.1e-07 pd=7.8e-07 nrd=1.16667 \
        nrs=1.16667 sa=1.4e-07 sb=2e-06 sd=160n sca=21.026 scb=0.0229138 \
        scc=0.00110307 m=(1)
mp6 (\7\:COb \4\:A \1\:VDD NW) g45p1svt w=(2.15e-07) l=4.5e-08 nf=1 \
        as=8.305e-14 ad=3.762e-14 ps=1.32e-06 pd=7.8e-07 nrd=1.16667 \
        nrs=1.16667 sa=3.6e-07 sb=1.99709e-06 sd=160n sca=17.3029 \
        scb=0.01671 scc=0.000962068 m=(1)
mp0 (\5\:n0 \6\:A \1\:VDD NW) g45p1svt w=(2.15e-07) l=4.5e-08 nf=1 \
        as=6.998e-14 ad=4.3e-14 ps=1.66e-06 pd=8.3e-07 nrd=1.16667 \
        nrs=1.16667 sa=1.03e-06 sb=1.42337e-06 sd=160n sca=15.6338 \
        scb=0.015455 scc=0.000959319 m=(1)
mp4 (\8\:Sb \4\:B \5\:n0 NW) g45p1svt w=(2.15e-07) l=4.5e-08 nf=1 \
        as=4.3e-14 ad=5.052e-14 ps=8.3e-07 pd=9e-07 nrd=1.16667 \
        nrs=1.16667 sa=1.275e-06 sb=1.17837e-06 sd=160n sca=15.6338 \
        scb=0.015455 scc=0.000959319 m=(1)
mp3 (\8\:Sb n1 n3 NW) g45p1svt w=(2.15e-07) l=4.5e-08 nf=1 as=3.332e-14 \
        ad=5.052e-14 ps=7.4e-07 pd=9e-07 nrd=1.16667 nrs=1.16667 \
        sa=1.555e-06 sb=8.98372e-07 sd=160n sca=15.6338 scb=0.015455 \
        scc=0.000959319 m=(1)
mp2 (n3 \2\:n0 \6\:VDD NW) g45p1svt w=(2.15e-07) l=4.5e-08 nf=1 \
        as=8.075e-14 ad=3.332e-14 ps=1.38e-06 pd=7.4e-07 nrd=1.16667 \
        nrs=1.16667 sa=1.755e-06 sb=6.98372e-07 sd=160n sca=15.6338 \
        scb=0.015455 scc=0.000959319 m=(1)
mp1 (\6\:n1 \8\:B \6\:VDD NW) g45p1svt w=(2.15e-07) l=4.5e-08 nf=1 \
        as=6.39e-14 ad=3.01e-14 ps=1.45e-06 pd=7.1e-07 nrd=1.16667 \
        nrs=1.16667 sa=1.12791e-06 sb=1.4e-07 sd=160n sca=50.7282 \
        scb=0.0349898 scc=0.00599471 m=(1)
C1 (NW VSS) capacitor c=4.1339e-16
C2 (S VSS) capacitor c=2.35573e-17
C3 (VDD VSS) capacitor c=2.88672e-17
C4 (B VSS) capacitor c=9.74319e-17
C5 (CO VSS) capacitor c=6.72865e-17
C6 (n4 VSS) capacitor c=1.29764e-18
C7 (COb VSS) capacitor c=1.98708e-16
C8 (n0 VSS) capacitor c=9.40438e-17
C9 (Sb VSS) capacitor c=1.88475e-16
C10 (n1 VSS) capacitor c=4.10422e-17
C11 (\8\:B VSS) capacitor c=4.99871e-17
C12 (\2\:n0 VSS) capacitor c=4.98324e-17
C13 (\4\:B VSS) capacitor c=5.21772e-17
C14 (\6\:A VSS) capacitor c=4.206e-17
C15 (\4\:A VSS) capacitor c=2.42975e-17
C16 (\1\:B VSS) capacitor c=3.34053e-17
C17 (\9\:B VSS) capacitor c=2.7117e-17
C18 (\6\:B VSS) capacitor c=8.03793e-17
C19 (\3\:n1 VSS) capacitor c=4.19314e-17
C20 (\5\:A VSS) capacitor c=5.35156e-17
C21 (\3\:A VSS) capacitor c=5.23265e-17
C22 (\3\:B VSS) capacitor c=1.9409e-17
C23 (\10\:B VSS) capacitor c=2.19294e-17
C24 (\3\:n0 VSS) capacitor c=3.21844e-17
C25 (\4\:n1 VSS) capacitor c=3.35379e-17
C26 (\7\:B VSS) capacitor c=2.94892e-17
C27 (\5\:B VSS) capacitor c=2.62693e-17
C28 (\7\:A VSS) capacitor c=3.88456e-17
C29 (\1\:A VSS) capacitor c=3.13562e-17
C30 (\2\:B VSS) capacitor c=3.36344e-17
C31 (\6\:n1 VSS) capacitor c=7.97797e-17
C32 (\3\:S VSS) capacitor c=6.78853e-17
C33 (\8\:Sb VSS) capacitor c=5.46899e-17
C34 (\5\:n0 VSS) capacitor c=1.1405e-16
C35 (\1\:VDD VSS) capacitor c=1.61191e-16
C36 (\1\:CO VSS) capacitor c=4.31098e-17
C37 (\7\:COb VSS) capacitor c=2.79216e-17
C38 (\11\:VDD VSS) capacitor c=3.65186e-17
C39 (\8\:n1 VSS) capacitor c=3.5028e-17
C40 (\1\:S VSS) capacitor c=3.82099e-17
C41 (\11\:Sb VSS) capacitor c=3.69193e-17
C42 (\7\:n0 VSS) capacitor c=8.38314e-17
C43 (\3\:CO VSS) capacitor c=9.8151e-17
C44 (\10\:COb VSS) capacitor c=5.47139e-17
C45 (\2\:A VSS) capacitor c=2.18427e-17
C46 (\2\:n1 VSS) capacitor c=4.37483e-17
C47 (\9\:COb VSS) capacitor c=9.42385e-17
C48 (\12\:COb VSS) capacitor c=7.10105e-17
C49 (\8\:A VSS) capacitor c=1.41458e-16
C50 (\9\:A VSS) capacitor c=7.63286e-17
C51 (\4\:n0 VSS) capacitor c=5.86701e-17
C52 (\10\:Sb VSS) capacitor c=6.50348e-17
C53 (\13\:Sb VSS) capacitor c=6.48401e-17
C54 (\11\:B VSS) capacitor c=7.52984e-17
C55 (\12\:B VSS) capacitor c=8.52557e-17
C56 (\13\:B VSS) capacitor c=1.45124e-16
C57 (\14\:B VSS) capacitor c=4.15656e-17
C58 (\15\:B VSS) capacitor c=2.30158e-17
C59 (\16\:B VSS) capacitor c=8.00398e-17
C60 (\5\:n1 VSS) capacitor c=1.33757e-16
C61 (\5\:VDD VSS) capacitor c=3.09041e-17
C62 (\6\:VDD VSS) capacitor c=2.26709e-16
Rk13 (\2\:S S) resistor r=0.06584 c=0
Rk14 (S \4\:S) resistor r=0.1742 c=0
Rk26 (\5\:VDD VDD) resistor r=0.06723 c=0
Rk25 (\1\:VDD \5\:VDD) resistor r=0.2127 c=0
Rk27 (\1\:VDD \6\:VDD) resistor r=0.4633 c=0
Rk30 (\5\:VDD \12\:VDD) resistor r=0.3331 c=0
Rk15 (\11\:B \12\:B) resistor r=0.6681 c=0
Rk17 (\13\:B B) resistor r=1.0327 c=0
Rk16 (\12\:B \13\:B) resistor r=0.2242 c=0
Rk18 (B \14\:B) resistor r=0.06992 c=0
Rk19 (\12\:B \15\:B) resistor r=0.0529 c=0
Rk20 (\13\:B \16\:B) resistor r=0.3772 c=0
Rk4 (\2\:CO CO) resistor r=0.1079 c=0
Rk5 (CO \4\:CO) resistor r=0.4183 c=0
Rk6 (\8\:A A) resistor r=0.008457 c=0
Rk7 (A \9\:A) resistor r=0.6088 c=0
Rk32 (\2\:VSS \3\:VSS) resistor r=0.09661 c=0
Rk34 (\3\:VSS \5\:VSS) resistor r=0.4175 c=0
Rk37 (\6\:VSS VSS) resistor r=0.2477 c=0
Rk35 (\5\:VSS \6\:VSS) resistor r=0.06653 c=0
Rk1 (\8\:COb \9\:COb) resistor r=0.1196 c=0
Rk2 (\9\:COb \11\:COb) resistor r=0.4804 c=0
Rk3 (\9\:COb \12\:COb) resistor r=0.4412 c=0
Rk8 (\4\:n0 \6\:n0) resistor r=0.5155 c=0
Rk9 (\6\:n0 \8\:n0) resistor r=0.3658 c=0
Rk10 (\9\:Sb \10\:Sb) resistor r=0.2687 c=0
Rk11 (\10\:Sb \12\:Sb) resistor r=0.1185 c=0
Rk12 (\10\:Sb \13\:Sb) resistor r=0.3284 c=0
Rk21 (\5\:n1 \7\:n1) resistor r=0.874 c=0
Rk22 (\7\:n1 \9\:n1) resistor r=0.2346 c=0
Rl26 (\8\:B \9\:B) resistor r=92.3077 c=0
Rl27 (\9\:B \10\:B) resistor r=44.9028 c=0
Rl14 (\6\:B \7\:B) resistor r=85.3072 c=0
Rl13 (\4\:B \5\:B) resistor r=31.8672 c=0
Rl1 (\1\:B \2\:B) resistor r=86.5385 c=0
Rl2 (\2\:B \3\:B) resistor r=29.9451 c=0
Rl11 (\5\:A \6\:A) resistor r=143.15 c=0
Rl12 (\6\:A \7\:A) resistor r=39.2094 c=0
Rl5 (\2\:A \4\:A) resistor r=27.9498 c=0
Rl4 (\2\:A \3\:A) resistor r=120.314 c=0
Rl3 (\1\:A \2\:A) resistor r=17.3448 c=0
Rl18 (n0 \2\:n0) resistor r=141.873 c=0
Rl19 (\2\:n0 \3\:n0) resistor r=30.2349 c=0
Rl15 (n1 \2\:n1) resistor r=23.7402 c=0
Rl16 (\2\:n1 \3\:n1) resistor r=126.797 c=0
Rl17 (\2\:n1 \4\:n1) resistor r=5.1011 c=0
Rz5 (\2\:S \1\:S) resistor r=75 c=0
Rz2 (\4\:CO \3\:CO) resistor r=75 c=0
Rz1 (\11\:COb \10\:COb) resistor r=75 c=0
Rz3 (\7\:n0 \8\:n0) resistor r=75 c=0
Rz4 (\12\:Sb \11\:Sb) resistor r=75 c=0
Rz6 (\8\:n1 \9\:n1) resistor r=75 c=0
Ry5 (\4\:S \3\:S) resistor r=62 c=0
Ry10 (\12\:VDD \11\:VDD) resistor r=62 c=0
Ry2 (\2\:CO \1\:CO) resistor r=62 c=0
Ry12 (\2\:VSS \1\:VSS) resistor r=20.6667 c=0
Ry13 (\5\:VSS \1\:VSS) resistor r=5.1667 c=0
Ry1 (\8\:COb \7\:COb) resistor r=62 c=0
Ry3 (\5\:n0 \6\:n0) resistor r=62 c=0
Ry4 (\9\:Sb \8\:Sb) resistor r=62 c=0
Ry6 (\6\:n1 \7\:n1) resistor r=62 c=0
Rx6 (\10\:B \11\:B) resistor r=45 c=0
Rx7 (\2\:B \14\:B) resistor r=45 c=0
Rx8 (\7\:B \15\:B) resistor r=45 c=0
Rx9 (\5\:B \16\:B) resistor r=45 c=0
Rx2 (\1\:A \8\:A) resistor r=45 c=0
Rx3 (\7\:A \9\:A) resistor r=45 c=0
Rx1 (\12\:COb COb) resistor r=45 c=0
Rx4 (\3\:n0 \4\:n0) resistor r=45 c=0
Rx5 (\13\:Sb Sb) resistor r=45 c=0
Rx10 (\4\:n1 \5\:n1) resistor r=45 c=0
mn7 (\10\:COb \3\:B n4 VSS) g45n1svt w=(1.45e-07) l=4.5e-08 nf=1 \
        as=2.973e-14 ad=2.755e-14 ps=7e-07 pd=6.7e-07 nrd=1.16667 \
        nrs=1.16667 sa=1.9e-07 sb=2e-06 sd=160n sca=23.279 scb=0.0230742 \
        scc=0.00267719 m=(1)
mn6 (n4 \3\:A \6\:VSS VSS) g45n1svt w=(1.45e-07) l=4.5e-08 nf=1 \
        as=5.765e-14 ad=2.973e-14 ps=1.6e-06 pd=7e-07 nrd=1.16667 \
        nrs=1.16667 sa=4.4e-07 sb=2e-06 sd=160n sca=23.279 scb=0.0230742 \
        scc=0.00267719 m=(1)
mn0 (\7\:n0 \5\:A \6\:VSS VSS) g45n1svt w=(1.45e-07) l=4.5e-08 nf=1 \
        as=8.985e-14 ad=5.075e-14 ps=1.6e-06 pd=9.9e-07 nrd=1.16667 \
        nrs=1.16667 sa=1.105e-06 sb=1.59e-06 sd=160n sca=23.279 \
        scb=0.0230742 scc=0.00267719 m=(1)
mn4 (\11\:Sb \3\:n1 \7\:n0 VSS) g45n1svt w=(1.45e-07) l=4.5e-08 nf=1 \
        as=5.075e-14 ad=2.32e-14 ps=9.9e-07 pd=6.1e-07 nrd=1.16667 \
        nrs=1.16667 sa=1.5e-06 sb=1.195e-06 sd=160n sca=23.279 \
        scb=0.0230742 scc=0.00267719 m=(1)
mn3 (\11\:Sb \6\:B n2 VSS) g45n1svt w=(1.45e-07) l=4.5e-08 nf=1 \
        as=8.7e-15 ad=2.32e-14 ps=4.1e-07 pd=6.1e-07 nrd=1.16667 \
        nrs=1.16667 sa=1.705e-06 sb=9.9e-07 sd=160n sca=23.279 \
        scb=0.0230742 scc=0.00267719 m=(1)
mn2 (n2 n0 \3\:VSS VSS) g45n1svt w=(1.45e-07) l=4.5e-08 nf=1 \
        as=8.985e-14 ad=8.7e-15 ps=1.6e-06 pd=4.1e-07 nrd=1.16667 \
        nrs=1.16667 sa=1.81e-06 sb=8.85e-07 sd=160n sca=23.279 \
        scb=0.0230742 scc=0.00267719 m=(1)
mn1 (\8\:n1 \9\:B \3\:VSS VSS) g45n1svt w=(1.45e-07) l=4.5e-08 nf=1 \
        as=9.13e-14 ad=2.03e-14 ps=1.62e-06 pd=5.7e-07 nrd=1.16667 \
        nrs=1.16667 sa=2e-06 sb=1.4e-07 sd=160n sca=23.279 scb=0.0230742 \
        scc=0.00267719 m=(1)
mn5 (\1\:S Sb \3\:VSS VSS) g45n1svt w=(2.6e-07) l=4.5e-08 nf=1 \
        as=9.058e-14 ad=4.16e-14 ps=1.61e-06 pd=8.4e-07 nrd=1.16667 \
        nrs=1.16667 sa=1.19058e-06 sb=5.11635e-07 sd=160n sca=17.5885 \
        scb=0.0172826 scc=0.00162584 m=(2)
mn8 (\3\:CO COb \6\:VSS VSS) g45n1svt w=(2.6e-07) l=4.5e-08 nf=1 \
        as=7.375e-14 ad=4.16e-14 ps=1.6e-06 pd=8.4e-07 nrd=1.16667 \
        nrs=1.16667 sa=3.98365e-07 sb=1.28125e-06 sd=160n sca=17.5885 \
        scb=0.0172826 scc=0.00162584 m=(2)
mp8_1__rcx (\1\:CO COb \1\:VDD NW) g45p1svt w=(3.9e-07) l=4.5e-08 nf=1 \
        as=7.651e-14 ad=6.24e-14 ps=1.49e-06 pd=1.1e-06 nrd=1.16667 \
        nrs=1.16667 sa=4.20833e-07 sb=1.14481e-06 sd=160n sca=13.4335 \
        scb=0.0117789 scc=0.000556063 m=(2)
mp5 (\3\:S Sb \6\:VDD NW) g45p1svt w=(3.9e-07) l=4.5e-08 nf=1 \
        as=7.233e-14 ad=6.24e-14 ps=1.415e-06 pd=1.1e-06 nrd=1.16667 \
        nrs=1.16667 sa=1.15641e-06 sb=4.35449e-07 sd=160n sca=31.0599 \
        scb=0.0204054 scc=0.00336104 m=(2)
ends ADDHX2
// End of subcircuit definition.
