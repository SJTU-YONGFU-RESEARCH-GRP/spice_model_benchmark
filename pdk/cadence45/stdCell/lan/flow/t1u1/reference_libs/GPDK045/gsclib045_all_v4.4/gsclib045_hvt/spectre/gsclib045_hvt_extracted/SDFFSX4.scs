// Generated for: spectre (May  1 09:16:01 2013 )
// Library name: gsclib045_hvt
// Cell name: SDFFSX4
// View name: extracted

simulator lang=spectre

subckt SDFFSX4 CK D Q QN SE SI SN VDD VSS
mp56 (\14\:net492 \16\:qbint \22\:VDD VDD) g45p1hvt w=(3.9e-07) \
        l=4.5e-08 nf=1 as=6.24e-14 ad=4.38e-14 ps=1.1e-06 pd=1.06e-06 \
        nrd=1.16667 nrs=1.16667 sa=1.12308e-07 sb=1.52744e-06 sd=160n \
        sca=13.5671 scb=0.012183 scc=0.000647513 m=(1)
mp57_1__rcx (QN net492 VDD VDD) g45p1hvt w=(3.9e-07) l=4.5e-08 nf=1 \
        as=5.58e-14 ad=6.24e-14 ps=1.08e-06 pd=1.1e-06 nrd=1.16667 \
        nrs=1.16667 sa=1.4e-07 sb=7.27308e-07 sd=160n sca=44.1638 \
        scb=0.0392167 scc=0.00476734 m=(4)
mp55_1__rcx (Q qbint \22\:VDD VDD) g45p1hvt w=(3.9e-07) l=4.5e-08 nf=1 \
        as=6.12e-14 ad=6.24e-14 ps=1.1e-06 pd=1.1e-06 nrd=1.16667 \
        nrs=1.16667 sa=3.17308e-07 sb=1.32244e-06 sd=160n sca=13.5671 \
        scb=0.012183 scc=0.000647513 m=(4)
C1 (CK VSS) capacitor c=1.07694e-16
C2 (SE VSS) capacitor c=4.26541e-17
C3 (SN VSS) capacitor c=1.91044e-16
C4 (SI VSS) capacitor c=4.0814e-17
C5 (QN VSS) capacitor c=2.12925e-16
C6 (D VSS) capacitor c=4.0662e-17
C7 (Q VSS) capacitor c=2.84818e-16
C8 (VDD VSS) capacitor c=6.55149e-16
C9 (net492 VSS) capacitor c=1.91922e-16
C10 (qbint VSS) capacitor c=2.35708e-16
C11 (n35 VSS) capacitor c=2.06966e-16
C12 (net518 VSS) capacitor c=3.18242e-18
C13 (CKb VSS) capacitor c=3.24901e-17
C14 (mout VSS) capacitor c=2.59816e-17
C15 (CKbb VSS) capacitor c=3.26463e-17
C16 (n20 VSS) capacitor c=2.51871e-17
C17 (Db VSS) capacitor c=4.91516e-17
C18 (net494 VSS) capacitor c=8.83234e-18
C19 (SEb VSS) capacitor c=3.19583e-17
C20 (net405 VSS) capacitor c=8.79322e-17
C21 (net417 VSS) capacitor c=1.10836e-18
C22 (net433 VSS) capacitor c=3.3673e-18
C23 (\7\:SE VSS) capacitor c=5.28682e-17
C24 (\3\:SI VSS) capacitor c=5.56322e-17
C25 (\2\:SE VSS) capacitor c=3.89017e-17
C26 (\3\:D VSS) capacitor c=4.88171e-17
C27 (\1\:CK VSS) capacitor c=3.3654e-17
C28 (\11\:CKb VSS) capacitor c=2.37305e-17
C29 (\5\:CKbb VSS) capacitor c=3.02927e-17
C30 (\5\:CKb VSS) capacitor c=6.9698e-17
C31 (\3\:mout VSS) capacitor c=9.13372e-17
C32 (\4\:n20 VSS) capacitor c=4.55189e-17
C33 (\4\:SN VSS) capacitor c=4.68729e-17
C34 (\3\:CKb VSS) capacitor c=5.26463e-17
C35 (\17\:qbint VSS) capacitor c=5.31648e-17
C36 (\1\:SN VSS) capacitor c=5.25778e-17
C37 (\16\:qbint VSS) capacitor c=3.55076e-17
C38 (\5\:SE VSS) capacitor c=2.99651e-17
C39 (\1\:SI VSS) capacitor c=6.47736e-17
C40 (\3\:SE VSS) capacitor c=6.87488e-17
C41 (\3\:SEb VSS) capacitor c=7.20712e-17
C42 (\1\:D VSS) capacitor c=3.98931e-17
C43 (\3\:CK VSS) capacitor c=4.8259e-17
C44 (\7\:CKb VSS) capacitor c=2.2918e-17
C45 (\9\:CKb VSS) capacitor c=5.05913e-17
C46 (\7\:CKbb VSS) capacitor c=3.98771e-17
C47 (\3\:n20 VSS) capacitor c=6.57676e-17
C48 (\6\:SN VSS) capacitor c=4.17603e-17
C49 (\3\:CKbb VSS) capacitor c=2.74024e-17
C50 (\19\:qbint VSS) capacitor c=2.32118e-17
C51 (\3\:SN VSS) capacitor c=4.46369e-17
C52 (\7\:qbint VSS) capacitor c=2.57208e-17
C53 (\6\:SE VSS) capacitor c=4.43641e-17
C54 (\2\:SI VSS) capacitor c=6.16559e-17
C55 (\4\:SE VSS) capacitor c=4.7594e-17
C56 (\2\:SEb VSS) capacitor c=6.51999e-17
C57 (\1\:SE VSS) capacitor c=4.25606e-17
C58 (\2\:D VSS) capacitor c=5.39514e-17
C59 (\2\:CK VSS) capacitor c=4.39692e-17
C60 (\6\:CKbb VSS) capacitor c=3.69933e-17
C61 (\6\:CKb VSS) capacitor c=2.67541e-17
C62 (\2\:mout VSS) capacitor c=4.88771e-17
C63 (\5\:SN VSS) capacitor c=4.34452e-17
C64 (\4\:CKbb VSS) capacitor c=2.76775e-17
C65 (\4\:CKb VSS) capacitor c=2.69999e-17
C66 (\2\:CKb VSS) capacitor c=3.44292e-17
C67 (\18\:qbint VSS) capacitor c=4.46228e-17
C68 (\2\:SN VSS) capacitor c=6.26177e-17
C69 (\6\:n35 VSS) capacitor c=1.77258e-17
C70 (\9\:qbint VSS) capacitor c=2.28606e-17
C71 (\8\:net492 VSS) capacitor c=9.75019e-18
C72 (\8\:SEb VSS) capacitor c=1.4032e-17
C73 (\6\:VDD VSS) capacitor c=2.8859e-17
C74 (\8\:Db VSS) capacitor c=8.6752e-17
C75 (\8\:VDD VSS) capacitor c=1.81001e-17
C76 (\12\:CKb VSS) capacitor c=5.11017e-17
C77 (\10\:VDD VSS) capacitor c=1.41705e-17
C78 (\10\:CKbb VSS) capacitor c=1.02298e-16
C79 (\6\:Db VSS) capacitor c=8.89775e-17
C80 (\9\:n20 VSS) capacitor c=4.05658e-17
C81 (\13\:VDD VSS) capacitor c=1.49695e-17
C82 (\12\:mout VSS) capacitor c=3.04485e-17
C83 (\16\:VDD VSS) capacitor c=2.84134e-17
C84 (\14\:mout VSS) capacitor c=3.47096e-17
C85 (\10\:n35 VSS) capacitor c=8.60932e-17
C86 (\20\:VDD VSS) capacitor c=2.86854e-17
C87 (\3\:net405 VSS) capacitor c=9.75647e-17
C88 (\26\:qbint VSS) capacitor c=8.70509e-17
C89 (\14\:net492 VSS) capacitor c=3.25352e-17
C90 (\1\:VDD VSS) capacitor c=8.24093e-17
C91 (\4\:SEb VSS) capacitor c=7.53462e-17
C92 (\19\:CKb VSS) capacitor c=5.53213e-17
C93 (\8\:CKbb VSS) capacitor c=8.12608e-17
C94 (\4\:Db VSS) capacitor c=1.67388e-16
C95 (\5\:n20 VSS) capacitor c=5.14752e-17
C96 (\10\:mout VSS) capacitor c=2.97135e-17
C97 (\8\:mout VSS) capacitor c=9.5013e-17
C98 (\12\:n35 VSS) capacitor c=3.50244e-17
C99 (\24\:qbint VSS) capacitor c=2.32681e-17
C100 (\18\:net492 VSS) capacitor c=1.51591e-17
C101 (\6\:qbint VSS) capacitor c=1.36419e-17
C102 (\2\:CKbb VSS) capacitor c=2.29337e-17
C103 (\2\:n20 VSS) capacitor c=3.62463e-17
C104 (\16\:net492 VSS) capacitor c=2.07114e-17
C105 (\17\:net492 VSS) capacitor c=1.8227e-17
C106 (\8\:CKb VSS) capacitor c=3.35554e-17
C107 (\20\:qbint VSS) capacitor c=6.72624e-17
C108 (\21\:qbint VSS) capacitor c=6.43771e-17
C109 (\23\:qbint VSS) capacitor c=4.08533e-17
C110 (\8\:n35 VSS) capacitor c=1.60197e-16
C111 (\9\:n35 VSS) capacitor c=1.61515e-16
C112 (\7\:SN VSS) capacitor c=1.84852e-16
C113 (\8\:SN VSS) capacitor c=8.37469e-17
C114 (\4\:mout VSS) capacitor c=5.23717e-17
C115 (\5\:mout VSS) capacitor c=4.08722e-17
C116 (\6\:mout VSS) capacitor c=3.63553e-17
C117 (\7\:mout VSS) capacitor c=6.57502e-17
C118 (\7\:n20 VSS) capacitor c=6.3996e-17
C119 (\8\:n20 VSS) capacitor c=4.54689e-17
C120 (\12\:CKbb VSS) capacitor c=2.00873e-16
C121 (\13\:CKbb VSS) capacitor c=2.03768e-16
C122 (\14\:CKbb VSS) capacitor c=6.00383e-17
C123 (\14\:CKb VSS) capacitor c=1.29069e-16
C124 (\15\:CKb VSS) capacitor c=9.76116e-17
C125 (\16\:CKb VSS) capacitor c=1.44538e-16
C126 (\17\:CKb VSS) capacitor c=1.59136e-16
C127 (\18\:CKb VSS) capacitor c=8.98833e-17
C128 (\4\:D VSS) capacitor c=7.27952e-17
C129 (\3\:Db VSS) capacitor c=2.16681e-16
C130 (\4\:SI VSS) capacitor c=4.70998e-17
C131 (\8\:SE VSS) capacitor c=5.30396e-17
C132 (\9\:SE VSS) capacitor c=7.68465e-17
C133 (\10\:SE VSS) capacitor c=6.45579e-17
C134 (\6\:SEb VSS) capacitor c=9.57093e-17
C135 (\7\:SEb VSS) capacitor c=5.68098e-17
C136 (\3\:VDD VSS) capacitor c=2.33876e-17
C137 (\4\:VDD VSS) capacitor c=3.17883e-17
C138 (\12\:VDD VSS) capacitor c=4.22e-17
C139 (\15\:VDD VSS) capacitor c=1.83509e-17
C140 (\19\:VDD VSS) capacitor c=1.38208e-17
C141 (\22\:VDD VSS) capacitor c=3.1058e-16
Rk60 (\2\:VSS \3\:VSS) resistor r=0.09006 c=0
Rk61 (\3\:VSS \4\:VSS) resistor r=0.4408 c=0
Rk62 (\4\:VSS \5\:VSS) resistor r=0.2718 c=0
Rk63 (\3\:VSS \7\:VSS) resistor r=0.3106 c=0
Rk64 (\4\:VSS \9\:VSS) resistor r=0.2632 c=0
Rk65 (\5\:VSS \10\:VSS) resistor r=0.5714 c=0
Rk66 (\10\:VSS \11\:VSS) resistor r=0.2794 c=0
Rk67 (\11\:VSS \12\:VSS) resistor r=0.3498 c=0
Rk68 (\12\:VSS \13\:VSS) resistor r=0.5062 c=0
Rk73 (\17\:VSS VSS) resistor r=0.1252 c=0
Rk72 (\13\:VSS \17\:VSS) resistor r=0.06499 c=0
Rk76 (\5\:VSS \21\:VSS) resistor r=0.07145 c=0
Rk77 (\10\:VSS \23\:VSS) resistor r=0.278 c=0
Rk78 (\11\:VSS \25\:VSS) resistor r=0.04329 c=0
Rk47 (\4\:CK CK) resistor r=0.00264 c=0
Rk54 (SE \8\:SE) resistor r=0.1929 c=0
Rk55 (\8\:SE \9\:SE) resistor r=0.2622 c=0
Rk56 (\9\:SE \10\:SE) resistor r=0.4257 c=0
Rk25 (\7\:SN SN) resistor r=1.33 c=0
Rk26 (SN \8\:SN) resistor r=0.4257 c=0
Rk53 (SI \4\:SI) resistor r=0.01176 c=0
Rk48 (D \4\:D) resistor r=0.05101 c=0
Rk86 (\2\:VDD \3\:VDD) resistor r=0.09758 c=0
Rk87 (\3\:VDD \4\:VDD) resistor r=0.4534 c=0
Rk88 (\4\:VDD \5\:VDD) resistor r=0.2505 c=0
Rk89 (\3\:VDD \7\:VDD) resistor r=0.2036 c=0
Rk90 (\4\:VDD \9\:VDD) resistor r=0.2036 c=0
Rk91 (\5\:VDD \11\:VDD) resistor r=0.1199 c=0
Rk92 (\5\:VDD \12\:VDD) resistor r=0.6212 c=0
Rk93 (\12\:VDD \14\:VDD) resistor r=0.04329 c=0
Rk94 (\12\:VDD \15\:VDD) resistor r=0.3672 c=0
Rk95 (\15\:VDD \17\:VDD) resistor r=0.1557 c=0
Rk96 (\15\:VDD \18\:VDD) resistor r=0.2129 c=0
Rk97 (\18\:VDD \19\:VDD) resistor r=0.2881 c=0
Rk98 (\19\:VDD \21\:VDD) resistor r=0.219 c=0
Rk99 (\19\:VDD \22\:VDD) resistor r=0.2328 c=0
Rk108 (\34\:VDD VDD) resistor r=0.1402 c=0
Rk107 (\22\:VDD \34\:VDD) resistor r=0.06499 c=0
Rk7 (\15\:net492 \16\:net492) resistor r=0.2251 c=0
Rk8 (\16\:net492 \17\:net492) resistor r=0.1311 c=0
Rk9 (\16\:net492 \19\:net492) resistor r=0.1174 c=0
Rk16 (\20\:qbint \21\:qbint) resistor r=0.3788 c=0
Rk17 (\21\:qbint \22\:qbint) resistor r=0.06153 c=0
Rk18 (\22\:qbint \23\:qbint) resistor r=0.1475 c=0
Rk19 (\21\:qbint \25\:qbint) resistor r=0.1041 c=0
Rk20 (\22\:qbint \27\:qbint) resistor r=0.3776 c=0
Rk22 (\8\:n35 \9\:n35) resistor r=1.0176 c=0
Rk23 (\9\:n35 \11\:n35) resistor r=0.4233 c=0
Rk24 (\9\:n35 \13\:n35) resistor r=0.08643 c=0
Rk41 (\13\:CKb \14\:CKb) resistor r=0.3463 c=0
Rk42 (\14\:CKb \15\:CKb) resistor r=0.4032 c=0
Rk43 (\14\:CKb \16\:CKb) resistor r=0.6196 c=0
Rk44 (\16\:CKb \17\:CKb) resistor r=0.9034 c=0
Rk45 (\17\:CKb \18\:CKb) resistor r=0.5308 c=0
Rk46 (\15\:CKb \20\:CKb) resistor r=0.3914 c=0
Rk27 (\4\:mout \5\:mout) resistor r=0.2233 c=0
Rk28 (\5\:mout \6\:mout) resistor r=0.1867 c=0
Rk29 (\6\:mout \7\:mout) resistor r=0.2377 c=0
Rk30 (\7\:mout \9\:mout) resistor r=0.4579 c=0
Rk31 (\5\:mout \11\:mout) resistor r=0.1216 c=0
Rk32 (\6\:mout \13\:mout) resistor r=0.1128 c=0
Rk33 (\7\:mout \15\:mout) resistor r=0.1202 c=0
Rk37 (\9\:CKbb \11\:CKbb) resistor r=0.3652 c=0
Rk38 (\11\:CKbb \12\:CKbb) resistor r=0.4421 c=0
Rk39 (\12\:CKbb \13\:CKbb) resistor r=1.246 c=0
Rk40 (\12\:CKbb \14\:CKbb) resistor r=0.246 c=0
Rk34 (\6\:n20 \7\:n20) resistor r=0.3333 c=0
Rk35 (\7\:n20 \8\:n20) resistor r=0.2209 c=0
Rk36 (\7\:n20 \10\:n20) resistor r=0.0932 c=0
Rk49 (\2\:Db \3\:Db) resistor r=0.3001 c=0
Rk50 (\3\:Db \5\:Db) resistor r=1.1436 c=0
Rk51 (\5\:Db \7\:Db) resistor r=0.3956 c=0
Rk52 (\3\:Db \9\:Db) resistor r=0.6019 c=0
Rk57 (\5\:SEb \6\:SEb) resistor r=0.7996 c=0
Rk58 (\6\:SEb \7\:SEb) resistor r=0.4064 c=0
Rk59 (\6\:SEb \9\:SEb) resistor r=0.04776 c=0
Rk21 (\2\:net405 \4\:net405) resistor r=0.4518 c=0
Rl57 (\1\:CK \2\:CK) resistor r=62.2302 c=0
Rl58 (\2\:CK \3\:CK) resistor r=158.384 c=0
Rl68 (\6\:SE \7\:SE) resistor r=178.021 c=0
Rl67 (\5\:SE \6\:SE) resistor r=35.7134 c=0
Rl64 (\3\:SE \4\:SE) resistor r=26.1559 c=0
Rl61 (\1\:SE \2\:SE) resistor r=62.7538 c=0
Rl43 (\4\:SN \5\:SN) resistor r=99.3524 c=0
Rl44 (\5\:SN \6\:SN) resistor r=29.5379 c=0
Rl34 (\1\:SN \2\:SN) resistor r=119.922 c=0
Rl35 (\2\:SN \3\:SN) resistor r=102.615 c=0
Rl66 (\2\:SI \3\:SI) resistor r=130.12 c=0
Rl65 (\1\:SI \2\:SI) resistor r=84.4104 c=0
Rl60 (\2\:D \3\:D) resistor r=118.464 c=0
Rl59 (\1\:D \2\:D) resistor r=113.016 c=0
Rl7 (net492 \8\:net492) resistor r=9.5287 c=0
Rl36 (\18\:qbint \17\:qbint) resistor r=193 c=0
Rl37 (\18\:qbint \19\:qbint) resistor r=29.5379 c=0
Rl20 (qbint \9\:qbint) resistor r=4.8851 c=0
Rl17 (\6\:qbint qbint) resistor r=68.5478 c=0
Rl27 (\6\:qbint \16\:qbint) resistor r=105.003 c=0
Rl18 (\6\:qbint \7\:qbint) resistor r=28.0797 c=0
Rl32 (n35 \6\:n35) resistor r=4.8851 c=0
Rl56 (\10\:CKb \11\:CKb) resistor r=65.0908 c=0
Rl50 (\5\:CKb \6\:CKb) resistor r=62.2302 c=0
Rl42 (\3\:CKb \4\:CKb) resistor r=105.746 c=0
Rl38 (CKb \2\:CKb) resistor r=97.3098 c=0
Rl53 (\7\:CKb \8\:CKb) resistor r=24.1336 c=0
Rl54 (\8\:CKb \9\:CKb) resistor r=179.653 c=0
Rl55 (\8\:CKb \10\:CKb) resistor r=3.3568 c=0
Rl49 (\2\:mout \3\:mout) resistor r=91.2285 c=0
Rl48 (mout \2\:mout) resistor r=28.8462 c=0
Rl51 (\5\:CKbb \6\:CKbb) resistor r=29.5379 c=0
Rl52 (\6\:CKbb \7\:CKbb) resistor r=100.257 c=0
Rl39 (CKbb \2\:CKbb) resistor r=74.2335 c=0
Rl40 (\2\:CKbb \3\:CKbb) resistor r=58.8489 c=0
Rl41 (\2\:CKbb \4\:CKbb) resistor r=62.3759 c=0
Rl47 (\2\:n20 \4\:n20) resistor r=37.3411 c=0
Rl46 (\2\:n20 \3\:n20) resistor r=150.368 c=0
Rl45 (n20 \2\:n20) resistor r=1.2334 c=0
Rl62 (SEb \2\:SEb) resistor r=24.2328 c=0
Rl63 (\2\:SEb \3\:SEb) resistor r=210.285 c=0
Rz16 (\7\:VSS \6\:VSS) resistor r=75 c=0
Rz17 (\9\:VSS \8\:VSS) resistor r=75 c=0
Rz18 (\21\:VSS \20\:VSS) resistor r=75 c=0
Rz19 (\23\:VSS \22\:VSS) resistor r=75 c=0
Rz20 (\25\:VSS \24\:VSS) resistor r=75 c=0
Rz28 (\2\:VDD \1\:VDD) resistor r=18.75 c=0
Rz29 (\5\:VDD \1\:VDD) resistor r=6.25 c=0
Rz30 (\18\:VDD \1\:VDD) resistor r=6.25 c=0
Rz31 (\34\:VDD \1\:VDD) resistor r=6.25 c=0
Rz3 (\19\:net492 \18\:net492) resistor r=75 c=0
Rz6 (\25\:qbint \24\:qbint) resistor r=75 c=0
Rz7 (\13\:n35 \12\:n35) resistor r=75 c=0
Rz12 (\19\:CKb \20\:CKb) resistor r=75 c=0
Rz8 (\8\:mout \9\:mout) resistor r=75 c=0
Rz9 (\10\:mout \11\:mout) resistor r=75 c=0
Rz11 (\8\:CKbb \9\:CKbb) resistor r=75 c=0
Rz10 (\5\:n20 \6\:n20) resistor r=75 c=0
Rz13 (Db \2\:Db) resistor r=75 c=0
Rz14 (\4\:Db \5\:Db) resistor r=75 c=0
Rz15 (\4\:SEb \5\:SEb) resistor r=75 c=0
Ry18 (\2\:VSS \1\:VSS) resistor r=15.5 c=0
Ry19 (\5\:VSS \1\:VSS) resistor r=5.1667 c=0
Ry20 (\12\:VSS \1\:VSS) resistor r=5.1667 c=0
Ry21 (\17\:VSS \1\:VSS) resistor r=5.1667 c=0
Ry22 (\7\:VDD \6\:VDD) resistor r=62 c=0
Ry23 (\9\:VDD \8\:VDD) resistor r=62 c=0
Ry24 (\11\:VDD \10\:VDD) resistor r=62 c=0
Ry25 (\14\:VDD \13\:VDD) resistor r=62 c=0
Ry26 (\17\:VDD \16\:VDD) resistor r=62 c=0
Ry27 (\21\:VDD \20\:VDD) resistor r=62 c=0
Ry3 (\15\:net492 \14\:net492) resistor r=62 c=0
Ry6 (\27\:qbint \26\:qbint) resistor r=31 c=0
Ry9 (\11\:n35 \10\:n35) resistor r=62 c=0
Ry14 (\12\:CKb \13\:CKb) resistor r=62 c=0
Ry10 (\12\:mout \13\:mout) resistor r=62 c=0
Ry11 (\14\:mout \15\:mout) resistor r=62 c=0
Ry13 (\10\:CKbb \11\:CKbb) resistor r=62 c=0
Ry12 (\9\:n20 \10\:n20) resistor r=62 c=0
Ry15 (\6\:Db \7\:Db) resistor r=62 c=0
Ry16 (\8\:Db \9\:Db) resistor r=62 c=0
Ry17 (\8\:SEb \9\:SEb) resistor r=62 c=0
Ry7 (net405 \2\:net405) resistor r=62 c=0
Ry8 (\3\:net405 \4\:net405) resistor r=62 c=0
Rx15 (\2\:CK \4\:CK) resistor r=45 c=0
Rx18 (\6\:SE \8\:SE) resistor r=45 c=0
Rx19 (\4\:SE \9\:SE) resistor r=45 c=0
Rx20 (\1\:SE \10\:SE) resistor r=45 c=0
Rx5 (\5\:SN \7\:SN) resistor r=45 c=0
Rx6 (\2\:SN \8\:SN) resistor r=45 c=0
Rx17 (\2\:SI \4\:SI) resistor r=45 c=0
Rx16 (\2\:D \4\:D) resistor r=45 c=0
Rx1 (\17\:net492 \8\:net492) resistor r=45 c=0
Rx2 (\20\:qbint \18\:qbint) resistor r=45 c=0
Rx3 (\23\:qbint \9\:qbint) resistor r=45 c=0
Rx4 (\8\:n35 \6\:n35) resistor r=45 c=0
Rx11 (\10\:CKb \15\:CKb) resistor r=45 c=0
Rx12 (\6\:CKb \16\:CKb) resistor r=45 c=0
Rx13 (\4\:CKb \17\:CKb) resistor r=45 c=0
Rx14 (\2\:CKb \18\:CKb) resistor r=45 c=0
Rx7 (\2\:mout \4\:mout) resistor r=45 c=0
Rx9 (\4\:CKbb \13\:CKbb) resistor r=45 c=0
Rx10 (\6\:CKbb \14\:CKbb) resistor r=45 c=0
Rx8 (n20 \8\:n20) resistor r=45 c=0
Rx21 (\2\:SEb \7\:SEb) resistor r=45 c=0
mn56 (\18\:net492 \7\:qbint \13\:VSS VSS) g45n1hvt w=(2.6e-07) l=4.5e-08 \
        nf=1 as=4.16e-14 ad=3.08e-14 ps=8.4e-07 pd=8e-07 nrd=1.16667 \
        nrs=1.16667 sa=1.18462e-07 sb=1.61692e-06 sd=160n sca=17.5885 \
        scb=0.0172826 scc=0.00162584 m=(1)
mn57_1__rcx (QN net492 VSS VSS) g45n1hvt w=(2.6e-07) l=4.5e-08 nf=1 \
        as=4.25e-14 ad=4.16e-14 ps=9.95e-07 pd=8.4e-07 nrd=1.16667 \
        nrs=1.16667 sa=1.4e-07 sb=7.15e-07 sd=160n sca=17.5885 \
        scb=0.0172826 scc=0.00162584 m=(4)
mn55_1__rcx (Q qbint \13\:VSS VSS) g45n1hvt w=(2.6e-07) l=4.5e-08 nf=1 \
        as=4.077e-14 ad=4.16e-14 ps=8.4e-07 pd=8.4e-07 nrd=1.16667 \
        nrs=1.16667 sa=3.23462e-07 sb=1.52625e-06 sd=160n sca=17.5885 \
        scb=0.0172826 scc=0.00162584 m=(4)
mn45 (\24\:qbint n35 \13\:VSS VSS) g45n1hvt w=(2.05e-07) l=4.5e-08 nf=1 \
        as=3.882e-14 ad=3.28e-14 ps=8.55e-07 pd=7.3e-07 nrd=1.16667 \
        nrs=1.16667 sa=1.13768e-06 sb=1.24927e-06 sd=160n sca=13.8179 \
        scb=0.0141903 scc=0.000851218 m=(2)
mn50 (net521 \3\:SN \13\:VSS VSS) g45n1hvt w=(1.45e-07) l=4.5e-08 nf=1 \
        as=3.935e-14 ad=2.32e-14 ps=8.7e-07 pd=6.1e-07 nrd=1.16667 \
        nrs=1.16667 sa=1.60638e-06 sb=1.16e-06 sd=160n sca=11.4452 \
        scb=0.0112553 scc=0.00042156 m=(1)
mn51 (net518 \19\:qbint net521 VSS) g45n1hvt w=(1.45e-07) l=4.5e-08 nf=1 \
        as=2.32e-14 ad=7.25e-14 ps=6.1e-07 pd=1.29e-06 nrd=1.16667 \
        nrs=1.16667 sa=1.81138e-06 sb=9.55e-07 sd=160n sca=11.4452 \
        scb=0.0112553 scc=0.00042156 m=(1)
mn52 (\12\:n35 CKb net518 VSS) g45n1hvt w=(1.45e-07) l=4.5e-08 nf=1 \
        as=7.25e-14 ad=3.262e-14 ps=1.29e-06 pd=7.4e-07 nrd=1.16667 \
        nrs=1.16667 sa=2e-06 sb=4.1e-07 sd=160n sca=11.4452 scb=0.0112553 \
        scc=0.00042156 m=(1)
mn40 (\12\:n35 \3\:CKbb \8\:mout VSS) g45n1hvt w=(1.45e-07) l=4.5e-08 \
        nf=1 as=2.03e-14 ad=3.262e-14 ps=5.7e-07 pd=7.4e-07 nrd=1.16667 \
        nrs=1.16667 sa=2e-06 sb=1.4e-07 sd=160n sca=11.4452 scb=0.0112553 \
        scc=0.00042156 m=(1)
mn30 (net442 \6\:SN \24\:VSS VSS) g45n1hvt w=(1.45e-07) l=4.5e-08 nf=1 \
        as=5.765e-14 ad=8.7e-15 ps=1.18e-06 pd=4.1e-07 nrd=1.16667 \
        nrs=1.16667 sa=1.7e-07 sb=2.45e-07 sd=160n sca=9.50767 \
        scb=0.00818119 scc=0.00019576 m=(1)
mn31 (\10\:mout \3\:n20 net442 VSS) g45n1hvt w=(1.45e-07) l=4.5e-08 nf=1 \
        as=8.7e-15 ad=2.03e-14 ps=4.1e-07 pd=5.7e-07 nrd=1.16667 \
        nrs=1.16667 sa=2.75e-07 sb=1.4e-07 sd=160n sca=9.50767 \
        scb=0.00818119 scc=0.00019576 m=(1)
mn35 (net478 mout \22\:VSS VSS) g45n1hvt w=(1.45e-07) l=4.5e-08 nf=1 \
        as=2.03e-14 ad=2.392e-14 ps=5.7e-07 pd=6.2e-07 nrd=1.16667 \
        nrs=1.16667 sa=1.4e-07 sb=5.55e-07 sd=160n sca=10.4914 \
        scb=0.00978575 scc=0.000300434 m=(1)
mn36 (\5\:n20 \7\:CKbb net478 VSS) g45n1hvt w=(1.45e-07) l=4.5e-08 nf=1 \
        as=2.392e-14 ad=2.32e-14 ps=6.2e-07 pd=6.1e-07 nrd=1.16667 \
        nrs=1.16667 sa=3.5e-07 sb=3.45e-07 sd=160n sca=10.4914 \
        scb=0.00978575 scc=0.000300434 m=(1)
mn25 (\4\:Db \9\:CKb \5\:n20 VSS) g45n1hvt w=(1.45e-07) l=4.5e-08 nf=1 \
        as=2.32e-14 ad=2.03e-14 ps=6.1e-07 pd=5.7e-07 nrd=1.16667 \
        nrs=1.16667 sa=5.55e-07 sb=1.4e-07 sd=160n sca=10.4914 \
        scb=0.00978575 scc=0.000300434 m=(1)
mn21 (\8\:CKbb \7\:CKb \20\:VSS VSS) g45n1hvt w=(1.45e-07) l=4.5e-08 \
        nf=1 as=5.175e-14 ad=2.972e-14 ps=1.48e-06 pd=7e-07 nrd=1.16667 \
        nrs=1.16667 sa=2.05e-07 sb=1.8e-07 sd=160n sca=12.9138 \
        scb=0.0133404 scc=0.000640143 m=(1)
mn20 (\19\:CKb \3\:CK \8\:VSS VSS) g45n1hvt w=(1.45e-07) l=4.5e-08 nf=1 \
        as=4.295e-14 ad=3.552e-14 ps=9.1e-07 pd=7.8e-07 nrd=1.16667 \
        nrs=1.16667 sa=2.45e-07 sb=1.265e-06 sd=160n sca=13.6097 \
        scb=0.014254 scc=0.000755054 m=(1)
mn11 (net494 \1\:D \8\:VSS VSS) g45n1hvt w=(1.45e-07) l=4.5e-08 nf=1 \
        as=4.295e-14 ad=4.205e-14 ps=9.1e-07 pd=8.7e-07 nrd=1.16667 \
        nrs=1.16667 sa=5.2e-07 sb=9.9e-07 sd=160n sca=13.6097 scb=0.014254 \
        scc=0.000755054 m=(1)
mn12 (Db \3\:SEb net494 VSS) g45n1hvt w=(1.45e-07) l=4.5e-08 nf=1 \
        as=4.205e-14 ad=2.32e-14 ps=8.7e-07 pd=6.1e-07 nrd=1.16667 \
        nrs=1.16667 sa=8.55e-07 sb=6.55e-07 sd=160n sca=13.6097 \
        scb=0.014254 scc=0.000755054 m=(1)
mn14 (Db \3\:SE net506 VSS) g45n1hvt w=(1.45e-07) l=4.5e-08 nf=1 \
        as=8.7e-15 ad=2.32e-14 ps=4.1e-07 pd=6.1e-07 nrd=1.16667 \
        nrs=1.16667 sa=1.06e-06 sb=4.5e-07 sd=160n sca=13.6097 \
        scb=0.014254 scc=0.000755054 m=(1)
mn13 (net506 \1\:SI \6\:VSS VSS) g45n1hvt w=(1.45e-07) l=4.5e-08 nf=1 \
        as=2.32e-14 ad=8.7e-15 ps=6.1e-07 pd=4.1e-07 nrd=1.16667 \
        nrs=1.16667 sa=1.165e-06 sb=3.45e-07 sd=160n sca=13.6097 \
        scb=0.014254 scc=0.000755054 m=(1)
mn10 (\4\:SEb \5\:SE \6\:VSS VSS) g45n1hvt w=(1.45e-07) l=4.5e-08 nf=1 \
        as=2.32e-14 ad=2.03e-14 ps=6.1e-07 pd=5.7e-07 nrd=1.16667 \
        nrs=1.16667 sa=1.37e-06 sb=1.4e-07 sd=160n sca=13.6097 \
        scb=0.014254 scc=0.000755054 m=(1)
mp45 (\26\:qbint n35 \22\:VDD VDD) g45p1hvt w=(3.1e-07) l=4.5e-08 nf=1 \
        as=5.828e-14 ad=4.96e-14 ps=1.09e-06 pd=9.4e-07 nrd=1.16667 \
        nrs=1.16667 sa=1.13016e-06 sb=6.59194e-07 sd=160n sca=11.3312 \
        scb=0.00941412 scc=0.000228915 m=(2)
mp50 (\3\:net405 \1\:SN \22\:VDD VDD) g45p1hvt w=(2.15e-07) l=4.5e-08 \
        nf=1 as=5.895e-14 ad=3.44e-14 ps=1.08e-06 pd=7.5e-07 nrd=1.16667 \
        nrs=1.16667 sa=1.605e-06 sb=3.35698e-07 sd=160n sca=10.2104 \
        scb=0.00747301 scc=8.05149e-05 m=(1)
mp51 (\3\:net405 \17\:qbint \20\:VDD VDD) g45p1hvt w=(2.15e-07) \
        l=4.5e-08 nf=1 as=2.81e-14 ad=3.44e-14 ps=7.4e-07 pd=7.5e-07 \
        nrd=1.16667 nrs=1.16667 sa=1.81e-06 sb=1.30698e-07 sd=160n \
        sca=10.2104 scb=0.00747301 scc=8.05149e-05 m=(1)
mp52 (\10\:n35 CKbb net405 VDD) g45p1hvt w=(2.15e-07) l=4.5e-08 nf=1 \
        as=4.91e-14 ad=6.558e-14 ps=1.09e-06 pd=1.04e-06 nrd=1.16667 \
        nrs=1.16667 sa=2.28372e-07 sb=4.72326e-07 sd=160n sca=45.7906 \
        scb=0.0283307 scc=0.00588417 m=(1)
mp40 (\10\:n35 \3\:CKb \14\:mout VDD) g45p1hvt w=(2.15e-07) l=4.5e-08 \
        nf=1 as=2.63e-14 ad=6.558e-14 ps=7.1e-07 pd=1.04e-06 nrd=1.16667 \
        nrs=1.16667 sa=5.78372e-07 sb=1.22326e-07 sd=160n sca=45.7906 \
        scb=0.0283307 scc=0.00588417 m=(1)
mp30 (\12\:mout \4\:SN \16\:VDD VDD) g45p1hvt w=(2.15e-07) l=4.5e-08 \
        nf=1 as=6.842e-14 ad=3.977e-14 ps=2.24e-06 pd=8e-07 nrd=1.16667 \
        nrs=1.16667 sa=1.02791e-07 sb=1.02e-06 sd=160n sca=45.7906 \
        scb=0.0283307 scc=0.00588417 m=(1)
mp31 (\12\:mout \4\:n20 \13\:VDD VDD) g45p1hvt w=(2.15e-07) l=4.5e-08 \
        nf=1 as=6.64e-14 ad=3.977e-14 ps=1.9e-06 pd=8e-07 nrd=1.16667 \
        nrs=1.16667 sa=3.32791e-07 sb=7.9e-07 sd=160n sca=45.7906 \
        scb=0.0283307 scc=0.00588417 m=(1)
mp35 (net417 \3\:mout \13\:VDD VDD) g45p1hvt w=(2.15e-07) l=4.5e-08 nf=1 \
        as=6.64e-14 ad=1.29e-14 ps=1.9e-06 pd=5.5e-07 nrd=1.16667 \
        nrs=1.16667 sa=5.27791e-07 sb=5.95e-07 sd=160n sca=45.7906 \
        scb=0.0283307 scc=0.00588417 m=(1)
mp36 (\9\:n20 \5\:CKb net417 VDD) g45p1hvt w=(2.15e-07) l=4.5e-08 nf=1 \
        as=1.29e-14 ad=4.407e-14 ps=5.5e-07 pd=8.4e-07 nrd=1.16667 \
        nrs=1.16667 sa=6.32791e-07 sb=4.9e-07 sd=160n sca=45.7906 \
        scb=0.0283307 scc=0.00588417 m=(1)
mp25 (\9\:n20 \5\:CKbb \6\:Db VDD) g45p1hvt w=(2.15e-07) l=4.5e-08 nf=1 \
        as=5.16e-14 ad=4.407e-14 ps=9.1e-07 pd=8.4e-07 nrd=1.16667 \
        nrs=1.16667 sa=8.82791e-07 sb=2.4e-07 sd=160n sca=45.7906 \
        scb=0.0283307 scc=0.00588417 m=(1)
mp21 (\10\:CKbb \11\:CKb \10\:VDD VDD) g45p1hvt w=(2.15e-07) l=4.5e-08 \
        nf=1 as=5.99e-14 ad=3.01e-14 ps=1.97e-06 pd=7.1e-07 nrd=1.16667 \
        nrs=1.16667 sa=1.4e-07 sb=1.19767e-07 sd=160n sca=45.7906 \
        scb=0.0283307 scc=0.00588417 m=(1)
mp20 (\12\:CKb \1\:CK \8\:VDD VDD) g45p1hvt w=(2.15e-07) l=4.5e-08 nf=1 \
        as=3.762e-14 ad=2.63e-14 ps=7.8e-07 pd=7.1e-07 nrd=1.16667 \
        nrs=1.16667 sa=1.22326e-07 sb=1.25e-06 sd=160n sca=10.1292 \
        scb=0.00731698 scc=7.20009e-05 m=(1)
mp11 (net433 \3\:D \8\:VDD VDD) g45p1hvt w=(2.15e-07) l=4.5e-08 nf=1 \
        as=3.762e-14 ad=3.87e-14 ps=7.8e-07 pd=7.9e-07 nrd=1.16667 \
        nrs=1.16667 sa=3.42326e-07 sb=1.03e-06 sd=160n sca=10.1292 \
        scb=0.00731698 scc=7.20009e-05 m=(1)
mp12 (\8\:Db \2\:SE net433 VDD) g45p1hvt w=(2.15e-07) l=4.5e-08 nf=1 \
        as=3.87e-14 ad=3.87e-14 ps=7.9e-07 pd=7.9e-07 nrd=1.16667 \
        nrs=1.16667 sa=5.67326e-07 sb=8.05e-07 sd=160n sca=10.1292 \
        scb=0.00731698 scc=7.20009e-05 m=(1)
mp14 (\8\:Db SEb net441 VDD) g45p1hvt w=(2.15e-07) l=4.5e-08 nf=1 \
        as=4.085e-14 ad=3.87e-14 ps=8.1e-07 pd=7.9e-07 nrd=1.16667 \
        nrs=1.16667 sa=7.92326e-07 sb=5.8e-07 sd=160n sca=10.1879 \
        scb=0.00732855 scc=7.2002e-05 m=(1)
mp13 (net441 \3\:SI \6\:VDD VDD) g45p1hvt w=(2.15e-07) l=4.5e-08 nf=1 \
        as=3.44e-14 ad=4.085e-14 ps=7.5e-07 pd=8.1e-07 nrd=1.16667 \
        nrs=1.16667 sa=1.02733e-06 sb=3.45e-07 sd=160n sca=10.9165 \
        scb=0.00767076 scc=7.22049e-05 m=(1)
mp10 (\8\:SEb \7\:SE \6\:VDD VDD) g45p1hvt w=(2.15e-07) l=4.5e-08 nf=1 \
        as=3.44e-14 ad=3.01e-14 ps=7.5e-07 pd=7.1e-07 nrd=1.16667 \
        nrs=1.16667 sa=1.23233e-06 sb=1.4e-07 sd=160n sca=12.4536 \
        scb=0.00949372 scc=8.10217e-05 m=(1)
ends SDFFSX4
// End of subcircuit definition.
