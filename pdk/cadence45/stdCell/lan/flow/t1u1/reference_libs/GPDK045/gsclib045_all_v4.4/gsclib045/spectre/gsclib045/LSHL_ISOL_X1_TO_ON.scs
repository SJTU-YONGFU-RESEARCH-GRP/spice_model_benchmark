// gsclib045/LSHL_ISOL_X1_TO_ON/schematic

simulator lang=spectre

subckt LSHL_ISOL_X1_TO_ON A ISO Y VSS VDD
NM1 (VSS ISO ison VSS) g45n1svt w=(145n) l=45n nf=1 m=(1)
NM3 (GatedVSS ison VSS VSS) g45n1svt w=(520n) l=45n nf=2 m=(1)
NM0 (Y n0 VSS VSS) g45n1svt w=(260n) l=45n nf=1 m=(1)
mn0 (GatedVSS A n0 VSS) g45n1svt w=(145n) l=45n nf=1 m=(1)
PM2 (ison ISO VDD VDD) g45p1svt w=(215n) l=45n nf=1 m=(1)
PM1 (n0 ison VDD VDD) g45p1svt w=(215n) l=45n nf=1 m=(1)
PM0 (Y n0 VDD VDD) g45p1svt w=(390n) l=45n nf=1 m=(1)
mp0 (n0 A VDD VDD) g45p1svt w=(215n) l=45n nf=1 m=(1)
ends LSHL_ISOL_X1_TO_ON
