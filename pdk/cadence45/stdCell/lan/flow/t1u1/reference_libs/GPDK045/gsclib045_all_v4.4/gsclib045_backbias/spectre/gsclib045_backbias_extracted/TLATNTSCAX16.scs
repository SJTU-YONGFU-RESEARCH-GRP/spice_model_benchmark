// Generated for: spectre (May  1 11:33:26 2013 )
// Library name: gsclib045_backbias
// Cell name: TLATNTSCAX16
// View name: extracted

simulator lang=spectre

subckt TLATNTSCAX16 CK E ECK NW SE VDD VSS
mp1 (\6\:Eb \1\:E net246 NW) g45p1svt w=(2.15e-07) l=4.5e-08 nf=1 \
        as=1.29e-14 ad=3.01e-14 ps=5.5e-07 pd=7.1e-07 nrd=1.16667 \
        nrs=1.16667 sa=1.4e-07 sb=5.74186e-07 sd=160n sca=21.6445 \
        scb=0.0248175 scc=0.000977801 m=(1)
mp0 (net246 \3\:SE \43\:VDD NW) g45p1svt w=(2.15e-07) l=4.5e-08 nf=1 \
        as=5.59e-14 ad=1.29e-14 ps=9.5e-07 pd=5.5e-07 nrd=1.16667 \
        nrs=1.16667 sa=2.45e-07 sb=4.69186e-07 sd=160n sca=17.1049 \
        scb=0.017493 scc=0.000461861 m=(1)
mp2 (\15\:CKb \1\:CK \43\:VDD NW) g45p1svt w=(2.15e-07) l=4.5e-08 nf=1 \
        as=5.59e-14 ad=3.53e-14 ps=9.5e-07 pd=8.6e-07 nrd=1.16667 \
        nrs=1.16667 sa=5.5e-07 sb=1.64186e-07 sd=160n sca=13.2687 \
        scb=0.0115749 scc=0.000361009 m=(1)
mp5 (\12\:n5 \3\:CKbb \3\:Eb NW) g45p1svt w=(2.15e-07) l=4.5e-08 nf=1 \
        as=3.65e-14 ad=3.44e-14 ps=8.8e-07 pd=7.5e-07 nrd=1.16667 \
        nrs=1.16667 sa=1.69767e-07 sb=5.56047e-07 sd=160n sca=10.2815 \
        scb=0.00760864 scc=8.81378e-05 m=(1)
mp16 (\12\:n5 \3\:CKb net234 NW) g45p1svt w=(2.15e-07) l=4.5e-08 nf=1 \
        as=1.29e-14 ad=3.44e-14 ps=5.5e-07 pd=7.5e-07 nrd=1.16667 \
        nrs=1.16667 sa=3.74767e-07 sb=3.51047e-07 sd=160n sca=10.2815 \
        scb=0.00760864 scc=8.81378e-05 m=(1)
mp15 (net234 \3\:Eint \41\:VDD NW) g45p1svt w=(2.15e-07) l=4.5e-08 nf=1 \
        as=5.73e-14 ad=1.29e-14 ps=1.41e-06 pd=5.5e-07 nrd=1.16667 \
        nrs=1.16667 sa=4.79767e-07 sb=2.46047e-07 sd=160n sca=10.2815 \
        scb=0.00760864 scc=8.81378e-05 m=(1)
mp3 (\21\:CKbb \5\:CKb \41\:VDD NW) g45p1svt w=(2.15e-07) l=4.5e-08 nf=1 \
        as=5.73e-14 ad=3.01e-14 ps=1.41e-06 pd=7.1e-07 nrd=1.16667 \
        nrs=1.16667 sa=2.92558e-07 sb=1.4e-07 sd=160n sca=15.6338 \
        scb=0.015455 scc=0.000959319 m=(1)
C1 (NW VSS) capacitor c=9.65399e-16
C2 (VDD VSS) capacitor c=4.41219e-17
C3 (CK VSS) capacitor c=8.62059e-17
C4 (SE VSS) capacitor c=9.20991e-17
C5 (E VSS) capacitor c=4.52068e-17
C6 (ECK VSS) capacitor c=9.98784e-16
C7 (Eb VSS) capacitor c=7.49598e-17
C8 (CKb VSS) capacitor c=2.25204e-17
C9 (n5 VSS) capacitor c=8.40239e-17
C10 (net263 VSS) capacitor c=1.96898e-18
C11 (CKbb VSS) capacitor c=3.38592e-17
C12 (Eint VSS) capacitor c=4.16415e-17
C13 (ECKb VSS) capacitor c=7.32472e-16
C14 (18 VSS) capacitor c=3.73915e-18
C15 (19 VSS) capacitor c=1.79722e-18
C16 (20 VSS) capacitor c=2.59478e-18
C17 (net246 VSS) capacitor c=1.43799e-18
C18 (net234 VSS) capacitor c=1.33795e-18
C19 (\5\:CKb VSS) capacitor c=6.55466e-17
C20 (\3\:Eint VSS) capacitor c=9.87672e-17
C21 (\3\:CKb VSS) capacitor c=7.11737e-17
C22 (\3\:CKbb VSS) capacitor c=5.90585e-17
C23 (\1\:CK VSS) capacitor c=4.58644e-17
C24 (\3\:SE VSS) capacitor c=9.06075e-17
C25 (\1\:E VSS) capacitor c=5.65319e-17
C26 (\15\:Eint VSS) capacitor c=6.86978e-17
C27 (\14\:CKbb VSS) capacitor c=3.58995e-17
C28 (\13\:CKbb VSS) capacitor c=4.62553e-17
C29 (\7\:Eint VSS) capacitor c=6.20788e-17
C30 (\11\:Eint VSS) capacitor c=4.00571e-17
C31 (\4\:CKbb VSS) capacitor c=4.57892e-17
C32 (\6\:CKbb VSS) capacitor c=4.66411e-17
C33 (\4\:Eint VSS) capacitor c=8.69289e-17
C34 (\6\:CKb VSS) capacitor c=3.67127e-17
C35 (\3\:CK VSS) capacitor c=2.83895e-17
C36 (\1\:SE VSS) capacitor c=3.29526e-17
C37 (\4\:E VSS) capacitor c=5.04913e-17
C38 (\5\:CKbb VSS) capacitor c=5.8937e-16
C39 (\5\:Eint VSS) capacitor c=6.76254e-16
C40 (\7\:CKb VSS) capacitor c=1.64251e-17
C41 (\2\:Eint VSS) capacitor c=6.48721e-17
C42 (\2\:CKbb VSS) capacitor c=8.21774e-17
C43 (\4\:CKb VSS) capacitor c=5.53579e-17
C44 (\2\:CKb VSS) capacitor c=1.94455e-17
C45 (\2\:CK VSS) capacitor c=4.41669e-17
C46 (\2\:SE VSS) capacitor c=7.34442e-17
C47 (\3\:E VSS) capacitor c=1.40266e-17
C48 (\1\:VDD VSS) capacitor c=1.43769e-15
C49 (\56\:ECKb VSS) capacitor c=4.10331e-16
C50 (\22\:Eint VSS) capacitor c=6.96363e-17
C51 (\21\:CKbb VSS) capacitor c=1.02436e-16
C52 (\41\:VDD VSS) capacitor c=4.34119e-17
C53 (\12\:n5 VSS) capacitor c=1.75312e-16
C54 (\3\:Eb VSS) capacitor c=1.31905e-16
C55 (\15\:CKb VSS) capacitor c=1.02522e-16
C56 (\43\:VDD VSS) capacitor c=5.60078e-17
C57 (\6\:Eb VSS) capacitor c=2.20845e-17
C58 (\64\:ECKb VSS) capacitor c=9.90067e-17
C59 (\70\:ECKb VSS) capacitor c=8.26747e-17
C60 (\24\:Eint VSS) capacitor c=4.2806e-17
C61 (\18\:CKbb VSS) capacitor c=1.61761e-16
C62 (\10\:n5 VSS) capacitor c=8.46602e-17
C63 (\12\:CKb VSS) capacitor c=2.56783e-17
C64 (\8\:Eb VSS) capacitor c=8.76216e-17
C65 (\2\:E VSS) capacitor c=5.1359e-17
C66 (\3\:n5 VSS) capacitor c=8.76307e-17
C67 (\5\:E VSS) capacitor c=3.07792e-17
C68 (\4\:SE VSS) capacitor c=4.7195e-17
C69 (\4\:CK VSS) capacitor c=4.30956e-17
C70 (\5\:Eb VSS) capacitor c=1.38682e-16
C71 (\8\:CKb VSS) capacitor c=1.07599e-16
C72 (\9\:CKb VSS) capacitor c=9.14474e-17
C73 (\10\:CKb VSS) capacitor c=5.05184e-17
C74 (\11\:CKb VSS) capacitor c=7.90214e-17
C75 (\14\:CKb VSS) capacitor c=7.43344e-17
C76 (\8\:n5 VSS) capacitor c=1.2418e-16
C77 (\20\:CKbb VSS) capacitor c=1.40615e-16
C78 (\19\:Eint VSS) capacitor c=2.74048e-17
C79 (\20\:Eint VSS) capacitor c=7.59429e-17
C80 (\21\:Eint VSS) capacitor c=1.00622e-16
C81 (\59\:ECKb VSS) capacitor c=9.56608e-17
C82 (\15\:VDD VSS) capacitor c=9.5939e-17
C83 (\16\:VDD VSS) capacitor c=8.52537e-17
Rk71 (\1\:VDD \15\:VDD) resistor r=0.3056 c=0
Rk73 (\16\:VDD VDD) resistor r=0.1952 c=0
Rk72 (\15\:VDD \16\:VDD) resistor r=0.6041 c=0
Rk86 (\15\:VDD \42\:VDD) resistor r=0.2266 c=0
Rk87 (\16\:VDD \44\:VDD) resistor r=0.295 c=0
Rk3 (CK \4\:CK) resistor r=0.09313 c=0
Rk88 (\2\:VSS \3\:VSS) resistor r=0.04495 c=0
Rk97 (\3\:VSS \12\:VSS) resistor r=0.3533 c=0
Rk98 (\12\:VSS \13\:VSS) resistor r=0.06753 c=0
Rk99 (\13\:VSS \14\:VSS) resistor r=0.2531 c=0
Rk101 (\14\:VSS \16\:VSS) resistor r=0.2821 c=0
Rk102 (\16\:VSS \17\:VSS) resistor r=0.3735 c=0
Rk104 (\18\:VSS VSS) resistor r=0.2284 c=0
Rk103 (\17\:VSS \18\:VSS) resistor r=0.3234 c=0
Rk105 (VSS \20\:VSS) resistor r=0.1797 c=0
Rk114 (\12\:VSS \38\:VSS) resistor r=0.2601 c=0
Rk117 (\16\:VSS \44\:VSS) resistor r=0.1229 c=0
Rk118 (\18\:VSS \46\:VSS) resistor r=0.1816 c=0
Rk2 (SE \4\:SE) resistor r=0.09313 c=0
Rk1 (E \5\:E) resistor r=0.1377 c=0
Rk4 (\2\:Eb \4\:Eb) resistor r=0.5484 c=0
Rk5 (\4\:Eb \5\:Eb) resistor r=0.7217 c=0
Rk6 (\5\:Eb \7\:Eb) resistor r=0.1751 c=0
Rk7 (\5\:Eb \9\:Eb) resistor r=0.5826 c=0
Rk8 (\8\:CKb \9\:CKb) resistor r=0.5513 c=0
Rk9 (\9\:CKb \10\:CKb) resistor r=0.1623 c=0
Rk10 (\10\:CKb \11\:CKb) resistor r=0.2864 c=0
Rk11 (\11\:CKb \13\:CKb) resistor r=0.05533 c=0
Rk12 (\9\:CKb \14\:CKb) resistor r=0.5877 c=0
Rk13 (\11\:CKb \16\:CKb) resistor r=0.5857 c=0
Rk14 (\8\:n5 \9\:n5) resistor r=0.9943 c=0
Rk15 (\9\:n5 \11\:n5) resistor r=0.5515 c=0
Rk16 (\9\:n5 \13\:n5) resistor r=0.02462 c=0
Rk18 (\5\:CKbb \19\:CKbb) resistor r=1.0401 c=0
Rk19 (\19\:CKbb \20\:CKbb) resistor r=0.6329 c=0
Rk20 (\20\:CKbb \22\:CKbb) resistor r=0.5273 c=0
Rk23 (\5\:Eint \19\:Eint) resistor r=0.1784 c=0
Rk24 (\19\:Eint \20\:Eint) resistor r=0.04306 c=0
Rk25 (\20\:Eint \21\:Eint) resistor r=0.6125 c=0
Rk26 (\19\:Eint \23\:Eint) resistor r=0.3377 c=0
Rk27 (\20\:Eint \25\:Eint) resistor r=0.1622 c=0
Rk29 (\56\:ECKb \59\:ECKb) resistor r=0.403 c=0
Rk33 (\59\:ECKb \65\:ECKb) resistor r=0.417 c=0
Rk36 (\65\:ECKb \71\:ECKb) resistor r=0.4983 c=0
Rl6 (\1\:CK \2\:CK) resistor r=208.384 c=0
Rl7 (\2\:CK \3\:CK) resistor r=39.1533 c=0
Rl5 (\2\:SE \3\:SE) resistor r=236.093 c=0
Rl4 (\1\:SE \2\:SE) resistor r=37.6944 c=0
Rl1 (\1\:E \2\:E) resistor r=75.3952 c=0
Rl3 (\2\:E \4\:E) resistor r=185.863 c=0
Rl2 (\2\:E \3\:E) resistor r=9.7597 c=0
Rl14 (\5\:CKb \6\:CKb) resistor r=168.796 c=0
Rl15 (\6\:CKb \7\:CKb) resistor r=35.3072 c=0
Rl9 (\3\:CKb \4\:CKb) resistor r=60.3072 c=0
Rl8 (CKb \2\:CKb) resistor r=93.4636 c=0
Rl17 (\3\:n5 n5) resistor r=77.3132 c=0
Rl37 (\5\:CKbb \14\:CKbb) resistor r=30.0028 c=0
Rl36 (\5\:CKbb \13\:CKbb) resistor r=29.579 c=0
Rl24 (\5\:CKbb \4\:CKbb) resistor r=85.3597 c=0
Rl25 (\5\:CKbb \6\:CKbb) resistor r=28.5806 c=0
Rl11 (\2\:CKbb \3\:CKbb) resistor r=234.593 c=0
Rl10 (\2\:CKbb CKbb) resistor r=45.9489 c=0
Rl40 (\5\:Eint \15\:Eint) resistor r=90.1797 c=0
Rl29 (\5\:Eint \7\:Eint) resistor r=124.51 c=0
Rl32 (\5\:Eint \11\:Eint) resistor r=94.6154 c=0
Rl22 (\5\:Eint \4\:Eint) resistor r=153.412 c=0
Rl13 (\2\:Eint \3\:Eint) resistor r=182.95 c=0
Rl12 (\2\:Eint Eint) resistor r=41.0764 c=0
Rz16 (\20\:VSS \19\:VSS) resistor r=75 c=0
Rz25 (\38\:VSS \37\:VSS) resistor r=75 c=0
Rz28 (\44\:VSS \43\:VSS) resistor r=75 c=0
Rz29 (\46\:VSS \45\:VSS) resistor r=75 c=0
Rz1 (Eb \2\:Eb) resistor r=75 c=0
Rz2 (\8\:Eb \9\:Eb) resistor r=75 c=0
Rz3 (\12\:CKb \13\:CKb) resistor r=75 c=0
Rz4 (\11\:n5 \10\:n5) resistor r=75 c=0
Rz5 (\19\:CKbb \18\:CKbb) resistor r=75 c=0
Rz6 (\25\:Eint \24\:Eint) resistor r=75 c=0
Rz7 (\65\:ECKb \64\:ECKb) resistor r=75 c=0
Rz8 (\71\:ECKb \70\:ECKb) resistor r=75 c=0
Ry31 (\42\:VDD \41\:VDD) resistor r=62 c=0
Ry32 (\44\:VDD \43\:VDD) resistor r=62 c=0
Ry33 (\2\:VSS \1\:VSS) resistor r=31 c=0
Ry34 (\3\:VSS \1\:VSS) resistor r=5.1667 c=0
Ry35 (\13\:VSS \1\:VSS) resistor r=5.1667 c=0
Ry36 (\17\:VSS \1\:VSS) resistor r=5.1667 c=0
Ry1 (\3\:Eb \4\:Eb) resistor r=62 c=0
Ry2 (\6\:Eb \7\:Eb) resistor r=62 c=0
Ry3 (\15\:CKb \16\:CKb) resistor r=62 c=0
Ry4 (\13\:n5 \12\:n5) resistor r=62 c=0
Ry5 (\22\:CKbb \21\:CKbb) resistor r=62 c=0
Ry6 (\23\:Eint \22\:Eint) resistor r=31 c=0
Rx3 (\2\:CK \4\:CK) resistor r=45 c=0
Rx2 (\2\:SE \4\:SE) resistor r=45 c=0
Rx1 (\3\:E \5\:E) resistor r=45 c=0
Rx4 (\4\:CKb \8\:CKb) resistor r=45 c=0
Rx5 (\2\:CKb \10\:CKb) resistor r=45 c=0
Rx6 (\7\:CKb \14\:CKb) resistor r=45 c=0
Rx7 (\8\:n5 \3\:n5) resistor r=45 c=0
Rx10 (\20\:CKbb \2\:CKbb) resistor r=45 c=0
Rx14 (\21\:Eint \2\:Eint) resistor r=45 c=0
Rx15 (\59\:ECKb ECKb) resistor r=45 c=0
mn1 (\8\:Eb \4\:E \19\:VSS VSS) g45n1svt w=(1.45e-07) l=4.5e-08 nf=1 \
        as=2.03e-14 ad=2.61e-14 ps=5.7e-07 pd=6.5e-07 nrd=1.16667 \
        nrs=1.16667 sa=1.4e-07 sb=5.75e-07 sd=160n sca=6.59604 \
        scb=0.00318587 scc=2.16275e-05 m=(1)
mn0 (\8\:Eb \1\:SE \45\:VSS VSS) g45n1svt w=(1.45e-07) l=4.5e-08 nf=1 \
        as=2.393e-14 ad=2.61e-14 ps=6.2e-07 pd=6.5e-07 nrd=1.16667 \
        nrs=1.16667 sa=3.65e-07 sb=3.5e-07 sd=160n sca=6.59604 \
        scb=0.00318587 scc=2.16275e-05 m=(1)
mn2 (\12\:CKb \3\:CK \45\:VSS VSS) g45n1svt w=(1.45e-07) l=4.5e-08 nf=1 \
        as=2.393e-14 ad=2.03e-14 ps=6.2e-07 pd=5.7e-07 nrd=1.16667 \
        nrs=1.16667 sa=5.75e-07 sb=1.4e-07 sd=160n sca=6.59604 \
        scb=0.00318587 scc=2.16275e-05 m=(1)
mn5 (Eb CKb \10\:n5 VSS) g45n1svt w=(1.45e-07) l=4.5e-08 nf=1 \
        as=5.075e-14 ad=2.03e-14 ps=9.9e-07 pd=5.7e-07 nrd=1.16667 \
        nrs=1.16667 sa=1.4e-07 sb=1.075e-06 sd=160n sca=20.6444 \
        scb=0.0212501 scc=0.00213091 m=(1)
mn16 (\10\:n5 CKbb net263 VSS) g45n1svt w=(1.45e-07) l=4.5e-08 nf=1 \
        as=1.668e-14 ad=5.075e-14 ps=5.2e-07 pd=9.9e-07 nrd=1.16667 \
        nrs=1.16667 sa=5.35e-07 sb=6.8e-07 sd=160n sca=20.6444 \
        scb=0.0212501 scc=0.00213091 m=(1)
mn15 (net263 Eint \43\:VSS VSS) g45n1svt w=(1.45e-07) l=4.5e-08 nf=1 \
        as=8.14e-14 ad=1.667e-14 ps=1.53e-06 pd=5.2e-07 nrd=1.16667 \
        nrs=1.16667 sa=6.95e-07 sb=5.2e-07 sd=160n sca=20.6444 \
        scb=0.0212501 scc=0.00213091 m=(1)
mn3 (\18\:CKbb \6\:CKb \43\:VSS VSS) g45n1svt w=(1.45e-07) l=4.5e-08 \
        nf=1 as=8.14e-14 ad=2.827e-14 ps=1.53e-06 pd=6.8e-07 nrd=1.16667 \
        nrs=1.16667 sa=1.02e-06 sb=1.95e-07 sd=160n sca=20.6444 \
        scb=0.0212501 scc=0.00213091 m=(1)
mn10_1__rcx (\24\:Eint n5 \14\:VSS VSS) g45n1svt w=(2.05e-07) l=4.5e-08 \
        nf=1 as=7.21e-14 ad=3.28e-14 ps=1.35e-06 pd=7.3e-07 nrd=1.16667 \
        nrs=1.16667 sa=1.7e-07 sb=1.71061e-06 sd=160n sca=19.867 \
        scb=0.0198061 scc=0.00201945 m=(2)
mn20_1__rcx (17 \4\:Eint \14\:VSS VSS) g45n1svt w=(2.6e-07) l=4.5e-08 \
        nf=1 as=6.435e-14 ad=1.56e-14 ps=1.2e-06 pd=6.4e-07 nrd=1.16667 \
        nrs=1.16667 sa=5.08654e-07 sb=2e-06 sd=160n sca=13.9783 \
        scb=0.013979 scc=0.000942864 m=(1)
mn21_1__rcx (\70\:ECKb \6\:CKbb 17 VSS) g45n1svt w=(2.6e-07) l=4.5e-08 \
        nf=1 as=1.56e-14 ad=4.16e-14 ps=6.4e-07 pd=8.4e-07 nrd=1.16667 \
        nrs=1.16667 sa=6.13654e-07 sb=2e-06 sd=160n sca=13.9783 \
        scb=0.013979 scc=0.000942864 m=(1)
mn21_2__rcx (\70\:ECKb \4\:CKbb 18 VSS) g45n1svt w=(2.6e-07) l=4.5e-08 \
        nf=1 as=2.86e-14 ad=4.16e-14 ps=7.4e-07 pd=8.4e-07 nrd=1.16667 \
        nrs=1.16667 sa=8.18654e-07 sb=2e-06 sd=160n sca=13.9783 \
        scb=0.013979 scc=0.000942864 m=(1)
mn20_2__rcx (18 \11\:Eint \37\:VSS VSS) g45n1svt w=(2.6e-07) l=4.5e-08 \
        nf=1 as=4.16e-14 ad=2.86e-14 ps=8.4e-07 pd=7.4e-07 nrd=1.16667 \
        nrs=1.16667 sa=9.73654e-07 sb=2e-06 sd=160n sca=13.9783 \
        scb=0.013979 scc=0.000942864 m=(1)
mn20_3__rcx (19 \7\:Eint \37\:VSS VSS) g45n1svt w=(2.6e-07) l=4.5e-08 \
        nf=1 as=4.16e-14 ad=1.56e-14 ps=8.4e-07 pd=6.4e-07 nrd=1.16667 \
        nrs=1.16667 sa=1.17865e-06 sb=2e-06 sd=160n sca=13.9783 \
        scb=0.013979 scc=0.000942864 m=(1)
mn21_3__rcx (\64\:ECKb \13\:CKbb 19 VSS) g45n1svt w=(2.6e-07) l=4.5e-08 \
        nf=1 as=1.56e-14 ad=4.16e-14 ps=6.4e-07 pd=8.4e-07 nrd=1.16667 \
        nrs=1.16667 sa=1.28365e-06 sb=2e-06 sd=160n sca=13.9783 \
        scb=0.013979 scc=0.000942864 m=(1)
mn21 (\64\:ECKb \14\:CKbb 20 VSS) g45n1svt w=(2.6e-07) l=4.5e-08 nf=1 \
        as=2.34e-14 ad=4.16e-14 ps=7e-07 pd=8.4e-07 nrd=1.16667 \
        nrs=1.16667 sa=1.48865e-06 sb=2e-06 sd=160n sca=13.9783 \
        scb=0.013979 scc=0.000942864 m=(1)
mn20 (20 \15\:Eint \3\:VSS VSS) g45n1svt w=(2.6e-07) l=4.5e-08 nf=1 \
        as=5.16e-14 ad=2.34e-14 ps=9.6e-07 pd=7e-07 nrd=1.16667 \
        nrs=1.16667 sa=1.62365e-06 sb=2e-06 sd=160n sca=13.9783 \
        scb=0.013979 scc=0.000942864 m=(1)
mn22_1__rcx (ECK ECKb \3\:VSS VSS) g45n1svt w=(2.95e-07) l=4.5e-08 nf=1 \
        as=4.709e-14 ad=4.72e-14 ps=9.1071e-07 pd=9.1e-07 nrd=1.16667 \
        nrs=1.16667 sa=1.60525e-06 sb=2e-06 sd=160n sca=16.4223 \
        scb=0.0158966 scc=0.0014413 m=(14)
mp10 (\22\:Eint \3\:n5 \1\:VDD NW) g45p1svt w=(3.1e-07) l=4.5e-08 nf=1 \
        as=8.415e-14 ad=4.96e-14 ps=1.355e-06 pd=9.4e-07 nrd=1.16667 \
        nrs=1.16667 sa=1.7e-07 sb=2e-06 sd=160n sca=11.3312 scb=0.00941412 \
        scc=0.000228915 m=(2)
mp20_1__rcx (\56\:ECKb \5\:Eint \1\:VDD NW) g45p1svt w=(3.9e-07) \
        l=4.5e-08 nf=1 as=7.033e-14 ad=6.24e-14 ps=1.1775e-06 pd=1.1e-06 \
        nrd=1.16667 nrs=1.16667 sa=5.61026e-07 sb=2e-06 sd=160n \
        sca=13.5671 scb=0.012183 scc=0.000647513 m=(4)
mp21_1__rcx (\56\:ECKb \5\:CKbb \1\:VDD NW) g45p1svt w=(3.9e-07) \
        l=4.5e-08 nf=1 as=6.24e-14 ad=6.24e-14 ps=1.1e-06 pd=1.1e-06 \
        nrd=1.16667 nrs=1.16667 sa=7.66026e-07 sb=2e-06 sd=160n \
        sca=13.5671 scb=0.012183 scc=0.000647513 m=(4)
mp22_1__rcx (ECK ECKb \1\:VDD NW) g45p1svt w=(4.45e-07) l=4.5e-08 nf=1 \
        as=7.033e-14 ad=7.12e-14 ps=1.20714e-06 pd=1.21e-06 nrd=1.16667 \
        nrs=1.16667 sa=1.71843e-06 sb=2e-06 sd=160n sca=16.8284 \
        scb=0.0145775 scc=0.00130846 m=(14)
ends TLATNTSCAX16
// End of subcircuit definition.
