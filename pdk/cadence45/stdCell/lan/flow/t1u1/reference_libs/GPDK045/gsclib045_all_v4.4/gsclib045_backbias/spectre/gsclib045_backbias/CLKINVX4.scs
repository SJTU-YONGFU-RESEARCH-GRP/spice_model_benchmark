// Generated for: spectre (Apr 26 15:36:51 2013 )
// Library name: gsclib045_backbias
// Cell name: CLKINVX4
// View name: schematic

simulator lang=spectre

subckt CLKINVX4 A Y NW VDD VSS
mp0 (Y A VDD NW) g45p1svt w=(1.56u) l=45n nf=1 as=218.4f ad=218.4f \
        ps=3.4u pd=3.4u nrd=89.7436m nrs=89.7436m sa=140n sb=140n sd=160n \
        sca=61.39246 scb=0.05939 scc=0.00742 m=(1)
mn0 (Y A VSS VSS) g45n1svt w=(1.04u) l=45n nf=1 as=145.6f ad=145.6f \
        ps=2.36u pd=2.36u nrd=134.615m nrs=134.615m sa=140n sb=140n \
        sd=160n sca=71.11936 scb=0.06501 scc=0.00848 m=(1)
ends CLKINVX4
// End of subcircuit definition.
