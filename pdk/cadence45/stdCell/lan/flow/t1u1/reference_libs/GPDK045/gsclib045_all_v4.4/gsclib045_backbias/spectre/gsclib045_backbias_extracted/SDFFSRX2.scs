// Generated for: spectre (May  1 11:32:34 2013 )
// Library name: gsclib045_backbias
// Cell name: SDFFSRX2
// View name: extracted

simulator lang=spectre

subckt SDFFSRX2 CK D NW Q QN RN SE SI SN VDD VSS
mp10 (\8\:SEb \1\:SE \28\:VDD NW) g45p1svt w=(2.15e-07) l=4.5e-08 nf=1 \
        as=3.44e-14 ad=3.01e-14 ps=7.5e-07 pd=7.1e-07 nrd=1.16667 \
        nrs=1.16667 sa=1.4e-07 sb=1.33372e-06 sd=160n sca=15.5538 \
        scb=0.0148381 scc=0.000219117 m=(1)
mp13 (n3 \1\:SI \28\:VDD NW) g45p1svt w=(2.15e-07) l=4.5e-08 nf=1 \
        as=3.44e-14 ad=6.02e-14 ps=7.5e-07 pd=9.9e-07 nrd=1.16667 \
        nrs=1.16667 sa=3.45e-07 sb=1.12872e-06 sd=160n sca=11.9632 \
        scb=0.00880681 scc=7.89905e-05 m=(1)
mp14 (\9\:Db \3\:SEb n3 NW) g45p1svt w=(2.15e-07) l=4.5e-08 nf=1 \
        as=6.02e-14 ad=5.405e-14 ps=9.9e-07 pd=1.05e-06 nrd=1.16667 \
        nrs=1.16667 sa=6.7e-07 sb=8.03721e-07 sd=160n sca=10.3677 \
        scb=0.00742953 scc=7.53776e-05 m=(1)
mp12 (\9\:Db \6\:SE n1 NW) g45p1svt w=(2.15e-07) l=4.5e-08 nf=1 \
        as=1.29e-14 ad=5.405e-14 ps=5.5e-07 pd=1.05e-06 nrd=1.16667 \
        nrs=1.16667 sa=7.95814e-07 sb=6.8e-07 sd=160n sca=10.2104 \
        scb=0.00747301 scc=8.05149e-05 m=(1)
mp11 (n1 \1\:D \26\:VDD NW) g45p1svt w=(2.15e-07) l=4.5e-08 nf=1 \
        as=8.385e-14 ad=1.29e-14 ps=1.21e-06 pd=5.5e-07 nrd=1.16667 \
        nrs=1.16667 sa=9.00814e-07 sb=5.75e-07 sd=160n sca=10.2104 \
        scb=0.00747301 scc=8.05149e-05 m=(1)
mp20 (\16\:CKb \1\:CK \26\:VDD NW) g45p1svt w=(2.15e-07) l=4.5e-08 nf=1 \
        as=8.385e-14 ad=3.01e-14 ps=1.21e-06 pd=7.1e-07 nrd=1.16667 \
        nrs=1.16667 sa=1.33581e-06 sb=1.4e-07 sd=160n sca=10.2104 \
        scb=0.00747301 scc=8.05149e-05 m=(1)
mp21 (\12\:CKbb \7\:CKb \24\:VDD NW) g45p1svt w=(2.15e-07) l=4.5e-08 \
        nf=1 as=5.565e-14 ad=2.63e-14 ps=1.8e-06 pd=7.1e-07 nrd=1.16667 \
        nrs=1.16667 sa=1e-07 sb=1.22326e-07 sd=160n sca=45.7906 \
        scb=0.0283307 scc=0.00588417 m=(1)
mp25 (\7\:n20 CKbb \7\:Db NW) g45p1svt w=(2.15e-07) l=4.5e-08 nf=1 \
        as=2.63e-14 ad=4.515e-14 ps=7.1e-07 pd=8.5e-07 nrd=1.16667 \
        nrs=1.16667 sa=1.22326e-07 sb=1.2414e-06 sd=160n sca=13.6743 \
        scb=0.0130525 scc=0.000590384 m=(1)
mp36 (\7\:n20 CKb n7 NW) g45p1svt w=(2.15e-07) l=4.5e-08 nf=1 as=1.29e-14 \
        ad=4.515e-14 ps=5.5e-07 pd=8.5e-07 nrd=1.16667 nrs=1.16667 \
        sa=3.77326e-07 sb=9.86395e-07 sd=160n sca=13.6743 scb=0.0130525 \
        scc=0.000590384 m=(1)
mp35 (n7 \3\:mout \22\:VDD NW) g45p1svt w=(2.15e-07) l=4.5e-08 nf=1 \
        as=9.745e-14 ad=1.29e-14 ps=1.7e-06 pd=5.5e-07 nrd=1.16667 \
        nrs=1.16667 sa=4.82326e-07 sb=8.81395e-07 sd=160n sca=13.6743 \
        scb=0.0130525 scc=0.000590384 m=(1)
mp30 (\13\:mout \3\:SN \22\:VDD NW) g45p1svt w=(2.15e-07) l=4.5e-08 nf=1 \
        as=9.745e-14 ad=7.74e-14 ps=1.7e-06 pd=1.15e-06 nrd=1.16667 \
        nrs=1.16667 sa=6.96512e-07 sb=6.8e-07 sd=160n sca=15.2551 \
        scb=0.0150251 scc=0.000885438 m=(1)
mp32 (\13\:mout \3\:n20 n5 NW) g45p1svt w=(2.15e-07) l=4.5e-08 nf=1 \
        as=1.29e-14 ad=7.74e-14 ps=5.5e-07 pd=1.15e-06 nrd=1.16667 \
        nrs=1.16667 sa=1.10151e-06 sb=2.75e-07 sd=160n sca=15.2551 \
        scb=0.0150251 scc=0.000885438 m=(1)
mp31 (n5 \4\:RNb \20\:VDD NW) g45p1svt w=(2.15e-07) l=4.5e-08 nf=1 \
        as=6.775e-14 ad=1.29e-14 ps=1.29e-06 pd=5.5e-07 nrd=1.16667 \
        nrs=1.16667 sa=1.20651e-06 sb=1.7e-07 sd=160n sca=15.2551 \
        scb=0.0150251 scc=0.000885438 m=(1)
mp40 (\8\:n35 \8\:CKb \6\:mout NW) g45p1svt w=(2.15e-07) l=4.5e-08 nf=1 \
        as=3.44e-14 ad=5.483e-14 ps=7.5e-07 pd=9.4e-07 nrd=1.16667 \
        nrs=1.16667 sa=1.6e-07 sb=4.4e-07 sd=160n sca=45.7906 \
        scb=0.0283307 scc=0.00588417 m=(1)
mp53 (\8\:n35 \5\:CKbb \3\:n11 NW) g45p1svt w=(2.15e-07) l=4.5e-08 nf=1 \
        as=3.01e-14 ad=5.483e-14 ps=7.1e-07 pd=9.4e-07 nrd=1.16667 \
        nrs=1.16667 sa=4.6e-07 sb=1.4e-07 sd=160n sca=45.7906 \
        scb=0.0283307 scc=0.00588417 m=(1)
mp51 (n9 \2\:RNb \18\:VDD NW) g45p1svt w=(2.15e-07) l=4.5e-08 nf=1 \
        as=4.765e-14 ad=2.0102e-13 ps=1.48e-06 pd=2.3e-06 nrd=1.16667 \
        nrs=1.16667 sa=1e-07 sb=1.72e-06 sd=160n sca=29.9075 scb=0.0247057 \
        scc=0.00372713 m=(1)
mp52 (n11 \3\:qbint n9 NW) g45p1svt w=(2.15e-07) l=4.5e-08 nf=1 \
        as=2.0102e-13 ad=3.763e-14 ps=2.3e-06 pd=7.8e-07 nrd=1.16667 \
        nrs=1.16667 sa=1.08e-06 sb=7.4e-07 sd=160n sca=29.9075 \
        scb=0.0247057 scc=0.00372713 m=(1)
mp50 (n11 \6\:SN \16\:VDD NW) g45p1svt w=(2.15e-07) l=4.5e-08 nf=1 \
        as=1.267e-13 ad=3.763e-14 ps=1.94e-06 pd=7.8e-07 nrd=1.16667 \
        nrs=1.16667 sa=1.3e-06 sb=5.2e-07 sd=160n sca=29.9075 \
        scb=0.0247057 scc=0.00372713 m=(1)
mp22 (\9\:RNb \1\:RN \1\:VDD NW) g45p1svt w=(2.15e-07) l=4.5e-08 nf=1 \
        as=5.19e-14 ad=3.01e-14 ps=1.1e-06 pd=7.1e-07 nrd=1.16667 \
        nrs=1.16667 sa=1.4e-07 sb=1.09523e-06 sd=160n sca=12.1244 \
        scb=0.0107968 scc=0.000332109 m=(1)
mp56 (\11\:net573 \11\:qbint \1\:VDD NW) g45p1svt w=(2.15e-07) l=4.5e-08 \
        nf=1 as=5.728e-14 ad=3.01e-14 ps=1.15e-06 pd=7.1e-07 nrd=1.16667 \
        nrs=1.16667 sa=1.11558e-06 sb=1.4e-07 sd=160n sca=41.2633 \
        scb=0.0315497 scc=0.00492372 m=(1)
C1 (NW VSS) capacitor c=1.25645e-15
C2 (D VSS) capacitor c=3.73808e-17
C3 (RN VSS) capacitor c=8.39913e-17
C4 (SN VSS) capacitor c=7.37355e-17
C5 (Q VSS) capacitor c=1.71594e-17
C6 (SI VSS) capacitor c=1.15588e-16
C7 (QN VSS) capacitor c=3.69025e-17
C8 (VDD VSS) capacitor c=4.15208e-17
C9 (CK VSS) capacitor c=5.18385e-17
C10 (SEb VSS) capacitor c=5.40503e-17
C11 (n2 VSS) capacitor c=1.45178e-18
C12 (Db VSS) capacitor c=9.66745e-17
C13 (n0 VSS) capacitor c=2.62602e-18
C14 (CKb VSS) capacitor c=6.00254e-17
C15 (CKbb VSS) capacitor c=3.60113e-17
C16 (n20 VSS) capacitor c=4.95733e-17
C17 (n6 VSS) capacitor c=2.29239e-18
C18 (mout VSS) capacitor c=5.70737e-17
C19 (n4 VSS) capacitor c=6.3555e-17
C20 (RNb VSS) capacitor c=1.04377e-16
C21 (n35 VSS) capacitor c=4.38144e-17
C22 (n10 VSS) capacitor c=1.15867e-16
C23 (n8 VSS) capacitor c=8.59808e-17
C24 (qbint VSS) capacitor c=3.21556e-17
C25 (net573 VSS) capacitor c=1.65389e-16
C26 (n7 VSS) capacitor c=1.61783e-18
C27 (n5 VSS) capacitor c=8.79766e-19
C28 (n11 VSS) capacitor c=2.27586e-16
C29 (n9 VSS) capacitor c=3.51749e-17
C30 (\11\:qbint VSS) capacitor c=6.23694e-17
C31 (\5\:qbint VSS) capacitor c=4.15548e-16
C32 (\1\:RN VSS) capacitor c=3.8042e-17
C33 (\3\:n35 VSS) capacitor c=3.62457e-17
C34 (\6\:SN VSS) capacitor c=6.05843e-17
C35 (\3\:qbint VSS) capacitor c=6.25437e-17
C36 (\2\:RNb VSS) capacitor c=1.00563e-16
C37 (\5\:CKbb VSS) capacitor c=7.06731e-17
C38 (\8\:CKb VSS) capacitor c=3.85932e-17
C39 (\4\:RNb VSS) capacitor c=1.49963e-16
C40 (\3\:n20 VSS) capacitor c=7.28639e-17
C41 (\3\:SN VSS) capacitor c=3.61546e-17
C42 (\3\:mout VSS) capacitor c=5.99079e-17
C43 (\7\:CKb VSS) capacitor c=2.61775e-17
C44 (\1\:CK VSS) capacitor c=4.50318e-17
C45 (\1\:D VSS) capacitor c=8.11875e-17
C46 (\6\:SE VSS) capacitor c=6.3598e-17
C47 (\3\:SEb VSS) capacitor c=4.29327e-17
C48 (\1\:SI VSS) capacitor c=4.66291e-17
C49 (\1\:SE VSS) capacitor c=5.84887e-17
C50 (\12\:qbint VSS) capacitor c=2.36183e-17
C51 (\3\:RN VSS) capacitor c=4.74355e-17
C52 (\5\:SN VSS) capacitor c=8.55261e-17
C53 (\10\:CKb VSS) capacitor c=4.77723e-17
C54 (\6\:CKbb VSS) capacitor c=9.83268e-17
C55 (\6\:RNb VSS) capacitor c=6.71917e-17
C56 (\1\:SN VSS) capacitor c=2.84306e-17
C57 (\3\:CKbb VSS) capacitor c=5.35365e-17
C58 (\5\:CKb VSS) capacitor c=3.62922e-17
C59 (\6\:CKb VSS) capacitor c=1.43435e-17
C60 (\3\:CK VSS) capacitor c=2.04394e-17
C61 (\3\:D VSS) capacitor c=2.49951e-17
C62 (\4\:SE VSS) capacitor c=4.19704e-17
C63 (\3\:SI VSS) capacitor c=4.55644e-17
C64 (\3\:SE VSS) capacitor c=2.37718e-17
C65 (\13\:qbint VSS) capacitor c=1.88704e-17
C66 (\2\:RN VSS) capacitor c=3.11771e-17
C67 (\2\:n35 VSS) capacitor c=3.51231e-17
C68 (\4\:qbint VSS) capacitor c=2.79948e-17
C69 (\7\:SN VSS) capacitor c=3.01527e-17
C70 (\5\:RNb VSS) capacitor c=3.38457e-17
C71 (\11\:CKb VSS) capacitor c=3.35285e-17
C72 (\9\:CKb VSS) capacitor c=3.58685e-17
C73 (\2\:n20 VSS) capacitor c=4.67909e-17
C74 (\7\:CKbb VSS) capacitor c=6.67059e-17
C75 (\4\:SN VSS) capacitor c=2.3301e-17
C76 (\2\:SN VSS) capacitor c=3.62868e-17
C77 (\2\:mout VSS) capacitor c=6.291e-17
C78 (\2\:CKb VSS) capacitor c=5.51665e-17
C79 (\4\:CKbb VSS) capacitor c=2.29007e-17
C80 (\2\:CKbb VSS) capacitor c=3.45275e-17
C81 (\4\:CKb VSS) capacitor c=2.26373e-17
C82 (\2\:CK VSS) capacitor c=3.91178e-17
C83 (\2\:D VSS) capacitor c=4.60155e-17
C84 (\7\:SE VSS) capacitor c=4.42834e-17
C85 (\2\:SEb VSS) capacitor c=6.704e-17
C86 (\5\:SE VSS) capacitor c=5.11969e-17
C87 (\2\:SI VSS) capacitor c=5.78919e-17
C88 (\2\:SE VSS) capacitor c=5.16533e-17
C89 (\11\:net573 VSS) capacitor c=1.75078e-17
C90 (\1\:VDD VSS) capacitor c=3.868e-16
C91 (\1\:QN VSS) capacitor c=7.94382e-17
C92 (\3\:Q VSS) capacitor c=7.73758e-17
C93 (\9\:RNb VSS) capacitor c=2.96135e-16
C94 (\23\:qbint VSS) capacitor c=8.62017e-17
C95 (\16\:VDD VSS) capacitor c=1.70387e-17
C96 (\18\:VDD VSS) capacitor c=4.16466e-17
C97 (\3\:n11 VSS) capacitor c=2.01024e-16
C98 (\8\:n35 VSS) capacitor c=4.01624e-17
C99 (\6\:mout VSS) capacitor c=7.48635e-17
C100 (\20\:VDD VSS) capacitor c=3.65076e-17
C101 (\13\:mout VSS) capacitor c=3.85164e-17
C102 (\22\:VDD VSS) capacitor c=1.22802e-17
C103 (\7\:n20 VSS) capacitor c=8.75458e-17
C104 (\7\:Db VSS) capacitor c=2.99936e-17
C105 (\12\:CKbb VSS) capacitor c=5.65669e-17
C106 (\24\:VDD VSS) capacitor c=2.37564e-17
C107 (\16\:CKb VSS) capacitor c=6.37261e-17
C108 (\26\:VDD VSS) capacitor c=4.87347e-17
C109 (\9\:Db VSS) capacitor c=1.99223e-17
C110 (\28\:VDD VSS) capacitor c=3.05638e-17
C111 (\8\:SEb VSS) capacitor c=1.39768e-17
C112 (\7\:net573 VSS) capacitor c=1.89005e-17
C113 (\4\:QN VSS) capacitor c=2.88312e-17
C114 (\1\:Q VSS) capacitor c=8.03561e-17
C115 (\7\:RNb VSS) capacitor c=1.229e-16
C116 (\17\:qbint VSS) capacitor c=6.19653e-17
C117 (\3\:n10 VSS) capacitor c=1.82853e-16
C118 (\3\:n8 VSS) capacitor c=7.89496e-17
C119 (\6\:n35 VSS) capacitor c=4.7697e-17
C120 (\4\:mout VSS) capacitor c=5.929e-17
C121 (\11\:mout VSS) capacitor c=4.61742e-17
C122 (\3\:n4 VSS) capacitor c=8.10863e-17
C123 (\5\:n20 VSS) capacitor c=1.54916e-16
C124 (\10\:CKbb VSS) capacitor c=9.59486e-17
C125 (\14\:CKb VSS) capacitor c=5.70406e-17
C126 (\5\:Db VSS) capacitor c=1.15833e-16
C127 (\6\:SEb VSS) capacitor c=7.04519e-17
C128 (\3\:CKb VSS) capacitor c=4.37378e-17
C129 (\4\:SEb VSS) capacitor c=1.06467e-16
C130 (\5\:SEb VSS) capacitor c=9.77102e-17
C131 (\8\:SE VSS) capacitor c=1.626e-16
C132 (\9\:SE VSS) capacitor c=1.33121e-16
C133 (\10\:SE VSS) capacitor c=2.52746e-17
C134 (\11\:SE VSS) capacitor c=6.63155e-17
C135 (\4\:D VSS) capacitor c=6.73441e-17
C136 (\3\:RNb VSS) capacitor c=8.1512e-17
C137 (\4\:CK VSS) capacitor c=6.33623e-17
C138 (\2\:qbint VSS) capacitor c=4.05568e-17
C139 (\12\:CKb VSS) capacitor c=3.33041e-17
C140 (\13\:CKb VSS) capacitor c=7.73331e-17
C141 (\3\:Db VSS) capacitor c=1.88858e-16
C142 (\4\:Db VSS) capacitor c=2.19575e-16
C143 (\8\:SN VSS) capacitor c=5.13986e-17
C144 (\8\:CKbb VSS) capacitor c=9.58154e-17
C145 (\9\:CKbb VSS) capacitor c=7.01371e-17
C146 (\14\:CKbb VSS) capacitor c=7.3121e-17
C147 (\15\:CKbb VSS) capacitor c=1.05001e-16
C148 (\4\:n20 VSS) capacitor c=1.11726e-16
C149 (\8\:mout VSS) capacitor c=8.19913e-17
C150 (\9\:mout VSS) capacitor c=6.10499e-17
C151 (\10\:mout VSS) capacitor c=6.17096e-17
C152 (\18\:CKb VSS) capacitor c=7.73716e-17
C153 (\19\:CKb VSS) capacitor c=3.35884e-16
C154 (\20\:CKb VSS) capacitor c=2.62694e-16
C155 (\9\:SN VSS) capacitor c=3.16293e-16
C156 (\10\:SN VSS) capacitor c=3.14828e-16
C157 (\4\:n35 VSS) capacitor c=2.59361e-16
C158 (\5\:n35 VSS) capacitor c=2.17818e-16
C159 (\11\:RNb VSS) capacitor c=3.35517e-16
C160 (\4\:RN VSS) capacitor c=3.32846e-17
C161 (\3\:QN VSS) capacitor c=2.89955e-17
C162 (\14\:qbint VSS) capacitor c=8.3272e-17
C163 (\19\:qbint VSS) capacitor c=7.2653e-17
C164 (\20\:qbint VSS) capacitor c=7.76452e-17
C165 (\9\:net573 VSS) capacitor c=3.33296e-17
C166 (\10\:net573 VSS) capacitor c=3.42701e-17
C167 (\5\:VDD VSS) capacitor c=1.23632e-16
C168 (\6\:VDD VSS) capacitor c=1.47219e-16
C169 (\7\:VDD VSS) capacitor c=1.19977e-16
C170 (\8\:VDD VSS) capacitor c=9.38969e-17
C171 (\9\:VDD VSS) capacitor c=9.85648e-17
C172 (\10\:VDD VSS) capacitor c=9.6844e-17
C173 (\11\:VDD VSS) capacitor c=7.12165e-17
Rk9 (D \4\:D) resistor r=0.113 c=0
Rk45 (\4\:RN RN) resistor r=0.04718 c=0
Rk19 (\8\:SN SN) resistor r=0.09513 c=0
Rk38 (\9\:SN \10\:SN) resistor r=2.4258 c=0
Rk47 (\4\:Q Q) resistor r=0.02395 c=0
Rk46 (\2\:Q \4\:Q) resistor r=0.3149 c=0
Rk65 (\1\:VSS \7\:VSS) resistor r=0.3924 c=0
Rk66 (\7\:VSS \8\:VSS) resistor r=0.5591 c=0
Rk67 (\8\:VSS \9\:VSS) resistor r=1.2038 c=0
Rk68 (\9\:VSS \10\:VSS) resistor r=0.1192 c=0
Rk69 (\10\:VSS \11\:VSS) resistor r=0.6181 c=0
Rk70 (\11\:VSS \12\:VSS) resistor r=0.3758 c=0
Rk71 (\12\:VSS \13\:VSS) resistor r=0.08758 c=0
Rk73 (\14\:VSS VSS) resistor r=0.1425 c=0
Rk72 (\13\:VSS \14\:VSS) resistor r=0.4086 c=0
Rk76 (\7\:VSS \20\:VSS) resistor r=0.3207 c=0
Rk77 (\10\:VSS \22\:VSS) resistor r=0.04331 c=0
Rk78 (\11\:VSS \24\:VSS) resistor r=0.3646 c=0
Rk79 (\12\:VSS \26\:VSS) resistor r=0.2546 c=0
Rk80 (\14\:VSS \28\:VSS) resistor r=0.2456 c=0
Rk5 (\8\:SE \9\:SE) resistor r=1.1035 c=0
Rk6 (\9\:SE \10\:SE) resistor r=0.08682 c=0
Rk8 (\11\:SE SE) resistor r=0.003332 c=0
Rk7 (\9\:SE \11\:SE) resistor r=0.2808 c=0
Rk1 (SI \4\:SI) resistor r=0.004474 c=0
Rk49 (\3\:QN QN) resistor r=0.1123 c=0
Rk48 (\2\:QN \3\:QN) resistor r=0.313 c=0
Rk50 (\3\:QN \5\:QN) resistor r=0.07591 c=0
Rk83 (\1\:VDD \5\:VDD) resistor r=0.4861 c=0
Rk84 (\5\:VDD \6\:VDD) resistor r=0.7344 c=0
Rk85 (\6\:VDD \7\:VDD) resistor r=0.6943 c=0
Rk86 (\7\:VDD \8\:VDD) resistor r=0.4184 c=0
Rk87 (\8\:VDD \9\:VDD) resistor r=0.5328 c=0
Rk88 (\9\:VDD \10\:VDD) resistor r=0.3698 c=0
Rk90 (\11\:VDD VDD) resistor r=0.1701 c=0
Rk89 (\10\:VDD \11\:VDD) resistor r=0.5162 c=0
Rk93 (\5\:VDD \17\:VDD) resistor r=0.1026 c=0
Rk94 (\6\:VDD \19\:VDD) resistor r=0.1528 c=0
Rk95 (\7\:VDD \21\:VDD) resistor r=0.1528 c=0
Rk96 (\8\:VDD \23\:VDD) resistor r=0.07393 c=0
Rk97 (\9\:VDD \25\:VDD) resistor r=0.04331 c=0
Rk98 (\10\:VDD \27\:VDD) resistor r=0.2313 c=0
Rk99 (\11\:VDD \29\:VDD) resistor r=0.1942 c=0
Rk10 (CK \4\:CK) resistor r=0.1441 c=0
Rk2 (\4\:SEb \5\:SEb) resistor r=0.6909 c=0
Rk3 (\5\:SEb \7\:SEb) resistor r=0.6223 c=0
Rk4 (\5\:SEb \9\:SEb) resistor r=0.04795 c=0
Rk14 (\2\:Db \3\:Db) resistor r=0.4897 c=0
Rk15 (\3\:Db \4\:Db) resistor r=1.3038 c=0
Rk16 (\4\:Db \6\:Db) resistor r=0.659 c=0
Rk17 (\3\:Db \8\:Db) resistor r=0.02078 c=0
Rk18 (\4\:Db \10\:Db) resistor r=0.104 c=0
Rk11 (\12\:CKb \13\:CKb) resistor r=0.2395 c=0
Rk12 (\13\:CKb \15\:CKb) resistor r=0.3468 c=0
Rk13 (\13\:CKb \17\:CKb) resistor r=0.3414 c=0
Rk34 (\18\:CKb \19\:CKb) resistor r=0.5865 c=0
Rk35 (\19\:CKb \20\:CKb) resistor r=1.9267 c=0
Rk20 (\8\:CKbb \9\:CKbb) resistor r=0.4919 c=0
Rk21 (\9\:CKbb \11\:CKbb) resistor r=0.4177 c=0
Rk22 (\11\:CKbb \13\:CKbb) resistor r=0.2974 c=0
Rk23 (\9\:CKbb \14\:CKbb) resistor r=0.09434 c=0
Rk24 (\14\:CKbb \15\:CKbb) resistor r=0.6992 c=0
Rk25 (\4\:n20 \6\:n20) resistor r=0.866 c=0
Rk26 (\6\:n20 \8\:n20) resistor r=0.4885 c=0
Rk28 (\5\:mout \7\:mout) resistor r=0.3297 c=0
Rk29 (\7\:mout \8\:mout) resistor r=0.3395 c=0
Rk30 (\8\:mout \9\:mout) resistor r=0.4478 c=0
Rk31 (\9\:mout \10\:mout) resistor r=0.2513 c=0
Rk32 (\8\:mout \12\:mout) resistor r=0.2652 c=0
Rk33 (\9\:mout \14\:mout) resistor r=0.08669 c=0
Rk27 (\2\:n4 \4\:n4) resistor r=0.4641 c=0
Rk43 (\8\:RNb \10\:RNb) resistor r=0.7754 c=0
Rk44 (\10\:RNb \11\:RNb) resistor r=2.0913 c=0
Rk40 (\4\:n35 \5\:n35) resistor r=1.7333 c=0
Rk41 (\5\:n35 \7\:n35) resistor r=0.2304 c=0
Rk42 (\5\:n35 \9\:n35) resistor r=0.126 c=0
Rk37 (\2\:n10 \4\:n10) resistor r=1.2491 c=0
Rk39 (\2\:n8 \4\:n8) resistor r=0.382 c=0
Rk51 (\14\:qbint \5\:qbint) resistor r=0.6163 c=0
Rk53 (\5\:qbint \18\:qbint) resistor r=0.5127 c=0
Rk54 (\18\:qbint \19\:qbint) resistor r=0.1495 c=0
Rk55 (\19\:qbint \20\:qbint) resistor r=0.3442 c=0
Rk58 (\19\:qbint \24\:qbint) resistor r=0.3679 c=0
Rk59 (\8\:net573 \9\:net573) resistor r=0.2324 c=0
Rk60 (\9\:net573 \10\:net573) resistor r=0.1482 c=0
Rk61 (\9\:net573 \12\:net573) resistor r=0.1545 c=0
Rk36 (\2\:n11 \4\:n11) resistor r=1.2651 c=0
Rl9 (\1\:D \2\:D) resistor r=189.617 c=0
Rl10 (\2\:D \3\:D) resistor r=55.0021 c=0
Rl44 (\1\:RN \2\:RN) resistor r=29.5379 c=0
Rl45 (\2\:RN \3\:RN) resistor r=110.307 c=0
Rl40 (\5\:SN \6\:SN) resistor r=207.258 c=0
Rl41 (\6\:SN \7\:SN) resistor r=59.5926 c=0
Rl25 (\3\:SN \4\:SN) resistor r=50.6918 c=0
Rl24 (\2\:SN \3\:SN) resistor r=112.333 c=0
Rl23 (\1\:SN \2\:SN) resistor r=36.5385 c=0
Rl8 (\6\:SE \7\:SE) resistor r=71.8456 c=0
Rl5 (\4\:SE \5\:SE) resistor r=29.5379 c=0
Rl1 (\1\:SE \2\:SE) resistor r=226.923 c=0
Rl2 (\2\:SE \3\:SE) resistor r=39.5604 c=0
Rl3 (\1\:SI \2\:SI) resistor r=131.461 c=0
Rl4 (\2\:SI \3\:SI) resistor r=133.384 c=0
Rl11 (\1\:CK \2\:CK) resistor r=209.615 c=0
Rl12 (\2\:CK \3\:CK) resistor r=39.5604 c=0
Rl7 (\2\:SEb \3\:SEb) resistor r=131.925 c=0
Rl6 (SEb \2\:SEb) resistor r=164.939 c=0
Rl31 (\10\:CKb \11\:CKb) resistor r=81.408 c=0
Rl28 (\8\:CKb \9\:CKb) resistor r=24.2328 c=0
Rl15 (CKb \2\:CKb) resistor r=74.2328 c=0
Rl20 (\4\:CKb \7\:CKb) resistor r=32.4874 c=0
Rl19 (\4\:CKb \6\:CKb) resistor r=24.7951 c=0
Rl18 (\3\:CKb \5\:CKb) resistor r=76.6046 c=0
Rl16 (\2\:CKb \3\:CKb) resistor r=111.505 c=0
Rl17 (\3\:CKb \4\:CKb) resistor r=173.466 c=0
Rl29 (\5\:CKbb \6\:CKbb) resistor r=170.285 c=0
Rl30 (\6\:CKbb \7\:CKbb) resistor r=445.667 c=0
Rl14 (\3\:CKbb \4\:CKbb) resistor r=61.106 c=0
Rl13 (CKbb \2\:CKbb) resistor r=31.461 c=0
Rl27 (\2\:n20 \3\:n20) resistor r=110.771 c=0
Rl26 (n20 \2\:n20) resistor r=69.7702 c=0
Rl22 (\2\:mout \3\:mout) resistor r=59.1695 c=0
Rl21 (mout \2\:mout) resistor r=120.387 c=0
Rl32 (RNb \2\:RNb) resistor r=505.335 c=0
Rl36 (\4\:RNb \6\:RNb) resistor r=266.873 c=0
Rl33 (\2\:RNb \3\:RNb) resistor r=255.747 c=0
Rl34 (\3\:RNb \4\:RNb) resistor r=649.978 c=0
Rl35 (\3\:RNb \5\:RNb) resistor r=154.219 c=0
Rl43 (\2\:n35 \3\:n35) resistor r=24.2328 c=0
Rl42 (n35 \2\:n35) resistor r=84.3311 c=0
Rl55 (\12\:qbint \11\:qbint) resistor r=141.873 c=0
Rl56 (\13\:qbint \12\:qbint) resistor r=29.5379 c=0
Rl38 (\2\:qbint \3\:qbint) resistor r=149.075 c=0
Rl37 (\2\:qbint qbint) resistor r=24.4619 c=0
Rl39 (\2\:qbint \4\:qbint) resistor r=4.5402 c=0
Rz17 (\2\:Q \1\:Q) resistor r=75 c=0
Rz24 (\20\:VSS \19\:VSS) resistor r=75 c=0
Rz25 (\22\:VSS \21\:VSS) resistor r=75 c=0
Rz26 (\24\:VSS \23\:VSS) resistor r=75 c=0
Rz27 (\26\:VSS \25\:VSS) resistor r=75 c=0
Rz28 (\28\:VSS \27\:VSS) resistor r=75 c=0
Rz18 (\5\:QN \4\:QN) resistor r=75 c=0
Rz1 (\6\:SEb \7\:SEb) resistor r=75 c=0
Rz3 (Db \2\:Db) resistor r=75 c=0
Rz4 (\5\:Db \6\:Db) resistor r=75 c=0
Rz2 (\14\:CKb \15\:CKb) resistor r=75 c=0
Rz5 (\10\:CKbb \11\:CKbb) resistor r=75 c=0
Rz6 (\5\:n20 \6\:n20) resistor r=75 c=0
Rz9 (\4\:mout \5\:mout) resistor r=75 c=0
Rz10 (\11\:mout \12\:mout) resistor r=75 c=0
Rz7 (n4 \2\:n4) resistor r=75 c=0
Rz8 (\3\:n4 \4\:n4) resistor r=75 c=0
Rz16 (\7\:RNb \8\:RNb) resistor r=75 c=0
Rz15 (\6\:n35 \7\:n35) resistor r=75 c=0
Rz11 (n10 \2\:n10) resistor r=75 c=0
Rz12 (\3\:n10 \4\:n10) resistor r=75 c=0
Rz13 (n8 \2\:n8) resistor r=75 c=0
Rz14 (\3\:n8 \4\:n8) resistor r=75 c=0
Rz19 (\18\:qbint \17\:qbint) resistor r=75 c=0
Rz20 (\8\:net573 \7\:net573) resistor r=75 c=0
Ry13 (\4\:Q \3\:Q) resistor r=20.6667 c=0
Ry17 (\1\:VSS \4\:VSS) resistor r=5.6364 c=0
Ry18 (\8\:VSS \4\:VSS) resistor r=5.1667 c=0
Ry19 (\9\:VSS \4\:VSS) resistor r=5.1667 c=0
Ry20 (\13\:VSS \4\:VSS) resistor r=5.1667 c=0
Ry14 (\2\:QN \1\:QN) resistor r=20.6667 c=0
Ry24 (\17\:VDD \16\:VDD) resistor r=62 c=0
Ry25 (\19\:VDD \18\:VDD) resistor r=62 c=0
Ry26 (\21\:VDD \20\:VDD) resistor r=62 c=0
Ry27 (\23\:VDD \22\:VDD) resistor r=62 c=0
Ry28 (\25\:VDD \24\:VDD) resistor r=62 c=0
Ry29 (\27\:VDD \26\:VDD) resistor r=62 c=0
Ry30 (\29\:VDD \28\:VDD) resistor r=62 c=0
Ry1 (\8\:SEb \9\:SEb) resistor r=62 c=0
Ry3 (\7\:Db \8\:Db) resistor r=62 c=0
Ry4 (\9\:Db \10\:Db) resistor r=62 c=0
Ry2 (\16\:CKb \17\:CKb) resistor r=62 c=0
Ry5 (\12\:CKbb \13\:CKbb) resistor r=62 c=0
Ry6 (\7\:n20 \8\:n20) resistor r=62 c=0
Ry7 (\6\:mout \7\:mout) resistor r=62 c=0
Ry8 (\13\:mout \14\:mout) resistor r=62 c=0
Ry12 (\9\:RNb \10\:RNb) resistor r=62 c=0
Ry11 (\8\:n35 \9\:n35) resistor r=62 c=0
Ry15 (\24\:qbint \23\:qbint) resistor r=31 c=0
Ry16 (\12\:net573 \11\:net573) resistor r=62 c=0
Ry9 (n11 \2\:n11) resistor r=62 c=0
Ry10 (\3\:n11 \4\:n11) resistor r=62 c=0
Rx6 (\2\:D \4\:D) resistor r=45 c=0
Rx22 (\2\:RN \4\:RN) resistor r=45 c=0
Rx9 (\2\:SN \8\:SN) resistor r=45 c=0
Rx18 (\7\:SN \9\:SN) resistor r=45 c=0
Rx19 (\4\:SN \10\:SN) resistor r=45 c=0
Rx3 (\7\:SE \8\:SE) resistor r=45 c=0
Rx4 (\5\:SE \10\:SE) resistor r=45 c=0
Rx5 (\2\:SE \11\:SE) resistor r=45 c=0
Rx1 (\2\:SI \4\:SI) resistor r=45 c=0
Rx7 (\2\:CK \4\:CK) resistor r=45 c=0
Rx2 (\2\:SEb \4\:SEb) resistor r=45 c=0
Rx8 (\4\:CKb \12\:CKb) resistor r=45 c=0
Rx15 (\11\:CKb \18\:CKb) resistor r=45 c=0
Rx16 (\9\:CKb \19\:CKb) resistor r=45 c=0
Rx17 (\2\:CKb \20\:CKb) resistor r=45 c=0
Rx10 (\2\:CKbb \8\:CKbb) resistor r=45 c=0
Rx11 (\4\:CKbb \14\:CKbb) resistor r=45 c=0
Rx12 (\7\:CKbb \15\:CKbb) resistor r=45 c=0
Rx13 (\2\:n20 \4\:n20) resistor r=45 c=0
Rx14 (\2\:mout \10\:mout) resistor r=45 c=0
Rx21 (\5\:RNb \11\:RNb) resistor r=45 c=0
Rx20 (\2\:n35 \4\:n35) resistor r=45 c=0
Rx23 (\14\:qbint \13\:qbint) resistor r=45 c=0
Rx24 (\20\:qbint \4\:qbint) resistor r=45 c=0
Rx27 (\10\:net573 net573) resistor r=45 c=0
mn10 (\6\:SEb \3\:SE \27\:VSS VSS) g45n1svt w=(1.45e-07) l=4.5e-08 nf=1 \
        as=3.118e-14 ad=2.465e-14 ps=7.2e-07 pd=6.3e-07 nrd=1.16667 \
        nrs=1.16667 sa=1.7e-07 sb=1.52e-06 sd=160n sca=8.85152 \
        scb=0.00706865 scc=0.000138481 m=(1)
mn13 (n2 \3\:SI \27\:VSS VSS) g45n1svt w=(1.45e-07) l=4.5e-08 nf=1 \
        as=3.117e-14 ad=2.682e-14 ps=7.2e-07 pd=6.6e-07 nrd=1.16667 \
        nrs=1.16667 sa=4.3e-07 sb=1.26e-06 sd=160n sca=8.85152 \
        scb=0.00706865 scc=0.000138481 m=(1)
mn14 (\5\:Db \4\:SE n2 VSS) g45n1svt w=(1.45e-07) l=4.5e-08 nf=1 \
        as=2.682e-14 ad=2.32e-14 ps=6.6e-07 pd=6.1e-07 nrd=1.16667 \
        nrs=1.16667 sa=6.6e-07 sb=1.03e-06 sd=160n sca=8.85152 \
        scb=0.00706865 scc=0.000138481 m=(1)
mn12 (\5\:Db SEb n0 VSS) g45n1svt w=(1.45e-07) l=4.5e-08 nf=1 \
        as=3.625e-14 ad=2.32e-14 ps=7.9e-07 pd=6.1e-07 nrd=1.16667 \
        nrs=1.16667 sa=8.65e-07 sb=8.25e-07 sd=160n sca=8.85152 \
        scb=0.00706865 scc=0.000138481 m=(1)
mn11 (n0 \3\:D \25\:VSS VSS) g45n1svt w=(1.45e-07) l=4.5e-08 nf=1 \
        as=5.003e-14 ad=3.625e-14 ps=9.8e-07 pd=7.9e-07 nrd=1.16667 \
        nrs=1.16667 sa=1.16e-06 sb=5.3e-07 sd=160n sca=8.85152 \
        scb=0.00706865 scc=0.000138481 m=(1)
mn20 (\14\:CKb \3\:CK \25\:VSS VSS) g45n1svt w=(1.45e-07) l=4.5e-08 nf=1 \
        as=5.003e-14 ad=2.03e-14 ps=9.8e-07 pd=5.7e-07 nrd=1.16667 \
        nrs=1.16667 sa=1.55e-06 sb=1.4e-07 sd=160n sca=8.85152 \
        scb=0.00706865 scc=0.000138481 m=(1)
mn21 (\10\:CKbb \6\:CKb \23\:VSS VSS) g45n1svt w=(1.45e-07) l=4.5e-08 \
        nf=1 as=2.683e-14 ad=2.32e-14 ps=6.6e-07 pd=6.1e-07 nrd=1.16667 \
        nrs=1.16667 sa=1.85e-07 sb=1.6e-07 sd=160n sca=23.279 \
        scb=0.0230742 scc=0.00267719 m=(1)
mn25 (Db \5\:CKb \5\:n20 VSS) g45n1svt w=(1.45e-07) l=4.5e-08 nf=1 \
        as=3.843e-14 ad=2.61e-14 ps=8.2e-07 pd=6.5e-07 nrd=1.16667 \
        nrs=1.16667 sa=1.8e-07 sb=1.64e-06 sd=160n sca=13.6097 \
        scb=0.014254 scc=0.000755054 m=(1)
mn36 (\5\:n20 \3\:CKbb n6 VSS) g45n1svt w=(1.45e-07) l=4.5e-08 nf=1 \
        as=1.958e-14 ad=3.843e-14 ps=5.6e-07 pd=8.2e-07 nrd=1.16667 \
        nrs=1.16667 sa=4.9e-07 sb=1.33e-06 sd=160n sca=13.6097 \
        scb=0.014254 scc=0.000755054 m=(1)
mn35 (n6 mout \21\:VSS VSS) g45n1svt w=(1.45e-07) l=4.5e-08 nf=1 \
        as=7.45e-14 ad=1.958e-14 ps=1.44e-06 pd=5.6e-07 nrd=1.16667 \
        nrs=1.16667 sa=6.7e-07 sb=1.15e-06 sd=160n sca=13.6097 \
        scb=0.014254 scc=0.000755054 m=(1)
mn30 (\3\:n4 \1\:SN \21\:VSS VSS) g45n1svt w=(1.45e-07) l=4.5e-08 nf=1 \
        as=7.45e-14 ad=7.177e-14 ps=1.44e-06 pd=1.28e-06 nrd=1.16667 \
        nrs=1.16667 sa=9.35e-07 sb=8.85e-07 sd=160n sca=13.6097 \
        scb=0.014254 scc=0.000755054 m=(1)
mn32 (\11\:mout n20 \3\:n4 VSS) g45n1svt w=(1.45e-07) l=4.5e-08 nf=1 \
        as=7.177e-14 ad=2.32e-14 ps=1.28e-06 pd=6.1e-07 nrd=1.16667 \
        nrs=1.16667 sa=1.475e-06 sb=3.45e-07 sd=160n sca=13.6097 \
        scb=0.014254 scc=0.000755054 m=(1)
mn31 (\11\:mout \6\:RNb n4 VSS) g45n1svt w=(1.45e-07) l=4.5e-08 nf=1 \
        as=2.03e-14 ad=2.32e-14 ps=5.7e-07 pd=6.1e-07 nrd=1.16667 \
        nrs=1.16667 sa=1.68e-06 sb=1.4e-07 sd=160n sca=13.6097 \
        scb=0.014254 scc=0.000755054 m=(1)
mn40 (\6\:n35 \6\:CKbb \4\:mout VSS) g45n1svt w=(1.45e-07) l=4.5e-08 nf=1 \
        as=3.698e-14 ad=2.32e-14 ps=8e-07 pd=6.1e-07 nrd=1.16667 \
        nrs=1.16667 sa=2.55e-07 sb=3.45e-07 sd=160n sca=12.9138 \
        scb=0.0133404 scc=0.000640143 m=(1)
mn53 (\6\:n35 \10\:CKb n10 VSS) g45n1svt w=(1.45e-07) l=4.5e-08 nf=1 \
        as=2.03e-14 ad=2.32e-14 ps=5.7e-07 pd=6.1e-07 nrd=1.16667 \
        nrs=1.16667 sa=4.6e-07 sb=1.4e-07 sd=160n sca=12.9138 \
        scb=0.0133404 scc=0.000640143 m=(1)
mn51 (\3\:n10 RNb \3\:n8 VSS) g45n1svt w=(1.45e-07) l=4.5e-08 nf=1 \
        as=2.03e-14 ad=2.538e-14 ps=5.7e-07 pd=6.4e-07 nrd=1.16667 \
        nrs=1.16667 sa=1.4e-07 sb=7.95e-07 sd=160n sca=12.5912 \
        scb=0.0129007 scc=0.000589158 m=(1)
mn52 (\3\:n10 qbint n8 VSS) g45n1svt w=(1.45e-07) l=4.5e-08 nf=1 \
        as=2.32e-14 ad=2.538e-14 ps=6.1e-07 pd=6.4e-07 nrd=1.16667 \
        nrs=1.16667 sa=3.6e-07 sb=5.75e-07 sd=160n sca=12.5912 \
        scb=0.0129007 scc=0.000589158 m=(1)
mn50 (n8 \5\:SN \19\:VSS VSS) g45n1svt w=(1.45e-07) l=4.5e-08 nf=1 \
        as=2.92e-14 ad=2.32e-14 ps=7.3e-07 pd=6.1e-07 nrd=1.16667 \
        nrs=1.16667 sa=5.65e-07 sb=3.7e-07 sd=160n sca=12.5912 \
        scb=0.0129007 scc=0.000589158 m=(1)
mn22 (\7\:RNb \3\:RN \1\:VSS VSS) g45n1svt w=(1.45e-07) l=4.5e-08 nf=1 \
        as=5.91e-14 ad=2.03e-14 ps=1.62e-06 pd=5.7e-07 nrd=1.16667 \
        nrs=1.16667 sa=1.4e-07 sb=1.475e-06 sd=160n sca=23.279 \
        scb=0.0230742 scc=0.00267719 m=(1)
mn56 (\7\:net573 \12\:qbint \1\:VSS VSS) g45n1svt w=(1.45e-07) l=4.5e-08 \
        nf=1 as=8.985e-14 ad=2.03e-14 ps=1.6e-06 pd=5.7e-07 nrd=1.16667 \
        nrs=1.16667 sa=1.475e-06 sb=1.4e-07 sd=160n sca=23.279 \
        scb=0.0230742 scc=0.00267719 m=(1)
mn45 (\17\:qbint n35 \19\:VSS VSS) g45n1svt w=(2.05e-07) l=4.5e-08 nf=1 \
        as=2.92e-14 ad=3.383e-14 ps=7.3e-07 pd=7.4e-07 nrd=1.16667 \
        nrs=1.16667 sa=5.73902e-07 sb=1.65e-07 sd=160n sca=15.5643 \
        scb=0.0161016 scc=0.00117276 m=(1)
mn57_1__rcx (\4\:QN net573 \1\:VSS VSS) g45n1svt w=(2.6e-07) l=4.5e-08 \
        nf=1 as=9.273e-14 ad=7.41e-14 ps=1.6e-06 pd=1.09e-06 nrd=1.16667 \
        nrs=1.16667 sa=7.71635e-07 sb=6.31058e-07 sd=160n sca=17.5885 \
        scb=0.0172826 scc=0.00162584 m=(2)
mn55 (\1\:Q \5\:qbint \1\:VSS VSS) g45n1svt w=(2.6e-07) l=4.5e-08 nf=1 \
        as=7.735e-14 ad=5.85e-14 ps=1.61e-06 pd=9.7e-07 nrd=1.16667 \
        nrs=1.16667 sa=2.36635e-07 sb=1.16606e-06 sd=160n sca=17.5885 \
        scb=0.0172826 scc=0.00162584 m=(2)
mp45 (\23\:qbint \3\:n35 \16\:VDD NW) g45p1svt w=(3.1e-07) l=4.5e-08 \
        nf=1 as=1.267e-13 ad=6.2e-14 ps=1.94e-06 pd=1.02e-06 nrd=1.16667 \
        nrs=1.16667 sa=1.1925e-06 sb=2e-07 sd=160n sca=24.2842 \
        scb=0.0202139 scc=0.00265344 m=(1)
mp57 (\1\:QN net573 \1\:VDD NW) g45p1svt w=(3.9e-07) l=4.5e-08 nf=1 \
        as=7.154e-14 ad=6.24e-14 ps=1.185e-06 pd=1.1e-06 nrd=1.16667 \
        nrs=1.16667 sa=7.70064e-07 sb=4.53846e-07 sd=160n sca=25.9986 \
        scb=0.0191329 scc=0.00277829 m=(2)
mp55_1__rcx (\3\:Q \5\:qbint \1\:VDD NW) g45p1svt w=(3.9e-07) l=4.5e-08 \
        nf=1 as=6.885e-14 ad=8.775e-14 ps=1.16e-06 pd=1.23e-06 nrd=1.16667 \
        nrs=1.16667 sa=2.35064e-07 sb=9.88846e-07 sd=160n sca=25.6993 \
        scb=0.0190507 scc=0.00277827 m=(2)
ends SDFFSRX2
// End of subcircuit definition.
