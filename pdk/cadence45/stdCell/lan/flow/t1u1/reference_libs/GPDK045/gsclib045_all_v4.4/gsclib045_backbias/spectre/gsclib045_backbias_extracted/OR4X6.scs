// Generated for: spectre (May  1 11:32:04 2013 )
// Library name: gsclib045_backbias
// Cell name: OR4X6
// View name: extracted

simulator lang=spectre

subckt OR4X6 A B C D NW VDD VSS Y
mp0_1__rcx (2 \1\:A \10\:VDD NW) g45p1svt w=(3.9e-07) l=4.5e-08 nf=1 \
        as=5.46e-14 ad=2.34e-14 ps=1.06e-06 pd=9e-07 nrd=1.16667 \
        nrs=1.16667 sa=1.4e-07 sb=1.88615e-06 sd=160n sca=15.9946 \
        scb=0.0153756 scc=0.000392843 m=(1)
mp1_1__rcx (4 \1\:B 2 NW) g45p1svt w=(3.9e-07) l=4.5e-08 nf=1 as=2.34e-14 \
        ad=6.825e-14 ps=9e-07 pd=1.13e-06 nrd=1.16667 nrs=1.16667 \
        sa=2.45e-07 sb=1.86462e-06 sd=160n sca=14.2697 scb=0.0124687 \
        scc=0.000342275 m=(1)
mp2_1__rcx (4 \1\:C 6 NW) g45p1svt w=(3.9e-07) l=4.5e-08 nf=1 as=9.36e-14 \
        ad=6.825e-14 ps=1.26e-06 pd=1.13e-06 nrd=1.16667 nrs=1.16667 \
        sa=4.65e-07 sb=1.81949e-06 sd=160n sca=12.6655 scb=0.010598 \
        scc=0.000333408 m=(1)
mp3_1__rcx (\29\:n0 \5\:D 6 NW) g45p1svt w=(3.9e-07) l=4.5e-08 nf=1 \
        as=9.36e-14 ad=6.24e-14 ps=1.26e-06 pd=1.1e-06 nrd=1.16667 \
        nrs=1.16667 sa=7.5e-07 sb=1.67359e-06 sd=160n sca=11.9453 \
        scb=0.010292 scc=0.000333254 m=(1)
mp3 (\29\:n0 \1\:D 7 NW) g45p1svt w=(3.9e-07) l=4.5e-08 nf=1 as=4.485e-14 \
        ad=6.24e-14 ps=1.01e-06 pd=1.1e-06 nrd=1.16667 nrs=1.16667 \
        sa=9.55e-07 sb=1.46859e-06 sd=160n sca=11.9453 scb=0.010292 \
        scc=0.000333254 m=(1)
mp2 (7 \4\:C 8 NW) g45p1svt w=(3.9e-07) l=4.5e-08 nf=1 as=5.85e-14 \
        ad=4.485e-14 ps=1.08e-06 pd=1.01e-06 nrd=1.16667 nrs=1.16667 \
        sa=1.115e-06 sb=1.30859e-06 sd=160n sca=11.9453 scb=0.010292 \
        scc=0.000333254 m=(1)
mp1 (3 \6\:B 8 NW) g45p1svt w=(3.9e-07) l=4.5e-08 nf=1 as=5.85e-14 \
        ad=2.34e-14 ps=1.08e-06 pd=9e-07 nrd=1.16667 nrs=1.16667 \
        sa=1.31e-06 sb=1.11359e-06 sd=160n sca=11.9453 scb=0.010292 \
        scc=0.000333254 m=(1)
mp0 (3 \6\:A \1\:VDD NW) g45p1svt w=(3.9e-07) l=4.5e-08 nf=1 \
        as=1.194e-13 ad=2.34e-14 ps=1.9e-06 pd=9e-07 nrd=1.16667 \
        nrs=1.16667 sa=1.415e-06 sb=1.00859e-06 sd=160n sca=11.9453 \
        scb=0.010292 scc=0.000333254 m=(1)
C1 (NW VSS) capacitor c=3.91898e-16
C2 (Y VSS) capacitor c=2.48229e-16
C3 (B VSS) capacitor c=2.74149e-17
C4 (VDD VSS) capacitor c=2.89746e-17
C5 (C VSS) capacitor c=9.40362e-17
C6 (D VSS) capacitor c=9.06653e-17
C7 (A VSS) capacitor c=6.25945e-16
C8 (n0 VSS) capacitor c=3.65813e-16
C9 (2 VSS) capacitor c=2.75713e-18
C10 (4 VSS) capacitor c=6.37875e-18
C11 (6 VSS) capacitor c=1.04894e-17
C12 (7 VSS) capacitor c=6.21517e-18
C13 (8 VSS) capacitor c=8.55036e-18
C14 (3 VSS) capacitor c=3.20036e-18
C15 (\6\:A VSS) capacitor c=8.60657e-17
C16 (\6\:B VSS) capacitor c=7.62272e-17
C17 (\4\:C VSS) capacitor c=7.84682e-17
C18 (\1\:D VSS) capacitor c=5.21616e-17
C19 (\5\:D VSS) capacitor c=3.53775e-17
C20 (\1\:C VSS) capacitor c=4.35268e-17
C21 (\1\:B VSS) capacitor c=7.07507e-17
C22 (\1\:A VSS) capacitor c=6.029e-17
C23 (\2\:D VSS) capacitor c=5.16144e-17
C24 (\2\:C VSS) capacitor c=2.9834e-16
C25 (\2\:B VSS) capacitor c=5.18722e-16
C26 (\1\:VDD VSS) capacitor c=4.01307e-16
C27 (\29\:n0 VSS) capacitor c=1.43456e-16
C28 (\10\:VDD VSS) capacitor c=3.71824e-17
C29 (\1\:Y VSS) capacitor c=2.09537e-16
C30 (\21\:n0 VSS) capacitor c=2.63218e-16
C31 (\3\:D VSS) capacitor c=7.19214e-17
C32 (\7\:D VSS) capacitor c=3.33612e-17
C33 (\20\:n0 VSS) capacitor c=1.41451e-16
C34 (\5\:VDD VSS) capacitor c=8.88755e-17
Rk16 (\1\:Y Y) resistor r=0.275 c=0
Rk5 (\2\:B B) resistor r=0.054 c=0
Rk33 (\3\:VSS VSS) resistor r=0.03465 c=0
Rk25 (\2\:VSS \3\:VSS) resistor r=0.03239 c=0
Rk38 (\3\:VSS \20\:VSS) resistor r=0.1987 c=0
Rk44 (\5\:VDD VDD) resistor r=0.0923 c=0
Rk43 (\1\:VDD \5\:VDD) resistor r=0.7556 c=0
Rk47 (\5\:VDD \11\:VDD) resistor r=0.1934 c=0
Rk2 (C \2\:C) resistor r=0.02267 c=0
Rk1 (\7\:D D) resistor r=0.1117 c=0
Rk9 (n0 \20\:n0) resistor r=0.1826 c=0
Rk10 (\20\:n0 \21\:n0) resistor r=0.2773 c=0
Rk14 (\20\:n0 \30\:n0) resistor r=1.0277 c=0
Rl15 (\2\:B \6\:B) resistor r=29.5379 c=0
Rl3 (\2\:B \1\:B) resistor r=29.5379 c=0
Rl12 (\2\:C \4\:C) resistor r=131.461 c=0
Rl5 (\2\:C \1\:C) resistor r=56.461 c=0
Rl7 (\2\:D \1\:D) resistor r=149.977 c=0
Rl10 (\2\:D \5\:D) resistor r=130.746 c=0
Rl8 (\3\:D \2\:D) resistor r=2.7713 c=0
Rl17 (A \6\:A) resistor r=57.4874 c=0
Rl1 (A \1\:A) resistor r=30.5087 c=0
Rz12 (\20\:VSS \19\:VSS) resistor r=75 c=0
Ry5 (\2\:VSS \1\:VSS) resistor r=15.5 c=0
Ry6 (\3\:VSS \1\:VSS) resistor r=5.1667 c=0
Ry10 (\11\:VDD \10\:VDD) resistor r=62 c=0
Ry1 (\30\:n0 \29\:n0) resistor r=62 c=0
Rx1 (\7\:D \2\:D) resistor r=45 c=0
mn3 (\21\:n0 \3\:D \19\:VSS VSS) g45n1svt w=(2.6e-07) l=4.5e-08 nf=1 \
        as=4.16e-14 ad=4.615e-14 ps=8.4e-07 pd=8.75e-07 nrd=1.16667 \
        nrs=1.16667 sa=8e-07 sb=2e-06 sd=160n sca=9.14564 scb=0.00759168 \
        scc=0.000213449 m=(2)
mn0_1__rcx (\21\:n0 A \3\:VSS VSS) g45n1svt w=(2.6e-07) l=4.5e-08 nf=1 \
        as=4.345e-14 ad=4.55e-14 ps=8.85e-07 pd=8.7e-07 nrd=1.16667 \
        nrs=1.16667 sa=1.4e-07 sb=2e-06 sd=160n sca=9.14564 scb=0.00759168 \
        scc=0.000213449 m=(2)
mn1_1__rcx (\21\:n0 \2\:B \3\:VSS VSS) g45n1svt w=(2.6e-07) l=4.5e-08 \
        nf=1 as=4.485e-14 ad=4.55e-14 ps=8.65e-07 pd=8.7e-07 nrd=1.16667 \
        nrs=1.16667 sa=3.6e-07 sb=2e-06 sd=160n sca=9.14564 scb=0.00759168 \
        scc=0.000213449 m=(2)
mn2 (\21\:n0 \2\:C \3\:VSS VSS) g45n1svt w=(2.6e-07) l=4.5e-08 nf=1 \
        as=4.485e-14 ad=4.615e-14 ps=8.65e-07 pd=8.75e-07 nrd=1.16667 \
        nrs=1.16667 sa=5.8e-07 sb=2e-06 sd=160n sca=9.14564 scb=0.00759168 \
        scc=0.000213449 m=(2)
mn4_1__rcx (\1\:Y n0 \3\:VSS VSS) g45n1svt w=(3.1e-07) l=4.5e-08 nf=1 \
        as=4.978e-14 ad=4.836e-14 ps=9.46e-07 pd=9.32e-07 nrd=1.16667 \
        nrs=1.16667 sa=1.5971e-06 sb=9.6e-07 sd=160n sca=10.4852 \
        scb=0.00950193 scc=0.000416321 m=(5)
mp4_1__rcx (Y n0 \1\:VDD NW) g45p1svt w=(4.7e-07) l=4.5e-08 nf=1 \
        as=8.404e-14 ad=7.332e-14 ps=1.388e-06 pd=1.252e-06 nrd=1.16667 \
        nrs=1.16667 sa=1.14213e-06 sb=9.6e-07 sd=160n sca=26.9787 \
        scb=0.0178954 scc=0.0027966 m=(5)
ends OR4X6
// End of subcircuit definition.
