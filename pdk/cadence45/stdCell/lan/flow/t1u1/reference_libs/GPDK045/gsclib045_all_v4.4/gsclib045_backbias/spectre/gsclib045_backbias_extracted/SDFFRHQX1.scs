// Generated for: spectre (May  1 11:32:18 2013 )
// Library name: gsclib045_backbias
// Cell name: SDFFRHQX1
// View name: extracted

simulator lang=spectre

subckt SDFFRHQX1 CK D NW Q RN SE SI VDD VSS
mp55 (\1\:Q \4\:qbint \19\:VDD NW) g45p1svt w=(3.9e-07) l=4.5e-08 nf=1 \
        as=6.535e-14 ad=5.46e-14 ps=1.16e-06 pd=1.06e-06 nrd=1.16667 \
        nrs=1.16667 sa=1.4e-07 sb=2.72308e-07 sd=160n sca=23.0036 \
        scb=0.0261368 scc=0.00127103 m=(1)
mp11 (net381 \1\:D \9\:VDD NW) g45p1svt w=(3.9e-07) l=4.5e-08 nf=1 \
        as=6.98e-14 ad=2.34e-14 ps=1.62e-06 pd=9e-07 nrd=1.16667 \
        nrs=1.16667 sa=2.35064e-07 sb=8.20897e-07 sd=160n sca=12.2138 \
        scb=0.0106342 scc=0.00038358 m=(1)
mp12 (\3\:Db \2\:SE net381 NW) g45p1svt w=(3.9e-07) l=4.5e-08 nf=1 \
        as=2.34e-14 ad=7.02e-14 ps=9e-07 pd=1.14e-06 nrd=1.16667 \
        nrs=1.16667 sa=3.40064e-07 sb=7.15897e-07 sd=160n sca=12.2524 \
        scb=0.0106415 scc=0.00038358 m=(1)
mp14 (\3\:Db SEb net373 NW) g45p1svt w=(3.9e-07) l=4.5e-08 nf=1 \
        as=5.265e-14 ad=7.02e-14 ps=1.05e-06 pd=1.14e-06 nrd=1.16667 \
        nrs=1.16667 sa=5.65064e-07 sb=4.90897e-07 sd=160n sca=12.9125 \
        scb=0.0109255 scc=0.000383719 m=(1)
mp13 (net373 \3\:SI \1\:VDD NW) g45p1svt w=(3.9e-07) l=4.5e-08 nf=1 \
        as=8.147e-14 ad=5.265e-14 ps=1.31e-06 pd=1.05e-06 nrd=1.16667 \
        nrs=1.16667 sa=7.45064e-07 sb=3.10897e-07 sd=160n sca=14.0619 \
        scb=0.0121239 scc=0.000387547 m=(1)
C1 (NW VSS) capacitor c=6.468e-16
C2 (D VSS) capacitor c=4.02028e-17
C3 (Q VSS) capacitor c=1.32008e-17
C4 (RN VSS) capacitor c=4.92285e-17
C5 (VDD VSS) capacitor c=3.94477e-17
C6 (SE VSS) capacitor c=7.29724e-17
C7 (SI VSS) capacitor c=4.95859e-17
C8 (qbint VSS) capacitor c=1.87077e-17
C9 (CKb VSS) capacitor c=5.79398e-17
C10 (net337 VSS) capacitor c=4.46366e-18
C11 (n30 VSS) capacitor c=5.62737e-17
C12 (net405 VSS) capacitor c=2.68183e-18
C13 (mout VSS) capacitor c=5.89201e-17
C14 (CKbb VSS) capacitor c=2.15079e-17
C15 (n20 VSS) capacitor c=5.10107e-17
C16 (Db VSS) capacitor c=1.25246e-16
C17 (net450 VSS) capacitor c=6.64026e-18
C18 (SEb VSS) capacitor c=4.56599e-17
C19 (net326 VSS) capacitor c=3.58673e-18
C20 (net349 VSS) capacitor c=5.66685e-17
C21 (net381 VSS) capacitor c=1.5388e-18
C22 (net373 VSS) capacitor c=3.87756e-18
C23 (\5\:SE VSS) capacitor c=4.34616e-17
C24 (\3\:SI VSS) capacitor c=6.71766e-17
C25 (\2\:SE VSS) capacitor c=7.2781e-17
C26 (\1\:D VSS) capacitor c=1.08477e-16
C27 (\8\:CKb VSS) capacitor c=5.09535e-17
C28 (\7\:CKbb VSS) capacitor c=5.28889e-17
C29 (\5\:CKb VSS) capacitor c=5.37722e-17
C30 (\2\:RN VSS) capacitor c=1.36567e-16
C31 (\3\:n20 VSS) capacitor c=5.76825e-17
C32 (\3\:CKb VSS) capacitor c=4.47561e-17
C33 (\3\:CKbb VSS) capacitor c=8.9782e-17
C34 (\5\:qbint VSS) capacitor c=6.9645e-17
C35 (\3\:RN VSS) capacitor c=1.05408e-16
C36 (\1\:CK VSS) capacitor c=4.15702e-17
C37 (\4\:qbint VSS) capacitor c=5.81951e-17
C38 (\7\:SE VSS) capacitor c=3.38833e-17
C39 (\1\:SI VSS) capacitor c=8.0021e-17
C40 (\3\:SE VSS) capacitor c=5.85988e-17
C41 (\3\:SEb VSS) capacitor c=6.55313e-17
C42 (\4\:D VSS) capacitor c=3.86458e-17
C43 (\10\:CKb VSS) capacitor c=6.32977e-17
C44 (\7\:CKb VSS) capacitor c=4.90036e-17
C45 (\4\:CKbb VSS) capacitor c=4.60951e-17
C46 (\3\:mout VSS) capacitor c=6.5346e-17
C47 (\1\:RN VSS) capacitor c=8.98021e-17
C48 (\7\:qbint VSS) capacitor c=5.63759e-17
C49 (\5\:RN VSS) capacitor c=5.13029e-17
C50 (\3\:n30 VSS) capacitor c=2.92865e-17
C51 (\3\:CK VSS) capacitor c=4.94278e-17
C52 (\3\:qbint VSS) capacitor c=3.43207e-17
C53 (\6\:SE VSS) capacitor c=4.00113e-17
C54 (\2\:SI VSS) capacitor c=6.47187e-17
C55 (\4\:SE VSS) capacitor c=4.35427e-17
C56 (\2\:SEb VSS) capacitor c=5.76262e-17
C57 (\1\:SE VSS) capacitor c=5.21226e-17
C58 (\3\:D VSS) capacitor c=2.56249e-17
C59 (\9\:CKb VSS) capacitor c=2.77675e-17
C60 (\6\:CKbb VSS) capacitor c=3.78216e-17
C61 (\6\:CKb VSS) capacitor c=2.06381e-17
C62 (\5\:CKbb VSS) capacitor c=4.02057e-17
C63 (\2\:mout VSS) capacitor c=5.94537e-17
C64 (\2\:n20 VSS) capacitor c=4.95181e-17
C65 (\4\:CKb VSS) capacitor c=3.20777e-17
C66 (\2\:CKbb VSS) capacitor c=5.81745e-17
C67 (\2\:CKb VSS) capacitor c=5.73752e-17
C68 (\6\:qbint VSS) capacitor c=6.90841e-17
C69 (\6\:RN VSS) capacitor c=2.54239e-17
C70 (\2\:n30 VSS) capacitor c=3.94228e-17
C71 (\2\:CK VSS) capacitor c=4.49341e-17
C72 (\5\:SEb VSS) capacitor c=9.49591e-17
C73 (\1\:VDD VSS) capacitor c=1.27859e-16
C74 (\3\:Db VSS) capacitor c=1.44401e-16
C75 (\9\:VDD VSS) capacitor c=1.80082e-17
C76 (\8\:CKbb VSS) capacitor c=6.70995e-17
C77 (\6\:Db VSS) capacitor c=1.70823e-16
C78 (\4\:n20 VSS) capacitor c=5.7e-17
C79 (\11\:VDD VSS) capacitor c=3.4848e-17
C80 (\3\:net349 VSS) capacitor c=6.80599e-17
C81 (\13\:VDD VSS) capacitor c=4.70293e-17
C82 (\8\:mout VSS) capacitor c=8.76327e-17
C83 (\4\:n30 VSS) capacitor c=1.20594e-16
C84 (\15\:VDD VSS) capacitor c=5.04875e-17
C85 (\12\:qbint VSS) capacitor c=5.57533e-17
C86 (\17\:VDD VSS) capacitor c=3.84223e-17
C87 (\15\:CKb VSS) capacitor c=1.39541e-16
C88 (\19\:VDD VSS) capacitor c=6.8759e-17
C89 (\1\:Q VSS) capacitor c=6.65291e-17
C90 (\7\:SEb VSS) capacitor c=7.51405e-17
C91 (\14\:CKbb VSS) capacitor c=1.91864e-17
C92 (\8\:Db VSS) capacitor c=1.05964e-16
C93 (\8\:n20 VSS) capacitor c=9.32742e-17
C94 (\6\:mout VSS) capacitor c=6.53465e-17
C95 (\6\:n30 VSS) capacitor c=1.5523e-16
C96 (\10\:qbint VSS) capacitor c=1.45716e-16
C97 (\19\:CKb VSS) capacitor c=1.12488e-16
C98 (\4\:Q VSS) capacitor c=3.18057e-17
C99 (\2\:qbint VSS) capacitor c=2.41639e-17
C100 (\4\:RN VSS) capacitor c=3.35345e-17
C101 (\2\:D VSS) capacitor c=2.57214e-17
C102 (\3\:Q VSS) capacitor c=5.2911e-17
C103 (\4\:CK VSS) capacitor c=5.9995e-17
C104 (\5\:CK VSS) capacitor c=4.32737e-17
C105 (\8\:RN VSS) capacitor c=4.94178e-17
C106 (\8\:qbint VSS) capacitor c=6.41541e-17
C107 (\9\:qbint VSS) capacitor c=1.04086e-16
C108 (\14\:qbint VSS) capacitor c=1.2535e-16
C109 (\8\:n30 VSS) capacitor c=1.20216e-16
C110 (\4\:mout VSS) capacitor c=8.78146e-17
C111 (\5\:mout VSS) capacitor c=1.06079e-16
C112 (\6\:n20 VSS) capacitor c=9.96866e-17
C113 (\7\:n20 VSS) capacitor c=8.07361e-17
C114 (\10\:CKbb VSS) capacitor c=3.8112e-17
C115 (\11\:CKbb VSS) capacitor c=9.89327e-17
C116 (\12\:CKbb VSS) capacitor c=2.22983e-16
C117 (\13\:CKbb VSS) capacitor c=1.89909e-16
C118 (\16\:CKbb VSS) capacitor c=3.84947e-17
C119 (\11\:CKb VSS) capacitor c=8.07945e-17
C120 (\12\:CKb VSS) capacitor c=1.48916e-16
C121 (\13\:CKb VSS) capacitor c=1.35084e-16
C122 (\14\:CKb VSS) capacitor c=1.65188e-16
C123 (\17\:CKb VSS) capacitor c=8.29889e-17
C124 (\18\:CKb VSS) capacitor c=5.22664e-17
C125 (\6\:D VSS) capacitor c=3.78147e-17
C126 (\5\:Db VSS) capacitor c=5.07665e-17
C127 (\4\:SI VSS) capacitor c=5.5802e-17
C128 (\8\:SE VSS) capacitor c=6.22354e-17
C129 (\9\:SE VSS) capacitor c=4.45e-17
C130 (\10\:SE VSS) capacitor c=5.99161e-17
C131 (\4\:SEb VSS) capacitor c=8.13389e-17
C132 (\3\:VDD VSS) capacitor c=1.06097e-16
C133 (\4\:VDD VSS) capacitor c=7.4176e-17
C134 (\5\:VDD VSS) capacitor c=7.18054e-17
C135 (\6\:VDD VSS) capacitor c=8.15202e-17
C136 (\7\:VDD VSS) capacitor c=4.56673e-17
C137 (\8\:VDD VSS) capacitor c=3.2353e-17
Rk36 (\5\:D \6\:D) resistor r=0.002289 c=0
Rk37 (\7\:D D) resistor r=0.002403 c=0
Rk38 (\6\:D \7\:D) resistor r=0.09354 c=0
Rk2 (\3\:Q Q) resistor r=0.007258 c=0
Rk1 (\2\:Q \3\:Q) resistor r=0.4303 c=0
Rk3 (\3\:Q \5\:Q) resistor r=0.1825 c=0
Rk7 (\7\:RN \8\:RN) resistor r=0.008733 c=0
Rk8 (\9\:RN RN) resistor r=0.008733 c=0
Rk9 (\8\:RN \9\:RN) resistor r=0.01996 c=0
Rk59 (\2\:VDD \3\:VDD) resistor r=0.5778 c=0
Rk60 (\3\:VDD \4\:VDD) resistor r=0.4657 c=0
Rk61 (\4\:VDD \5\:VDD) resistor r=0.2196 c=0
Rk62 (\5\:VDD \6\:VDD) resistor r=0.4741 c=0
Rk63 (\6\:VDD \7\:VDD) resistor r=0.2657 c=0
Rk65 (\8\:VDD VDD) resistor r=0.1251 c=0
Rk64 (\7\:VDD \8\:VDD) resistor r=0.213 c=0
Rk66 (\3\:VDD \10\:VDD) resistor r=0.07476 c=0
Rk67 (\4\:VDD \12\:VDD) resistor r=0.04338 c=0
Rk68 (\5\:VDD \14\:VDD) resistor r=0.1543 c=0
Rk69 (\6\:VDD \16\:VDD) resistor r=0.247 c=0
Rk70 (\7\:VDD \18\:VDD) resistor r=0.1543 c=0
Rk71 (\8\:VDD \20\:VDD) resistor r=0.3203 c=0
Rk45 (\8\:SE SE) resistor r=0.3149 c=0
Rk46 (SE \9\:SE) resistor r=0.0751 c=0
Rk47 (\9\:SE \10\:SE) resistor r=0.2249 c=0
Rk44 (SI \4\:SI) resistor r=0.02621 c=0
Rk50 (\2\:VSS \4\:VSS) resistor r=0.7354 c=0
Rk51 (\4\:VSS \5\:VSS) resistor r=0.6777 c=0
Rk52 (\5\:VSS \6\:VSS) resistor r=0.5277 c=0
Rk54 (\7\:VSS VSS) resistor r=0.1251 c=0
Rk53 (\6\:VSS \7\:VSS) resistor r=0.4266 c=0
Rk55 (\4\:VSS \9\:VSS) resistor r=0.3693 c=0
Rk56 (\5\:VSS \11\:VSS) resistor r=0.2545 c=0
Rk57 (\6\:VSS \13\:VSS) resistor r=0.1976 c=0
Rk58 (\7\:VSS \15\:VSS) resistor r=0.3086 c=0
Rk4 (CK \4\:CK) resistor r=0.004227 c=0
Rk6 (\4\:CK \5\:CK) resistor r=0.07064 c=0
Rk5 (\5\:CK \6\:CK) resistor r=0.004227 c=0
Rk10 (\8\:qbint \9\:qbint) resistor r=0.3799 c=0
Rk11 (\9\:qbint \11\:qbint) resistor r=0.5415 c=0
Rk12 (\9\:qbint \13\:qbint) resistor r=0.2374 c=0
Rk13 (\11\:qbint \14\:qbint) resistor r=0.6457 c=0
Rk29 (\11\:CKb \12\:CKb) resistor r=0.3924 c=0
Rk30 (\12\:CKb \13\:CKb) resistor r=0.8429 c=0
Rk31 (\13\:CKb \14\:CKb) resistor r=0.3488 c=0
Rk32 (\14\:CKb \16\:CKb) resistor r=0.781 c=0
Rk33 (\13\:CKb \17\:CKb) resistor r=0.2949 c=0
Rk34 (\14\:CKb \18\:CKb) resistor r=0.326 c=0
Rk35 (\16\:CKb \20\:CKb) resistor r=0.5326 c=0
Rk14 (\5\:n30 \7\:n30) resistor r=0.588 c=0
Rk15 (\7\:n30 \8\:n30) resistor r=0.7398 c=0
Rk16 (\4\:mout \5\:mout) resistor r=0.473 c=0
Rk17 (\5\:mout \7\:mout) resistor r=0.2059 c=0
Rk18 (\5\:mout \9\:mout) resistor r=0.3244 c=0
Rk23 (\9\:CKbb \10\:CKbb) resistor r=0.3799 c=0
Rk24 (\10\:CKbb \11\:CKbb) resistor r=0.1571 c=0
Rk25 (\11\:CKbb \12\:CKbb) resistor r=0.8393 c=0
Rk26 (\12\:CKbb \13\:CKbb) resistor r=1.0921 c=0
Rk27 (\10\:CKbb \15\:CKbb) resistor r=0.0921 c=0
Rk28 (\12\:CKbb \16\:CKbb) resistor r=0.07888 c=0
Rk20 (\5\:n20 \6\:n20) resistor r=0.2171 c=0
Rk21 (\6\:n20 \7\:n20) resistor r=0.5467 c=0
Rk22 (\6\:n20 \9\:n20) resistor r=0.3571 c=0
Rk39 (\2\:Db \4\:Db) resistor r=0.7348 c=0
Rk40 (\4\:Db \5\:Db) resistor r=0.0391 c=0
Rk41 (\5\:Db \7\:Db) resistor r=0.583 c=0
Rk42 (\7\:Db \9\:Db) resistor r=0.6106 c=0
Rk43 (\5\:Db \10\:Db) resistor r=0.0987 c=0
Rk48 (\4\:SEb \6\:SEb) resistor r=0.5531 c=0
Rk49 (\6\:SEb \8\:SEb) resistor r=0.5391 c=0
Rk19 (\2\:net349 \4\:net349) resistor r=0.3075 c=0
Rl29 (\1\:D \2\:D) resistor r=127.726 c=0
Rl31 (\2\:D \4\:D) resistor r=45.0334 c=0
Rl30 (\2\:D \3\:D) resistor r=3.1183 c=0
Rl17 (\2\:RN \3\:RN) resistor r=603.412 c=0
Rl16 (\1\:RN \2\:RN) resistor r=215.232 c=0
Rl18 (\3\:RN \4\:RN) resistor r=96.9565 c=0
Rl19 (\4\:RN \5\:RN) resistor r=106.572 c=0
Rl20 (\4\:RN \6\:RN) resistor r=5.013 c=0
Rl38 (\5\:SE \6\:SE) resistor r=119.922 c=0
Rl39 (\6\:SE \7\:SE) resistor r=46.8456 c=0
Rl35 (\3\:SE \4\:SE) resistor r=24.2328 c=0
Rl32 (\1\:SE \2\:SE) resistor r=36.4253 c=0
Rl37 (\2\:SI \3\:SI) resistor r=101.477 c=0
Rl36 (\1\:SI \2\:SI) resistor r=85.7713 c=0
Rl4 (\1\:CK \2\:CK) resistor r=104.538 c=0
Rl5 (\2\:CK \3\:CK) resistor r=110.307 c=0
Rl8 (\5\:qbint \6\:qbint) resistor r=160.771 c=0
Rl9 (\6\:qbint \7\:qbint) resistor r=24.2328 c=0
Rl3 (\2\:qbint \4\:qbint) resistor r=121.957 c=0
Rl2 (\2\:qbint \3\:qbint) resistor r=41.1873 c=0
Rl1 (qbint \2\:qbint) resistor r=1.2334 c=0
Rl28 (\8\:CKb \10\:CKb) resistor r=182.692 c=0
Rl25 (\5\:CKb \7\:CKb) resistor r=150 c=0
Rl27 (\8\:CKb \9\:CKb) resistor r=52.1862 c=0
Rl24 (\5\:CKb \6\:CKb) resistor r=64.1533 c=0
Rl11 (\3\:CKb \4\:CKb) resistor r=35.7713 c=0
Rl10 (CKb \2\:CKb) resistor r=70.3867 c=0
Rl6 (n30 \2\:n30) resistor r=158.384 c=0
Rl7 (\2\:n30 \3\:n30) resistor r=29.5379 c=0
Rl21 (mout \2\:mout) resistor r=108.79 c=0
Rl22 (\2\:mout \3\:mout) resistor r=72.2519 c=0
Rl26 (\6\:CKbb \7\:CKbb) resistor r=99.2573 c=0
Rl23 (\4\:CKbb \5\:CKbb) resistor r=41.5405 c=0
Rl13 (\2\:CKbb \3\:CKbb) resistor r=214.504 c=0
Rl12 (CKbb \2\:CKbb) resistor r=24.2328 c=0
Rl15 (\2\:n20 \3\:n20) resistor r=51.0989 c=0
Rl14 (n20 \2\:n20) resistor r=138.462 c=0
Rl33 (SEb \2\:SEb) resistor r=24.2328 c=0
Rl34 (\2\:SEb \3\:SEb) resistor r=135.404 c=0
Rz1 (\4\:Q \5\:Q) resistor r=37.5 c=0
Rz11 (\1\:VSS \2\:VSS) resistor r=75 c=0
Rz12 (\8\:VSS \9\:VSS) resistor r=75 c=0
Rz13 (\10\:VSS \11\:VSS) resistor r=75 c=0
Rz14 (\12\:VSS \13\:VSS) resistor r=75 c=0
Rz15 (\14\:VSS \15\:VSS) resistor r=37.5 c=0
Rz2 (\10\:qbint \11\:qbint) resistor r=75 c=0
Rz7 (\19\:CKb \20\:CKb) resistor r=75 c=0
Rz3 (\6\:n30 \7\:n30) resistor r=75 c=0
Rz4 (\6\:mout \7\:mout) resistor r=75 c=0
Rz6 (\14\:CKbb \15\:CKbb) resistor r=75 c=0
Rz5 (\8\:n20 \9\:n20) resistor r=75 c=0
Rz8 (Db \2\:Db) resistor r=75 c=0
Rz9 (\8\:Db \9\:Db) resistor r=75 c=0
Rz10 (\7\:SEb \8\:SEb) resistor r=75 c=0
Ry1 (\1\:Q \2\:Q) resistor r=20.6667 c=0
Ry16 (\1\:VDD \2\:VDD) resistor r=62 c=0
Ry17 (\9\:VDD \10\:VDD) resistor r=62 c=0
Ry18 (\11\:VDD \12\:VDD) resistor r=62 c=0
Ry19 (\13\:VDD \14\:VDD) resistor r=62 c=0
Ry20 (\15\:VDD \16\:VDD) resistor r=62 c=0
Ry21 (\17\:VDD \18\:VDD) resistor r=62 c=0
Ry22 (\19\:VDD \20\:VDD) resistor r=20.6667 c=0
Ry14 (\3\:VSS \4\:VSS) resistor r=5.1667 c=0
Ry15 (\3\:VSS \6\:VSS) resistor r=5.1667 c=0
Ry2 (\12\:qbint \13\:qbint) resistor r=62 c=0
Ry9 (\15\:CKb \16\:CKb) resistor r=62 c=0
Ry3 (\4\:n30 \5\:n30) resistor r=62 c=0
Ry4 (\8\:mout \9\:mout) resistor r=62 c=0
Ry8 (\8\:CKbb \9\:CKbb) resistor r=62 c=0
Ry7 (\4\:n20 \5\:n20) resistor r=31 c=0
Ry10 (\3\:Db \4\:Db) resistor r=62 c=0
Ry11 (\6\:Db \7\:Db) resistor r=31 c=0
Ry12 (\3\:Db \10\:Db) resistor r=62 c=0
Ry13 (\5\:SEb \6\:SEb) resistor r=62 c=0
Ry5 (net349 \2\:net349) resistor r=62 c=0
Ry6 (\3\:net349 \4\:net349) resistor r=62 c=0
Rx15 (\3\:D \5\:D) resistor r=45 c=0
Rx2 (\6\:RN \7\:RN) resistor r=45 c=0
Rx17 (\1\:SE \8\:SE) resistor r=45 c=0
Rx18 (\4\:SE \9\:SE) resistor r=45 c=0
Rx19 (\6\:SE \10\:SE) resistor r=45 c=0
Rx16 (\2\:SI \4\:SI) resistor r=45 c=0
Rx1 (\2\:CK \6\:CK) resistor r=45 c=0
Rx3 (\6\:qbint \8\:qbint) resistor r=45 c=0
Rx4 (qbint \14\:qbint) resistor r=45 c=0
Rx11 (\9\:CKb \11\:CKb) resistor r=45 c=0
Rx12 (\6\:CKb \12\:CKb) resistor r=45 c=0
Rx13 (\4\:CKb \17\:CKb) resistor r=45 c=0
Rx14 (\2\:CKb \18\:CKb) resistor r=45 c=0
Rx5 (\2\:n30 \8\:n30) resistor r=45 c=0
Rx6 (\2\:mout \4\:mout) resistor r=45 c=0
Rx8 (\6\:CKbb \11\:CKbb) resistor r=45 c=0
Rx9 (\2\:CKbb \13\:CKbb) resistor r=45 c=0
Rx10 (\5\:CKbb \16\:CKbb) resistor r=45 c=0
Rx7 (\2\:n20 \7\:n20) resistor r=45 c=0
Rx20 (\2\:SEb \4\:SEb) resistor r=45 c=0
mn55 (\4\:Q \3\:qbint \14\:VSS VSS) g45n1svt w=(2.6e-07) l=4.5e-08 nf=1 \
        as=4.365e-14 ad=3.64e-14 ps=9e-07 pd=8e-07 nrd=1.16667 nrs=1.16667 \
        sa=1.4e-07 sb=2.73846e-07 sd=160n sca=10.5507 scb=0.0097116 \
        scc=0.000384728 m=(1)
mn11 (net450 \4\:D \8\:VSS VSS) g45n1svt w=(2.6e-07) l=4.5e-08 nf=1 \
        as=3.47e-14 ad=6.76e-14 ps=8.4e-07 pd=1.04e-06 nrd=1.16667 \
        nrs=1.16667 sa=2.36635e-07 sb=8.51635e-07 sd=160n sca=10.79 \
        scb=0.0100512 scc=0.000418069 m=(1)
mn12 (Db \3\:SEb net450 VSS) g45n1svt w=(2.6e-07) l=4.5e-08 nf=1 \
        as=6.76e-14 ad=4.16e-14 ps=1.04e-06 pd=8.4e-07 nrd=1.16667 \
        nrs=1.16667 sa=5.41635e-07 sb=5.46635e-07 sd=160n sca=10.79 \
        scb=0.0100512 scc=0.000418069 m=(1)
mn14 (Db \3\:SE net442 VSS) g45n1svt w=(2.6e-07) l=4.5e-08 nf=1 \
        as=1.56e-14 ad=4.16e-14 ps=6.4e-07 pd=8.4e-07 nrd=1.16667 \
        nrs=1.16667 sa=7.46635e-07 sb=3.41635e-07 sd=160n sca=10.79 \
        scb=0.0100512 scc=0.000418069 m=(1)
mn13 (net442 \1\:SI \1\:VSS VSS) g45n1svt w=(2.6e-07) l=4.5e-08 nf=1 \
        as=3.47e-14 ad=1.56e-14 ps=8.4e-07 pd=6.4e-07 nrd=1.16667 \
        nrs=1.16667 sa=8.51635e-07 sb=2.36635e-07 sd=160n sca=10.79 \
        scb=0.0100512 scc=0.000418069 m=(1)
mn20 (\19\:CKb \3\:CK \14\:VSS VSS) g45n1svt w=(1.45e-07) l=4.5e-08 nf=1 \
        as=4.365e-14 ad=2.103e-14 ps=9e-07 pd=5.8e-07 nrd=1.16667 \
        nrs=1.16667 sa=3.75e-07 sb=1.45e-07 sd=160n sca=12.9138 \
        scb=0.0133404 scc=0.000640143 m=(1)
mn21 (\14\:CKbb \10\:CKb \8\:VSS VSS) g45n1svt w=(1.45e-07) l=4.5e-08 \
        nf=1 as=3.47e-14 ad=2.03e-14 ps=8.4e-07 pd=5.7e-07 nrd=1.16667 \
        nrs=1.16667 sa=1.4e-07 sb=1.12276e-06 sd=160n sca=13.253 \
        scb=0.0137915 scc=0.000695334 m=(1)
mn10 (\7\:SEb \7\:SE \1\:VSS VSS) g45n1svt w=(1.45e-07) l=4.5e-08 nf=1 \
        as=3.47e-14 ad=2.03e-14 ps=8.4e-07 pd=5.7e-07 nrd=1.16667 \
        nrs=1.16667 sa=1.12276e-06 sb=1.4e-07 sd=160n sca=11.7118 \
        scb=0.0116498 scc=0.000458536 m=(1)
mn46 (\10\:qbint \3\:n30 net337 VSS) g45n1svt w=(2.05e-07) l=4.5e-08 nf=1 \
        as=3.28e-14 ad=3.793e-14 ps=7.3e-07 pd=7.8e-07 nrd=1.16667 \
        nrs=1.16667 sa=1.85e-07 sb=2e-06 sd=160n sca=9.00745 scb=0.0073653 \
        scc=0.000173562 m=(1)
mn45 (net337 \5\:RN \12\:VSS VSS) g45n1svt w=(2.05e-07) l=4.5e-08 nf=1 \
        as=5.77e-14 ad=3.28e-14 ps=1.06e-06 pd=7.3e-07 nrd=1.16667 \
        nrs=1.16667 sa=3.9e-07 sb=1.95e-06 sd=160n sca=9.00745 \
        scb=0.0073653 scc=0.000173562 m=(1)
mn50 (net405 \7\:qbint \12\:VSS VSS) g45n1svt w=(2.05e-07) l=4.5e-08 \
        nf=1 as=5.77e-14 ad=1.23e-14 ps=1.06e-06 pd=5.3e-07 nrd=1.16667 \
        nrs=1.16667 sa=6.55e-07 sb=1.685e-06 sd=160n sca=9.00745 \
        scb=0.0073653 scc=0.000173562 m=(1)
mn51 (\6\:n30 CKb net405 VSS) g45n1svt w=(2.05e-07) l=4.5e-08 nf=1 \
        as=1.23e-14 ad=5.228e-14 ps=5.3e-07 pd=9.2e-07 nrd=1.16667 \
        nrs=1.16667 sa=7.6e-07 sb=1.58e-06 sd=160n sca=9.00745 \
        scb=0.0073653 scc=0.000173562 m=(1)
mn40 (\6\:n30 CKbb \6\:mout VSS) g45n1svt w=(2.05e-07) l=4.5e-08 nf=1 \
        as=5.945e-14 ad=5.228e-14 ps=9.9e-07 pd=9.2e-07 nrd=1.16667 \
        nrs=1.16667 sa=1.06e-06 sb=1.28e-06 sd=160n sca=9.00745 \
        scb=0.0073653 scc=0.000173562 m=(1)
mn30 (\6\:mout n20 \10\:VSS VSS) g45n1svt w=(2.05e-07) l=4.5e-08 nf=1 \
        as=5.245e-14 ad=5.945e-14 ps=1.24e-06 pd=9.9e-07 nrd=1.16667 \
        nrs=1.16667 sa=1.395e-06 sb=9.45e-07 sd=160n sca=9.00745 \
        scb=0.0073653 scc=0.000173562 m=(1)
mn35 (net426 \1\:RN \10\:VSS VSS) g45n1svt w=(2.05e-07) l=4.5e-08 nf=1 \
        as=5.245e-14 ad=2.665e-14 ps=1.24e-06 pd=6.7e-07 nrd=1.16667 \
        nrs=1.16667 sa=1.63e-06 sb=7.1e-07 sd=160n sca=9.00745 \
        scb=0.0073653 scc=0.000173562 m=(1)
mn36 (net422 \3\:mout net426 VSS) g45n1svt w=(2.05e-07) l=4.5e-08 nf=1 \
        as=2.665e-14 ad=1.333e-14 ps=6.7e-07 pd=5.4e-07 nrd=1.16667 \
        nrs=1.16667 sa=1.805e-06 sb=5.35e-07 sd=160n sca=9.00745 \
        scb=0.0073653 scc=0.000173562 m=(1)
mn37 (\8\:n20 \4\:CKbb net422 VSS) g45n1svt w=(2.05e-07) l=4.5e-08 nf=1 \
        as=1.333e-14 ad=4.613e-14 ps=5.4e-07 pd=8.6e-07 nrd=1.16667 \
        nrs=1.16667 sa=1.915e-06 sb=4.25e-07 sd=160n sca=9.00745 \
        scb=0.0073653 scc=0.000173562 m=(1)
mn25 (\8\:n20 \7\:CKb \8\:Db VSS) g45n1svt w=(2.05e-07) l=4.5e-08 nf=1 \
        as=3.178e-14 ad=4.613e-14 ps=7.2e-07 pd=8.6e-07 nrd=1.16667 \
        nrs=1.16667 sa=2e-06 sb=1.55e-07 sd=160n sca=9.00745 scb=0.0073653 \
        scc=0.000173562 m=(1)
mp20 (\15\:CKb \1\:CK \19\:VDD NW) g45p1svt w=(2.15e-07) l=4.5e-08 nf=1 \
        as=6.535e-14 ad=3.118e-14 ps=1.16e-06 pd=7.2e-07 nrd=1.16667 \
        nrs=1.16667 sa=3.75e-07 sb=1.45e-07 sd=160n sca=12.6299 \
        scb=0.00978612 scc=8.84613e-05 m=(1)
mp21 (\8\:CKbb \8\:CKb \9\:VDD NW) g45p1svt w=(2.15e-07) l=4.5e-08 nf=1 \
        as=6.98e-14 ad=3.01e-14 ps=1.62e-06 pd=7.1e-07 nrd=1.16667 \
        nrs=1.16667 sa=1.4e-07 sb=1.165e-06 sd=160n sca=13.9534 \
        scb=0.0134231 scc=0.000640578 m=(1)
mp10 (\5\:SEb \5\:SE \1\:VDD NW) g45p1svt w=(2.15e-07) l=4.5e-08 nf=1 \
        as=8.147e-14 ad=3.01e-14 ps=1.31e-06 pd=7.1e-07 nrd=1.16667 \
        nrs=1.16667 sa=1.165e-06 sb=1.4e-07 sd=160n sca=25.1693 \
        scb=0.0296469 scc=0.00157586 m=(1)
mp46 (\12\:qbint n30 \17\:VDD NW) g45p1svt w=(3.1e-07) l=4.5e-08 nf=1 \
        as=6.83e-14 ad=4.96e-14 ps=1.22e-06 pd=9.4e-07 nrd=1.16667 \
        nrs=1.16667 sa=1.7e-07 sb=1.735e-06 sd=160n sca=12.1897 \
        scb=0.0106254 scc=0.000361908 m=(1)
mp45 (\15\:VDD \3\:RN \12\:qbint NW) g45p1svt w=(3.1e-07) l=4.5e-08 nf=1 \
        as=4.96e-14 ad=6.82e-14 ps=9.4e-07 pd=1.06e-06 nrd=1.16667 \
        nrs=1.16667 sa=3.75e-07 sb=1.53e-06 sd=160n sca=12.1411 \
        scb=0.0106159 scc=0.000361907 m=(1)
mp50 (net326 \5\:qbint \15\:VDD NW) g45p1svt w=(3.1e-07) l=4.5e-08 nf=1 \
        as=6.82e-14 ad=4.805e-14 ps=1.06e-06 pd=9.3e-07 nrd=1.16667 \
        nrs=1.16667 sa=6.4e-07 sb=1.265e-06 sd=160n sca=12.1411 \
        scb=0.0106159 scc=0.000361907 m=(1)
mp51 (\4\:n30 \3\:CKbb net326 NW) g45p1svt w=(3.1e-07) l=4.5e-08 nf=1 \
        as=4.805e-14 ad=4.96e-14 ps=9.3e-07 pd=9.4e-07 nrd=1.16667 \
        nrs=1.16667 sa=8.4e-07 sb=1.065e-06 sd=160n sca=12.1411 \
        scb=0.0106159 scc=0.000361907 m=(1)
mp40 (\4\:n30 \3\:CKb \8\:mout NW) g45p1svt w=(3.1e-07) l=4.5e-08 nf=1 \
        as=7.13e-14 ad=4.96e-14 ps=1.08e-06 pd=9.4e-07 nrd=1.16667 \
        nrs=1.16667 sa=1.045e-06 sb=8.6e-07 sd=160n sca=12.1411 \
        scb=0.0106159 scc=0.000361907 m=(1)
mp30 (\8\:mout \3\:n20 \13\:VDD NW) g45p1svt w=(3.1e-07) l=4.5e-08 nf=1 \
        as=8.38e-14 ad=7.13e-14 ps=1.32e-06 pd=1.08e-06 nrd=1.16667 \
        nrs=1.16667 sa=1.32e-06 sb=5.85e-07 sd=160n sca=12.1411 \
        scb=0.0106159 scc=0.000361907 m=(1)
mp35 (\3\:net349 \2\:RN \13\:VDD NW) g45p1svt w=(3.1e-07) l=4.5e-08 nf=1 \
        as=8.38e-14 ad=4.96e-14 ps=1.32e-06 pd=9.4e-07 nrd=1.16667 \
        nrs=1.16667 sa=1.585e-06 sb=3.2e-07 sd=160n sca=12.1411 \
        scb=0.0106159 scc=0.000361907 m=(1)
mp36 (\3\:net349 mout \11\:VDD NW) g45p1svt w=(3.1e-07) l=4.5e-08 nf=1 \
        as=5.883e-14 ad=4.96e-14 ps=1.47e-06 pd=9.4e-07 nrd=1.16667 \
        nrs=1.16667 sa=1.79e-06 sb=1.15e-07 sd=160n sca=12.1411 \
        scb=0.0106159 scc=0.000361907 m=(1)
mp37 (\4\:n20 \5\:CKb net349 NW) g45p1svt w=(3.1e-07) l=4.5e-08 nf=1 \
        as=4.34e-14 ad=4.96e-14 ps=9e-07 pd=9.4e-07 nrd=1.16667 \
        nrs=1.16667 sa=1.4e-07 sb=3.45e-07 sd=160n sca=35.6995 \
        scb=0.0234062 scc=0.00420468 m=(1)
mp25 (\4\:n20 \7\:CKbb \6\:Db NW) g45p1svt w=(3.1e-07) l=4.5e-08 nf=1 \
        as=4.34e-14 ad=4.96e-14 ps=9e-07 pd=9.4e-07 nrd=1.16667 \
        nrs=1.16667 sa=3.45e-07 sb=1.4e-07 sd=160n sca=35.6995 \
        scb=0.0234062 scc=0.00420468 m=(1)
ends SDFFRHQX1
// End of subcircuit definition.
