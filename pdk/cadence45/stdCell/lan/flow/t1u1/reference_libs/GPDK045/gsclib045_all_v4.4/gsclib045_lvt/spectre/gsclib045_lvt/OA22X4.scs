// gsclib045_lvt/OA22X4/schematic

simulator lang=spectre

subckt OA22X4 A0 A1 B0 B1 Y VDD VSS
mp3 (net128 B1 net115 VDD) g45p1lvt w=(390n) l=45n nf=1 m=(1)
mp2 (net115 B0 VDD VDD) g45p1lvt w=(390n) l=45n nf=1 m=(1)
mp1 (net128 A1 net119 VDD) g45p1lvt w=(390n) l=45n nf=1 m=(1)
mp0 (net119 A0 VDD VDD) g45p1lvt w=(390n) l=45n nf=1 m=(1)
mp4 (Y net128 VDD VDD) g45p1lvt w=(1.56u) l=45n nf=1 m=(1)
mn3 (net128 B1 net124 VSS) g45n1lvt w=(260n) l=45n nf=1 m=(1)
mn2 (net128 B0 net124 VSS) g45n1lvt w=(260n) l=45n nf=1 m=(1)
mn1 (net124 A1 VSS VSS) g45n1lvt w=(260n) l=45n nf=1 m=(1)
mn0 (net124 A0 VSS VSS) g45n1lvt w=(260n) l=45n nf=1 m=(1)
mn4 (Y net128 VSS VSS) g45n1lvt w=(1.04u) l=45n nf=1 m=(1)
ends OA22X4
