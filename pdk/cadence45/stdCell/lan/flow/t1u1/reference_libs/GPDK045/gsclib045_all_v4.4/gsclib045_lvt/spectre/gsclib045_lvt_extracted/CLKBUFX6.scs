// Generated for: spectre (May  1 09:12:57 2013 )
// Library name: gsclib045_lvt
// Cell name: CLKBUFX6
// View name: extracted

simulator lang=spectre

subckt CLKBUFX6 A VDD VSS Y
mp1 (\1\:Y net44 \1\:VDD VDD) g45p1lvt w=(4.7e-07) l=4.5e-08 nf=1 \
        as=7.424e-14 ad=7.332e-14 ps=1.26e-06 pd=1.252e-06 nrd=1.16667 \
        nrs=1.16667 sa=1.4e-07 sb=1.2934e-06 sd=160n sca=40.6416 \
        scb=0.0369115 scc=0.00420297 m=(5)
C1 (VDD VSS) capacitor c=6.13466e-17
C2 (A VSS) capacitor c=3.86308e-17
C3 (Y VSS) capacitor c=1.29606e-17
C4 (net44 VSS) capacitor c=4.3084e-16
C5 (\1\:A VSS) capacitor c=1.43029e-16
C6 (\6\:A VSS) capacitor c=1.1125e-17
C7 (\1\:VDD VSS) capacitor c=3.24051e-16
C8 (\16\:net44 VSS) capacitor c=8.18986e-17
C9 (\1\:Y VSS) capacitor c=2.97765e-16
C10 (\21\:net44 VSS) capacitor c=3.06689e-17
C11 (\5\:Y VSS) capacitor c=2.31824e-16
C12 (\18\:net44 VSS) capacitor c=6.10909e-17
C13 (\9\:A VSS) capacitor c=7.38283e-17
Rk30 (\1\:VSS VSS) resistor r=0.1024 c=0
Rk22 (\1\:VDD VDD) resistor r=0.1024 c=0
Rk17 (A \9\:A) resistor r=0.03004 c=0
Rk3 (\1\:Y Y) resistor r=0.05801 c=0
Rk4 (Y \5\:Y) resistor r=0.1508 c=0
Rk12 (\18\:net44 net44) resistor r=0.5569 c=0
Rk11 (\17\:net44 \18\:net44) resistor r=0.2535 c=0
Rk14 (\18\:net44 \22\:net44) resistor r=0.1818 c=0
Rl18 (\1\:A \6\:A) resistor r=4.8851 c=0
Rz4 (\22\:net44 \21\:net44) resistor r=75 c=0
Ry4 (\17\:net44 \16\:net44) resistor r=20.6667 c=0
Rx3 (\9\:A \6\:A) resistor r=45 c=0
mn1 (\5\:Y net44 \1\:VSS VSS) g45n1lvt w=(3.1e-07) l=4.5e-08 nf=1 \
        as=4.9e-14 ad=4.836e-14 ps=9.4e-07 pd=9.32e-07 nrd=1.16667 \
        nrs=1.16667 sa=1.4e-07 sb=1.29742e-06 sd=160n sca=15.9751 \
        scb=0.0153507 scc=0.00137372 m=(5)
mn0 (\21\:net44 \1\:A \1\:VSS VSS) g45n1lvt w=(2.6e-07) l=4.5e-08 nf=1 \
        as=4.15e-14 ad=4.16e-14 ps=8.7e-07 pd=8.4e-07 nrd=1.16667 \
        nrs=1.16667 sa=1.165e-06 sb=3.45e-07 sd=160n sca=12.8392 \
        scb=0.0126987 scc=0.00074151 m=(2)
mp0 (\16\:net44 \1\:A \1\:VDD VDD) g45p1lvt w=(3.9e-07) l=4.5e-08 nf=1 \
        as=6.25e-14 ad=6.24e-14 ps=1.16e-06 pd=1.1e-06 nrd=1.16667 \
        nrs=1.16667 sa=1.165e-06 sb=3.45e-07 sd=160n sca=32.0467 \
        scb=0.0213026 scc=0.00336306 m=(2)
ends CLKBUFX6
// End of subcircuit definition.
