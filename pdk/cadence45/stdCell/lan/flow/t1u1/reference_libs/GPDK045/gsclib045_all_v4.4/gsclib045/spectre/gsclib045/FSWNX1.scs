// gsclib045/FSWNX1/schematic

simulator lang=spectre

subckt FSWNX1 PSOn PSOn_out VSS VDD ExtVSS
PM2 (pso PSOn VDD VDD) g45p1svt w=(390n) l=45n nf=1 m=(1)
PM1 (PSOn_out pso VDD VDD) g45p1svt w=(390n) l=45n nf=1 m=(1)
mp0 (n0 pso VDD VDD) g45p1svt w=(900n) l=45n nf=2 m=(1)
NM2 (ExtVSS PSOn pso ExtVSS) g45n1svt w=(260n) l=45n nf=1 m=(1)
NM0 (ExtVSS pso PSOn_out ExtVSS) g45n1svt w=(260n) l=45n nf=1 m=(1)
mn0 (ExtVSS pso n0 ExtVSS) g45n1svt w=(600n) l=45n nf=2 m=(1)
NM1 (ExtVSS n0 VSS ExtVSS) g45n1hvt w=(1.2u) l=45n nf=4 m=(20)
ends FSWNX1
