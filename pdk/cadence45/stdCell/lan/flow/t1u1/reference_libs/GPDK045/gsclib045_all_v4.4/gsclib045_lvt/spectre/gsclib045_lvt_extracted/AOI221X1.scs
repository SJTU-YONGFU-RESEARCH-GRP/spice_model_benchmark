// Generated for: spectre (May  1 09:11:52 2013 )
// Library name: gsclib045_lvt
// Cell name: AOI221X1
// View name: extracted

simulator lang=spectre

subckt AOI221X1 A0 A1 B0 B1 C0 VDD VSS Y
mp0 (\3\:net111 \3\:A0 \4\:VDD VDD) g45p1lvt w=(3.9e-07) l=4.5e-08 nf=1 \
        as=5.46e-14 ad=6.24e-14 ps=1.06e-06 pd=1.1e-06 nrd=1.16667 \
        nrs=1.16667 sa=1.4e-07 sb=3.05e-07 sd=160n sca=40.7758 \
        scb=0.038454 scc=0.00437052 m=(1)
mp1 (\3\:net111 \1\:A1 \6\:VDD VDD) g45p1lvt w=(3.9e-07) l=4.5e-08 nf=1 \
        as=7.265e-14 ad=6.24e-14 ps=1.78e-06 pd=1.1e-06 nrd=1.16667 \
        nrs=1.16667 sa=3.45e-07 sb=1e-07 sd=160n sca=30.7421 scb=0.0237813 \
        scc=0.0030059 m=(1)
mp3 (\3\:net108 \1\:B1 net111 VDD) g45p1lvt w=(3.9e-07) l=4.5e-08 nf=1 \
        as=6.24e-14 ad=5.46e-14 ps=1.1e-06 pd=1.06e-06 nrd=1.16667 \
        nrs=1.16667 sa=1.4e-07 sb=5.5e-07 sd=160n sca=28.7609 scb=0.020281 \
        scc=0.00296496 m=(1)
mp2 (net108 \1\:B0 net111 VDD) g45p1lvt w=(3.9e-07) l=4.5e-08 nf=1 \
        as=6.24e-14 ad=6.24e-14 ps=1.1e-06 pd=1.1e-06 nrd=1.16667 \
        nrs=1.16667 sa=3.45e-07 sb=3.45e-07 sd=160n sca=30.4607 \
        scb=0.0232925 scc=0.00299608 m=(1)
mp4 (\4\:Y \1\:C0 net108 VDD) g45p1lvt w=(3.9e-07) l=4.5e-08 nf=1 \
        as=6.24e-14 ad=5.46e-14 ps=1.1e-06 pd=1.06e-06 nrd=1.16667 \
        nrs=1.16667 sa=5.5e-07 sb=1.4e-07 sd=160n sca=39.2278 \
        scb=0.0367431 scc=0.00406631 m=(1)
C1 (A0 VSS) capacitor c=2.97989e-17
C2 (Y VSS) capacitor c=4.10303e-17
C3 (VDD VSS) capacitor c=6.17573e-17
C4 (net128 VSS) capacitor c=1.68696e-18
C5 (net120 VSS) capacitor c=3.08887e-18
C6 (net111 VSS) capacitor c=9.31927e-17
C7 (net108 VSS) capacitor c=7.03119e-17
C8 (\1\:C0 VSS) capacitor c=4.54404e-17
C9 (\1\:B0 VSS) capacitor c=4.8345e-17
C10 (\1\:B1 VSS) capacitor c=5.7665e-17
C11 (\1\:A1 VSS) capacitor c=5.57769e-17
C12 (\3\:A0 VSS) capacitor c=4.67489e-17
C13 (\3\:C0 VSS) capacitor c=3.885e-17
C14 (\3\:B0 VSS) capacitor c=7.0818e-17
C15 (\4\:B1 VSS) capacitor c=5.34304e-17
C16 (\3\:A1 VSS) capacitor c=4.52751e-17
C17 (\1\:A0 VSS) capacitor c=3.7681e-17
C18 (\2\:C0 VSS) capacitor c=3.62648e-17
C19 (\2\:B0 VSS) capacitor c=5.53929e-17
C20 (\3\:B1 VSS) capacitor c=4.9841e-17
C21 (\2\:A1 VSS) capacitor c=3.80539e-17
C22 (\2\:A0 VSS) capacitor c=3.89199e-17
C23 (\4\:Y VSS) capacitor c=2.65774e-17
C24 (\3\:net108 VSS) capacitor c=6.50594e-17
C25 (\6\:VDD VSS) capacitor c=1.18976e-17
C26 (\3\:net111 VSS) capacitor c=5.76187e-17
C27 (\4\:VDD VSS) capacitor c=3.57731e-17
C28 (\6\:Y VSS) capacitor c=2.70432e-17
C29 (\1\:Y VSS) capacitor c=7.52161e-17
C30 (\4\:A0 VSS) capacitor c=4.18223e-17
C31 (\4\:A1 VSS) capacitor c=6.18813e-17
C32 (\6\:B1 VSS) capacitor c=6.01841e-17
C33 (\7\:B1 VSS) capacitor c=4.1422e-17
C34 (\4\:B0 VSS) capacitor c=7.1584e-17
C35 (\6\:B0 VSS) capacitor c=3.2288e-17
C36 (\4\:C0 VSS) capacitor c=4.55041e-17
C37 (\6\:C0 VSS) capacitor c=3.83502e-17
C38 (\3\:Y VSS) capacitor c=8.01942e-17
C39 (\3\:VDD VSS) capacitor c=4.02359e-17
Rk11 (C0 \4\:C0) resistor r=0.002852 c=0
Rk13 (\4\:C0 \6\:C0) resistor r=0.007527 c=0
Rk12 (\5\:C0 \6\:C0) resistor r=0.002852 c=0
Rk2 (\4\:A1 A1) resistor r=0.03258 c=0
Rk7 (\4\:B0 \5\:B0) resistor r=0.001408 c=0
Rk8 (B0 \6\:B0) resistor r=0.001314 c=0
Rk9 (\4\:B0 \6\:B0) resistor r=0.04218 c=0
Rk1 (A0 \4\:A0) resistor r=0.07948 c=0
Rk15 (\3\:Y Y) resistor r=0.4127 c=0
Rk14 (\2\:Y \3\:Y) resistor r=0.4174 c=0
Rk16 (Y \5\:Y) resistor r=0.03477 c=0
Rk17 (\3\:Y \7\:Y) resistor r=0.08872 c=0
Rk23 (\3\:VDD VDD) resistor r=0.2204 c=0
Rk24 (VDD \5\:VDD) resistor r=0.3929 c=0
Rk25 (\3\:VDD \7\:VDD) resistor r=0.1563 c=0
Rk19 (\3\:VSS VSS) resistor r=0.01709 c=0
Rk18 (\2\:VSS \3\:VSS) resistor r=0.2127 c=0
Rk20 (\3\:VSS \5\:VSS) resistor r=0.283 c=0
Rk21 (\5\:VSS \7\:VSS) resistor r=0.3165 c=0
Rk3 (\5\:B1 \6\:B1) resistor r=0.001878 c=0
Rk4 (B1 \7\:B1) resistor r=0.001784 c=0
Rk5 (\5\:B1 \7\:B1) resistor r=0.1097 c=0
Rk6 (\2\:net111 \4\:net111) resistor r=0.4022 c=0
Rk10 (\2\:net108 \4\:net108) resistor r=0.3777 c=0
Rl10 (\1\:C0 \2\:C0) resistor r=79.0433 c=0
Rl11 (\2\:C0 \3\:C0) resistor r=60.989 c=0
Rl3 (\1\:A1 \2\:A1) resistor r=73.7687 c=0
Rl4 (\2\:A1 \3\:A1) resistor r=62.2302 c=0
Rl8 (\1\:B0 \2\:B0) resistor r=41.3798 c=0
Rl9 (\2\:B0 \3\:B0) resistor r=94.0258 c=0
Rl2 (\2\:A0 \3\:A0) resistor r=106.868 c=0
Rl1 (\1\:A0 \2\:A0) resistor r=30.7692 c=0
Rl5 (\1\:B1 \2\:B1) resistor r=91.1873 c=0
Rl7 (\2\:B1 \4\:B1) resistor r=60.4181 c=0
Rl6 (\2\:B1 \3\:B1) resistor r=0.6051 c=0
Rz1 (\1\:Y \2\:Y) resistor r=75 c=0
Rz2 (\6\:Y \7\:Y) resistor r=75 c=0
Rz3 (\1\:VSS \2\:VSS) resistor r=37.5 c=0
Rz4 (\6\:VSS \7\:VSS) resistor r=75 c=0
Ry5 (\4\:Y \5\:Y) resistor r=20.6667 c=0
Ry7 (\4\:VDD \5\:VDD) resistor r=20.6667 c=0
Ry8 (\6\:VDD \7\:VDD) resistor r=62 c=0
Ry1 (net111 \2\:net111) resistor r=62 c=0
Ry2 (\3\:net111 \4\:net111) resistor r=62 c=0
Ry3 (net108 \2\:net108) resistor r=31 c=0
Ry4 (\3\:net108 \4\:net108) resistor r=62 c=0
Rx5 (\2\:C0 \5\:C0) resistor r=45 c=0
Rx2 (\2\:A1 \4\:A1) resistor r=45 c=0
Rx4 (\2\:B0 \5\:B0) resistor r=45 c=0
Rx1 (\2\:A0 \4\:A0) resistor r=45 c=0
Rx3 (\3\:B1 \6\:B1) resistor r=45 c=0
mn0 (net128 \1\:A0 \1\:VSS VSS) g45n1lvt w=(2.6e-07) l=4.5e-08 nf=1 \
        as=4.55e-14 ad=2.34e-14 ps=8.7e-07 pd=7e-07 nrd=1.16667 \
        nrs=1.16667 sa=1.75e-07 sb=1.03e-06 sd=160n sca=7.84363 \
        scb=0.00546499 scc=9.84911e-05 m=(1)
mn1 (\1\:Y \3\:A1 net128 VSS) g45n1lvt w=(2.6e-07) l=4.5e-08 nf=1 \
        as=2.34e-14 ad=8.32e-14 ps=7e-07 pd=1.16e-06 nrd=1.16667 \
        nrs=1.16667 sa=3.1e-07 sb=8.95e-07 sd=160n sca=7.84363 \
        scb=0.00546499 scc=9.84911e-05 m=(1)
mn3 (\1\:Y \4\:B1 net120 VSS) g45n1lvt w=(2.6e-07) l=4.5e-08 nf=1 \
        as=1.82e-14 ad=8.32e-14 ps=6.6e-07 pd=1.16e-06 nrd=1.16667 \
        nrs=1.16667 sa=6.75e-07 sb=5.3e-07 sd=160n sca=7.84363 \
        scb=0.00546499 scc=9.84911e-05 m=(1)
mn2 (net120 \3\:B0 \6\:VSS VSS) g45n1lvt w=(2.6e-07) l=4.5e-08 nf=1 \
        as=4.16e-14 ad=1.82e-14 ps=8.4e-07 pd=6.6e-07 nrd=1.16667 \
        nrs=1.16667 sa=7.9e-07 sb=4.15e-07 sd=160n sca=7.84363 \
        scb=0.00546499 scc=9.84911e-05 m=(1)
mn4 (\6\:Y \3\:C0 \6\:VSS VSS) g45n1lvt w=(2.6e-07) l=4.5e-08 nf=1 \
        as=4.16e-14 ad=5.46e-14 ps=8.4e-07 pd=9.4e-07 nrd=1.16667 \
        nrs=1.16667 sa=9.95e-07 sb=2.1e-07 sd=160n sca=7.84363 \
        scb=0.00546499 scc=9.84911e-05 m=(1)
ends AOI221X1
// End of subcircuit definition.
