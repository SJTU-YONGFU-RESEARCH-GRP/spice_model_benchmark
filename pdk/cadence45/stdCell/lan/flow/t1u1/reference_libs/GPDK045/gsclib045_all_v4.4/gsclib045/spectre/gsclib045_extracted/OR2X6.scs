// Generated for: spectre (May  1 08:17:47 2013 )
// Library name: gsclib045
// Cell name: OR2X6
// View name: extracted

simulator lang=spectre

subckt OR2X6 A B VDD VSS Y
mp0_1__rcx (2 \1\:A \12\:VDD VDD) g45p1svt w=(3.9e-07) l=4.5e-08 nf=1 \
        as=5.46e-14 ad=3.51e-14 ps=1.06e-06 pd=9.6e-07 nrd=1.16667 \
        nrs=1.16667 sa=1.4e-07 sb=1.68e-06 sd=160n sca=18.0856 \
        scb=0.0187649 scc=0.00060075 m=(1)
mp1_1__rcx (\23\:n0 \5\:B 2 VDD) g45p1svt w=(3.9e-07) l=4.5e-08 nf=1 \
        as=3.51e-14 ad=6.24e-14 ps=9.6e-07 pd=1.1e-06 nrd=1.16667 \
        nrs=1.16667 sa=2.75e-07 sb=1.545e-06 sd=160n sca=15.1734 \
        scb=0.013698 scc=0.000458097 m=(1)
mp1 (\23\:n0 \1\:B 4 VDD) g45p1svt w=(3.9e-07) l=4.5e-08 nf=1 as=2.34e-14 \
        ad=6.24e-14 ps=9e-07 pd=1.1e-06 nrd=1.16667 nrs=1.16667 sa=4.8e-07 \
        sb=1.34e-06 sd=160n sca=13.4386 scb=0.0114697 scc=0.000444227 \
        m=(1)
mp0 (4 \6\:A \1\:VDD VDD) g45p1svt w=(3.9e-07) l=4.5e-08 nf=1 \
        as=9.77e-14 ad=2.34e-14 ps=1.4e-06 pd=9e-07 nrd=1.16667 \
        nrs=1.16667 sa=5.85e-07 sb=1.235e-06 sd=160n sca=12.9998 \
        scb=0.0111784 scc=0.000443945 m=(1)
C1 (A VSS) capacitor c=2.66716e-17
C2 (VDD VSS) capacitor c=1.1077e-16
C3 (Y VSS) capacitor c=2.24538e-17
C4 (B VSS) capacitor c=3.48008e-17
C5 (n0 VSS) capacitor c=4.29497e-16
C6 (2 VSS) capacitor c=1.21067e-18
C7 (4 VSS) capacitor c=1.33527e-18
C8 (\6\:A VSS) capacitor c=8.68457e-17
C9 (\1\:B VSS) capacitor c=7.70357e-17
C10 (\5\:B VSS) capacitor c=4.23577e-17
C11 (\1\:A VSS) capacitor c=5.95335e-17
C12 (\2\:B VSS) capacitor c=2.93177e-17
C13 (\2\:A VSS) capacitor c=3.59883e-16
C14 (\1\:Y VSS) capacitor c=2.88429e-16
C15 (\1\:VDD VSS) capacitor c=2.86926e-16
C16 (\23\:n0 VSS) capacitor c=9.37255e-17
C17 (\12\:VDD VSS) capacitor c=4.36101e-17
C18 (\3\:B VSS) capacitor c=9.77736e-17
C19 (\7\:B VSS) capacitor c=3.63971e-17
C20 (\19\:n0 VSS) capacitor c=1.21403e-16
C21 (\20\:n0 VSS) capacitor c=2.34948e-16
C22 (\4\:Y VSS) capacitor c=2.99725e-16
C23 (\7\:VDD VSS) capacitor c=1.5657e-17
Rk37 (VSS \15\:VSS) resistor r=0.3168 c=0
Rk3 (\2\:A A) resistor r=0.01427 c=0
Rk25 (\7\:VDD VDD) resistor r=0.06481 c=0
Rk24 (\1\:VDD \7\:VDD) resistor r=0.3259 c=0
Rk28 (\7\:VDD \13\:VDD) resistor r=0.3 c=0
Rk20 (\4\:Y Y) resistor r=0.06242 c=0
Rk11 (\1\:Y \4\:Y) resistor r=0.1348 c=0
Rk1 (B \7\:B) resistor r=0.04792 c=0
Rk5 (n0 \19\:n0) resistor r=0.2354 c=0
Rk6 (\19\:n0 \20\:n0) resistor r=0.3061 c=0
Rk8 (\19\:n0 \24\:n0) resistor r=0.6687 c=0
Rl9 (\2\:A \6\:A) resistor r=76.0989 c=0
Rl1 (\2\:A \1\:A) resistor r=86.5157 c=0
Rl3 (\2\:B \1\:B) resistor r=77.4283 c=0
Rl6 (\2\:B \5\:B) resistor r=21.9171 c=0
Rl4 (\3\:B \2\:B) resistor r=54.2909 c=0
Rz11 (\15\:VSS \14\:VSS) resistor r=37.5 c=0
Ry8 (\13\:VDD \12\:VDD) resistor r=20.6667 c=0
Ry1 (\24\:n0 \23\:n0) resistor r=31 c=0
Rx1 (\7\:B \2\:B) resistor r=45 c=0
mn1_1__rcx (\20\:n0 \3\:B \14\:VSS VSS) g45n1svt w=(2.6e-07) l=4.5e-08 \
        nf=1 as=4.16e-14 ad=4.355e-14 ps=8.4e-07 pd=8.55e-07 nrd=1.16667 \
        nrs=1.16667 sa=3.6e-07 sb=1.59e-06 sd=160n sca=12.8392 \
        scb=0.0126987 scc=0.00074151 m=(2)
mn0_1__rcx (\20\:n0 \2\:A VSS VSS) g45n1svt w=(2.6e-07) l=4.5e-08 nf=1 \
        as=4.345e-14 ad=4.355e-14 ps=8.85e-07 pd=8.55e-07 nrd=1.16667 \
        nrs=1.16667 sa=1.4e-07 sb=1.81e-06 sd=160n sca=12.8392 \
        scb=0.0126987 scc=0.00074151 m=(2)
mn2_1__rcx (\4\:Y n0 VSS VSS) g45n1svt w=(3.1e-07) l=4.5e-08 nf=1 \
        as=4.978e-14 ad=4.836e-14 ps=9.46e-07 pd=9.32e-07 nrd=1.16667 \
        nrs=1.16667 sa=8.46452e-07 sb=9.6e-07 sd=160n sca=15.9751 \
        scb=0.0153507 scc=0.00137372 m=(5)
mp2_1__rcx (\1\:Y n0 \1\:VDD VDD) g45p1svt w=(4.7e-07) l=4.5e-08 nf=1 \
        as=7.97e-14 ad=7.332e-14 ps=1.288e-06 pd=1.252e-06 nrd=1.16667 \
        nrs=1.16667 sa=7.30638e-07 sb=9.6e-07 sd=160n sca=16.497 \
        scb=0.0142421 scc=0.00124485 m=(5)
ends OR2X6
// End of subcircuit definition.
