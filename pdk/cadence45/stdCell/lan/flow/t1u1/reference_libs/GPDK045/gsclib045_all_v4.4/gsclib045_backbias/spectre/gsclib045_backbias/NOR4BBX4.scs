// gsclib045_backbias/NOR4BBX4/schematic

simulator lang=spectre

subckt NOR4BBX4 AN BN C D Y NW VSS VDD
mn2 (Y n0 VSS VSS) g45n1svt w=(1.04u) l=45n nf=1 m=(1)
mn1 (n1 BN VSS VSS) g45n1svt w=(260n) l=45n nf=1 m=(1)
mn3 (Y n1 VSS VSS) g45n1svt w=(1.04u) l=45n nf=1 m=(1)
mn5 (Y D VSS VSS) g45n1svt w=(1.04u) l=45n nf=1 m=(1)
mn4 (Y C VSS VSS) g45n1svt w=(1.04u) l=45n nf=1 m=(1)
mn0 (n0 AN VSS VSS) g45n1svt w=(260n) l=45n nf=1 m=(1)
mp0 (n0 AN VDD NW) g45p1svt w=(390n) l=45n nf=1 m=(1)
mp5 (Y D n4 NW) g45p1svt w=(1.56u) l=45n nf=1 m=(1)
mp4 (n4 C n3 NW) g45p1svt w=(1.56u) l=45n nf=1 m=(1)
mp1 (n1 BN VDD NW) g45p1svt w=(390n) l=45n nf=1 m=(1)
mp3 (n3 n1 n2 NW) g45p1svt w=(1.56u) l=45n nf=1 m=(1)
mp2 (n2 n0 VDD NW) g45p1svt w=(1.56u) l=45n nf=1 m=(1)
ends NOR4BBX4
