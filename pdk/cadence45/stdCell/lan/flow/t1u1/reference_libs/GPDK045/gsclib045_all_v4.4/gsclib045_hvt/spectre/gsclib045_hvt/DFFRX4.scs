// gsclib045_hvt/DFFRX4/schematic

simulator lang=spectre

subckt DFFRX4 CK D Q QN RN VDD VSS
mp26 (n20 CKbb n22 VDD) g45p1hvt w=(215n) l=45n nf=1 m=(1)
mp25 (n22 D VDD VDD) g45p1hvt w=(215n) l=45n nf=1 m=(1)
mp51 (n30 CKbb n41 VDD) g45p1hvt w=(215n) l=45n nf=1 m=(1)
mp50 (n41 qbint VDD VDD) g45p1hvt w=(215n) l=45n nf=1 m=(1)
mp57 (QN qint VDD VDD) g45p1hvt w=(1.56u) l=45n nf=1 m=(1)
mp55 (Q qbint VDD VDD) g45p1hvt w=(1.56u) l=45n nf=1 m=(1)
mp20 (CKb CK VDD VDD) g45p1hvt w=(215n) l=45n nf=1 m=(1)
mp21 (CKbb CKb VDD VDD) g45p1hvt w=(215n) l=45n nf=1 m=(1)
mp36 (n26 mout VDD VDD) g45p1hvt w=(215n) l=45n nf=1 m=(1)
mp30 (mout n20 VDD VDD) g45p1hvt w=(215n) l=45n nf=1 m=(1)
mp35 (n26 RN VDD VDD) g45p1hvt w=(215n) l=45n nf=1 m=(1)
mp37 (n20 CKb n26 VDD) g45p1hvt w=(215n) l=45n nf=1 m=(1)
mp46 (qbint n30 VDD VDD) g45p1hvt w=(620n) l=45n nf=1 m=(1)
mp40 (n30 CKb mout VDD) g45p1hvt w=(215n) l=45n nf=1 m=(1)
mp45 (qbint RN VDD VDD) g45p1hvt w=(620n) l=45n nf=1 m=(1)
mp56 (qint qbint VDD VDD) g45p1hvt w=(390n) l=45n nf=1 m=(1)
mn36 (n25 mout n27 VSS) g45n1hvt w=(145n) l=45n nf=1 m=(1)
mn35 (n27 RN VSS VSS) g45n1hvt w=(145n) l=45n nf=1 m=(1)
mn37 (n20 CKbb n25 VSS) g45n1hvt w=(145n) l=45n nf=1 m=(1)
mn26 (n20 CKb n21 VSS) g45n1hvt w=(145n) l=45n nf=1 m=(1)
mn25 (n21 D VSS VSS) g45n1hvt w=(145n) l=45n nf=1 m=(1)
mn57 (QN qint VSS VSS) g45n1hvt w=(1.04u) l=45n nf=1 m=(1)
mn55 (Q qbint VSS VSS) g45n1hvt w=(1.04u) l=45n nf=1 m=(1)
mn45 (n35 RN VSS VSS) g45n1hvt w=(410n) l=45n nf=1 m=(1)
mn46 (qbint n30 n35 VSS) g45n1hvt w=(410n) l=45n nf=1 m=(1)
mn51 (n30 CKb n40 VSS) g45n1hvt w=(145n) l=45n nf=1 m=(1)
mn50 (n40 qbint VSS VSS) g45n1hvt w=(145n) l=45n nf=1 m=(1)
mn21 (CKbb CKb VSS VSS) g45n1hvt w=(145n) l=45n nf=1 m=(1)
mn40 (n30 CKbb mout VSS) g45n1hvt w=(145n) l=45n nf=1 m=(1)
mn30 (mout n20 VSS VSS) g45n1hvt w=(145n) l=45n nf=1 m=(1)
mn56 (qint qbint VSS VSS) g45n1hvt w=(260n) l=45n nf=1 m=(1)
mn20 (CKb CK VSS VSS) g45n1hvt w=(145n) l=45n nf=1 m=(1)
ends DFFRX4
