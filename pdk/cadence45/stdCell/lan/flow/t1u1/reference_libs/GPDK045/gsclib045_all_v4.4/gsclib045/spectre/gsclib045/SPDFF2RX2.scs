// gsclib045/SPDFF2RX2/schematic

simulator lang=spectre

subckt SPDFF2RX2 CK D1 D2 Q1 Q1N Q2 Q2N RN SE SI1 SI2 VSS VDD
NM19 (Q2N qint_2 VSS VSS) g45n1svt w=(520n) l=45n nf=1 m=(1)
NM18 (qint_2 qbint_2 VSS VSS) g45n1svt w=(145n) l=45n nf=1 m=(1)
NM17 (Q2 qbint_2 VSS VSS) g45n1svt w=(520n) l=45n nf=1 m=(1)
NM16 (n30_2 CKb n11_2 VSS) g45n1svt w=(145n) l=45n nf=1 m=(1)
NM15 (n11_2 qbint_2 VSS VSS) g45n1svt w=(145n) l=45n nf=1 m=(1)
NM14 (n9_2 RN VSS VSS) g45n1svt w=(205n) l=45n nf=1 m=(1)
NM13 (qbint_2 n30_2 n9_2 VSS) g45n1svt w=(205n) l=45n nf=1 m=(1)
NM12 (mout_2 Ckbb n30_2 VSS) g45n1svt w=(145n) l=45n nf=1 m=(1)
NM11 (n5_2 mout_2 n7_2 VSS) g45n1svt w=(145n) l=45n nf=1 m=(1)
NM10 (n7_2 RN VSS VSS) g45n1svt w=(145n) l=45n nf=1 m=(1)
NM9 (n20_2 Ckbb n5_2 VSS) g45n1svt w=(145n) l=45n nf=1 m=(1)
NM8 (mout_2 n20_2 VSS VSS) g45n1svt w=(145n) l=45n nf=1 m=(1)
NM7 (Db_2 CKb n20_2 VSS) g45n1svt w=(145n) l=45n nf=1 m=(1)
NM4 (n3_2 SI2 VSS VSS) g45n1svt w=(145n) l=45n nf=1 m=(1)
NM3 (Db_2 SE n3_2 VSS) g45n1svt w=(145n) l=45n nf=1 m=(1)
NM2 (Db_2 SEb_2 n1_2 VSS) g45n1svt w=(145n) l=45n nf=1 m=(1)
NM1 (n1_2 D2 VSS VSS) g45n1svt w=(145n) l=45n nf=1 m=(1)
NM0 (SEb_2 SE VSS VSS) g45n1svt w=(145n) l=45n nf=1 m=(1)
mn36 (n5 mout n7 VSS) g45n1svt w=(145n) l=45n nf=1 m=(1)
mn35 (n7 RN VSS VSS) g45n1svt w=(145n) l=45n nf=1 m=(1)
mn37 (n20 Ckbb n5 VSS) g45n1svt w=(145n) l=45n nf=1 m=(1)
mn13 (n3 SI1 VSS VSS) g45n1svt w=(145n) l=45n nf=1 m=(1)
mn14 (Db SE n3 VSS) g45n1svt w=(145n) l=45n nf=1 m=(1)
mn12 (Db SEb n1 VSS) g45n1svt w=(145n) l=45n nf=1 m=(1)
mn11 (n1 D1 VSS VSS) g45n1svt w=(145n) l=45n nf=1 m=(1)
mn57 (Q1N qint VSS VSS) g45n1svt w=(520n) l=45n nf=1 m=(1)
mn55 (Q1 qbint VSS VSS) g45n1svt w=(520n) l=45n nf=1 m=(1)
mn45 (n9 RN VSS VSS) g45n1svt w=(205n) l=45n nf=1 m=(1)
mn46 (qbint n30 n9 VSS) g45n1svt w=(205n) l=45n nf=1 m=(1)
mn51 (n30 CKb n11 VSS) g45n1svt w=(145n) l=45n nf=1 m=(1)
mn50 (n11 qbint VSS VSS) g45n1svt w=(145n) l=45n nf=1 m=(1)
mn20 (CKb CK VSS VSS) g45n1svt w=(145n) l=45n nf=1 m=(1)
mn56 (qint qbint VSS VSS) g45n1svt w=(145n) l=45n nf=1 m=(1)
mn40 (mout Ckbb n30 VSS) g45n1svt w=(145n) l=45n nf=1 m=(1)
mn30 (mout n20 VSS VSS) g45n1svt w=(145n) l=45n nf=1 m=(1)
mn21 (Ckbb CKb VSS VSS) g45n1svt w=(145n) l=45n nf=1 m=(1)
mn10 (SEb SE VSS VSS) g45n1svt w=(145n) l=45n nf=1 m=(1)
mn25 (Db CKb n20 VSS) g45n1svt w=(145n) l=45n nf=1 m=(1)
PM19 (Q2N qint_2 VDD VDD) g45p1svt w=(780n) l=45n nf=1 m=(1)
PM18 (qint_2 qbint_2 VDD VDD) g45p1svt w=(215n) l=45n nf=1 m=(1)
PM17 (Q2 qbint_2 VDD VDD) g45p1svt w=(780n) l=45n nf=1 m=(1)
PM16 (n30_2 Ckbb n8_2 VDD) g45p1svt w=(215n) l=45n nf=1 m=(1)
PM15 (n8_2 qbint_2 VDD VDD) g45p1svt w=(215n) l=45n nf=1 m=(1)
PM14 (qbint_2 n30_2 VDD VDD) g45p1svt w=(310n) l=45n nf=1 m=(1)
PM13 (qbint_2 RN VDD VDD) g45p1svt w=(310n) l=45n nf=1 m=(1)
PM12 (n30_2 CKb mout_2 VDD) g45p1svt w=(215n) l=45n nf=1 m=(1)
PM11 (n6_2 mout_2 VDD VDD) g45p1svt w=(215n) l=45n nf=1 m=(1)
PM10 (n20_2 CKb n6_2 VDD) g45p1svt w=(215n) l=45n nf=1 m=(1)
PM9 (n6_2 RN VDD VDD) g45p1svt w=(215n) l=45n nf=1 m=(1)
PM8 (mout_2 n20_2 VDD VDD) g45p1svt w=(215n) l=45n nf=1 m=(1)
PM7 (n20_2 Ckbb Db_2 VDD) g45p1svt w=(215n) l=45n nf=1 m=(1)
PM4 (Db_2 SEb_2 n4_2 VDD) g45p1svt w=(215n) l=45n nf=1 m=(1)
PM3 (n4_2 SI2 VDD VDD) g45p1svt w=(215n) l=45n nf=1 m=(1)
PM2 (Db_2 SE n2_2 VDD) g45p1svt w=(215n) l=45n nf=1 m=(1)
PM1 (n2_2 D2 VDD VDD) g45p1svt w=(215n) l=45n nf=1 m=(1)
PM0 (SEb_2 SE VDD VDD) g45p1svt w=(215n) l=45n nf=1 m=(1)
mp14 (Db SEb n4 VDD) g45p1svt w=(215n) l=45n nf=1 m=(1)
mp13 (n4 SI1 VDD VDD) g45p1svt w=(215n) l=45n nf=1 m=(1)
mp12 (Db SE n2 VDD) g45p1svt w=(215n) l=45n nf=1 m=(1)
mp11 (n2 D1 VDD VDD) g45p1svt w=(215n) l=45n nf=1 m=(1)
mp51 (n30 Ckbb n8 VDD) g45p1svt w=(215n) l=45n nf=1 m=(1)
mp50 (n8 qbint VDD VDD) g45p1svt w=(215n) l=45n nf=1 m=(1)
mp55 (Q1 qbint VDD VDD) g45p1svt w=(780n) l=45n nf=1 m=(1)
mp20 (CKb CK VDD VDD) g45p1svt w=(215n) l=45n nf=1 m=(1)
mp46 (qbint n30 VDD VDD) g45p1svt w=(310n) l=45n nf=1 m=(1)
mp56 (qint qbint VDD VDD) g45p1svt w=(215n) l=45n nf=1 m=(1)
mp45 (qbint RN VDD VDD) g45p1svt w=(310n) l=45n nf=1 m=(1)
mp35 (n6 RN VDD VDD) g45p1svt w=(215n) l=45n nf=1 m=(1)
mp36 (n6 mout VDD VDD) g45p1svt w=(215n) l=45n nf=1 m=(1)
mp37 (n20 CKb n6 VDD) g45p1svt w=(215n) l=45n nf=1 m=(1)
mp40 (n30 CKb mout VDD) g45p1svt w=(215n) l=45n nf=1 m=(1)
mp30 (mout n20 VDD VDD) g45p1svt w=(215n) l=45n nf=1 m=(1)
mp21 (Ckbb CKb VDD VDD) g45p1svt w=(215n) l=45n nf=1 m=(1)
mp25 (n20 Ckbb Db VDD) g45p1svt w=(215n) l=45n nf=1 m=(1)
mp10 (SEb SE VDD VDD) g45p1svt w=(215n) l=45n nf=1 m=(1)
mp57 (Q1N qint VDD VDD) g45p1svt w=(780n) l=45n nf=1 m=(1)
ends SPDFF2RX2
