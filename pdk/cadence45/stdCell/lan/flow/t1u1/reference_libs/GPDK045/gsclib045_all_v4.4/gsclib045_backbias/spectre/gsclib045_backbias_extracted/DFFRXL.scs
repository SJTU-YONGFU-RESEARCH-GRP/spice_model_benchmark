// Generated for: spectre (May  1 11:28:53 2013 )
// Library name: gsclib045_backbias
// Cell name: DFFRXL
// View name: extracted

simulator lang=spectre

subckt DFFRXL CK D NW Q QN RN VDD VSS
mp57 (\1\:QN \4\:qint \19\:VDD NW) g45p1svt w=(2.15e-07) l=4.5e-08 nf=1 \
        as=5.73e-14 ad=3.548e-14 ps=1.47e-06 pd=7.6e-07 nrd=1.16667 \
        nrs=1.16667 sa=1.65e-07 sb=3.27326e-07 sd=160n sca=49.8399 \
        scb=0.0334143 scc=0.00594375 m=(1)
mp56 (\5\:qint \7\:qbint \19\:VDD NW) g45p1svt w=(2.15e-07) l=4.5e-08 \
        nf=1 as=5.73e-14 ad=2.63e-14 ps=1.47e-06 pd=7.1e-07 nrd=1.16667 \
        nrs=1.16667 sa=3.7e-07 sb=1.22326e-07 sd=160n sca=47.1852 \
        scb=0.0292558 scc=0.00588561 m=(1)
mp55 (\4\:Q \6\:qbint \17\:VDD NW) g45p1svt w=(2.15e-07) l=4.5e-08 nf=1 \
        as=9.77e-14 ad=2.63e-14 ps=2.03e-06 pd=7.1e-07 nrd=1.16667 \
        nrs=1.16667 sa=1.22326e-07 sb=5.25e-07 sd=160n sca=17.4239 \
        scb=0.0172882 scc=0.00131682 m=(1)
mp20 (\13\:CKb \1\:CK \17\:VDD NW) g45p1svt w=(2.15e-07) l=4.5e-08 nf=1 \
        as=9.77e-14 ad=3.44e-14 ps=2.03e-06 pd=7.5e-07 nrd=1.16667 \
        nrs=1.16667 sa=4.87326e-07 sb=1.6e-07 sd=160n sca=17.4145 \
        scb=0.0172865 scc=0.00131682 m=(1)
mp46 (\12\:qbint \3\:n30 \15\:VDD NW) g45p1svt w=(2.15e-07) l=4.5e-08 \
        nf=1 as=5.19e-14 ad=3.44e-14 ps=1.65e-06 pd=7.5e-07 nrd=1.16667 \
        nrs=1.16667 sa=1e-07 sb=1.88e-06 sd=160n sca=21.1782 scb=0.0203295 \
        scc=0.00208843 m=(1)
mp45 (\12\:qbint \3\:RN \13\:VDD NW) g45p1svt w=(2.15e-07) l=4.5e-08 \
        nf=1 as=6.265e-14 ad=3.44e-14 ps=1.75e-06 pd=7.5e-07 nrd=1.16667 \
        nrs=1.16667 sa=3.05e-07 sb=1.675e-06 sd=160n sca=21.1782 \
        scb=0.0203295 scc=0.00208843 m=(1)
mp50 (n41 \10\:qbint \13\:VDD NW) g45p1svt w=(2.15e-07) l=4.5e-08 nf=1 \
        as=6.265e-14 ad=3.44e-14 ps=1.75e-06 pd=7.5e-07 nrd=1.16667 \
        nrs=1.16667 sa=5e-07 sb=1.48e-06 sd=160n sca=21.1782 scb=0.0203295 \
        scc=0.00208843 m=(1)
mp51 (\8\:n30 \2\:CKbb n41 NW) g45p1svt w=(2.15e-07) l=4.5e-08 nf=1 \
        as=3.44e-14 ad=3.44e-14 ps=7.5e-07 pd=7.5e-07 nrd=1.16667 \
        nrs=1.16667 sa=7.05e-07 sb=1.275e-06 sd=160n sca=21.1782 \
        scb=0.0203295 scc=0.00208843 m=(1)
mp40 (\8\:n30 \4\:CKb \6\:mout NW) g45p1svt w=(2.15e-07) l=4.5e-08 nf=1 \
        as=8.815e-14 ad=3.44e-14 ps=1.25e-06 pd=7.5e-07 nrd=1.16667 \
        nrs=1.16667 sa=9.1e-07 sb=1.07e-06 sd=160n sca=21.1782 \
        scb=0.0203295 scc=0.00208843 m=(1)
mp30 (\6\:mout \4\:n20 \11\:VDD NW) g45p1svt w=(2.15e-07) l=4.5e-08 nf=1 \
        as=1.001e-13 ad=8.815e-14 ps=1.75e-06 pd=1.25e-06 nrd=1.16667 \
        nrs=1.16667 sa=1.365e-06 sb=6.15e-07 sd=160n sca=21.1782 \
        scb=0.0203295 scc=0.00208843 m=(1)
mp35 (n26 \6\:RN \11\:VDD NW) g45p1svt w=(2.15e-07) l=4.5e-08 nf=1 \
        as=1.001e-13 ad=4.408e-14 ps=1.75e-06 pd=8.4e-07 nrd=1.16667 \
        nrs=1.16667 sa=1.63e-06 sb=3.5e-07 sd=160n sca=21.1782 \
        scb=0.0203295 scc=0.00208843 m=(1)
mp36 (n26 mout \9\:VDD NW) g45p1svt w=(2.15e-07) l=4.5e-08 nf=1 \
        as=6.33e-14 ad=4.407e-14 ps=1.84e-06 pd=8.4e-07 nrd=1.16667 \
        nrs=1.16667 sa=1.88e-06 sb=1e-07 sd=160n sca=21.1782 scb=0.0203295 \
        scc=0.00208843 m=(1)
mp37 (\8\:n20 \5\:CKb \3\:n26 NW) g45p1svt w=(2.15e-07) l=4.5e-08 nf=1 \
        as=3.01e-14 ad=4.515e-14 ps=7.1e-07 pd=8.5e-07 nrd=1.16667 \
        nrs=1.16667 sa=1.4e-07 sb=6.69651e-07 sd=160n sca=12.8114 \
        scb=0.0117123 scc=0.000425192 m=(1)
mp26 (\8\:n20 \7\:CKbb n22 NW) g45p1svt w=(2.15e-07) l=4.5e-08 nf=1 \
        as=3.117e-14 ad=4.515e-14 ps=7.2e-07 pd=8.5e-07 nrd=1.16667 \
        nrs=1.16667 sa=3.95e-07 sb=4.14651e-07 sd=160n sca=13.6979 \
        scb=0.0122064 scc=0.000425621 m=(1)
mp25 (n22 \1\:D \1\:VDD NW) g45p1svt w=(2.15e-07) l=4.5e-08 nf=1 \
        as=9.635e-14 ad=3.117e-14 ps=1.88e-06 pd=7.2e-07 nrd=1.16667 \
        nrs=1.16667 sa=5.85e-07 sb=2.24651e-07 sd=160n sca=15.3538 \
        scb=0.0143677 scc=0.000439386 m=(1)
mp21 (\15\:CKbb \9\:CKb \1\:VDD NW) g45p1svt w=(2.15e-07) l=4.5e-08 nf=1 \
        as=9.635e-14 ad=3.01e-14 ps=1.88e-06 pd=7.1e-07 nrd=1.16667 \
        nrs=1.16667 sa=2.74419e-07 sb=1.4e-07 sd=160n sca=53.5485 \
        scb=0.0463759 scc=0.00660315 m=(1)
C1 (NW VSS) capacitor c=6.89868e-16
C2 (D VSS) capacitor c=3.82572e-17
C3 (Q VSS) capacitor c=1.50252e-17
C4 (RN VSS) capacitor c=8.58391e-17
C5 (QN VSS) capacitor c=2.14014e-17
C6 (VDD VSS) capacitor c=4.16719e-17
C7 (CK VSS) capacitor c=3.08568e-17
C8 (qint VSS) capacitor c=2.14096e-17
C9 (qbint VSS) capacitor c=2.42826e-17
C10 (CKb VSS) capacitor c=2.84994e-17
C11 (n30 VSS) capacitor c=3.09923e-17
C12 (n40 VSS) capacitor c=4.97174e-18
C13 (mout VSS) capacitor c=5.02305e-17
C14 (CKbb VSS) capacitor c=5.10878e-17
C15 (n20 VSS) capacitor c=1.86289e-17
C16 (n21 VSS) capacitor c=1.3336e-18
C17 (n41 VSS) capacitor c=1.57584e-18
C18 (n26 VSS) capacitor c=5.96217e-17
C19 (n22 VSS) capacitor c=8.99794e-19
C20 (\9\:CKb VSS) capacitor c=3.45771e-17
C21 (\1\:D VSS) capacitor c=5.63406e-17
C22 (\7\:CKbb VSS) capacitor c=4.48651e-17
C23 (\5\:CKb VSS) capacitor c=4.63289e-17
C24 (\6\:RN VSS) capacitor c=6.24375e-17
C25 (\4\:n20 VSS) capacitor c=3.86933e-17
C26 (\4\:CKb VSS) capacitor c=2.96683e-17
C27 (\2\:CKbb VSS) capacitor c=4.92606e-17
C28 (\10\:qbint VSS) capacitor c=4.78737e-17
C29 (\3\:RN VSS) capacitor c=4.35281e-17
C30 (\3\:n30 VSS) capacitor c=5.05776e-17
C31 (\1\:CK VSS) capacitor c=2.79303e-17
C32 (\6\:qbint VSS) capacitor c=3.41113e-17
C33 (\7\:qbint VSS) capacitor c=3.50752e-17
C34 (\4\:qint VSS) capacitor c=3.7074e-17
C35 (\8\:CKb VSS) capacitor c=4.75866e-17
C36 (\3\:D VSS) capacitor c=3.04717e-17
C37 (\7\:CKb VSS) capacitor c=5.34228e-17
C38 (\5\:CKbb VSS) capacitor c=6.74515e-17
C39 (\3\:mout VSS) capacitor c=5.6898e-17
C40 (\5\:RN VSS) capacitor c=8.76577e-17
C41 (\3\:n20 VSS) capacitor c=3.69929e-17
C42 (\3\:CKbb VSS) capacitor c=3.68681e-17
C43 (\3\:CKb VSS) capacitor c=6.19582e-17
C44 (\8\:qbint VSS) capacitor c=5.42973e-17
C45 (\1\:RN VSS) capacitor c=5.02095e-17
C46 (\3\:CK VSS) capacitor c=4.20444e-17
C47 (\5\:qbint VSS) capacitor c=2.10229e-17
C48 (\3\:qint VSS) capacitor c=2.7225e-17
C49 (\10\:CKb VSS) capacitor c=1.5566e-17
C50 (\2\:D VSS) capacitor c=4.75488e-17
C51 (\8\:CKbb VSS) capacitor c=3.07078e-17
C52 (\6\:CKb VSS) capacitor c=1.74097e-17
C53 (\6\:CKbb VSS) capacitor c=3.31662e-17
C54 (\2\:mout VSS) capacitor c=5.71724e-17
C55 (\7\:RN VSS) capacitor c=2.5335e-17
C56 (\4\:CKbb VSS) capacitor c=4.30823e-17
C57 (\9\:qbint VSS) capacitor c=4.28396e-17
C58 (\4\:RN VSS) capacitor c=2.62146e-17
C59 (\2\:RN VSS) capacitor c=5.65253e-17
C60 (\2\:n30 VSS) capacitor c=4.55308e-17
C61 (\2\:CK VSS) capacitor c=2.67834e-17
C62 (\2\:qbint VSS) capacitor c=1.52563e-17
C63 (\15\:CKbb VSS) capacitor c=9.40398e-18
C64 (\1\:VDD VSS) capacitor c=1.13495e-16
C65 (\8\:n20 VSS) capacitor c=6.87123e-17
C66 (\3\:n26 VSS) capacitor c=6.68717e-17
C67 (\9\:VDD VSS) capacitor c=1.63641e-17
C68 (\11\:VDD VSS) capacitor c=2.58768e-17
C69 (\6\:mout VSS) capacitor c=5.55371e-17
C70 (\8\:n30 VSS) capacitor c=7.59755e-17
C71 (\13\:VDD VSS) capacitor c=2.6828e-17
C72 (\12\:qbint VSS) capacitor c=1.66667e-16
C73 (\15\:VDD VSS) capacitor c=9.04633e-18
C74 (\13\:CKb VSS) capacitor c=2.08639e-16
C75 (\17\:VDD VSS) capacitor c=4.42262e-18
C76 (\4\:Q VSS) capacitor c=1.30203e-17
C77 (\5\:qint VSS) capacitor c=3.01215e-17
C78 (\19\:VDD VSS) capacitor c=1.45828e-17
C79 (\1\:QN VSS) capacitor c=1.57166e-17
C80 (\9\:CKbb VSS) capacitor c=3.67977e-17
C81 (\5\:n20 VSS) capacitor c=3.96239e-17
C82 (\8\:mout VSS) capacitor c=4.06471e-17
C83 (\4\:n30 VSS) capacitor c=4.46828e-17
C84 (\14\:qbint VSS) capacitor c=1.72531e-16
C85 (\11\:CKb VSS) capacitor c=8.34076e-17
C86 (\1\:Q VSS) capacitor c=8.68144e-17
C87 (\9\:qint VSS) capacitor c=4.07156e-17
C88 (\3\:QN VSS) capacitor c=4.14431e-17
C89 (\2\:qint VSS) capacitor c=1.33022e-17
C90 (\3\:qbint VSS) capacitor c=1.92875e-17
C91 (\4\:qbint VSS) capacitor c=3.68412e-17
C92 (\2\:CKb VSS) capacitor c=3.76958e-17
C93 (\2\:n20 VSS) capacitor c=2.55193e-17
C94 (\7\:qint VSS) capacitor c=3.26977e-17
C95 (\8\:qint VSS) capacitor c=3.39278e-17
C96 (\3\:Q VSS) capacitor c=5.66282e-17
C97 (\4\:CK VSS) capacitor c=8.18776e-17
C98 (\10\:RN VSS) capacitor c=5.66272e-17
C99 (\11\:qbint VSS) capacitor c=6.71849e-17
C100 (\16\:qbint VSS) capacitor c=1.23577e-16
C101 (\6\:n30 VSS) capacitor c=9.59129e-17
C102 (\7\:n30 VSS) capacitor c=5.61701e-17
C103 (\11\:RN VSS) capacitor c=1.63804e-16
C104 (\12\:RN VSS) capacitor c=1.66635e-16
C105 (\4\:mout VSS) capacitor c=7.766e-17
C106 (\5\:mout VSS) capacitor c=9.0548e-17
C107 (\7\:n20 VSS) capacitor c=1.16204e-16
C108 (\10\:n20 VSS) capacitor c=8.6783e-17
C109 (\4\:D VSS) capacitor c=6.32096e-17
C110 (\15\:CKb VSS) capacitor c=2.40526e-16
C111 (\16\:CKb VSS) capacitor c=6.31145e-17
C112 (\17\:CKb VSS) capacitor c=1.98984e-16
C113 (\18\:CKb VSS) capacitor c=7.38677e-17
C114 (\11\:CKbb VSS) capacitor c=6.0344e-17
C115 (\12\:CKbb VSS) capacitor c=1.34874e-16
C116 (\13\:CKbb VSS) capacitor c=1.84071e-16
C117 (\14\:CKbb VSS) capacitor c=1.25617e-16
C118 (\17\:CKbb VSS) capacitor c=5.81967e-17
C119 (\3\:VDD VSS) capacitor c=7.58909e-17
C120 (\4\:VDD VSS) capacitor c=7.47886e-17
C121 (\5\:VDD VSS) capacitor c=7.95749e-17
C122 (\6\:VDD VSS) capacitor c=5.19564e-17
C123 (\7\:VDD VSS) capacitor c=6.03563e-17
C124 (\8\:VDD VSS) capacitor c=4.33354e-17
Rk27 (D \4\:D) resistor r=0.01152 c=0
Rk8 (\3\:Q Q) resistor r=0.007742 c=0
Rk6 (\2\:Q \3\:Q) resistor r=0.4793 c=0
Rk7 (\3\:Q \5\:Q) resistor r=0.09901 c=0
Rk10 (\8\:RN RN) resistor r=0.008949 c=0
Rk12 (\8\:RN \10\:RN) resistor r=0.04354 c=0
Rk11 (\9\:RN \10\:RN) resistor r=0.008949 c=0
Rk19 (\11\:RN \12\:RN) resistor r=1.0469 c=0
Rk52 (\2\:VSS \3\:VSS) resistor r=0.1879 c=0
Rk53 (\3\:VSS \4\:VSS) resistor r=0.4638 c=0
Rk54 (\4\:VSS \5\:VSS) resistor r=0.06501 c=0
Rk55 (\5\:VSS \6\:VSS) resistor r=0.6341 c=0
Rk56 (\6\:VSS \7\:VSS) resistor r=0.5039 c=0
Rk57 (\3\:VSS \9\:VSS) resistor r=0.3187 c=0
Rk58 (\5\:VSS \11\:VSS) resistor r=0.1227 c=0
Rk59 (\6\:VSS \13\:VSS) resistor r=0.2443 c=0
Rk61 (\14\:VSS VSS) resistor r=0.1952 c=0
Rk60 (\7\:VSS \14\:VSS) resistor r=0.3565 c=0
Rk62 (\7\:VSS \16\:VSS) resistor r=0.3778 c=0
Rk63 (\14\:VSS \18\:VSS) resistor r=0.3692 c=0
Rk2 (\4\:QN QN) resistor r=0.07594 c=0
Rk1 (\2\:QN \4\:QN) resistor r=0.2248 c=0
Rk39 (\2\:VDD \3\:VDD) resistor r=0.5861 c=0
Rk40 (\3\:VDD \4\:VDD) resistor r=0.1742 c=0
Rk41 (\4\:VDD \5\:VDD) resistor r=0.5294 c=0
Rk42 (\5\:VDD \6\:VDD) resistor r=0.1993 c=0
Rk43 (\6\:VDD \7\:VDD) resistor r=0.3733 c=0
Rk45 (\8\:VDD VDD) resistor r=0.2102 c=0
Rk44 (\7\:VDD \8\:VDD) resistor r=0.2855 c=0
Rk46 (\3\:VDD \10\:VDD) resistor r=0.07393 c=0
Rk47 (\4\:VDD \12\:VDD) resistor r=0.04331 c=0
Rk48 (\5\:VDD \14\:VDD) resistor r=0.04331 c=0
Rk49 (\6\:VDD \16\:VDD) resistor r=0.07393 c=0
Rk50 (\7\:VDD \18\:VDD) resistor r=0.07393 c=0
Rk51 (\8\:VDD \20\:VDD) resistor r=0.2243 c=0
Rk9 (CK \4\:CK) resistor r=0.01694 c=0
Rk3 (\6\:qint \7\:qint) resistor r=0.1148 c=0
Rk4 (\7\:qint \8\:qint) resistor r=0.1194 c=0
Rk5 (\7\:qint \10\:qint) resistor r=0.1088 c=0
Rk13 (\11\:qbint \13\:qbint) resistor r=0.3623 c=0
Rk14 (\13\:qbint \15\:qbint) resistor r=0.876 c=0
Rk15 (\15\:qbint \16\:qbint) resistor r=0.9598 c=0
Rk28 (\12\:CKb \14\:CKb) resistor r=0.4396 c=0
Rk29 (\14\:CKb \15\:CKb) resistor r=1.0766 c=0
Rk30 (\15\:CKb \16\:CKb) resistor r=0.2453 c=0
Rk31 (\15\:CKb \17\:CKb) resistor r=1.0026 c=0
Rk32 (\17\:CKb \18\:CKb) resistor r=0.6634 c=0
Rk16 (\5\:n30 \6\:n30) resistor r=0.2473 c=0
Rk17 (\6\:n30 \7\:n30) resistor r=0.3312 c=0
Rk18 (\6\:n30 \9\:n30) resistor r=0.4824 c=0
Rk20 (\4\:mout \5\:mout) resistor r=0.4552 c=0
Rk21 (\5\:mout \7\:mout) resistor r=0.2707 c=0
Rk22 (\5\:mout \9\:mout) resistor r=0.08541 c=0
Rk33 (\10\:CKbb \11\:CKbb) resistor r=0.2997 c=0
Rk34 (\11\:CKbb \12\:CKbb) resistor r=0.3619 c=0
Rk35 (\12\:CKbb \13\:CKbb) resistor r=0.7921 c=0
Rk36 (\13\:CKbb \14\:CKbb) resistor r=0.9969 c=0
Rk37 (\11\:CKbb \16\:CKbb) resistor r=0.09567 c=0
Rk38 (\14\:CKbb \17\:CKbb) resistor r=0.2851 c=0
Rk24 (\6\:n20 \7\:n20) resistor r=0.2028 c=0
Rk25 (\7\:n20 \9\:n20) resistor r=0.3899 c=0
Rk26 (\7\:n20 \10\:n20) resistor r=0.5688 c=0
Rk23 (\2\:n26 \4\:n26) resistor r=0.2431 c=0
Rl35 (\1\:D \2\:D) resistor r=128.079 c=0
Rl36 (\2\:D \3\:D) resistor r=65.924 c=0
Rl27 (\5\:RN \6\:RN) resistor r=189.95 c=0
Rl28 (\6\:RN \7\:RN) resistor r=71.8456 c=0
Rl16 (\3\:RN \4\:RN) resistor r=71.8456 c=0
Rl15 (\2\:RN \3\:RN) resistor r=68.4636 c=0
Rl14 (\1\:RN \2\:RN) resistor r=93.4636 c=0
Rl10 (\1\:CK \2\:CK) resistor r=30.0021 c=0
Rl11 (\2\:CK \3\:CK) resistor r=74.2328 c=0
Rl3 (\2\:qint \4\:qint) resistor r=47.791 c=0
Rl2 (\2\:qint \3\:qint) resistor r=36.2526 c=0
Rl1 (qint \2\:qint) resistor r=2.0213 c=0
Rl18 (\9\:qbint \10\:qbint) resistor r=24.2328 c=0
Rl17 (\8\:qbint \9\:qbint) resistor r=101.008 c=0
Rl4 (qbint \2\:qbint) resistor r=29.0109 c=0
Rl8 (\3\:qbint \6\:qbint) resistor r=95.8353 c=0
Rl5 (\2\:qbint \3\:qbint) resistor r=23.8124 c=0
Rl9 (\4\:qbint \7\:qbint) resistor r=60.772 c=0
Rl7 (\4\:qbint \5\:qbint) resistor r=28.0797 c=0
Rl6 (\3\:qbint \4\:qbint) resistor r=131.607 c=0
Rl37 (\8\:CKb \9\:CKb) resistor r=153.412 c=0
Rl33 (\5\:CKb \7\:CKb) resistor r=190.385 c=0
Rl38 (\9\:CKb \10\:CKb) resistor r=24.2328 c=0
Rl32 (\5\:CKb \6\:CKb) resistor r=24.2328 c=0
Rl23 (\2\:CKb \4\:CKb) resistor r=35.772 c=0
Rl22 (\2\:CKb \3\:CKb) resistor r=146.876 c=0
Rl21 (CKb \2\:CKb) resistor r=32.3537 c=0
Rl13 (\2\:n30 \3\:n30) resistor r=135.714 c=0
Rl12 (n30 \2\:n30) resistor r=30.7692 c=0
Rl29 (mout \2\:mout) resistor r=99.2328 c=0
Rl30 (\2\:mout \3\:mout) resistor r=24.2328 c=0
Rl34 (\7\:CKbb \8\:CKbb) resistor r=24.2328 c=0
Rl31 (\5\:CKbb \6\:CKbb) resistor r=26.1559 c=0
Rl20 (\3\:CKbb \4\:CKbb) resistor r=29.5379 c=0
Rl19 (CKbb \2\:CKbb) resistor r=53.1035 c=0
Rl26 (\2\:n20 \4\:n20) resistor r=47.791 c=0
Rl25 (\2\:n20 \3\:n20) resistor r=97.7911 c=0
Rl24 (n20 \2\:n20) resistor r=1.2713 c=0
Rz3 (\1\:Q \2\:Q) resistor r=75 c=0
Rz10 (\8\:VSS \9\:VSS) resistor r=75 c=0
Rz11 (\10\:VSS \11\:VSS) resistor r=75 c=0
Rz12 (\12\:VSS \13\:VSS) resistor r=75 c=0
Rz13 (\15\:VSS \16\:VSS) resistor r=75 c=0
Rz14 (\17\:VSS \18\:VSS) resistor r=75 c=0
Rz1 (\3\:QN \4\:QN) resistor r=75 c=0
Rz2 (\9\:qint \10\:qint) resistor r=75 c=0
Rz4 (\14\:qbint \15\:qbint) resistor r=75 c=0
Rz8 (\11\:CKb \12\:CKb) resistor r=75 c=0
Rz5 (\4\:n30 \5\:n30) resistor r=75 c=0
Rz6 (\8\:mout \9\:mout) resistor r=75 c=0
Rz9 (\9\:CKbb \10\:CKbb) resistor r=75 c=0
Rz7 (\5\:n20 \6\:n20) resistor r=75 c=0
Ry3 (\4\:Q \5\:Q) resistor r=62 c=0
Ry19 (\1\:VSS \2\:VSS) resistor r=62 c=0
Ry20 (\1\:VSS \4\:VSS) resistor r=5.1667 c=0
Ry21 (\1\:VSS \7\:VSS) resistor r=5.1667 c=0
Ry1 (\1\:QN \2\:QN) resistor r=62 c=0
Ry12 (\1\:VDD \2\:VDD) resistor r=62 c=0
Ry13 (\9\:VDD \10\:VDD) resistor r=62 c=0
Ry14 (\11\:VDD \12\:VDD) resistor r=62 c=0
Ry15 (\13\:VDD \14\:VDD) resistor r=62 c=0
Ry16 (\15\:VDD \16\:VDD) resistor r=62 c=0
Ry17 (\17\:VDD \18\:VDD) resistor r=62 c=0
Ry18 (\19\:VDD \20\:VDD) resistor r=62 c=0
Ry2 (\5\:qint \6\:qint) resistor r=62 c=0
Ry4 (\12\:qbint \13\:qbint) resistor r=62 c=0
Ry10 (\13\:CKb \14\:CKb) resistor r=62 c=0
Ry5 (\8\:n30 \9\:n30) resistor r=62 c=0
Ry6 (\6\:mout \7\:mout) resistor r=62 c=0
Ry11 (\15\:CKbb \16\:CKbb) resistor r=62 c=0
Ry9 (\8\:n20 \9\:n20) resistor r=62 c=0
Ry7 (n26 \2\:n26) resistor r=62 c=0
Ry8 (\3\:n26 \4\:n26) resistor r=62 c=0
Rx11 (\2\:D \4\:D) resistor r=45 c=0
Rx3 (\2\:RN \9\:RN) resistor r=45 c=0
Rx7 (\7\:RN \11\:RN) resistor r=45 c=0
Rx8 (\4\:RN \12\:RN) resistor r=45 c=0
Rx2 (\2\:CK \4\:CK) resistor r=45 c=0
Rx1 (qint \8\:qint) resistor r=45 c=0
Rx4 (\9\:qbint \11\:qbint) resistor r=45 c=0
Rx5 (\2\:qbint \16\:qbint) resistor r=45 c=0
Rx12 (CKb \16\:CKb) resistor r=45 c=0
Rx13 (\6\:CKb \17\:CKb) resistor r=45 c=0
Rx14 (\10\:CKb \18\:CKb) resistor r=45 c=0
Rx6 (\2\:n30 \7\:n30) resistor r=45 c=0
Rx9 (\2\:mout \4\:mout) resistor r=45 c=0
Rx15 (\8\:CKbb \12\:CKbb) resistor r=45 c=0
Rx16 (\6\:CKbb \13\:CKbb) resistor r=45 c=0
Rx17 (\4\:CKbb \14\:CKbb) resistor r=45 c=0
Rx18 (CKbb \17\:CKbb) resistor r=45 c=0
Rx10 (n20 \10\:n20) resistor r=45 c=0
mn57 (\3\:QN \3\:qint \17\:VSS VSS) g45n1svt w=(1.45e-07) l=4.5e-08 nf=1 \
        as=2.32e-14 ad=2.392e-14 ps=6.1e-07 pd=6.2e-07 nrd=1.16667 \
        nrs=1.16667 sa=1.65e-07 sb=3.45e-07 sd=160n sca=23.279 \
        scb=0.0230742 scc=0.00267719 m=(1)
mn56 (\9\:qint \5\:qbint \17\:VSS VSS) g45n1svt w=(1.45e-07) l=4.5e-08 \
        nf=1 as=2.32e-14 ad=2.03e-14 ps=6.1e-07 pd=5.7e-07 nrd=1.16667 \
        nrs=1.16667 sa=3.7e-07 sb=1.4e-07 sd=160n sca=23.279 scb=0.0230742 \
        scc=0.00267719 m=(1)
mn55 (\1\:Q qbint \15\:VSS VSS) g45n1svt w=(1.45e-07) l=4.5e-08 nf=1 \
        as=3.27e-14 ad=2.03e-14 ps=8.7e-07 pd=5.7e-07 nrd=1.16667 \
        nrs=1.16667 sa=1.4e-07 sb=2.72414e-07 sd=160n sca=13.253 \
        scb=0.0137915 scc=0.000695334 m=(1)
mn20 (\11\:CKb \3\:CK \15\:VSS VSS) g45n1svt w=(1.45e-07) l=4.5e-08 nf=1 \
        as=3.27e-14 ad=3.045e-14 ps=8.7e-07 pd=7.1e-07 nrd=1.16667 \
        nrs=1.16667 sa=2.2e-07 sb=2.1e-07 sd=160n sca=23.279 scb=0.0230742 \
        scc=0.00267719 m=(1)
mn46 (\14\:qbint n30 n35 VSS) g45n1svt w=(1.45e-07) l=4.5e-08 nf=1 \
        as=1.522e-14 ad=2.03e-14 ps=5e-07 pd=5.7e-07 nrd=1.16667 \
        nrs=1.16667 sa=1.4e-07 sb=8.63276e-07 sd=160n sca=8.85152 \
        scb=0.00706865 scc=0.000138481 m=(1)
mn45 (n35 \1\:RN \12\:VSS VSS) g45n1svt w=(1.45e-07) l=4.5e-08 nf=1 \
        as=3.23e-14 ad=1.522e-14 ps=8.6e-07 pd=5e-07 nrd=1.16667 \
        nrs=1.16667 sa=2.9e-07 sb=7.59828e-07 sd=160n sca=8.85152 \
        scb=0.00706865 scc=0.000138481 m=(1)
mn50 (n40 \8\:qbint \12\:VSS VSS) g45n1svt w=(1.45e-07) l=4.5e-08 nf=1 \
        as=3.23e-14 ad=2.827e-14 ps=8.6e-07 pd=6.8e-07 nrd=1.16667 \
        nrs=1.16667 sa=2.46552e-07 sb=1.97034e-06 sd=160n sca=13.253 \
        scb=0.0137915 scc=0.000695334 m=(1)
mn51 (\4\:n30 \3\:CKb n40 VSS) g45n1svt w=(1.45e-07) l=4.5e-08 nf=1 \
        as=2.827e-14 ad=3.552e-14 ps=6.8e-07 pd=7.8e-07 nrd=1.16667 \
        nrs=1.16667 sa=4.86552e-07 sb=1.96207e-06 sd=160n sca=13.253 \
        scb=0.0137915 scc=0.000695334 m=(1)
mn40 (\4\:n30 \3\:CKbb \8\:mout VSS) g45n1svt w=(1.45e-07) l=4.5e-08 nf=1 \
        as=3.625e-14 ad=3.552e-14 ps=7.9e-07 pd=7.8e-07 nrd=1.16667 \
        nrs=1.16667 sa=7.76552e-07 sb=1.90862e-06 sd=160n sca=13.253 \
        scb=0.0137915 scc=0.000695334 m=(1)
mn30 (\8\:mout \3\:n20 \10\:VSS VSS) g45n1svt w=(1.45e-07) l=4.5e-08 \
        nf=1 as=8.557e-14 ad=3.625e-14 ps=1.57e-06 pd=7.9e-07 nrd=1.16667 \
        nrs=1.16667 sa=1.07155e-06 sb=1.61362e-06 sd=160n sca=13.253 \
        scb=0.0137915 scc=0.000695334 m=(1)
mn35 (n27 \5\:RN \10\:VSS VSS) g45n1svt w=(1.45e-07) l=4.5e-08 nf=1 \
        as=8.557e-14 ad=8.7e-15 ps=1.57e-06 pd=4.1e-07 nrd=1.16667 \
        nrs=1.16667 sa=1.42431e-06 sb=1.25e-06 sd=160n sca=13.6097 \
        scb=0.014254 scc=0.000755054 m=(1)
mn36 (n25 \3\:mout n27 VSS) g45n1svt w=(1.45e-07) l=4.5e-08 nf=1 \
        as=8.7e-15 ad=1.957e-14 ps=4.1e-07 pd=5.6e-07 nrd=1.16667 \
        nrs=1.16667 sa=1.52931e-06 sb=1.145e-06 sd=160n sca=13.6097 \
        scb=0.014254 scc=0.000755054 m=(1)
mn37 (\5\:n20 \5\:CKbb n25 VSS) g45n1svt w=(1.45e-07) l=4.5e-08 nf=1 \
        as=1.957e-14 ad=2.682e-14 ps=5.6e-07 pd=6.6e-07 nrd=1.16667 \
        nrs=1.16667 sa=1.69534e-06 sb=9.65e-07 sd=160n sca=13.6097 \
        scb=0.014254 scc=0.000755054 m=(1)
mn26 (\5\:n20 \7\:CKb n21 VSS) g45n1svt w=(1.45e-07) l=4.5e-08 nf=1 \
        as=3.19e-14 ad=2.682e-14 ps=7.3e-07 pd=6.6e-07 nrd=1.16667 \
        nrs=1.16667 sa=1.85397e-06 sb=7.35e-07 sd=160n sca=13.6097 \
        scb=0.014254 scc=0.000755054 m=(1)
mn25 (n21 \3\:D \8\:VSS VSS) g45n1svt w=(1.45e-07) l=4.5e-08 nf=1 \
        as=4.132e-14 ad=3.19e-14 ps=8.6e-07 pd=7.3e-07 nrd=1.16667 \
        nrs=1.16667 sa=1.96138e-06 sb=4.7e-07 sd=160n sca=13.6097 \
        scb=0.014254 scc=0.000755054 m=(1)
mn21 (\9\:CKbb \8\:CKb \8\:VSS VSS) g45n1svt w=(1.45e-07) l=4.5e-08 nf=1 \
        as=4.132e-14 ad=2.03e-14 ps=8.6e-07 pd=5.7e-07 nrd=1.16667 \
        nrs=1.16667 sa=1.97276e-06 sb=1.4e-07 sd=160n sca=13.6097 \
        scb=0.014254 scc=0.000755054 m=(1)
ends DFFRXL
// End of subcircuit definition.
