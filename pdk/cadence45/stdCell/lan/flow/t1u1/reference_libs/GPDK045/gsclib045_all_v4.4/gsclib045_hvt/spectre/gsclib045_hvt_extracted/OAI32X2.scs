// Generated for: spectre (May  1 09:19:21 2013 )
// Library name: gsclib045_hvt
// Cell name: OAI32X2
// View name: extracted

simulator lang=spectre

subckt OAI32X2 A0 A1 A2 B0 B1 VDD VSS Y
mp0_1__rcx (3 \1\:A0 \11\:VDD VDD) g45p1hvt w=(3.9e-07) l=4.5e-08 nf=1 \
        as=5.46e-14 ad=2.34e-14 ps=1.06e-06 pd=9e-07 nrd=1.16667 \
        nrs=1.16667 sa=1.4e-07 sb=1.87e-06 sd=160n sca=20.0993 \
        scb=0.0192799 scc=0.0012385 m=(1)
mp1_1__rcx (3 \1\:A1 6 VDD) g45p1hvt w=(3.9e-07) l=4.5e-08 nf=1 \
        as=7.41e-14 ad=2.34e-14 ps=1.16e-06 pd=9e-07 nrd=1.16667 \
        nrs=1.16667 sa=2.45e-07 sb=1.765e-06 sd=160n sca=18.4756 \
        scb=0.0165821 scc=0.00119613 m=(1)
mp2_1__rcx (\6\:Y \5\:A2 6 VDD) g45p1hvt w=(3.9e-07) l=4.5e-08 nf=1 \
        as=7.41e-14 ad=6.24e-14 ps=1.16e-06 pd=1.1e-06 nrd=1.16667 \
        nrs=1.16667 sa=4.8e-07 sb=1.53e-06 sd=160n sca=16.8836 \
        scb=0.0148184 scc=0.00118871 m=(1)
mp2 (\6\:Y \6\:A2 7 VDD) g45p1hvt w=(3.9e-07) l=4.5e-08 nf=1 as=7.02e-14 \
        ad=6.24e-14 ps=1.14e-06 pd=1.1e-06 nrd=1.16667 nrs=1.16667 \
        sa=6.85e-07 sb=1.325e-06 sd=160n sca=16.3055 scb=0.014587 \
        scc=0.00118861 m=(1)
mp1 (7 \4\:A1 8 VDD) g45p1hvt w=(3.9e-07) l=4.5e-08 nf=1 as=5.265e-14 \
        ad=7.02e-14 ps=1.05e-06 pd=1.14e-06 nrd=1.16667 nrs=1.16667 \
        sa=9.1e-07 sb=1.1e-06 sd=160n sca=16.2669 scb=0.0145797 \
        scc=0.00118861 m=(1)
mp0 (8 \6\:A0 \9\:VDD VDD) g45p1hvt w=(3.9e-07) l=4.5e-08 nf=1 \
        as=1.3065e-13 ad=5.265e-14 ps=1.63e-06 pd=1.05e-06 nrd=1.16667 \
        nrs=1.16667 sa=1.09e-06 sb=9.2e-07 sd=160n sca=16.2669 \
        scb=0.0145797 scc=0.00118861 m=(1)
mp3_1__rcx (4 \1\:B0 \9\:VDD VDD) g45p1hvt w=(3.9e-07) l=4.5e-08 nf=1 \
        as=1.3065e-13 ad=2.34e-14 ps=1.63e-06 pd=9e-07 nrd=1.16667 \
        nrs=1.16667 sa=1.43e-06 sb=5.8e-07 sd=160n sca=16.3679 \
        scb=0.0146009 scc=0.00118861 m=(1)
mp4_1__rcx (\9\:Y \4\:B1 4 VDD) g45p1hvt w=(3.9e-07) l=4.5e-08 nf=1 \
        as=2.34e-14 ad=6.24e-14 ps=9e-07 pd=1.1e-06 nrd=1.16667 \
        nrs=1.16667 sa=1.535e-06 sb=4.75e-07 sd=160n sca=16.6397 \
        scb=0.0146915 scc=0.00118864 m=(1)
mp4 (\9\:Y \6\:B1 9 VDD) g45p1hvt w=(3.9e-07) l=4.5e-08 nf=1 as=3.315e-14 \
        ad=6.24e-14 ps=9.5e-07 pd=1.1e-06 nrd=1.16667 nrs=1.16667 \
        sa=1.74e-06 sb=2.7e-07 sd=160n sca=17.591 scb=0.0154265 \
        scc=0.00118981 m=(1)
mp3 (9 \6\:B0 \7\:VDD VDD) g45p1hvt w=(3.9e-07) l=4.5e-08 nf=1 \
        as=5.46e-14 ad=3.315e-14 ps=1.06e-06 pd=9.5e-07 nrd=1.16667 \
        nrs=1.16667 sa=1.87e-06 sb=1.4e-07 sd=160n sca=18.843 \
        scb=0.0171484 scc=0.00120158 m=(1)
C1 (A0 VSS) capacitor c=4.86641e-16
C2 (B0 VSS) capacitor c=3.20137e-17
C3 (A1 VSS) capacitor c=2.76115e-17
C4 (VDD VSS) capacitor c=1.02008e-16
C5 (Y VSS) capacitor c=3.55825e-17
C6 (A2 VSS) capacitor c=5.86833e-17
C7 (B1 VSS) capacitor c=3.80474e-17
C8 (n0 VSS) capacitor c=3.34711e-16
C9 (3 VSS) capacitor c=1.24857e-18
C10 (6 VSS) capacitor c=1.52163e-18
C11 (7 VSS) capacitor c=6.05118e-18
C12 (8 VSS) capacitor c=5.17503e-18
C13 (4 VSS) capacitor c=1.73737e-18
C14 (\6\:B0 VSS) capacitor c=6.60956e-17
C15 (\6\:B1 VSS) capacitor c=4.4404e-17
C16 (\4\:B1 VSS) capacitor c=6.08533e-17
C17 (\1\:B0 VSS) capacitor c=8.63558e-17
C18 (\6\:A0 VSS) capacitor c=6.15817e-17
C19 (\4\:A1 VSS) capacitor c=5.74405e-17
C20 (\6\:A2 VSS) capacitor c=4.08175e-17
C21 (\5\:A2 VSS) capacitor c=2.46857e-17
C22 (\1\:A1 VSS) capacitor c=8.7569e-17
C23 (\1\:A0 VSS) capacitor c=8.25668e-17
C24 (\1\:B1 VSS) capacitor c=9.72318e-17
C25 (\1\:A2 VSS) capacitor c=1.02618e-16
C26 (\3\:B1 VSS) capacitor c=4.92893e-17
C27 (\2\:B0 VSS) capacitor c=3.17346e-16
C28 (\3\:A2 VSS) capacitor c=2.91441e-17
C29 (\2\:A1 VSS) capacitor c=3.65674e-16
C30 (\7\:VDD VSS) capacitor c=3.66554e-17
C31 (\9\:Y VSS) capacitor c=5.99834e-17
C32 (\9\:VDD VSS) capacitor c=3.53014e-17
C33 (\6\:Y VSS) capacitor c=5.71542e-17
C34 (\11\:VDD VSS) capacitor c=4.59699e-17
C35 (\1\:VDD VSS) capacitor c=2.40799e-17
C36 (\9\:n0 VSS) capacitor c=8.00082e-17
C37 (\1\:Y VSS) capacitor c=2.23402e-16
C38 (\7\:A2 VSS) capacitor c=4.28237e-17
C39 (\7\:B1 VSS) capacitor c=6.01473e-17
C40 (\5\:Y VSS) capacitor c=9.60874e-17
C41 (\3\:VDD VSS) capacitor c=1.78778e-17
C42 (\4\:VDD VSS) capacitor c=1.79058e-17
C43 (\6\:VDD VSS) capacitor c=1.66697e-17
Rk15 (\2\:B0 B0) resistor r=0.09124 c=0
Rk2 (A1 \2\:A1) resistor r=0.05061 c=0
Rk21 (\2\:VDD \3\:VDD) resistor r=0.135 c=0
Rk22 (\3\:VDD \4\:VDD) resistor r=0.3903 c=0
Rk23 (\4\:VDD \5\:VDD) resistor r=0.125 c=0
Rk25 (\6\:VDD VDD) resistor r=0.09723 c=0
Rk24 (\5\:VDD \6\:VDD) resistor r=0.4531 c=0
Rk26 (\3\:VDD \8\:VDD) resistor r=0.3383 c=0
Rk27 (\4\:VDD \10\:VDD) resistor r=0.1581 c=0
Rk28 (\6\:VDD \12\:VDD) resistor r=0.3383 c=0
Rk10 (\5\:Y Y) resistor r=0.08382 c=0
Rk9 (\1\:Y \5\:Y) resistor r=0.6159 c=0
Rk11 (Y \7\:Y) resistor r=0.3161 c=0
Rk12 (\7\:Y \8\:Y) resistor r=0.1458 c=0
Rk13 (\5\:Y \10\:Y) resistor r=0.447 c=0
Rk33 (\3\:VSS VSS) resistor r=0.1148 c=0
Rk29 (\2\:VSS \3\:VSS) resistor r=0.6159 c=0
Rk35 (\3\:VSS \10\:VSS) resistor r=0.1018 c=0
Rk1 (\7\:A2 A2) resistor r=0.2015 c=0
Rk7 (B1 \7\:B1) resistor r=0.1011 c=0
Rl13 (A0 \6\:A0) resistor r=103.079 c=0
Rl1 (A0 \1\:A0) resistor r=124.566 c=0
Rl22 (\2\:B0 \6\:B0) resistor r=105.708 c=0
Rl14 (\2\:B0 \1\:B0) resistor r=94.9225 c=0
Rl10 (\2\:A1 \4\:A1) resistor r=79.9442 c=0
Rl3 (\2\:A1 \1\:A1) resistor r=90.1797 c=0
Rl9 (\3\:A2 \6\:A2) resistor r=105.323 c=0
Rl8 (\3\:A2 \5\:A2) resistor r=24.2328 c=0
Rl6 (\1\:A2 \3\:A2) resistor r=68.1451 c=0
Rl20 (\3\:B1 \6\:B1) resistor r=42.1458 c=0
Rl18 (\3\:B1 \4\:B1) resistor r=56.2772 c=0
Rl17 (\1\:B1 \3\:B1) resistor r=60.4528 c=0
Rz9 (\1\:VDD \2\:VDD) resistor r=75 c=0
Rz10 (\1\:VDD \5\:VDD) resistor r=6.25 c=0
Rz12 (\10\:VSS \9\:VSS) resistor r=75 c=0
Rz7 (n0 \9\:n0) resistor r=75 c=0
Ry4 (\7\:VDD \8\:VDD) resistor r=20.6667 c=0
Ry5 (\9\:VDD \10\:VDD) resistor r=62 c=0
Ry6 (\11\:VDD \12\:VDD) resistor r=20.6667 c=0
Ry1 (\7\:Y \6\:Y) resistor r=62 c=0
Ry2 (\8\:Y \6\:Y) resistor r=62 c=0
Ry3 (\10\:Y \9\:Y) resistor r=62 c=0
Ry7 (\2\:VSS \1\:VSS) resistor r=62 c=0
Ry8 (\3\:VSS \1\:VSS) resistor r=5.1667 c=0
Rx1 (\7\:A2 \3\:A2) resistor r=45 c=0
Rx6 (\7\:B1 \3\:B1) resistor r=45 c=0
mn4_1__rcx (\1\:Y \1\:B1 \9\:n0 VSS) g45n1hvt w=(2.6e-07) l=4.5e-08 nf=1 \
        as=4.16e-14 ad=4.16e-14 ps=8.4e-07 pd=8.4e-07 nrd=1.16667 \
        nrs=1.16667 sa=1.805e-06 sb=5.5e-07 sd=160n sca=9.50447 \
        scb=0.0081528 scc=0.00025289 m=(2)
mn0_1__rcx (n0 A0 \3\:VSS VSS) g45n1hvt w=(2.6e-07) l=4.5e-08 nf=1 \
        as=8.18e-14 ad=4.55e-14 ps=1.37e-06 pd=8.7e-07 nrd=1.16667 \
        nrs=1.16667 sa=1.4e-07 sb=2e-06 sd=160n sca=9.50447 scb=0.0081528 \
        scc=0.00025289 m=(2)
mn1 (n0 \2\:A1 \3\:VSS VSS) g45n1hvt w=(2.6e-07) l=4.5e-08 nf=1 \
        as=8.18e-14 ad=4.16e-14 ps=1.37e-06 pd=8.4e-07 nrd=1.16667 \
        nrs=1.16667 sa=4.05e-07 sb=1.95e-06 sd=160n sca=9.50447 \
        scb=0.0081528 scc=0.00025289 m=(2)
mn3_1__rcx (\1\:Y \2\:B0 n0 VSS) g45n1hvt w=(2.6e-07) l=4.5e-08 nf=1 \
        as=4.55e-14 ad=4.16e-14 ps=8.7e-07 pd=8.4e-07 nrd=1.16667 \
        nrs=1.16667 sa=1.6e-06 sb=7.55e-07 sd=160n sca=9.50447 \
        scb=0.0081528 scc=0.00025289 m=(2)
mn2_1__rcx (n0 \1\:A2 \9\:VSS VSS) g45n1hvt w=(2.6e-07) l=4.5e-08 nf=1 \
        as=8.18e-14 ad=4.16e-14 ps=1.37e-06 pd=8.4e-07 nrd=1.16667 \
        nrs=1.16667 sa=6.1e-07 sb=1.745e-06 sd=160n sca=9.50447 \
        scb=0.0081528 scc=0.00025289 m=(2)
ends OAI32X2
// End of subcircuit definition.
