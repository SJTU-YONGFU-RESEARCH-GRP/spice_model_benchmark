// Generated for: spectre (May  1 11:29:06 2013 )
// Library name: gsclib045_backbias
// Cell name: DFFSX4
// View name: extracted

simulator lang=spectre

subckt DFFSX4 CK D NW Q QN SN VDD VSS
mp20 (\15\:CKb \3\:CK \28\:VDD NW) g45p1svt w=(2.15e-07) l=4.5e-08 nf=1 \
        as=6.45e-14 ad=4.837e-14 ps=1.03e-06 pd=8.8e-07 nrd=1.16667 \
        nrs=1.16667 sa=2.25e-07 sb=1.84733e-06 sd=160n sca=25.0615 \
        scb=0.0281532 scc=0.00173703 m=(1)
mp25 (n22 \1\:D \28\:VDD NW) g45p1svt w=(2.15e-07) l=4.5e-08 nf=1 \
        as=6.45e-14 ad=3.44e-14 ps=1.03e-06 pd=7.5e-07 nrd=1.16667 \
        nrs=1.16667 sa=5.7e-07 sb=1.50233e-06 sd=160n sca=19.0383 \
        scb=0.0183896 scc=0.00142445 m=(1)
mp26 (\8\:n20 \3\:CKbb n22 NW) g45p1svt w=(2.15e-07) l=4.5e-08 nf=1 \
        as=3.44e-14 ad=3.44e-14 ps=7.5e-07 pd=7.5e-07 nrd=1.16667 \
        nrs=1.16667 sa=7.75e-07 sb=1.29733e-06 sd=160n sca=18.2092 \
        scb=0.0178429 scc=0.00142384 m=(1)
mp36 (\8\:n20 \3\:CKb n31 NW) g45p1svt w=(2.15e-07) l=4.5e-08 nf=1 \
        as=3.01e-14 ad=3.44e-14 ps=7.1e-07 pd=7.5e-07 nrd=1.16667 \
        nrs=1.16667 sa=9.8e-07 sb=1.09233e-06 sd=160n sca=17.9376 \
        scb=0.0177709 scc=0.00142383 m=(1)
mp35 (n31 \3\:mout \26\:VDD NW) g45p1svt w=(2.15e-07) l=4.5e-08 nf=1 \
        as=9.71e-14 ad=3.01e-14 ps=1.7e-06 pd=7.1e-07 nrd=1.16667 \
        nrs=1.16667 sa=1.165e-06 sb=9.07326e-07 sd=160n sca=17.9376 \
        scb=0.0177709 scc=0.00142383 m=(1)
mp31 (\8\:mout \3\:n20 \26\:VDD NW) g45p1svt w=(2.15e-07) l=4.5e-08 nf=1 \
        as=9.71e-14 ad=4.515e-14 ps=1.7e-06 pd=8.5e-07 nrd=1.16667 \
        nrs=1.16667 sa=1.43e-06 sb=6.42326e-07 sd=160n sca=17.9376 \
        scb=0.0177709 scc=0.00142383 m=(1)
mp30 (\8\:mout \1\:SN \24\:VDD NW) g45p1svt w=(2.15e-07) l=4.5e-08 nf=1 \
        as=9.71e-14 ad=4.515e-14 ps=1.7e-06 pd=8.5e-07 nrd=1.16667 \
        nrs=1.16667 sa=1.685e-06 sb=3.87326e-07 sd=160n sca=17.9376 \
        scb=0.0177709 scc=0.00142383 m=(1)
mp21 (\14\:CKbb \8\:CKb \24\:VDD NW) g45p1svt w=(2.15e-07) l=4.5e-08 \
        nf=1 as=9.71e-14 ad=2.63e-14 ps=1.7e-06 pd=7.1e-07 nrd=1.16667 \
        nrs=1.16667 sa=1.95e-06 sb=1.22326e-07 sd=160n sca=17.9376 \
        scb=0.0177709 scc=0.00142383 m=(1)
mp40 (\10\:n35 \9\:CKb \6\:mout NW) g45p1svt w=(2.15e-07) l=4.5e-08 nf=1 \
        as=2.67e-14 ad=3.548e-14 ps=7.1e-07 pd=7.6e-07 nrd=1.16667 \
        nrs=1.16667 sa=1.24186e-07 sb=3.5e-07 sd=160n sca=11.6359 \
        scb=0.0100097 scc=0.00025962 m=(1)
mp52 (\10\:n35 \7\:CKbb \3\:n41 NW) g45p1svt w=(2.15e-07) l=4.5e-08 nf=1 \
        as=3.01e-14 ad=3.548e-14 ps=7.1e-07 pd=7.6e-07 nrd=1.16667 \
        nrs=1.16667 sa=3.34186e-07 sb=1.4e-07 sd=160n sca=11.6359 \
        scb=0.0100097 scc=0.00025962 m=(1)
mp51 (n41 qbint \22\:VDD NW) g45p1svt w=(2.15e-07) l=4.5e-08 nf=1 \
        as=7.255e-14 ad=3.44e-14 ps=1.37e-06 pd=7.5e-07 nrd=1.16667 \
        nrs=1.16667 sa=1.7e-07 sb=2e-06 sd=160n sca=11.3578 scb=0.0095436 \
        scc=0.000220652 m=(1)
mp50 (n41 \4\:SN \1\:VDD NW) g45p1svt w=(2.15e-07) l=4.5e-08 nf=1 \
        as=6.647e-14 ad=3.44e-14 ps=1.15e-06 pd=7.5e-07 nrd=1.16667 \
        nrs=1.16667 sa=3.75e-07 sb=2e-06 sd=160n sca=11.3578 scb=0.0095436 \
        scc=0.000220652 m=(1)
C1 (NW VSS) capacitor c=8.29254e-16
C2 (SN VSS) capacitor c=1.61656e-16
C3 (Q VSS) capacitor c=2.53199e-17
C4 (D VSS) capacitor c=6.20526e-17
C5 (QN VSS) capacitor c=1.26179e-17
C6 (VDD VSS) capacitor c=4.40442e-17
C7 (CKb VSS) capacitor c=4.80763e-17
C8 (n20 VSS) capacitor c=4.31262e-17
C9 (n30 VSS) capacitor c=2.74938e-18
C10 (CKbb VSS) capacitor c=2.80653e-17
C11 (mout VSS) capacitor c=4.82387e-17
C12 (n25 VSS) capacitor c=3.61404e-18
C13 (n35 VSS) capacitor c=1.80801e-16
C14 (n40 VSS) capacitor c=1.87763e-18
C15 (qbint VSS) capacitor c=5.44691e-17
C16 (net331 VSS) capacitor c=2.6808e-16
C17 (n22 VSS) capacitor c=3.00795e-18
C18 (n41 VSS) capacitor c=9.56851e-17
C19 (\20\:qbint VSS) capacitor c=4.4716e-17
C20 (\4\:qbint VSS) capacitor c=2.50711e-16
C21 (\4\:SN VSS) capacitor c=4.28001e-17
C22 (\7\:CKbb VSS) capacitor c=4.76929e-17
C23 (\9\:CKb VSS) capacitor c=3.87009e-17
C24 (\8\:CKb VSS) capacitor c=4.44114e-17
C25 (\1\:SN VSS) capacitor c=6.60852e-17
C26 (\3\:n20 VSS) capacitor c=4.01723e-17
C27 (\3\:mout VSS) capacitor c=5.7818e-17
C28 (\3\:CKb VSS) capacitor c=4.93022e-17
C29 (\3\:CKbb VSS) capacitor c=7.76262e-17
C30 (\1\:D VSS) capacitor c=3.1159e-17
C31 (\3\:CK VSS) capacitor c=2.09056e-17
C32 (\18\:qbint VSS) capacitor c=2.80148e-17
C33 (\6\:SN VSS) capacitor c=6.75226e-17
C34 (\3\:qbint VSS) capacitor c=3.92661e-17
C35 (\5\:CKb VSS) capacitor c=7.98918e-17
C36 (\4\:CKbb VSS) capacitor c=4.22763e-17
C37 (\6\:CKb VSS) capacitor c=6.57967e-17
C38 (\2\:SN VSS) capacitor c=3.4709e-17
C39 (\3\:D VSS) capacitor c=6.69805e-17
C40 (\1\:CK VSS) capacitor c=4.60208e-17
C41 (\19\:qbint VSS) capacitor c=4.1617e-17
C42 (\6\:n35 VSS) capacitor c=1.05376e-17
C43 (\5\:SN VSS) capacitor c=6.41586e-17
C44 (\2\:qbint VSS) capacitor c=4.92227e-17
C45 (\6\:CKbb VSS) capacitor c=2.72448e-17
C46 (\10\:CKb VSS) capacitor c=1.61872e-17
C47 (\3\:SN VSS) capacitor c=2.06198e-17
C48 (\2\:n20 VSS) capacitor c=4.63214e-17
C49 (\2\:mout VSS) capacitor c=5.7061e-17
C50 (\2\:CKbb VSS) capacitor c=6.81264e-17
C51 (\4\:CKb VSS) capacitor c=2.33503e-17
C52 (\2\:CKb VSS) capacitor c=5.07811e-17
C53 (\2\:D VSS) capacitor c=5.02414e-17
C54 (\2\:CK VSS) capacitor c=3.9862e-17
C55 (\20\:net331 VSS) capacitor c=3.06606e-17
C56 (\1\:VDD VSS) capacitor c=7.13496e-16
C57 (\1\:Q VSS) capacitor c=1.5989e-16
C58 (\27\:qbint VSS) capacitor c=6.55567e-17
C59 (\22\:VDD VSS) capacitor c=1.93944e-17
C60 (\3\:n41 VSS) capacitor c=8.01478e-17
C61 (\10\:n35 VSS) capacitor c=4.77662e-17
C62 (\6\:mout VSS) capacitor c=1.37522e-16
C63 (\14\:CKbb VSS) capacitor c=4.19808e-17
C64 (\24\:VDD VSS) capacitor c=2.49505e-17
C65 (\8\:mout VSS) capacitor c=9.97639e-17
C66 (\26\:VDD VSS) capacitor c=2.05798e-17
C67 (\8\:n20 VSS) capacitor c=2.89628e-17
C68 (\28\:VDD VSS) capacitor c=5.7312e-17
C69 (\15\:CKb VSS) capacitor c=5.65607e-17
C70 (\16\:net331 VSS) capacitor c=3.33321e-17
C71 (\1\:QN VSS) capacitor c=8.73462e-17
C72 (\29\:qbint VSS) capacitor c=2.06954e-17
C73 (\12\:n35 VSS) capacitor c=8.77201e-17
C74 (\4\:mout VSS) capacitor c=1.2753e-16
C75 (\12\:CKbb VSS) capacitor c=2.22356e-17
C76 (\11\:mout VSS) capacitor c=3.06091e-17
C77 (\6\:n20 VSS) capacitor c=7.28213e-17
C78 (\17\:CKb VSS) capacitor c=1.933e-17
C79 (\5\:CKbb VSS) capacitor c=3.15235e-17
C80 (\7\:CKb VSS) capacitor c=5.09209e-17
C81 (\4\:CK VSS) capacitor c=6.43401e-17
C82 (\5\:CK VSS) capacitor c=5.16264e-17
C83 (\4\:D VSS) capacitor c=6.28157e-17
C84 (\4\:n20 VSS) capacitor c=5.60763e-17
C85 (\5\:n20 VSS) capacitor c=7.74768e-17
C86 (\11\:CKb VSS) capacitor c=1.04833e-16
C87 (\12\:CKb VSS) capacitor c=1.45131e-16
C88 (\13\:CKb VSS) capacitor c=1.55248e-16
C89 (\14\:CKb VSS) capacitor c=9.82358e-17
C90 (\8\:CKbb VSS) capacitor c=4.16166e-17
C91 (\9\:CKbb VSS) capacitor c=2.83473e-17
C92 (\10\:CKbb VSS) capacitor c=1.1159e-16
C93 (\11\:CKbb VSS) capacitor c=1.28092e-16
C94 (\10\:mout VSS) capacitor c=5.72782e-17
C95 (\13\:mout VSS) capacitor c=3.63018e-17
C96 (\7\:SN VSS) capacitor c=6.97404e-17
C97 (\8\:SN VSS) capacitor c=1.47328e-16
C98 (\8\:n35 VSS) capacitor c=1.2433e-16
C99 (\9\:n35 VSS) capacitor c=1.58729e-16
C100 (\4\:Q VSS) capacitor c=1.09579e-16
C101 (\5\:QN VSS) capacitor c=1.72236e-16
C102 (\21\:qbint VSS) capacitor c=2.25381e-16
C103 (\22\:qbint VSS) capacitor c=1.85102e-16
C104 (\23\:qbint VSS) capacitor c=3.03812e-17
C105 (\24\:qbint VSS) capacitor c=4.32722e-17
C106 (\25\:qbint VSS) capacitor c=5.78195e-17
C107 (\26\:qbint VSS) capacitor c=3.3016e-17
C108 (\18\:net331 VSS) capacitor c=4.04509e-17
C109 (\19\:net331 VSS) capacitor c=4.89001e-17
C110 (\8\:VDD VSS) capacitor c=8.53105e-17
C111 (\9\:VDD VSS) capacitor c=9.73032e-17
C112 (\10\:VDD VSS) capacitor c=7.4261e-17
C113 (\11\:VDD VSS) capacitor c=7.44749e-17
Rk23 (\7\:SN SN) resistor r=0.3441 c=0
Rk24 (SN \8\:SN) resistor r=1.2331 c=0
Rk30 (\1\:Q Q) resistor r=0.07275 c=0
Rk31 (Q \4\:Q) resistor r=0.1621 c=0
Rk4 (\4\:D D) resistor r=0.04146 c=0
Rk36 (\1\:QN QN) resistor r=0.04298 c=0
Rk37 (QN \5\:QN) resistor r=0.1878 c=0
Rk55 (\1\:VSS \9\:VSS) resistor r=0.7369 c=0
Rk56 (\9\:VSS \10\:VSS) resistor r=0.3647 c=0
Rk57 (\10\:VSS \11\:VSS) resistor r=0.09913 c=0
Rk59 (\12\:VSS VSS) resistor r=0.1851 c=0
Rk58 (\11\:VSS \12\:VSS) resistor r=0.3658 c=0
Rk65 (\9\:VSS \24\:VSS) resistor r=0.127 c=0
Rk66 (\10\:VSS \26\:VSS) resistor r=0.04329 c=0
Rk67 (\12\:VSS \28\:VSS) resistor r=0.1762 c=0
Rk73 (\1\:VDD \8\:VDD) resistor r=0.2277 c=0
Rk74 (\8\:VDD \9\:VDD) resistor r=0.6831 c=0
Rk75 (\9\:VDD \10\:VDD) resistor r=0.2594 c=0
Rk77 (\11\:VDD VDD) resistor r=0.2177 c=0
Rk76 (\10\:VDD \11\:VDD) resistor r=0.4158 c=0
Rk83 (\8\:VDD \23\:VDD) resistor r=0.1024 c=0
Rk84 (\9\:VDD \25\:VDD) resistor r=0.04329 c=0
Rk85 (\10\:VDD \27\:VDD) resistor r=0.07369 c=0
Rk86 (\11\:VDD \29\:VDD) resistor r=0.3502 c=0
Rk1 (CK \4\:CK) resistor r=0.001952 c=0
Rk3 (\4\:CK \5\:CK) resistor r=0.02435 c=0
Rk2 (\5\:CK \6\:CK) resistor r=0.002019 c=0
Rk8 (\11\:CKb \12\:CKb) resistor r=0.7005 c=0
Rk9 (\12\:CKb \13\:CKb) resistor r=0.6671 c=0
Rk10 (\13\:CKb \14\:CKb) resistor r=0.499 c=0
Rk11 (\14\:CKb \16\:CKb) resistor r=0.6031 c=0
Rk12 (\14\:CKb \18\:CKb) resistor r=0.097 c=0
Rk5 (\4\:n20 \5\:n20) resistor r=0.3443 c=0
Rk6 (\5\:n20 \7\:n20) resistor r=0.4427 c=0
Rk7 (\5\:n20 \9\:n20) resistor r=0.1307 c=0
Rk13 (\8\:CKbb \9\:CKbb) resistor r=0.1202 c=0
Rk14 (\9\:CKbb \10\:CKbb) resistor r=0.2222 c=0
Rk15 (\10\:CKbb \11\:CKbb) resistor r=1.0275 c=0
Rk16 (\9\:CKbb \13\:CKbb) resistor r=0.1155 c=0
Rk17 (\10\:CKbb \15\:CKbb) resistor r=0.1664 c=0
Rk18 (\5\:mout \7\:mout) resistor r=0.7392 c=0
Rk19 (\7\:mout \9\:mout) resistor r=0.6137 c=0
Rk20 (\9\:mout \10\:mout) resistor r=0.3339 c=0
Rk21 (\10\:mout \12\:mout) resistor r=0.07479 c=0
Rk22 (\10\:mout \13\:mout) resistor r=0.1825 c=0
Rk26 (\8\:n35 \9\:n35) resistor r=0.8385 c=0
Rk27 (\9\:n35 \11\:n35) resistor r=0.2583 c=0
Rk28 (\9\:n35 \13\:n35) resistor r=0.4121 c=0
Rk40 (\21\:qbint \22\:qbint) resistor r=1.8272 c=0
Rk41 (\22\:qbint \23\:qbint) resistor r=0.09741 c=0
Rk42 (\23\:qbint \24\:qbint) resistor r=0.1601 c=0
Rk43 (\24\:qbint \25\:qbint) resistor r=0.3388 c=0
Rk44 (\22\:qbint \26\:qbint) resistor r=0.1025 c=0
Rk45 (\23\:qbint \28\:qbint) resistor r=0.28 c=0
Rk46 (\24\:qbint \30\:qbint) resistor r=0.06442 c=0
Rk47 (\17\:net331 \18\:net331) resistor r=0.3792 c=0
Rk48 (\18\:net331 \19\:net331) resistor r=0.271 c=0
Rk49 (\18\:net331 \21\:net331) resistor r=0.097 c=0
Rk25 (\2\:n41 \4\:n41) resistor r=0.3958 c=0
Rl13 (\1\:SN \2\:SN) resistor r=151.489 c=0
Rl25 (\4\:SN \5\:SN) resistor r=69.208 c=0
Rl26 (\5\:SN \6\:SN) resistor r=95.9489 c=0
Rl14 (\2\:SN \3\:SN) resistor r=24.2328 c=0
Rl3 (\1\:D \2\:D) resistor r=50.6918 c=0
Rl4 (\2\:D \3\:D) resistor r=164.153 c=0
Rl2 (\2\:CK \3\:CK) resistor r=26.3736 c=0
Rl1 (\1\:CK \2\:CK) resistor r=190.385 c=0
Rl18 (\5\:CKb \6\:CKb) resistor r=414.95 c=0
Rl22 (\8\:CKb \10\:CKb) resistor r=50.6918 c=0
Rl6 (\3\:CKb \4\:CKb) resistor r=71.8456 c=0
Rl5 (CKb \2\:CKb) resistor r=91.4826 c=0
Rl21 (\7\:CKb \9\:CKb) resistor r=142.286 c=0
Rl20 (\7\:CKb \8\:CKb) resistor r=153.824 c=0
Rl19 (\6\:CKb \7\:CKb) resistor r=90.0661 c=0
Rl12 (\2\:n20 \3\:n20) resistor r=26.1559 c=0
Rl11 (n20 \2\:n20) resistor r=114.183 c=0
Rl8 (\2\:CKbb \3\:CKbb) resistor r=257.95 c=0
Rl7 (CKbb \2\:CKbb) resistor r=29.5379 c=0
Rl17 (\5\:CKbb \7\:CKbb) resistor r=118.912 c=0
Rl15 (\4\:CKbb \5\:CKbb) resistor r=80.7471 c=0
Rl16 (\5\:CKbb \6\:CKbb) resistor r=40.3099 c=0
Rl10 (\2\:mout \3\:mout) resistor r=97.6132 c=0
Rl9 (mout \2\:mout) resistor r=117.103 c=0
Rl31 (n35 \6\:n35) resistor r=1.2301 c=0
Rl61 (\19\:qbint \20\:qbint) resistor r=47.3097 c=0
Rl60 (\19\:qbint \18\:qbint) resistor r=59.5201 c=0
Rl23 (\2\:qbint qbint) resistor r=137.694 c=0
Rl24 (\2\:qbint \3\:qbint) resistor r=26.1559 c=0
Rz19 (\24\:VSS \23\:VSS) resistor r=75 c=0
Rz20 (\26\:VSS \25\:VSS) resistor r=75 c=0
Rz21 (\28\:VSS \27\:VSS) resistor r=75 c=0
Rz2 (\17\:CKb \18\:CKb) resistor r=75 c=0
Rz1 (\6\:n20 \7\:n20) resistor r=75 c=0
Rz3 (\12\:CKbb \13\:CKbb) resistor r=75 c=0
Rz4 (\4\:mout \5\:mout) resistor r=75 c=0
Rz5 (\11\:mout \12\:mout) resistor r=75 c=0
Rz6 (\13\:n35 \12\:n35) resistor r=75 c=0
Rz11 (\30\:qbint \29\:qbint) resistor r=75 c=0
Rz12 (\17\:net331 \16\:net331) resistor r=75 c=0
Ry15 (\1\:VSS \3\:VSS) resistor r=3.1 c=0
Ry17 (\11\:VSS \3\:VSS) resistor r=5.1667 c=0
Ry24 (\23\:VDD \22\:VDD) resistor r=62 c=0
Ry25 (\25\:VDD \24\:VDD) resistor r=62 c=0
Ry26 (\27\:VDD \26\:VDD) resistor r=62 c=0
Ry27 (\29\:VDD \28\:VDD) resistor r=62 c=0
Ry2 (\15\:CKb \16\:CKb) resistor r=62 c=0
Ry1 (\8\:n20 \9\:n20) resistor r=62 c=0
Ry3 (\14\:CKbb \15\:CKbb) resistor r=62 c=0
Ry4 (\6\:mout \7\:mout) resistor r=62 c=0
Ry5 (\8\:mout \9\:mout) resistor r=62 c=0
Ry8 (\11\:n35 \10\:n35) resistor r=62 c=0
Ry13 (\28\:qbint \27\:qbint) resistor r=31 c=0
Ry14 (\21\:net331 \20\:net331) resistor r=20.6667 c=0
Ry6 (n41 \2\:n41) resistor r=62 c=0
Ry7 (\3\:n41 \4\:n41) resistor r=62 c=0
Rx10 (\5\:SN \7\:SN) resistor r=45 c=0
Rx11 (\3\:SN \8\:SN) resistor r=45 c=0
Rx2 (\2\:D \4\:D) resistor r=45 c=0
Rx1 (\2\:CK \6\:CK) resistor r=45 c=0
Rx4 (\10\:CKb \11\:CKb) resistor r=45 c=0
Rx5 (\4\:CKb \12\:CKb) resistor r=45 c=0
Rx6 (\2\:CKb \13\:CKb) resistor r=45 c=0
Rx3 (\2\:n20 \4\:n20) resistor r=45 c=0
Rx7 (\6\:CKbb \8\:CKbb) resistor r=45 c=0
Rx8 (\2\:CKbb \11\:CKbb) resistor r=45 c=0
Rx9 (\2\:mout \13\:mout) resistor r=45 c=0
Rx12 (\8\:n35 \6\:n35) resistor r=45 c=0
Rx13 (\21\:qbint \19\:qbint) resistor r=45 c=0
Rx14 (\25\:qbint \2\:qbint) resistor r=45 c=0
Rx15 (\26\:qbint \4\:qbint) resistor r=45 c=0
Rx16 (\19\:net331 net331) resistor r=45 c=0
mn20 (\17\:CKb \1\:CK \27\:VSS VSS) g45n1svt w=(1.45e-07) l=4.5e-08 nf=1 \
        as=3.263e-14 ad=2.03e-14 ps=7.4e-07 pd=5.7e-07 nrd=1.16667 \
        nrs=1.16667 sa=1.4e-07 sb=1e-06 sd=160n sca=6.59604 scb=0.00318587 \
        scc=2.16275e-05 m=(1)
mn25 (n21 \3\:D \27\:VSS VSS) g45n1svt w=(1.45e-07) l=4.5e-08 nf=1 \
        as=3.263e-14 ad=1.088e-14 ps=7.4e-07 pd=4.4e-07 nrd=1.16667 \
        nrs=1.16667 sa=4.1e-07 sb=7.3e-07 sd=160n sca=6.59604 \
        scb=0.00318587 scc=2.16275e-05 m=(1)
mn26 (\6\:n20 CKb n21 VSS) g45n1svt w=(1.45e-07) l=4.5e-08 nf=1 \
        as=1.088e-14 ad=3.988e-14 ps=4.4e-07 pd=8.4e-07 nrd=1.16667 \
        nrs=1.16667 sa=5.3e-07 sb=6.1e-07 sd=160n sca=6.59604 \
        scb=0.00318587 scc=2.16275e-05 m=(1)
mn35 (\6\:n20 CKbb n30 VSS) g45n1svt w=(1.45e-07) l=4.5e-08 nf=1 \
        as=2.103e-14 ad=3.988e-14 ps=5.8e-07 pd=8.4e-07 nrd=1.16667 \
        nrs=1.16667 sa=8.5e-07 sb=2.9e-07 sd=160n sca=6.59604 \
        scb=0.00318587 scc=2.16275e-05 m=(1)
mn36 (n30 mout \25\:VSS VSS) g45n1svt w=(1.45e-07) l=4.5e-08 nf=1 \
        as=3.04e-14 ad=2.103e-14 ps=9.3e-07 pd=5.8e-07 nrd=1.16667 \
        nrs=1.16667 sa=1.04e-06 sb=1e-07 sd=160n sca=6.59604 \
        scb=0.00318587 scc=2.16275e-05 m=(1)
mn31 (\11\:mout n20 n25 VSS) g45n1svt w=(1.45e-07) l=4.5e-08 nf=1 \
        as=2.393e-14 ad=2.03e-14 ps=6.2e-07 pd=5.7e-07 nrd=1.16667 \
        nrs=1.16667 sa=1.4e-07 sb=8.55e-07 sd=160n sca=21.4614 \
        scb=0.0218523 scc=0.00230065 m=(1)
mn30 (n25 \2\:SN \23\:VSS VSS) g45n1svt w=(1.45e-07) l=4.5e-08 nf=1 \
        as=1.081e-13 ad=2.393e-14 ps=1.9e-06 pd=6.2e-07 nrd=1.16667 \
        nrs=1.16667 sa=3.5e-07 sb=6.45e-07 sd=160n sca=21.4614 \
        scb=0.0218523 scc=0.00230065 m=(1)
mn21 (\12\:CKbb \6\:CKb \23\:VSS VSS) g45n1svt w=(1.45e-07) l=4.5e-08 \
        nf=1 as=1.081e-13 ad=2.03e-14 ps=1.9e-06 pd=5.7e-07 nrd=1.16667 \
        nrs=1.16667 sa=8.55e-07 sb=1.4e-07 sd=160n sca=21.4614 \
        scb=0.0218523 scc=0.00230065 m=(1)
mn40 (\12\:n35 \4\:CKbb \4\:mout VSS) g45n1svt w=(1.45e-07) l=4.5e-08 \
        nf=1 as=2.03e-14 ad=2.32e-14 ps=5.7e-07 pd=6.1e-07 nrd=1.16667 \
        nrs=1.16667 sa=1.4e-07 sb=2e-06 sd=160n sca=16.7245 scb=0.0178071 \
        scc=0.00133148 m=(1)
mn52 (\12\:n35 \5\:CKb n40 VSS) g45n1svt w=(1.45e-07) l=4.5e-08 nf=1 \
        as=4.858e-14 ad=2.32e-14 ps=9.6e-07 pd=6.1e-07 nrd=1.16667 \
        nrs=1.16667 sa=3.45e-07 sb=2e-06 sd=160n sca=16.7245 scb=0.0178071 \
        scc=0.00133148 m=(1)
mn51 (n40 \3\:qbint n42 VSS) g45n1svt w=(1.45e-07) l=4.5e-08 nf=1 \
        as=8.7e-15 ad=4.858e-14 ps=4.1e-07 pd=9.6e-07 nrd=1.16667 \
        nrs=1.16667 sa=7.25e-07 sb=2e-06 sd=160n sca=16.7245 scb=0.0178071 \
        scc=0.00133148 m=(1)
mn50 (n42 \6\:SN \1\:VSS VSS) g45n1svt w=(1.45e-07) l=4.5e-08 nf=1 \
        as=2.92e-14 ad=8.7e-15 ps=7.3e-07 pd=4.1e-07 nrd=1.16667 \
        nrs=1.16667 sa=8.3e-07 sb=2e-06 sd=160n sca=16.7245 scb=0.0178071 \
        scc=0.00133148 m=(1)
mn45_1__rcx (\29\:qbint n35 \1\:VSS VSS) g45n1svt w=(2.05e-07) l=4.5e-08 \
        nf=1 as=4.554e-14 ad=3.28e-14 ps=9e-07 pd=7.3e-07 nrd=1.16667 \
        nrs=1.16667 sa=7.61341e-07 sb=2e-06 sd=160n sca=19.867 \
        scb=0.0198061 scc=0.00201945 m=(2)
mn56 (\16\:net331 \18\:qbint \1\:VSS VSS) g45n1svt w=(2.6e-07) l=4.5e-08 \
        nf=1 as=6.24e-14 ad=3.64e-14 ps=1e-06 pd=8e-07 nrd=1.16667 \
        nrs=1.16667 sa=2e-06 sb=1.4e-07 sd=160n sca=17.5885 scb=0.0172826 \
        scc=0.00162584 m=(1)
mn57_1__rcx (\1\:QN net331 \1\:VSS VSS) g45n1svt w=(2.6e-07) l=4.5e-08 \
        nf=1 as=8.73e-14 ad=4.615e-14 ps=1.45e-06 pd=8.75e-07 nrd=1.16667 \
        nrs=1.16667 sa=1.69654e-06 sb=1.135e-06 sd=160n sca=17.5885 \
        scb=0.0172826 scc=0.00162584 m=(4)
mn55_1__rcx (\4\:Q \4\:qbint \1\:VSS VSS) g45n1svt w=(2.6e-07) l=4.5e-08 \
        nf=1 as=8.717e-14 ad=4.16e-14 ps=1.4675e-06 pd=8.4e-07 nrd=1.16667 \
        nrs=1.16667 sa=1.03538e-06 sb=2e-06 sd=160n sca=17.5885 \
        scb=0.0172826 scc=0.00162584 m=(4)
mp45 (\27\:qbint n35 \1\:VDD NW) g45p1svt w=(3.1e-07) l=4.5e-08 nf=1 \
        as=6.829e-14 ad=4.96e-14 ps=1.155e-06 pd=9.4e-07 nrd=1.16667 \
        nrs=1.16667 sa=5.05726e-07 sb=2e-06 sd=160n sca=14.1869 \
        scb=0.0131869 scc=0.000739194 m=(2)
mp56 (\20\:net331 \20\:qbint \1\:VDD NW) g45p1svt w=(3.9e-07) l=4.5e-08 \
        nf=1 as=6.24e-14 ad=5.46e-14 ps=1.1e-06 pd=1.06e-06 nrd=1.16667 \
        nrs=1.16667 sa=1.95487e-06 sb=1.4e-07 sd=160n sca=24.44 \
        scb=0.022002 scc=0.00203224 m=(1)
mp57 (\5\:QN net331 \1\:VDD NW) g45p1svt w=(3.9e-07) l=4.5e-08 nf=1 \
        as=6.24e-14 ad=6.24e-14 ps=1.1e-06 pd=1.1e-06 nrd=1.16667 \
        nrs=1.16667 sa=1.60045e-06 sb=9.6e-07 sd=160n sca=20.5009 \
        scb=0.0171135 scc=0.00197772 m=(4)
mp55_1__rcx (\1\:Q \4\:qbint \1\:VDD NW) g45p1svt w=(3.9e-07) l=4.5e-08 \
        nf=1 as=6.432e-14 ad=6.24e-14 ps=1.115e-06 pd=1.1e-06 nrd=1.16667 \
        nrs=1.16667 sa=7.80449e-07 sb=1.78e-06 sd=160n sca=20.5009 \
        scb=0.0171135 scc=0.00197772 m=(4)
ends DFFSX4
// End of subcircuit definition.
