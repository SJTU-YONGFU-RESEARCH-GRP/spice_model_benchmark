// Generated for: spectre (May  1 11:33:17 2013 )
// Library name: gsclib045_backbias
// Cell name: TLATNCAX20
// View name: extracted

simulator lang=spectre

subckt TLATNCAX20 CK E ECK NW VDD VSS
mp0 (\15\:CKb \1\:CK \49\:VDD NW) g45p1svt w=(2.15e-07) l=4.5e-08 nf=1 \
        as=3.44e-14 ad=3.01e-14 ps=7.5e-07 pd=7.1e-07 nrd=1.16667 \
        nrs=1.16667 sa=1.4e-07 sb=1.32756e-06 sd=160n sca=16.9134 \
        scb=0.0172871 scc=0.000377502 m=(1)
mp5 (net217 \1\:E \49\:VDD NW) g45p1svt w=(2.15e-07) l=4.5e-08 nf=1 \
        as=3.44e-14 ad=4.408e-14 ps=7.5e-07 pd=8.4e-07 nrd=1.16667 \
        nrs=1.16667 sa=3.45e-07 sb=1.12256e-06 sd=160n sca=13.2059 \
        scb=0.0110334 scc=0.000224619 m=(1)
mp6 (\12\:n0 \3\:CKbb net217 NW) g45p1svt w=(2.15e-07) l=4.5e-08 nf=1 \
        as=4.408e-14 ad=3.44e-14 ps=8.4e-07 pd=7.5e-07 nrd=1.16667 \
        nrs=1.16667 sa=5.95e-07 sb=8.72558e-07 sd=160n sca=11.7941 \
        scb=0.00968423 scc=0.000220689 m=(1)
mp16 (\12\:n0 \3\:CKb net205 NW) g45p1svt w=(2.15e-07) l=4.5e-08 nf=1 \
        as=1.505e-14 ad=3.44e-14 ps=5.7e-07 pd=7.5e-07 nrd=1.16667 \
        nrs=1.16667 sa=8e-07 sb=6.67558e-07 sd=160n sca=11.3578 \
        scb=0.0095436 scc=0.000220652 m=(1)
mp15 (net205 \3\:Eint \16\:VDD NW) g45p1svt w=(2.15e-07) l=4.5e-08 nf=1 \
        as=8.72e-14 ad=1.505e-14 ps=1.64e-06 pd=5.7e-07 nrd=1.16667 \
        nrs=1.16667 sa=9.15e-07 sb=5.52558e-07 sd=160n sca=11.3578 \
        scb=0.0095436 scc=0.000220652 m=(1)
mp1 (\26\:CKbb \6\:CKb \16\:VDD NW) g45p1svt w=(2.15e-07) l=4.5e-08 nf=1 \
        as=1.1785e-13 ad=3.01e-14 ps=1.9e-06 pd=7.1e-07 nrd=1.16667 \
        nrs=1.16667 sa=5.7e-07 sb=1.4e-07 sd=160n sca=45.7906 \
        scb=0.0283307 scc=0.00588417 m=(1)
C1 (CK VSS) capacitor c=1.29089e-16
C2 (NW VSS) capacitor c=9.23972e-16
C3 (VDD VSS) capacitor c=4.38465e-17
C4 (ECK VSS) capacitor c=1.71542e-15
C5 (E VSS) capacitor c=3.30934e-17
C6 (CKb VSS) capacitor c=5.45545e-17
C7 (n0 VSS) capacitor c=1.72304e-16
C8 (CKbb VSS) capacitor c=2.9222e-17
C9 (Eint VSS) capacitor c=4.46864e-17
C10 (16 VSS) capacitor c=1.79092e-18
C11 (ECKb VSS) capacitor c=8.97048e-16
C12 (17 VSS) capacitor c=1.79092e-18
C13 (18 VSS) capacitor c=5.30593e-18
C14 (19 VSS) capacitor c=4.59784e-18
C15 (20 VSS) capacitor c=1.74642e-18
C16 (net217 VSS) capacitor c=2.32223e-18
C17 (net205 VSS) capacitor c=1.66895e-18
C18 (\6\:CKb VSS) capacitor c=2.63827e-17
C19 (\3\:Eint VSS) capacitor c=8.74718e-17
C20 (\3\:CKb VSS) capacitor c=7.18051e-17
C21 (\3\:CKbb VSS) capacitor c=7.57684e-17
C22 (\1\:E VSS) capacitor c=3.39582e-17
C23 (\1\:CK VSS) capacitor c=3.15586e-17
C24 (\21\:Eint VSS) capacitor c=7.84571e-17
C25 (\16\:CKbb VSS) capacitor c=4.60661e-17
C26 (\17\:CKbb VSS) capacitor c=2.48713e-17
C27 (\15\:Eint VSS) capacitor c=2.64639e-17
C28 (\16\:Eint VSS) capacitor c=2.59984e-17
C29 (\11\:CKbb VSS) capacitor c=2.38625e-17
C30 (\10\:CKbb VSS) capacitor c=4.47183e-17
C31 (\4\:Eint VSS) capacitor c=6.21368e-17
C32 (\8\:Eint VSS) capacitor c=5.73247e-17
C33 (\4\:CKbb VSS) capacitor c=5.56558e-17
C34 (\5\:CKb VSS) capacitor c=4.75573e-17
C35 (\3\:E VSS) capacitor c=9.24821e-17
C36 (\3\:CK VSS) capacitor c=5.67228e-17
C37 (\5\:CKbb VSS) capacitor c=7.91621e-16
C38 (\7\:CKb VSS) capacitor c=2.38322e-17
C39 (\2\:Eint VSS) capacitor c=8.22087e-17
C40 (\2\:CKbb VSS) capacitor c=7.37836e-17
C41 (\4\:CKb VSS) capacitor c=3.13985e-17
C42 (\2\:CKb VSS) capacitor c=4.63369e-17
C43 (\2\:E VSS) capacitor c=6.29269e-17
C44 (\2\:CK VSS) capacitor c=5.25691e-17
C45 (\1\:VDD VSS) capacitor c=1.75765e-15
C46 (\68\:ECKb VSS) capacitor c=6.00307e-16
C47 (\26\:CKbb VSS) capacitor c=4.81888e-17
C48 (\28\:Eint VSS) capacitor c=1.32986e-16
C49 (\12\:n0 VSS) capacitor c=4.02007e-17
C50 (\49\:VDD VSS) capacitor c=4.7527e-17
C51 (\15\:CKb VSS) capacitor c=7.93376e-17
C52 (\77\:ECKb VSS) capacitor c=1.04635e-16
C53 (\85\:ECKb VSS) capacitor c=1.55228e-16
C54 (\87\:ECKb VSS) capacitor c=7.82884e-17
C55 (\23\:CKbb VSS) capacitor c=7.1378e-17
C56 (\26\:Eint VSS) capacitor c=5.73951e-17
C57 (\10\:n0 VSS) capacitor c=6.0877e-17
C58 (\12\:CKb VSS) capacitor c=1.96308e-17
C59 (\5\:Eint VSS) capacitor c=8.59643e-16
C60 (\12\:Eint VSS) capacitor c=2.36085e-17
C61 (\13\:Eint VSS) capacitor c=1.84886e-17
C62 (\4\:E VSS) capacitor c=1.00251e-16
C63 (\8\:n0 VSS) capacitor c=4.12254e-17
C64 (\9\:n0 VSS) capacitor c=8.9205e-17
C65 (\8\:CKb VSS) capacitor c=9.36964e-17
C66 (\9\:CKb VSS) capacitor c=1.32862e-16
C67 (\10\:CKb VSS) capacitor c=1.54865e-16
C68 (\11\:CKb VSS) capacitor c=1.05407e-16
C69 (\14\:CKb VSS) capacitor c=1.96121e-17
C70 (\22\:CKbb VSS) capacitor c=3.06738e-17
C71 (\25\:CKbb VSS) capacitor c=1.12246e-16
C72 (\30\:Eint VSS) capacitor c=5.1708e-17
C73 (\71\:ECKb VSS) capacitor c=9.11116e-17
C74 (\16\:VDD VSS) capacitor c=1.64781e-16
C75 (\18\:VDD VSS) capacitor c=6.39021e-17
Rk1 (\4\:CK CK) resistor r=0.01805 c=0
Rk85 (\1\:VDD \16\:VDD) resistor r=0.2204 c=0
Rk88 (\18\:VDD VDD) resistor r=0.1677 c=0
Rk87 (\16\:VDD \18\:VDD) resistor r=0.3885 c=0
Rk104 (\18\:VDD \50\:VDD) resistor r=0.285 c=0
Rk4 (\4\:E E) resistor r=0.03911 c=0
Rk116 (\1\:VSS \15\:VSS) resistor r=0.1403 c=0
Rk117 (\15\:VSS \16\:VSS) resistor r=0.3609 c=0
Rk118 (\16\:VSS \17\:VSS) resistor r=0.4302 c=0
Rk121 (\19\:VSS VSS) resistor r=0.1626 c=0
Rk120 (\17\:VSS \19\:VSS) resistor r=0.3887 c=0
Rk130 (\15\:VSS \37\:VSS) resistor r=0.2541 c=0
Rk131 (\16\:VSS \39\:VSS) resistor r=0.2541 c=0
Rk134 (\19\:VSS \45\:VSS) resistor r=0.1776 c=0
Rk8 (\8\:CKb \9\:CKb) resistor r=0.6959 c=0
Rk9 (\9\:CKb \10\:CKb) resistor r=0.7369 c=0
Rk10 (\10\:CKb \11\:CKb) resistor r=0.4567 c=0
Rk11 (\11\:CKb \13\:CKb) resistor r=0.09782 c=0
Rk12 (\9\:CKb \14\:CKb) resistor r=0.03511 c=0
Rk13 (\11\:CKb \16\:CKb) resistor r=0.6805 c=0
Rk5 (\8\:n0 \9\:n0) resistor r=0.3307 c=0
Rk6 (\9\:n0 \11\:n0) resistor r=0.392 c=0
Rk7 (\9\:n0 \13\:n0) resistor r=0.2538 c=0
Rk16 (\5\:CKbb \22\:CKbb) resistor r=0.3006 c=0
Rk17 (\22\:CKbb \24\:CKbb) resistor r=0.1182 c=0
Rk18 (\24\:CKbb \25\:CKbb) resistor r=0.7789 c=0
Rk19 (\22\:CKbb \27\:CKbb) resistor r=0.1619 c=0
Rk22 (\5\:Eint \25\:Eint) resistor r=1.0003 c=0
Rk23 (\25\:Eint \27\:Eint) resistor r=0.2408 c=0
Rk24 (\25\:Eint \29\:Eint) resistor r=0.03277 c=0
Rk25 (\27\:Eint \30\:Eint) resistor r=0.2633 c=0
Rk27 (\68\:ECKb \71\:ECKb) resistor r=0.3866 c=0
Rk32 (\71\:ECKb \78\:ECKb) resistor r=0.3928 c=0
Rk36 (\78\:ECKb \86\:ECKb) resistor r=0.7162 c=0
Rk37 (\86\:ECKb \88\:ECKb) resistor r=0.4711 c=0
Rl1 (\1\:CK \2\:CK) resistor r=24.2328 c=0
Rl2 (\2\:CK \3\:CK) resistor r=231.925 c=0
Rl3 (\1\:E \2\:E) resistor r=35.7134 c=0
Rl4 (\2\:E \3\:E) resistor r=216.483 c=0
Rl17 (\5\:CKb \6\:CKb) resistor r=94.0778 c=0
Rl18 (\6\:CKb \7\:CKb) resistor r=50.6918 c=0
Rl6 (\3\:CKb \4\:CKb) resistor r=29.5379 c=0
Rl5 (CKb \2\:CKb) resistor r=93.4636 c=0
Rl42 (\5\:CKbb \16\:CKbb) resistor r=28.0797 c=0
Rl43 (\5\:CKbb \17\:CKbb) resistor r=31.8361 c=0
Rl29 (\5\:CKbb \11\:CKbb) resistor r=30.0028 c=0
Rl28 (\5\:CKbb \10\:CKbb) resistor r=29.579 c=0
Rl19 (\5\:CKbb \4\:CKbb) resistor r=28.6412 c=0
Rl8 (\2\:CKbb \3\:CKbb) resistor r=279.104 c=0
Rl7 (\2\:CKbb CKbb) resistor r=29.5379 c=0
Rl10 (\2\:Eint \3\:Eint) resistor r=194.129 c=0
Rl9 (\2\:Eint Eint) resistor r=70.3288 c=0
Rl46 (\5\:Eint \21\:Eint) resistor r=90.1797 c=0
Rl21 (\5\:Eint \4\:Eint) resistor r=124.51 c=0
Rl24 (\5\:Eint \8\:Eint) resistor r=94.6154 c=0
Rl35 (\12\:Eint \15\:Eint) resistor r=28.0797 c=0
Rl32 (\12\:Eint \5\:Eint) resistor r=91.3489 c=0
Rl36 (\13\:Eint \16\:Eint) resistor r=25.0634 c=0
Rl34 (\13\:Eint \5\:Eint) resistor r=27.8457 c=0
Rl33 (\13\:Eint \12\:Eint) resistor r=102.268 c=0
Rz26 (\37\:VSS \36\:VSS) resistor r=75 c=0
Rz27 (\39\:VSS \38\:VSS) resistor r=75 c=0
Rz30 (\45\:VSS \44\:VSS) resistor r=75 c=0
Rz2 (\12\:CKb \13\:CKb) resistor r=75 c=0
Rz1 (\11\:n0 \10\:n0) resistor r=75 c=0
Rz3 (\24\:CKbb \23\:CKbb) resistor r=75 c=0
Rz4 (\27\:Eint \26\:Eint) resistor r=75 c=0
Rz5 (\78\:ECKb \77\:ECKb) resistor r=75 c=0
Rz6 (\86\:ECKb \85\:ECKb) resistor r=75 c=0
Rz7 (\88\:ECKb \87\:ECKb) resistor r=75 c=0
Ry35 (\50\:VDD \49\:VDD) resistor r=62 c=0
Ry39 (\17\:VSS \1\:VSS) resistor r=5.1667 c=0
Ry2 (\15\:CKb \16\:CKb) resistor r=62 c=0
Ry1 (\13\:n0 \12\:n0) resistor r=62 c=0
Ry3 (\27\:CKbb \26\:CKbb) resistor r=62 c=0
Ry4 (\29\:Eint \28\:Eint) resistor r=62 c=0
Rx1 (\2\:CK \4\:CK) resistor r=45 c=0
Rx2 (\2\:E \4\:E) resistor r=45 c=0
Rx4 (\7\:CKb \8\:CKb) resistor r=45 c=0
Rx5 (\2\:CKb \10\:CKb) resistor r=45 c=0
Rx6 (\4\:CKb \14\:CKb) resistor r=45 c=0
Rx3 (\8\:n0 n0) resistor r=45 c=0
Rx10 (\25\:CKbb \2\:CKbb) resistor r=45 c=0
Rx14 (\30\:Eint \2\:Eint) resistor r=45 c=0
Rx15 (\71\:ECKb ECKb) resistor r=45 c=0
mn0 (\12\:CKb \3\:CK \44\:VSS VSS) g45n1svt w=(1.45e-07) l=4.5e-08 nf=1 \
        as=2.32e-14 ad=2.03e-14 ps=6.1e-07 pd=5.7e-07 nrd=1.16667 \
        nrs=1.16667 sa=1.4e-07 sb=9.85e-07 sd=160n sca=6.59604 \
        scb=0.00318587 scc=2.16275e-05 m=(1)
mn5 (net254 \3\:E \44\:VSS VSS) g45n1svt w=(1.45e-07) l=4.5e-08 nf=1 \
        as=2.32e-14 ad=8.7e-15 ps=6.1e-07 pd=4.1e-07 nrd=1.16667 \
        nrs=1.16667 sa=3.45e-07 sb=7.8e-07 sd=160n sca=6.59604 \
        scb=0.00318587 scc=2.16275e-05 m=(1)
mn6 (\10\:n0 CKb net254 VSS) g45n1svt w=(1.45e-07) l=4.5e-08 nf=1 \
        as=8.7e-15 ad=4.132e-14 ps=4.1e-07 pd=8.6e-07 nrd=1.16667 \
        nrs=1.16667 sa=4.5e-07 sb=6.75e-07 sd=160n sca=6.59604 \
        scb=0.00318587 scc=2.16275e-05 m=(1)
mn16 (\10\:n0 CKbb net230 VSS) g45n1svt w=(1.45e-07) l=4.5e-08 nf=1 \
        as=1.885e-14 ad=4.132e-14 ps=5.5e-07 pd=8.6e-07 nrd=1.16667 \
        nrs=1.16667 sa=7.8e-07 sb=3.45e-07 sd=160n sca=6.59604 \
        scb=0.00318587 scc=2.16275e-05 m=(1)
mn15 (net230 Eint \17\:VSS VSS) g45n1svt w=(1.45e-07) l=4.5e-08 nf=1 \
        as=6.99e-14 ad=1.885e-14 ps=1.6e-06 pd=5.5e-07 nrd=1.16667 \
        nrs=1.16667 sa=9.55e-07 sb=1.7e-07 sd=160n sca=6.59604 \
        scb=0.00318587 scc=2.16275e-05 m=(1)
mn1 (\23\:CKbb \5\:CKb \17\:VSS VSS) g45n1svt w=(1.45e-07) l=4.5e-08 \
        nf=1 as=8.985e-14 ad=2.03e-14 ps=1.6e-06 pd=5.7e-07 nrd=1.16667 \
        nrs=1.16667 sa=5.7e-07 sb=1.4e-07 sd=160n sca=23.279 scb=0.0230742 \
        scc=0.00267719 m=(1)
mn21_1__rcx (\87\:ECKb \4\:CKbb 16 VSS) g45n1svt w=(2.6e-07) l=4.5e-08 \
        nf=1 as=1.56e-14 ad=3.64e-14 ps=6.4e-07 pd=8e-07 nrd=1.16667 \
        nrs=1.16667 sa=1.4e-07 sb=2e-06 sd=160n sca=13.198 scb=0.0131159 \
        scc=0.000803647 m=(1)
mn20_1__rcx (16 \8\:Eint \38\:VSS VSS) g45n1svt w=(2.6e-07) l=4.5e-08 \
        nf=1 as=4.16e-14 ad=1.56e-14 ps=8.4e-07 pd=6.4e-07 nrd=1.16667 \
        nrs=1.16667 sa=2.45e-07 sb=2e-06 sd=160n sca=13.198 scb=0.0131159 \
        scc=0.000803647 m=(1)
mn20_2__rcx (17 \4\:Eint \38\:VSS VSS) g45n1svt w=(2.6e-07) l=4.5e-08 \
        nf=1 as=4.16e-14 ad=1.56e-14 ps=8.4e-07 pd=6.4e-07 nrd=1.16667 \
        nrs=1.16667 sa=4.5e-07 sb=2e-06 sd=160n sca=13.198 scb=0.0131159 \
        scc=0.000803647 m=(1)
mn21_2__rcx (\85\:ECKb \10\:CKbb 17 VSS) g45n1svt w=(2.6e-07) l=4.5e-08 \
        nf=1 as=1.56e-14 ad=4.16e-14 ps=6.4e-07 pd=8.4e-07 nrd=1.16667 \
        nrs=1.16667 sa=5.55e-07 sb=2e-06 sd=160n sca=13.198 scb=0.0131159 \
        scc=0.000803647 m=(1)
mn21_3__rcx (\85\:ECKb \11\:CKbb 18 VSS) g45n1svt w=(2.6e-07) l=4.5e-08 \
        nf=1 as=4.16e-14 ad=4.16e-14 ps=8.4e-07 pd=8.4e-07 nrd=1.16667 \
        nrs=1.16667 sa=7.6e-07 sb=2e-06 sd=160n sca=13.198 scb=0.0131159 \
        scc=0.000803647 m=(1)
mn20_3__rcx (18 \16\:Eint \36\:VSS VSS) g45n1svt w=(2.6e-07) l=4.5e-08 \
        nf=1 as=7.93e-14 ad=4.16e-14 ps=1.13e-06 pd=8.4e-07 nrd=1.16667 \
        nrs=1.16667 sa=9.65e-07 sb=2e-06 sd=160n sca=13.198 scb=0.0131159 \
        scc=0.000803647 m=(1)
mn20_4__rcx (19 \15\:Eint \36\:VSS VSS) g45n1svt w=(2.6e-07) l=4.5e-08 \
        nf=1 as=7.93e-14 ad=4.16e-14 ps=1.13e-06 pd=8.4e-07 nrd=1.16667 \
        nrs=1.16667 sa=1.315e-06 sb=2e-06 sd=160n sca=13.198 scb=0.0131159 \
        scc=0.000803647 m=(1)
mn21_4__rcx (\77\:ECKb \17\:CKbb 19 VSS) g45n1svt w=(2.6e-07) l=4.5e-08 \
        nf=1 as=4.16e-14 ad=4.16e-14 ps=8.4e-07 pd=8.4e-07 nrd=1.16667 \
        nrs=1.16667 sa=1.52e-06 sb=2e-06 sd=160n sca=13.198 scb=0.0131159 \
        scc=0.000803647 m=(1)
mn21 (\77\:ECKb \16\:CKbb 20 VSS) g45n1svt w=(2.6e-07) l=4.5e-08 nf=1 \
        as=1.56e-14 ad=4.16e-14 ps=6.4e-07 pd=8.4e-07 nrd=1.16667 \
        nrs=1.16667 sa=1.725e-06 sb=2e-06 sd=160n sca=13.198 scb=0.0131159 \
        scc=0.000803647 m=(1)
mn20 (20 \21\:Eint \1\:VSS VSS) g45n1svt w=(2.6e-07) l=4.5e-08 nf=1 \
        as=5.91e-14 ad=1.56e-14 ps=1.03e-06 pd=6.4e-07 nrd=1.16667 \
        nrs=1.16667 sa=1.83e-06 sb=2e-06 sd=160n sca=13.198 scb=0.0131159 \
        scc=0.000803647 m=(1)
mn10_1__rcx (\26\:Eint n0 \17\:VSS VSS) g45n1svt w=(2.6e-07) l=4.5e-08 \
        nf=1 as=7.987e-14 ad=4.16e-14 ps=1.6e-06 pd=8.4e-07 nrd=1.16667 \
        nrs=1.16667 sa=1e-07 sb=5.06058e-07 sd=160n sca=17.5885 \
        scb=0.0172826 scc=0.00162584 m=(2)
mn22_1__rcx (ECK ECKb \1\:VSS VSS) g45n1svt w=(3.05e-07) l=4.5e-08 nf=1 \
        as=4.941e-14 ad=4.916e-14 ps=9.3588e-07 pd=9.3235e-07 nrd=1.16667 \
        nrs=1.16667 sa=1.71967e-06 sb=2e-06 sd=160n sca=16.121 \
        scb=0.0155296 scc=0.00139557 m=(17)
mp10_1__rcx (\28\:Eint n0 \16\:VDD NW) g45p1svt w=(3.9e-07) l=4.5e-08 \
        nf=1 as=1.0252e-13 ad=6.24e-14 ps=1.77e-06 pd=1.1e-06 nrd=1.16667 \
        nrs=1.16667 sa=5.84615e-07 sb=5.04551e-07 sd=160n sca=30.5009 \
        scb=0.0202006 scc=0.00336097 m=(2)
mp21_1__rcx (\68\:ECKb \5\:CKbb \1\:VDD NW) g45p1svt w=(3.9e-07) \
        l=4.5e-08 nf=1 as=5.868e-14 ad=6.24e-14 ps=1.092e-06 pd=1.1e-06 \
        nrd=1.16667 nrs=1.16667 sa=1.12308e-07 sb=2e-06 sd=160n \
        sca=13.5671 scb=0.012183 scc=0.000647513 m=(5)
mp20 (\68\:ECKb \5\:Eint \1\:VDD NW) g45p1svt w=(3.9e-07) l=4.5e-08 nf=1 \
        as=9.497e-14 ad=6.24e-14 ps=1.424e-06 pd=1.1e-06 nrd=1.16667 \
        nrs=1.16667 sa=3.17308e-07 sb=2e-06 sd=160n sca=13.5671 \
        scb=0.012183 scc=0.000647513 m=(5)
mp22_1__rcx (ECK ECKb \1\:VDD NW) g45p1svt w=(4.6e-07) l=4.5e-08 nf=1 \
        as=7.332e-14 ad=7.36e-14 ps=1.24e-06 pd=1.24e-06 nrd=1.16667 \
        nrs=1.16667 sa=1.71087e-06 sb=2e-06 sd=160n sca=18.2478 \
        scb=0.0152569 scc=0.00157133 m=(16)
mp22_16__rcx (ECK ECKb \1\:VDD NW) g45p1svt w=(4.55e-07) l=4.5e-08 nf=1 \
        as=7.33e-14 ad=6.37e-14 ps=1.24e-06 pd=1.19e-06 nrd=1.16667 \
        nrs=1.16667 sa=2e-06 sb=1.4e-07 sd=160n sca=25.0172 scb=0.024999 \
        scc=0.0018514 m=(1)
ends TLATNCAX20
// End of subcircuit definition.
