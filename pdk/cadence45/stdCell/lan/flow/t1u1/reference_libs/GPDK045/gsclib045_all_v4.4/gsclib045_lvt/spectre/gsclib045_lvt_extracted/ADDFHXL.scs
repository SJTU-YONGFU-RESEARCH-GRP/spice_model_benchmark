// Generated for: spectre (May  1 09:10:56 2013 )
// Library name: gsclib045_lvt
// Cell name: ADDFHXL
// View name: extracted

simulator lang=spectre

subckt ADDFHXL A B CI CO S VDD VSS
mp12 (\1\:CO COb \16\:VDD VDD) g45p1lvt w=(3.1e-07) l=4.5e-08 nf=1 \
        as=4.34e-14 ad=4.34e-14 ps=9e-07 pd=9e-07 nrd=1.16667 nrs=1.16667 \
        sa=1.4e-07 sb=1.4e-07 sd=160n sca=43.8293 scb=0.0353699 \
        scc=0.00464516 m=(1)
mp2 (n3 \1\:A \14\:VDD VDD) g45p1lvt w=(3.1e-07) l=4.5e-08 nf=1 \
        as=7.265e-14 ad=4.34e-14 ps=1.77e-06 pd=9e-07 nrd=1.16667 \
        nrs=1.16667 sa=1.4e-07 sb=3.55484e-07 sd=160n sca=19.2885 \
        scb=0.0175179 scc=0.00172295 m=(1)
mp3 (\3\:n3 \1\:B \14\:VDD VDD) g45p1lvt w=(3.1e-07) l=4.5e-08 nf=1 \
        as=7.265e-14 ad=4.96e-14 ps=1.77e-06 pd=9.4e-07 nrd=1.16667 \
        nrs=1.16667 sa=2.36452e-07 sb=3.45e-07 sd=160n sca=11.3312 \
        scb=0.00941412 scc=0.000228915 m=(1)
mp4 (\12\:COb \1\:CI \3\:n3 VDD) g45p1lvt w=(3.1e-07) l=4.5e-08 nf=1 \
        as=4.96e-14 ad=4.34e-14 ps=9.4e-07 pd=9e-07 nrd=1.16667 \
        nrs=1.16667 sa=4.41452e-07 sb=1.4e-07 sd=160n sca=11.3312 \
        scb=0.00941412 scc=0.000228915 m=(1)
mp1 (\9\:COb \6\:B n1 VDD) g45p1lvt w=(3.1e-07) l=4.5e-08 nf=1 \
        as=1.86e-14 ad=4.65e-14 ps=7.4e-07 pd=9.2e-07 nrd=1.16667 \
        nrs=1.16667 sa=1.5e-07 sb=9.14839e-07 sd=160n sca=10.6008 \
        scb=0.00822388 scc=0.000121216 m=(1)
mp0 (n1 \6\:A \12\:VDD VDD) g45p1lvt w=(3.1e-07) l=4.5e-08 nf=1 \
        as=9.455e-14 ad=1.86e-14 ps=1.23e-06 pd=7.4e-07 nrd=1.16667 \
        nrs=1.16667 sa=2.55e-07 sb=8.09839e-07 sd=160n sca=10.6008 \
        scb=0.00822388 scc=0.000121216 m=(1)
mp7 (\3\:n5 \5\:CI \12\:VDD VDD) g45p1lvt w=(3.1e-07) l=4.5e-08 nf=1 \
        as=9.455e-14 ad=4.96e-14 ps=1.23e-06 pd=9.4e-07 nrd=1.16667 \
        nrs=1.16667 sa=6.05e-07 sb=4.59839e-07 sd=160n sca=10.6008 \
        scb=0.00822388 scc=0.000121216 m=(1)
mp6 (\3\:n5 \7\:B \1\:VDD VDD) g45p1lvt w=(3.1e-07) l=4.5e-08 nf=1 \
        as=7.265e-14 ad=4.96e-14 ps=1.77e-06 pd=9.4e-07 nrd=1.16667 \
        nrs=1.16667 sa=8.1e-07 sb=2.54839e-07 sd=160n sca=10.6008 \
        scb=0.00822388 scc=0.000121216 m=(1)
mp5 (n5 \9\:A \1\:VDD VDD) g45p1lvt w=(3.1e-07) l=4.5e-08 nf=1 \
        as=7.265e-14 ad=5.48e-14 ps=1.77e-06 pd=1.2e-06 nrd=1.16667 \
        nrs=1.16667 sa=4.50323e-07 sb=2.19032e-07 sd=160n sca=19.1541 \
        scb=0.0174883 scc=0.00172295 m=(1)
mp8 (\11\:Sb \6\:COb n5 VDD) g45p1lvt w=(3.1e-07) l=4.5e-08 nf=1 \
        as=5.48e-14 ad=5.32e-14 ps=1.2e-06 pd=1.19e-06 nrd=1.16667 \
        nrs=1.16667 sa=5.69355e-07 sb=1.71613e-07 sd=160n sca=11.3312 \
        scb=0.00941412 scc=0.000228915 m=(1)
mp11 (\9\:Sb \11\:CI n9 VDD) g45p1lvt w=(3.1e-07) l=4.5e-08 nf=1 \
        as=4.185e-14 ad=3.58e-14 ps=8.9e-07 pd=9e-07 nrd=1.16667 \
        nrs=1.16667 sa=1.15484e-07 sb=8.2e-07 sd=160n sca=11.3312 \
        scb=0.00941412 scc=0.000228915 m=(1)
mp10 (n9 \10\:B n8 VDD) g45p1lvt w=(3.1e-07) l=4.5e-08 nf=1 as=3.1e-14 \
        ad=4.185e-14 ps=8.2e-07 pd=8.9e-07 nrd=1.16667 nrs=1.16667 \
        sa=2.95484e-07 sb=6.4e-07 sd=160n sca=11.4887 scb=0.00945 \
        scc=0.00022892 m=(1)
mp9 (n8 \10\:A \10\:VDD VDD) g45p1lvt w=(3.1e-07) l=4.5e-08 nf=1 \
        as=9.62e-14 ad=3.1e-14 ps=1.4e-06 pd=8.2e-07 nrd=1.16667 \
        nrs=1.16667 sa=4.40484e-07 sb=4.95e-07 sd=160n sca=11.9282 \
        scb=0.00964102 scc=0.000229002 m=(1)
mp13 (\4\:S Sb \10\:VDD VDD) g45p1lvt w=(3.1e-07) l=4.5e-08 nf=1 \
        as=9.62e-14 ad=5.89e-14 ps=1.4e-06 pd=1e-06 nrd=1.16667 \
        nrs=1.16667 sa=7.45484e-07 sb=1.9e-07 sd=160n sca=14.4228 \
        scb=0.0128311 scc=0.000253304 m=(1)
C1 (VDD VSS) capacitor c=2.99258e-16
C2 (B VSS) capacitor c=1.39893e-16
C3 (CI VSS) capacitor c=6.0747e-17
C4 (CO VSS) capacitor c=6.4289e-17
C5 (S VSS) capacitor c=2.33964e-17
C6 (COb VSS) capacitor c=2.42014e-17
C7 (n2 VSS) capacitor c=7.81101e-17
C8 (n4 VSS) capacitor c=7.39192e-17
C9 (Sb VSS) capacitor c=4.18344e-17
C10 (n7 VSS) capacitor c=2.09961e-18
C11 (n6 VSS) capacitor c=3.49935e-18
C12 (n3 VSS) capacitor c=6.50969e-17
C13 (n1 VSS) capacitor c=1.71568e-18
C14 (n5 VSS) capacitor c=8.26506e-17
C15 (n9 VSS) capacitor c=3.83514e-18
C16 (n8 VSS) capacitor c=3.16792e-18
C17 (\10\:A VSS) capacitor c=6.16299e-17
C18 (\10\:B VSS) capacitor c=5.33096e-17
C19 (\11\:CI VSS) capacitor c=7.05701e-17
C20 (\6\:COb VSS) capacitor c=4.28184e-17
C21 (\9\:A VSS) capacitor c=6.83846e-17
C22 (\7\:B VSS) capacitor c=5.15558e-17
C23 (\5\:CI VSS) capacitor c=6.25839e-17
C24 (\6\:A VSS) capacitor c=7.80256e-17
C25 (\6\:B VSS) capacitor c=6.34952e-17
C26 (\1\:CI VSS) capacitor c=6.24736e-17
C27 (\1\:B VSS) capacitor c=5.14322e-17
C28 (\1\:A VSS) capacitor c=5.00304e-17
C29 (\3\:Sb VSS) capacitor c=2.5183e-17
C30 (\12\:A VSS) capacitor c=5.02258e-17
C31 (\12\:B VSS) capacitor c=8.75567e-17
C32 (\8\:CI VSS) capacitor c=5.10374e-17
C33 (\4\:COb VSS) capacitor c=5.2395e-17
C34 (\7\:A VSS) capacitor c=5.07578e-17
C35 (\9\:B VSS) capacitor c=6.05018e-17
C36 (\7\:CI VSS) capacitor c=3.37279e-17
C37 (\4\:A VSS) capacitor c=6.80535e-17
C38 (\4\:B VSS) capacitor c=1.03476e-16
C39 (\3\:CI VSS) capacitor c=3.23125e-17
C40 (\3\:B VSS) capacitor c=5.40402e-17
C41 (\3\:A VSS) capacitor c=4.68315e-17
C42 (\3\:COb VSS) capacitor c=3.09934e-17
C43 (\2\:Sb VSS) capacitor c=3.2719e-17
C44 (\11\:A VSS) capacitor c=4.59596e-17
C45 (\11\:B VSS) capacitor c=6.06031e-17
C46 (\10\:CI VSS) capacitor c=2.73445e-17
C47 (\7\:COb VSS) capacitor c=2.2357e-17
C48 (\8\:A VSS) capacitor c=4.76039e-17
C49 (\8\:B VSS) capacitor c=6.06154e-17
C50 (\6\:CI VSS) capacitor c=5.25396e-17
C51 (\5\:A VSS) capacitor c=7.23717e-17
C52 (\5\:B VSS) capacitor c=6.0704e-17
C53 (\4\:CI VSS) capacitor c=4.70164e-17
C54 (\2\:B VSS) capacitor c=5.44883e-17
C55 (\2\:A VSS) capacitor c=3.58522e-17
C56 (\2\:COb VSS) capacitor c=1.67311e-17
C57 (\4\:S VSS) capacitor c=5.11479e-17
C58 (\10\:VDD VSS) capacitor c=6.00986e-17
C59 (\9\:Sb VSS) capacitor c=8.81568e-17
C60 (\11\:Sb VSS) capacitor c=4.79826e-17
C61 (\1\:VDD VSS) capacitor c=2.89079e-17
C62 (\3\:n5 VSS) capacitor c=8.41487e-17
C63 (\12\:VDD VSS) capacitor c=4.72885e-17
C64 (\9\:COb VSS) capacitor c=1.7666e-16
C65 (\12\:COb VSS) capacitor c=2.94243e-17
C66 (\3\:n3 VSS) capacitor c=7.07553e-17
C67 (\14\:VDD VSS) capacitor c=2.42685e-17
C68 (\1\:CO VSS) capacitor c=9.0773e-17
C69 (\16\:VDD VSS) capacitor c=4.25392e-17
C70 (\5\:VDD VSS) capacitor c=6.67146e-17
C71 (\2\:S VSS) capacitor c=5.5611e-17
C72 (\4\:Sb VSS) capacitor c=7.22113e-17
C73 (\6\:Sb VSS) capacitor c=4.9118e-17
C74 (\3\:n4 VSS) capacitor c=7.14466e-17
C75 (\19\:COb VSS) capacitor c=5.36657e-17
C76 (\16\:COb VSS) capacitor c=1.43732e-17
C77 (\3\:n2 VSS) capacitor c=7.08557e-17
C78 (\3\:CO VSS) capacitor c=6.13067e-17
C79 (\2\:CI VSS) capacitor c=3.14316e-17
C80 (\5\:COb VSS) capacitor c=4.88869e-17
C81 (\9\:CI VSS) capacitor c=4.46223e-17
C82 (\8\:COb VSS) capacitor c=1.99e-16
C83 (\11\:COb VSS) capacitor c=1.22069e-16
C84 (\14\:COb VSS) capacitor c=2.07134e-16
C85 (\15\:COb VSS) capacitor c=1.10778e-16
C86 (\18\:COb VSS) capacitor c=4.97576e-17
C87 (\12\:CI VSS) capacitor c=1.44026e-16
C88 (\13\:CI VSS) capacitor c=1.44858e-16
C89 (\14\:CI VSS) capacitor c=3.85465e-17
C90 (\13\:B VSS) capacitor c=1.23834e-16
C91 (\14\:B VSS) capacitor c=2.10704e-16
C92 (\16\:B VSS) capacitor c=8.19519e-17
C93 (\13\:A VSS) capacitor c=1.37541e-16
C94 (\14\:A VSS) capacitor c=1.92826e-16
C95 (\15\:A VSS) capacitor c=1.90736e-16
C96 (\16\:A VSS) capacitor c=1.07257e-16
C97 (\8\:Sb VSS) capacitor c=1.78473e-16
C98 (\3\:VDD VSS) capacitor c=3.71556e-17
C99 (\4\:VDD VSS) capacitor c=3.23972e-17
C100 (\7\:VDD VSS) capacitor c=1.9723e-17
C101 (\8\:VDD VSS) capacitor c=1.43541e-17
Rk22 (A \13\:A) resistor r=0.003104 c=0
Rk23 (\13\:A \14\:A) resistor r=0.9007 c=0
Rk24 (\14\:A \15\:A) resistor r=0.5026 c=0
Rk25 (\15\:A \16\:A) resistor r=0.7694 c=0
Rk44 (\2\:VSS \3\:VSS) resistor r=0.2878 c=0
Rk45 (\3\:VSS \5\:VSS) resistor r=0.4337 c=0
Rk46 (\5\:VSS \6\:VSS) resistor r=0.1192 c=0
Rk48 (\7\:VSS VSS) resistor r=0.03466 c=0
Rk47 (\6\:VSS \7\:VSS) resistor r=0.3949 c=0
Rk49 (\3\:VSS \8\:VSS) resistor r=0.2103 c=0
Rk50 (\8\:VSS \10\:VSS) resistor r=0.1995 c=0
Rk51 (\6\:VSS \12\:VSS) resistor r=0.04331 c=0
Rk52 (\7\:VSS \14\:VSS) resistor r=0.2744 c=0
Rk53 (\8\:VSS \15\:VSS) resistor r=0.4587 c=0
Rk54 (\15\:VSS \17\:VSS) resistor r=0.4208 c=0
Rk33 (\2\:VDD \3\:VDD) resistor r=0.04331 c=0
Rk34 (\3\:VDD \4\:VDD) resistor r=0.2921 c=0
Rk35 (\4\:VDD \6\:VDD) resistor r=0.3659 c=0
Rk36 (\6\:VDD \7\:VDD) resistor r=0.1192 c=0
Rk38 (\8\:VDD VDD) resistor r=0.03466 c=0
Rk37 (\7\:VDD \8\:VDD) resistor r=0.3949 c=0
Rk39 (\3\:VDD \9\:VDD) resistor r=0.4427 c=0
Rk40 (\9\:VDD \11\:VDD) resistor r=0.3406 c=0
Rk41 (\4\:VDD \13\:VDD) resistor r=0.1857 c=0
Rk42 (\7\:VDD \15\:VDD) resistor r=0.04331 c=0
Rk43 (\8\:VDD \17\:VDD) resistor r=0.3628 c=0
Rk18 (\13\:B \14\:B) resistor r=0.9231 c=0
Rk20 (\15\:B B) resistor r=0.005207 c=0
Rk19 (\14\:B \15\:B) resistor r=0.5499 c=0
Rk21 (\15\:B \16\:B) resistor r=0.4236 c=0
Rk16 (\13\:CI CI) resistor r=0.3243 c=0
Rk15 (\12\:CI \13\:CI) resistor r=0.8368 c=0
Rk17 (CI \14\:CI) resistor r=0.06635 c=0
Rk1 (\2\:CO CO) resistor r=0.4648 c=0
Rk2 (CO \4\:CO) resistor r=0.2836 c=0
Rk30 (S \1\:S) resistor r=0.07549 c=0
Rk31 (\1\:S \3\:S) resistor r=0.08787 c=0
Rk32 (\1\:S \5\:S) resistor r=0.4153 c=0
Rk7 (\8\:COb \10\:COb) resistor r=1.3892 c=0
Rk8 (\10\:COb \11\:COb) resistor r=0.1621 c=0
Rk9 (\11\:COb \13\:COb) resistor r=0.06391 c=0
Rk10 (\11\:COb \14\:COb) resistor r=1.0341 c=0
Rk11 (\14\:COb \15\:COb) resistor r=0.8971 c=0
Rk12 (\15\:COb \17\:COb) resistor r=0.03458 c=0
Rk13 (\14\:COb \18\:COb) resistor r=0.159 c=0
Rk14 (\15\:COb \20\:COb) resistor r=0.2602 c=0
Rk4 (\2\:n2 \4\:n2) resistor r=0.2822 c=0
Rk6 (\2\:n4 \4\:n4) resistor r=0.2778 c=0
Rk26 (\5\:Sb \7\:Sb) resistor r=0.2431 c=0
Rk27 (\5\:Sb \8\:Sb) resistor r=0.5482 c=0
Rk28 (\8\:Sb \10\:Sb) resistor r=0.873 c=0
Rk29 (\10\:Sb \12\:Sb) resistor r=0.1246 c=0
Rk3 (\2\:n3 \4\:n3) resistor r=0.2195 c=0
Rk5 (\2\:n5 \4\:n5) resistor r=0.2402 c=0
Rl28 (\10\:A \11\:A) resistor r=85.7713 c=0
Rl29 (\11\:A \12\:A) resistor r=64.6174 c=0
Rl19 (\8\:A \9\:A) resistor r=24.2328 c=0
Rl18 (\7\:A \8\:A) resistor r=100.539 c=0
Rl13 (\5\:A \6\:A) resistor r=114.01 c=0
Rl12 (\4\:A \5\:A) resistor r=84.6154 c=0
Rl3 (\1\:A \2\:A) resistor r=24.2328 c=0
Rl4 (\2\:A \3\:A) resistor r=84.1695 c=0
Rl26 (\10\:B \11\:B) resistor r=24.2328 c=0
Rl27 (\11\:B \12\:B) resistor r=126.156 c=0
Rl16 (\7\:B \8\:B) resistor r=24.2328 c=0
Rl17 (\8\:B \9\:B) resistor r=158.848 c=0
Rl11 (\5\:B \6\:B) resistor r=39.6174 c=0
Rl10 (\4\:B \5\:B) resistor r=177.645 c=0
Rl5 (\1\:B \2\:B) resistor r=24.2328 c=0
Rl6 (\2\:B \3\:B) resistor r=114.617 c=0
Rl14 (\5\:CI \6\:CI) resistor r=158.848 c=0
Rl15 (\6\:CI \7\:CI) resistor r=24.2328 c=0
Rl7 (\1\:CI \2\:CI) resistor r=135.772 c=0
Rl8 (\2\:CI \3\:CI) resistor r=28.0797 c=0
Rl9 (\2\:CI \4\:CI) resistor r=97.9741 c=0
Rl25 (\9\:CI \11\:CI) resistor r=135.855 c=0
Rl23 (\8\:CI \9\:CI) resistor r=40.105 c=0
Rl24 (\9\:CI \10\:CI) resistor r=46.5525 c=0
Rl1 (COb \2\:COb) resistor r=29.5379 c=0
Rl2 (\2\:COb \3\:COb) resistor r=66.0764 c=0
Rl21 (\5\:COb \6\:COb) resistor r=53.824 c=0
Rl20 (\4\:COb \5\:COb) resistor r=143.912 c=0
Rl22 (\5\:COb \7\:COb) resistor r=85.285 c=0
Rl30 (Sb \2\:Sb) resistor r=126.156 c=0
Rl31 (\2\:Sb \3\:Sb) resistor r=24.2328 c=0
Rz13 (\1\:VSS \2\:VSS) resistor r=75 c=0
Rz14 (\9\:VSS \10\:VSS) resistor r=75 c=0
Rz15 (\11\:VSS \12\:VSS) resistor r=75 c=0
Rz16 (\13\:VSS \14\:VSS) resistor r=75 c=0
Rz17 (\16\:VSS \17\:VSS) resistor r=75 c=0
Rz11 (\5\:VDD \6\:VDD) resistor r=6.25 c=0
Rz12 (\5\:VDD \9\:VDD) resistor r=7.5 c=0
Rz1 (\3\:CO \4\:CO) resistor r=75 c=0
Rz10 (\2\:S \3\:S) resistor r=75 c=0
Rz6 (\16\:COb \17\:COb) resistor r=75 c=0
Rz7 (\19\:COb \20\:COb) resistor r=75 c=0
Rz2 (n2 \2\:n2) resistor r=75 c=0
Rz3 (\3\:n2 \4\:n2) resistor r=75 c=0
Rz4 (n4 \2\:n4) resistor r=75 c=0
Rz5 (\3\:n4 \4\:n4) resistor r=75 c=0
Rz8 (\4\:Sb \5\:Sb) resistor r=75 c=0
Rz9 (\6\:Sb \7\:Sb) resistor r=75 c=0
Ry16 (\4\:VSS \5\:VSS) resistor r=5.1667 c=0
Ry17 (\4\:VSS \15\:VSS) resistor r=6.2 c=0
Ry11 (\1\:VDD \2\:VDD) resistor r=62 c=0
Ry12 (\10\:VDD \11\:VDD) resistor r=62 c=0
Ry13 (\12\:VDD \13\:VDD) resistor r=62 c=0
Ry14 (\14\:VDD \15\:VDD) resistor r=62 c=0
Ry15 (\16\:VDD \17\:VDD) resistor r=62 c=0
Ry1 (\1\:CO \2\:CO) resistor r=31 c=0
Ry10 (\4\:S \5\:S) resistor r=31 c=0
Ry6 (\9\:COb \10\:COb) resistor r=31 c=0
Ry7 (\12\:COb \13\:COb) resistor r=31 c=0
Ry8 (\9\:Sb \10\:Sb) resistor r=62 c=0
Ry9 (\11\:Sb \12\:Sb) resistor r=62 c=0
Ry2 (n3 \2\:n3) resistor r=62 c=0
Ry3 (\3\:n3 \4\:n3) resistor r=62 c=0
Ry4 (n5 \2\:n5) resistor r=62 c=0
Ry5 (\3\:n5 \4\:n5) resistor r=62 c=0
Rx10 (\11\:A \13\:A) resistor r=45 c=0
Rx11 (\8\:A \14\:A) resistor r=45 c=0
Rx12 (\5\:A \15\:A) resistor r=45 c=0
Rx13 (\2\:A \16\:A) resistor r=45 c=0
Rx6 (\11\:B \13\:B) resistor r=45 c=0
Rx7 (\8\:B \14\:B) resistor r=45 c=0
Rx8 (\5\:B \15\:B) resistor r=45 c=0
Rx9 (\2\:B \16\:B) resistor r=45 c=0
Rx3 (\10\:CI \12\:CI) resistor r=45 c=0
Rx4 (\6\:CI \13\:CI) resistor r=45 c=0
Rx5 (\4\:CI \14\:CI) resistor r=45 c=0
Rx1 (\7\:COb \8\:COb) resistor r=45 c=0
Rx2 (\2\:COb \18\:COb) resistor r=45 c=0
Rx14 (\2\:Sb \8\:Sb) resistor r=45 c=0
mn12 (\3\:CO \3\:COb \13\:VSS VSS) g45n1lvt w=(2.05e-07) l=4.5e-08 nf=1 \
        as=2.87e-14 ad=2.87e-14 ps=6.9e-07 pd=6.9e-07 nrd=1.16667 \
        nrs=1.16667 sa=1.4e-07 sb=1.4e-07 sd=160n sca=12.4149 scb=0.012446 \
        scc=0.000614222 m=(1)
mn2 (\3\:n2 \3\:A \11\:VSS VSS) g45n1lvt w=(2.05e-07) l=4.5e-08 nf=1 \
        as=9.01e-14 ad=2.87e-14 ps=1.6e-06 pd=6.9e-07 nrd=1.16667 \
        nrs=1.16667 sa=1.4e-07 sb=6.1e-07 sd=160n sca=19.867 scb=0.0198061 \
        scc=0.00201945 m=(1)
mn3 (n2 \3\:B \11\:VSS VSS) g45n1lvt w=(2.05e-07) l=4.5e-08 nf=1 \
        as=9.01e-14 ad=3.28e-14 ps=1.6e-06 pd=7.3e-07 nrd=1.16667 \
        nrs=1.16667 sa=4.05e-07 sb=3.45e-07 sd=160n sca=19.867 \
        scb=0.0198061 scc=0.00201945 m=(1)
mn4 (\16\:COb \3\:CI n2 VSS) g45n1lvt w=(2.05e-07) l=4.5e-08 nf=1 \
        as=3.28e-14 ad=2.87e-14 ps=7.3e-07 pd=6.9e-07 nrd=1.16667 \
        nrs=1.16667 sa=6.1e-07 sb=1.4e-07 sd=160n sca=19.867 scb=0.0198061 \
        scc=0.00201945 m=(1)
mn1 (\19\:COb \4\:B n0 VSS) g45n1lvt w=(2.05e-07) l=4.5e-08 nf=1 \
        as=1.23e-14 ad=2.87e-14 ps=5.3e-07 pd=6.9e-07 nrd=1.16667 \
        nrs=1.16667 sa=1.4e-07 sb=1.12329e-06 sd=160n sca=13.8179 \
        scb=0.0141903 scc=0.000851218 m=(1)
mn0 (n0 \4\:A \1\:VSS VSS) g45n1lvt w=(2.05e-07) l=4.5e-08 nf=1 \
        as=3.485e-14 ad=1.23e-14 ps=7.5e-07 pd=5.3e-07 nrd=1.16667 \
        nrs=1.16667 sa=2.45e-07 sb=1.01829e-06 sd=160n sca=13.8179 \
        scb=0.0141903 scc=0.000851218 m=(1)
mn7 (\3\:n4 \7\:CI \1\:VSS VSS) g45n1lvt w=(2.05e-07) l=4.5e-08 nf=1 \
        as=3.485e-14 ad=3.28e-14 ps=7.5e-07 pd=7.3e-07 nrd=1.16667 \
        nrs=1.16667 sa=4.6e-07 sb=8.03293e-07 sd=160n sca=13.8179 \
        scb=0.0141903 scc=0.000851218 m=(1)
mn6 (\3\:n4 \9\:B \9\:VSS VSS) g45n1lvt w=(2.05e-07) l=4.5e-08 nf=1 \
        as=6.01e-14 ad=3.28e-14 ps=1.1e-06 pd=7.3e-07 nrd=1.16667 \
        nrs=1.16667 sa=6.65e-07 sb=5.98293e-07 sd=160n sca=13.8179 \
        scb=0.0141903 scc=0.000851218 m=(1)
mn5 (n4 \7\:A \9\:VSS VSS) g45n1lvt w=(2.05e-07) l=4.5e-08 nf=1 \
        as=6.01e-14 ad=3.28e-14 ps=1.1e-06 pd=7.3e-07 nrd=1.16667 \
        nrs=1.16667 sa=9.3e-07 sb=3.33293e-07 sd=160n sca=13.8179 \
        scb=0.0141903 scc=0.000851218 m=(1)
mn8 (\6\:Sb \4\:COb n4 VSS) g45n1lvt w=(2.05e-07) l=4.5e-08 nf=1 \
        as=3.28e-14 ad=2.63e-14 ps=7.3e-07 pd=6.9e-07 nrd=1.16667 \
        nrs=1.16667 sa=1.135e-06 sb=1.28293e-07 sd=160n sca=13.8179 \
        scb=0.0141903 scc=0.000851218 m=(1)
mn11 (\4\:Sb \8\:CI n7 VSS) g45n1lvt w=(2.05e-07) l=4.5e-08 nf=1 \
        as=1.23e-14 ad=2.53e-14 ps=5.3e-07 pd=6.9e-07 nrd=1.16667 \
        nrs=1.16667 sa=1.23415e-07 sb=7.45e-07 sd=160n sca=16.0682 \
        scb=0.0166045 scc=0.00126927 m=(1)
mn10 (n7 \12\:B n6 VSS) g45n1lvt w=(2.05e-07) l=4.5e-08 nf=1 as=2.05e-14 \
        ad=1.23e-14 ps=6.1e-07 pd=5.3e-07 nrd=1.16667 nrs=1.16667 \
        sa=2.28415e-07 sb=6.4e-07 sd=160n sca=16.0682 scb=0.0166045 \
        scc=0.00126927 m=(1)
mn9 (n6 \12\:A \16\:VSS VSS) g45n1lvt w=(2.05e-07) l=4.5e-08 nf=1 \
        as=6.89e-14 ad=2.05e-14 ps=1.19e-06 pd=6.1e-07 nrd=1.16667 \
        nrs=1.16667 sa=3.73415e-07 sb=4.95e-07 sd=160n sca=16.0682 \
        scb=0.0166045 scc=0.00126927 m=(1)
mn13 (\2\:S \3\:Sb \16\:VSS VSS) g45n1lvt w=(2.05e-07) l=4.5e-08 nf=1 \
        as=6.89e-14 ad=3.895e-14 ps=1.19e-06 pd=7.9e-07 nrd=1.16667 \
        nrs=1.16667 sa=6.78415e-07 sb=1.9e-07 sd=160n sca=16.0682 \
        scb=0.0166045 scc=0.00126927 m=(1)
ends ADDFHXL
// End of subcircuit definition.
