// Generated for: spectre (May  1 11:28:28 2013 )
// Library name: gsclib045_backbias
// Cell name: CLKMX2X2
// View name: extracted

simulator lang=spectre

subckt CLKMX2X2 A B NW S0 VDD VSS Y
mp0 (\10\:S0b \1\:S0 \7\:VDD NW) g45p1svt w=(2.15e-07) l=4.5e-08 nf=1 \
        as=3.762e-14 ad=3.01e-14 ps=7.8e-07 pd=7.1e-07 nrd=1.16667 \
        nrs=1.16667 sa=1.4e-07 sb=1.4e-06 sd=160n sca=15.5214 \
        scb=0.0147757 scc=0.000215748 m=(1)
mp1 (net123 \1\:A \7\:VDD NW) g45p1svt w=(2.15e-07) l=4.5e-08 nf=1 \
        as=3.762e-14 ad=3.977e-14 ps=7.8e-07 pd=8e-07 nrd=1.16667 \
        nrs=1.16667 sa=3.6e-07 sb=1.18e-06 sd=160n sca=11.7983 \
        scb=0.00857189 scc=7.47494e-05 m=(1)
mp2 (\12\:n0 \6\:S0 net123 NW) g45p1svt w=(2.15e-07) l=4.5e-08 nf=1 \
        as=3.977e-14 ad=4.73e-14 ps=8e-07 pd=8.7e-07 nrd=1.16667 \
        nrs=1.16667 sa=5.9e-07 sb=9.5e-07 sd=160n sca=10.5655 \
        scb=0.0074576 scc=7.20375e-05 m=(1)
mp4 (\12\:n0 \3\:S0b net115 NW) g45p1svt w=(2.15e-07) l=4.5e-08 nf=1 \
        as=1.935e-14 ad=4.73e-14 ps=6.1e-07 pd=8.7e-07 nrd=1.16667 \
        nrs=1.16667 sa=8.55e-07 sb=6.85e-07 sd=160n sca=10.707 \
        scb=0.00753257 scc=7.20801e-05 m=(1)
mp3 (net115 \4\:B \1\:VDD NW) g45p1svt w=(2.15e-07) l=4.5e-08 nf=1 \
        as=5.19e-14 ad=1.935e-14 ps=1.1e-06 pd=6.1e-07 nrd=1.16667 \
        nrs=1.16667 sa=9.9e-07 sb=5.5e-07 sd=160n sca=11.3858 \
        scb=0.0080918 scc=7.29969e-05 m=(1)
C1 (S0 VSS) capacitor c=2.90938e-17
C2 (A VSS) capacitor c=5.58589e-17
C3 (Y VSS) capacitor c=2.80318e-17
C4 (VDD VSS) capacitor c=4.62066e-17
C5 (NW VSS) capacitor c=3.09505e-16
C6 (S0b VSS) capacitor c=6.79703e-17
C7 (n0 VSS) capacitor c=1.69293e-16
C8 (net140 VSS) capacitor c=5.94741e-18
C9 (net115 VSS) capacitor c=1.60173e-18
C10 (\4\:B VSS) capacitor c=6.951e-17
C11 (\3\:S0b VSS) capacitor c=4.76558e-17
C12 (\6\:S0 VSS) capacitor c=4.00511e-17
C13 (\1\:A VSS) capacitor c=4.19649e-17
C14 (\1\:S0 VSS) capacitor c=3.16105e-17
C15 (\3\:B VSS) capacitor c=5.60282e-17
C16 (\4\:S0 VSS) capacitor c=6.09393e-17
C17 (\3\:A VSS) capacitor c=9.14968e-17
C18 (\3\:S0 VSS) capacitor c=5.66864e-17
C19 (\4\:n0 VSS) capacitor c=4.35991e-17
C20 (\1\:B VSS) capacitor c=2.36277e-17
C21 (\4\:S0b VSS) capacitor c=4.56261e-17
C22 (\5\:S0 VSS) capacitor c=8.07182e-17
C23 (\2\:S0b VSS) capacitor c=5.59139e-17
C24 (\2\:A VSS) capacitor c=7.1716e-17
C25 (\2\:S0 VSS) capacitor c=5.50439e-17
C26 (\1\:VDD VSS) capacitor c=2.09172e-16
C27 (\4\:Y VSS) capacitor c=1.01047e-16
C28 (\12\:n0 VSS) capacitor c=9.39762e-17
C29 (\7\:VDD VSS) capacitor c=3.92693e-17
C30 (\10\:S0b VSS) capacitor c=9.35684e-17
C31 (\2\:Y VSS) capacitor c=3.0196e-17
C32 (\10\:n0 VSS) capacitor c=5.572e-17
C33 (\8\:S0b VSS) capacitor c=2.07457e-17
C34 (\2\:B VSS) capacitor c=5.15356e-17
C35 (\4\:A VSS) capacitor c=6.08691e-17
C36 (\7\:S0 VSS) capacitor c=8.23351e-17
C37 (\8\:S0 VSS) capacitor c=7.28826e-17
C38 (\5\:S0b VSS) capacitor c=7.67003e-17
C39 (\6\:S0b VSS) capacitor c=1.21501e-16
C40 (\7\:S0b VSS) capacitor c=8.12973e-17
C41 (\5\:B VSS) capacitor c=1.23449e-16
C42 (\8\:n0 VSS) capacitor c=3.24213e-17
C43 (\9\:n0 VSS) capacitor c=1.11192e-16
C44 (\1\:Y VSS) capacitor c=4.75549e-17
C45 (\4\:VDD VSS) capacitor c=6.13588e-17
Rk3 (\8\:S0 S0) resistor r=0.02104 c=0
Rk2 (\7\:S0 \8\:S0) resistor r=0.417 c=0
Rk21 (\1\:VSS \5\:VSS) resistor r=0.1955 c=0
Rk23 (\6\:VSS VSS) resistor r=0.1701 c=0
Rk22 (\5\:VSS \6\:VSS) resistor r=0.2306 c=0
Rk25 (\6\:VSS \10\:VSS) resistor r=0.194 c=0
Rk1 (A \4\:A) resistor r=0.07467 c=0
Rk12 (Y \1\:Y) resistor r=0.111 c=0
Rk13 (\1\:Y \3\:Y) resistor r=0.1478 c=0
Rk14 (\1\:Y \5\:Y) resistor r=0.502 c=0
Rk17 (\4\:VDD VDD) resistor r=0.1701 c=0
Rk16 (\1\:VDD \4\:VDD) resistor r=0.4261 c=0
Rk19 (\4\:VDD \8\:VDD) resistor r=0.2093 c=0
Rk8 (B \5\:B) resistor r=0.006762 c=0
Rk4 (\5\:S0b \6\:S0b) resistor r=0.4511 c=0
Rk5 (\6\:S0b \7\:S0b) resistor r=0.3941 c=0
Rk6 (\7\:S0b \9\:S0b) resistor r=0.09765 c=0
Rk7 (\7\:S0b \11\:S0b) resistor r=0.7268 c=0
Rk9 (\8\:n0 \9\:n0) resistor r=0.1576 c=0
Rk10 (\9\:n0 \11\:n0) resistor r=0.4052 c=0
Rk11 (\9\:n0 \13\:n0) resistor r=0.5968 c=0
Rl7 (\5\:S0 \6\:S0) resistor r=74.2328 c=0
Rl6 (\4\:S0 \5\:S0) resistor r=236.093 c=0
Rl1 (\1\:S0 \2\:S0) resistor r=41.0764 c=0
Rl2 (\2\:S0 \3\:S0) resistor r=248.769 c=0
Rl3 (\1\:A \2\:A) resistor r=76.1559 c=0
Rl4 (\2\:A \3\:A) resistor r=210.771 c=0
Rl11 (\2\:B \4\:B) resistor r=128.56 c=0
Rl10 (\2\:B \3\:B) resistor r=178.56 c=0
Rl9 (\1\:B \2\:B) resistor r=2.0213 c=0
Rl8 (\3\:S0b \4\:S0b) resistor r=62.9746 c=0
Rl5 (S0b \2\:S0b) resistor r=83.8482 c=0
Rl14 (n0 \4\:n0) resistor r=4.1351 c=0
Rz6 (\10\:VSS \9\:VSS) resistor r=75 c=0
Rz3 (\3\:Y \2\:Y) resistor r=75 c=0
Rz1 (\8\:S0b \9\:S0b) resistor r=75 c=0
Rz2 (\11\:n0 \10\:n0) resistor r=75 c=0
Ry3 (\5\:Y \4\:Y) resistor r=20.6667 c=0
Ry6 (\8\:VDD \7\:VDD) resistor r=62 c=0
Ry1 (\10\:S0b \11\:S0b) resistor r=62 c=0
Ry2 (\13\:n0 \12\:n0) resistor r=62 c=0
Rx2 (\5\:S0 \7\:S0) resistor r=45 c=0
Rx3 (\2\:S0 \8\:S0) resistor r=45 c=0
Rx1 (\2\:A \4\:A) resistor r=45 c=0
Rx6 (\1\:B \5\:B) resistor r=45 c=0
Rx4 (\4\:S0b \5\:S0b) resistor r=45 c=0
Rx5 (\2\:S0b \6\:S0b) resistor r=45 c=0
Rx7 (\8\:n0 \4\:n0) resistor r=45 c=0
mn0 (\8\:S0b \3\:S0 \9\:VSS VSS) g45n1svt w=(1.45e-07) l=4.5e-08 nf=1 \
        as=2.537e-14 ad=2.03e-14 ps=6.4e-07 pd=5.7e-07 nrd=1.16667 \
        nrs=1.16667 sa=1.4e-07 sb=1.4e-06 sd=160n sca=7.00131 \
        scb=0.00386446 scc=3.38236e-05 m=(1)
mn1 (net148 \3\:A \9\:VSS VSS) g45n1svt w=(1.45e-07) l=4.5e-08 nf=1 \
        as=2.537e-14 ad=8.7e-15 ps=6.4e-07 pd=4.1e-07 nrd=1.16667 \
        nrs=1.16667 sa=3.6e-07 sb=1.18e-06 sd=160n sca=7.00131 \
        scb=0.00386446 scc=3.38236e-05 m=(1)
mn2 (\10\:n0 S0b net148 VSS) g45n1svt w=(1.45e-07) l=4.5e-08 nf=1 \
        as=8.7e-15 ad=2.32e-14 ps=4.1e-07 pd=6.1e-07 nrd=1.16667 \
        nrs=1.16667 sa=4.65e-07 sb=1.075e-06 sd=160n sca=7.00131 \
        scb=0.00386446 scc=3.38236e-05 m=(1)
mn4 (\10\:n0 \4\:S0 net140 VSS) g45n1svt w=(1.45e-07) l=4.5e-08 nf=1 \
        as=3.988e-14 ad=2.32e-14 ps=8.4e-07 pd=6.1e-07 nrd=1.16667 \
        nrs=1.16667 sa=6.7e-07 sb=8.7e-07 sd=160n sca=7.00131 \
        scb=0.00386446 scc=3.38236e-05 m=(1)
mn3 (net140 \3\:B \1\:VSS VSS) g45n1svt w=(1.45e-07) l=4.5e-08 nf=1 \
        as=3.47e-14 ad=3.988e-14 ps=8.4e-07 pd=8.4e-07 nrd=1.16667 \
        nrs=1.16667 sa=9.9e-07 sb=5.5e-07 sd=160n sca=7.00131 \
        scb=0.00386446 scc=3.38236e-05 m=(1)
mn5 (\2\:Y n0 \1\:VSS VSS) g45n1svt w=(2.6e-07) l=4.5e-08 nf=1 \
        as=3.555e-14 ad=4.16e-14 ps=8.2e-07 pd=8.4e-07 nrd=1.16667 \
        nrs=1.16667 sa=7.10673e-07 sb=3.45e-07 sd=160n sca=8.51051 \
        scb=0.00656948 scc=0.000151659 m=(2)
mp5 (\4\:Y n0 \1\:VDD NW) g45p1svt w=(3.9e-07) l=4.5e-08 nf=1 \
        as=5.325e-14 ad=6.24e-14 ps=1.08e-06 pd=1.1e-06 nrd=1.16667 \
        nrs=1.16667 sa=7.03654e-07 sb=3.45e-07 sd=160n sca=15.9948 \
        scb=0.0151656 scc=0.000454155 m=(2)
ends CLKMX2X2
// End of subcircuit definition.
