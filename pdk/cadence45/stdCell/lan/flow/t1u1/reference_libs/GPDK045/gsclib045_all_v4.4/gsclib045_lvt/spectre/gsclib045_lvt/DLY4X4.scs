// gsclib045_lvt/DLY4X4/schematic

simulator lang=spectre

subckt DLY4X4 A Y VDD VSS
mp8 (net369 VSS net300 VDD) g45p1lvt w=(215n) l=45n nf=1 m=(1)
mp7 (net300 net377 VDD VDD) g45p1lvt w=(215n) l=45n nf=1 m=(1)
mp9 (net292 net369 VDD VDD) g45p1lvt w=(215n) l=45n nf=1 m=(1)
mp10 (net361 VSS net292 VDD) g45p1lvt w=(215n) l=45n nf=1 m=(1)
mp6 (net377 VSS net308 VDD) g45p1lvt w=(215n) l=45n nf=1 m=(1)
mp5 (net308 net385 VDD VDD) g45p1lvt w=(215n) l=45n nf=1 m=(1)
mp4 (net385 VSS net316 VDD) g45p1lvt w=(215n) l=45n nf=1 m=(1)
mp3 (net316 net393 VDD VDD) g45p1lvt w=(215n) l=45n nf=1 m=(1)
mp2 (net393 VSS net324 VDD) g45p1lvt w=(215n) l=45n nf=1 m=(1)
mp1 (net324 net397 VDD VDD) g45p1lvt w=(215n) l=45n nf=1 m=(1)
mp11 (net284 net361 VDD VDD) g45p1lvt w=(215n) l=45n nf=1 m=(1)
mp12 (net353 VSS net284 VDD) g45p1lvt w=(215n) l=45n nf=1 m=(1)
mp13 (net276 net353 VDD VDD) g45p1lvt w=(215n) l=45n nf=1 m=(1)
mp14 (net345 VSS net276 VDD) g45p1lvt w=(215n) l=45n nf=1 m=(1)
mp15 (net333 net345 VDD VDD) g45p1lvt w=(390n) l=45n nf=1 m=(1)
mp0 (net397 A VDD VDD) g45p1lvt w=(215n) l=45n nf=1 m=(1)
mp16 (Y net333 VDD VDD) g45p1lvt w=(1.56u) l=45n nf=1 m=(1)
mn14 (net345 VDD net341 VSS) g45n1lvt w=(145n) l=45n nf=1 m=(1)
mn13 (net341 net353 VSS VSS) g45n1lvt w=(145n) l=45n nf=1 m=(1)
mn12 (net353 VDD net349 VSS) g45n1lvt w=(145n) l=45n nf=1 m=(1)
mn11 (net349 net361 VSS VSS) g45n1lvt w=(145n) l=45n nf=1 m=(1)
mn10 (net361 VDD net357 VSS) g45n1lvt w=(145n) l=45n nf=1 m=(1)
mn9 (net357 net369 VSS VSS) g45n1lvt w=(145n) l=45n nf=1 m=(1)
mn15 (net333 net345 VSS VSS) g45n1lvt w=(260n) l=45n nf=1 m=(1)
mn6 (net377 VDD net373 VSS) g45n1lvt w=(145n) l=45n nf=1 m=(1)
mn0 (net397 A VSS VSS) g45n1lvt w=(145n) l=45n nf=1 m=(1)
mn4 (net385 VDD net381 VSS) g45n1lvt w=(145n) l=45n nf=1 m=(1)
mn1 (net389 net397 VSS VSS) g45n1lvt w=(145n) l=45n nf=1 m=(1)
mn7 (net365 net377 VSS VSS) g45n1lvt w=(145n) l=45n nf=1 m=(1)
mn16 (Y net333 VSS VSS) g45n1lvt w=(1.04u) l=45n nf=1 m=(1)
mn3 (net381 net393 VSS VSS) g45n1lvt w=(145n) l=45n nf=1 m=(1)
mn2 (net393 VDD net389 VSS) g45n1lvt w=(145n) l=45n nf=1 m=(1)
mn8 (net369 VDD net365 VSS) g45n1lvt w=(145n) l=45n nf=1 m=(1)
mn5 (net373 net385 VSS VSS) g45n1lvt w=(145n) l=45n nf=1 m=(1)
ends DLY4X4
