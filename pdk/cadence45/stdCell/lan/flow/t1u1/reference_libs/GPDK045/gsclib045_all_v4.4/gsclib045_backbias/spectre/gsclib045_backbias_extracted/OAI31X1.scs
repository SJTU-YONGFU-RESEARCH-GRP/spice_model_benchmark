// Generated for: spectre (May  1 11:31:41 2013 )
// Library name: gsclib045_backbias
// Cell name: OAI31X1
// View name: extracted

simulator lang=spectre

subckt OAI31X1 A0 A1 A2 B0 NW VDD VSS Y
mp0 (n1 \1\:A0 \4\:VDD NW) g45p1svt w=(3.9e-07) l=4.5e-08 nf=1 \
        as=5.46e-14 ad=2.34e-14 ps=1.06e-06 pd=9e-07 nrd=1.16667 \
        nrs=1.16667 sa=1.4e-07 sb=6.25e-07 sd=160n sca=15.9959 \
        scb=0.0151266 scc=0.000303017 m=(1)
mp1 (n2 \1\:A1 n1 NW) g45p1svt w=(3.9e-07) l=4.5e-08 nf=1 as=2.34e-14 \
        ad=5.07e-14 ps=9e-07 pd=1.04e-06 nrd=1.16667 nrs=1.16667 \
        sa=2.45e-07 sb=5.2e-07 sd=160n sca=14.532 scb=0.0121946 \
        scc=0.000242813 m=(1)
mp2 (\3\:Y \3\:A2 n2 NW) g45p1svt w=(3.9e-07) l=4.5e-08 nf=1 as=5.07e-14 \
        ad=6.24e-14 ps=1.04e-06 pd=1.1e-06 nrd=1.16667 nrs=1.16667 \
        sa=4.2e-07 sb=3.45e-07 sd=160n sca=14.1757 scb=0.0114808 \
        scc=0.000235907 m=(1)
mp3 (\3\:Y \3\:B0 \1\:VDD NW) g45p1svt w=(3.9e-07) l=4.5e-08 nf=1 \
        as=5.46e-14 ad=6.24e-14 ps=1.06e-06 pd=1.1e-06 nrd=1.16667 \
        nrs=1.16667 sa=6.25e-07 sb=1.4e-07 sd=160n sca=16.9977 \
        scb=0.017051 scc=0.00037561 m=(1)
C1 (B0 VSS) capacitor c=8.33932e-17
C2 (A0 VSS) capacitor c=4.21916e-17
C3 (A2 VSS) capacitor c=1.20927e-16
C4 (NW VSS) capacitor c=1.92236e-16
C5 (A1 VSS) capacitor c=4.54516e-17
C6 (Y VSS) capacitor c=8.9617e-17
C7 (VDD VSS) capacitor c=3.08655e-17
C8 (n0 VSS) capacitor c=8.30946e-17
C9 (n2 VSS) capacitor c=2.06673e-18
C10 (\3\:B0 VSS) capacitor c=3.9126e-17
C11 (\3\:A2 VSS) capacitor c=5.95038e-17
C12 (\1\:A1 VSS) capacitor c=1.04506e-16
C13 (\1\:A0 VSS) capacitor c=9.5475e-17
C14 (\1\:B0 VSS) capacitor c=4.96643e-17
C15 (\1\:A2 VSS) capacitor c=5.42172e-17
C16 (\3\:A1 VSS) capacitor c=4.38156e-17
C17 (\4\:A0 VSS) capacitor c=3.72809e-17
C18 (\2\:B0 VSS) capacitor c=4.32609e-17
C19 (\2\:A2 VSS) capacitor c=5.58225e-17
C20 (\2\:A1 VSS) capacitor c=6.54818e-17
C21 (\3\:A0 VSS) capacitor c=1.33714e-17
C22 (\1\:VDD VSS) capacitor c=1.13019e-16
C23 (\3\:Y VSS) capacitor c=1.27594e-16
C24 (\4\:VDD VSS) capacitor c=4.00808e-17
C25 (\1\:Y VSS) capacitor c=2.76202e-17
C26 (\3\:n0 VSS) capacitor c=7.2029e-17
C27 (\2\:A0 VSS) capacitor c=5.10448e-17
C28 (\5\:A0 VSS) capacitor c=2.62904e-17
C29 (\4\:A1 VSS) capacitor c=5.6259e-17
C30 (\5\:B0 VSS) capacitor c=4.12543e-17
C31 (\3\:VDD VSS) capacitor c=5.45265e-17
Rk7 (B0 \5\:B0) resistor r=0.06633 c=0
Rk1 (\5\:A0 A0) resistor r=0.1432 c=0
Rk13 (\2\:VSS \4\:VSS) resistor r=0.1212 c=0
Rk15 (\5\:VSS VSS) resistor r=0.03716 c=0
Rk14 (\4\:VSS \5\:VSS) resistor r=0.2137 c=0
Rk16 (\5\:VSS \7\:VSS) resistor r=0.2228 c=0
Rk3 (\4\:A2 A2) resistor r=0.003 c=0
Rk2 (A1 \4\:A1) resistor r=0.225 c=0
Rk8 (\2\:Y Y) resistor r=0.07668 c=0
Rk9 (Y \4\:Y) resistor r=0.8007 c=0
Rk11 (\3\:VDD VDD) resistor r=0.08731 c=0
Rk10 (\2\:VDD \3\:VDD) resistor r=0.5697 c=0
Rk12 (\3\:VDD \5\:VDD) resistor r=0.264 c=0
Rk4 (\2\:n0 \4\:n0) resistor r=0.4289 c=0
Rl9 (\2\:B0 \3\:B0) resistor r=37.6374 c=0
Rl8 (\1\:B0 \2\:B0) resistor r=169.231 c=0
Rl1 (\1\:A0 \2\:A0) resistor r=178.356 c=0
Rl3 (\2\:A0 \4\:A0) resistor r=51.385 c=0
Rl2 (\2\:A0 \3\:A0) resistor r=4.5402 c=0
Rl7 (\2\:A2 \3\:A2) resistor r=76.098 c=0
Rl6 (\1\:A2 \2\:A2) resistor r=122.252 c=0
Rl4 (\1\:A1 \2\:A1) resistor r=148.769 c=0
Rl5 (\2\:A1 \3\:A1) resistor r=56.461 c=0
Rz4 (\1\:VSS \2\:VSS) resistor r=75 c=0
Rz5 (\6\:VSS \7\:VSS) resistor r=37.5 c=0
Rz3 (\1\:Y \2\:Y) resistor r=37.5 c=0
Rz1 (n0 \2\:n0) resistor r=37.5 c=0
Rz2 (\3\:n0 \4\:n0) resistor r=37.5 c=0
Ry1 (\3\:Y \4\:Y) resistor r=20.6667 c=0
Ry2 (\1\:VDD \2\:VDD) resistor r=31 c=0
Ry3 (\4\:VDD \5\:VDD) resistor r=20.6667 c=0
Rx4 (\2\:B0 \5\:B0) resistor r=45 c=0
Rx1 (\3\:A0 \5\:A0) resistor r=45 c=0
Rx3 (\2\:A2 \4\:A2) resistor r=45 c=0
Rx2 (\2\:A1 \4\:A1) resistor r=45 c=0
mn0 (\3\:n0 \4\:A0 \6\:VSS VSS) g45n1svt w=(2.6e-07) l=4.5e-08 nf=1 \
        as=3.64e-14 ad=4.16e-14 ps=8e-07 pd=8.4e-07 nrd=1.16667 \
        nrs=1.16667 sa=1.4e-07 sb=7.8e-07 sd=160n sca=7.84363 \
        scb=0.00546499 scc=9.84911e-05 m=(1)
mn1 (\3\:n0 \3\:A1 \1\:VSS VSS) g45n1svt w=(2.6e-07) l=4.5e-08 nf=1 \
        as=4.42e-14 ad=4.16e-14 ps=8.6e-07 pd=8.4e-07 nrd=1.16667 \
        nrs=1.16667 sa=3.45e-07 sb=5.75e-07 sd=160n sca=7.84363 \
        scb=0.00546499 scc=9.84911e-05 m=(1)
mn2 (n0 \1\:A2 \1\:VSS VSS) g45n1svt w=(2.6e-07) l=4.5e-08 nf=1 \
        as=4.42e-14 ad=4.55e-14 ps=8.6e-07 pd=8.7e-07 nrd=1.16667 \
        nrs=1.16667 sa=5.6e-07 sb=3.6e-07 sd=160n sca=7.84363 \
        scb=0.00546499 scc=9.84911e-05 m=(1)
mn3 (\1\:Y \1\:B0 n0 VSS) g45n1svt w=(2.6e-07) l=4.5e-08 nf=1 as=4.55e-14 \
        ad=3.64e-14 ps=8.7e-07 pd=8e-07 nrd=1.16667 nrs=1.16667 sa=7.8e-07 \
        sb=1.4e-07 sd=160n sca=7.84363 scb=0.00546499 scc=9.84911e-05 \
        m=(1)
ends OAI31X1
// End of subcircuit definition.
