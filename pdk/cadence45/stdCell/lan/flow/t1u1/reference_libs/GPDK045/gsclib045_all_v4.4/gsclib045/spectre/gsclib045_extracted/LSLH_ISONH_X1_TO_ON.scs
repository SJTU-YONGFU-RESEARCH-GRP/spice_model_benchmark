// Generated for: spectre (May  1 08:12:00 2013 )
// Library name: gsclib045
// Cell name: LSLH_ISONH_X1_TO_ON
// View name: extracted

simulator lang=spectre

subckt LSLH_ISONH_X1_TO_ON A ExtVDD ISOn VDD VSS Y
PM2 (\7\:Ab \9\:A \4\:ExtVDD ExtVDD) g45p1svt w=(2.15e-07) l=4.5e-08 \
        nf=1 as=3.01e-14 ad=3.01e-14 ps=7.1e-07 pd=7.1e-07 nrd=1.16667 \
        nrs=1.16667 sa=1.4e-07 sb=1.4e-07 sd=160n sca=24.4536 \
        scb=0.0294943 scc=0.001293 m=(1)
PM0 (\11\:Ybint \4\:Yint \10\:VDD VDD) g45p1svt w=(2.15e-07) l=4.5e-08 \
        nf=1 as=3.01e-14 ad=3.01e-14 ps=7.1e-07 pd=7.1e-07 nrd=1.16667 \
        nrs=1.16667 sa=1.4e-07 sb=1.4e-07 sd=160n sca=23.0829 \
        scb=0.0252371 scc=0.00197374 m=(1)
PM1 (\11\:Yint Ybint \3\:VDD VDD) g45p1svt w=(2.15e-07) l=4.5e-08 nf=1 \
        as=3.01e-14 ad=3.01e-14 ps=7.1e-07 pd=7.1e-07 nrd=1.16667 \
        nrs=1.16667 sa=1.4e-07 sb=1.4e-07 sd=160n sca=7.11886 \
        scb=0.00384538 scc=3.76076e-05 m=(1)
C1 (VDD VSS) capacitor c=3.58063e-16
C2 (ISOn VSS) capacitor c=2.33759e-17
C3 (Y VSS) capacitor c=2.95241e-17
C4 (A VSS) capacitor c=1.9958e-17
C5 (ExtVDD VSS) capacitor c=6.91494e-17
C6 (Yint VSS) capacitor c=3.66296e-17
C7 (Ab VSS) capacitor c=1.55271e-16
C8 (Ybint VSS) capacitor c=3.26303e-17
C9 (GatedVSS VSS) capacitor c=3.45877e-17
C10 (\6\:Ybint VSS) capacitor c=2.92527e-17
C11 (\1\:ISOn VSS) capacitor c=3.83574e-17
C12 (\4\:Yint VSS) capacitor c=3.0596e-17
C13 (\9\:A VSS) capacitor c=4.92695e-17
C14 (\3\:Ybint VSS) capacitor c=2.54544e-17
C15 (\1\:A VSS) capacitor c=2.09342e-16
C16 (\10\:A VSS) capacitor c=2.43985e-17
C17 (\5\:Ybint VSS) capacitor c=7.83673e-18
C18 (\2\:Y VSS) capacitor c=3.21152e-17
C19 (\1\:Y VSS) capacitor c=3.12551e-17
C20 (\2\:ISOn VSS) capacitor c=2.22483e-17
C21 (\2\:Ybint VSS) capacitor c=2.41265e-17
C22 (\3\:Yint VSS) capacitor c=2.4391e-17
C23 (\2\:GatedVSS VSS) capacitor c=3.15366e-17
C24 (\4\:Ab VSS) capacitor c=6.12182e-17
C25 (\6\:A VSS) capacitor c=2.15167e-17
C26 (\6\:Y VSS) capacitor c=7.57738e-17
C27 (\1\:VDD VSS) capacitor c=9.0416e-17
C28 (\3\:Y VSS) capacitor c=5.41573e-17
C29 (\8\:VDD VSS) capacitor c=6.65171e-17
C30 (\3\:VDD VSS) capacitor c=5.18302e-17
C31 (\11\:Yint VSS) capacitor c=5.04072e-17
C32 (\11\:Ybint VSS) capacitor c=8.50568e-17
C33 (\10\:VDD VSS) capacitor c=5.22442e-17
C34 (\7\:Ab VSS) capacitor c=8.57897e-17
C35 (\4\:ExtVDD VSS) capacitor c=3.5164e-17
C36 (\9\:Y VSS) capacitor c=3.88959e-17
C37 (\9\:GatedVSS VSS) capacitor c=9.87053e-17
C38 (\3\:GatedVSS VSS) capacitor c=2.57382e-16
C39 (\5\:Yint VSS) capacitor c=1.89238e-16
C40 (\10\:Ab VSS) capacitor c=6.32466e-17
C41 (\15\:GatedVSS VSS) capacitor c=1.09109e-16
C42 (ExtVDD VSS) capacitor c=3.05636e-17
C43 (VDD VSS) capacitor c=3.36875e-17
C44 (\2\:Yint VSS) capacitor c=2.50995e-17
C45 (\4\:A VSS) capacitor c=1.65128e-16
C46 (\5\:A VSS) capacitor c=2.24741e-17
C47 (\3\:ISOn VSS) capacitor c=1.31612e-16
C48 (\4\:Ybint VSS) capacitor c=8.75889e-18
C49 (\11\:A VSS) capacitor c=3.51098e-17
C50 (\3\:ExtVDD VSS) capacitor c=1.93217e-17
C51 (\9\:Ab VSS) capacitor c=1.05321e-16
C52 (\8\:Yint VSS) capacitor c=3.86168e-17
C53 (\13\:Yint VSS) capacitor c=3.22417e-17
C54 (\6\:GatedVSS VSS) capacitor c=8.02674e-17
C55 (\5\:Y VSS) capacitor c=4.62553e-17
C56 (\11\:GatedVSS VSS) capacitor c=4.06595e-16
C57 (\14\:GatedVSS VSS) capacitor c=1.87362e-16
C58 (\23\:GatedVSS VSS) capacitor c=1.03938e-16
C59 (\10\:ISOn VSS) capacitor c=2.65767e-17
C60 (\12\:ISOn VSS) capacitor c=1.16035e-17
C61 (\7\:Ybint VSS) capacitor c=5.30765e-17
C62 (\8\:Ybint VSS) capacitor c=1.74742e-16
C63 (\10\:Ybint VSS) capacitor c=6.19032e-17
C64 (\8\:Y VSS) capacitor c=6.69319e-17
C65 (\5\:VDD VSS) capacitor c=1.05913e-16
C66 (\7\:VDD VSS) capacitor c=3.43577e-17
Rk51 (VDD VDD) resistor r=0.3021 c=0
Rk47 (\2\:VDD \4\:VDD) resistor r=0.5799 c=0
Rk48 (\4\:VDD \5\:VDD) resistor r=0.2406 c=0
Rk50 (\7\:VDD VDD) resistor r=0.2262 c=0
Rk49 (\5\:VDD \7\:VDD) resistor r=0.2183 c=0
Rk52 (\5\:VDD \9\:VDD) resistor r=0.561 c=0
Rk53 (VDD \11\:VDD) resistor r=0.2857 c=0
Rk25 (\10\:ISOn \11\:ISOn) resistor r=0.003235 c=0
Rk26 (ISOn \12\:ISOn) resistor r=0.003235 c=0
Rk27 (\10\:ISOn \12\:ISOn) resistor r=0.0469 c=0
Rk28 (\13\:ISOn ISOn) resistor r=0.003235 c=0
Rk29 (\12\:ISOn \13\:ISOn) resistor r=0.009821 c=0
Rk43 (VSS VSS) resistor r=0.3143 c=0
Rk42 (\1\:VSS VSS) resistor r=0.3016 c=0
Rk55 (VSS VSS) resistor r=0.275 c=0
Rk44 (VSS \7\:VSS) resistor r=0.07882 c=0
Rk54 (\13\:VSS VSS) resistor r=0.589 c=0
Rk56 (VSS \14\:VSS) resistor r=0.1181 c=0
Rk15 (\4\:Y \5\:Y) resistor r=0.2695 c=0
Rk36 (Y \7\:Y) resistor r=0.211 c=0
Rk37 (\7\:Y \8\:Y) resistor r=0.5182 c=0
Rk38 (Y \10\:Y) resistor r=0.2216 c=0
Rk1 (\11\:A A) resistor r=0.02676 c=0
Rk4 (\3\:ExtVDD ExtVDD) resistor r=0.02412 c=0
Rk3 (ExtVDD \3\:ExtVDD) resistor r=0.03418 c=0
Rk5 (\3\:ExtVDD \5\:ExtVDD) resistor r=0.2887 c=0
Rk9 (\5\:Yint \8\:Yint) resistor r=0.201 c=0
Rk11 (\12\:Yint \13\:Yint) resistor r=0.2045 c=0
Rk6 (\8\:Ab \9\:Ab) resistor r=0.6827 c=0
Rk7 (\9\:Ab \11\:Ab) resistor r=0.4468 c=0
Rk30 (\7\:Ybint \8\:Ybint) resistor r=0.3012 c=0
Rk32 (\8\:Ybint \10\:Ybint) resistor r=0.1518 c=0
Rk33 (\10\:Ybint \12\:Ybint) resistor r=0.5775 c=0
Rk13 (\3\:GatedVSS \6\:GatedVSS) resistor r=1.1963 c=0
Rk16 (\10\:GatedVSS \11\:GatedVSS) resistor r=0.6479 c=0
Rk19 (\11\:GatedVSS \14\:GatedVSS) resistor r=0.3558 c=0
Rk20 (\14\:GatedVSS \16\:GatedVSS) resistor r=0.7651 c=0
Rk24 (\14\:GatedVSS \23\:GatedVSS) resistor r=0.8113 c=0
Rl20 (\2\:ISOn \1\:ISOn) resistor r=67.8776 c=0
Rl21 (\3\:ISOn \2\:ISOn) resistor r=25.5508 c=0
Rl28 (\1\:Y \2\:Y) resistor r=105.578 c=0
Rl18 (\4\:A \9\:A) resistor r=239.672 c=0
Rl13 (\4\:A \1\:A) resistor r=494.483 c=0
Rl19 (\5\:A \10\:A) resistor r=59.022 c=0
Rl15 (\5\:A \6\:A) resistor r=46.4864 c=0
Rl14 (\5\:A \4\:A) resistor r=192.732 c=0
Rl9 (\2\:Yint \4\:Yint) resistor r=41.7694 c=0
Rl7 (\2\:Yint Yint) resistor r=148.662 c=0
Rl8 (\2\:Yint \3\:Yint) resistor r=34.5546 c=0
Rl4 (Ab \4\:Ab) resistor r=178.013 c=0
Rl10 (\2\:Ybint Ybint) resistor r=58.6635 c=0
Rl31 (\4\:Ybint \6\:Ybint) resistor r=53.5603 c=0
Rl29 (\4\:Ybint \3\:Ybint) resistor r=53.5603 c=0
Rl30 (\4\:Ybint \5\:Ybint) resistor r=2.0166 c=0
Rl1 (\2\:GatedVSS GatedVSS) resistor r=171.167 c=0
Rz14 (\9\:Y \10\:Y) resistor r=37.5 c=0
Rz2 (\11\:Ab \10\:Ab) resistor r=75 c=0
Rz7 (\10\:GatedVSS \9\:GatedVSS) resistor r=37.5 c=0
Rz8 (\16\:GatedVSS \15\:GatedVSS) resistor r=75 c=0
Ry9 (\1\:VDD \2\:VDD) resistor r=20.6667 c=0
Ry10 (\3\:VDD \4\:VDD) resistor r=62 c=0
Ry11 (\8\:VDD \9\:VDD) resistor r=20.6667 c=0
Ry12 (\10\:VDD \11\:VDD) resistor r=62 c=0
Ry7 (\1\:VSS \3\:VSS) resistor r=7.75 c=0
Ry8 (\7\:VSS \3\:VSS) resistor r=5.1667 c=0
Ry13 (\13\:VSS \12\:VSS) resistor r=7.75 c=0
Ry14 (\14\:VSS \12\:VSS) resistor r=5.1667 c=0
Ry4 (\3\:Y \4\:Y) resistor r=20.6667 c=0
Ry6 (\6\:Y \7\:Y) resistor r=20.6667 c=0
Ry1 (\4\:ExtVDD \5\:ExtVDD) resistor r=62 c=0
Ry3 (\12\:Yint \11\:Yint) resistor r=62 c=0
Ry2 (\8\:Ab \7\:Ab) resistor r=62 c=0
Ry5 (\12\:Ybint \11\:Ybint) resistor r=62 c=0
Rx8 (\11\:ISOn \2\:ISOn) resistor r=45 c=0
Rx6 (\2\:Y \5\:Y) resistor r=45 c=0
Rx11 (\1\:Y \8\:Y) resistor r=45 c=0
Rx1 (\11\:A \6\:A) resistor r=45 c=0
Rx3 (\8\:Yint \3\:Yint) resistor r=45 c=0
Rx4 (\13\:Yint Yint) resistor r=45 c=0
Rx2 (\9\:Ab \4\:Ab) resistor r=45 c=0
Rx9 (\7\:Ybint \5\:Ybint) resistor r=45 c=0
Rx10 (\10\:Ybint \2\:Ybint) resistor r=45 c=0
Rx5 (\6\:GatedVSS \2\:GatedVSS) resistor r=45 c=0
Rx7 (\23\:GatedVSS GatedVSS) resistor r=45 c=0
NM2 (\15\:GatedVSS \10\:A \10\:Ab VSS) g45n1svt w=(1.45e-07) l=4.5e-08 \
        nf=1 as=2.03e-14 ad=2.03e-14 ps=5.7e-07 pd=5.7e-07 nrd=1.16667 \
        nrs=1.16667 sa=1.4e-07 sb=1.4e-07 sd=160n sca=12.9138 \
        scb=0.0133404 scc=0.000640143 m=(1)
mn0 (\9\:Y \3\:Ybint \9\:GatedVSS VSS) g45n1svt w=(2.6e-07) l=4.5e-08 \
        nf=1 as=3.64e-14 ad=3.64e-14 ps=8e-07 pd=8e-07 nrd=1.16667 \
        nrs=1.16667 sa=1.4e-07 sb=1.4e-07 sd=160n sca=15.3338 \
        scb=0.0153436 scc=0.00119435 m=(1)
NM3_1__rcx (\3\:GatedVSS \3\:ISOn \1\:VSS VSS) g45n1svt w=(2.6e-07) \
        l=4.5e-08 nf=1 as=4.16e-14 ad=3.9e-14 ps=8.4e-07 pd=8.2e-07 \
        nrd=1.16667 nrs=1.16667 sa=1.4e-07 sb=7.55e-07 sd=160n sca=9.14564 \
        scb=0.00759168 scc=0.000213449 m=(4)
NM1_1__rcx (\5\:Yint Ab \11\:GatedVSS VSS) g45n1svt w=(2.6e-07) l=4.5e-08 \
        nf=1 as=4.16e-14 ad=3.987e-14 ps=8.4e-07 pd=8.2667e-07 nrd=1.16667 \
        nrs=1.16667 sa=5.5e-07 sb=7.55e-07 sd=160n sca=15.3338 \
        scb=0.0153436 scc=0.00119435 m=(3)
NM0 (\8\:Ybint \1\:A \11\:GatedVSS VSS) g45n1svt w=(2.6e-07) l=4.5e-08 \
        nf=1 as=3.987e-14 ad=4.16e-14 ps=8.2667e-07 pd=8.4e-07 nrd=1.16667 \
        nrs=1.16667 sa=7.55e-07 sb=5.5e-07 sd=160n sca=15.3338 \
        scb=0.0153436 scc=0.00119435 m=(3)
PM4 (\3\:Y \1\:ISOn \8\:VDD VDD) g45p1svt w=(3.9e-07) l=4.5e-08 nf=1 \
        as=5.46e-14 ad=5.46e-14 ps=1.06e-06 pd=1.06e-06 nrd=1.16667 \
        nrs=1.16667 sa=1.4e-07 sb=1.4e-07 sd=160n sca=17.4004 \
        scb=0.0152661 scc=0.00148051 m=(1)
mp0 (\6\:Y \6\:Ybint \1\:VDD VDD) g45p1svt w=(3.9e-07) l=4.5e-08 nf=1 \
        as=5.46e-14 ad=5.46e-14 ps=1.06e-06 pd=1.06e-06 nrd=1.16667 \
        nrs=1.16667 sa=1.4e-07 sb=1.4e-07 sd=160n sca=29.774 scb=0.0318253 \
        scc=0.00283569 m=(1)
ends LSLH_ISONH_X1_TO_ON
// End of subcircuit definition.
