// gsclib045_backbias/OA21X4/schematic

simulator lang=spectre

subckt OA21X4 A0 A1 B0 Y VSS VDD NW
mn1 (net107 A1 VSS VSS) g45n1svt w=(260n) l=45n nf=1 m=(1)
mn0 (net107 A0 VSS VSS) g45n1svt w=(260n) l=45n nf=1 m=(1)
mn3 (Y net95 VSS VSS) g45n1svt w=(1.04u) l=45n nf=1 m=(1)
mn2 (net95 B0 net107 VSS) g45n1svt w=(260n) l=45n nf=1 m=(1)
mp1 (net95 A1 net98 NW) g45p1svt w=(390n) l=45n nf=1 m=(1)
mp0 (net98 A0 VDD NW) g45p1svt w=(390n) l=45n nf=1 m=(1)
mp3 (Y net95 VDD NW) g45p1svt w=(1.56u) l=45n nf=1 m=(1)
mp2 (net95 B0 VDD NW) g45p1svt w=(390n) l=45n nf=1 m=(1)
ends OA21X4
