// Generated for: spectre (Mar 20 14:04:25 2013 )
// Library name: gsclib045
// Cell name: CLKINVX8
// View name: schematic

simulator lang=spectre

subckt CLKINVX8 A Y VDD VSS
mp0 (Y A VDD VDD) g45p1svt w=(3.115u) l=45n nf=1 as=436.1f ad=436.1f \
        ps=6.51u pd=6.51u nrd=44.9438m nrs=44.9438m sa=140n sb=140n \
        sd=160n sca=51.31501 scb=0.05377 scc=0.00636 m=(1)
mn0 (Y A VSS VSS) g45n1svt w=(2.065u) l=45n nf=1 as=289.1f ad=289.1f \
        ps=4.41u pd=4.41u nrd=67.7966m nrs=67.7966m sa=140n sb=140n \
        sd=160n sca=56.50260 scb=0.05663 scc=0.00690 m=(1)
ends CLKINVX8
// End of subcircuit definition.
