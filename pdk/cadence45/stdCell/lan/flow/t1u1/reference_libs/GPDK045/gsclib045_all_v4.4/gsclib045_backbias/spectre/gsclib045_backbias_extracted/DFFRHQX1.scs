// Generated for: spectre (May  1 11:28:47 2013 )
// Library name: gsclib045_backbias
// Cell name: DFFRHQX1
// View name: extracted

simulator lang=spectre

subckt DFFRHQX1 CK D NW Q RN VDD VSS
mp55 (\1\:Q qbint \16\:VDD NW) g45p1svt w=(3.9e-07) l=4.5e-08 nf=1 \
        as=6.535e-14 ad=5.46e-14 ps=1.16e-06 pd=1.06e-06 nrd=1.16667 \
        nrs=1.16667 sa=1.4e-07 sb=2.61346e-07 sd=160n sca=30.3965 \
        scb=0.0339368 scc=0.00268693 m=(1)
C1 (NW VSS) capacitor c=4.94444e-16
C2 (Q VSS) capacitor c=4.49951e-17
C3 (CK VSS) capacitor c=5.00619e-17
C4 (D VSS) capacitor c=4.62016e-17
C5 (VDD VSS) capacitor c=3.57531e-17
C6 (qbint VSS) capacitor c=5.37814e-17
C7 (CKb VSS) capacitor c=4.97774e-17
C8 (n35 VSS) capacitor c=1.23531e-18
C9 (n30 VSS) capacitor c=5.94889e-17
C10 (n40 VSS) capacitor c=1.30342e-18
C11 (mout VSS) capacitor c=5.38733e-17
C12 (CKbb VSS) capacitor c=2.51902e-17
C13 (n20 VSS) capacitor c=5.05968e-17
C14 (n21 VSS) capacitor c=1.23445e-18
C15 (n41 VSS) capacitor c=1.08267e-18
C16 (n26 VSS) capacitor c=1.20385e-16
C17 (n22 VSS) capacitor c=9.87314e-20
C18 (\8\:CKb VSS) capacitor c=2.85359e-17
C19 (\1\:D VSS) capacitor c=1.1132e-16
C20 (\6\:CKbb VSS) capacitor c=7.02065e-17
C21 (\5\:CKb VSS) capacitor c=3.64428e-17
C22 (\1\:RN VSS) capacitor c=1.42628e-16
C23 (\3\:CKb VSS) capacitor c=3.79559e-17
C24 (\3\:CKbb VSS) capacitor c=9.35877e-17
C25 (\4\:qbint VSS) capacitor c=9.03406e-17
C26 (\2\:RN VSS) capacitor c=1.05385e-16
C27 (\3\:n30 VSS) capacitor c=5.66571e-17
C28 (\1\:CK VSS) capacitor c=3.62963e-17
C29 (\10\:CKb VSS) capacitor c=4.6685e-17
C30 (\3\:D VSS) capacitor c=7.18923e-17
C31 (\7\:CKb VSS) capacitor c=6.96053e-17
C32 (\4\:CKbb VSS) capacitor c=4.19606e-17
C33 (\3\:mout VSS) capacitor c=5.42261e-17
C34 (\5\:RN VSS) capacitor c=7.13108e-17
C35 (\3\:n20 VSS) capacitor c=4.81596e-17
C36 (\6\:qbint VSS) capacitor c=5.81999e-17
C37 (\4\:RN VSS) capacitor c=8.08593e-17
C38 (\3\:CK VSS) capacitor c=4.73568e-17
C39 (\3\:qbint VSS) capacitor c=3.26871e-17
C40 (\9\:CKb VSS) capacitor c=5.12762e-17
C41 (\2\:D VSS) capacitor c=6.84267e-17
C42 (\7\:CKbb VSS) capacitor c=5.17329e-17
C43 (\6\:CKb VSS) capacitor c=4.57864e-17
C44 (\5\:CKbb VSS) capacitor c=3.74601e-17
C45 (\2\:mout VSS) capacitor c=6.19949e-17
C46 (\2\:n20 VSS) capacitor c=4.58148e-17
C47 (\4\:CKb VSS) capacitor c=3.11925e-17
C48 (\2\:CKbb VSS) capacitor c=7.497e-17
C49 (\2\:CKb VSS) capacitor c=5.63669e-17
C50 (\5\:qbint VSS) capacitor c=7.87274e-17
C51 (\3\:RN VSS) capacitor c=5.28322e-17
C52 (\2\:n30 VSS) capacitor c=4.22487e-17
C53 (\2\:CK VSS) capacitor c=4.75037e-17
C54 (\2\:qbint VSS) capacitor c=3.4983e-17
C55 (\12\:CKbb VSS) capacitor c=3.53364e-17
C56 (\1\:VDD VSS) capacitor c=1.39826e-16
C57 (\4\:n20 VSS) capacitor c=1.20274e-16
C58 (\8\:VDD VSS) capacitor c=6.07133e-17
C59 (\3\:n26 VSS) capacitor c=1.01938e-16
C60 (\10\:VDD VSS) capacitor c=6.87273e-17
C61 (\8\:mout VSS) capacitor c=1.12123e-16
C62 (\4\:n30 VSS) capacitor c=1.04635e-16
C63 (\12\:VDD VSS) capacitor c=9.14879e-17
C64 (\11\:qbint VSS) capacitor c=8.24971e-17
C65 (\14\:VDD VSS) capacitor c=7.58692e-17
C66 (\20\:CKb VSS) capacitor c=3.6369e-17
C67 (\16\:VDD VSS) capacitor c=7.51267e-17
C68 (\1\:Q VSS) capacitor c=3.36843e-17
C69 (\15\:CKbb VSS) capacitor c=1.61375e-17
C70 (\8\:n20 VSS) capacitor c=6.085e-17
C71 (\6\:mout VSS) capacitor c=6.02542e-17
C72 (\8\:n30 VSS) capacitor c=3.30566e-17
C73 (\13\:qbint VSS) capacitor c=3.84702e-17
C74 (\17\:CKb VSS) capacitor c=1.04714e-16
C75 (\3\:Q VSS) capacitor c=7.06496e-17
C76 (\4\:CK VSS) capacitor c=4.02521e-17
C77 (\7\:qbint VSS) capacitor c=7.02437e-17
C78 (\8\:qbint VSS) capacitor c=1.48628e-16
C79 (\9\:qbint VSS) capacitor c=1.8069e-16
C80 (\10\:qbint VSS) capacitor c=1.46097e-16
C81 (\6\:RN VSS) capacitor c=7.08568e-17
C82 (\8\:RN VSS) capacitor c=6.81434e-17
C83 (\6\:n30 VSS) capacitor c=1.41619e-16
C84 (\7\:n30 VSS) capacitor c=1.11477e-16
C85 (\4\:mout VSS) capacitor c=1.00263e-16
C86 (\5\:mout VSS) capacitor c=1.27625e-16
C87 (\6\:n20 VSS) capacitor c=1.68474e-16
C88 (\7\:n20 VSS) capacitor c=1.38912e-16
C89 (\4\:D VSS) capacitor c=7.25127e-17
C90 (\11\:CKb VSS) capacitor c=1.6371e-16
C91 (\12\:CKb VSS) capacitor c=3.41845e-16
C92 (\13\:CKb VSS) capacitor c=2.32392e-16
C93 (\14\:CKb VSS) capacitor c=8.59697e-17
C94 (\15\:CKb VSS) capacitor c=2.76465e-16
C95 (\16\:CKb VSS) capacitor c=2.38568e-16
C96 (\19\:CKb VSS) capacitor c=7.46463e-17
C97 (\8\:CKbb VSS) capacitor c=3.59147e-17
C98 (\9\:CKbb VSS) capacitor c=2.69096e-16
C99 (\10\:CKbb VSS) capacitor c=1.36757e-16
C100 (\11\:CKbb VSS) capacitor c=6.79526e-17
C101 (\14\:CKbb VSS) capacitor c=1.8255e-16
C102 (\17\:CKbb VSS) capacitor c=7.84808e-17
C103 (\3\:VDD VSS) capacitor c=8.91193e-17
C104 (\4\:VDD VSS) capacitor c=7.61816e-17
C105 (\5\:VDD VSS) capacitor c=8.11837e-17
C106 (\6\:VDD VSS) capacitor c=4.80207e-17
C107 (\7\:VDD VSS) capacitor c=3.28392e-17
Rk1 (Q \2\:Q) resistor r=0.07294 c=0
Rk2 (Q \4\:Q) resistor r=0.4479 c=0
Rk3 (\4\:CK CK) resistor r=0.05341 c=0
Rk22 (D \4\:D) resistor r=0.1047 c=0
Rk38 (\2\:VSS \3\:VSS) resistor r=0.2514 c=0
Rk39 (\3\:VSS \5\:VSS) resistor r=0.4594 c=0
Rk40 (\3\:VSS \6\:VSS) resistor r=0.4541 c=0
Rk42 (\7\:VSS VSS) resistor r=0.1035 c=0
Rk41 (\6\:VSS \7\:VSS) resistor r=0.4537 c=0
Rk43 (\5\:VSS \9\:VSS) resistor r=0.2571 c=0
Rk44 (\5\:VSS \11\:VSS) resistor r=0.3398 c=0
Rk45 (\6\:VSS \13\:VSS) resistor r=0.2782 c=0
Rk46 (\7\:VSS \15\:VSS) resistor r=0.309 c=0
Rk47 (\2\:VDD \3\:VDD) resistor r=0.7586 c=0
Rk48 (\3\:VDD \4\:VDD) resistor r=0.2075 c=0
Rk49 (\4\:VDD \5\:VDD) resistor r=0.4383 c=0
Rk50 (\5\:VDD \6\:VDD) resistor r=0.243 c=0
Rk52 (\7\:VDD VDD) resistor r=0.1035 c=0
Rk51 (\6\:VDD \7\:VDD) resistor r=0.2253 c=0
Rk53 (\3\:VDD \9\:VDD) resistor r=0.3115 c=0
Rk54 (\4\:VDD \11\:VDD) resistor r=0.3676 c=0
Rk55 (\5\:VDD \13\:VDD) resistor r=0.4013 c=0
Rk56 (\6\:VDD \15\:VDD) resistor r=0.3386 c=0
Rk57 (\7\:VDD \17\:VDD) resistor r=0.3605 c=0
Rk9 (\6\:RN \7\:RN) resistor r=0.00567 c=0
Rk10 (RN \8\:RN) resistor r=0.00567 c=0
Rk11 (\6\:RN \8\:RN) resistor r=0.06642 c=0
Rk4 (\7\:qbint \8\:qbint) resistor r=0.3386 c=0
Rk5 (\8\:qbint \9\:qbint) resistor r=0.5369 c=0
Rk6 (\9\:qbint \10\:qbint) resistor r=0.9141 c=0
Rk7 (\8\:qbint \12\:qbint) resistor r=0.3894 c=0
Rk8 (\9\:qbint \14\:qbint) resistor r=0.1112 c=0
Rk23 (\11\:CKb \12\:CKb) resistor r=1.1591 c=0
Rk24 (\12\:CKb \13\:CKb) resistor r=1.3824 c=0
Rk25 (\13\:CKb \14\:CKb) resistor r=0.3979 c=0
Rk26 (\13\:CKb \15\:CKb) resistor r=0.5539 c=0
Rk27 (\15\:CKb \16\:CKb) resistor r=1.3763 c=0
Rk28 (\16\:CKb \18\:CKb) resistor r=0.461 c=0
Rk29 (\15\:CKb \19\:CKb) resistor r=0.4123 c=0
Rk30 (\16\:CKb \21\:CKb) resistor r=0.1996 c=0
Rk12 (\5\:n30 \6\:n30) resistor r=0.6402 c=0
Rk13 (\6\:n30 \7\:n30) resistor r=0.6152 c=0
Rk14 (\6\:n30 \9\:n30) resistor r=0.08583 c=0
Rk15 (\4\:mout \5\:mout) resistor r=0.5031 c=0
Rk16 (\5\:mout \7\:mout) resistor r=0.2002 c=0
Rk17 (\5\:mout \9\:mout) resistor r=0.4231 c=0
Rk31 (\8\:CKbb \9\:CKbb) resistor r=0.06918 c=0
Rk32 (\9\:CKbb \10\:CKbb) resistor r=1.0875 c=0
Rk33 (\10\:CKbb \11\:CKbb) resistor r=0.252 c=0
Rk34 (\11\:CKbb \13\:CKbb) resistor r=0.2478 c=0
Rk35 (\9\:CKbb \14\:CKbb) resistor r=1.1807 c=0
Rk36 (\10\:CKbb \16\:CKbb) resistor r=0.07674 c=0
Rk37 (\11\:CKbb \17\:CKbb) resistor r=0.3146 c=0
Rk19 (\5\:n20 \6\:n20) resistor r=0.676 c=0
Rk20 (\6\:n20 \7\:n20) resistor r=0.7869 c=0
Rk21 (\6\:n20 \9\:n20) resistor r=0.2139 c=0
Rk18 (\2\:n26 \4\:n26) resistor r=0.5797 c=0
Rl3 (\1\:CK \2\:CK) resistor r=96.8456 c=0
Rl4 (\2\:CK \3\:CK) resistor r=154.538 c=0
Rl25 (\1\:D \2\:D) resistor r=168.257 c=0
Rl26 (\2\:D \3\:D) resistor r=111.459 c=0
Rl15 (\1\:RN \2\:RN) resistor r=367.561 c=0
Rl18 (\1\:RN \5\:RN) resistor r=207.692 c=0
Rl16 (\2\:RN \3\:RN) resistor r=40.8576 c=0
Rl17 (\3\:RN \4\:RN) resistor r=138.31 c=0
Rl7 (\4\:qbint \5\:qbint) resistor r=127.926 c=0
Rl8 (\5\:qbint \6\:qbint) resistor r=53.079 c=0
Rl1 (qbint \2\:qbint) resistor r=106.867 c=0
Rl2 (\2\:qbint \3\:qbint) resistor r=26.098 c=0
Rl27 (\8\:CKb \9\:CKb) resistor r=26.1559 c=0
Rl28 (\9\:CKb \10\:CKb) resistor r=187.694 c=0
Rl22 (\5\:CKb \6\:CKb) resistor r=42.3077 c=0
Rl23 (\6\:CKb \7\:CKb) resistor r=141.209 c=0
Rl12 (\3\:CKb \4\:CKb) resistor r=35.3072 c=0
Rl9 (CKb \2\:CKb) resistor r=51.098 c=0
Rl6 (\2\:n30 \3\:n30) resistor r=149.175 c=0
Rl5 (n30 \2\:n30) resistor r=60.6757 c=0
Rl19 (mout \2\:mout) resistor r=133.848 c=0
Rl20 (\2\:mout \3\:mout) resistor r=45.3867 c=0
Rl24 (\6\:CKbb \7\:CKbb) resistor r=71.8456 c=0
Rl21 (\4\:CKbb \5\:CKbb) resistor r=29.5379 c=0
Rl11 (\2\:CKbb \3\:CKbb) resistor r=174.543 c=0
Rl10 (CKbb \2\:CKbb) resistor r=55.3008 c=0
Rl13 (n20 \2\:n20) resistor r=56.4615 c=0
Rl14 (\2\:n20 \3\:n20) resistor r=124.527 c=0
Rz1 (\3\:Q \4\:Q) resistor r=37.5 c=0
Rz8 (\1\:VSS \2\:VSS) resistor r=75 c=0
Rz9 (\8\:VSS \9\:VSS) resistor r=75 c=0
Rz10 (\10\:VSS \11\:VSS) resistor r=75 c=0
Rz11 (\12\:VSS \13\:VSS) resistor r=75 c=0
Rz12 (\14\:VSS \15\:VSS) resistor r=37.5 c=0
Rz2 (\13\:qbint \14\:qbint) resistor r=75 c=0
Rz6 (\17\:CKb \18\:CKb) resistor r=75 c=0
Rz3 (\8\:n30 \9\:n30) resistor r=75 c=0
Rz4 (\6\:mout \7\:mout) resistor r=75 c=0
Rz7 (\15\:CKbb \16\:CKbb) resistor r=75 c=0
Rz5 (\8\:n20 \9\:n20) resistor r=75 c=0
Ry1 (\1\:Q \2\:Q) resistor r=20.6667 c=0
Ry10 (\4\:VSS \5\:VSS) resistor r=10.3333 c=0
Ry11 (\4\:VSS \6\:VSS) resistor r=5.1667 c=0
Ry12 (\1\:VDD \2\:VDD) resistor r=62 c=0
Ry13 (\8\:VDD \9\:VDD) resistor r=31 c=0
Ry14 (\10\:VDD \11\:VDD) resistor r=62 c=0
Ry15 (\12\:VDD \13\:VDD) resistor r=62 c=0
Ry16 (\14\:VDD \15\:VDD) resistor r=31 c=0
Ry17 (\16\:VDD \17\:VDD) resistor r=20.6667 c=0
Ry2 (\11\:qbint \12\:qbint) resistor r=62 c=0
Ry8 (\20\:CKb \21\:CKb) resistor r=62 c=0
Ry3 (\4\:n30 \5\:n30) resistor r=62 c=0
Ry4 (\8\:mout \9\:mout) resistor r=62 c=0
Ry9 (\12\:CKbb \13\:CKbb) resistor r=62 c=0
Ry7 (\4\:n20 \5\:n20) resistor r=62 c=0
Ry5 (n26 \2\:n26) resistor r=31 c=0
Ry6 (\3\:n26 \4\:n26) resistor r=31 c=0
Rx1 (\2\:CK \4\:CK) resistor r=45 c=0
Rx8 (\2\:D \4\:D) resistor r=45 c=0
Rx4 (\3\:RN \7\:RN) resistor r=45 c=0
Rx2 (\5\:qbint \7\:qbint) resistor r=45 c=0
Rx3 (\2\:qbint \10\:qbint) resistor r=45 c=0
Rx9 (\9\:CKb \11\:CKb) resistor r=45 c=0
Rx10 (\6\:CKb \12\:CKb) resistor r=45 c=0
Rx11 (\4\:CKb \14\:CKb) resistor r=45 c=0
Rx12 (\2\:CKb \19\:CKb) resistor r=45 c=0
Rx5 (\2\:n30 \7\:n30) resistor r=45 c=0
Rx6 (\2\:mout \4\:mout) resistor r=45 c=0
Rx13 (\5\:CKbb \8\:CKbb) resistor r=45 c=0
Rx14 (\2\:CKbb \14\:CKbb) resistor r=45 c=0
Rx15 (\7\:CKbb \17\:CKbb) resistor r=45 c=0
Rx7 (\2\:n20 \7\:n20) resistor r=45 c=0
mn55 (\3\:Q \3\:qbint \14\:VSS VSS) g45n1svt w=(2.6e-07) l=4.5e-08 nf=1 \
        as=4.365e-14 ad=3.64e-14 ps=9e-07 pd=8e-07 nrd=1.16667 nrs=1.16667 \
        sa=1.4e-07 sb=2.85e-07 sd=160n sca=9.32128 scb=0.00786794 \
        scc=0.000232361 m=(1)
mn20 (\17\:CKb \3\:CK \14\:VSS VSS) g45n1svt w=(1.45e-07) l=4.5e-08 nf=1 \
        as=4.365e-14 ad=2.393e-14 ps=9e-07 pd=6.2e-07 nrd=1.16667 \
        nrs=1.16667 sa=3.75e-07 sb=1.65e-07 sd=160n sca=7.47547 \
        scb=0.00467957 scc=5.27432e-05 m=(1)
mn21 (\15\:CKbb \10\:CKb \10\:VSS VSS) g45n1svt w=(1.45e-07) l=4.5e-08 \
        nf=1 as=2.03e-14 ad=2.03e-14 ps=5.7e-07 pd=5.7e-07 nrd=1.16667 \
        nrs=1.16667 sa=1.4e-07 sb=1.4e-07 sd=160n sca=7.37439 \
        scb=0.00450456 scc=4.82709e-05 m=(1)
mn46 (\13\:qbint n30 n35 VSS) g45n1svt w=(2.05e-07) l=4.5e-08 nf=1 \
        as=1.23e-14 ad=2.53e-14 ps=5.3e-07 pd=6.9e-07 nrd=1.16667 \
        nrs=1.16667 sa=1.23415e-07 sb=1.98037e-06 sd=160n sca=9.00745 \
        scb=0.0073653 scc=0.000173562 m=(1)
mn45 (n35 \4\:RN \12\:VSS VSS) g45n1svt w=(2.05e-07) l=4.5e-08 nf=1 \
        as=4.733e-14 ad=1.23e-14 ps=1.19e-06 pd=5.3e-07 nrd=1.16667 \
        nrs=1.16667 sa=2.28415e-07 sb=1.89073e-06 sd=160n sca=9.00745 \
        scb=0.0073653 scc=0.000173562 m=(1)
mn50 (n40 \6\:qbint \12\:VSS VSS) g45n1svt w=(2.05e-07) l=4.5e-08 nf=1 \
        as=4.733e-14 ad=1.23e-14 ps=1.19e-06 pd=5.3e-07 nrd=1.16667 \
        nrs=1.16667 sa=4.38415e-07 sb=1.68073e-06 sd=160n sca=9.00745 \
        scb=0.0073653 scc=0.000173562 m=(1)
mn51 (\8\:n30 CKb n40 VSS) g45n1svt w=(2.05e-07) l=4.5e-08 nf=1 \
        as=1.23e-14 ad=4.715e-14 ps=5.3e-07 pd=8.7e-07 nrd=1.16667 \
        nrs=1.16667 sa=5.43415e-07 sb=1.57573e-06 sd=160n sca=9.00745 \
        scb=0.0073653 scc=0.000173562 m=(1)
mn40 (\8\:n30 CKbb \6\:mout VSS) g45n1svt w=(2.05e-07) l=4.5e-08 nf=1 \
        as=4.51e-14 ad=4.715e-14 ps=8.5e-07 pd=8.7e-07 nrd=1.16667 \
        nrs=1.16667 sa=8.18415e-07 sb=1.30073e-06 sd=160n sca=9.00745 \
        scb=0.0073653 scc=0.000173562 m=(1)
mn30 (\6\:mout \3\:n20 \1\:VSS VSS) g45n1svt w=(2.05e-07) l=4.5e-08 nf=1 \
        as=5.92e-14 ad=4.51e-14 ps=1.24e-06 pd=8.5e-07 nrd=1.16667 \
        nrs=1.16667 sa=1.08341e-06 sb=1.03573e-06 sd=160n sca=9.00745 \
        scb=0.0073653 scc=0.000173562 m=(1)
mn35 (n27 \5\:RN \1\:VSS VSS) g45n1svt w=(2.05e-07) l=4.5e-08 nf=1 \
        as=5.92e-14 ad=3.28e-14 ps=1.24e-06 pd=7.3e-07 nrd=1.16667 \
        nrs=1.16667 sa=1.31841e-06 sb=8.00732e-07 sd=160n sca=9.00745 \
        scb=0.0073653 scc=0.000173562 m=(1)
mn36 (n25 \3\:mout n27 VSS) g45n1svt w=(2.05e-07) l=4.5e-08 nf=1 \
        as=3.28e-14 ad=1.23e-14 ps=7.3e-07 pd=5.3e-07 nrd=1.16667 \
        nrs=1.16667 sa=1.52341e-06 sb=5.95732e-07 sd=160n sca=9.00745 \
        scb=0.0073653 scc=0.000173562 m=(1)
mn37 (\8\:n20 \4\:CKbb n25 VSS) g45n1svt w=(2.05e-07) l=4.5e-08 nf=1 \
        as=1.23e-14 ad=4.305e-14 ps=5.3e-07 pd=8.3e-07 nrd=1.16667 \
        nrs=1.16667 sa=1.62841e-06 sb=4.90732e-07 sd=160n sca=9.00745 \
        scb=0.0073653 scc=0.000173562 m=(1)
mn26 (\8\:n20 \7\:CKb n21 VSS) g45n1svt w=(2.05e-07) l=4.5e-08 nf=1 \
        as=1.23e-14 ad=4.305e-14 ps=5.3e-07 pd=8.3e-07 nrd=1.16667 \
        nrs=1.16667 sa=1.88341e-06 sb=2.35732e-07 sd=160n sca=9.00745 \
        scb=0.0073653 scc=0.000173562 m=(1)
mn25 (n21 \3\:D \8\:VSS VSS) g45n1svt w=(2.05e-07) l=4.5e-08 nf=1 \
        as=3.04e-14 ad=1.23e-14 ps=8.1e-07 pd=5.3e-07 nrd=1.16667 \
        nrs=1.16667 sa=1.98549e-06 sb=1.30732e-07 sd=160n sca=9.00745 \
        scb=0.0073653 scc=0.000173562 m=(1)
mp20 (\20\:CKb \1\:CK \16\:VDD NW) g45p1svt w=(2.15e-07) l=4.5e-08 nf=1 \
        as=6.535e-14 ad=2.69e-14 ps=1.16e-06 pd=7.2e-07 nrd=1.16667 \
        nrs=1.16667 sa=3.75e-07 sb=1.25116e-07 sd=160n sca=13.8096 \
        scb=0.0118363 scc=0.000162518 m=(1)
mp21 (\12\:CKbb \8\:CKb \1\:VDD NW) g45p1svt w=(2.15e-07) l=4.5e-08 nf=1 \
        as=5.415e-14 ad=2.63e-14 ps=1e-06 pd=7.1e-07 nrd=1.16667 \
        nrs=1.16667 sa=7.2e-07 sb=1.22326e-07 sd=160n sca=27.6163 \
        scb=0.0324392 scc=0.00204694 m=(1)
mp46 (\11\:qbint \3\:n30 \14\:VDD NW) g45p1svt w=(3.1e-07) l=4.5e-08 \
        nf=1 as=4.66e-14 ad=5.735e-14 ps=9.5e-07 pd=9.9e-07 nrd=1.16667 \
        nrs=1.16667 sa=1.50323e-07 sb=1.65597e-06 sd=160n sca=12.8747 \
        scb=0.0114137 scc=0.000458937 m=(1)
mp45 (\11\:qbint \2\:RN \12\:VDD NW) g45p1svt w=(3.1e-07) l=4.5e-08 nf=1 \
        as=6.045e-14 ad=5.735e-14 ps=1.01e-06 pd=9.9e-07 nrd=1.16667 \
        nrs=1.16667 sa=3.80323e-07 sb=1.42597e-06 sd=160n sca=12.6932 \
        scb=0.0113709 scc=0.000458931 m=(1)
mp50 (n41 \4\:qbint \12\:VDD NW) g45p1svt w=(3.1e-07) l=4.5e-08 nf=1 \
        as=6.045e-14 ad=2.015e-14 ps=1.01e-06 pd=7.5e-07 nrd=1.16667 \
        nrs=1.16667 sa=6.20323e-07 sb=1.18597e-06 sd=160n sca=12.6932 \
        scb=0.0113709 scc=0.000458931 m=(1)
mp51 (\4\:n30 \3\:CKbb n41 NW) g45p1svt w=(3.1e-07) l=4.5e-08 nf=1 \
        as=2.015e-14 ad=6.355e-14 ps=7.5e-07 pd=1.03e-06 nrd=1.16667 \
        nrs=1.16667 sa=7.30323e-07 sb=1.07597e-06 sd=160n sca=12.6932 \
        scb=0.0113709 scc=0.000458931 m=(1)
mp40 (\4\:n30 \3\:CKb \8\:mout NW) g45p1svt w=(3.1e-07) l=4.5e-08 nf=1 \
        as=6.51e-14 ad=6.355e-14 ps=1.04e-06 pd=1.03e-06 nrd=1.16667 \
        nrs=1.16667 sa=9.80323e-07 sb=8.25968e-07 sd=160n sca=12.6932 \
        scb=0.0113709 scc=0.000458931 m=(1)
mp30 (\8\:mout n20 \10\:VDD NW) g45p1svt w=(3.1e-07) l=4.5e-08 nf=1 \
        as=5.89e-14 ad=6.51e-14 ps=1e-06 pd=1.04e-06 nrd=1.16667 \
        nrs=1.16667 sa=1.23532e-06 sb=5.70968e-07 sd=160n sca=12.6932 \
        scb=0.0113709 scc=0.000458931 m=(1)
mp35 (\3\:n26 \1\:RN \10\:VDD NW) g45p1svt w=(3.1e-07) l=4.5e-08 nf=1 \
        as=5.89e-14 ad=4.96e-14 ps=1e-06 pd=9.4e-07 nrd=1.16667 \
        nrs=1.16667 sa=1.47032e-06 sb=3.35968e-07 sd=160n sca=12.6932 \
        scb=0.0113709 scc=0.000458931 m=(1)
mp36 (\3\:n26 mout \8\:VDD NW) g45p1svt w=(3.1e-07) l=4.5e-08 nf=1 \
        as=4.06e-14 ad=4.96e-14 ps=9e-07 pd=9.4e-07 nrd=1.16667 \
        nrs=1.16667 sa=1.67532e-06 sb=1.30968e-07 sd=160n sca=12.6932 \
        scb=0.0113709 scc=0.000458931 m=(1)
mp37 (\4\:n20 \5\:CKb n26 NW) g45p1svt w=(3.1e-07) l=4.5e-08 nf=1 \
        as=5.145e-14 ad=4.96e-14 ps=9.7e-07 pd=9.4e-07 nrd=1.16667 \
        nrs=1.16667 sa=1.65968e-07 sb=6.00726e-07 sd=160n sca=13.271 \
        scb=0.0115865 scc=0.00045901 m=(1)
mp26 (\4\:n20 \6\:CKbb n22 NW) g45p1svt w=(3.1e-07) l=4.5e-08 nf=1 \
        as=1.86e-14 ad=4.96e-14 ps=7.4e-07 pd=9.4e-07 nrd=1.16667 \
        nrs=1.16667 sa=3.70968e-07 sb=3.95726e-07 sd=160n sca=14.4949 \
        scb=0.0127984 scc=0.000462551 m=(1)
mp25 (n22 \1\:D \1\:VDD NW) g45p1svt w=(3.1e-07) l=4.5e-08 nf=1 \
        as=5.415e-14 ad=1.86e-14 ps=1e-06 pd=7.4e-07 nrd=1.16667 \
        nrs=1.16667 sa=4.75968e-07 sb=2.90726e-07 sd=160n sca=15.7848 \
        scb=0.014788 scc=0.000483319 m=(1)
ends DFFRHQX1
// End of subcircuit definition.
