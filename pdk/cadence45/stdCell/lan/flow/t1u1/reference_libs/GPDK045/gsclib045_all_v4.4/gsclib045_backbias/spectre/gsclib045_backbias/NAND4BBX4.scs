// gsclib045_backbias/NAND4BBX4/schematic

simulator lang=spectre

subckt NAND4BBX4 AN BN C D Y VSS NW VDD
mn1 (n1 BN VSS VSS) g45n1svt w=(260n) l=45n nf=1 m=(1)
mn2 (n4 n0 VSS VSS) g45n1svt w=(1.04u) l=45n nf=1 m=(1)
mn4 (n2 C n3 VSS) g45n1svt w=(1.04u) l=45n nf=1 m=(1)
mn5 (Y D n2 VSS) g45n1svt w=(1.04u) l=45n nf=1 m=(1)
mn0 (n0 AN VSS VSS) g45n1svt w=(260n) l=45n nf=1 m=(1)
mn3 (n3 n1 n4 VSS) g45n1svt w=(1.04u) l=45n nf=1 m=(1)
mp2 (Y n0 VDD NW) g45p1svt w=(1.56u) l=45n nf=1 m=(1)
mp0 (n0 AN VDD NW) g45p1svt w=(390n) l=45n nf=1 m=(1)
mp5 (Y D VDD NW) g45p1svt w=(1.56u) l=45n nf=1 m=(1)
mp4 (Y C VDD NW) g45p1svt w=(1.56u) l=45n nf=1 m=(1)
mp1 (n1 BN VDD NW) g45p1svt w=(390n) l=45n nf=1 m=(1)
mp3 (Y n1 VDD NW) g45p1svt w=(1.56u) l=45n nf=1 m=(1)
ends NAND4BBX4
