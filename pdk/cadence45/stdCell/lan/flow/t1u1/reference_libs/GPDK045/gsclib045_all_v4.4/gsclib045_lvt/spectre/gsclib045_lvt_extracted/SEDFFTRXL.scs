// Generated for: spectre (May  1 09:15:32 2013 )
// Library name: gsclib045_lvt
// Cell name: SEDFFTRXL
// View name: extracted

simulator lang=spectre

subckt SEDFFTRXL CK D E Q QN RN SE SI VDD VSS
mp57 (\1\:QN \4\:net582 \26\:VDD VDD) g45p1lvt w=(2.15e-07) l=4.5e-08 \
        nf=1 as=7.205e-14 ad=3.547e-14 ps=1.92e-06 pd=7.6e-07 nrd=1.16667 \
        nrs=1.16667 sa=1.65e-07 sb=3.45e-07 sd=160n sca=56.1973 \
        scb=0.0435219 scc=0.00667686 m=(1)
mp56 (\5\:net582 qbint \26\:VDD VDD) g45p1lvt w=(2.15e-07) l=4.5e-08 \
        nf=1 as=7.205e-14 ad=3.01e-14 ps=1.92e-06 pd=7.1e-07 nrd=1.16667 \
        nrs=1.16667 sa=3.7e-07 sb=1.4e-07 sd=160n sca=48.8019 \
        scb=0.0316124 scc=0.00590646 m=(1)
mp45 (\16\:qbint n30 \23\:VDD VDD) g45p1lvt w=(2.15e-07) l=4.5e-08 nf=1 \
        as=6.96e-14 ad=3.01e-14 ps=1.21e-06 pd=7.1e-07 nrd=1.16667 \
        nrs=1.16667 sa=1.4e-07 sb=1.72e-06 sd=160n sca=12.1962 \
        scb=0.0105853 scc=0.000305891 m=(1)
mp50 (net529 \4\:qbint \23\:VDD VDD) g45p1lvt w=(2.15e-07) l=4.5e-08 \
        nf=1 as=6.96e-14 ad=2.903e-14 ps=1.21e-06 pd=7e-07 nrd=1.16667 \
        nrs=1.16667 sa=4.25e-07 sb=1.435e-06 sd=160n sca=11.9515 \
        scb=0.0105226 scc=0.000305882 m=(1)
mp51 (\8\:n30 CKbb net529 VDD) g45p1lvt w=(2.15e-07) l=4.5e-08 nf=1 \
        as=2.903e-14 ad=3.548e-14 ps=7e-07 pd=7.6e-07 nrd=1.16667 \
        nrs=1.16667 sa=6.05e-07 sb=1.255e-06 sd=160n sca=11.9515 \
        scb=0.0105226 scc=0.000305882 m=(1)
mp40 (\8\:n30 \5\:CKb \8\:mout VDD) g45p1lvt w=(2.15e-07) l=4.5e-08 nf=1 \
        as=5.913e-14 ad=3.548e-14 ps=9.8e-07 pd=7.6e-07 nrd=1.16667 \
        nrs=1.16667 sa=8.15e-07 sb=1.045e-06 sd=160n sca=11.9515 \
        scb=0.0105226 scc=0.000305882 m=(1)
mp30 (\8\:mout n20 \19\:VDD VDD) g45p1lvt w=(2.15e-07) l=4.5e-08 nf=1 \
        as=4.73e-14 ad=5.912e-14 ps=8.7e-07 pd=9.8e-07 nrd=1.16667 \
        nrs=1.16667 sa=1.135e-06 sb=7.25e-07 sd=160n sca=11.9515 \
        scb=0.0105226 scc=0.000305882 m=(1)
mp35 (net521 mout \19\:VDD VDD) g45p1lvt w=(2.15e-07) l=4.5e-08 nf=1 \
        as=4.73e-14 ad=1.29e-14 ps=8.7e-07 pd=5.5e-07 nrd=1.16667 \
        nrs=1.16667 sa=1.4e-06 sb=4.6e-07 sd=160n sca=11.9515 \
        scb=0.0105226 scc=0.000305882 m=(1)
mp36 (\4\:n20 \4\:CKb net521 VDD) g45p1lvt w=(2.15e-07) l=4.5e-08 nf=1 \
        as=1.29e-14 ad=3.655e-14 ps=5.5e-07 pd=7.7e-07 nrd=1.16667 \
        nrs=1.16667 sa=1.505e-06 sb=3.55e-07 sd=160n sca=11.9515 \
        scb=0.0105226 scc=0.000305882 m=(1)
mp25 (\4\:n20 \8\:CKbb \8\:Dpb VDD) g45p1lvt w=(2.15e-07) l=4.5e-08 nf=1 \
        as=3.01e-14 ad=3.655e-14 ps=7.1e-07 pd=7.7e-07 nrd=1.16667 \
        nrs=1.16667 sa=1.72e-06 sb=1.4e-07 sd=160n sca=11.9515 \
        scb=0.0105226 scc=0.000305882 m=(1)
mp21 (\9\:CKbb CKb \16\:VDD VDD) g45p1lvt w=(2.15e-07) l=4.5e-08 nf=1 \
        as=7.5e-14 ad=4.3e-14 ps=1.98e-06 pd=8.3e-07 nrd=1.16667 \
        nrs=1.16667 sa=2e-07 sb=4.35e-07 sd=160n sca=45.7906 scb=0.0283307 \
        scc=0.00588417 m=(1)
mp20 (\10\:CKb \1\:CK \16\:VDD VDD) g45p1lvt w=(2.15e-07) l=4.5e-08 nf=1 \
        as=7.5e-14 ad=4.3e-14 ps=1.98e-06 pd=8.3e-07 nrd=1.16667 \
        nrs=1.16667 sa=4.35e-07 sb=2e-07 sd=160n sca=45.7906 scb=0.0283307 \
        scc=0.00588417 m=(1)
mp10 (\8\:SEb \1\:SE \12\:VDD VDD) g45p1lvt w=(2.15e-07) l=4.5e-08 nf=1 \
        as=1.067e-13 ad=3.01e-14 ps=1.86e-06 pd=7.1e-07 nrd=1.16667 \
        nrs=1.16667 sa=1.4e-07 sb=1.325e-06 sd=160n sca=35.2411 \
        scb=0.0263265 scc=0.00456529 m=(1)
mp13 (net557 \1\:SI \12\:VDD VDD) g45p1lvt w=(2.15e-07) l=4.5e-08 nf=1 \
        as=1.067e-13 ad=1.505e-14 ps=1.86e-06 pd=5.7e-07 nrd=1.16667 \
        nrs=1.16667 sa=4.05e-07 sb=1.06e-06 sd=160n sca=35.2411 \
        scb=0.0263265 scc=0.00456529 m=(1)
mp14 (\3\:Dpb SEb net557 VDD) g45p1lvt w=(2.15e-07) l=4.5e-08 nf=1 \
        as=1.505e-14 ad=4.838e-14 ps=5.7e-07 pd=8.8e-07 nrd=1.16667 \
        nrs=1.16667 sa=5.2e-07 sb=9.45e-07 sd=160n sca=35.2411 \
        scb=0.0263265 scc=0.00456529 m=(1)
mp12 (\3\:Dpb \5\:SE net549 VDD) g45p1lvt w=(2.15e-07) l=4.5e-08 nf=1 \
        as=4.838e-14 ad=4.838e-14 ps=8.8e-07 pd=8.8e-07 nrd=1.16667 \
        nrs=1.16667 sa=7.9e-07 sb=6.75e-07 sd=160n sca=35.2411 \
        scb=0.0263265 scc=0.00456529 m=(1)
mp11 (net549 Dp \9\:VDD VDD) g45p1lvt w=(2.15e-07) l=4.5e-08 nf=1 \
        as=1.067e-13 ad=4.838e-14 ps=1.86e-06 pd=8.8e-07 nrd=1.16667 \
        nrs=1.16667 sa=1.06e-06 sb=4.05e-07 sd=160n sca=35.2411 \
        scb=0.0263265 scc=0.00456529 m=(1)
mp55 (\1\:Q \7\:qbint \9\:VDD VDD) g45p1lvt w=(2.15e-07) l=4.5e-08 nf=1 \
        as=1.067e-13 ad=3.01e-14 ps=1.86e-06 pd=7.1e-07 nrd=1.16667 \
        nrs=1.16667 sa=1.325e-06 sb=1.4e-07 sd=160n sca=35.2411 \
        scb=0.0263265 scc=0.00456529 m=(1)
mp2 (\6\:RNb \3\:RN \6\:VDD VDD) g45p1lvt w=(2.15e-07) l=4.5e-08 nf=1 \
        as=8.918e-14 ad=4.085e-14 ps=1.56e-06 pd=8.1e-07 nrd=1.16667 \
        nrs=1.16667 sa=1.9e-07 sb=8.2e-07 sd=160n sca=12.7104 \
        scb=0.0116911 scc=0.00042519 m=(1)
mp3 (\3\:net493 \3\:RNb \6\:VDD VDD) g45p1lvt w=(2.15e-07) l=4.5e-08 \
        nf=1 as=8.918e-14 ad=3.44e-14 ps=1.56e-06 pd=7.5e-07 nrd=1.16667 \
        nrs=1.16667 sa=4.6e-07 sb=5.5e-07 sd=160n sca=12.7104 \
        scb=0.0116911 scc=0.00042519 m=(1)
mp5 (\3\:net505 \11\:qbint \3\:net493 VDD) g45p1lvt w=(2.15e-07) \
        l=4.5e-08 nf=1 as=3.44e-14 ad=3.44e-14 ps=7.5e-07 pd=7.5e-07 \
        nrd=1.16667 nrs=1.16667 sa=6.65e-07 sb=3.45e-07 sd=160n \
        sca=12.7104 scb=0.0116911 scc=0.00042519 m=(1)
mp4 (\3\:net505 \4\:Eb net493 VDD) g45p1lvt w=(2.15e-07) l=4.5e-08 nf=1 \
        as=3.01e-14 ad=3.44e-14 ps=7.1e-07 pd=7.5e-07 nrd=1.16667 \
        nrs=1.16667 sa=8.7e-07 sb=1.4e-07 sd=160n sca=12.7104 \
        scb=0.0116911 scc=0.00042519 m=(1)
mp6 (\11\:Dp \3\:E net505 VDD) g45p1lvt w=(2.15e-07) l=4.5e-08 nf=1 \
        as=3.762e-14 ad=3.01e-14 ps=7.8e-07 pd=7.1e-07 nrd=1.16667 \
        nrs=1.16667 sa=1.4e-07 sb=3.6e-07 sd=160n sca=15.2551 \
        scb=0.0150251 scc=0.000885438 m=(1)
mp7 (\4\:Dp Db net505 VDD) g45p1lvt w=(2.15e-07) l=4.5e-08 nf=1 \
        as=3.762e-14 ad=3.01e-14 ps=7.8e-07 pd=7.1e-07 nrd=1.16667 \
        nrs=1.16667 sa=3.6e-07 sb=1.4e-07 sd=160n sca=15.4613 \
        scb=0.0150753 scc=0.000885445 m=(1)
mp0 (\5\:Eb \4\:E \1\:VDD VDD) g45p1lvt w=(2.15e-07) l=4.5e-08 nf=1 \
        as=6.755e-14 ad=3.01e-14 ps=1.88e-06 pd=7.1e-07 nrd=1.16667 \
        nrs=1.16667 sa=1.4e-07 sb=3.45e-07 sd=160n sca=38.6797 \
        scb=0.0303382 scc=0.0046002 m=(1)
mp1 (\4\:Db \1\:D \1\:VDD VDD) g45p1lvt w=(2.15e-07) l=4.5e-08 nf=1 \
        as=6.755e-14 ad=3.01e-14 ps=1.88e-06 pd=7.1e-07 nrd=1.16667 \
        nrs=1.16667 sa=3.45e-07 sb=1.4e-07 sd=160n sca=47.8434 \
        scb=0.0441905 scc=0.00576115 m=(1)
C1 (D VSS) capacitor c=7.32131e-17
C2 (Q VSS) capacitor c=6.66787e-17
C3 (SE VSS) capacitor c=3.88064e-17
C4 (E VSS) capacitor c=2.80071e-17
C5 (VDD VSS) capacitor c=6.02573e-16
C6 (RN VSS) capacitor c=5.02271e-17
C7 (QN VSS) capacitor c=2.78099e-17
C8 (CK VSS) capacitor c=1.06824e-16
C9 (net582 VSS) capacitor c=2.01676e-17
C10 (qbint VSS) capacitor c=4.04758e-17
C11 (n30 VSS) capacitor c=3.97156e-17
C12 (net618 VSS) capacitor c=1.73811e-18
C13 (CKb VSS) capacitor c=3.73145e-17
C14 (mout VSS) capacitor c=6.51571e-17
C15 (CKbb VSS) capacitor c=5.70181e-17
C16 (n20 VSS) capacitor c=4.88936e-17
C17 (Dpb VSS) capacitor c=8.36781e-17
C18 (SEb VSS) capacitor c=6.13065e-17
C19 (net658 VSS) capacitor c=5.45368e-18
C20 (Dp VSS) capacitor c=5.09979e-17
C21 (RNb VSS) capacitor c=4.51231e-17
C22 (net634 VSS) capacitor c=2.6712e-18
C23 (Eb VSS) capacitor c=1.81182e-17
C24 (net638 VSS) capacitor c=4.7126e-20
C25 (Db VSS) capacitor c=6.72105e-17
C26 (net529 VSS) capacitor c=3.89755e-19
C27 (net521 VSS) capacitor c=1.06974e-18
C28 (net557 VSS) capacitor c=1.30105e-18
C29 (net549 VSS) capacitor c=3.18606e-18
C30 (net493 VSS) capacitor c=8.38751e-17
C31 (net505 VSS) capacitor c=8.35865e-17
C32 (\1\:D VSS) capacitor c=3.50687e-17
C33 (\4\:E VSS) capacitor c=4.50291e-17
C34 (\3\:E VSS) capacitor c=4.1497e-17
C35 (\4\:Eb VSS) capacitor c=5.62053e-17
C36 (\11\:qbint VSS) capacitor c=5.11968e-17
C37 (\3\:RNb VSS) capacitor c=5.58061e-17
C38 (\3\:RN VSS) capacitor c=3.42879e-17
C39 (\7\:qbint VSS) capacitor c=4.40616e-17
C40 (\5\:SE VSS) capacitor c=4.35701e-17
C41 (\1\:SI VSS) capacitor c=6.0149e-17
C42 (\1\:SE VSS) capacitor c=4.79751e-17
C43 (\1\:CK VSS) capacitor c=3.62202e-17
C44 (\8\:CKbb VSS) capacitor c=3.6891e-17
C45 (\4\:CKb VSS) capacitor c=1.43708e-16
C46 (\5\:CKb VSS) capacitor c=1.23655e-16
C47 (\4\:qbint VSS) capacitor c=5.48059e-17
C48 (\4\:net582 VSS) capacitor c=4.03274e-17
C49 (\4\:D VSS) capacitor c=3.06035e-17
C50 (\7\:E VSS) capacitor c=2.9615e-17
C51 (\2\:Db VSS) capacitor c=8.76941e-17
C52 (\1\:E VSS) capacitor c=6.94163e-17
C53 (\3\:Eb VSS) capacitor c=4.22204e-17
C54 (\10\:qbint VSS) capacitor c=9.16698e-17
C55 (\1\:RN VSS) capacitor c=4.69068e-17
C56 (\8\:qbint VSS) capacitor c=5.15035e-17
C57 (\3\:Dp VSS) capacitor c=3.70133e-17
C58 (\3\:SEb VSS) capacitor c=7.28271e-17
C59 (\7\:SE VSS) capacitor c=3.30523e-17
C60 (\3\:SI VSS) capacitor c=3.9754e-17
C61 (\4\:SE VSS) capacitor c=3.25038e-17
C62 (\3\:CK VSS) capacitor c=3.62732e-17
C63 (\8\:CKb VSS) capacitor c=2.46215e-17
C64 (\9\:CKb VSS) capacitor c=2.71305e-17
C65 (\5\:CKbb VSS) capacitor c=8.99785e-17
C66 (\3\:mout VSS) capacitor c=6.80648e-17
C67 (\3\:n20 VSS) capacitor c=3.21574e-17
C68 (\3\:CKbb VSS) capacitor c=6.03183e-17
C69 (\6\:CKb VSS) capacitor c=8.76305e-17
C70 (\5\:qbint VSS) capacitor c=5.50223e-17
C71 (\3\:n30 VSS) capacitor c=3.52379e-17
C72 (\2\:qbint VSS) capacitor c=4.65218e-17
C73 (\3\:net582 VSS) capacitor c=2.68516e-17
C74 (\3\:D VSS) capacitor c=2.31139e-17
C75 (\6\:E VSS) capacitor c=3.44925e-17
C76 (\3\:Db VSS) capacitor c=1.93283e-17
C77 (\2\:E VSS) capacitor c=7.18564e-17
C78 (\12\:qbint VSS) capacitor c=3.37711e-17
C79 (\2\:RNb VSS) capacitor c=6.1737e-17
C80 (\2\:RN VSS) capacitor c=4.32262e-17
C81 (\9\:qbint VSS) capacitor c=2.44319e-17
C82 (\2\:Dp VSS) capacitor c=4.26018e-17
C83 (\4\:SEb VSS) capacitor c=2.881e-17
C84 (\6\:SE VSS) capacitor c=4.41952e-17
C85 (\2\:SEb VSS) capacitor c=3.8516e-17
C86 (\2\:SI VSS) capacitor c=4.75867e-17
C87 (\3\:SE VSS) capacitor c=8.32292e-18
C88 (\2\:CK VSS) capacitor c=3.70519e-17
C89 (\7\:CKb VSS) capacitor c=1.81934e-17
C90 (\7\:CKbb VSS) capacitor c=4.59558e-17
C91 (\6\:CKbb VSS) capacitor c=2.9279e-17
C92 (\2\:mout VSS) capacitor c=5.5447e-17
C93 (\2\:n20 VSS) capacitor c=3.40951e-17
C94 (\4\:CKbb VSS) capacitor c=2.20394e-17
C95 (\2\:CKbb VSS) capacitor c=5.79835e-17
C96 (\6\:qbint VSS) capacitor c=3.01822e-17
C97 (\2\:n30 VSS) capacitor c=3.24285e-17
C98 (\3\:qbint VSS) capacitor c=2.05395e-17
C99 (\4\:Db VSS) capacitor c=1.03404e-16
C100 (\1\:VDD VSS) capacitor c=1.6342e-17
C101 (\5\:Eb VSS) capacitor c=6.69926e-17
C102 (\4\:Dp VSS) capacitor c=8.05347e-17
C103 (\11\:Dp VSS) capacitor c=1.93868e-17
C104 (\3\:net505 VSS) capacitor c=7.85439e-17
C105 (\3\:net493 VSS) capacitor c=6.20861e-17
C106 (\6\:VDD VSS) capacitor c=1.97754e-17
C107 (\6\:RNb VSS) capacitor c=4.51034e-17
C108 (\1\:Q VSS) capacitor c=3.24431e-17
C109 (\9\:VDD VSS) capacitor c=1.95567e-17
C110 (\3\:Dpb VSS) capacitor c=2.79923e-16
C111 (\12\:VDD VSS) capacitor c=3.01661e-17
C112 (\8\:SEb VSS) capacitor c=1.65027e-16
C113 (\10\:CKb VSS) capacitor c=7.01261e-17
C114 (\16\:VDD VSS) capacitor c=2.41455e-17
C115 (\9\:CKbb VSS) capacitor c=6.24833e-17
C116 (\8\:Dpb VSS) capacitor c=4.25912e-17
C117 (\4\:n20 VSS) capacitor c=5.1587e-17
C118 (\19\:VDD VSS) capacitor c=6.78051e-17
C119 (\8\:mout VSS) capacitor c=5.59473e-17
C120 (\8\:n30 VSS) capacitor c=3.53075e-17
C121 (\23\:VDD VSS) capacitor c=3.6315e-17
C122 (\16\:qbint VSS) capacitor c=8.29455e-17
C123 (\5\:net582 VSS) capacitor c=3.3424e-17
C124 (\26\:VDD VSS) capacitor c=8.57797e-18
C125 (\1\:QN VSS) capacitor c=2.74599e-17
C126 (\3\:VDD VSS) capacitor c=1.89865e-16
C127 (\7\:Db VSS) capacitor c=3.78694e-17
C128 (\7\:Eb VSS) capacitor c=1.32418e-16
C129 (\13\:Dp VSS) capacitor c=1.11311e-16
C130 (\8\:Dp VSS) capacitor c=1.76617e-16
C131 (\8\:RNb VSS) capacitor c=4.74504e-17
C132 (\3\:Q VSS) capacitor c=5.64952e-17
C133 (\6\:SEb VSS) capacitor c=2.09306e-16
C134 (\14\:CKb VSS) capacitor c=3.73793e-17
C135 (\11\:CKbb VSS) capacitor c=7.25052e-17
C136 (\6\:Dpb VSS) capacitor c=8.2835e-17
C137 (\8\:n20 VSS) capacitor c=3.71286e-17
C138 (\6\:mout VSS) capacitor c=5.34538e-17
C139 (\4\:n30 VSS) capacitor c=7.02948e-17
C140 (\19\:qbint VSS) capacitor c=6.48925e-17
C141 (\9\:net582 VSS) capacitor c=3.61863e-17
C142 (\3\:QN VSS) capacitor c=3.10658e-17
C143 (\2\:net582 VSS) capacitor c=1.25154e-17
C144 (\2\:CKb VSS) capacitor c=3.30968e-17
C145 (\3\:CKb VSS) capacitor c=6.93646e-17
C146 (\2\:SE VSS) capacitor c=1.84501e-17
C147 (\7\:net582 VSS) capacitor c=2.8393e-17
C148 (\8\:net582 VSS) capacitor c=3.5235e-17
C149 (\6\:n30 VSS) capacitor c=8.67204e-17
C150 (\7\:n30 VSS) capacitor c=7.2888e-17
C151 (\2\:Eb VSS) capacitor c=3.39978e-17
C152 (\4\:mout VSS) capacitor c=7.60995e-17
C153 (\5\:mout VSS) capacitor c=6.8662e-17
C154 (\6\:n20 VSS) capacitor c=5.69815e-17
C155 (\7\:n20 VSS) capacitor c=5.86263e-17
C156 (\5\:E VSS) capacitor c=3.05792e-17
C157 (\2\:D VSS) capacitor c=1.43486e-17
C158 (\13\:CKbb VSS) capacitor c=7.44355e-17
C159 (\14\:CKbb VSS) capacitor c=7.73877e-17
C160 (\15\:CKbb VSS) capacitor c=1.07005e-16
C161 (\16\:CKbb VSS) capacitor c=8.3966e-17
C162 (\17\:CKbb VSS) capacitor c=7.4181e-17
C163 (\12\:CKb VSS) capacitor c=7.20972e-17
C164 (\13\:CKb VSS) capacitor c=5.95718e-17
C165 (\4\:SI VSS) capacitor c=3.97247e-17
C166 (\6\:SI VSS) capacitor c=4.66197e-17
C167 (\8\:SE VSS) capacitor c=8.15745e-17
C168 (\9\:SE VSS) capacitor c=8.50443e-17
C169 (\5\:Dpb VSS) capacitor c=2.57207e-16
C170 (\5\:SEb VSS) capacitor c=1.17536e-16
C171 (\10\:SEb VSS) capacitor c=9.1974e-17
C172 (\4\:RN VSS) capacitor c=7.19295e-17
C173 (\4\:RNb VSS) capacitor c=6.27693e-17
C174 (\5\:RNb VSS) capacitor c=6.48936e-17
C175 (\13\:qbint VSS) capacitor c=9.0298e-17
C176 (\14\:qbint VSS) capacitor c=4.6283e-16
C177 (\15\:qbint VSS) capacitor c=4.68536e-16
C178 (\18\:qbint VSS) capacitor c=2.05984e-17
C179 (\21\:qbint VSS) capacitor c=2.69402e-17
C180 (\6\:Dp VSS) capacitor c=9.39588e-17
C181 (\7\:Dp VSS) capacitor c=1.33682e-16
C182 (\10\:Dp VSS) capacitor c=1.81878e-16
C183 (\8\:E VSS) capacitor c=4.05039e-17
C184 (\9\:E VSS) capacitor c=2.93775e-17
C185 (\10\:E VSS) capacitor c=2.69337e-17
C186 (\9\:Eb VSS) capacitor c=1.20107e-16
C187 (\5\:D VSS) capacitor c=5.66202e-17
C188 (\6\:Db VSS) capacitor c=9.25733e-17
C189 (\8\:VDD VSS) capacitor c=4.39889e-17
C190 (\11\:VDD VSS) capacitor c=4.02749e-17
C191 (\15\:VDD VSS) capacitor c=3.95667e-17
C192 (\18\:VDD VSS) capacitor c=5.65659e-17
C193 (\22\:VDD VSS) capacitor c=1.11894e-17
C194 (\25\:VDD VSS) capacitor c=1.09064e-17
Rk62 (D \5\:D) resistor r=0.1492 c=0
Rk37 (Q \2\:Q) resistor r=0.2127 c=0
Rk38 (Q \4\:Q) resistor r=0.1294 c=0
Rk29 (\9\:SE SE) resistor r=0.08774 c=0
Rk28 (\8\:SE \9\:SE) resistor r=0.5266 c=0
Rk59 (\9\:E E) resistor r=0.002661 c=0
Rk57 (\8\:E \9\:E) resistor r=0.1468 c=0
Rk58 (\9\:E \10\:E) resistor r=0.06555 c=0
Rk25 (\4\:SI \5\:SI) resistor r=0.007126 c=0
Rk26 (SI \6\:SI) resistor r=0.006968 c=0
Rk27 (\4\:SI \6\:SI) resistor r=0.01584 c=0
Rk65 (\2\:VDD \4\:VDD) resistor r=0.1325 c=0
Rk66 (\4\:VDD \5\:VDD) resistor r=0.8029 c=0
Rk67 (\5\:VDD \7\:VDD) resistor r=0.1208 c=0
Rk68 (\5\:VDD \8\:VDD) resistor r=0.416 c=0
Rk69 (\8\:VDD \10\:VDD) resistor r=0.04334 c=0
Rk70 (\8\:VDD \11\:VDD) resistor r=0.4594 c=0
Rk71 (\11\:VDD \13\:VDD) resistor r=0.04334 c=0
Rk72 (\11\:VDD \14\:VDD) resistor r=0.325 c=0
Rk73 (\14\:VDD \15\:VDD) resistor r=0.2021 c=0
Rk74 (\15\:VDD \17\:VDD) resistor r=0.04334 c=0
Rk75 (\15\:VDD \18\:VDD) resistor r=0.5933 c=0
Rk76 (\18\:VDD \20\:VDD) resistor r=0.3051 c=0
Rk77 (\18\:VDD \21\:VDD) resistor r=0.4063 c=0
Rk78 (\21\:VDD \22\:VDD) resistor r=0.1077 c=0
Rk79 (\22\:VDD \24\:VDD) resistor r=0.1914 c=0
Rk82 (\25\:VDD VDD) resistor r=0.12 c=0
Rk80 (\22\:VDD \25\:VDD) resistor r=0.3233 c=0
Rk81 (\25\:VDD \27\:VDD) resistor r=0.1031 c=0
Rk39 (RN \4\:RN) resistor r=0.03526 c=0
Rk83 (\2\:VSS \4\:VSS) resistor r=0.4131 c=0
Rk84 (\4\:VSS \5\:VSS) resistor r=0.3536 c=0
Rk85 (\5\:VSS \6\:VSS) resistor r=0.1426 c=0
Rk86 (\6\:VSS \7\:VSS) resistor r=0.248 c=0
Rk87 (\7\:VSS \8\:VSS) resistor r=0.05751 c=0
Rk88 (\8\:VSS \9\:VSS) resistor r=0.4163 c=0
Rk89 (\9\:VSS \10\:VSS) resistor r=0.4763 c=0
Rk90 (\10\:VSS \11\:VSS) resistor r=0.3109 c=0
Rk91 (\11\:VSS \12\:VSS) resistor r=0.2181 c=0
Rk92 (\12\:VSS \13\:VSS) resistor r=0.5792 c=0
Rk93 (\13\:VSS \14\:VSS) resistor r=0.4063 c=0
Rk94 (\14\:VSS \15\:VSS) resistor r=0.1227 c=0
Rk96 (\16\:VSS VSS) resistor r=0.12 c=0
Rk95 (\15\:VSS \16\:VSS) resistor r=0.3082 c=0
Rk97 (\5\:VSS \18\:VSS) resistor r=0.1903 c=0
Rk98 (\6\:VSS \20\:VSS) resistor r=0.1903 c=0
Rk99 (\7\:VSS \22\:VSS) resistor r=0.3206 c=0
Rk100 (\9\:VSS \24\:VSS) resistor r=0.2801 c=0
Rk101 (\10\:VSS \26\:VSS) resistor r=0.1735 c=0
Rk102 (\12\:VSS \28\:VSS) resistor r=0.2623 c=0
Rk103 (\13\:VSS \30\:VSS) resistor r=0.1433 c=0
Rk104 (\15\:VSS \32\:VSS) resistor r=0.3666 c=0
Rk105 (\16\:VSS \34\:VSS) resistor r=0.3818 c=0
Rk2 (\4\:QN QN) resistor r=0.05602 c=0
Rk1 (\2\:QN \4\:QN) resistor r=0.2328 c=0
Rk21 (\4\:CK CK) resistor r=0.006094 c=0
Rk3 (\6\:net582 \7\:net582) resistor r=0.115 c=0
Rk4 (\7\:net582 \8\:net582) resistor r=0.1197 c=0
Rk5 (\7\:net582 \10\:net582) resistor r=0.109 c=0
Rk43 (\13\:qbint \14\:qbint) resistor r=0.6255 c=0
Rk44 (\14\:qbint \15\:qbint) resistor r=3.4274 c=0
Rk45 (\15\:qbint \17\:qbint) resistor r=0.3782 c=0
Rk46 (\15\:qbint \18\:qbint) resistor r=0.03527 c=0
Rk47 (\17\:qbint \20\:qbint) resistor r=0.4621 c=0
Rk48 (\17\:qbint \21\:qbint) resistor r=0.1956 c=0
Rk6 (\5\:n30 \6\:n30) resistor r=0.3399 c=0
Rk7 (\6\:n30 \7\:n30) resistor r=0.4388 c=0
Rk8 (\6\:n30 \9\:n30) resistor r=0.05922 c=0
Rk22 (\11\:CKb \12\:CKb) resistor r=0.3939 c=0
Rk23 (\12\:CKb \13\:CKb) resistor r=0.3157 c=0
Rk24 (\12\:CKb \15\:CKb) resistor r=0.2238 c=0
Rk9 (\4\:mout \5\:mout) resistor r=0.3392 c=0
Rk10 (\5\:mout \7\:mout) resistor r=0.2603 c=0
Rk11 (\5\:mout \9\:mout) resistor r=0.1853 c=0
Rk15 (\10\:CKbb \12\:CKbb) resistor r=0.4342 c=0
Rk16 (\12\:CKbb \13\:CKbb) resistor r=0.2754 c=0
Rk17 (\13\:CKbb \14\:CKbb) resistor r=0.2112 c=0
Rk18 (\14\:CKbb \15\:CKbb) resistor r=0.4637 c=0
Rk19 (\15\:CKbb \16\:CKbb) resistor r=0.5537 c=0
Rk20 (\13\:CKbb \17\:CKbb) resistor r=0.4255 c=0
Rk12 (\5\:n20 \6\:n20) resistor r=0.2987 c=0
Rk13 (\6\:n20 \7\:n20) resistor r=0.31 c=0
Rk14 (\6\:n20 \9\:n20) resistor r=0.1284 c=0
Rk30 (\2\:Dpb \4\:Dpb) resistor r=0.5786 c=0
Rk31 (\4\:Dpb \5\:Dpb) resistor r=1.7445 c=0
Rk32 (\5\:Dpb \7\:Dpb) resistor r=0.4659 c=0
Rk33 (\5\:Dpb \9\:Dpb) resistor r=0.09047 c=0
Rk34 (\5\:SEb \7\:SEb) resistor r=0.8068 c=0
Rk35 (\7\:SEb \9\:SEb) resistor r=0.9062 c=0
Rk36 (\9\:SEb \10\:SEb) resistor r=0.5606 c=0
Rk51 (\5\:Dp \6\:Dp) resistor r=0.3165 c=0
Rk52 (\6\:Dp \7\:Dp) resistor r=0.6342 c=0
Rk53 (\7\:Dp \9\:Dp) resistor r=0.08336 c=0
Rk54 (\9\:Dp \10\:Dp) resistor r=1.5293 c=0
Rk55 (\6\:Dp \12\:Dp) resistor r=0.05709 c=0
Rk56 (\7\:Dp \14\:Dp) resistor r=0.678 c=0
Rk40 (\4\:RNb \5\:RNb) resistor r=0.28 c=0
Rk41 (\5\:RNb \7\:RNb) resistor r=0.2472 c=0
Rk42 (\5\:RNb \9\:RNb) resistor r=0.2342 c=0
Rk60 (\6\:Eb \8\:Eb) resistor r=0.3209 c=0
Rk61 (\8\:Eb \9\:Eb) resistor r=0.7042 c=0
Rk63 (\5\:Db \6\:Db) resistor r=0.7564 c=0
Rk64 (\5\:Db \8\:Db) resistor r=0.2759 c=0
Rk49 (\2\:net493 \4\:net493) resistor r=0.333 c=0
Rk50 (\2\:net505 \4\:net505) resistor r=0.5298 c=0
Rl57 (\1\:D \2\:D) resistor r=43.9449 c=0
Rl59 (\2\:D \4\:D) resistor r=47.791 c=0
Rl58 (\2\:D \3\:D) resistor r=1.2666 c=0
Rl34 (\5\:SE \6\:SE) resistor r=94.2308 c=0
Rl35 (\6\:SE \7\:SE) resistor r=39.5604 c=0
Rl28 (\1\:SE \2\:SE) resistor r=100.803 c=0
Rl30 (\2\:SE \4\:SE) resistor r=46.9565 c=0
Rl29 (\2\:SE \3\:SE) resistor r=3.1183 c=0
Rl51 (\2\:E \3\:E) resistor r=84.5926 c=0
Rl50 (\1\:E \2\:E) resistor r=134.41 c=0
Rl54 (\4\:E \5\:E) resistor r=55.0028 c=0
Rl56 (\5\:E \7\:E) resistor r=41.5412 c=0
Rl55 (\5\:E \6\:E) resistor r=75.3733 c=0
Rl31 (\1\:SI \2\:SI) resistor r=30.0021 c=0
Rl32 (\2\:SI \3\:SI) resistor r=99.2328 c=0
Rl42 (\2\:RN \3\:RN) resistor r=30.2198 c=0
Rl41 (\1\:RN \2\:RN) resistor r=140.385 c=0
Rl26 (\1\:CK \2\:CK) resistor r=24.2328 c=0
Rl27 (\2\:CK \3\:CK) resistor r=101.156 c=0
Rl3 (\2\:net582 \4\:net582) resistor r=47.791 c=0
Rl2 (\2\:net582 \3\:net582) resistor r=36.2526 c=0
Rl1 (net582 \2\:net582) resistor r=2.0213 c=0
Rl45 (\10\:qbint \11\:qbint) resistor r=211.104 c=0
Rl39 (\7\:qbint \8\:qbint) resistor r=157.692 c=0
Rl8 (\4\:qbint \5\:qbint) resistor r=167.308 c=0
Rl4 (qbint \2\:qbint) resistor r=92.3077 c=0
Rl46 (\11\:qbint \12\:qbint) resistor r=32.908 c=0
Rl40 (\7\:qbint \9\:qbint) resistor r=80.0021 c=0
Rl9 (\4\:qbint \6\:qbint) resistor r=24.2328 c=0
Rl5 (qbint \3\:qbint) resistor r=24.2328 c=0
Rl6 (n30 \2\:n30) resistor r=33.8482 c=0
Rl7 (\2\:n30 \3\:n30) resistor r=105.002 c=0
Rl21 (\4\:CKb \5\:CKb) resistor r=403.412 c=0
Rl22 (\5\:CKb \6\:CKb) resistor r=210.67 c=0
Rl24 (\7\:CKb \8\:CKb) resistor r=39.1533 c=0
Rl18 (CKb \2\:CKb) resistor r=53.0797 c=0
Rl23 (\2\:CKb \7\:CKb) resistor r=32.6176 c=0
Rl20 (\3\:CKb \4\:CKb) resistor r=195.697 c=0
Rl25 (\3\:CKb \9\:CKb) resistor r=30.4507 c=0
Rl19 (\2\:CKb \3\:CKb) resistor r=221.992 c=0
Rl14 (mout \2\:mout) resistor r=50.6918 c=0
Rl15 (\2\:mout \3\:mout) resistor r=91.0764 c=0
Rl17 (\7\:CKbb \8\:CKbb) resistor r=62.9746 c=0
Rl16 (\5\:CKbb \6\:CKbb) resistor r=41.5405 c=0
Rl11 (\3\:CKbb \4\:CKbb) resistor r=41.5405 c=0
Rl10 (CKbb \2\:CKbb) resistor r=64.6174 c=0
Rl12 (n20 \2\:n20) resistor r=112.23 c=0
Rl13 (\2\:n20 \3\:n20) resistor r=29.5379 c=0
Rl36 (\3\:SEb \4\:SEb) resistor r=51.1559 c=0
Rl33 (SEb \2\:SEb) resistor r=24.2328 c=0
Rl37 (Dp \2\:Dp) resistor r=103.079 c=0
Rl38 (\2\:Dp \3\:Dp) resistor r=26.1559 c=0
Rl44 (\2\:RNb \3\:RNb) resistor r=89.6174 c=0
Rl43 (RNb \2\:RNb) resistor r=93.0292 c=0
Rl49 (\2\:Eb \4\:Eb) resistor r=151.637 c=0
Rl48 (\2\:Eb \3\:Eb) resistor r=34.3295 c=0
Rl47 (Eb \2\:Eb) resistor r=5.915 c=0
Rl52 (Db \2\:Db) resistor r=240.385 c=0
Rl53 (Db \3\:Db) resistor r=24.2328 c=0
Rz11 (\3\:Q \4\:Q) resistor r=75 c=0
Rz18 (\3\:VDD \4\:VDD) resistor r=18.75 c=0
Rz19 (\3\:VDD \5\:VDD) resistor r=6.25 c=0
Rz20 (\3\:VDD \14\:VDD) resistor r=6.25 c=0
Rz21 (\3\:VDD \21\:VDD) resistor r=6.25 c=0
Rz22 (\1\:VSS \2\:VSS) resistor r=75 c=0
Rz23 (\17\:VSS \18\:VSS) resistor r=75 c=0
Rz24 (\19\:VSS \20\:VSS) resistor r=75 c=0
Rz25 (\21\:VSS \22\:VSS) resistor r=75 c=0
Rz26 (\23\:VSS \24\:VSS) resistor r=75 c=0
Rz27 (\25\:VSS \26\:VSS) resistor r=75 c=0
Rz28 (\27\:VSS \28\:VSS) resistor r=75 c=0
Rz29 (\29\:VSS \30\:VSS) resistor r=75 c=0
Rz30 (\31\:VSS \32\:VSS) resistor r=75 c=0
Rz31 (\33\:VSS \34\:VSS) resistor r=75 c=0
Rz1 (\3\:QN \4\:QN) resistor r=75 c=0
Rz2 (\9\:net582 \10\:net582) resistor r=75 c=0
Rz13 (\19\:qbint \20\:qbint) resistor r=75 c=0
Rz3 (\4\:n30 \5\:n30) resistor r=75 c=0
Rz7 (\14\:CKb \15\:CKb) resistor r=75 c=0
Rz4 (\6\:mout \7\:mout) resistor r=75 c=0
Rz6 (\11\:CKbb \12\:CKbb) resistor r=75 c=0
Rz5 (\8\:n20 \9\:n20) resistor r=75 c=0
Rz8 (Dpb \2\:Dpb) resistor r=75 c=0
Rz9 (\6\:Dpb \7\:Dpb) resistor r=75 c=0
Rz10 (\6\:SEb \7\:SEb) resistor r=75 c=0
Rz14 (\8\:Dp \9\:Dp) resistor r=75 c=0
Rz15 (\13\:Dp \14\:Dp) resistor r=75 c=0
Rz12 (\8\:RNb \9\:RNb) resistor r=75 c=0
Rz16 (\7\:Eb \8\:Eb) resistor r=75 c=0
Rz17 (\7\:Db \8\:Db) resistor r=75 c=0
Ry11 (\1\:Q \2\:Q) resistor r=62 c=0
Ry22 (\1\:VDD \2\:VDD) resistor r=62 c=0
Ry23 (\6\:VDD \7\:VDD) resistor r=62 c=0
Ry24 (\9\:VDD \10\:VDD) resistor r=62 c=0
Ry25 (\12\:VDD \13\:VDD) resistor r=62 c=0
Ry26 (\16\:VDD \17\:VDD) resistor r=62 c=0
Ry27 (\19\:VDD \20\:VDD) resistor r=62 c=0
Ry28 (\23\:VDD \24\:VDD) resistor r=62 c=0
Ry29 (\26\:VDD \27\:VDD) resistor r=62 c=0
Ry30 (\3\:VSS \4\:VSS) resistor r=15.5 c=0
Ry31 (\3\:VSS \8\:VSS) resistor r=5.1667 c=0
Ry32 (\3\:VSS \11\:VSS) resistor r=5.1667 c=0
Ry33 (\3\:VSS \14\:VSS) resistor r=5.1667 c=0
Ry1 (\1\:QN \2\:QN) resistor r=62 c=0
Ry2 (\5\:net582 \6\:net582) resistor r=62 c=0
Ry13 (\16\:qbint \17\:qbint) resistor r=62 c=0
Ry3 (\8\:n30 \9\:n30) resistor r=62 c=0
Ry7 (\10\:CKb \11\:CKb) resistor r=62 c=0
Ry4 (\8\:mout \9\:mout) resistor r=62 c=0
Ry6 (\9\:CKbb \10\:CKbb) resistor r=62 c=0
Ry5 (\4\:n20 \5\:n20) resistor r=62 c=0
Ry8 (\3\:Dpb \4\:Dpb) resistor r=62 c=0
Ry9 (\8\:Dpb \9\:Dpb) resistor r=62 c=0
Ry10 (\8\:SEb \9\:SEb) resistor r=62 c=0
Ry18 (\4\:Dp \5\:Dp) resistor r=62 c=0
Ry19 (\11\:Dp \12\:Dp) resistor r=62 c=0
Ry12 (\6\:RNb \7\:RNb) resistor r=62 c=0
Ry20 (\5\:Eb \6\:Eb) resistor r=62 c=0
Ry21 (\4\:Db \5\:Db) resistor r=62 c=0
Ry14 (net493 \2\:net493) resistor r=62 c=0
Ry15 (\3\:net493 \4\:net493) resistor r=62 c=0
Ry16 (net505 \2\:net505) resistor r=62 c=0
Ry17 (\3\:net505 \4\:net505) resistor r=62 c=0
Rx26 (\3\:D \5\:D) resistor r=45 c=0
Rx12 (\6\:SE \8\:SE) resistor r=45 c=0
Rx13 (\3\:SE \9\:SE) resistor r=45 c=0
Rx23 (\6\:E \8\:E) resistor r=45 c=0
Rx24 (\2\:E \10\:E) resistor r=45 c=0
Rx11 (\2\:SI \5\:SI) resistor r=45 c=0
Rx16 (\2\:RN \4\:RN) resistor r=45 c=0
Rx9 (\2\:CK \4\:CK) resistor r=45 c=0
Rx1 (net582 \8\:net582) resistor r=45 c=0
Rx18 (\12\:qbint \13\:qbint) resistor r=45 c=0
Rx19 (\9\:qbint \14\:qbint) resistor r=45 c=0
Rx20 (\6\:qbint \18\:qbint) resistor r=45 c=0
Rx21 (\3\:qbint \21\:qbint) resistor r=45 c=0
Rx2 (\2\:n30 \7\:n30) resistor r=45 c=0
Rx10 (\7\:CKb \13\:CKb) resistor r=45 c=0
Rx3 (\2\:mout \4\:mout) resistor r=45 c=0
Rx5 (\6\:CKbb \14\:CKbb) resistor r=45 c=0
Rx6 (\4\:CKbb \15\:CKbb) resistor r=45 c=0
Rx7 (\2\:CKbb \16\:CKbb) resistor r=45 c=0
Rx8 (\7\:CKbb \17\:CKbb) resistor r=45 c=0
Rx4 (\2\:n20 \7\:n20) resistor r=45 c=0
Rx14 (\4\:SEb \5\:SEb) resistor r=45 c=0
Rx15 (\2\:SEb \10\:SEb) resistor r=45 c=0
Rx22 (\2\:Dp \10\:Dp) resistor r=45 c=0
Rx17 (\2\:RNb \4\:RNb) resistor r=45 c=0
Rx25 (Eb \9\:Eb) resistor r=45 c=0
Rx27 (\3\:Db \6\:Db) resistor r=45 c=0
mn57 (\3\:QN \3\:net582 \33\:VSS VSS) g45n1lvt w=(1.45e-07) l=4.5e-08 \
        nf=1 as=2.32e-14 ad=2.03e-14 ps=6.1e-07 pd=5.7e-07 nrd=1.16667 \
        nrs=1.16667 sa=1.4e-07 sb=3.45e-07 sd=160n sca=23.279 \
        scb=0.0230742 scc=0.00267719 m=(1)
mn56 (\9\:net582 \2\:qbint \33\:VSS VSS) g45n1lvt w=(1.45e-07) l=4.5e-08 \
        nf=1 as=2.32e-14 ad=2.03e-14 ps=6.1e-07 pd=5.7e-07 nrd=1.16667 \
        nrs=1.16667 sa=3.45e-07 sb=1.4e-07 sd=160n sca=23.279 \
        scb=0.0230742 scc=0.00267719 m=(1)
mn45 (\19\:qbint \3\:n30 \31\:VSS VSS) g45n1lvt w=(1.45e-07) l=4.5e-08 \
        nf=1 as=3.48e-14 ad=2.03e-14 ps=7.7e-07 pd=5.7e-07 nrd=1.16667 \
        nrs=1.16667 sa=1.4e-07 sb=1.895e-06 sd=160n sca=23.279 \
        scb=0.0230742 scc=0.00267719 m=(1)
mn50 (net618 \5\:qbint \31\:VSS VSS) g45n1lvt w=(1.45e-07) l=4.5e-08 \
        nf=1 as=3.48e-14 ad=2.03e-14 ps=7.7e-07 pd=5.7e-07 nrd=1.16667 \
        nrs=1.16667 sa=4.25e-07 sb=1.61e-06 sd=160n sca=23.279 \
        scb=0.0230742 scc=0.00267719 m=(1)
mn51 (\4\:n30 \6\:CKb net618 VSS) g45n1lvt w=(1.45e-07) l=4.5e-08 nf=1 \
        as=2.03e-14 ad=2.32e-14 ps=5.7e-07 pd=6.1e-07 nrd=1.16667 \
        nrs=1.16667 sa=6.1e-07 sb=1.425e-06 sd=160n sca=23.279 \
        scb=0.0230742 scc=0.00267719 m=(1)
mn40 (\4\:n30 \3\:CKbb \6\:mout VSS) g45n1lvt w=(1.45e-07) l=4.5e-08 nf=1 \
        as=3.988e-14 ad=2.32e-14 ps=8.4e-07 pd=6.1e-07 nrd=1.16667 \
        nrs=1.16667 sa=8.15e-07 sb=1.22e-06 sd=160n sca=23.279 \
        scb=0.0230742 scc=0.00267719 m=(1)
mn30 (\6\:mout \3\:n20 \29\:VSS VSS) g45n1lvt w=(1.45e-07) l=4.5e-08 \
        nf=1 as=7.09e-14 ad=3.988e-14 ps=1.38e-06 pd=8.4e-07 nrd=1.16667 \
        nrs=1.16667 sa=1.135e-06 sb=9e-07 sd=160n sca=23.279 scb=0.0230742 \
        scc=0.00267719 m=(1)
mn35 (net606 \3\:mout \29\:VSS VSS) g45n1lvt w=(1.45e-07) l=4.5e-08 nf=1 \
        as=7.09e-14 ad=8.7e-15 ps=1.38e-06 pd=4.1e-07 nrd=1.16667 \
        nrs=1.16667 sa=1.4e-06 sb=6.35e-07 sd=160n sca=23.279 \
        scb=0.0230742 scc=0.00267719 m=(1)
mn36 (\8\:n20 \5\:CKbb net606 VSS) g45n1lvt w=(1.45e-07) l=4.5e-08 nf=1 \
        as=8.7e-15 ad=2.9e-14 ps=4.1e-07 pd=6.9e-07 nrd=1.16667 \
        nrs=1.16667 sa=1.505e-06 sb=5.3e-07 sd=160n sca=23.279 \
        scb=0.0230742 scc=0.00267719 m=(1)
mn25 (\8\:n20 \9\:CKb \6\:Dpb VSS) g45n1lvt w=(1.45e-07) l=4.5e-08 nf=1 \
        as=4.133e-14 ad=2.9e-14 ps=8.6e-07 pd=6.9e-07 nrd=1.16667 \
        nrs=1.16667 sa=1.75e-06 sb=2.85e-07 sd=160n sca=23.279 \
        scb=0.0230742 scc=0.00267719 m=(1)
mn21 (\11\:CKbb \8\:CKb \27\:VSS VSS) g45n1lvt w=(1.45e-07) l=4.5e-08 \
        nf=1 as=2.755e-14 ad=2.465e-14 ps=6.7e-07 pd=6.3e-07 nrd=1.16667 \
        nrs=1.16667 sa=1.7e-07 sb=3.75e-07 sd=160n sca=9.50767 \
        scb=0.00818119 scc=0.00019576 m=(1)
mn20 (\14\:CKb \3\:CK \27\:VSS VSS) g45n1lvt w=(1.45e-07) l=4.5e-08 nf=1 \
        as=2.755e-14 ad=2.03e-14 ps=6.7e-07 pd=5.7e-07 nrd=1.16667 \
        nrs=1.16667 sa=4.05e-07 sb=1.4e-07 sd=160n sca=9.50767 \
        scb=0.00818119 scc=0.00019576 m=(1)
mn10 (\6\:SEb \4\:SE \25\:VSS VSS) g45n1lvt w=(1.45e-07) l=4.5e-08 nf=1 \
        as=4.75e-14 ad=2.03e-14 ps=9.9e-07 pd=5.7e-07 nrd=1.16667 \
        nrs=1.16667 sa=1.4e-07 sb=1.41e-06 sd=160n sca=9.87692 \
        scb=0.0087933 scc=0.000232488 m=(1)
mn13 (net658 \3\:SI \25\:VSS VSS) g45n1lvt w=(1.45e-07) l=4.5e-08 nf=1 \
        as=4.75e-14 ad=3.915e-14 ps=9.9e-07 pd=8.3e-07 nrd=1.16667 \
        nrs=1.16667 sa=4.05e-07 sb=1.145e-06 sd=160n sca=9.87692 \
        scb=0.0087933 scc=0.000232488 m=(1)
mn14 (Dpb \7\:SE net658 VSS) g45n1lvt w=(1.45e-07) l=4.5e-08 nf=1 \
        as=3.915e-14 ad=2.32e-14 ps=8.3e-07 pd=6.1e-07 nrd=1.16667 \
        nrs=1.16667 sa=7.2e-07 sb=8.3e-07 sd=160n sca=9.87692 \
        scb=0.0087933 scc=0.000232488 m=(1)
mn12 (Dpb \3\:SEb net650 VSS) g45n1lvt w=(1.45e-07) l=4.5e-08 nf=1 \
        as=1.305e-14 ad=2.32e-14 ps=4.7e-07 pd=6.1e-07 nrd=1.16667 \
        nrs=1.16667 sa=9.25e-07 sb=6.25e-07 sd=160n sca=9.87692 \
        scb=0.0087933 scc=0.000232488 m=(1)
mn11 (net650 \3\:Dp \23\:VSS VSS) g45n1lvt w=(1.45e-07) l=4.5e-08 nf=1 \
        as=3.19e-14 ad=1.305e-14 ps=7.3e-07 pd=4.7e-07 nrd=1.16667 \
        nrs=1.16667 sa=1.06e-06 sb=4.9e-07 sd=160n sca=9.87692 \
        scb=0.0087933 scc=0.000232488 m=(1)
mn55 (\3\:Q \8\:qbint \23\:VSS VSS) g45n1lvt w=(1.45e-07) l=4.5e-08 nf=1 \
        as=3.19e-14 ad=3.263e-14 ps=7.3e-07 pd=7.4e-07 nrd=1.16667 \
        nrs=1.16667 sa=1.325e-06 sb=2.25e-07 sd=160n sca=9.87692 \
        scb=0.0087933 scc=0.000232488 m=(1)
mn2 (\8\:RNb \1\:RN \21\:VSS VSS) g45n1lvt w=(1.45e-07) l=4.5e-08 nf=1 \
        as=3.48e-14 ad=3.408e-14 ps=7.7e-07 pd=7.6e-07 nrd=1.16667 \
        nrs=1.16667 sa=2.35e-07 sb=7.75e-07 sd=160n sca=12.9138 \
        scb=0.0133404 scc=0.000640143 m=(1)
mn3 (\8\:Dp RNb \21\:VSS VSS) g45n1lvt w=(1.45e-07) l=4.5e-08 nf=1 \
        as=3.48e-14 ad=2.32e-14 ps=7.7e-07 pd=6.1e-07 nrd=1.16667 \
        nrs=1.16667 sa=5.2e-07 sb=4.9e-07 sd=160n sca=12.9138 \
        scb=0.0133404 scc=0.000640143 m=(1)
mn5 (\8\:Dp \10\:qbint net634 VSS) g45n1lvt w=(1.45e-07) l=4.5e-08 nf=1 \
        as=1.015e-14 ad=2.32e-14 ps=4.3e-07 pd=6.1e-07 nrd=1.16667 \
        nrs=1.16667 sa=7.25e-07 sb=2.85e-07 sd=160n sca=12.9138 \
        scb=0.0133404 scc=0.000640143 m=(1)
mn4 (net634 \3\:Eb \19\:VSS VSS) g45n1lvt w=(1.45e-07) l=4.5e-08 nf=1 \
        as=4.445e-14 ad=1.015e-14 ps=9.6e-07 pd=4.3e-07 nrd=1.16667 \
        nrs=1.16667 sa=8.4e-07 sb=1.7e-07 sd=160n sca=12.9138 \
        scb=0.0133404 scc=0.000640143 m=(1)
mn6 (net638 \1\:E \17\:VSS VSS) g45n1lvt w=(1.45e-07) l=4.5e-08 nf=1 \
        as=2.03e-14 ad=8.7e-15 ps=5.7e-07 pd=4.1e-07 nrd=1.16667 \
        nrs=1.16667 sa=1.4e-07 sb=2.45e-07 sd=160n sca=7.09016 \
        scb=0.00401586 scc=3.69756e-05 m=(1)
mn7 (\13\:Dp \2\:Db net638 VSS) g45n1lvt w=(1.45e-07) l=4.5e-08 nf=1 \
        as=8.7e-15 ad=2.03e-14 ps=4.1e-07 pd=5.7e-07 nrd=1.16667 \
        nrs=1.16667 sa=2.45e-07 sb=1.4e-07 sd=160n sca=7.09016 \
        scb=0.00401586 scc=3.69756e-05 m=(1)
mn0 (\7\:Eb \7\:E \1\:VSS VSS) g45n1lvt w=(1.45e-07) l=4.5e-08 nf=1 \
        as=2.32e-14 ad=2.03e-14 ps=6.1e-07 pd=5.7e-07 nrd=1.16667 \
        nrs=1.16667 sa=1.4e-07 sb=3.45e-07 sd=160n sca=23.279 \
        scb=0.0230742 scc=0.00267719 m=(1)
mn1 (\7\:Db \4\:D \1\:VSS VSS) g45n1lvt w=(1.45e-07) l=4.5e-08 nf=1 \
        as=2.32e-14 ad=2.03e-14 ps=6.1e-07 pd=5.7e-07 nrd=1.16667 \
        nrs=1.16667 sa=3.45e-07 sb=1.4e-07 sd=160n sca=23.279 \
        scb=0.0230742 scc=0.00267719 m=(1)
ends SEDFFTRXL
// End of subcircuit definition.
