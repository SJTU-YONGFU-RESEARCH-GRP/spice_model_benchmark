// Verilog-AMS netlist generated by the AMS netlister, version  ICADV12.1-64b.341 .
// Cadence Design Systems, Inc.

`include "disciplines.vams"

(* cds_ams_schematic *)
module NOR2X8 ( Y,.VDD(\VDD! ),A,B,.NW(\NW! ),
.VSS(\VSS! ) );

output  (*
integer supplySensitivity = "VDD";
integer
groundSensitivity = "VSS";
 *)
 Y;
input  (*
integer
inh_conn_prop_name = "VDD";
integer inh_conn_def_value
 = "cds_globals.\\VDD! ";
integer groundSensitivity = "VSS";
 *)

 \VDD! ;
input  (*
integer supplySensitivity = "VDD";
integer
groundSensitivity = "VSS";
 *)
 A;
input  (*
integer supplySensitivity
 = "VDD";
integer groundSensitivity = "VSS";
 *)
 B;
input  (*

integer inh_conn_prop_name = "NW";
integer inh_conn_def_value
 = "cds_globals.\\NW! ";
integer supplySensitivity = "VDD";
 *)

 \NW! ;
input  (*
integer inh_conn_prop_name = "VSS";
integer
inh_conn_def_value = "cds_globals.\\VSS! ";
integer supplySensitivity
 = "VDD";
 *)
 \VSS! ;

wire Y;
wire (*
integer inh_conn_prop_name = "VSS";
integer inh_conn_def_value
 = "cds_globals.\\VSS! ";
 *)
\VSS! ;
wire A;
wire B;
wire (*
integer inh_conn_prop_name = "VDD";
integer inh_conn_def_value
 = "cds_globals.\\VDD! ";
 *)
\VDD! ;

g45n1svt #(.ad(289.1f), .nrd(67.7966m), .sca(56.50260), .pd(4.41u), .scc(0.00690),
 .scb(0.05663), .as(289.1f), .nrs(67.7966m), .m(1), .ps(4.41u), .w(2.065u),
 .sa(140n), .nf(1), .sb(140n), .sd(160n), .l(45n)) (*
integer
library_binding = "gpdk045";
integer passed_mfactor = "m";
 *)
mn1 ( Y,
B, \VSS! , \VSS!  );
g45n1svt #(.ad(289.1f), .nrd(67.7966m), .sca(56.50260), .pd(4.41u), .scc(0.00690),
 .scb(0.05663), .as(289.1f), .nrs(67.7966m), .m(1), .ps(4.41u), .w(2.065u),
 .sa(140n), .nf(1), .sb(140n), .sd(160n), .l(45n)) (*
integer
library_binding = "gpdk045";
integer passed_mfactor = "m";
 *)
mn0 ( Y,
A, \VSS! , \VSS!  );

g45p1svt #(.ad(436.1f), .nrd(44.9438m), .sca(51.31501), .pd(6.51u), .scc(0.00636),
 .scb(0.05377), .as(436.1f), .nrs(44.9438m), .m(1), .ps(6.51u), .w(3.115u),
 .sa(140n), .nf(1), .sb(140n), .sd(160n), .l(45n)) (*
integer
library_binding = "gpdk045";
integer passed_mfactor = "m";
 *)
mp1 ( Y,
B, net41, \NW!  );
g45p1svt #(.ad(436.1f), .nrd(44.9438m), .sca(51.31501), .pd(6.51u), .scc(0.00636),
 .scb(0.05377), .as(436.1f), .nrs(44.9438m), .m(1), .ps(6.51u), .w(3.115u),
 .sa(140n), .nf(1), .sb(140n), .sd(160n), .l(45n)) (*
integer
library_binding = "gpdk045";
integer passed_mfactor = "m";
 *)
mp0 (
net41, A, \VDD! , \NW!  );

endmodule
