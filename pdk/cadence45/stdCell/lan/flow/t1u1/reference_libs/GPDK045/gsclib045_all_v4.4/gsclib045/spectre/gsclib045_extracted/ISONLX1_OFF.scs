// Generated for: spectre (May  1 08:11:39 2013 )
// Library name: gsclib045
// Cell name: ISONLX1_OFF
// View name: extracted

simulator lang=spectre

subckt ISONLX1_OFF A ExtVDD ISOn VSS Y
mp1 (\8\:n0 \1\:ISOn \5\:ExtVDD ExtVDD) g45p1svt w=(2.15e-07) l=4.5e-08 \
        nf=1 as=3.01e-14 ad=3.44e-14 ps=7.1e-07 pd=7.5e-07 nrd=1.16667 \
        nrs=1.16667 sa=3.45e-07 sb=1.4e-07 sd=160n sca=10.9495 \
        scb=0.00875135 scc=0.000103322 m=(1)
mp0 (\8\:n0 \1\:A \7\:ExtVDD ExtVDD) g45p1svt w=(2.15e-07) l=4.5e-08 \
        nf=1 as=3.44e-14 ad=3.01e-14 ps=7.5e-07 pd=7.1e-07 nrd=1.16667 \
        nrs=1.16667 sa=1.4e-07 sb=3.45e-07 sd=160n sca=25.7248 \
        scb=0.0268097 scc=0.00266528 m=(1)
C1 (ExtVDD VSS) capacitor c=2.57245e-16
C2 (Y VSS) capacitor c=4.32253e-17
C3 (A VSS) capacitor c=1.72393e-17
C4 (VDD VSS) capacitor c=1.43708e-16
C5 (ISOn VSS) capacitor c=2.99103e-17
C6 (n0 VSS) capacitor c=2.66734e-17
C7 (\3\:n0 VSS) capacitor c=4.62118e-17
C8 (\1\:ISOn VSS) capacitor c=5.11078e-17
C9 (\1\:A VSS) capacitor c=4.28221e-17
C10 (\3\:ISOn VSS) capacitor c=4.99975e-17
C11 (\3\:A VSS) capacitor c=7.99256e-17
C12 (\2\:n0 VSS) capacitor c=2.76959e-17
C13 (\2\:ISOn VSS) capacitor c=7.22601e-17
C14 (\2\:A VSS) capacitor c=6.22329e-17
C15 (\1\:Y VSS) capacitor c=5.69102e-17
C16 (\1\:ExtVDD VSS) capacitor c=5.83114e-17
C17 (\5\:ExtVDD VSS) capacitor c=8.64723e-17
C18 (\8\:n0 VSS) capacitor c=9.14898e-17
C19 (\7\:ExtVDD VSS) capacitor c=7.44277e-17
C20 (\3\:Y VSS) capacitor c=5.66908e-17
C21 (\6\:n0 VSS) capacitor c=5.59582e-17
C22 (VDD VSS) capacitor c=1.50188e-16
C23 (\5\:A VSS) capacitor c=4.72328e-18
C24 (\7\:A VSS) capacitor c=2.2185e-17
C25 (\4\:ISOn VSS) capacitor c=3.73098e-17
C26 (\4\:n0 VSS) capacitor c=7.30512e-17
C27 (\5\:n0 VSS) capacitor c=1.22672e-16
Rk8 (ExtVDD ExtVDD) resistor r=0.002413 c=0
Rk7 (\2\:ExtVDD ExtVDD) resistor r=0.4341 c=0
Rk10 (ExtVDD \6\:ExtVDD) resistor r=0.3938 c=0
Rk11 (\6\:ExtVDD \8\:ExtVDD) resistor r=0.633 c=0
Rk15 (Y \2\:Y) resistor r=0.2855 c=0
Rk16 (Y \4\:Y) resistor r=0.338 c=0
Rk1 (\4\:A A) resistor r=0.00257 c=0
Rk2 (A \5\:A) resistor r=0.00257 c=0
Rk3 (\4\:A \5\:A) resistor r=0.03619 c=0
Rk5 (\5\:A \7\:A) resistor r=0.03354 c=0
Rk4 (\6\:A \7\:A) resistor r=0.00257 c=0
Rk23 (VDD VDD) resistor r=0.1713 c=0
Rk25 (VSS VSS) resistor r=0.02895 c=0
Rk19 (VSS VSS) resistor r=0.02895 c=0
Rk18 (\3\:VSS VSS) resistor r=0.1226 c=0
Rk17 (\2\:VSS \3\:VSS) resistor r=0.4268 c=0
Rk20 (VSS \4\:VSS) resistor r=0.09675 c=0
Rk21 (\4\:VSS \6\:VSS) resistor r=0.299 c=0
Rk22 (\3\:VSS \8\:VSS) resistor r=0.2248 c=0
Rk24 (\10\:VSS VSS) resistor r=0.5498 c=0
Rk26 (VSS \11\:VSS) resistor r=0.09675 c=0
Rk6 (\4\:ISOn ISOn) resistor r=0.02871 c=0
Rk12 (\4\:n0 \5\:n0) resistor r=0.439 c=0
Rk13 (\5\:n0 \7\:n0) resistor r=0.4496 c=0
Rk14 (\5\:n0 \9\:n0) resistor r=0.4899 c=0
Rl1 (\1\:A \2\:A) resistor r=97.5321 c=0
Rl2 (\2\:A \3\:A) resistor r=166.528 c=0
Rl3 (\1\:ISOn \2\:ISOn) resistor r=168.745 c=0
Rl4 (\2\:ISOn \3\:ISOn) resistor r=90.6165 c=0
Rl6 (\2\:n0 \3\:n0) resistor r=133.743 c=0
Rl5 (n0 \2\:n0) resistor r=45.3288 c=0
Rz3 (\3\:Y \4\:Y) resistor r=37.5 c=0
Rz4 (\5\:VSS \6\:VSS) resistor r=75 c=0
Rz5 (\7\:VSS \8\:VSS) resistor r=37.5 c=0
Rz2 (\6\:n0 \7\:n0) resistor r=75 c=0
Ry1 (\1\:ExtVDD \2\:ExtVDD) resistor r=20.6667 c=0
Ry2 (\5\:ExtVDD \6\:ExtVDD) resistor r=62 c=0
Ry3 (\7\:ExtVDD \8\:ExtVDD) resistor r=62 c=0
Ry5 (\1\:Y \2\:Y) resistor r=20.6667 c=0
Ry6 (\1\:VSS \2\:VSS) resistor r=31 c=0
Ry7 (\1\:VSS \4\:VSS) resistor r=5.1667 c=0
Ry8 (\9\:VSS \10\:VSS) resistor r=31 c=0
Ry9 (\9\:VSS \11\:VSS) resistor r=5.1667 c=0
Ry4 (\8\:n0 \9\:n0) resistor r=62 c=0
Rx1 (\2\:A \6\:A) resistor r=45 c=0
Rx2 (\2\:ISOn \4\:ISOn) resistor r=45 c=0
Rx3 (\2\:n0 \4\:n0) resistor r=45 c=0
mn0 (net127 \3\:ISOn \5\:VSS VSS) g45n1svt w=(1.45e-07) l=4.5e-08 nf=1 \
        as=2.03e-14 ad=8.7e-15 ps=5.7e-07 pd=4.1e-07 nrd=1.16667 \
        nrs=1.16667 sa=2.45e-07 sb=1.4e-07 sd=160n sca=10.0732 \
        scb=0.00911402 scc=0.000253284 m=(1)
mn1 (\6\:n0 \3\:A net127 VSS) g45n1svt w=(1.45e-07) l=4.5e-08 nf=1 \
        as=8.7e-15 ad=2.03e-14 ps=4.1e-07 pd=5.7e-07 nrd=1.16667 \
        nrs=1.16667 sa=1.4e-07 sb=2.45e-07 sd=160n sca=10.0732 \
        scb=0.00911402 scc=0.000253284 m=(1)
mn2 (\3\:Y n0 \7\:VSS VSS) g45n1svt w=(2.6e-07) l=4.5e-08 nf=1 \
        as=3.64e-14 ad=3.64e-14 ps=8e-07 pd=8e-07 nrd=1.16667 nrs=1.16667 \
        sa=1.4e-07 sb=1.4e-07 sd=160n sca=12.1772 scb=0.0118935 \
        scc=0.000630577 m=(1)
mp2 (\1\:Y \3\:n0 \1\:ExtVDD ExtVDD) g45p1svt w=(3.9e-07) l=4.5e-08 nf=1 \
        as=5.46e-14 ad=5.46e-14 ps=1.06e-06 pd=1.06e-06 nrd=1.16667 \
        nrs=1.16667 sa=1.4e-07 sb=1.4e-07 sd=160n sca=25.7882 \
        scb=0.0272171 scc=0.00268607 m=(1)
ends ISONLX1_OFF
// End of subcircuit definition.
