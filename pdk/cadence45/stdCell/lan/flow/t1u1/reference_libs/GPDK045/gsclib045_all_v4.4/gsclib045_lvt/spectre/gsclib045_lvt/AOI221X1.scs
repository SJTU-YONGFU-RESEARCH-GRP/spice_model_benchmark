// gsclib045_lvt/AOI221X1/schematic

simulator lang=spectre

subckt AOI221X1 A0 A1 B0 B1 C0 Y VDD VSS
mp3 (net108 B1 net111 VDD) g45p1lvt w=(390n) l=45n nf=1 m=(1)
mp2 (net108 B0 net111 VDD) g45p1lvt w=(390n) l=45n nf=1 m=(1)
mp0 (net111 A0 VDD VDD) g45p1lvt w=(390n) l=45n nf=1 m=(1)
mp1 (net111 A1 VDD VDD) g45p1lvt w=(390n) l=45n nf=1 m=(1)
mp4 (Y C0 net108 VDD) g45p1lvt w=(390n) l=45n nf=1 m=(1)
mn2 (net120 B0 VSS VSS) g45n1lvt w=(260n) l=45n nf=1 m=(1)
mn3 (Y B1 net120 VSS) g45n1lvt w=(260n) l=45n nf=1 m=(1)
mn4 (Y C0 VSS VSS) g45n1lvt w=(260n) l=45n nf=1 m=(1)
mn1 (Y A1 net128 VSS) g45n1lvt w=(260n) l=45n nf=1 m=(1)
mn0 (net128 A0 VSS VSS) g45n1lvt w=(260n) l=45n nf=1 m=(1)
ends AOI221X1
