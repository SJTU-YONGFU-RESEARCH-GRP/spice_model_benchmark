// Generated for: spectre (May  1 09:13:52 2013 )
// Library name: gsclib045_hvt
// Cell name: CLKINVX16
// View name: extracted

simulator lang=spectre

subckt CLKINVX16 A VDD VSS Y
mp0 (Y \1\:A \1\:VDD VDD) g45p1hvt w=(4.45e-07) l=4.5e-08 nf=1 \
        as=6.993e-14 ad=7.12e-14 ps=1.20429e-06 pd=1.21e-06 nrd=1.16667 \
        nrs=1.16667 sa=1.4e-07 sb=2e-06 sd=160n sca=33.496 scb=0.0262642 \
        scc=0.00310781 m=(14)
C1 (A VSS) capacitor c=2.1506e-17
C2 (Y VSS) capacitor c=6.76068e-16
C3 (VDD VSS) capacitor c=8.85565e-17
C4 (\1\:A VSS) capacitor c=9.4543e-16
C5 (\1\:VDD VSS) capacitor c=4.60088e-16
C6 (\17\:Y VSS) capacitor c=4.05981e-16
Rk56 (\1\:VSS VSS) resistor r=0.06474 c=0
Rk8 (\1\:A A) resistor r=0.01234 c=0
Rk19 (Y \17\:Y) resistor r=0.2528 c=0
Rk39 (\1\:VDD VDD) resistor r=0.06474 c=0
mn0 (\17\:Y \1\:A \1\:VSS VSS) g45n1hvt w=(2.95e-07) l=4.5e-08 nf=1 \
        as=4.636e-14 ad=4.72e-14 ps=9.0429e-07 pd=9.1e-07 nrd=1.16667 \
        nrs=1.16667 sa=1.4e-07 sb=2e-06 sd=160n sca=16.4223 scb=0.0158966 \
        scc=0.0014413 m=(14)
ends CLKINVX16
// End of subcircuit definition.
