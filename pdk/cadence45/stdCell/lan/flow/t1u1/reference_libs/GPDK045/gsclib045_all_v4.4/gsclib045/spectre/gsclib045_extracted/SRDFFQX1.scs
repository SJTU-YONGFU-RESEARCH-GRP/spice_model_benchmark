// Generated for: spectre (May  1 08:12:41 2013 )
// Library name: gsclib045
// Cell name: SRDFFQX1
// View name: extracted

simulator lang=spectre

subckt SRDFFQX1 CK D ExtVDD Q RT SE SI VDD VSS
mp10 (\8\:SEb \3\:SE \12\:VDD VDD) g45p1svt w=(2.15e-07) l=4.5e-08 nf=1 \
        as=3.44e-14 ad=3.01e-14 ps=7.5e-07 pd=7.1e-07 nrd=1.16667 \
        nrs=1.16667 sa=7.9e-07 sb=1.4e-07 sd=160n sca=34.2363 \
        scb=0.0392303 scc=0.00368484 m=(1)
mp21 (\14\:CKbb \4\:CKb \19\:VDD VDD) g45p1svt w=(2.15e-07) l=4.5e-08 \
        nf=1 as=1.362e-13 ad=3.01e-14 ps=2.93e-06 pd=7.1e-07 nrd=1.16667 \
        nrs=1.16667 sa=1.4e-07 sb=3.45e-07 sd=160n sca=15.238 \
        scb=0.0153511 scc=0.00103803 m=(1)
mp20 (\16\:CKb \4\:CK \19\:VDD VDD) g45p1svt w=(2.15e-07) l=4.5e-08 nf=1 \
        as=3.01e-14 ad=1.362e-13 ps=7.1e-07 pd=2.93e-06 nrd=1.16667 \
        nrs=1.16667 sa=3.45e-07 sb=1.4e-07 sd=160n sca=14.7851 \
        scb=0.0152025 scc=0.00103799 m=(1)
mp11 (n1 \4\:D \19\:VDD VDD) g45p1svt w=(2.15e-07) l=4.5e-08 nf=1 \
        as=1.362e-13 ad=1.29e-14 ps=2.93e-06 pd=5.5e-07 nrd=1.16667 \
        nrs=1.16667 sa=1.7e-07 sb=7.6e-07 sd=160n sca=15.238 scb=0.0153511 \
        scc=0.00103803 m=(1)
mp25 (\9\:n20 \2\:CKbb \5\:Db VDD) g45p1svt w=(2.15e-07) l=4.5e-08 nf=1 \
        as=3.01e-14 ad=3.01e-14 ps=7.1e-07 pd=7.1e-07 nrd=1.16667 \
        nrs=1.16667 sa=1.4e-07 sb=1.4e-07 sd=160n sca=20.1774 \
        scb=0.0226612 scc=0.00118174 m=(1)
mp36 (\12\:n20 \9\:CKb n7 VDD) g45p1svt w=(2.15e-07) l=4.5e-08 nf=1 \
        as=1.29e-14 ad=3.01e-14 ps=5.5e-07 pd=7.1e-07 nrd=1.16667 \
        nrs=1.16667 sa=1.4e-07 sb=2.95e-07 sd=160n sca=6.7773 \
        scb=0.0027674 scc=1.42147e-05 m=(1)
mp35 (n7 mout \17\:VDD VDD) g45p1svt w=(2.15e-07) l=4.5e-08 nf=1 \
        as=4.085e-14 ad=1.29e-14 ps=8.1e-07 pd=5.5e-07 nrd=1.16667 \
        nrs=1.16667 sa=2.45e-07 sb=1.9e-07 sd=160n sca=6.40652 \
        scb=0.0025693 scc=1.40931e-05 m=(1)
mp32 (\15\:mout \3\:n20 \14\:VDD VDD) g45p1svt w=(2.15e-07) l=4.5e-08 \
        nf=1 as=3.01e-14 ad=3.01e-14 ps=7.1e-07 pd=7.1e-07 nrd=1.16667 \
        nrs=1.16667 sa=1.4e-07 sb=1.4e-07 sd=160n sca=6.37787 \
        scb=0.00255822 scc=1.40897e-05 m=(1)
mp12 (\3\:Db \4\:SE n1 VDD) g45p1svt w=(2.15e-07) l=4.5e-08 nf=1 \
        as=1.29e-14 ad=3.44e-14 ps=5.5e-07 pd=7.5e-07 nrd=1.16667 \
        nrs=1.16667 sa=2.75e-07 sb=6.55e-07 sd=160n sca=15.6684 \
        scb=0.0156302 scc=0.00103829 m=(1)
mp14 (\3\:Db SEb n3 VDD) g45p1svt w=(2.15e-07) l=4.5e-08 nf=1 as=1.29e-14 \
        ad=3.44e-14 ps=5.5e-07 pd=7.5e-07 nrd=1.16667 nrs=1.16667 \
        sa=4.8e-07 sb=4.5e-07 sd=160n sca=17.3611 scb=0.0177712 \
        scc=0.00105096 m=(1)
mp13 (n3 \3\:SI \12\:VDD VDD) g45p1svt w=(2.15e-07) l=4.5e-08 nf=1 \
        as=3.44e-14 ad=1.29e-14 ps=7.5e-07 pd=5.5e-07 nrd=1.16667 \
        nrs=1.16667 sa=5.85e-07 sb=3.45e-07 sd=160n sca=19.3151 \
        scb=0.0211393 scc=0.00112289 m=(1)
mp40 (\13\:n35 \8\:CKb \5\:mout VDD) g45p1svt w=(2.15e-07) l=4.5e-08 nf=1 \
        as=3.01e-14 ad=3.01e-14 ps=7.1e-07 pd=7.1e-07 nrd=1.16667 \
        nrs=1.16667 sa=1.4e-07 sb=1.4e-07 sd=160n sca=25.5298 \
        scb=0.0265038 scc=0.00266093 m=(1)
PM0 (\7\:n35g \3\:RT \5\:n35 ExtVDD) g45p1svt w=(2.15e-07) l=4.5e-08 nf=1 \
        as=3.01e-14 ad=3.01e-14 ps=7.1e-07 pd=7.1e-07 nrd=1.16667 \
        nrs=1.16667 sa=1.4e-07 sb=1.4e-07 sd=160n sca=28.4784 \
        scb=0.0312204 scc=0.00281308 m=(1)
mp45 (\14\:qbint \3\:n35g \3\:ExtVDD ExtVDD) g45p1svt w=(2.15e-07) \
        l=4.5e-08 nf=1 as=3.01e-14 ad=3.01e-14 ps=7.1e-07 pd=7.1e-07 \
        nrd=1.16667 nrs=1.16667 sa=1.4e-07 sb=1.4e-07 sd=160n sca=25.2796 \
        scb=0.0259458 scc=0.00265434 m=(1)
PM2 (net234 \4\:qbint \6\:ExtVDD ExtVDD) g45p1svt w=(2.15e-07) l=4.5e-08 \
        nf=1 as=3.01e-14 ad=1.29e-14 ps=7.1e-07 pd=5.5e-07 nrd=1.16667 \
        nrs=1.16667 sa=1.4e-07 sb=2.45e-07 sd=160n sca=14.5295 \
        scb=0.0144143 scc=0.000486924 m=(1)
PM1 (\9\:RTb \6\:RT \11\:ExtVDD ExtVDD) g45p1svt w=(2.15e-07) l=4.5e-08 \
        nf=1 as=3.01e-14 ad=3.01e-14 ps=7.1e-07 pd=7.1e-07 nrd=1.16667 \
        nrs=1.16667 sa=1.4e-07 sb=1.4e-07 sd=160n sca=26.768 scb=0.029923 \
        scc=0.00243217 m=(1)
PM3 (\15\:n35g \4\:RTb net234 ExtVDD) g45p1svt w=(2.15e-07) l=4.5e-08 \
        nf=1 as=1.29e-14 ad=3.01e-14 ps=5.5e-07 pd=7.1e-07 nrd=1.16667 \
        nrs=1.16667 sa=2.45e-07 sb=1.4e-07 sd=160n sca=25.2796 \
        scb=0.0259458 scc=0.00265434 m=(1)
mp53 (\17\:n35 \10\:CKbb \3\:net0110 VDD) g45p1svt w=(2.15e-07) l=4.5e-08 \
        nf=1 as=3.01e-14 ad=3.01e-14 ps=7.1e-07 pd=7.1e-07 nrd=1.16667 \
        nrs=1.16667 sa=1.4e-07 sb=1.4e-07 sd=160n sca=28.514 scb=0.0312305 \
        scc=0.00281308 m=(1)
mp52 (net0110 \7\:qbint \1\:VDD VDD) g45p1svt w=(2.15e-07) l=4.5e-08 \
        nf=1 as=3.01e-14 ad=3.01e-14 ps=7.1e-07 pd=7.1e-07 nrd=1.16667 \
        nrs=1.16667 sa=1.4e-07 sb=1.4e-07 sd=160n sca=15.3268 \
        scb=0.0155038 scc=0.000337499 m=(1)
C1 (VDD VSS) capacitor c=6.59586e-16
C2 (SI VSS) capacitor c=8.02433e-17
C3 (SE VSS) capacitor c=8.83151e-17
C4 (CK VSS) capacitor c=9.95769e-17
C5 (Q VSS) capacitor c=1.86267e-17
C6 (RT VSS) capacitor c=1.16808e-16
C7 (D VSS) capacitor c=7.41503e-17
C8 (ExtVDD VSS) capacitor c=2.94217e-16
C9 (n20 VSS) capacitor c=3.87782e-17
C10 (CKbb VSS) capacitor c=6.08809e-17
C11 (mout VSS) capacitor c=4.78609e-17
C12 (CKb VSS) capacitor c=6.17772e-17
C13 (SEb VSS) capacitor c=7.74852e-17
C14 (n35g VSS) capacitor c=1.63271e-17
C15 (qbint VSS) capacitor c=4.52018e-17
C16 (RTb VSS) capacitor c=5.59439e-17
C17 (n35 VSS) capacitor c=3.96806e-17
C18 (Db VSS) capacitor c=9.70263e-17
C19 (net0110 VSS) capacitor c=7.18175e-17
C20 (net0118 VSS) capacitor c=4.57878e-17
C21 (n1 VSS) capacitor c=1.02126e-18
C22 (\7\:qbint VSS) capacitor c=9.70103e-17
C23 (\10\:qbint VSS) capacitor c=2.73315e-17
C24 (\10\:CKbb VSS) capacitor c=4.78773e-17
C25 (\4\:RTb VSS) capacitor c=1.20039e-16
C26 (\6\:RT VSS) capacitor c=5.07865e-17
C27 (\4\:qbint VSS) capacitor c=8.14438e-17
C28 (\3\:n35g VSS) capacitor c=9.26335e-17
C29 (\3\:RT VSS) capacitor c=9.54348e-17
C30 (\3\:SE VSS) capacitor c=7.8051e-17
C31 (\8\:CKb VSS) capacitor c=2.93543e-17
C32 (\3\:SI VSS) capacitor c=9.50859e-17
C33 (\4\:SE VSS) capacitor c=1.25301e-16
C34 (\4\:D VSS) capacitor c=7.04726e-17
C35 (\3\:n20 VSS) capacitor c=2.92652e-17
C36 (\4\:CK VSS) capacitor c=4.60839e-17
C37 (\4\:CKb VSS) capacitor c=5.31851e-17
C38 (\9\:CKb VSS) capacitor c=8.40618e-17
C39 (\2\:CKbb VSS) capacitor c=9.30095e-17
C40 (\6\:qbint VSS) capacitor c=4.9317e-17
C41 (\11\:qbint VSS) capacitor c=3.14309e-17
C42 (\10\:CKb VSS) capacitor c=4.37115e-17
C43 (\4\:RT VSS) capacitor c=1.60592e-16
C44 (\5\:RT VSS) capacitor c=6.68518e-17
C45 (\5\:qbint VSS) capacitor c=3.8933e-17
C46 (\4\:n35g VSS) capacitor c=2.9038e-17
C47 (\5\:SE VSS) capacitor c=5.74977e-17
C48 (\4\:CKbb VSS) capacitor c=2.44609e-17
C49 (\1\:SI VSS) capacitor c=4.92919e-17
C50 (\6\:SE VSS) capacitor c=8.71049e-17
C51 (\3\:SEb VSS) capacitor c=6.6818e-17
C52 (\1\:D VSS) capacitor c=4.95493e-17
C53 (\6\:n20 VSS) capacitor c=5.57838e-17
C54 (\1\:CK VSS) capacitor c=4.15185e-17
C55 (\3\:mout VSS) capacitor c=4.54358e-17
C56 (\6\:CKb VSS) capacitor c=3.91595e-17
C57 (\9\:CKbb VSS) capacitor c=4.84921e-17
C58 (\7\:CKb VSS) capacitor c=4.67907e-17
C59 (\11\:CKb VSS) capacitor c=4.26457e-17
C60 (\3\:n35 VSS) capacitor c=5.52362e-17
C61 (\9\:qbint VSS) capacitor c=4.21767e-17
C62 (\11\:CKbb VSS) capacitor c=4.98232e-17
C63 (\1\:RT VSS) capacitor c=1.50923e-16
C64 (\8\:CKbb VSS) capacitor c=1.29661e-16
C65 (\3\:RTb VSS) capacitor c=9.35151e-17
C66 (\4\:n35 VSS) capacitor c=6.31627e-17
C67 (\3\:qbint VSS) capacitor c=3.59555e-17
C68 (\1\:ExtVDD VSS) capacitor c=7.79936e-17
C69 (\2\:ExtVDD VSS) capacitor c=8.00935e-17
C70 (\2\:RTb VSS) capacitor c=5.40085e-17
C71 (\5\:n35g VSS) capacitor c=1.02401e-16
C72 (\2\:n35 VSS) capacitor c=4.25786e-17
C73 (\1\:SE VSS) capacitor c=2.47457e-17
C74 (\2\:SI VSS) capacitor c=7.7367e-17
C75 (\2\:SEb VSS) capacitor c=7.84229e-17
C76 (\3\:D VSS) capacitor c=1.51176e-17
C77 (\3\:CK VSS) capacitor c=2.44724e-17
C78 (\2\:mout VSS) capacitor c=3.7012e-17
C79 (\4\:mout VSS) capacitor c=2.84256e-17
C80 (\5\:CKb VSS) capacitor c=6.01895e-17
C81 (\5\:n20 VSS) capacitor c=6.40427e-17
C82 (\3\:CKbb VSS) capacitor c=7.34993e-17
C83 (\7\:CKbb VSS) capacitor c=2.52951e-17
C84 (\2\:n20 VSS) capacitor c=3.96498e-17
C85 (\1\:VDD VSS) capacitor c=5.16216e-17
C86 (\10\:VDD VSS) capacitor c=5.35146e-17
C87 (\1\:Q VSS) capacitor c=5.54644e-17
C88 (\3\:net0110 VSS) capacitor c=7.74287e-17
C89 (\17\:n35 VSS) capacitor c=9.39029e-17
C90 (\15\:n35g VSS) capacitor c=5.07526e-17
C91 (\9\:RTb VSS) capacitor c=4.33843e-17
C92 (\11\:ExtVDD VSS) capacitor c=3.62391e-17
C93 (\7\:n35g VSS) capacitor c=7.31267e-17
C94 (\14\:qbint VSS) capacitor c=6.80915e-17
C95 (\5\:n35 VSS) capacitor c=6.17198e-17
C96 (\8\:SEb VSS) capacitor c=5.30906e-17
C97 (\13\:n35 VSS) capacitor c=7.12791e-17
C98 (\12\:VDD VSS) capacitor c=6.40562e-17
C99 (\5\:mout VSS) capacitor c=7.18931e-17
C100 (\3\:Db VSS) capacitor c=1.80796e-16
C101 (\14\:VDD VSS) capacitor c=3.44636e-17
C102 (\19\:VDD VSS) capacitor c=3.46661e-17
C103 (\15\:mout VSS) capacitor c=5.28158e-17
C104 (\16\:CKb VSS) capacitor c=3.81071e-17
C105 (\17\:VDD VSS) capacitor c=4.09734e-17
C106 (\14\:CKbb VSS) capacitor c=6.86337e-17
C107 (\12\:n20 VSS) capacitor c=6.22411e-17
C108 (\5\:Db VSS) capacitor c=1.8887e-16
C109 (\9\:n20 VSS) capacitor c=6.24083e-17
C110 (\3\:Q VSS) capacitor c=4.25754e-17
C111 (\3\:net0118 VSS) capacitor c=4.54938e-17
C112 (\19\:n35 VSS) capacitor c=8.11619e-17
C113 (\11\:n35g VSS) capacitor c=2.64761e-17
C114 (\6\:RTb VSS) capacitor c=1.79346e-16
C115 (\9\:n35g VSS) capacitor c=8.30299e-17
C116 (\16\:qbint VSS) capacitor c=2.41475e-17
C117 (\11\:n35 VSS) capacitor c=2.58948e-17
C118 (\4\:SEb VSS) capacitor c=3.83082e-17
C119 (\9\:n35 VSS) capacitor c=2.70788e-17
C120 (\11\:mout VSS) capacitor c=2.25518e-17
C121 (\13\:mout VSS) capacitor c=2.50977e-17
C122 (\12\:CKb VSS) capacitor c=4.20416e-17
C123 (\17\:CKbb VSS) capacitor c=5.50139e-17
C124 (\16\:n20 VSS) capacitor c=8.66247e-17
C125 (\7\:Db VSS) capacitor c=9.49107e-17
C126 (\7\:n20 VSS) capacitor c=5.99392e-17
C127 (\2\:CK VSS) capacitor c=3.50802e-17
C128 (\4\:n20 VSS) capacitor c=5.56193e-17
C129 (\2\:D VSS) capacitor c=3.57349e-17
C130 (\2\:SE VSS) capacitor c=2.59689e-17
C131 (VDD VSS) capacitor c=1.95669e-16
C132 (\2\:CKb VSS) capacitor c=1.69209e-16
C133 (\3\:CKb VSS) capacitor c=8.69564e-17
C134 (\2\:n35g VSS) capacitor c=2.97324e-17
C135 (\2\:qbint VSS) capacitor c=4.16747e-17
C136 (\5\:CKbb VSS) capacitor c=1.31932e-16
C137 (\6\:CKbb VSS) capacitor c=6.98522e-17
C138 (\2\:RT VSS) capacitor c=8.11903e-17
C139 (\11\:n20 VSS) capacitor c=4.5683e-17
C140 (\8\:qbint VSS) capacitor c=7.45977e-17
C141 (\12\:CKbb VSS) capacitor c=9.84605e-17
C142 (\13\:CKbb VSS) capacitor c=9.62087e-17
C143 (\14\:n20 VSS) capacitor c=5.23223e-17
C144 (\15\:n20 VSS) capacitor c=9.1105e-17
C145 (\16\:CKbb VSS) capacitor c=7.37877e-17
C146 (\14\:CKb VSS) capacitor c=7.21698e-17
C147 (\15\:CKb VSS) capacitor c=5.58963e-17
C148 (\7\:mout VSS) capacitor c=6.49076e-17
C149 (\8\:mout VSS) capacitor c=2.58223e-17
C150 (\9\:mout VSS) capacitor c=5.20763e-17
C151 (\10\:mout VSS) capacitor c=6.25099e-17
C152 (\17\:mout VSS) capacitor c=4.88739e-17
C153 (\6\:SEb VSS) capacitor c=7.01308e-17
C154 (\7\:SEb VSS) capacitor c=7.68236e-17
C155 (\7\:n35 VSS) capacitor c=7.59066e-17
C156 (\8\:n35 VSS) capacitor c=8.01397e-17
C157 (\6\:n35g VSS) capacitor c=4.52176e-17
C158 (\5\:ExtVDD VSS) capacitor c=1.07807e-16
C159 (\13\:ExtVDD VSS) capacitor c=4.77254e-17
C160 (\12\:qbint VSS) capacitor c=9.03043e-17
C161 (\13\:qbint VSS) capacitor c=1.11663e-16
C162 (\13\:n35g VSS) capacitor c=1.18515e-16
C163 (\14\:n35g VSS) capacitor c=1.17731e-16
C164 (\15\:n35 VSS) capacitor c=6.81975e-17
C165 (\16\:n35 VSS) capacitor c=6.93483e-17
C166 (\5\:RTb VSS) capacitor c=8.32399e-17
C167 (\8\:RTb VSS) capacitor c=1.11319e-16
C168 (\19\:CKbb VSS) capacitor c=1.29892e-16
C169 (\20\:CKbb VSS) capacitor c=1.0265e-16
C170 (\18\:qbint VSS) capacitor c=1.7124e-17
C171 (\19\:qbint VSS) capacitor c=3.06171e-17
C172 (\18\:CKb VSS) capacitor c=2.4007e-16
C173 (\19\:CKb VSS) capacitor c=3.02646e-16
C174 (\21\:n35 VSS) capacitor c=3.28621e-17
C175 (\3\:VDD VSS) capacitor c=2.85914e-17
C176 (\5\:VDD VSS) capacitor c=1.04535e-16
C177 (\6\:VDD VSS) capacitor c=7.10366e-17
C178 (\7\:VDD VSS) capacitor c=2.10993e-17
C179 (\9\:VDD VSS) capacitor c=2.88587e-17
C180 (\16\:VDD VSS) capacitor c=4.54613e-17
Rk64 (\2\:VDD \3\:VDD) resistor r=0.3442 c=0
Rk66 (\5\:VDD VDD) resistor r=1.1048 c=0
Rk65 (\3\:VDD \5\:VDD) resistor r=0.07413 c=0
Rk67 (VDD \6\:VDD) resistor r=0.4683 c=0
Rk68 (\6\:VDD \7\:VDD) resistor r=0.23 c=0
Rk69 (\7\:VDD \9\:VDD) resistor r=0.1094 c=0
Rk70 (\3\:VDD \11\:VDD) resistor r=0.3561 c=0
Rk71 (\6\:VDD \13\:VDD) resistor r=0.3658 c=0
Rk72 (\7\:VDD \15\:VDD) resistor r=0.2067 c=0
Rk76 (\16\:VDD VDD) resistor r=0.1953 c=0
Rk73 (\9\:VDD \16\:VDD) resistor r=0.1634 c=0
Rk74 (\16\:VDD \18\:VDD) resistor r=0.2107 c=0
Rk75 (\9\:VDD \20\:VDD) resistor r=0.2347 c=0
Rk77 (\2\:VSS \4\:VSS) resistor r=0.3775 c=0
Rk78 (\4\:VSS \5\:VSS) resistor r=0.7805 c=0
Rk80 (\6\:VSS VSS) resistor r=0.3318 c=0
Rk79 (\5\:VSS \6\:VSS) resistor r=0.06175 c=0
Rk81 (VSS \7\:VSS) resistor r=0.8152 c=0
Rk83 (\8\:VSS VSS) resistor r=0.1187 c=0
Rk82 (\7\:VSS \8\:VSS) resistor r=0.04193 c=0
Rk84 (VSS \10\:VSS) resistor r=0.2917 c=0
Rk85 (\5\:VSS \12\:VSS) resistor r=0.1658 c=0
Rk86 (\7\:VSS \14\:VSS) resistor r=0.2396 c=0
Rk87 (\16\:VSS \18\:VSS) resistor r=0.3056 c=0
Rk88 (\18\:VSS \19\:VSS) resistor r=0.808 c=0
Rk89 (\19\:VSS \21\:VSS) resistor r=0.189 c=0
Rk90 (\19\:VSS \22\:VSS) resistor r=0.03449 c=0
Rk93 (\23\:VSS VSS) resistor r=0.1581 c=0
Rk91 (\22\:VSS \23\:VSS) resistor r=0.1732 c=0
Rk92 (\23\:VSS \25\:VSS) resistor r=0.194 c=0
Rk94 (VSS \26\:VSS) resistor r=0.4832 c=0
Rk95 (\26\:VSS \28\:VSS) resistor r=0.2385 c=0
Rk96 (\26\:VSS \29\:VSS) resistor r=0.3068 c=0
Rk97 (\29\:VSS \31\:VSS) resistor r=0.2486 c=0
Rk99 (\32\:VSS VSS) resistor r=0.1187 c=0
Rk98 (\29\:VSS \32\:VSS) resistor r=0.0667 c=0
Rk100 (VSS \34\:VSS) resistor r=0.3158 c=0
Rk60 (Q \2\:Q) resistor r=0.2843 c=0
Rk61 (Q \4\:Q) resistor r=0.221 c=0
Rk54 (RT \7\:RT) resistor r=0.006187 c=0
Rk40 (ExtVDD ExtVDD) resistor r=0.00206 c=0
Rk37 (\4\:ExtVDD \5\:ExtVDD) resistor r=0.02218 c=0
Rk38 (\5\:ExtVDD \7\:ExtVDD) resistor r=0.02218 c=0
Rk42 (\8\:ExtVDD ExtVDD) resistor r=0.03859 c=0
Rk39 (\5\:ExtVDD \8\:ExtVDD) resistor r=0.01996 c=0
Rk43 (\12\:ExtVDD \13\:ExtVDD) resistor r=0.08309 c=0
Rk1 (\8\:n20 \10\:n20) resistor r=0.5425 c=0
Rk2 (\10\:n20 \11\:n20) resistor r=0.2539 c=0
Rk4 (\13\:n20 \14\:n20) resistor r=0.3399 c=0
Rk5 (\13\:n20 \15\:n20) resistor r=0.2292 c=0
Rk6 (\15\:n20 \17\:n20) resistor r=0.4959 c=0
Rk3 (\12\:CKbb \13\:CKbb) resistor r=0.7504 c=0
Rk7 (\15\:CKbb \16\:CKbb) resistor r=0.3834 c=0
Rk8 (\16\:CKbb \18\:CKbb) resistor r=0.205 c=0
Rk55 (\19\:CKbb \20\:CKbb) resistor r=0.6808 c=0
Rk17 (\6\:mout \7\:mout) resistor r=0.6015 c=0
Rk18 (\7\:mout \8\:mout) resistor r=0.2977 c=0
Rk19 (\8\:mout \9\:mout) resistor r=0.1545 c=0
Rk20 (\9\:mout \10\:mout) resistor r=0.2977 c=0
Rk21 (\7\:mout \12\:mout) resistor r=0.1277 c=0
Rk22 (\8\:mout \14\:mout) resistor r=0.09726 c=0
Rk23 (\9\:mout \16\:mout) resistor r=0.5258 c=0
Rk24 (\10\:mout \17\:mout) resistor r=0.3933 c=0
Rk10 (\13\:CKb \14\:CKb) resistor r=0.1958 c=0
Rk11 (\14\:CKb \15\:CKb) resistor r=0.1984 c=0
Rk12 (\14\:CKb \17\:CKb) resistor r=0.3032 c=0
Rk57 (\18\:CKb \19\:CKb) resistor r=1.9109 c=0
Rk27 (\5\:SEb \6\:SEb) resistor r=0.2018 c=0
Rk28 (\6\:SEb \7\:SEb) resistor r=0.3834 c=0
Rk29 (\6\:SEb \9\:SEb) resistor r=0.2942 c=0
Rk35 (\6\:n35g \8\:n35g) resistor r=0.1374 c=0
Rk36 (\8\:n35g \10\:n35g) resistor r=0.5859 c=0
Rk47 (\12\:n35g \13\:n35g) resistor r=0.2427 c=0
Rk48 (\13\:n35g \14\:n35g) resistor r=0.5649 c=0
Rk49 (\13\:n35g \16\:n35g) resistor r=0.4315 c=0
Rk44 (\12\:qbint \13\:qbint) resistor r=0.494 c=0
Rk45 (\13\:qbint \15\:qbint) resistor r=0.5666 c=0
Rk46 (\13\:qbint \17\:qbint) resistor r=0.1462 c=0
Rk56 (\18\:qbint \19\:qbint) resistor r=0.2116 c=0
Rk51 (\5\:RTb \7\:RTb) resistor r=0.5249 c=0
Rk52 (\7\:RTb \8\:RTb) resistor r=0.7664 c=0
Rk53 (\8\:RTb \10\:RTb) resistor r=0.116 c=0
Rk30 (\6\:n35 \7\:n35) resistor r=0.4108 c=0
Rk31 (\7\:n35 \8\:n35) resistor r=0.5458 c=0
Rk32 (\8\:n35 \10\:n35) resistor r=0.1747 c=0
Rk33 (\7\:n35 \12\:n35) resistor r=0.1489 c=0
Rk34 (\8\:n35 \14\:n35) resistor r=0.5545 c=0
Rk50 (\15\:n35 \16\:n35) resistor r=0.4085 c=0
Rk58 (\18\:n35 \20\:n35) resistor r=0.6786 c=0
Rk59 (\20\:n35 \21\:n35) resistor r=0.122 c=0
Rk14 (\2\:Db \4\:Db) resistor r=0.6357 c=0
Rk15 (\4\:Db \6\:Db) resistor r=1.3203 c=0
Rk16 (\6\:Db \8\:Db) resistor r=0.6005 c=0
Rk63 (\2\:net0110 \4\:net0110) resistor r=0.7099 c=0
Rk62 (\2\:net0118 \4\:net0118) resistor r=0.3981 c=0
Rl18 (\2\:SI \3\:SI) resistor r=155.002 c=0
Rl17 (\1\:SI \2\:SI) resistor r=24.2328 c=0
Rl21 (\3\:SE \4\:SE) resistor r=294.192 c=0
Rl23 (\5\:SE \6\:SE) resistor r=241.873 c=0
Rl20 (\2\:SE \3\:SE) resistor r=49.6369 c=0
Rl22 (\2\:SE \5\:SE) resistor r=147.714 c=0
Rl19 (\1\:SE \2\:SE) resistor r=0.767 c=0
Rl8 (\2\:CK \4\:CK) resistor r=70.868 c=0
Rl6 (\1\:CK \2\:CK) resistor r=140.099 c=0
Rl7 (\2\:CK \3\:CK) resistor r=2.0166 c=0
Rl51 (\1\:RT \4\:RT) resistor r=752.514 c=0
Rl53 (\2\:RT \6\:RT) resistor r=35.9829 c=0
Rl50 (\2\:RT \3\:RT) resistor r=273.346 c=0
Rl52 (\2\:RT \5\:RT) resistor r=195.631 c=0
Rl49 (\1\:RT \2\:RT) resistor r=176.551 c=0
Rl14 (\2\:D \4\:D) resistor r=115.099 c=0
Rl12 (\1\:D \2\:D) resistor r=84.3295 c=0
Rl13 (\2\:D \3\:D) resistor r=5.1123 c=0
Rl38 (\1\:ExtVDD \2\:ExtVDD) resistor r=149.73 c=0
Rl1 (n20 \2\:n20) resistor r=123.512 c=0
Rl9 (\3\:n20 \4\:n20) resistor r=83.1175 c=0
Rl11 (\4\:n20 \6\:n20) resistor r=197.322 c=0
Rl10 (\4\:n20 \5\:n20) resistor r=244.414 c=0
Rl55 (\10\:CKbb \11\:CKbb) resistor r=195.656 c=0
Rl2 (CKbb \2\:CKbb) resistor r=200.882 c=0
Rl3 (\2\:CKbb \3\:CKbb) resistor r=330.626 c=0
Rl44 (\4\:CKbb \5\:CKbb) resistor r=66.1349 c=0
Rl47 (\5\:CKbb \8\:CKbb) resistor r=762.322 c=0
Rl48 (\6\:CKbb \9\:CKbb) resistor r=60.7265 c=0
Rl46 (\6\:CKbb \7\:CKbb) resistor r=81.3209 c=0
Rl45 (\5\:CKbb \6\:CKbb) resistor r=462.851 c=0
Rl4 (mout \2\:mout) resistor r=24.2328 c=0
Rl5 (\3\:mout \4\:mout) resistor r=24.2328 c=0
Rl29 (\6\:CKb \7\:CKb) resistor r=210.875 c=0
Rl56 (\10\:CKb \11\:CKb) resistor r=134.339 c=0
Rl27 (\4\:CKb \5\:CKb) resistor r=127.615 c=0
Rl28 (\5\:CKb \6\:CKb) resistor r=66.0764 c=0
Rl30 (\2\:CKb \8\:CKb) resistor r=127.816 c=0
Rl24 (CKb \2\:CKb) resistor r=354.912 c=0
Rl26 (\3\:CKb \4\:CKb) resistor r=104.389 c=0
Rl31 (\3\:CKb \9\:CKb) resistor r=147.793 c=0
Rl25 (\2\:CKb \3\:CKb) resistor r=431.465 c=0
Rl15 (SEb \2\:SEb) resistor r=101.718 c=0
Rl16 (\2\:SEb \3\:SEb) resistor r=132.669 c=0
Rl35 (\3\:n35g \5\:n35g) resistor r=332.357 c=0
Rl33 (\2\:n35g \3\:n35g) resistor r=181.74 c=0
Rl34 (\2\:n35g \4\:n35g) resistor r=94.1963 c=0
Rl32 (n35g \2\:n35g) resistor r=2.4834 c=0
Rl57 (\6\:qbint \7\:qbint) resistor r=235.906 c=0
Rl43 (\3\:qbint \5\:qbint) resistor r=35.3072 c=0
Rl42 (\2\:qbint \4\:qbint) resistor r=148.502 c=0
Rl40 (qbint \2\:qbint) resistor r=112.732 c=0
Rl41 (\2\:qbint \3\:qbint) resistor r=74.1915 c=0
Rl58 (\7\:qbint \8\:qbint) resistor r=540.591 c=0
Rl60 (\8\:qbint \10\:qbint) resistor r=67.086 c=0
Rl61 (\8\:qbint \11\:qbint) resistor r=76.4828 c=0
Rl59 (\8\:qbint \9\:qbint) resistor r=219.718 c=0
Rl39 (\3\:RTb \4\:RTb) resistor r=338.853 c=0
Rl36 (RTb \2\:RTb) resistor r=115.333 c=0
Rl54 (\3\:n35 \4\:n35) resistor r=234.929 c=0
Rl37 (n35 \2\:n35) resistor r=149.925 c=0
Rz23 (\1\:VSS \2\:VSS) resistor r=75 c=0
Rz24 (\9\:VSS \10\:VSS) resistor r=75 c=0
Rz25 (\11\:VSS \12\:VSS) resistor r=75 c=0
Rz26 (\13\:VSS \14\:VSS) resistor r=75 c=0
Rz27 (\15\:VSS \16\:VSS) resistor r=37.5 c=0
Rz28 (\20\:VSS \21\:VSS) resistor r=75 c=0
Rz29 (\24\:VSS \25\:VSS) resistor r=75 c=0
Rz30 (\27\:VSS \28\:VSS) resistor r=75 c=0
Rz31 (\30\:VSS \31\:VSS) resistor r=75 c=0
Rz32 (\33\:VSS \34\:VSS) resistor r=75 c=0
Rz18 (\3\:Q \4\:Q) resistor r=37.5 c=0
Rz1 (\7\:n20 \8\:n20) resistor r=75 c=0
Rz2 (\16\:n20 \17\:n20) resistor r=75 c=0
Rz3 (\17\:CKbb \18\:CKbb) resistor r=75 c=0
Rz7 (\11\:mout \12\:mout) resistor r=75 c=0
Rz8 (\13\:mout \14\:mout) resistor r=75 c=0
Rz4 (\12\:CKb \13\:CKb) resistor r=75 c=0
Rz9 (\4\:SEb \5\:SEb) resistor r=75 c=0
Rz12 (\9\:n35g \10\:n35g) resistor r=75 c=0
Rz15 (\11\:n35g \12\:n35g) resistor r=75 c=0
Rz14 (\16\:qbint \17\:qbint) resistor r=75 c=0
Rz16 (\6\:RTb \7\:RTb) resistor r=75 c=0
Rz10 (\9\:n35 \10\:n35) resistor r=75 c=0
Rz11 (\11\:n35 \12\:n35) resistor r=75 c=0
Rz17 (\19\:n35 \20\:n35) resistor r=75 c=0
Rz5 (Db \2\:Db) resistor r=75 c=0
Rz6 (\7\:Db \8\:Db) resistor r=75 c=0
Rz19 (net0118 \2\:net0118) resistor r=75 c=0
Rz20 (\3\:net0118 \4\:net0118) resistor r=75 c=0
Ry23 (\1\:VDD \2\:VDD) resistor r=62 c=0
Ry24 (\10\:VDD \11\:VDD) resistor r=20.6667 c=0
Ry25 (\12\:VDD \13\:VDD) resistor r=62 c=0
Ry26 (\14\:VDD \15\:VDD) resistor r=62 c=0
Ry27 (\17\:VDD \18\:VDD) resistor r=62 c=0
Ry28 (\19\:VDD \20\:VDD) resistor r=62 c=0
Ry29 (\3\:VSS \4\:VSS) resistor r=12.4 c=0
Ry30 (\3\:VSS \6\:VSS) resistor r=5.1667 c=0
Ry31 (\3\:VSS \8\:VSS) resistor r=5.1667 c=0
Ry32 (\17\:VSS \18\:VSS) resistor r=12.4 c=0
Ry33 (\17\:VSS \22\:VSS) resistor r=5.1667 c=0
Ry34 (\17\:VSS \32\:VSS) resistor r=5.1667 c=0
Ry20 (\1\:Q \2\:Q) resistor r=20.6667 c=0
Ry13 (\3\:ExtVDD \4\:ExtVDD) resistor r=62 c=0
Ry14 (\6\:ExtVDD \7\:ExtVDD) resistor r=62 c=0
Ry15 (\11\:ExtVDD \12\:ExtVDD) resistor r=62 c=0
Ry1 (\9\:n20 \10\:n20) resistor r=62 c=0
Ry2 (\12\:n20 \13\:n20) resistor r=62 c=0
Ry3 (\14\:CKbb \15\:CKbb) resistor r=62 c=0
Ry7 (\5\:mout \6\:mout) resistor r=62 c=0
Ry8 (\15\:mout \16\:mout) resistor r=62 c=0
Ry4 (\16\:CKb \17\:CKb) resistor r=62 c=0
Ry9 (\8\:SEb \9\:SEb) resistor r=62 c=0
Ry12 (\7\:n35g \8\:n35g) resistor r=62 c=0
Ry17 (\15\:n35g \16\:n35g) resistor r=62 c=0
Ry16 (\14\:qbint \15\:qbint) resistor r=62 c=0
Ry18 (\9\:RTb \10\:RTb) resistor r=62 c=0
Ry10 (\5\:n35 \6\:n35) resistor r=62 c=0
Ry11 (\13\:n35 \14\:n35) resistor r=62 c=0
Ry19 (\17\:n35 \18\:n35) resistor r=62 c=0
Ry5 (\3\:Db \4\:Db) resistor r=62 c=0
Ry6 (\5\:Db \6\:Db) resistor r=62 c=0
Ry21 (net0110 \2\:net0110) resistor r=62 c=0
Ry22 (\3\:net0110 \4\:net0110) resistor r=62 c=0
Rx12 (\2\:SI SI) resistor r=45 c=0
Rx13 (\1\:SE SE) resistor r=45 c=0
Rx7 (\3\:CK CK) resistor r=45 c=0
Rx25 (\1\:RT \7\:RT) resistor r=45 c=0
Rx9 (\3\:D D) resistor r=45 c=0
Rx17 (\2\:ExtVDD \8\:ExtVDD) resistor r=15 c=0
Rx18 (\1\:ExtVDD \13\:ExtVDD) resistor r=45 c=0
Rx1 (n20 \11\:n20) resistor r=45 c=0
Rx4 (\2\:n20 \14\:n20) resistor r=45 c=0
Rx5 (\5\:n20 \15\:n20) resistor r=45 c=0
Rx2 (\3\:CKbb \12\:CKbb) resistor r=45 c=0
Rx3 (\7\:CKbb \13\:CKbb) resistor r=45 c=0
Rx6 (CKbb \16\:CKbb) resistor r=45 c=0
Rx26 (\11\:CKbb \19\:CKbb) resistor r=45 c=0
Rx27 (\8\:CKbb \20\:CKbb) resistor r=45 c=0
Rx10 (\4\:mout \10\:mout) resistor r=45 c=0
Rx11 (\2\:mout \17\:mout) resistor r=45 c=0
Rx8 (\5\:CKb \15\:CKb) resistor r=45 c=0
Rx30 (CKb \18\:CKb) resistor r=45 c=0
Rx31 (\11\:CKb \19\:CKb) resistor r=45 c=0
Rx14 (\2\:SEb \7\:SEb) resistor r=45 c=0
Rx16 (\5\:n35g \6\:n35g) resistor r=45 c=0
Rx20 (n35g \14\:n35g) resistor r=45 c=0
Rx19 (\3\:qbint \12\:qbint) resistor r=45 c=0
Rx28 (\9\:qbint \18\:qbint) resistor r=45 c=0
Rx29 (qbint \19\:qbint) resistor r=45 c=0
Rx23 (\2\:RTb \5\:RTb) resistor r=45 c=0
Rx24 (\3\:RTb \8\:RTb) resistor r=45 c=0
Rx15 (\2\:n35 \7\:n35) resistor r=45 c=0
Rx21 (\4\:n35 \15\:n35) resistor r=45 c=0
Rx22 (n35 \16\:n35) resistor r=45 c=0
Rx32 (\3\:n35 \21\:n35) resistor r=45 c=0
mn13 (n2 \1\:SI \27\:VSS VSS) g45n1svt w=(1.45e-07) l=4.5e-08 nf=1 \
        as=2.32e-14 ad=8.7e-15 ps=6.1e-07 pd=4.1e-07 nrd=1.16667 \
        nrs=1.16667 sa=5.55e-07 sb=3.45e-07 sd=160n sca=8.85152 \
        scb=0.00706865 scc=0.000138481 m=(1)
mn21 (\17\:CKbb \6\:CKb \33\:VSS VSS) g45n1svt w=(1.45e-07) l=4.5e-08 \
        nf=1 as=2.32e-14 ad=2.03e-14 ps=6.1e-07 pd=5.7e-07 nrd=1.16667 \
        nrs=1.16667 sa=1.4e-07 sb=3.45e-07 sd=160n sca=8.0352 \
        scb=0.00565402 scc=8.19771e-05 m=(1)
mn20 (\12\:CKb \1\:CK \33\:VSS VSS) g45n1svt w=(1.45e-07) l=4.5e-08 nf=1 \
        as=2.03e-14 ad=2.32e-14 ps=5.7e-07 pd=6.1e-07 nrd=1.16667 \
        nrs=1.16667 sa=3.45e-07 sb=1.4e-07 sd=160n sca=8.0352 \
        scb=0.00565402 scc=8.19771e-05 m=(1)
mn10 (\4\:SEb \5\:SE \27\:VSS VSS) g45n1svt w=(1.45e-07) l=4.5e-08 nf=1 \
        as=2.32e-14 ad=2.03e-14 ps=6.1e-07 pd=5.7e-07 nrd=1.16667 \
        nrs=1.16667 sa=7.6e-07 sb=1.4e-07 sd=160n sca=8.85152 \
        scb=0.00706865 scc=0.000138481 m=(1)
NM1 (\6\:RTb \5\:RT \11\:VSS VSS) g45n1svt w=(1.45e-07) l=4.5e-08 nf=1 \
        as=2.03e-14 ad=3.81e-14 ps=5.7e-07 pd=8.5e-07 nrd=1.16667 \
        nrs=1.16667 sa=1.8e-07 sb=1.4e-07 sd=160n sca=8.42104 \
        scb=0.00632542 scc=0.000106623 m=(1)
mn12 (Db \3\:SEb n0 VSS) g45n1svt w=(1.45e-07) l=4.5e-08 nf=1 as=2.32e-14 \
        ad=8.7e-15 ps=6.1e-07 pd=4.1e-07 nrd=1.16667 nrs=1.16667 \
        sa=2.45e-07 sb=6.55e-07 sd=160n sca=8.85152 scb=0.00706865 \
        scc=0.000138481 m=(1)
mn25 (\7\:Db \7\:CKb \7\:n20 VSS) g45n1svt w=(1.45e-07) l=4.5e-08 nf=1 \
        as=2.03e-14 ad=2.03e-14 ps=5.7e-07 pd=5.7e-07 nrd=1.16667 \
        nrs=1.16667 sa=1.4e-07 sb=1.4e-07 sd=160n sca=8.0352 \
        scb=0.00565402 scc=8.19771e-05 m=(1)
mn36 (\16\:n20 \9\:CKbb n6 VSS) g45n1svt w=(1.45e-07) l=4.5e-08 nf=1 \
        as=8.7e-15 ad=2.03e-14 ps=4.1e-07 pd=5.7e-07 nrd=1.16667 \
        nrs=1.16667 sa=1.4e-07 sb=3.1e-07 sd=160n sca=8.42104 \
        scb=0.00632542 scc=0.000106623 m=(1)
mn35 (n6 \3\:mout \9\:VSS VSS) g45n1svt w=(1.45e-07) l=4.5e-08 nf=1 \
        as=2.973e-14 ad=8.7e-15 ps=7e-07 pd=4.1e-07 nrd=1.16667 \
        nrs=1.16667 sa=2.45e-07 sb=2.05e-07 sd=160n sca=8.42104 \
        scb=0.00632542 scc=0.000106623 m=(1)
mn32 (\13\:mout \6\:n20 \13\:VSS VSS) g45n1svt w=(1.45e-07) l=4.5e-08 \
        nf=1 as=2.03e-14 ad=2.03e-14 ps=5.7e-07 pd=5.7e-07 nrd=1.16667 \
        nrs=1.16667 sa=1.4e-07 sb=1.4e-07 sd=160n sca=8.42104 \
        scb=0.00632542 scc=0.000106623 m=(1)
mn11 (n0 \1\:D \30\:VSS VSS) g45n1svt w=(1.45e-07) l=4.5e-08 nf=1 \
        as=2.03e-14 ad=8.7e-15 ps=5.7e-07 pd=4.1e-07 nrd=1.16667 \
        nrs=1.16667 sa=1.4e-07 sb=7.6e-07 sd=160n sca=8.85152 \
        scb=0.00706865 scc=0.000138481 m=(1)
mn14 (Db \6\:SE n2 VSS) g45n1svt w=(1.45e-07) l=4.5e-08 nf=1 as=8.7e-15 \
        ad=2.32e-14 ps=4.1e-07 pd=6.1e-07 nrd=1.16667 nrs=1.16667 \
        sa=4.5e-07 sb=4.5e-07 sd=160n sca=8.85152 scb=0.00706865 \
        scc=0.000138481 m=(1)
mn40 (\9\:n35 \4\:CKbb \11\:mout VSS) g45n1svt w=(1.45e-07) l=4.5e-08 \
        nf=1 as=2.03e-14 ad=2.03e-14 ps=5.7e-07 pd=5.7e-07 nrd=1.16667 \
        nrs=1.16667 sa=1.4e-07 sb=1.4e-07 sd=160n sca=8.42104 \
        scb=0.00632542 scc=0.000106623 m=(1)
NM0 (\9\:n35g RTb \11\:n35 VSS) g45n1svt w=(1.45e-07) l=4.5e-08 nf=1 \
        as=2.03e-14 ad=2.03e-14 ps=5.7e-07 pd=5.7e-07 nrd=1.16667 \
        nrs=1.16667 sa=1.4e-07 sb=1.4e-07 sd=160n sca=8.42104 \
        scb=0.00632542 scc=0.000106623 m=(1)
mn45 (\16\:qbint \4\:n35g \24\:VSS VSS) g45n1svt w=(1.45e-07) l=4.5e-08 \
        nf=1 as=2.03e-14 ad=2.03e-14 ps=5.7e-07 pd=5.7e-07 nrd=1.16667 \
        nrs=1.16667 sa=1.4e-07 sb=1.4e-07 sd=160n sca=9.33388 \
        scb=0.00788941 scc=0.00017958 m=(1)
NM3 (net0134 \5\:qbint \20\:VSS VSS) g45n1svt w=(1.45e-07) l=4.5e-08 \
        nf=1 as=2.03e-14 ad=8.7e-15 ps=5.7e-07 pd=4.1e-07 nrd=1.16667 \
        nrs=1.16667 sa=1.4e-07 sb=2.45e-07 sd=160n sca=9.33388 \
        scb=0.00788941 scc=0.00017958 m=(1)
NM2 (\11\:n35g \4\:RT net0134 VSS) g45n1svt w=(1.45e-07) l=4.5e-08 nf=1 \
        as=8.7e-15 ad=2.03e-14 ps=4.1e-07 pd=5.7e-07 nrd=1.16667 \
        nrs=1.16667 sa=2.45e-07 sb=1.4e-07 sd=160n sca=9.33388 \
        scb=0.00788941 scc=0.00017958 m=(1)
mn53 (\19\:n35 \10\:CKb \3\:net0118 VSS) g45n1svt w=(1.45e-07) l=4.5e-08 \
        nf=1 as=2.03e-14 ad=2.03e-14 ps=5.7e-07 pd=5.7e-07 nrd=1.16667 \
        nrs=1.16667 sa=1.4e-07 sb=1.4e-07 sd=160n sca=8.42104 \
        scb=0.00632542 scc=0.000106623 m=(1)
mn52 (net0118 \6\:qbint \1\:VSS VSS) g45n1svt w=(1.45e-07) l=4.5e-08 \
        nf=1 as=2.03e-14 ad=2.03e-14 ps=5.7e-07 pd=5.7e-07 nrd=1.16667 \
        nrs=1.16667 sa=1.4e-07 sb=1.4e-07 sd=160n sca=8.42104 \
        scb=0.00632542 scc=0.000106623 m=(1)
mn55 (\3\:Q \11\:qbint \15\:VSS VSS) g45n1svt w=(2.6e-07) l=4.5e-08 nf=1 \
        as=3.64e-14 ad=3.64e-14 ps=8e-07 pd=8e-07 nrd=1.16667 nrs=1.16667 \
        sa=1.4e-07 sb=1.4e-07 sd=160n sca=9.50447 scb=0.0081528 \
        scc=0.00025289 m=(1)
mp55 (\1\:Q \10\:qbint \10\:VDD VDD) g45p1svt w=(3.9e-07) l=4.5e-08 nf=1 \
        as=5.46e-14 ad=5.46e-14 ps=1.06e-06 pd=1.06e-06 nrd=1.16667 \
        nrs=1.16667 sa=1.4e-07 sb=1.4e-07 sd=160n sca=20.7413 \
        scb=0.0191761 scc=0.00151516 m=(1)
ends SRDFFQX1
// End of subcircuit definition.
