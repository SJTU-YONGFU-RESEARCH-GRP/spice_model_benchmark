// Generated for: spectre (May  1 09:17:16 2013 )
// Library name: gsclib045_hvt
// Cell name: ACHCONX2
// View name: extracted

simulator lang=spectre

subckt ACHCONX2 A B CI CON VDD VSS
mp11_1__rcx (\20\:n13 \3\:B VDD VDD) g45p1hvt w=(3.85e-07) l=4.5e-08 \
        nf=1 as=1.182e-13 ad=9.19e-14 ps=1.855e-06 pd=1.33e-06 nrd=1.16667 \
        nrs=1.16667 sa=9.02727e-07 sb=3.93701e-07 sd=160n sca=30.7686 \
        scb=0.0203743 scc=0.00340396 m=(2)
mp6_1__rcx (\13\:n15 \1\:A VDD VDD) g45p1hvt w=(3.85e-07) l=4.5e-08 nf=1 \
        as=1.1355e-13 ad=6.16e-14 ps=1.86e-06 pd=1.09e-06 nrd=1.16667 \
        nrs=1.16667 sa=1.7e-07 sb=1.10695e-06 sd=160n sca=41.5694 \
        scb=0.0360757 scc=0.00426513 m=(2)
mp10 (net0370 \1\:CI \1\:VDD VDD) g45p1hvt w=(3.85e-07) l=4.5e-08 nf=1 \
        as=8.345e-14 ad=6.16e-14 ps=1.41e-06 pd=1.09e-06 nrd=1.16667 \
        nrs=1.16667 sa=1.7e-07 sb=3.75e-07 sd=160n sca=13.8213 \
        scb=0.011888 scc=0.000231499 m=(2)
mp9_1__rcx (\8\:n12 n10 \8\:CON VDD) g45p1hvt w=(3.85e-07) l=4.5e-08 nf=1 \
        as=5.775e-14 ad=6.16e-14 ps=1.07e-06 pd=1.09e-06 nrd=1.16667 \
        nrs=1.16667 sa=1.4e-07 sb=8.45e-07 sd=160n sca=15.5058 \
        scb=0.0140133 scc=0.00103524 m=(2)
mp7_1__rcx (\6\:n12 \23\:B \7\:VDD VDD) g45p1hvt w=(3.85e-07) l=4.5e-08 \
        nf=1 as=1.0265e-13 ad=9.13e-14 ps=1.73e-06 pd=1.32e-06 nrd=1.16667 \
        nrs=1.16667 sa=1.7e-07 sb=4.35e-07 sd=160n sca=21.496 \
        scb=0.0176393 scc=0.00214786 m=(2)
mp8_1__rcx (\4\:net0370 n9 \8\:CON VDD) g45p1hvt w=(3.85e-07) l=4.5e-08 \
        nf=1 as=6.353e-14 ad=8.47e-14 ps=1.1e-06 pd=1.21e-06 nrd=1.16667 \
        nrs=1.16667 sa=5.5e-07 sb=4.35e-07 sd=160n sca=15.5058 \
        scb=0.0140133 scc=0.00103524 m=(2)
mp3 (\11\:n9 \1\:B \22\:n15 VDD) g45p1hvt w=(3.85e-07) l=4.5e-08 nf=1 \
        as=5.775e-14 ad=6.737e-14 ps=1.07e-06 pd=1.12e-06 nrd=1.16667 \
        nrs=1.16667 sa=1.4e-07 sb=8.3e-07 sd=160n sca=15.5058 \
        scb=0.0140133 scc=0.00103524 m=(2)
mp2_1__rcx (\22\:n15 \4\:n13 \12\:n10 VDD) g45p1hvt w=(3.85e-07) \
        l=4.5e-08 nf=1 as=9.73e-14 ad=5.775e-14 ps=1.42e-06 pd=1.07e-06 \
        nrd=1.16667 nrs=1.16667 sa=5.65e-07 sb=4.05e-07 sd=160n \
        sca=15.5058 scb=0.0140133 scc=0.00103524 m=(2)
C1 (CON VSS) capacitor c=5.72431e-17
C2 (B VSS) capacitor c=3.843e-17
C3 (VDD VSS) capacitor c=6.10679e-16
C4 (CI VSS) capacitor c=2.84387e-17
C5 (n15 VSS) capacitor c=1.12385e-16
C6 (n11 VSS) capacitor c=2.8316e-16
C7 (n13 VSS) capacitor c=6.91692e-17
C8 (n9 VSS) capacitor c=1.29719e-16
C9 (n10 VSS) capacitor c=1.12045e-16
C10 (n12 VSS) capacitor c=1.12216e-16
C11 (net0370 VSS) capacitor c=2.78258e-17
C12 (\1\:CI VSS) capacitor c=1.18556e-16
C13 (\23\:B VSS) capacitor c=1.6904e-16
C14 (\13\:n13 VSS) capacitor c=1.58783e-16
C15 (\16\:B VSS) capacitor c=1.43921e-16
C16 (\1\:B VSS) capacitor c=1.07439e-16
C17 (\1\:A VSS) capacitor c=1.18331e-16
C18 (\4\:n10 VSS) capacitor c=1.02541e-16
C19 (\20\:B VSS) capacitor c=9.11674e-17
C20 (\10\:B VSS) capacitor c=8.21312e-17
C21 (\6\:n10 VSS) capacitor c=3.73557e-17
C22 (\5\:n9 VSS) capacitor c=3.06097e-17
C23 (\22\:B VSS) capacitor c=1.91751e-17
C24 (\15\:n13 VSS) capacitor c=3.79321e-17
C25 (\3\:n13 VSS) capacitor c=4.52832e-17
C26 (\14\:B VSS) capacitor c=2.88565e-17
C27 (\13\:B VSS) capacitor c=4.42683e-17
C28 (\8\:n13 VSS) capacitor c=1.68756e-17
C29 (\3\:B VSS) capacitor c=1.62813e-16
C30 (\4\:n15 VSS) capacitor c=1.24255e-17
C31 (\4\:A VSS) capacitor c=1.12583e-17
C32 (\1\:VDD VSS) capacitor c=3.61319e-17
C33 (\4\:net0370 VSS) capacitor c=6.23161e-17
C34 (\8\:n12 VSS) capacitor c=9.32851e-17
C35 (\6\:n12 VSS) capacitor c=1.2429e-16
C36 (\9\:n9 VSS) capacitor c=3.28432e-16
C37 (\8\:n11 VSS) capacitor c=6.19325e-16
C38 (\10\:n10 VSS) capacitor c=3.03466e-16
C39 (\12\:n10 VSS) capacitor c=1.50238e-16
C40 (\11\:n9 VSS) capacitor c=3.05601e-16
C41 (\22\:n15 VSS) capacitor c=3.57088e-16
C42 (\20\:n13 VSS) capacitor c=7.37296e-17
C43 (\15\:n11 VSS) capacitor c=2.47183e-16
C44 (\13\:n15 VSS) capacitor c=5.18732e-17
C45 (\3\:VDD VSS) capacitor c=1.64082e-16
C46 (\9\:net0370 VSS) capacitor c=3.17373e-17
C47 (\1\:CON VSS) capacitor c=2.30438e-16
C48 (\7\:net0370 VSS) capacitor c=6.04549e-17
C49 (\4\:n12 VSS) capacitor c=5.78564e-17
C50 (\16\:n9 VSS) capacitor c=1.91224e-16
C51 (\16\:n10 VSS) capacitor c=1.13233e-16
C52 (\15\:n15 VSS) capacitor c=2.7574e-16
C53 (\14\:n10 VSS) capacitor c=1.23313e-16
C54 (\13\:n9 VSS) capacitor c=1.04283e-16
C55 (\18\:n13 VSS) capacitor c=8.53368e-17
C56 (\17\:n11 VSS) capacitor c=4.15241e-17
C57 (\11\:n15 VSS) capacitor c=1.43326e-17
C58 (\4\:n13 VSS) capacitor c=1.72058e-16
C59 (\6\:n13 VSS) capacitor c=1.12499e-16
C60 (\8\:A VSS) capacitor c=4.33572e-17
C61 (\10\:A VSS) capacitor c=2.07527e-17
C62 (\11\:A VSS) capacitor c=2.10568e-17
C63 (\9\:n15 VSS) capacitor c=2.19965e-17
C64 (\10\:n15 VSS) capacitor c=3.77943e-17
C65 (\3\:n9 VSS) capacitor c=1.26238e-16
C66 (\29\:B VSS) capacitor c=4.36218e-17
C67 (\17\:n13 VSS) capacitor c=5.59663e-17
C68 (\30\:B VSS) capacitor c=7.24595e-17
C69 (\31\:B VSS) capacitor c=6.58457e-17
C70 (\21\:n15 VSS) capacitor c=1.5816e-16
C71 (\24\:n15 VSS) capacitor c=1.97525e-17
C72 (\32\:B VSS) capacitor c=9.10088e-17
C73 (\33\:B VSS) capacitor c=8.88495e-17
C74 (\22\:n13 VSS) capacitor c=8.61267e-17
C75 (\23\:n13 VSS) capacitor c=7.75637e-17
C76 (\34\:B VSS) capacitor c=6.86317e-17
C77 (\35\:B VSS) capacitor c=5.60193e-17
C78 (\15\:n9 VSS) capacitor c=1.40901e-16
C79 (\3\:n12 VSS) capacitor c=9.76193e-17
C80 (\8\:n10 VSS) capacitor c=7.3032e-17
C81 (\9\:n10 VSS) capacitor c=2.39319e-16
C82 (\8\:CON VSS) capacitor c=2.06533e-16
C83 (\3\:net0370 VSS) capacitor c=7.44982e-17
C84 (\6\:net0370 VSS) capacitor c=6.30808e-17
C85 (\7\:CI VSS) capacitor c=5.10125e-17
C86 (\7\:VDD VSS) capacitor c=8.47997e-17
Rk47 (\1\:CON CON) resistor r=0.3565 c=0
Rk48 (CON \8\:CON) resistor r=0.1487 c=0
Rk9 (B \29\:B) resistor r=0.02495 c=0
Rk12 (\30\:B \31\:B) resistor r=0.3431 c=0
Rk20 (\32\:B \33\:B) resistor r=0.5279 c=0
Rk32 (\34\:B \35\:B) resistor r=0.3668 c=0
Rk1 (\8\:A \9\:A) resistor r=0.004315 c=0
Rk2 (A \10\:A) resistor r=0.002981 c=0
Rk3 (\8\:A \10\:A) resistor r=0.131 c=0
Rk4 (A \11\:A) resistor r=0.004237 c=0
Rk5 (\10\:A \11\:A) resistor r=0.003925 c=0
Rk80 (\1\:VSS \6\:VSS) resistor r=0.395 c=0
Rk81 (\6\:VSS \7\:VSS) resistor r=0.3875 c=0
Rk84 (\9\:VSS VSS) resistor r=0.9441 c=0
Rk83 (\7\:VSS \9\:VSS) resistor r=0.548 c=0
Rk63 (\1\:VDD \6\:VDD) resistor r=0.396 c=0
Rk64 (\6\:VDD \7\:VDD) resistor r=0.3875 c=0
Rk67 (\9\:VDD VDD) resistor r=0.9441 c=0
Rk66 (\7\:VDD \9\:VDD) resistor r=0.548 c=0
Rk58 (\7\:CI CI) resistor r=0.03134 c=0
Rk57 (\6\:CI \7\:CI) resistor r=0.001404 c=0
Rk6 (\9\:n15 \10\:n15) resistor r=0.1936 c=0
Rk7 (\10\:n15 \12\:n15) resistor r=0.14 c=0
Rk8 (\10\:n15 \14\:n15) resistor r=0.2545 c=0
Rk16 (\21\:n15 \22\:n15) resistor r=0.9409 c=0
Rk15 (\15\:n15 \21\:n15) resistor r=0.8016 c=0
Rk17 (\21\:n15 \24\:n15) resistor r=0.1413 c=0
Rk27 (n11 \9\:n11) resistor r=0.584 c=0
Rk30 (\8\:n11 \16\:n11) resistor r=2.0288 c=0
Rk31 (\16\:n11 \18\:n11) resistor r=0.2864 c=0
Rk10 (\17\:n13 \19\:n13) resistor r=0.3752 c=0
Rk11 (\19\:n13 \21\:n13) resistor r=0.359 c=0
Rk21 (\22\:n13 \23\:n13) resistor r=0.4623 c=0
Rk22 (\10\:n9 \12\:n9) resistor r=1.6127 c=0
Rk23 (\12\:n9 \14\:n9) resistor r=0.7132 c=0
Rk33 (\15\:n9 \17\:n9) resistor r=1.0916 c=0
Rk34 (\17\:n9 \18\:n9) resistor r=0.369 c=0
Rk39 (\8\:n10 \9\:n10) resistor r=0.307 c=0
Rk40 (\9\:n10 \11\:n10) resistor r=1.6899 c=0
Rk41 (\11\:n10 \13\:n10) resistor r=0.7903 c=0
Rk42 (\13\:n10 \15\:n10) resistor r=0.3355 c=0
Rk43 (\15\:n10 \17\:n10) resistor r=0.5938 c=0
Rk35 (\2\:n12 \3\:n12) resistor r=0.678 c=0
Rk36 (\3\:n12 \5\:n12) resistor r=0.2445 c=0
Rk37 (\3\:n12 \7\:n12) resistor r=0.1129 c=0
Rk38 (\9\:n12 \10\:n12) resistor r=0.6006 c=0
Rk52 (\2\:net0370 \3\:net0370) resistor r=0.218 c=0
Rk53 (\3\:net0370 \5\:net0370) resistor r=0.3714 c=0
Rk54 (\3\:net0370 \6\:net0370) resistor r=0.3912 c=0
Rk55 (\6\:net0370 \8\:net0370) resistor r=0.2749 c=0
Rk56 (\6\:net0370 \10\:net0370) resistor r=0.2546 c=0
Rl44 (\16\:B \20\:B) resistor r=277.645 c=0
Rl46 (\22\:B \20\:B) resistor r=33.8482 c=0
Rl25 (\14\:B \10\:B) resistor r=19.1561 c=0
Rl24 (\13\:B \10\:B) resistor r=16.4898 c=0
Rl15 (\3\:B \1\:B) resistor r=194.964 c=0
Rl3 (\1\:A \4\:A) resistor r=4.3693 c=0
Rl11 (n15 \6\:n15) resistor r=2.9484 c=0
Rl9 (n15 \4\:n15) resistor r=4.8851 c=0
Rl39 (\13\:n13 \15\:n13) resistor r=28.1587 c=0
Rl28 (\3\:n13 n13) resistor r=33.8482 c=0
Rl29 (\4\:n13 \3\:n13) resistor r=194.748 c=0
Rl33 (\6\:n13 \8\:n13) resistor r=13.7341 c=0
Rl31 (\6\:n13 \4\:n13) resistor r=154.981 c=0
Rl55 (\3\:n9 n9) resistor r=156.469 c=0
Rl57 (\3\:n9 \5\:n9) resistor r=101.848 c=0
Rl62 (\6\:n10 \4\:n10) resistor r=15.3298 c=0
Rz24 (VDD \3\:VDD) resistor r=6.25 c=0
Rz21 (\1\:VDD \3\:VDD) resistor r=75 c=0
Rz22 (\6\:VDD \3\:VDD) resistor r=6.25 c=0
Rz23 (\9\:VDD \3\:VDD) resistor r=6.25 c=0
Rz1 (\12\:n15 \11\:n15) resistor r=75 c=0
Rz10 (\18\:n11 \17\:n11) resistor r=75 c=0
Rz2 (\19\:n13 \18\:n13) resistor r=75 c=0
Rz6 (\14\:n9 \13\:n9) resistor r=75 c=0
Rz11 (\17\:n9 \16\:n9) resistor r=75 c=0
Rz14 (\15\:n10 \14\:n10) resistor r=75 c=0
Rz15 (\17\:n10 \16\:n10) resistor r=75 c=0
Rz12 (\2\:n12 n12) resistor r=75 c=0
Rz13 (\5\:n12 \4\:n12) resistor r=75 c=0
Rz19 (\8\:net0370 \7\:net0370) resistor r=75 c=0
Rz20 (\10\:net0370 \9\:net0370) resistor r=75 c=0
Ry35 (VSS \3\:VSS) resistor r=5.1667 c=0
Ry32 (\1\:VSS \3\:VSS) resistor r=62 c=0
Ry33 (\6\:VSS \3\:VSS) resistor r=5.1667 c=0
Ry34 (\9\:VSS \3\:VSS) resistor r=5.1667 c=0
Ry1 (\14\:n15 \13\:n15) resistor r=20.6667 c=0
Ry8 (\9\:n11 \8\:n11) resistor r=62 c=0
Ry12 (\16\:n11 \15\:n11) resistor r=31 c=0
Ry2 (\21\:n13 \20\:n13) resistor r=62 c=0
Ry6 (\10\:n9 \9\:n9) resistor r=62 c=0
Ry7 (\12\:n9 \11\:n9) resistor r=62 c=0
Ry13 (\18\:n9 \9\:n9) resistor r=62 c=0
Ry17 (\11\:n10 \10\:n10) resistor r=62 c=0
Ry18 (\13\:n10 \12\:n10) resistor r=62 c=0
Ry14 (\7\:n12 \6\:n12) resistor r=62 c=0
Ry15 (\9\:n12 \8\:n12) resistor r=62 c=0
Ry16 (\10\:n12 \6\:n12) resistor r=62 c=0
Ry22 (\2\:net0370 net0370) resistor r=62 c=0
Ry23 (\5\:net0370 \4\:net0370) resistor r=62 c=0
Rx3 (\29\:B \3\:B) resistor r=45 c=0
Rx5 (\30\:B \13\:B) resistor r=45 c=0
Rx6 (\31\:B \1\:B) resistor r=45 c=0
Rx8 (\32\:B \14\:B) resistor r=45 c=0
Rx9 (\33\:B \16\:B) resistor r=45 c=0
Rx12 (\34\:B \23\:B) resistor r=22.5 c=0
Rx13 (\35\:B \22\:B) resistor r=45 c=0
Rx1 (\9\:A \4\:A) resistor r=45 c=0
Rx17 (\6\:CI \1\:CI) resistor r=22.5 c=0
Rx2 (\9\:n15 \4\:n15) resistor r=45 c=0
Rx7 (\24\:n15 \6\:n15) resistor r=45 c=0
Rx4 (\17\:n13 \8\:n13) resistor r=45 c=0
Rx10 (\22\:n13 \3\:n13) resistor r=45 c=0
Rx11 (\23\:n13 \15\:n13) resistor r=45 c=0
Rx14 (\15\:n9 \5\:n9) resistor r=45 c=0
Rx15 (\8\:n10 \6\:n10) resistor r=45 c=0
Rx16 (\9\:n10 n10) resistor r=45 c=0
mn11_1__rcx (\18\:n13 \3\:B VSS VSS) g45n1hvt w=(1.95e-07) l=4.5e-08 \
        nf=1 as=9.151e-14 ad=4.29e-14 ps=1.635e-06 pd=8.3e-07 nrd=1.16667 \
        nrs=1.16667 sa=1.04987e-06 sb=4.35e-07 sd=160n sca=20.3563 \
        scb=0.0203131 scc=0.00210921 m=(2)
mn6_1__rcx (\11\:n15 \1\:A VSS VSS) g45n1hvt w=(1.95e-07) l=4.5e-08 nf=1 \
        as=8.343e-14 ad=3.12e-14 ps=1.56e-06 pd=7.1e-07 nrd=1.16667 \
        nrs=1.16667 sa=1.7e-07 sb=1.28513e-06 sd=160n sca=20.3563 \
        scb=0.0203131 scc=0.00210921 m=(2)
mn7_1__rcx (\4\:n12 \23\:B \7\:VSS VSS) g45n1hvt w=(1.95e-07) l=4.5e-08 \
        nf=1 as=6.255e-14 ad=4.29e-14 ps=1.22e-06 pd=8.3e-07 nrd=1.16667 \
        nrs=1.16667 sa=1.7e-07 sb=4.35e-07 sd=160n sca=9.4847 \
        scb=0.00814735 scc=0.000215444 m=(2)
mn10_1__rcx (\9\:net0370 \1\:CI \1\:VSS VSS) g45n1hvt w=(1.95e-07) \
        l=4.5e-08 nf=1 as=7.635e-14 ad=3.12e-14 ps=1.45e-06 pd=7.1e-07 \
        nrd=1.16667 nrs=1.16667 sa=1.7e-07 sb=3.75e-07 sd=160n sca=16.9754 \
        scb=0.0175701 scc=0.00143458 m=(2)
mn9_1__rcx (n12 \3\:n9 \1\:CON VSS) g45n1hvt w=(1.95e-07) l=4.5e-08 nf=1 \
        as=4.522e-14 ad=4.59e-14 ps=9e-07 pd=8.8e-07 nrd=1.16667 \
        nrs=1.16667 sa=1.7e-07 sb=1.03e-06 sd=160n sca=10.7156 \
        scb=0.0100774 scc=0.000358522 m=(2)
mn3 (\13\:n9 \6\:n13 \15\:n15 VSS) g45n1hvt w=(1.95e-07) l=4.5e-08 nf=1 \
        as=3.982e-14 ad=4.95e-14 ps=8.1e-07 pd=9.4e-07 nrd=1.16667 \
        nrs=1.16667 sa=1.7e-07 sb=9.65e-07 sd=160n sca=7.87233 \
        scb=0.00543612 scc=8.31178e-05 m=(2)
mn2 (\15\:n15 \10\:B \14\:n10 VSS) g45n1hvt w=(1.95e-07) l=4.5e-08 nf=1 \
        as=4.95e-14 ad=4.163e-14 ps=9.4e-07 pd=8.4e-07 nrd=1.16667 \
        nrs=1.16667 sa=7e-07 sb=4.35e-07 sd=160n sca=7.87233 \
        scb=0.00543612 scc=8.31178e-05 m=(2)
mn8 (\7\:net0370 \4\:n10 \1\:CON VSS) g45n1hvt w=(1.95e-07) l=4.5e-08 \
        nf=1 as=4.522e-14 ad=6.217e-14 ps=9e-07 pd=1.07e-06 nrd=1.16667 \
        nrs=1.16667 sa=7e-07 sb=5e-07 sd=160n sca=10.7156 scb=0.0100774 \
        scc=0.000358522 m=(2)
mn5_1__rcx (\17\:n11 n15 VSS VSS) g45n1hvt w=(1.55e-07) l=4.5e-08 nf=1 \
        as=9.539e-14 ad=3.41e-14 ps=1.685e-06 pd=7.5e-07 nrd=1.16667 \
        nrs=1.16667 sa=6.4e-07 sb=1.05e-06 sd=160n sca=22.6209 \
        scb=0.0224923 scc=0.0025451 m=(2)
mn4 (n11 \20\:B \16\:n9 VSS) g45n1hvt w=(1.55e-07) l=4.5e-08 nf=1 \
        as=3.71e-14 ad=5.772e-14 ps=8e-07 pd=1.1e-06 nrd=1.16667 \
        nrs=1.16667 sa=9e-07 sb=4.35e-07 sd=160n sca=9.18993 \
        scb=0.00765118 scc=0.000170292 m=(2)
mn1_1__rcx (\16\:n10 n13 n11 VSS) g45n1hvt w=(1.55e-07) l=4.5e-08 nf=1 \
        as=5.772e-14 ad=3.71e-14 ps=1.1e-06 pd=8e-07 nrd=1.16667 \
        nrs=1.16667 sa=1.7e-07 sb=1.165e-06 sd=160n sca=9.18993 \
        scb=0.00765118 scc=0.000170292 m=(2)
mp5 (\15\:n11 n15 VDD VDD) g45p1hvt w=(2.6e-07) l=4.5e-08 nf=1 \
        as=1.283e-13 ad=6.24e-14 ps=1.965e-06 pd=1e-06 nrd=1.16667 \
        nrs=1.16667 sa=6.4e-07 sb=9.88846e-07 sd=160n sca=41.048 \
        scb=0.0261997 scc=0.00496428 m=(2)
mp4_1__rcx (\8\:n11 \13\:n13 \9\:n9 VDD) g45p1hvt w=(2.6e-07) l=4.5e-08 \
        nf=1 as=1.035e-13 ad=8.07e-14 ps=1.51e-06 pd=1.41e-06 nrd=1.16667 \
        nrs=1.16667 sa=5.87885e-07 sb=5.3e-07 sd=160n sca=12.7937 \
        scb=0.0116617 scc=0.000458138 m=(2)
mp1 (\10\:n10 \16\:B \8\:n11 VDD) g45p1hvt w=(2.6e-07) l=4.5e-08 nf=1 \
        as=8.4e-14 ad=5.72e-14 ps=1.465e-06 pd=9.6e-07 nrd=1.16667 \
        nrs=1.16667 sa=1.7e-07 sb=9.27788e-07 sd=160n sca=16.2062 \
        scb=0.015669 scc=0.00110578 m=(2)
ends ACHCONX2
// End of subcircuit definition.
