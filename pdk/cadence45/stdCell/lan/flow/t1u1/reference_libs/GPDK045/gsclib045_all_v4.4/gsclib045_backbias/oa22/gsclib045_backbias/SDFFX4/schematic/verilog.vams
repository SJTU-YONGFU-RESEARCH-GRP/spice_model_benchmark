// Verilog-AMS netlist generated by the AMS netlister, version  ICADV12.1-64b.341 .
// Cadence Design Systems, Inc.

`include "disciplines.vams"

(* cds_ams_schematic *)
module SDFFX4 ( SI,QN,.VDD(\VDD! ),CK,D,.NW(
\NW! ),Q,.VSS(\VSS! ),SE );

input   SI;
output   QN;
input  (*
integer inh_conn_prop_name
 = "VDD";
integer inh_conn_def_value = "cds_globals.\\VDD! ";
 *)

 \VDD! ;
input   CK;
input   D;
input  (*
integer inh_conn_prop_name
 = "NW";
integer inh_conn_def_value = "cds_globals.\\NW! ";
integer
supplySensitivity = "VDD";
 *)
 \NW! ;
output   Q;
input  (*
integer
inh_conn_prop_name = "VSS";
integer inh_conn_def_value
 = "cds_globals.\\VSS! ";
 *)
 \VSS! ;
input   SE;

wire SI;
wire QN;
wire (*
integer inh_conn_prop_name = "VSS";
integer inh_conn_def_value
 = "cds_globals.\\VSS! ";
 *)
\VSS! ;
wire n30;
wire qbint;
wire CK;
wire CKb;
wire CKbb;
wire net392;
wire net376;
wire D;
wire net449;
wire Db;
wire n20;
wire mout;
wire Q;
wire net384;
wire SE;
wire (*
integer inh_conn_prop_name = "VDD";
integer inh_conn_def_value
 = "cds_globals.\\VDD! ";
 *)
\VDD! ;
wire net367;
wire SEb;

g45n1svt #(.ad(20.3f), .nrd(965.517m), .sca(203.41795), .pd(570n), .scc(0.02523),
 .scb(0.11509), .as(20.3f), .nrs(965.517m), .m(1), .ps(570n), .w(145n),
 .sa(140n), .nf(1), .sb(140n), .sd(160n), .l(45n)) (*
integer
library_binding = "gpdk045";
integer passed_mfactor = "m";
 *)
mn13 (
net461, SI, \VSS! , \VSS!  );
g45n1svt #(.ad(20.3f), .nrd(965.517m), .sca(203.41795), .pd(570n), .scc(0.02523),
 .scb(0.11509), .as(20.3f), .nrs(965.517m), .m(1), .ps(570n), .w(145n),
 .sa(140n), .nf(1), .sb(140n), .sd(160n), .l(45n)) (*
integer
library_binding = "gpdk045";
integer passed_mfactor = "m";
 *)
mn14 (
Db, SE, net461, \VSS!  );
g45n1svt #(.ad(20.3f), .nrd(965.517m), .sca(203.41795), .pd(570n), .scc(0.02523),
 .scb(0.11509), .as(20.3f), .nrs(965.517m), .m(1), .ps(570n), .w(145n),
 .sa(140n), .nf(1), .sb(140n), .sd(160n), .l(45n)) (*
integer
library_binding = "gpdk045";
integer passed_mfactor = "m";
 *)
mn12 (
Db, SEb, net449, \VSS!  );
g45n1svt #(.ad(20.3f), .nrd(965.517m), .sca(203.41795), .pd(570n), .scc(0.02523),
 .scb(0.11509), .as(20.3f), .nrs(965.517m), .m(1), .ps(570n), .w(145n),
 .sa(140n), .nf(1), .sb(140n), .sd(160n), .l(45n)) (*
integer
library_binding = "gpdk045";
integer passed_mfactor = "m";
 *)
mn11 (
net449, D, \VSS! , \VSS!  );
g45n1svt #(.ad(145.6f), .nrd(134.615m), .sca(71.11936), .pd(2.36u), .scc(0.00848),
 .scb(0.06501), .as(145.6f), .nrs(134.615m), .m(1), .ps(2.36u), .w(1.04u),
 .sa(140n), .nf(1), .sb(140n), .sd(160n), .l(45n)) (*
integer
library_binding = "gpdk045";
integer passed_mfactor = "m";
 *)
mn57 (
QN, net367, \VSS! , \VSS!  );
g45n1svt #(.ad(145.6f), .nrd(134.615m), .sca(71.11936), .pd(2.36u), .scc(0.00848),
 .scb(0.06501), .as(145.6f), .nrs(134.615m), .m(1), .ps(2.36u), .w(1.04u),
 .sa(140n), .nf(1), .sb(140n), .sd(160n), .l(45n)) (*
integer
library_binding = "gpdk045";
integer passed_mfactor = "m";
 *)
mn55 (
Q, qbint, \VSS! , \VSS!  );
g45n1svt #(.ad(20.3f), .nrd(965.517m), .sca(203.41795), .pd(570n), .scc(0.02523),
 .scb(0.11509), .as(20.3f), .nrs(965.517m), .m(1), .ps(570n), .w(145n),
 .sa(140n), .nf(1), .sb(140n), .sd(160n), .l(45n)) (*
integer
library_binding = "gpdk045";
integer passed_mfactor = "m";
 *)
mn50 (
net436, qbint, \VSS! , \VSS!  );
g45n1svt #(.ad(20.3f), .nrd(965.517m), .sca(203.41795), .pd(570n), .scc(0.02523),
 .scb(0.11509), .as(20.3f), .nrs(965.517m), .m(1), .ps(570n), .w(145n),
 .sa(140n), .nf(1), .sb(140n), .sd(160n), .l(45n)) (*
integer
library_binding = "gpdk045";
integer passed_mfactor = "m";
 *)
mn51 (
n30, CKb, net436, \VSS!  );
g45n1svt #(.ad(20.3f), .nrd(965.517m), .sca(203.41795), .pd(570n), .scc(0.02523),
 .scb(0.11509), .as(20.3f), .nrs(965.517m), .m(1), .ps(570n), .w(145n),
 .sa(140n), .nf(1), .sb(140n), .sd(160n), .l(45n)) (*
integer
library_binding = "gpdk045";
integer passed_mfactor = "m";
 *)
mn35 (
net429, mout, \VSS! , \VSS!  );
g45n1svt #(.ad(20.3f), .nrd(965.517m), .sca(203.41795), .pd(570n), .scc(0.02523),
 .scb(0.11509), .as(20.3f), .nrs(965.517m), .m(1), .ps(570n), .w(145n),
 .sa(140n), .nf(1), .sb(140n), .sd(160n), .l(45n)) (*
integer
library_binding = "gpdk045";
integer passed_mfactor = "m";
 *)
mn36 (
n20, CKbb, net429, \VSS!  );
g45n1svt #(.ad(20.3f), .nrd(965.517m), .sca(203.41795), .pd(570n), .scc(0.02523),
 .scb(0.11509), .as(20.3f), .nrs(965.517m), .m(1), .ps(570n), .w(145n),
 .sa(140n), .nf(1), .sb(140n), .sd(160n), .l(45n)) (*
integer
library_binding = "gpdk045";
integer passed_mfactor = "m";
 *)
mn20 (
CKb, CK, \VSS! , \VSS!  );
g45n1svt #(.ad(57.4f), .nrd(341.463m), .sca(111.73831), .pd(1.1u), .scc(0.01336),
 .scb(0.08844), .as(57.4f), .nrs(341.463m), .m(1), .ps(1.1u), .w(410n),
 .sa(140n), .nf(1), .sb(140n), .sd(160n), .l(45n)) (*
integer
library_binding = "gpdk045";
integer passed_mfactor = "m";
 *)
mn45 (
qbint, n30, \VSS! , \VSS!  );
g45n1svt #(.ad(36.4f), .nrd(538.462m), .sca(144.98299), .pd(800n), .scc(0.01780),
 .scb(0.10251), .as(36.4f), .nrs(538.462m), .m(1), .ps(800n), .w(260n),
 .sa(140n), .nf(1), .sb(140n), .sd(160n), .l(45n)) (*
integer
library_binding = "gpdk045";
integer passed_mfactor = "m";
 *)
mn56 (
net367, qbint, \VSS! , \VSS!  );
g45n1svt #(.ad(20.3f), .nrd(965.517m), .sca(203.41795), .pd(570n), .scc(0.02523),
 .scb(0.11509), .as(20.3f), .nrs(965.517m), .m(1), .ps(570n), .w(145n),
 .sa(140n), .nf(1), .sb(140n), .sd(160n), .l(45n)) (*
integer
library_binding = "gpdk045";
integer passed_mfactor = "m";
 *)
mn21 (
CKbb, CKb, \VSS! , \VSS!  );
g45n1svt #(.ad(20.3f), .nrd(965.517m), .sca(203.41795), .pd(570n), .scc(0.02523),
 .scb(0.11509), .as(20.3f), .nrs(965.517m), .m(1), .ps(570n), .w(145n),
 .sa(140n), .nf(1), .sb(140n), .sd(160n), .l(45n)) (*
integer
library_binding = "gpdk045";
integer passed_mfactor = "m";
 *)
mn40 (
n30, CKbb, mout, \VSS!  );
g45n1svt #(.ad(20.3f), .nrd(965.517m), .sca(203.41795), .pd(570n), .scc(0.02523),
 .scb(0.11509), .as(20.3f), .nrs(965.517m), .m(1), .ps(570n), .w(145n),
 .sa(140n), .nf(1), .sb(140n), .sd(160n), .l(45n)) (*
integer
library_binding = "gpdk045";
integer passed_mfactor = "m";
 *)
mn30 (
mout, n20, \VSS! , \VSS!  );
g45n1svt #(.ad(20.3f), .nrd(965.517m), .sca(203.41795), .pd(570n), .scc(0.02523),
 .scb(0.11509), .as(20.3f), .nrs(965.517m), .m(1), .ps(570n), .w(145n),
 .sa(140n), .nf(1), .sb(140n), .sd(160n), .l(45n)) (*
integer
library_binding = "gpdk045";
integer passed_mfactor = "m";
 *)
mn10 (
SEb, SE, \VSS! , \VSS!  );
g45n1svt #(.ad(20.3f), .nrd(965.517m), .sca(203.41795), .pd(570n), .scc(0.02523),
 .scb(0.11509), .as(20.3f), .nrs(965.517m), .m(1), .ps(570n), .w(145n),
 .sa(140n), .nf(1), .sb(140n), .sd(160n), .l(45n)) (*
integer
library_binding = "gpdk045";
integer passed_mfactor = "m";
 *)
mn25 (
n20, CKb, Db, \VSS!  );

g45p1svt #(.ad(30.1f), .nrd(651.163m), .sca(162.02845), .pd(710n), .scc(0.02009),
 .scb(0.10751), .as(30.1f), .nrs(651.163m), .m(1), .ps(710n), .w(215n),
 .sa(140n), .nf(1), .sb(140n), .sd(160n), .l(45n)) (*
integer
library_binding = "gpdk045";
integer passed_mfactor = "m";
 *)
mp14 (
Db, SEb, net392, \NW!  );
g45p1svt #(.ad(30.1f), .nrd(651.163m), .sca(162.02845), .pd(710n), .scc(0.02009),
 .scb(0.10751), .as(30.1f), .nrs(651.163m), .m(1), .ps(710n), .w(215n),
 .sa(140n), .nf(1), .sb(140n), .sd(160n), .l(45n)) (*
integer
library_binding = "gpdk045";
integer passed_mfactor = "m";
 *)
mp13 (
net392, SI, \VDD! , \NW!  );
g45p1svt #(.ad(30.1f), .nrd(651.163m), .sca(162.02845), .pd(710n), .scc(0.02009),
 .scb(0.10751), .as(30.1f), .nrs(651.163m), .m(1), .ps(710n), .w(215n),
 .sa(140n), .nf(1), .sb(140n), .sd(160n), .l(45n)) (*
integer
library_binding = "gpdk045";
integer passed_mfactor = "m";
 *)
mp12 (
Db, SE, net384, \NW!  );
g45p1svt #(.ad(30.1f), .nrd(651.163m), .sca(162.02845), .pd(710n), .scc(0.02009),
 .scb(0.10751), .as(30.1f), .nrs(651.163m), .m(1), .ps(710n), .w(215n),
 .sa(140n), .nf(1), .sb(140n), .sd(160n), .l(45n)) (*
integer
library_binding = "gpdk045";
integer passed_mfactor = "m";
 *)
mp11 (
net384, D, \VDD! , \NW!  );
g45p1svt #(.ad(30.1f), .nrd(651.163m), .sca(162.02845), .pd(710n), .scc(0.02009),
 .scb(0.10751), .as(30.1f), .nrs(651.163m), .m(1), .ps(710n), .w(215n),
 .sa(140n), .nf(1), .sb(140n), .sd(160n), .l(45n)) (*
integer
library_binding = "gpdk045";
integer passed_mfactor = "m";
 *)
mp51 (
n30, CKbb, net376, \NW!  );
g45p1svt #(.ad(30.1f), .nrd(651.163m), .sca(162.02845), .pd(710n), .scc(0.02009),
 .scb(0.10751), .as(30.1f), .nrs(651.163m), .m(1), .ps(710n), .w(215n),
 .sa(140n), .nf(1), .sb(140n), .sd(160n), .l(45n)) (*
integer
library_binding = "gpdk045";
integer passed_mfactor = "m";
 *)
mp50 (
net376, qbint, \VDD! , \NW!  );
g45p1svt #(.ad(218.4f), .nrd(89.7436m), .sca(61.39246), .pd(3.4u), .scc(0.00742),
 .scb(0.05939), .as(218.4f), .nrs(89.7436m), .m(1), .ps(3.4u), .w(1.56u),
 .sa(140n), .nf(1), .sb(140n), .sd(160n), .l(45n)) (*
integer
library_binding = "gpdk045";
integer passed_mfactor = "m";
 *)
mp57 (
QN, net367, \VDD! , \NW!  );
g45p1svt #(.ad(218.4f), .nrd(89.7436m), .sca(61.39246), .pd(3.4u), .scc(0.00742),
 .scb(0.05939), .as(218.4f), .nrs(89.7436m), .m(1), .ps(3.4u), .w(1.56u),
 .sa(140n), .nf(1), .sb(140n), .sd(160n), .l(45n)) (*
integer
library_binding = "gpdk045";
integer passed_mfactor = "m";
 *)
mp55 (
Q, qbint, \VDD! , \NW!  );
g45p1svt #(.ad(30.1f), .nrd(651.163m), .sca(162.02845), .pd(710n), .scc(0.02009),
 .scb(0.10751), .as(30.1f), .nrs(651.163m), .m(1), .ps(710n), .w(215n),
 .sa(140n), .nf(1), .sb(140n), .sd(160n), .l(45n)) (*
integer
library_binding = "gpdk045";
integer passed_mfactor = "m";
 *)
mp35 (
net356, mout, \VDD! , \NW!  );
g45p1svt #(.ad(30.1f), .nrd(651.163m), .sca(162.02845), .pd(710n), .scc(0.02009),
 .scb(0.10751), .as(30.1f), .nrs(651.163m), .m(1), .ps(710n), .w(215n),
 .sa(140n), .nf(1), .sb(140n), .sd(160n), .l(45n)) (*
integer
library_binding = "gpdk045";
integer passed_mfactor = "m";
 *)
mp36 (
n20, CKb, net356, \NW!  );
g45p1svt #(.ad(30.1f), .nrd(651.163m), .sca(162.02845), .pd(710n), .scc(0.02009),
 .scb(0.10751), .as(30.1f), .nrs(651.163m), .m(1), .ps(710n), .w(215n),
 .sa(140n), .nf(1), .sb(140n), .sd(160n), .l(45n)) (*
integer
library_binding = "gpdk045";
integer passed_mfactor = "m";
 *)
mp20 (
CKb, CK, \VDD! , \NW!  );
g45p1svt #(.ad(86.8f), .nrd(225.806m), .sca(89.83593), .pd(1.52u), .scc(0.01064),
 .scb(0.07618), .as(86.8f), .nrs(225.806m), .m(1), .ps(1.52u), .w(620n),
 .sa(140n), .nf(1), .sb(140n), .sd(160n), .l(45n)) (*
integer
library_binding = "gpdk045";
integer passed_mfactor = "m";
 *)
mp45 (
qbint, n30, \VDD! , \NW!  );
g45p1svt #(.ad(54.6f), .nrd(358.974m), .sca(114.89040), .pd(1.06u), .scc(0.01377),
 .scb(0.09003), .as(54.6f), .nrs(358.974m), .m(1), .ps(1.06u), .w(390n),
 .sa(140n), .nf(1), .sb(140n), .sd(160n), .l(45n)) (*
integer
library_binding = "gpdk045";
integer passed_mfactor = "m";
 *)
mp56 (
net367, qbint, \VDD! , \NW!  );
g45p1svt #(.ad(30.1f), .nrd(651.163m), .sca(162.02845), .pd(710n), .scc(0.02009),
 .scb(0.10751), .as(30.1f), .nrs(651.163m), .m(1), .ps(710n), .w(215n),
 .sa(140n), .nf(1), .sb(140n), .sd(160n), .l(45n)) (*
integer
library_binding = "gpdk045";
integer passed_mfactor = "m";
 *)
mp21 (
CKbb, CKb, \VDD! , \NW!  );
g45p1svt #(.ad(30.1f), .nrd(651.163m), .sca(162.02845), .pd(710n), .scc(0.02009),
 .scb(0.10751), .as(30.1f), .nrs(651.163m), .m(1), .ps(710n), .w(215n),
 .sa(140n), .nf(1), .sb(140n), .sd(160n), .l(45n)) (*
integer
library_binding = "gpdk045";
integer passed_mfactor = "m";
 *)
mp40 (
n30, CKb, mout, \NW!  );
g45p1svt #(.ad(30.1f), .nrd(651.163m), .sca(162.02845), .pd(710n), .scc(0.02009),
 .scb(0.10751), .as(30.1f), .nrs(651.163m), .m(1), .ps(710n), .w(215n),
 .sa(140n), .nf(1), .sb(140n), .sd(160n), .l(45n)) (*
integer
library_binding = "gpdk045";
integer passed_mfactor = "m";
 *)
mp30 (
mout, n20, \VDD! , \NW!  );
g45p1svt #(.ad(30.1f), .nrd(651.163m), .sca(162.02845), .pd(710n), .scc(0.02009),
 .scb(0.10751), .as(30.1f), .nrs(651.163m), .m(1), .ps(710n), .w(215n),
 .sa(140n), .nf(1), .sb(140n), .sd(160n), .l(45n)) (*
integer
library_binding = "gpdk045";
integer passed_mfactor = "m";
 *)
mp25 (
n20, CKbb, Db, \NW!  );
g45p1svt #(.ad(30.1f), .nrd(651.163m), .sca(162.02845), .pd(710n), .scc(0.02009),
 .scb(0.10751), .as(30.1f), .nrs(651.163m), .m(1), .ps(710n), .w(215n),
 .sa(140n), .nf(1), .sb(140n), .sd(160n), .l(45n)) (*
integer
library_binding = "gpdk045";
integer passed_mfactor = "m";
 *)
mp10 (
SEb, SE, \VDD! , \NW!  );

endmodule
