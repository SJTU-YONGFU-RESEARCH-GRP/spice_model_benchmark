// Generated for: spectre (May  1 09:10:58 2013 )
// Library name: gsclib045_lvt
// Cell name: ADDFX1
// View name: extracted

simulator lang=spectre

subckt ADDFX1 A B CI CO S VDD VSS
mp12 (\1\:CO \4\:COb \16\:VDD VDD) g45p1lvt w=(3.9e-07) l=4.5e-08 nf=1 \
        as=5.615e-14 ad=5.46e-14 ps=1.33e-06 pd=1.06e-06 nrd=1.16667 \
        nrs=1.16667 sa=1.4e-07 sb=1.12821e-07 sd=160n sca=24.8923 \
        scb=0.0283314 scc=0.00161065 m=(1)
mp13 (\1\:S Sb \1\:VDD VDD) g45p1lvt w=(3.9e-07) l=4.5e-08 nf=1 \
        as=6.055e-14 ad=5.46e-14 ps=1.17e-06 pd=1.06e-06 nrd=1.16667 \
        nrs=1.16667 sa=1.15032e-06 sb=1.4e-07 sd=160n sca=26.7686 \
        scb=0.0307018 scc=0.00196241 m=(1)
C1 (A VSS) capacitor c=1.01999e-16
C2 (CO VSS) capacitor c=5.52841e-17
C3 (VDD VSS) capacitor c=2.32048e-16
C4 (B VSS) capacitor c=1.10238e-16
C5 (CI VSS) capacitor c=1.93031e-16
C6 (S VSS) capacitor c=5.97791e-17
C7 (COb VSS) capacitor c=1.31676e-17
C8 (n2 VSS) capacitor c=8.98264e-17
C9 (n4 VSS) capacitor c=7.94254e-17
C10 (Sb VSS) capacitor c=4.62147e-17
C11 (n7 VSS) capacitor c=1.78033e-18
C12 (n6 VSS) capacitor c=1.50273e-18
C13 (n3 VSS) capacitor c=6.36086e-17
C14 (n1 VSS) capacitor c=1.4721e-18
C15 (n5 VSS) capacitor c=6.90334e-17
C16 (\12\:A VSS) capacitor c=9.26743e-17
C17 (\12\:B VSS) capacitor c=9.39089e-17
C18 (\10\:CI VSS) capacitor c=1.07452e-16
C19 (\7\:COb VSS) capacitor c=3.23339e-17
C20 (\9\:A VSS) capacitor c=6.56997e-17
C21 (\7\:B VSS) capacitor c=3.94173e-17
C22 (\5\:CI VSS) capacitor c=6.47935e-17
C23 (\4\:A VSS) capacitor c=6.88815e-17
C24 (\4\:B VSS) capacitor c=5.10292e-17
C25 (\4\:CI VSS) capacitor c=5.65197e-17
C26 (\1\:B VSS) capacitor c=4.08861e-17
C27 (\1\:A VSS) capacitor c=5.19026e-17
C28 (\4\:COb VSS) capacitor c=3.78442e-17
C29 (\3\:Sb VSS) capacitor c=5.04827e-17
C30 (\10\:A VSS) capacitor c=5.8465e-17
C31 (\10\:B VSS) capacitor c=8.65976e-17
C32 (\8\:CI VSS) capacitor c=4.2949e-17
C33 (\5\:COb VSS) capacitor c=6.71707e-17
C34 (\7\:A VSS) capacitor c=3.8526e-17
C35 (\9\:B VSS) capacitor c=6.35541e-17
C36 (\7\:CI VSS) capacitor c=4.17523e-17
C37 (\6\:A VSS) capacitor c=7.57983e-17
C38 (\6\:B VSS) capacitor c=8.59046e-17
C39 (\3\:CI VSS) capacitor c=4.32155e-17
C40 (\3\:B VSS) capacitor c=6.41382e-17
C41 (\3\:A VSS) capacitor c=4.58444e-17
C42 (\3\:COb VSS) capacitor c=3.58924e-17
C43 (\2\:Sb VSS) capacitor c=4.40298e-17
C44 (\11\:A VSS) capacitor c=8.54228e-17
C45 (\11\:B VSS) capacitor c=1.01704e-16
C46 (\9\:CI VSS) capacitor c=8.81238e-17
C47 (\6\:COb VSS) capacitor c=7.7706e-17
C48 (\8\:A VSS) capacitor c=6.18142e-17
C49 (\8\:B VSS) capacitor c=6.55005e-17
C50 (\6\:CI VSS) capacitor c=6.87861e-17
C51 (\5\:A VSS) capacitor c=8.52733e-17
C52 (\5\:B VSS) capacitor c=9.3073e-17
C53 (\1\:CI VSS) capacitor c=3.20724e-17
C54 (\2\:B VSS) capacitor c=7.02887e-17
C55 (\2\:A VSS) capacitor c=5.80913e-17
C56 (\1\:S VSS) capacitor c=3.16251e-17
C57 (\1\:VDD VSS) capacitor c=5.66035e-17
C58 (\7\:Sb VSS) capacitor c=1.08087e-16
C59 (\6\:VDD VSS) capacitor c=1.31301e-17
C60 (\3\:n5 VSS) capacitor c=6.75843e-17
C61 (\9\:VDD VSS) capacitor c=7.59635e-18
C62 (\12\:COb VSS) capacitor c=2.37964e-17
C63 (\13\:VDD VSS) capacitor c=1.30474e-17
C64 (\3\:n3 VSS) capacitor c=5.91025e-17
C65 (\16\:VDD VSS) capacitor c=2.69513e-17
C66 (\1\:CO VSS) capacitor c=3.37004e-17
C67 (\3\:VDD VSS) capacitor c=4.67674e-17
C68 (\3\:S VSS) capacitor c=7.41156e-17
C69 (\4\:Sb VSS) capacitor c=1.28368e-16
C70 (\3\:n4 VSS) capacitor c=8.16894e-17
C71 (\14\:COb VSS) capacitor c=1.52776e-16
C72 (\3\:n2 VSS) capacitor c=9.46317e-17
C73 (\3\:CO VSS) capacitor c=4.54658e-17
C74 (\2\:COb VSS) capacitor c=1.87253e-17
C75 (\2\:CI VSS) capacitor c=4.51448e-17
C76 (\8\:COb VSS) capacitor c=1.80605e-16
C77 (\9\:COb VSS) capacitor c=2.01574e-16
C78 (\10\:COb VSS) capacitor c=1.90789e-16
C79 (\11\:COb VSS) capacitor c=5.10434e-17
C80 (\11\:CI VSS) capacitor c=1.57629e-16
C81 (\13\:CI VSS) capacitor c=7.2765e-17
C82 (\13\:B VSS) capacitor c=1.12492e-16
C83 (\14\:B VSS) capacitor c=1.09444e-16
C84 (\15\:B VSS) capacitor c=1.22764e-16
C85 (\16\:B VSS) capacitor c=6.8853e-17
C86 (\13\:A VSS) capacitor c=1.77265e-16
C87 (\14\:A VSS) capacitor c=9.08879e-17
C88 (\15\:A VSS) capacitor c=1.29404e-16
C89 (\16\:A VSS) capacitor c=1.46182e-16
C90 (\6\:Sb VSS) capacitor c=1.73037e-16
C91 (\5\:VDD VSS) capacitor c=2.2715e-17
C92 (\8\:VDD VSS) capacitor c=6.79515e-18
C93 (\12\:VDD VSS) capacitor c=1.19106e-17
C94 (\15\:VDD VSS) capacitor c=8.18917e-18
Rk20 (\13\:A A) resistor r=0.4796 c=0
Rk19 (\13\:A \14\:A) resistor r=0.7021 c=0
Rk21 (A \15\:A) resistor r=0.2359 c=0
Rk22 (\15\:A \16\:A) resistor r=0.7149 c=0
Rk27 (\2\:VSS \4\:VSS) resistor r=0.2377 c=0
Rk28 (\4\:VSS \5\:VSS) resistor r=0.4323 c=0
Rk29 (\5\:VSS \6\:VSS) resistor r=0.2207 c=0
Rk30 (\6\:VSS \7\:VSS) resistor r=0.1003 c=0
Rk31 (\7\:VSS \8\:VSS) resistor r=0.2611 c=0
Rk33 (\9\:VSS VSS) resistor r=0.1026 c=0
Rk32 (\8\:VSS \9\:VSS) resistor r=0.188 c=0
Rk34 (\5\:VSS \11\:VSS) resistor r=0.1087 c=0
Rk35 (\6\:VSS \13\:VSS) resistor r=0.189 c=0
Rk36 (\8\:VSS \15\:VSS) resistor r=0.1947 c=0
Rk37 (\9\:VSS \17\:VSS) resistor r=0.4242 c=0
Rk1 (\2\:CO CO) resistor r=0.168 c=0
Rk2 (CO \4\:CO) resistor r=0.3521 c=0
Rk38 (\2\:VDD \4\:VDD) resistor r=0.3917 c=0
Rk39 (\4\:VDD \5\:VDD) resistor r=0.4536 c=0
Rk40 (\5\:VDD \7\:VDD) resistor r=0.1133 c=0
Rk41 (\5\:VDD \8\:VDD) resistor r=0.1842 c=0
Rk42 (\8\:VDD \10\:VDD) resistor r=0.1188 c=0
Rk43 (\8\:VDD \11\:VDD) resistor r=0.1154 c=0
Rk44 (\11\:VDD \12\:VDD) resistor r=0.2862 c=0
Rk45 (\12\:VDD \14\:VDD) resistor r=0.1154 c=0
Rk48 (\15\:VDD VDD) resistor r=0.1026 c=0
Rk46 (\12\:VDD \15\:VDD) resistor r=0.1629 c=0
Rk47 (\15\:VDD \17\:VDD) resistor r=0.1706 c=0
Rk15 (\13\:B B) resistor r=0.5524 c=0
Rk16 (B \14\:B) resistor r=0.2651 c=0
Rk17 (\14\:B \15\:B) resistor r=0.5802 c=0
Rk18 (\15\:B \16\:B) resistor r=0.3774 c=0
Rk12 (\11\:CI CI) resistor r=0.8769 c=0
Rk13 (CI \12\:CI) resistor r=0.002725 c=0
Rk14 (CI \13\:CI) resistor r=0.364 c=0
Rk25 (\2\:S S) resistor r=0.1218 c=0
Rk26 (S \4\:S) resistor r=0.5035 c=0
Rk7 (\8\:COb \9\:COb) resistor r=1.113 c=0
Rk8 (\9\:COb \10\:COb) resistor r=0.6087 c=0
Rk9 (\10\:COb \11\:COb) resistor r=0.2346 c=0
Rk10 (\9\:COb \13\:COb) resistor r=0.0716 c=0
Rk11 (\10\:COb \15\:COb) resistor r=1.0491 c=0
Rk3 (\2\:n2 \4\:n2) resistor r=0.5995 c=0
Rk6 (\2\:n4 \4\:n4) resistor r=0.3718 c=0
Rk23 (\5\:Sb \6\:Sb) resistor r=0.7375 c=0
Rk24 (\6\:Sb \8\:Sb) resistor r=0.634 c=0
Rk4 (\2\:n3 \4\:n3) resistor r=0.338 c=0
Rk5 (\2\:n5 \4\:n5) resistor r=0.3676 c=0
Rl28 (\11\:A \12\:A) resistor r=150.223 c=0
Rl27 (\10\:A \11\:A) resistor r=81.8672 c=0
Rl20 (\8\:A \9\:A) resistor r=162.694 c=0
Rl19 (\7\:A \8\:A) resistor r=72.3097 c=0
Rl13 (\4\:A \5\:A) resistor r=74.2328 c=0
Rl14 (\5\:A \6\:A) resistor r=160.771 c=0
Rl4 (\1\:A \2\:A) resistor r=74.2328 c=0
Rl5 (\2\:A \3\:A) resistor r=160.771 c=0
Rl26 (\11\:B \12\:B) resistor r=116.54 c=0
Rl25 (\10\:B \11\:B) resistor r=126.234 c=0
Rl17 (\7\:B \8\:B) resistor r=28.079 c=0
Rl18 (\8\:B \9\:B) resistor r=206.925 c=0
Rl11 (\4\:B \5\:B) resistor r=28.079 c=0
Rl12 (\5\:B \6\:B) resistor r=206.925 c=0
Rl6 (\1\:B \2\:B) resistor r=28.079 c=0
Rl7 (\2\:B \3\:B) resistor r=206.925 c=0
Rl24 (\9\:CI \10\:CI) resistor r=214.401 c=0
Rl23 (\8\:CI \9\:CI) resistor r=28.8462 c=0
Rl15 (\5\:CI \6\:CI) resistor r=139.56 c=0
Rl16 (\6\:CI \7\:CI) resistor r=91.4826 c=0
Rl10 (\2\:CI \4\:CI) resistor r=129.649 c=0
Rl9 (\2\:CI \3\:CI) resistor r=123.88 c=0
Rl8 (\1\:CI \2\:CI) resistor r=3.1216 c=0
Rl22 (\6\:COb \7\:COb) resistor r=37.6365 c=0
Rl21 (\5\:COb \6\:COb) resistor r=199.969 c=0
Rl3 (\2\:COb \4\:COb) resistor r=49.7141 c=0
Rl2 (\2\:COb \3\:COb) resistor r=113.176 c=0
Rl1 (COb \2\:COb) resistor r=2.0213 c=0
Rl29 (Sb \2\:Sb) resistor r=56.8672 c=0
Rl30 (\2\:Sb \3\:Sb) resistor r=110.713 c=0
Rz9 (\1\:VSS \2\:VSS) resistor r=75 c=0
Rz10 (\10\:VSS \11\:VSS) resistor r=75 c=0
Rz11 (\12\:VSS \13\:VSS) resistor r=75 c=0
Rz12 (\14\:VSS \15\:VSS) resistor r=75 c=0
Rz13 (\16\:VSS \17\:VSS) resistor r=75 c=0
Rz1 (\3\:CO \4\:CO) resistor r=37.5 c=0
Rz14 (\3\:VDD \4\:VDD) resistor r=25 c=0
Rz15 (\3\:VDD \11\:VDD) resistor r=6.25 c=0
Rz8 (\3\:S \4\:S) resistor r=37.5 c=0
Rz6 (\14\:COb \15\:COb) resistor r=75 c=0
Rz2 (n2 \2\:n2) resistor r=75 c=0
Rz3 (\3\:n2 \4\:n2) resistor r=75 c=0
Rz4 (n4 \2\:n4) resistor r=75 c=0
Rz5 (\3\:n4 \4\:n4) resistor r=75 c=0
Rz7 (\4\:Sb \5\:Sb) resistor r=75 c=0
Ry9 (\3\:VSS \4\:VSS) resistor r=20.6667 c=0
Ry10 (\3\:VSS \7\:VSS) resistor r=5.1667 c=0
Ry1 (\1\:CO \2\:CO) resistor r=20.6667 c=0
Ry11 (\1\:VDD \2\:VDD) resistor r=31 c=0
Ry12 (\6\:VDD \7\:VDD) resistor r=62 c=0
Ry13 (\9\:VDD \10\:VDD) resistor r=62 c=0
Ry14 (\13\:VDD \14\:VDD) resistor r=62 c=0
Ry15 (\16\:VDD \17\:VDD) resistor r=62 c=0
Ry8 (\1\:S \2\:S) resistor r=20.6667 c=0
Ry6 (\12\:COb \13\:COb) resistor r=62 c=0
Ry7 (\7\:Sb \8\:Sb) resistor r=62 c=0
Ry2 (n3 \2\:n3) resistor r=62 c=0
Ry3 (\3\:n3 \4\:n3) resistor r=62 c=0
Ry4 (n5 \2\:n5) resistor r=62 c=0
Ry5 (\3\:n5 \4\:n5) resistor r=62 c=0
Rx10 (\5\:A \13\:A) resistor r=45 c=0
Rx11 (\2\:A \14\:A) resistor r=45 c=0
Rx12 (\8\:A \15\:A) resistor r=45 c=0
Rx13 (\11\:A \16\:A) resistor r=45 c=0
Rx6 (\11\:B \13\:B) resistor r=45 c=0
Rx7 (\8\:B \14\:B) resistor r=45 c=0
Rx8 (\5\:B \15\:B) resistor r=45 c=0
Rx9 (\2\:B \16\:B) resistor r=45 c=0
Rx3 (\9\:CI \11\:CI) resistor r=45 c=0
Rx4 (\6\:CI \12\:CI) resistor r=45 c=0
Rx5 (\1\:CI \13\:CI) resistor r=45 c=0
Rx1 (\6\:COb \8\:COb) resistor r=45 c=0
Rx2 (COb \11\:COb) resistor r=45 c=0
Rx14 (\2\:Sb \6\:Sb) resistor r=45 c=0
mn12 (\3\:CO \3\:COb \16\:VSS VSS) g45n1lvt w=(2.6e-07) l=4.5e-08 nf=1 \
        as=3.22e-14 ad=3.64e-14 ps=8e-07 pd=8e-07 nrd=1.16667 nrs=1.16667 \
        sa=1.4e-07 sb=1.23846e-07 sd=160n sca=17.5885 scb=0.0172826 \
        scc=0.00162584 m=(1)
mn13 (\3\:S \3\:Sb \1\:VSS VSS) g45n1lvt w=(2.6e-07) l=4.5e-08 nf=1 \
        as=3.47e-14 ad=3.64e-14 ps=8.4e-07 pd=8e-07 nrd=1.16667 \
        nrs=1.16667 sa=1.15962e-06 sb=1.4e-07 sd=160n sca=8.22858 \
        scb=0.00610564 scc=0.00012768 m=(1)
mn2 (\3\:n2 \3\:A \14\:VSS VSS) g45n1lvt w=(1.45e-07) l=4.5e-08 nf=1 \
        as=3.31e-14 ad=1.93e-14 ps=9.4e-07 pd=5.7e-07 nrd=1.16667 \
        nrs=1.16667 sa=1.33103e-07 sb=2e-06 sd=160n sca=6.83173 \
        scb=0.00357784 scc=2.82929e-05 m=(1)
mn3 (n2 \3\:B \14\:VSS VSS) g45n1lvt w=(1.45e-07) l=4.5e-08 nf=1 \
        as=3.31e-14 ad=2.32e-14 ps=9.4e-07 pd=6.1e-07 nrd=1.16667 \
        nrs=1.16667 sa=3.38103e-07 sb=2e-06 sd=160n sca=6.83173 \
        scb=0.00357784 scc=2.82929e-05 m=(1)
mn4 (\14\:COb \3\:CI n2 VSS) g45n1lvt w=(1.45e-07) l=4.5e-08 nf=1 \
        as=2.32e-14 ad=2.32e-14 ps=6.1e-07 pd=6.1e-07 nrd=1.16667 \
        nrs=1.16667 sa=5.43103e-07 sb=1.95e-06 sd=160n sca=6.83173 \
        scb=0.00357784 scc=2.82929e-05 m=(1)
mn1 (\14\:COb \6\:B n0 VSS) g45n1lvt w=(1.45e-07) l=4.5e-08 nf=1 \
        as=8.7e-15 ad=2.32e-14 ps=4.1e-07 pd=6.1e-07 nrd=1.16667 \
        nrs=1.16667 sa=7.48103e-07 sb=1.745e-06 sd=160n sca=6.83173 \
        scb=0.00357784 scc=2.82929e-05 m=(1)
mn0 (n0 \6\:A \12\:VSS VSS) g45n1lvt w=(1.45e-07) l=4.5e-08 nf=1 \
        as=3.31e-14 ad=8.7e-15 ps=9.4e-07 pd=4.1e-07 nrd=1.16667 \
        nrs=1.16667 sa=8.53103e-07 sb=1.64e-06 sd=160n sca=6.83173 \
        scb=0.00357784 scc=2.82929e-05 m=(1)
mn7 (\3\:n4 \7\:CI \12\:VSS VSS) g45n1lvt w=(1.45e-07) l=4.5e-08 nf=1 \
        as=3.31e-14 ad=2.32e-14 ps=9.4e-07 pd=6.1e-07 nrd=1.16667 \
        nrs=1.16667 sa=1.0581e-06 sb=1.435e-06 sd=160n sca=6.83173 \
        scb=0.00357784 scc=2.82929e-05 m=(1)
mn6 (\3\:n4 \9\:B \10\:VSS VSS) g45n1lvt w=(1.45e-07) l=4.5e-08 nf=1 \
        as=5.17e-14 ad=2.32e-14 ps=1.06e-06 pd=6.1e-07 nrd=1.16667 \
        nrs=1.16667 sa=1.2631e-06 sb=1.23e-06 sd=160n sca=6.83173 \
        scb=0.00357784 scc=2.82929e-05 m=(1)
mn5 (n4 \7\:A \10\:VSS VSS) g45n1lvt w=(1.45e-07) l=4.5e-08 nf=1 \
        as=5.17e-14 ad=2.32e-14 ps=1.06e-06 pd=6.1e-07 nrd=1.16667 \
        nrs=1.16667 sa=1.5281e-06 sb=9.65e-07 sd=160n sca=6.83173 \
        scb=0.00357784 scc=2.82929e-05 m=(1)
mn8 (\4\:Sb \5\:COb n4 VSS) g45n1lvt w=(1.45e-07) l=4.5e-08 nf=1 \
        as=2.32e-14 ad=2.32e-14 ps=6.1e-07 pd=6.1e-07 nrd=1.16667 \
        nrs=1.16667 sa=1.7331e-06 sb=7.6e-07 sd=160n sca=6.83173 \
        scb=0.00357784 scc=2.82929e-05 m=(1)
mn11 (\4\:Sb \8\:CI n7 VSS) g45n1lvt w=(1.45e-07) l=4.5e-08 nf=1 \
        as=8.7e-15 ad=2.32e-14 ps=4.1e-07 pd=6.1e-07 nrd=1.16667 \
        nrs=1.16667 sa=1.9381e-06 sb=5.55e-07 sd=160n sca=6.83173 \
        scb=0.00357784 scc=2.82929e-05 m=(1)
mn10 (n7 \10\:B n6 VSS) g45n1lvt w=(1.45e-07) l=4.5e-08 nf=1 as=8.7e-15 \
        ad=8.7e-15 ps=4.1e-07 pd=4.1e-07 nrd=1.16667 nrs=1.16667 sa=2e-06 \
        sb=4.5e-07 sd=160n sca=6.83173 scb=0.00357784 scc=2.82929e-05 \
        m=(1)
mn9 (n6 \10\:A \1\:VSS VSS) g45n1lvt w=(1.45e-07) l=4.5e-08 nf=1 \
        as=3.47e-14 ad=8.7e-15 ps=8.4e-07 pd=4.1e-07 nrd=1.16667 \
        nrs=1.16667 sa=2e-06 sb=3.45e-07 sd=160n sca=6.83173 \
        scb=0.00357784 scc=2.82929e-05 m=(1)
mp2 (\3\:n3 \1\:A \13\:VDD VDD) g45p1lvt w=(2.15e-07) l=4.5e-08 nf=1 \
        as=6.635e-14 ad=2.91e-14 ps=1.59e-06 pd=7.1e-07 nrd=1.16667 \
        nrs=1.16667 sa=1.35349e-07 sb=2e-06 sd=160n sca=14.1415 \
        scb=0.0126578 scc=0.000426771 m=(1)
mp3 (n3 \1\:B \13\:VDD VDD) g45p1lvt w=(2.15e-07) l=4.5e-08 nf=1 \
        as=6.635e-14 ad=3.44e-14 ps=1.59e-06 pd=7.5e-07 nrd=1.16667 \
        nrs=1.16667 sa=3.30349e-07 sb=2e-06 sd=160n sca=13.1633 \
        scb=0.0118398 scc=0.00042523 m=(1)
mp4 (\12\:COb \4\:CI n3 VDD) g45p1lvt w=(2.15e-07) l=4.5e-08 nf=1 \
        as=3.44e-14 ad=3.44e-14 ps=7.5e-07 pd=7.5e-07 nrd=1.16667 \
        nrs=1.16667 sa=5.35349e-07 sb=1.95e-06 sd=160n sca=12.7104 \
        scb=0.0116911 scc=0.00042519 m=(1)
mp1 (\12\:COb \4\:B n1 VDD) g45p1lvt w=(2.15e-07) l=4.5e-08 nf=1 \
        as=1.29e-14 ad=3.44e-14 ps=5.5e-07 pd=7.5e-07 nrd=1.16667 \
        nrs=1.16667 sa=7.40349e-07 sb=1.745e-06 sd=160n sca=12.7104 \
        scb=0.0116911 scc=0.00042519 m=(1)
mp0 (n1 \4\:A \9\:VDD VDD) g45p1lvt w=(2.15e-07) l=4.5e-08 nf=1 \
        as=6.62e-14 ad=1.29e-14 ps=1.55e-06 pd=5.5e-07 nrd=1.16667 \
        nrs=1.16667 sa=8.45349e-07 sb=1.64e-06 sd=160n sca=12.7104 \
        scb=0.0116911 scc=0.00042519 m=(1)
mp7 (\3\:n5 \5\:CI \9\:VDD VDD) g45p1lvt w=(2.15e-07) l=4.5e-08 nf=1 \
        as=6.62e-14 ad=3.44e-14 ps=1.55e-06 pd=7.5e-07 nrd=1.16667 \
        nrs=1.16667 sa=1.05035e-06 sb=1.435e-06 sd=160n sca=12.7104 \
        scb=0.0116911 scc=0.00042519 m=(1)
mp6 (\3\:n5 \7\:B \6\:VDD VDD) g45p1lvt w=(2.15e-07) l=4.5e-08 nf=1 \
        as=7.457e-14 ad=3.44e-14 ps=1.56e-06 pd=7.5e-07 nrd=1.16667 \
        nrs=1.16667 sa=1.25535e-06 sb=1.23e-06 sd=160n sca=12.7104 \
        scb=0.0116911 scc=0.00042519 m=(1)
mp5 (n5 \9\:A \6\:VDD VDD) g45p1lvt w=(2.15e-07) l=4.5e-08 nf=1 \
        as=7.457e-14 ad=3.44e-14 ps=1.56e-06 pd=7.5e-07 nrd=1.16667 \
        nrs=1.16667 sa=1.48535e-06 sb=1e-06 sd=160n sca=12.7104 \
        scb=0.0116911 scc=0.00042519 m=(1)
mp8 (\7\:Sb \7\:COb n5 VDD) g45p1lvt w=(2.15e-07) l=4.5e-08 nf=1 \
        as=3.44e-14 ad=3.44e-14 ps=7.5e-07 pd=7.5e-07 nrd=1.16667 \
        nrs=1.16667 sa=1.69035e-06 sb=7.95e-07 sd=160n sca=12.9421 \
        scb=0.0117495 scc=0.000425199 m=(1)
mp11 (\7\:Sb \10\:CI n9 VDD) g45p1lvt w=(2.15e-07) l=4.5e-08 nf=1 \
        as=1.29e-14 ad=3.44e-14 ps=5.5e-07 pd=7.5e-07 nrd=1.16667 \
        nrs=1.16667 sa=1.89535e-06 sb=5.9e-07 sd=160n sca=13.7253 \
        scb=0.0122307 scc=0.000425663 m=(1)
mp10 (n9 \12\:B n8 VDD) g45p1lvt w=(2.15e-07) l=4.5e-08 nf=1 as=1.29e-14 \
        ad=1.29e-14 ps=5.5e-07 pd=5.5e-07 nrd=1.16667 nrs=1.16667 \
        sa=1.99593e-06 sb=4.85e-07 sd=160n sca=14.4668 scb=0.0130588 \
        scc=0.000428492 m=(1)
mp9 (n8 \12\:A \1\:VDD VDD) g45p1lvt w=(2.15e-07) l=4.5e-08 nf=1 \
        as=6.055e-14 ad=1.29e-14 ps=1.17e-06 pd=5.5e-07 nrd=1.16667 \
        nrs=1.16667 sa=2e-06 sb=3.8e-07 sd=160n sca=15.7217 scb=0.0149728 \
        scc=0.00044748 m=(1)
ends ADDFX1
// End of subcircuit definition.
