// Generated for: spectre (May  1 11:27:10 2013 )
// Library name: gsclib045_backbias
// Cell name: AND4X2
// View name: extracted

simulator lang=spectre

subckt AND4X2 A B C D NW VDD VSS Y
mp3 (\13\:net100 \3\:D \10\:VDD NW) g45p1svt w=(2.15e-07) l=4.5e-08 nf=1 \
        as=4.465e-14 ad=3.548e-14 ps=1.36e-06 pd=7.6e-07 nrd=1.16667 \
        nrs=1.16667 sa=1e-07 sb=1.355e-06 sd=160n sca=19.3616 \
        scb=0.0212916 scc=0.000644055 m=(1)
mp2 (\13\:net100 \1\:C \8\:VDD NW) g45p1svt w=(2.15e-07) l=4.5e-08 nf=1 \
        as=5.54e-14 ad=3.548e-14 ps=1.46e-06 pd=7.6e-07 nrd=1.16667 \
        nrs=1.16667 sa=3.1e-07 sb=1.145e-06 sd=160n sca=13.6785 \
        scb=0.0116931 scc=0.000214399 m=(1)
mp1 (\11\:net100 \1\:B \8\:VDD NW) g45p1svt w=(2.15e-07) l=4.5e-08 nf=1 \
        as=5.54e-14 ad=5.913e-14 ps=1.46e-06 pd=9.8e-07 nrd=1.16667 \
        nrs=1.16667 sa=5.05e-07 sb=9.5e-07 sd=160n sca=12.115 \
        scb=0.00975563 scc=0.000203878 m=(1)
mp0 (\11\:net100 \1\:A \1\:VDD NW) g45p1svt w=(2.15e-07) l=4.5e-08 nf=1 \
        as=5.835e-14 ad=5.913e-14 ps=1.16e-06 pd=9.8e-07 nrd=1.16667 \
        nrs=1.16667 sa=8.25e-07 sb=6.3e-07 sd=160n sca=11.62 \
        scb=0.00944645 scc=0.000203609 m=(1)
C1 (NW VSS) capacitor c=2.55863e-16
C2 (B VSS) capacitor c=1.33514e-16
C3 (Y VSS) capacitor c=1.53861e-17
C4 (VDD VSS) capacitor c=2.68653e-17
C5 (C VSS) capacitor c=6.63874e-17
C6 (D VSS) capacitor c=5.43985e-17
C7 (A VSS) capacitor c=4.5751e-17
C8 (net132 VSS) capacitor c=2.92448e-18
C9 (net100 VSS) capacitor c=1.59044e-16
C10 (net124 VSS) capacitor c=5.97886e-18
C11 (net120 VSS) capacitor c=9.55244e-18
C12 (\1\:A VSS) capacitor c=4.25072e-17
C13 (\1\:B VSS) capacitor c=5.49735e-17
C14 (\1\:C VSS) capacitor c=6.26801e-17
C15 (\3\:D VSS) capacitor c=4.3058e-17
C16 (\3\:A VSS) capacitor c=4.10545e-17
C17 (\3\:B VSS) capacitor c=2.79181e-17
C18 (\3\:C VSS) capacitor c=4.6797e-17
C19 (\1\:D VSS) capacitor c=4.30629e-17
C20 (\2\:A VSS) capacitor c=4.0646e-17
C21 (\2\:B VSS) capacitor c=4.60993e-17
C22 (\2\:C VSS) capacitor c=5.81231e-17
C23 (\2\:D VSS) capacitor c=5.14774e-17
C24 (\1\:VDD VSS) capacitor c=1.91711e-16
C25 (\4\:Y VSS) capacitor c=8.41134e-17
C26 (\11\:net100 VSS) capacitor c=9.75372e-17
C27 (\8\:VDD VSS) capacitor c=1.14663e-17
C28 (\13\:net100 VSS) capacitor c=3.85623e-17
C29 (\2\:Y VSS) capacitor c=5.23223e-17
C30 (\9\:net100 VSS) capacitor c=4.8071e-17
C31 (\4\:D VSS) capacitor c=4.29367e-17
C32 (\4\:C VSS) capacitor c=6.75341e-17
C33 (\4\:A VSS) capacitor c=6.99812e-17
C34 (\7\:net100 VSS) capacitor c=6.8808e-17
C35 (\8\:net100 VSS) capacitor c=1.32167e-16
C36 (\1\:Y VSS) capacitor c=5.68304e-17
C37 (\4\:VDD VSS) capacitor c=4.21038e-17
C38 (\5\:VDD VSS) capacitor c=2.29071e-17
Rk21 (\5\:VSS VSS) resistor r=0.4001 c=0
Rk20 (\1\:VSS \5\:VSS) resistor r=0.1149 c=0
Rk9 (Y \1\:Y) resistor r=0.01982 c=0
Rk10 (\1\:Y \3\:Y) resistor r=0.271 c=0
Rk11 (\1\:Y \5\:Y) resistor r=0.4146 c=0
Rk13 (\1\:VDD \4\:VDD) resistor r=0.2423 c=0
Rk15 (\5\:VDD VDD) resistor r=0.05461 c=0
Rk14 (\4\:VDD \5\:VDD) resistor r=0.2023 c=0
Rk17 (\4\:VDD \9\:VDD) resistor r=0.07311 c=0
Rk18 (\5\:VDD \11\:VDD) resistor r=0.07311 c=0
Rk2 (C \4\:C) resistor r=0.2242 c=0
Rk1 (D \4\:D) resistor r=0.08954 c=0
Rk4 (A \4\:A) resistor r=0.02131 c=0
Rk5 (\7\:net100 \8\:net100) resistor r=0.3373 c=0
Rk6 (\8\:net100 \10\:net100) resistor r=0.4724 c=0
Rk7 (\8\:net100 \12\:net100) resistor r=0.5571 c=0
Rk8 (\12\:net100 \14\:net100) resistor r=0.2719 c=0
Rl5 (\1\:B \2\:B) resistor r=162.23 c=0
Rl6 (\2\:B \3\:B) resistor r=29.5379 c=0
Rl3 (\1\:C \2\:C) resistor r=160.307 c=0
Rl4 (\2\:C \3\:C) resistor r=31.461 c=0
Rl2 (\2\:D \3\:D) resistor r=147.872 c=0
Rl1 (\1\:D \2\:D) resistor r=44.208 c=0
Rl7 (\1\:A \2\:A) resistor r=93.4057 c=0
Rl8 (\2\:A \3\:A) resistor r=91.4826 c=0
Rz2 (\3\:Y \2\:Y) resistor r=75 c=0
Rz1 (\10\:net100 \9\:net100) resistor r=75 c=0
Ry3 (\5\:Y \4\:Y) resistor r=20.6667 c=0
Ry6 (\9\:VDD \8\:VDD) resistor r=62 c=0
Ry7 (\11\:VDD \10\:VDD) resistor r=62 c=0
Ry1 (\12\:net100 \11\:net100) resistor r=62 c=0
Ry2 (\14\:net100 \13\:net100) resistor r=62 c=0
Rx3 (\2\:B B) resistor r=45 c=0
Rx2 (\2\:C \4\:C) resistor r=45 c=0
Rx1 (\2\:D \4\:D) resistor r=45 c=0
Rx4 (\2\:A \4\:A) resistor r=45 c=0
Rx5 (\7\:net100 net100) resistor r=45 c=0
mn3 (\9\:net100 \1\:D net132 VSS) g45n1svt w=(1.45e-07) l=4.5e-08 nf=1 \
        as=8.7e-15 ad=2.03e-14 ps=4.1e-07 pd=5.7e-07 nrd=1.16667 \
        nrs=1.16667 sa=1.4e-07 sb=1.25e-06 sd=160n sca=11.9911 \
        scb=0.0120555 scc=0.000498628 m=(1)
mn2 (net132 \3\:C net124 VSS) g45n1svt w=(1.45e-07) l=4.5e-08 nf=1 \
        as=2.175e-14 ad=8.7e-15 ps=5.9e-07 pd=4.1e-07 nrd=1.16667 \
        nrs=1.16667 sa=2.45e-07 sb=1.145e-06 sd=160n sca=11.9911 \
        scb=0.0120555 scc=0.000498628 m=(1)
mn1 (net124 \3\:B net120 VSS) g45n1svt w=(1.45e-07) l=4.5e-08 nf=1 \
        as=3.988e-14 ad=2.175e-14 ps=8.4e-07 pd=5.9e-07 nrd=1.16667 \
        nrs=1.16667 sa=4.4e-07 sb=9.5e-07 sd=160n sca=11.9911 \
        scb=0.0120555 scc=0.000498628 m=(1)
mn0 (net120 \3\:A \1\:VSS VSS) g45n1svt w=(1.45e-07) l=4.5e-08 nf=1 \
        as=4.365e-14 ad=3.988e-14 ps=9e-07 pd=8.4e-07 nrd=1.16667 \
        nrs=1.16667 sa=7.6e-07 sb=6.3e-07 sd=160n sca=11.9911 \
        scb=0.0120555 scc=0.000498628 m=(1)
mn4 (\2\:Y net100 \1\:VSS VSS) g45n1svt w=(2.6e-07) l=4.5e-08 nf=1 \
        as=4.653e-14 ad=4.16e-14 ps=9e-07 pd=8.4e-07 nrd=1.16667 \
        nrs=1.16667 sa=6.16827e-07 sb=3.95e-07 sd=160n sca=9.89531 \
        scb=0.00874901 scc=0.000299334 m=(2)
mp4 (\4\:Y net100 \1\:VDD NW) g45p1svt w=(3.9e-07) l=4.5e-08 nf=1 \
        as=6.622e-14 ad=6.24e-14 ps=1.16e-06 pd=1.1e-06 nrd=1.16667 \
        nrs=1.16667 sa=6.29231e-07 sb=3.95e-07 sd=160n sca=21.3165 \
        scb=0.0178846 scc=0.00184501 m=(2)
ends AND4X2
// End of subcircuit definition.
