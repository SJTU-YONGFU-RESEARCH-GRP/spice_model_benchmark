// gsclib045/LSHL_ISOH_X1_FROM_OFF/schematic

simulator lang=spectre

subckt LSHL_ISOH_X1_FROM_OFF A ISO Y ExtVDD VDD VSS
NM1 (VSS ISO ison VSS) g45n1svt w=(145n) l=45n nf=1 m=(1)
NM3 (gatedVSS ison VSS VSS) g45n1svt w=(520n) l=45n nf=2 m=(1)
NM0 (Y n0 gatedVSS VSS) g45n1svt w=(260n) l=45n nf=1 m=(1)
mn0 (gatedVSS A n0 VSS) g45n1svt w=(145n) l=45n nf=1 m=(1)
PM1 (ison ISO ExtVDD ExtVDD) g45p1svt w=(215n) l=45n nf=1 m=(1)
PM4 (Y ison ExtVDD ExtVDD) g45p1svt w=(390n) l=45n nf=1 m=(1)
PM0 (Y n0 ExtVDD ExtVDD) g45p1svt w=(390n) l=45n nf=1 m=(1)
mp0 (n0 A ExtVDD ExtVDD) g45p1svt w=(215n) l=45n nf=1 m=(1)
ends LSHL_ISOH_X1_FROM_OFF
