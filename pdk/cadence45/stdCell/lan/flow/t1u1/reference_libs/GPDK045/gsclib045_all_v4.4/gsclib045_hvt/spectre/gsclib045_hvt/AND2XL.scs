// gsclib045_hvt/AND2XL/schematic

simulator lang=spectre

subckt AND2XL A B Y VSS VDD
mp1 (net57 B VDD VDD) g45p1hvt w=(215n) l=45n nf=1 m=(1)
mp0 (net57 A VDD VDD) g45p1hvt w=(215n) l=45n nf=1 m=(1)
mp2 (Y net57 VDD VDD) g45p1hvt w=(215n) l=45n nf=1 m=(1)
mn2 (Y net57 VSS VSS) g45n1hvt w=(145n) l=45n nf=1 m=(1)
mn0 (net73 A VSS VSS) g45n1hvt w=(145n) l=45n nf=1 m=(1)
mn1 (net57 B net73 VSS) g45n1hvt w=(145n) l=45n nf=1 m=(1)
ends AND2XL
