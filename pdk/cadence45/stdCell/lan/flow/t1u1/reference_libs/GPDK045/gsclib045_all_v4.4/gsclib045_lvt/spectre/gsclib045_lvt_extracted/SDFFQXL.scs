// Generated for: spectre (May  1 09:14:45 2013 )
// Library name: gsclib045_lvt
// Cell name: SDFFQXL
// View name: extracted

simulator lang=spectre

subckt SDFFQXL CK D Q SE SI VDD VSS
mp55 (\3\:Q \4\:qbint \1\:VDD VDD) g45p1lvt w=(2.15e-07) l=4.5e-08 nf=1 \
        as=3.44e-14 ad=3.01e-14 ps=7.5e-07 pd=7.1e-07 nrd=1.16667 \
        nrs=1.16667 sa=1.4e-07 sb=3.65e-07 sd=160n sca=22.7477 \
        scb=0.0252121 scc=0.00126954 m=(1)
mp20 (\15\:CKb \4\:CK \1\:VDD VDD) g45p1lvt w=(2.15e-07) l=4.5e-08 nf=1 \
        as=3.44e-14 ad=3.44e-14 ps=7.5e-07 pd=7.5e-07 nrd=1.16667 \
        nrs=1.16667 sa=3.45e-07 sb=1.6e-07 sd=160n sca=13.584 \
        scb=0.0113598 scc=0.000108591 m=(1)
mp45 (\13\:qbint n30 \5\:VDD VDD) g45p1lvt w=(2.15e-07) l=4.5e-08 nf=1 \
        as=8.57e-14 ad=3.01e-14 ps=1.51e-06 pd=7.1e-07 nrd=1.16667 \
        nrs=1.16667 sa=1.4e-07 sb=1.875e-06 sd=160n sca=17.4145 \
        scb=0.0172865 scc=0.00131682 m=(1)
mp50 (n8 \5\:qbint \5\:VDD VDD) g45p1lvt w=(2.15e-07) l=4.5e-08 nf=1 \
        as=8.57e-14 ad=4.837e-14 ps=1.51e-06 pd=8.8e-07 nrd=1.16667 \
        nrs=1.16667 sa=4.05e-07 sb=1.61e-06 sd=160n sca=17.4145 \
        scb=0.0172865 scc=0.00131682 m=(1)
mp51 (\4\:n30 \3\:CKbb n8 VDD) g45p1lvt w=(2.15e-07) l=4.5e-08 nf=1 \
        as=4.837e-14 ad=3.44e-14 ps=8.8e-07 pd=7.5e-07 nrd=1.16667 \
        nrs=1.16667 sa=6.75e-07 sb=1.34e-06 sd=160n sca=17.4145 \
        scb=0.0172865 scc=0.00131682 m=(1)
mp40 (\4\:n30 \3\:CKb \4\:mout VDD) g45p1lvt w=(2.15e-07) l=4.5e-08 nf=1 \
        as=4.945e-14 ad=3.44e-14 ps=8.9e-07 pd=7.5e-07 nrd=1.16667 \
        nrs=1.16667 sa=8.8e-07 sb=1.135e-06 sd=160n sca=17.4145 \
        scb=0.0172865 scc=0.00131682 m=(1)
mp30 (\4\:mout n20 \10\:VDD VDD) g45p1lvt w=(2.15e-07) l=4.5e-08 nf=1 \
        as=8.57e-14 ad=4.945e-14 ps=1.51e-06 pd=8.9e-07 nrd=1.16667 \
        nrs=1.16667 sa=1.155e-06 sb=8.6e-07 sd=160n sca=17.4145 \
        scb=0.0172865 scc=0.00131682 m=(1)
mp35 (n6 mout \10\:VDD VDD) g45p1lvt w=(2.15e-07) l=4.5e-08 nf=1 \
        as=8.57e-14 ad=1.935e-14 ps=1.51e-06 pd=6.1e-07 nrd=1.16667 \
        nrs=1.16667 sa=1.42e-06 sb=5.95e-07 sd=160n sca=17.4145 \
        scb=0.0172865 scc=0.00131682 m=(1)
mp36 (\4\:n20 \8\:CKb n6 VDD) g45p1lvt w=(2.15e-07) l=4.5e-08 nf=1 \
        as=1.935e-14 ad=3.87e-14 ps=6.1e-07 pd=7.9e-07 nrd=1.16667 \
        nrs=1.16667 sa=1.555e-06 sb=4.6e-07 sd=160n sca=17.4145 \
        scb=0.0172865 scc=0.00131682 m=(1)
mp25 (\4\:n20 \6\:CKbb \6\:Db VDD) g45p1lvt w=(2.15e-07) l=4.5e-08 nf=1 \
        as=5.052e-14 ad=3.87e-14 ps=9e-07 pd=7.9e-07 nrd=1.16667 \
        nrs=1.16667 sa=1.78e-06 sb=2.35e-07 sd=160n sca=17.4145 \
        scb=0.0172865 scc=0.00131682 m=(1)
mp21 (\8\:CKbb \5\:CKb \13\:VDD VDD) g45p1lvt w=(2.15e-07) l=4.5e-08 \
        nf=1 as=3.762e-14 ad=3.01e-14 ps=7.8e-07 pd=7.1e-07 nrd=1.16667 \
        nrs=1.16667 sa=1.4e-07 sb=1.185e-06 sd=160n sca=10.3756 \
        scb=0.00778655 scc=9.84544e-05 m=(1)
mp11 (n2 \1\:D \13\:VDD VDD) g45p1lvt w=(2.15e-07) l=4.5e-08 nf=1 \
        as=3.762e-14 ad=3.547e-14 ps=7.8e-07 pd=7.6e-07 nrd=1.16667 \
        nrs=1.16667 sa=3.6e-07 sb=9.65e-07 sd=160n sca=10.3756 \
        scb=0.00778655 scc=9.84544e-05 m=(1)
mp12 (\4\:Db \1\:SE n2 VDD) g45p1lvt w=(2.15e-07) l=4.5e-08 nf=1 \
        as=3.547e-14 ad=3.762e-14 ps=7.6e-07 pd=7.8e-07 nrd=1.16667 \
        nrs=1.16667 sa=5.7e-07 sb=7.55e-07 sd=160n sca=10.5693 \
        scb=0.00783293 scc=9.84607e-05 m=(1)
mp14 (\4\:Db SEb n4 VDD) g45p1lvt w=(2.15e-07) l=4.5e-08 nf=1 \
        as=3.117e-14 ad=3.762e-14 ps=7.2e-07 pd=7.8e-07 nrd=1.16667 \
        nrs=1.16667 sa=7.9e-07 sb=5.35e-07 sd=160n sca=11.3905 \
        scb=0.00832609 scc=9.89279e-05 m=(1)
mp13 (n4 \1\:SI \16\:VDD VDD) g45p1lvt w=(2.15e-07) l=4.5e-08 nf=1 \
        as=3.44e-14 ad=3.117e-14 ps=7.5e-07 pd=7.2e-07 nrd=1.16667 \
        nrs=1.16667 sa=9.8e-07 sb=3.45e-07 sd=160n sca=13.0884 \
        scb=0.0105751 scc=0.000113994 m=(1)
mp10 (\8\:SEb \5\:SE \16\:VDD VDD) g45p1lvt w=(2.15e-07) l=4.5e-08 nf=1 \
        as=3.44e-14 ad=3.01e-14 ps=7.5e-07 pd=7.1e-07 nrd=1.16667 \
        nrs=1.16667 sa=1.185e-06 sb=1.4e-07 sd=160n sca=19.3888 \
        scb=0.0210602 scc=0.000665938 m=(1)
C1 (D VSS) capacitor c=6.05613e-17
C2 (VDD VSS) capacitor c=3.8495e-16
C3 (CK VSS) capacitor c=7.94923e-17
C4 (SE VSS) capacitor c=5.17346e-17
C5 (Q VSS) capacitor c=6.44916e-17
C6 (SI VSS) capacitor c=3.82353e-17
C7 (qbint VSS) capacitor c=2.81436e-17
C8 (CKb VSS) capacitor c=5.40878e-17
C9 (n30 VSS) capacitor c=4.86362e-17
C10 (mout VSS) capacitor c=6.53272e-17
C11 (CKbb VSS) capacitor c=1.83192e-17
C12 (n20 VSS) capacitor c=3.83015e-17
C13 (Db VSS) capacitor c=8.26932e-17
C14 (n1 VSS) capacitor c=5.70493e-18
C15 (SEb VSS) capacitor c=3.4871e-17
C16 (n8 VSS) capacitor c=2.80538e-18
C17 (n2 VSS) capacitor c=6.53665e-20
C18 (\5\:SE VSS) capacitor c=5.44498e-17
C19 (\1\:SI VSS) capacitor c=5.26282e-17
C20 (\1\:SE VSS) capacitor c=4.1898e-17
C21 (\1\:D VSS) capacitor c=5.46909e-17
C22 (\5\:CKb VSS) capacitor c=5.47877e-17
C23 (\6\:CKbb VSS) capacitor c=4.53084e-17
C24 (\8\:CKb VSS) capacitor c=4.64708e-17
C25 (\3\:CKb VSS) capacitor c=5.29567e-17
C26 (\3\:CKbb VSS) capacitor c=4.57805e-17
C27 (\5\:qbint VSS) capacitor c=4.76656e-17
C28 (\4\:CK VSS) capacitor c=4.14179e-17
C29 (\4\:qbint VSS) capacitor c=5.73053e-17
C30 (\7\:SE VSS) capacitor c=2.80076e-17
C31 (\3\:SI VSS) capacitor c=7.51641e-17
C32 (\3\:SE VSS) capacitor c=6.86121e-17
C33 (\3\:SEb VSS) capacitor c=7.24169e-17
C34 (\4\:D VSS) capacitor c=3.34036e-17
C35 (\9\:CKb VSS) capacitor c=2.5578e-17
C36 (\10\:CKb VSS) capacitor c=2.90699e-17
C37 (\4\:CKbb VSS) capacitor c=7.60163e-17
C38 (\3\:mout VSS) capacitor c=5.22783e-17
C39 (\3\:n20 VSS) capacitor c=3.72854e-17
C40 (\8\:qbint VSS) capacitor c=4.96066e-17
C41 (\2\:n30 VSS) capacitor c=4.10821e-17
C42 (\1\:CK VSS) capacitor c=4.54399e-17
C43 (\3\:qbint VSS) capacitor c=2.70643e-17
C44 (\6\:SE VSS) capacitor c=5.37605e-17
C45 (\2\:SI VSS) capacitor c=6.44654e-17
C46 (\4\:SE VSS) capacitor c=4.39672e-17
C47 (\2\:SEb VSS) capacitor c=7.01382e-17
C48 (\2\:SE VSS) capacitor c=4.11907e-17
C49 (\3\:D VSS) capacitor c=3.1118e-17
C50 (\7\:CKbb VSS) capacitor c=4.26534e-17
C51 (\11\:CKb VSS) capacitor c=2.89881e-17
C52 (\5\:CKbb VSS) capacitor c=2.68119e-17
C53 (\2\:mout VSS) capacitor c=4.55585e-17
C54 (\2\:n20 VSS) capacitor c=3.80383e-17
C55 (\2\:CKbb VSS) capacitor c=5.4162e-17
C56 (\4\:CKb VSS) capacitor c=2.31422e-17
C57 (\2\:CKb VSS) capacitor c=3.15483e-17
C58 (\7\:qbint VSS) capacitor c=4.93385e-17
C59 (\3\:n30 VSS) capacitor c=2.21159e-17
C60 (\3\:CK VSS) capacitor c=5.2016e-17
C61 (\8\:SEb VSS) capacitor c=2.00361e-17
C62 (\16\:VDD VSS) capacitor c=4.3207e-17
C63 (\4\:Db VSS) capacitor c=5.31203e-17
C64 (\13\:VDD VSS) capacitor c=2.91009e-17
C65 (\8\:CKbb VSS) capacitor c=9.02551e-17
C66 (\6\:Db VSS) capacitor c=1.20672e-16
C67 (\4\:n20 VSS) capacitor c=3.00605e-17
C68 (\10\:VDD VSS) capacitor c=2.67871e-17
C69 (\4\:mout VSS) capacitor c=5.02916e-17
C70 (\4\:n30 VSS) capacitor c=7.70972e-17
C71 (\5\:VDD VSS) capacitor c=2.70169e-17
C72 (\13\:qbint VSS) capacitor c=3.50259e-17
C73 (\15\:CKb VSS) capacitor c=1.08462e-16
C74 (\1\:VDD VSS) capacitor c=3.13549e-17
C75 (\3\:Q VSS) capacitor c=7.23031e-17
C76 (\7\:VDD VSS) capacitor c=5.0753e-17
C77 (\4\:SEb VSS) capacitor c=4.2908e-17
C78 (\14\:CKbb VSS) capacitor c=6.1389e-17
C79 (\8\:Db VSS) capacitor c=6.08573e-17
C80 (\8\:n20 VSS) capacitor c=5.62832e-17
C81 (\7\:mout VSS) capacitor c=3.88399e-17
C82 (\6\:n30 VSS) capacitor c=9.93368e-17
C83 (\11\:qbint VSS) capacitor c=9.3593e-17
C84 (\19\:CKb VSS) capacitor c=1.06178e-16
C85 (\2\:qbint VSS) capacitor c=3.31913e-17
C86 (\6\:CKb VSS) capacitor c=6.686e-17
C87 (\7\:CKb VSS) capacitor c=7.8711e-17
C88 (\2\:D VSS) capacitor c=3.39548e-17
C89 (\5\:CK VSS) capacitor c=4.25936e-17
C90 (\9\:qbint VSS) capacitor c=3.15519e-17
C91 (\10\:qbint VSS) capacitor c=2.93585e-17
C92 (\15\:qbint VSS) capacitor c=1.04043e-16
C93 (\8\:n30 VSS) capacitor c=6.22715e-17
C94 (\6\:mout VSS) capacitor c=4.87914e-17
C95 (\9\:mout VSS) capacitor c=5.44356e-17
C96 (\12\:CKb VSS) capacitor c=6.69464e-17
C97 (\13\:CKb VSS) capacitor c=6.7767e-17
C98 (\14\:CKb VSS) capacitor c=8.47596e-17
C99 (\17\:CKb VSS) capacitor c=1.52887e-17
C100 (\18\:CKb VSS) capacitor c=6.08603e-17
C101 (\6\:n20 VSS) capacitor c=5.26596e-17
C102 (\7\:n20 VSS) capacitor c=6.50612e-17
C103 (\10\:CKbb VSS) capacitor c=1.19885e-16
C104 (\11\:CKbb VSS) capacitor c=6.55535e-17
C105 (\12\:CKbb VSS) capacitor c=8.36085e-17
C106 (\13\:CKbb VSS) capacitor c=1.19117e-16
C107 (\16\:CKbb VSS) capacitor c=1.73289e-17
C108 (\5\:D VSS) capacitor c=3.59585e-17
C109 (\3\:Db VSS) capacitor c=1.34204e-16
C110 (\8\:SE VSS) capacitor c=6.57447e-17
C111 (\9\:SE VSS) capacitor c=7.15e-17
C112 (\4\:SI VSS) capacitor c=1.0021e-16
C113 (\6\:SEb VSS) capacitor c=7.5654e-17
C114 (\7\:SEb VSS) capacitor c=5.83759e-17
C115 (\3\:VDD VSS) capacitor c=1.85221e-17
C116 (\4\:VDD VSS) capacitor c=1.61635e-17
C117 (\9\:VDD VSS) capacitor c=5.12075e-17
C118 (\12\:VDD VSS) capacitor c=2.50575e-17
Rk28 (\5\:D D) resistor r=0.1705 c=0
Rk52 (\3\:VDD VDD) resistor r=0.1073 c=0
Rk51 (\2\:VDD \3\:VDD) resistor r=0.1967 c=0
Rk53 (\3\:VDD \4\:VDD) resistor r=0.3831 c=0
Rk54 (\4\:VDD \6\:VDD) resistor r=0.1288 c=0
Rk55 (\4\:VDD \8\:VDD) resistor r=0.05996 c=0
Rk56 (\8\:VDD \9\:VDD) resistor r=0.4485 c=0
Rk57 (\9\:VDD \11\:VDD) resistor r=0.1288 c=0
Rk58 (\9\:VDD \12\:VDD) resistor r=0.6463 c=0
Rk59 (\12\:VDD \14\:VDD) resistor r=0.232 c=0
Rk60 (\12\:VDD \15\:VDD) resistor r=0.05746 c=0
Rk61 (\15\:VDD \17\:VDD) resistor r=0.603 c=0
Rk3 (\5\:CK CK) resistor r=0.1244 c=0
Rk34 (\9\:SE SE) resistor r=0.2199 c=0
Rk33 (\8\:SE \9\:SE) resistor r=0.3442 c=0
Rk35 (SE \10\:SE) resistor r=0.002697 c=0
Rk1 (\2\:Q Q) resistor r=0.002997 c=0
Rk2 (Q \4\:Q) resistor r=0.4885 c=0
Rk36 (SI \4\:SI) resistor r=0.009246 c=0
Rk40 (\2\:VSS \4\:VSS) resistor r=0.6617 c=0
Rk41 (\4\:VSS \5\:VSS) resistor r=0.07249 c=0
Rk42 (\5\:VSS \6\:VSS) resistor r=0.6504 c=0
Rk43 (\6\:VSS \7\:VSS) resistor r=0.4275 c=0
Rk44 (\7\:VSS \8\:VSS) resistor r=0.04397 c=0
Rk46 (\9\:VSS VSS) resistor r=0.08728 c=0
Rk45 (\8\:VSS \9\:VSS) resistor r=0.4173 c=0
Rk47 (\5\:VSS \11\:VSS) resistor r=0.2938 c=0
Rk48 (\6\:VSS \13\:VSS) resistor r=0.04328 c=0
Rk49 (\8\:VSS \15\:VSS) resistor r=0.04328 c=0
Rk50 (\9\:VSS \17\:VSS) resistor r=0.07358 c=0
Rk4 (\9\:qbint \10\:qbint) resistor r=0.1674 c=0
Rk5 (\10\:qbint \12\:qbint) resistor r=0.1206 c=0
Rk6 (\10\:qbint \14\:qbint) resistor r=0.2091 c=0
Rk7 (\12\:qbint \15\:qbint) resistor r=0.7664 c=0
Rk13 (\12\:CKb \13\:CKb) resistor r=0.5284 c=0
Rk14 (\13\:CKb \14\:CKb) resistor r=0.2795 c=0
Rk15 (\14\:CKb \16\:CKb) resistor r=0.537 c=0
Rk16 (\13\:CKb \17\:CKb) resistor r=0.03285 c=0
Rk17 (\14\:CKb \18\:CKb) resistor r=0.3554 c=0
Rk18 (\16\:CKb \20\:CKb) resistor r=0.5296 c=0
Rk8 (\5\:n30 \7\:n30) resistor r=0.4132 c=0
Rk9 (\7\:n30 \8\:n30) resistor r=0.5086 c=0
Rk10 (\5\:mout \6\:mout) resistor r=0.239 c=0
Rk11 (\6\:mout \8\:mout) resistor r=0.12 c=0
Rk12 (\6\:mout \9\:mout) resistor r=0.2517 c=0
Rk22 (\9\:CKbb \10\:CKbb) resistor r=0.6491 c=0
Rk23 (\10\:CKbb \11\:CKbb) resistor r=0.3242 c=0
Rk24 (\11\:CKbb \12\:CKbb) resistor r=0.2057 c=0
Rk25 (\12\:CKbb \13\:CKbb) resistor r=0.7737 c=0
Rk26 (\11\:CKbb \15\:CKbb) resistor r=0.3653 c=0
Rk27 (\12\:CKbb \16\:CKbb) resistor r=0.0529 c=0
Rk19 (\5\:n20 \6\:n20) resistor r=0.1253 c=0
Rk20 (\6\:n20 \7\:n20) resistor r=0.3025 c=0
Rk21 (\6\:n20 \9\:n20) resistor r=0.2416 c=0
Rk29 (\2\:Db \3\:Db) resistor r=0.6437 c=0
Rk30 (\3\:Db \5\:Db) resistor r=0.2692 c=0
Rk31 (\3\:Db \7\:Db) resistor r=0.5881 c=0
Rk32 (\7\:Db \9\:Db) resistor r=0.3444 c=0
Rk37 (\5\:SEb \6\:SEb) resistor r=0.3961 c=0
Rk38 (\6\:SEb \7\:SEb) resistor r=0.3301 c=0
Rk39 (\6\:SEb \9\:SEb) resistor r=0.08492 c=0
Rl28 (\1\:D \2\:D) resistor r=137.695 c=0
Rl30 (\2\:D \4\:D) resistor r=97.3105 c=0
Rl29 (\2\:D \3\:D) resistor r=29.6836 c=0
Rl6 (\2\:CK \4\:CK) resistor r=142.76 c=0
Rl4 (\1\:CK \2\:CK) resistor r=113.913 c=0
Rl5 (\2\:CK \3\:CK) resistor r=2.733 c=0
Rl37 (\5\:SE \6\:SE) resistor r=183.848 c=0
Rl38 (\6\:SE \7\:SE) resistor r=26.1559 c=0
Rl34 (\3\:SE \4\:SE) resistor r=26.1559 c=0
Rl31 (\1\:SE \2\:SE) resistor r=76.1559 c=0
Rl35 (\1\:SI \2\:SI) resistor r=93.4636 c=0
Rl36 (\2\:SI \3\:SI) resistor r=116.54 c=0
Rl3 (\2\:qbint \4\:qbint) resistor r=212.341 c=0
Rl2 (\2\:qbint \3\:qbint) resistor r=37.3411 c=0
Rl1 (qbint \2\:qbint) resistor r=5.0163 c=0
Rl9 (\5\:qbint \6\:qbint) resistor r=99.2798 c=0
Rl11 (\6\:qbint \8\:qbint) resistor r=34.3295 c=0
Rl10 (\6\:qbint \7\:qbint) resistor r=0.5166 c=0
Rl27 (\8\:CKb \11\:CKb) resistor r=24.2328 c=0
Rl13 (\3\:CKb \4\:CKb) resistor r=60.7713 c=0
Rl12 (CKb \2\:CKb) resistor r=30.0021 c=0
Rl22 (\5\:CKb \6\:CKb) resistor r=156.492 c=0
Rl25 (\6\:CKb \9\:CKb) resistor r=78.0797 c=0
Rl24 (\7\:CKb \8\:CKb) resistor r=134.159 c=0
Rl26 (\7\:CKb \10\:CKb) resistor r=30.4507 c=0
Rl23 (\6\:CKb \7\:CKb) resistor r=254.684 c=0
Rl7 (n30 \2\:n30) resistor r=132.692 c=0
Rl8 (\2\:n30 \3\:n30) resistor r=29.5379 c=0
Rl18 (mout \2\:mout) resistor r=77.6148 c=0
Rl19 (\2\:mout \3\:mout) resistor r=29.5379 c=0
Rl21 (\6\:CKbb \7\:CKbb) resistor r=30.0021 c=0
Rl20 (\4\:CKbb \5\:CKbb) resistor r=76.1559 c=0
Rl15 (\2\:CKbb \3\:CKbb) resistor r=110.587 c=0
Rl14 (CKbb \2\:CKbb) resistor r=24.5191 c=0
Rl16 (n20 \2\:n20) resistor r=26.098 c=0
Rl17 (\2\:n20 \3\:n20) resistor r=74.1749 c=0
Rl32 (SEb \2\:SEb) resistor r=24.2328 c=0
Rl33 (\2\:SEb \3\:SEb) resistor r=214.183 c=0
Rz16 (\7\:VDD \8\:VDD) resistor r=6.25 c=0
Rz17 (\7\:VDD \15\:VDD) resistor r=6.8182 c=0
Rz1 (\1\:Q \2\:Q) resistor r=75 c=0
Rz11 (\1\:VSS \2\:VSS) resistor r=75 c=0
Rz12 (\10\:VSS \11\:VSS) resistor r=75 c=0
Rz13 (\12\:VSS \13\:VSS) resistor r=75 c=0
Rz14 (\14\:VSS \15\:VSS) resistor r=75 c=0
Rz15 (\16\:VSS \17\:VSS) resistor r=75 c=0
Rz2 (\11\:qbint \12\:qbint) resistor r=75 c=0
Rz5 (\19\:CKb \20\:CKb) resistor r=75 c=0
Rz3 (\6\:n30 \7\:n30) resistor r=75 c=0
Rz4 (\7\:mout \8\:mout) resistor r=75 c=0
Rz7 (\14\:CKbb \15\:CKbb) resistor r=75 c=0
Rz6 (\8\:n20 \9\:n20) resistor r=75 c=0
Rz8 (Db \2\:Db) resistor r=75 c=0
Rz9 (\8\:Db \9\:Db) resistor r=75 c=0
Rz10 (\4\:SEb \5\:SEb) resistor r=75 c=0
Ry13 (\1\:VDD \2\:VDD) resistor r=62 c=0
Ry14 (\5\:VDD \6\:VDD) resistor r=62 c=0
Ry15 (\10\:VDD \11\:VDD) resistor r=62 c=0
Ry16 (\13\:VDD \14\:VDD) resistor r=62 c=0
Ry17 (\16\:VDD \17\:VDD) resistor r=62 c=0
Ry1 (\3\:Q \4\:Q) resistor r=62 c=0
Ry11 (\3\:VSS \4\:VSS) resistor r=5.6364 c=0
Ry12 (\3\:VSS \7\:VSS) resistor r=5.1667 c=0
Ry2 (\13\:qbint \14\:qbint) resistor r=62 c=0
Ry5 (\15\:CKb \16\:CKb) resistor r=62 c=0
Ry3 (\4\:n30 \5\:n30) resistor r=62 c=0
Ry4 (\4\:mout \5\:mout) resistor r=62 c=0
Ry7 (\8\:CKbb \9\:CKbb) resistor r=62 c=0
Ry6 (\4\:n20 \5\:n20) resistor r=62 c=0
Ry8 (\4\:Db \5\:Db) resistor r=62 c=0
Ry9 (\6\:Db \7\:Db) resistor r=62 c=0
Ry10 (\8\:SEb \9\:SEb) resistor r=62 c=0
Rx13 (\3\:D \5\:D) resistor r=45 c=0
Rx1 (\3\:CK \5\:CK) resistor r=45 c=0
Rx14 (\2\:SE \8\:SE) resistor r=45 c=0
Rx15 (\4\:SE \9\:SE) resistor r=45 c=0
Rx16 (\6\:SE \10\:SE) resistor r=45 c=0
Rx17 (\2\:SI \4\:SI) resistor r=45 c=0
Rx2 (\7\:qbint \9\:qbint) resistor r=45 c=0
Rx3 (qbint \15\:qbint) resistor r=45 c=0
Rx6 (\11\:CKb \12\:CKb) resistor r=45 c=0
Rx7 (\4\:CKb \17\:CKb) resistor r=45 c=0
Rx8 (\2\:CKb \18\:CKb) resistor r=45 c=0
Rx4 (\3\:n30 \8\:n30) resistor r=45 c=0
Rx5 (\2\:mout \9\:mout) resistor r=45 c=0
Rx10 (\7\:CKbb \10\:CKbb) resistor r=45 c=0
Rx11 (\2\:CKbb \13\:CKbb) resistor r=45 c=0
Rx12 (\5\:CKbb \16\:CKbb) resistor r=45 c=0
Rx9 (\2\:n20 \7\:n20) resistor r=45 c=0
Rx18 (\2\:SEb \7\:SEb) resistor r=45 c=0
mn55 (\1\:Q \3\:qbint \16\:VSS VSS) g45n1lvt w=(1.45e-07) l=4.5e-08 nf=1 \
        as=5.028e-14 ad=2.03e-14 ps=1.44e-06 pd=5.7e-07 nrd=1.16667 \
        nrs=1.16667 sa=1.4e-07 sb=3.95e-07 sd=160n sca=11.9911 \
        scb=0.0120555 scc=0.000498628 m=(1)
mn20 (\19\:CKb \1\:CK \16\:VSS VSS) g45n1lvt w=(1.45e-07) l=4.5e-08 nf=1 \
        as=5.028e-14 ad=2.538e-14 ps=1.44e-06 pd=6.4e-07 nrd=1.16667 \
        nrs=1.16667 sa=3.6e-07 sb=1.75e-07 sd=160n sca=11.9911 \
        scb=0.0120555 scc=0.000498628 m=(1)
mn45 (\11\:qbint \2\:n30 \14\:VSS VSS) g45n1lvt w=(1.45e-07) l=4.5e-08 \
        nf=1 as=5.19e-14 ad=2.465e-14 ps=1.6e-06 pd=6.3e-07 nrd=1.16667 \
        nrs=1.16667 sa=1.7e-07 sb=1.905e-06 sd=160n sca=23.279 \
        scb=0.0230742 scc=0.00267719 m=(1)
mn50 (n7 \8\:qbint \14\:VSS VSS) g45n1lvt w=(1.45e-07) l=4.5e-08 nf=1 \
        as=5.19e-14 ad=1.233e-14 ps=1.6e-06 pd=4.6e-07 nrd=1.16667 \
        nrs=1.16667 sa=3.65e-07 sb=1.71e-06 sd=160n sca=23.279 \
        scb=0.0230742 scc=0.00267719 m=(1)
mn51 (\6\:n30 CKb n7 VSS) g45n1lvt w=(1.45e-07) l=4.5e-08 nf=1 \
        as=1.233e-14 ad=4.423e-14 ps=4.6e-07 pd=9e-07 nrd=1.16667 \
        nrs=1.16667 sa=4.95e-07 sb=1.58e-06 sd=160n sca=23.279 \
        scb=0.0230742 scc=0.00267719 m=(1)
mn40 (\7\:mout CKbb \6\:n30 VSS) g45n1lvt w=(1.45e-07) l=4.5e-08 nf=1 \
        as=4.423e-14 ad=4.278e-14 ps=9e-07 pd=8.8e-07 nrd=1.16667 \
        nrs=1.16667 sa=8.45e-07 sb=1.23e-06 sd=160n sca=23.279 \
        scb=0.0230742 scc=0.00267719 m=(1)
mn30 (\7\:mout \3\:n20 \12\:VSS VSS) g45n1lvt w=(1.45e-07) l=4.5e-08 \
        nf=1 as=6.205e-14 ad=4.278e-14 ps=1.74e-06 pd=8.8e-07 nrd=1.16667 \
        nrs=1.16667 sa=1.185e-06 sb=8.9e-07 sd=160n sca=23.279 \
        scb=0.0230742 scc=0.00267719 m=(1)
mn36 (n5 \3\:mout \12\:VSS VSS) g45n1lvt w=(1.45e-07) l=4.5e-08 nf=1 \
        as=6.205e-14 ad=8.7e-15 ps=1.74e-06 pd=4.1e-07 nrd=1.16667 \
        nrs=1.16667 sa=1.45e-06 sb=6.25e-07 sd=160n sca=23.279 \
        scb=0.0230742 scc=0.00267719 m=(1)
mn35 (\8\:n20 \4\:CKbb n5 VSS) g45n1lvt w=(1.45e-07) l=4.5e-08 nf=1 \
        as=8.7e-15 ad=2.32e-14 ps=4.1e-07 pd=6.1e-07 nrd=1.16667 \
        nrs=1.16667 sa=1.555e-06 sb=5.2e-07 sd=160n sca=23.279 \
        scb=0.0230742 scc=0.00267719 m=(1)
mn25 (\8\:Db \10\:CKb \8\:n20 VSS) g45n1lvt w=(1.45e-07) l=4.5e-08 nf=1 \
        as=2.32e-14 ad=4.568e-14 ps=6.1e-07 pd=9.2e-07 nrd=1.16667 \
        nrs=1.16667 sa=1.76e-06 sb=3.15e-07 sd=160n sca=23.279 \
        scb=0.0230742 scc=0.00267719 m=(1)
mn21 (\14\:CKbb \9\:CKb \10\:VSS VSS) g45n1lvt w=(1.45e-07) l=4.5e-08 \
        nf=1 as=3.19e-14 ad=2.03e-14 ps=7.3e-07 pd=5.7e-07 nrd=1.16667 \
        nrs=1.16667 sa=1.4e-07 sb=1.285e-06 sd=160n sca=11.7118 \
        scb=0.0116498 scc=0.000458536 m=(1)
mn11 (n1 \4\:D \10\:VSS VSS) g45n1lvt w=(1.45e-07) l=4.5e-08 nf=1 \
        as=3.19e-14 ad=3.842e-14 ps=7.3e-07 pd=8.2e-07 nrd=1.16667 \
        nrs=1.16667 sa=4.05e-07 sb=1.02e-06 sd=160n sca=11.7118 \
        scb=0.0116498 scc=0.000458536 m=(1)
mn12 (Db \3\:SEb n1 VSS) g45n1lvt w=(1.45e-07) l=4.5e-08 nf=1 \
        as=3.842e-14 ad=2.32e-14 ps=8.2e-07 pd=6.1e-07 nrd=1.16667 \
        nrs=1.16667 sa=7.15e-07 sb=7.1e-07 sd=160n sca=11.7118 \
        scb=0.0116498 scc=0.000458536 m=(1)
mn14 (Db \3\:SE n3 VSS) g45n1lvt w=(1.45e-07) l=4.5e-08 nf=1 as=8.7e-15 \
        ad=2.32e-14 ps=4.1e-07 pd=6.1e-07 nrd=1.16667 nrs=1.16667 \
        sa=9.2e-07 sb=5.05e-07 sd=160n sca=11.7118 scb=0.0116498 \
        scc=0.000458536 m=(1)
mn13 (n3 \3\:SI \1\:VSS VSS) g45n1lvt w=(1.45e-07) l=4.5e-08 nf=1 \
        as=2.32e-14 ad=8.7e-15 ps=6.1e-07 pd=4.1e-07 nrd=1.16667 \
        nrs=1.16667 sa=1.025e-06 sb=4e-07 sd=160n sca=11.7118 \
        scb=0.0116498 scc=0.000458536 m=(1)
mn10 (\4\:SEb \7\:SE \1\:VSS VSS) g45n1lvt w=(1.45e-07) l=4.5e-08 nf=1 \
        as=2.32e-14 ad=2.827e-14 ps=6.1e-07 pd=6.8e-07 nrd=1.16667 \
        nrs=1.16667 sa=1.23e-06 sb=1.95e-07 sd=160n sca=11.7118 \
        scb=0.0116498 scc=0.000458536 m=(1)
ends SDFFQXL
// End of subcircuit definition.
