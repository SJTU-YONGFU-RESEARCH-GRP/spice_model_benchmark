// Generated for: spectre (May  1 08:12:12 2013 )
// Library name: gsclib045
// Cell name: RDFFNSRX1
// View name: extracted

simulator lang=spectre

subckt RDFFNSRX1 CKN D ExtVDD Q QN RN RT SN VDD VSS
mp21 (\12\:CKNbb \5\:CKNb \22\:VDD VDD) g45p1svt w=(2.15e-07) l=4.5e-08 \
        nf=1 as=3.44e-14 ad=3.01e-14 ps=7.5e-07 pd=7.1e-07 nrd=1.16667 \
        nrs=1.16667 sa=1.4e-07 sb=3.45e-07 sd=160n sca=8.57804 \
        scb=0.00665512 scc=0.000139907 m=(1)
mp20 (\18\:CKNb \4\:CKN \22\:VDD VDD) g45p1svt w=(2.15e-07) l=4.5e-08 \
        nf=1 as=3.01e-14 ad=3.44e-14 ps=7.1e-07 pd=7.5e-07 nrd=1.16667 \
        nrs=1.16667 sa=3.45e-07 sb=1.4e-07 sd=160n sca=8.74748 \
        scb=0.00669435 scc=0.000139912 m=(1)
mp50 (n41 \9\:SN \1\:VDD VDD) g45p1svt w=(2.15e-07) l=4.5e-08 nf=1 \
        as=3.44e-14 ad=3.01e-14 ps=7.5e-07 pd=7.1e-07 nrd=1.16667 \
        nrs=1.16667 sa=4.5e-07 sb=1.4e-07 sd=160n sca=17.6764 \
        scb=0.0200035 scc=0.000687881 m=(1)
mp56 (\9\:qint \13\:qbint \15\:VDD VDD) g45p1svt w=(2.15e-07) l=4.5e-08 \
        nf=1 as=6.535e-14 ad=3.01e-14 ps=1.16e-06 pd=7.1e-07 nrd=1.16667 \
        nrs=1.16667 sa=3.75e-07 sb=1.4e-07 sd=160n sca=16.7926 \
        scb=0.0173717 scc=0.000688766 m=(1)
mp22 (\11\:RNb \1\:RN \27\:VDD VDD) g45p1svt w=(2.15e-07) l=4.5e-08 nf=1 \
        as=3.01e-14 ad=3.01e-14 ps=7.1e-07 pd=7.1e-07 nrd=1.16667 \
        nrs=1.16667 sa=1.4e-07 sb=1.4e-07 sd=160n sca=16.6707 \
        scb=0.0178086 scc=0.000703955 m=(1)
mp25 (n22 \4\:D \29\:VDD VDD) g45p1svt w=(2.15e-07) l=4.5e-08 nf=1 \
        as=3.01e-14 ad=1.29e-14 ps=7.1e-07 pd=5.5e-07 nrd=1.16667 \
        nrs=1.16667 sa=1.4e-07 sb=2.45e-07 sd=160n sca=9.38867 \
        scb=0.00702624 scc=0.000140131 m=(1)
mp26 (\18\:n20 \3\:CKNb n22 VDD) g45p1svt w=(2.15e-07) l=4.5e-08 nf=1 \
        as=1.29e-14 ad=3.01e-14 ps=5.5e-07 pd=7.1e-07 nrd=1.16667 \
        nrs=1.16667 sa=2.45e-07 sb=1.4e-07 sd=160n sca=8.98202 \
        scb=0.00678072 scc=0.000139937 m=(1)
mp36 (\8\:n20 \6\:CKNbb n31 VDD) g45p1svt w=(2.15e-07) l=4.5e-08 nf=1 \
        as=1.29e-14 ad=3.01e-14 ps=5.5e-07 pd=7.1e-07 nrd=1.16667 \
        nrs=1.16667 sa=1.4e-07 sb=1.035e-06 sd=160n sca=6.16879 \
        scb=0.00249467 scc=1.40767e-05 m=(1)
mp35 (n31 mout \20\:VDD VDD) g45p1svt w=(2.15e-07) l=4.5e-08 nf=1 \
        as=6.773e-14 ad=1.29e-14 ps=1.06e-06 pd=5.5e-07 nrd=1.16667 \
        nrs=1.16667 sa=2.45e-07 sb=9.3e-07 sd=160n sca=6.07861 \
        scb=0.00247604 scc=1.40748e-05 m=(1)
mp30 (\15\:mout \1\:SN \20\:VDD VDD) g45p1svt w=(2.15e-07) l=4.5e-08 \
        nf=1 as=6.773e-14 ad=6.02e-14 ps=1.06e-06 pd=9.9e-07 nrd=1.16667 \
        nrs=1.16667 sa=6.05e-07 sb=5.7e-07 sd=160n sca=6.07861 \
        scb=0.00247604 scc=1.40748e-05 m=(1)
mp32 (\15\:mout \3\:n20 net402 VDD) g45p1svt w=(2.15e-07) l=4.5e-08 nf=1 \
        as=1.29e-14 ad=6.02e-14 ps=5.5e-07 pd=9.9e-07 nrd=1.16667 \
        nrs=1.16667 sa=9.3e-07 sb=2.45e-07 sd=160n sca=6.79882 \
        scb=0.00278203 scc=1.42286e-05 m=(1)
mp31 (net402 \7\:RNb \17\:VDD VDD) g45p1svt w=(2.15e-07) l=4.5e-08 nf=1 \
        as=3.01e-14 ad=1.29e-14 ps=7.1e-07 pd=5.5e-07 nrd=1.16667 \
        nrs=1.16667 sa=1.035e-06 sb=1.4e-07 sd=160n sca=7.36861 \
        scb=0.00328614 scc=1.51674e-05 m=(1)
mp40 (\13\:n35 \7\:CKNbb \5\:mout VDD) g45p1svt w=(2.15e-07) l=4.5e-08 \
        nf=1 as=3.01e-14 ad=3.01e-14 ps=7.1e-07 pd=7.1e-07 nrd=1.16667 \
        nrs=1.16667 sa=1.4e-07 sb=1.4e-07 sd=160n sca=25.5298 \
        scb=0.0265038 scc=0.00266093 m=(1)
PM0 (\7\:n35g \4\:RT \5\:n35 ExtVDD) g45p1svt w=(2.15e-07) l=4.5e-08 nf=1 \
        as=3.01e-14 ad=3.01e-14 ps=7.1e-07 pd=7.1e-07 nrd=1.16667 \
        nrs=1.16667 sa=1.4e-07 sb=1.4e-07 sd=160n sca=28.4784 \
        scb=0.0312204 scc=0.00281308 m=(1)
PM1 (\17\:qbint \3\:n35g \3\:ExtVDD ExtVDD) g45p1svt w=(2.15e-07) \
        l=4.5e-08 nf=1 as=3.01e-14 ad=3.01e-14 ps=7.1e-07 pd=7.1e-07 \
        nrd=1.16667 nrs=1.16667 sa=1.4e-07 sb=1.4e-07 sd=160n sca=25.2796 \
        scb=0.0259458 scc=0.00265434 m=(1)
PM2 (net205 \4\:qbint \6\:ExtVDD ExtVDD) g45p1svt w=(2.15e-07) l=4.5e-08 \
        nf=1 as=3.01e-14 ad=1.29e-14 ps=7.1e-07 pd=5.5e-07 nrd=1.16667 \
        nrs=1.16667 sa=1.4e-07 sb=2.45e-07 sd=160n sca=14.5295 \
        scb=0.0144143 scc=0.000486924 m=(1)
mp45 (\9\:RTb \7\:RT \11\:ExtVDD ExtVDD) g45p1svt w=(2.15e-07) l=4.5e-08 \
        nf=1 as=3.01e-14 ad=3.01e-14 ps=7.1e-07 pd=7.1e-07 nrd=1.16667 \
        nrs=1.16667 sa=1.4e-07 sb=1.4e-07 sd=160n sca=26.768 scb=0.029923 \
        scc=0.00243217 m=(1)
PM3 (\15\:n35g \4\:RTb net205 ExtVDD) g45p1svt w=(2.15e-07) l=4.5e-08 \
        nf=1 as=1.29e-14 ad=3.01e-14 ps=5.5e-07 pd=7.1e-07 nrd=1.16667 \
        nrs=1.16667 sa=2.45e-07 sb=1.4e-07 sd=160n sca=25.2796 \
        scb=0.0259458 scc=0.00265434 m=(1)
mp53 (\17\:n35 \12\:CKNb \3\:n41 VDD) g45p1svt w=(2.15e-07) l=4.5e-08 \
        nf=1 as=3.01e-14 ad=3.01e-14 ps=7.1e-07 pd=7.1e-07 nrd=1.16667 \
        nrs=1.16667 sa=1.4e-07 sb=1.4e-07 sd=160n sca=28.3325 \
        scb=0.0311878 scc=0.00281308 m=(1)
mp51 (n43 \9\:RNb \13\:VDD VDD) g45p1svt w=(2.15e-07) l=4.5e-08 nf=1 \
        as=3.01e-14 ad=1.29e-14 ps=7.1e-07 pd=5.5e-07 nrd=1.16667 \
        nrs=1.16667 sa=1.4e-07 sb=4.5e-07 sd=160n sca=11.7172 \
        scb=0.00907208 scc=0.000169405 m=(1)
mp52 (n41 \11\:qbint n43 VDD) g45p1svt w=(2.15e-07) l=4.5e-08 nf=1 \
        as=1.29e-14 ad=3.44e-14 ps=5.5e-07 pd=7.5e-07 nrd=1.16667 \
        nrs=1.16667 sa=2.45e-07 sb=3.45e-07 sd=160n sca=12.2449 \
        scb=0.0101425 scc=0.000180577 m=(1)
C1 (Q VSS) capacitor c=6.27753e-17
C2 (VDD VSS) capacitor c=6.65063e-16
C3 (CKN VSS) capacitor c=3.95538e-17
C4 (QN VSS) capacitor c=2.45629e-17
C5 (RT VSS) capacitor c=5.37439e-17
C6 (SN VSS) capacitor c=3.72706e-17
C7 (D VSS) capacitor c=3.64261e-17
C8 (ExtVDD VSS) capacitor c=3.28238e-16
C9 (n20 VSS) capacitor c=5.62854e-17
C10 (CKNb VSS) capacitor c=4.58103e-17
C11 (mout VSS) capacitor c=4.81917e-17
C12 (RNb VSS) capacitor c=3.84683e-17
C13 (CKNbb VSS) capacitor c=8.06678e-17
C14 (n35g VSS) capacitor c=1.62813e-17
C15 (qbint VSS) capacitor c=4.36122e-17
C16 (n35 VSS) capacitor c=4.80327e-17
C17 (RTb VSS) capacitor c=5.60816e-17
C18 (qint VSS) capacitor c=2.23515e-17
C19 (n41 VSS) capacitor c=8.41293e-17
C20 (net426 VSS) capacitor c=8.67118e-17
C21 (n40 VSS) capacitor c=8.44677e-17
C22 (n42 VSS) capacitor c=7.94906e-17
C23 (\9\:SN VSS) capacitor c=7.09325e-17
C24 (\7\:qbint VSS) capacitor c=3.32312e-17
C25 (\11\:qbint VSS) capacitor c=1.40941e-16
C26 (\9\:RNb VSS) capacitor c=1.30502e-16
C27 (\13\:qbint VSS) capacitor c=4.62303e-17
C28 (\3\:qint VSS) capacitor c=6.12091e-17
C29 (\12\:CKNb VSS) capacitor c=6.03131e-17
C30 (\4\:RTb VSS) capacitor c=1.21319e-16
C31 (\7\:RT VSS) capacitor c=4.93698e-17
C32 (\4\:qbint VSS) capacitor c=6.75487e-17
C33 (\3\:n35g VSS) capacitor c=9.4586e-17
C34 (\4\:RT VSS) capacitor c=9.91045e-17
C35 (\7\:CKNbb VSS) capacitor c=4.16873e-17
C36 (\7\:RNb VSS) capacitor c=5.57751e-17
C37 (\3\:n20 VSS) capacitor c=4.79469e-17
C38 (\4\:CKN VSS) capacitor c=5.89752e-17
C39 (\1\:SN VSS) capacitor c=2.606e-17
C40 (\5\:CKNb VSS) capacitor c=4.44539e-17
C41 (\6\:CKNbb VSS) capacitor c=9.32508e-17
C42 (\3\:CKNb VSS) capacitor c=1.65148e-16
C43 (\4\:D VSS) capacitor c=7.43696e-17
C44 (\1\:RN VSS) capacitor c=4.29439e-17
C45 (\10\:SN VSS) capacitor c=1.3534e-16
C46 (\6\:qbint VSS) capacitor c=3.7102e-17
C47 (\12\:qbint VSS) capacitor c=8.09571e-17
C48 (\8\:RNb VSS) capacitor c=6.63241e-17
C49 (\14\:qbint VSS) capacitor c=4.72963e-17
C50 (\4\:qint VSS) capacitor c=3.79151e-17
C51 (\9\:CKNbb VSS) capacitor c=5.34443e-17
C52 (\5\:RT VSS) capacitor c=1.52427e-16
C53 (\6\:RT VSS) capacitor c=6.61849e-17
C54 (\5\:qbint VSS) capacitor c=3.89239e-17
C55 (\4\:n35g VSS) capacitor c=2.69017e-17
C56 (\6\:CKNb VSS) capacitor c=3.40432e-17
C57 (\6\:n20 VSS) capacitor c=6.19385e-17
C58 (\1\:CKN VSS) capacitor c=2.98857e-17
C59 (\3\:SN VSS) capacitor c=4.74422e-17
C60 (\3\:mout VSS) capacitor c=4.58426e-17
C61 (\11\:CKNb VSS) capacitor c=4.92242e-17
C62 (\1\:D VSS) capacitor c=6.31199e-17
C63 (\4\:RN VSS) capacitor c=3.73284e-17
C64 (\10\:RNb VSS) capacitor c=5.67834e-17
C65 (\10\:CKNbb VSS) capacitor c=4.08533e-17
C66 (\3\:n35 VSS) capacitor c=7.89228e-17
C67 (\10\:qbint VSS) capacitor c=8.45149e-17
C68 (\8\:SN VSS) capacitor c=6.09072e-17
C69 (\11\:SN VSS) capacitor c=9.59314e-17
C70 (\13\:CKNb VSS) capacitor c=5.90466e-17
C71 (\1\:RT VSS) capacitor c=1.61007e-17
C72 (\10\:CKNb VSS) capacitor c=1.4153e-16
C73 (\3\:RTb VSS) capacitor c=9.74952e-17
C74 (\7\:SN VSS) capacitor c=5.69026e-17
C75 (\4\:n35 VSS) capacitor c=6.73437e-17
C76 (\3\:qbint VSS) capacitor c=4.83861e-17
C77 (\6\:SN VSS) capacitor c=1.70078e-16
C78 (\1\:ExtVDD VSS) capacitor c=7.97519e-17
C79 (\2\:ExtVDD VSS) capacitor c=8.02788e-17
C80 (\2\:RTb VSS) capacitor c=5.3727e-17
C81 (\5\:n35g VSS) capacitor c=1.02148e-16
C82 (\2\:n35 VSS) capacitor c=5.55761e-17
C83 (\3\:CKNbb VSS) capacitor c=6.30014e-17
C84 (\3\:RNb VSS) capacitor c=4.08981e-17
C85 (\2\:RNb VSS) capacitor c=4.4323e-17
C86 (\4\:RNb VSS) capacitor c=4.87602e-17
C87 (\7\:n20 VSS) capacitor c=5.43547e-17
C88 (\4\:n20 VSS) capacitor c=1.25323e-16
C89 (\3\:CKN VSS) capacitor c=2.44145e-17
C90 (\2\:CKNb VSS) capacitor c=9.76765e-17
C91 (\2\:SN VSS) capacitor c=4.95352e-17
C92 (\5\:SN VSS) capacitor c=2.63177e-17
C93 (\8\:CKNbb VSS) capacitor c=2.02608e-17
C94 (\2\:CKNbb VSS) capacitor c=5.34846e-17
C95 (\2\:mout VSS) capacitor c=4.34257e-17
C96 (\4\:mout VSS) capacitor c=3.22066e-17
C97 (\5\:n20 VSS) capacitor c=1.12042e-16
C98 (\4\:CKNb VSS) capacitor c=7.4897e-17
C99 (\9\:CKNb VSS) capacitor c=2.69681e-17
C100 (\3\:D VSS) capacitor c=1.56551e-17
C101 (\6\:RNb VSS) capacitor c=1.36287e-16
C102 (\2\:n20 VSS) capacitor c=7.01895e-17
C103 (\3\:RN VSS) capacitor c=4.84557e-17
C104 (\1\:VDD VSS) capacitor c=3.00017e-17
C105 (\11\:VDD VSS) capacitor c=4.48717e-17
C106 (\3\:Q VSS) capacitor c=7.32482e-17
C107 (\13\:VDD VSS) capacitor c=5.02887e-17
C108 (\9\:qint VSS) capacitor c=5.45409e-17
C109 (\15\:VDD VSS) capacitor c=7.79874e-17
C110 (\3\:n41 VSS) capacitor c=9.48264e-17
C111 (\4\:QN VSS) capacitor c=6.25258e-17
C112 (\17\:n35 VSS) capacitor c=1.09172e-16
C113 (\15\:n35g VSS) capacitor c=5.67279e-17
C114 (\9\:RTb VSS) capacitor c=3.97846e-17
C115 (\11\:ExtVDD VSS) capacitor c=3.2106e-17
C116 (\7\:n35g VSS) capacitor c=6.8192e-17
C117 (\17\:qbint VSS) capacitor c=6.5372e-17
C118 (\5\:n35 VSS) capacitor c=5.95714e-17
C119 (\13\:n35 VSS) capacitor c=1.03459e-16
C120 (\5\:mout VSS) capacitor c=1.31637e-16
C121 (\17\:VDD VSS) capacitor c=4.4153e-17
C122 (\18\:CKNb VSS) capacitor c=4.93383e-17
C123 (\15\:mout VSS) capacitor c=1.11019e-16
C124 (\22\:VDD VSS) capacitor c=6.1611e-17
C125 (\20\:VDD VSS) capacitor c=6.64615e-17
C126 (\12\:CKNbb VSS) capacitor c=5.94618e-17
C127 (\18\:n20 VSS) capacitor c=3.39798e-17
C128 (\8\:n20 VSS) capacitor c=6.24905e-17
C129 (\29\:VDD VSS) capacitor c=3.68595e-17
C130 (\11\:RNb VSS) capacitor c=5.05268e-17
C131 (\27\:VDD VSS) capacitor c=6.33098e-17
C132 (\1\:Q VSS) capacitor c=5.43561e-17
C133 (\5\:qint VSS) capacitor c=4.68737e-17
C134 (\3\:n42 VSS) capacitor c=8.06679e-17
C135 (\3\:n40 VSS) capacitor c=8.14238e-17
C136 (\1\:QN VSS) capacitor c=3.97953e-17
C137 (\19\:n35 VSS) capacitor c=9.34405e-17
C138 (\11\:n35g VSS) capacitor c=2.94486e-17
C139 (\6\:RTb VSS) capacitor c=1.84989e-16
C140 (\9\:n35g VSS) capacitor c=8.35633e-17
C141 (\19\:qbint VSS) capacitor c=2.26966e-17
C142 (\11\:n35 VSS) capacitor c=2.55746e-17
C143 (\9\:n35 VSS) capacitor c=2.61372e-17
C144 (\11\:mout VSS) capacitor c=3.71086e-17
C145 (\13\:mout VSS) capacitor c=3.81742e-17
C146 (\20\:CKNb VSS) capacitor c=5.05955e-17
C147 (\3\:net426 VSS) capacitor c=1.00362e-16
C148 (\15\:CKNbb VSS) capacitor c=4.73378e-17
C149 (\14\:n20 VSS) capacitor c=5.95926e-17
C150 (\12\:n20 VSS) capacitor c=8.57362e-17
C151 (\14\:RNb VSS) capacitor c=7.34185e-17
C152 (\2\:D VSS) capacitor c=6.16192e-17
C153 (\2\:CKN VSS) capacitor c=4.25179e-17
C154 (\5\:RNb VSS) capacitor c=1.79222e-16
C155 (VDD VSS) capacitor c=2.88654e-16
C156 (\4\:CKNbb VSS) capacitor c=9.12177e-17
C157 (\5\:CKNbb VSS) capacitor c=9.40322e-17
C158 (\2\:n35g VSS) capacitor c=3.44877e-17
C159 (\4\:SN VSS) capacitor c=2.1257e-16
C160 (\2\:qbint VSS) capacitor c=4.32875e-17
C161 (\7\:CKNb VSS) capacitor c=1.29241e-16
C162 (\8\:CKNb VSS) capacitor c=7.33205e-17
C163 (\2\:RT VSS) capacitor c=1.71393e-16
C164 (\3\:RT VSS) capacitor c=1.25224e-16
C165 (\2\:qint VSS) capacitor c=1.60211e-17
C166 (\5\:RN VSS) capacitor c=2.02867e-17
C167 (\6\:RN VSS) capacitor c=3.9388e-17
C168 (\13\:RNb VSS) capacitor c=1.06606e-16
C169 (\5\:D VSS) capacitor c=3.93105e-17
C170 (\14\:CKNb VSS) capacitor c=1.55266e-16
C171 (\15\:CKNb VSS) capacitor c=1.36735e-16
C172 (\8\:qbint VSS) capacitor c=5.17939e-17
C173 (\9\:qbint VSS) capacitor c=7.86799e-17
C174 (\10\:n20 VSS) capacitor c=7.42166e-17
C175 (\11\:n20 VSS) capacitor c=9.20337e-17
C176 (\16\:n20 VSS) capacitor c=7.24148e-17
C177 (\17\:n20 VSS) capacitor c=6.22832e-17
C178 (\11\:CKNbb VSS) capacitor c=3.33848e-17
C179 (\14\:CKNbb VSS) capacitor c=5.51421e-17
C180 (\12\:SN VSS) capacitor c=3.46371e-17
C181 (\13\:SN VSS) capacitor c=4.69491e-17
C182 (\7\:CKN VSS) capacitor c=2.74262e-17
C183 (\16\:CKNb VSS) capacitor c=3.93833e-17
C184 (\17\:CKNb VSS) capacitor c=4.56865e-17
C185 (\20\:n20 VSS) capacitor c=7.70558e-17
C186 (\21\:n20 VSS) capacitor c=7.94086e-17
C187 (\16\:RNb VSS) capacitor c=7.12198e-17
C188 (\17\:RNb VSS) capacitor c=8.13977e-17
C189 (\7\:mout VSS) capacitor c=1.55867e-16
C190 (\8\:mout VSS) capacitor c=5.31713e-17
C191 (\9\:mout VSS) capacitor c=1.00141e-16
C192 (\10\:mout VSS) capacitor c=8.61707e-17
C193 (\17\:mout VSS) capacitor c=6.8571e-17
C194 (\7\:n35 VSS) capacitor c=7.79361e-17
C195 (\8\:n35 VSS) capacitor c=1.20587e-16
C196 (\6\:n35g VSS) capacitor c=3.77814e-17
C197 (\5\:ExtVDD VSS) capacitor c=1.02057e-16
C198 (\13\:ExtVDD VSS) capacitor c=4.09202e-17
C199 (\15\:qbint VSS) capacitor c=9.00209e-17
C200 (\16\:qbint VSS) capacitor c=1.09296e-16
C201 (\13\:n35g VSS) capacitor c=1.068e-16
C202 (\14\:n35g VSS) capacitor c=1.17092e-16
C203 (\14\:SN VSS) capacitor c=3.34008e-17
C204 (\15\:SN VSS) capacitor c=5.07144e-17
C205 (\15\:n35 VSS) capacitor c=8.68911e-17
C206 (\16\:n35 VSS) capacitor c=7.4515e-17
C207 (\5\:RTb VSS) capacitor c=8.31761e-17
C208 (\8\:RTb VSS) capacitor c=1.02742e-16
C209 (\16\:SN VSS) capacitor c=8.38054e-17
C210 (\17\:SN VSS) capacitor c=8.40369e-17
C211 (\22\:CKNb VSS) capacitor c=1.25891e-16
C212 (\23\:CKNb VSS) capacitor c=1.24797e-16
C213 (\21\:qbint VSS) capacitor c=2.37255e-17
C214 (\22\:qbint VSS) capacitor c=2.9536e-17
C215 (\8\:RT VSS) capacitor c=4.57556e-17
C216 (\17\:CKNbb VSS) capacitor c=3.4265e-16
C217 (\18\:CKNbb VSS) capacitor c=3.83101e-16
C218 (\18\:RNb VSS) capacitor c=3.79771e-16
C219 (\19\:RNb VSS) capacitor c=3.25664e-16
C220 (\3\:QN VSS) capacitor c=3.57243e-17
C221 (\21\:n35 VSS) capacitor c=4.04189e-17
C222 (\7\:qint VSS) capacitor c=5.36963e-17
C223 (\8\:qint VSS) capacitor c=3.48306e-17
C224 (\3\:VDD VSS) capacitor c=3.07356e-17
C225 (\4\:VDD VSS) capacitor c=3.41452e-17
C226 (\6\:VDD VSS) capacitor c=9.99691e-18
C227 (\7\:VDD VSS) capacitor c=1.7633e-16
C228 (\8\:VDD VSS) capacitor c=6.21272e-17
C229 (\10\:VDD VSS) capacitor c=4.46133e-17
C230 (\19\:VDD VSS) capacitor c=1.4113e-17
C231 (\24\:VDD VSS) capacitor c=2.89963e-17
C232 (\26\:VDD VSS) capacitor c=6.03233e-17
Rk76 (\2\:Q Q) resistor r=0.174 c=0
Rk77 (Q \4\:Q) resistor r=0.3094 c=0
Rk90 (\2\:VDD \3\:VDD) resistor r=0.3387 c=0
Rk91 (\3\:VDD \4\:VDD) resistor r=0.2187 c=0
Rk92 (\4\:VDD \6\:VDD) resistor r=0.06703 c=0
Rk94 (\7\:VDD VDD) resistor r=1.0578 c=0
Rk93 (\6\:VDD \7\:VDD) resistor r=0.05209 c=0
Rk95 (VDD \8\:VDD) resistor r=0.5902 c=0
Rk96 (\8\:VDD \10\:VDD) resistor r=0.2214 c=0
Rk97 (\3\:VDD \12\:VDD) resistor r=0.3589 c=0
Rk98 (\4\:VDD \14\:VDD) resistor r=0.2948 c=0
Rk99 (\7\:VDD \16\:VDD) resistor r=0.3636 c=0
Rk100 (\8\:VDD \18\:VDD) resistor r=0.203 c=0
Rk101 (\10\:VDD \19\:VDD) resistor r=0.09503 c=0
Rk102 (\19\:VDD \21\:VDD) resistor r=0.2304 c=0
Rk103 (\10\:VDD \23\:VDD) resistor r=0.3555 c=0
Rk106 (\24\:VDD VDD) resistor r=0.1963 c=0
Rk104 (\19\:VDD \24\:VDD) resistor r=0.0768 c=0
Rk105 (\24\:VDD \25\:VDD) resistor r=0.2204 c=0
Rk107 (VDD \26\:VDD) resistor r=0.06977 c=0
Rk108 (\26\:VDD \28\:VDD) resistor r=0.5308 c=0
Rk109 (\26\:VDD \30\:VDD) resistor r=0.2824 c=0
Rk19 (\5\:CKN CKN) resistor r=0.003628 c=0
Rk21 (\5\:CKN \7\:CKN) resistor r=0.01536 c=0
Rk20 (\6\:CKN \7\:CKN) resistor r=0.00567 c=0
Rk68 (\3\:QN QN) resistor r=0.01882 c=0
Rk67 (\2\:QN \3\:QN) resistor r=0.2914 c=0
Rk69 (\3\:QN \5\:QN) resistor r=0.329 c=0
Rk84 (VSS VSS) resistor r=0.8416 c=0
Rk116 (VSS VSS) resistor r=0.8416 c=0
Rk80 (\2\:VSS \4\:VSS) resistor r=0.5203 c=0
Rk81 (\4\:VSS \5\:VSS) resistor r=0.7845 c=0
Rk83 (\6\:VSS VSS) resistor r=0.1989 c=0
Rk82 (\5\:VSS \6\:VSS) resistor r=0.1617 c=0
Rk85 (VSS \7\:VSS) resistor r=0.1546 c=0
Rk86 (\7\:VSS \8\:VSS) resistor r=0.03715 c=0
Rk87 (\8\:VSS \10\:VSS) resistor r=0.6748 c=0
Rk88 (\5\:VSS \12\:VSS) resistor r=0.1672 c=0
Rk89 (\8\:VSS \14\:VSS) resistor r=0.2528 c=0
Rk110 (\16\:VSS \18\:VSS) resistor r=0.4655 c=0
Rk111 (\18\:VSS \19\:VSS) resistor r=0.1368 c=0
Rk112 (\19\:VSS \20\:VSS) resistor r=0.6744 c=0
Rk113 (\20\:VSS \21\:VSS) resistor r=0.1343 c=0
Rk115 (\22\:VSS VSS) resistor r=0.1241 c=0
Rk114 (\21\:VSS \22\:VSS) resistor r=0.0745 c=0
Rk117 (VSS \23\:VSS) resistor r=0.0374 c=0
Rk118 (\23\:VSS \24\:VSS) resistor r=0.1168 c=0
Rk119 (\24\:VSS \26\:VSS) resistor r=0.559 c=0
Rk120 (\19\:VSS \28\:VSS) resistor r=0.2653 c=0
Rk121 (\20\:VSS \30\:VSS) resistor r=0.1905 c=0
Rk122 (\22\:VSS \32\:VSS) resistor r=0.1956 c=0
Rk123 (\23\:VSS \34\:VSS) resistor r=0.2422 c=0
Rk1 (RN \5\:RN) resistor r=0.004332 c=0
Rk3 (\5\:RN \6\:RN) resistor r=0.01325 c=0
Rk2 (\6\:RN \7\:RN) resistor r=0.004332 c=0
Rk64 (RT \8\:RT) resistor r=0.06404 c=0
Rk17 (\12\:SN SN) resistor r=0.03611 c=0
Rk18 (SN \13\:SN) resistor r=0.2358 c=0
Rk56 (\14\:SN \15\:SN) resistor r=0.1981 c=0
Rk61 (\16\:SN \17\:SN) resistor r=0.4591 c=0
Rk6 (\5\:D D) resistor r=0.05272 c=0
Rk46 (ExtVDD ExtVDD) resistor r=0.002122 c=0
Rk43 (\4\:ExtVDD \5\:ExtVDD) resistor r=0.02228 c=0
Rk44 (\5\:ExtVDD \7\:ExtVDD) resistor r=0.02228 c=0
Rk47 (\8\:ExtVDD ExtVDD) resistor r=0.01537 c=0
Rk45 (\5\:ExtVDD \8\:ExtVDD) resistor r=0.02004 c=0
Rk49 (\12\:ExtVDD \13\:ExtVDD) resistor r=0.08217 c=0
Rk8 (\9\:n20 \10\:n20) resistor r=0.3478 c=0
Rk9 (\9\:n20 \11\:n20) resistor r=0.231 c=0
Rk10 (\11\:n20 \13\:n20) resistor r=0.4998 c=0
Rk11 (\15\:n20 \16\:n20) resistor r=0.4739 c=0
Rk12 (\16\:n20 \17\:n20) resistor r=0.3426 c=0
Rk13 (\16\:n20 \19\:n20) resistor r=0.1648 c=0
Rk25 (\20\:n20 \21\:n20) resistor r=0.4658 c=0
Rk7 (\14\:CKNb \15\:CKNb) resistor r=0.8547 c=0
Rk22 (\16\:CKNb \17\:CKNb) resistor r=0.2184 c=0
Rk23 (\17\:CKNb \19\:CKNb) resistor r=0.2573 c=0
Rk24 (\17\:CKNb \21\:CKNb) resistor r=0.3307 c=0
Rk62 (\22\:CKNb \23\:CKNb) resistor r=0.7107 c=0
Rk28 (\6\:mout \7\:mout) resistor r=0.7671 c=0
Rk29 (\7\:mout \8\:mout) resistor r=0.3549 c=0
Rk30 (\8\:mout \9\:mout) resistor r=0.1721 c=0
Rk31 (\9\:mout \10\:mout) resistor r=0.3424 c=0
Rk32 (\7\:mout \12\:mout) resistor r=0.1239 c=0
Rk33 (\8\:mout \14\:mout) resistor r=0.1004 c=0
Rk34 (\9\:mout \16\:mout) resistor r=0.512 c=0
Rk35 (\10\:mout \17\:mout) resistor r=0.4279 c=0
Rk4 (\12\:RNb \13\:RNb) resistor r=0.1645 c=0
Rk5 (\13\:RNb \15\:RNb) resistor r=0.3928 c=0
Rk27 (\16\:RNb \17\:RNb) resistor r=0.3488 c=0
Rk66 (\18\:RNb \19\:RNb) resistor r=2.3507 c=0
Rk14 (\11\:CKNbb \13\:CKNbb) resistor r=0.1523 c=0
Rk15 (\13\:CKNbb \14\:CKNbb) resistor r=0.5018 c=0
Rk16 (\14\:CKNbb \16\:CKNbb) resistor r=0.2297 c=0
Rk65 (\17\:CKNbb \18\:CKNbb) resistor r=2.3425 c=0
Rk41 (\6\:n35g \8\:n35g) resistor r=0.1272 c=0
Rk42 (\8\:n35g \10\:n35g) resistor r=0.5905 c=0
Rk53 (\12\:n35g \13\:n35g) resistor r=0.2446 c=0
Rk54 (\13\:n35g \14\:n35g) resistor r=0.5695 c=0
Rk55 (\13\:n35g \16\:n35g) resistor r=0.4349 c=0
Rk50 (\15\:qbint \16\:qbint) resistor r=0.498 c=0
Rk51 (\16\:qbint \18\:qbint) resistor r=0.571 c=0
Rk52 (\16\:qbint \20\:qbint) resistor r=0.1473 c=0
Rk63 (\21\:qbint \22\:qbint) resistor r=0.2132 c=0
Rk36 (\6\:n35 \7\:n35) resistor r=0.414 c=0
Rk37 (\7\:n35 \8\:n35) resistor r=0.5501 c=0
Rk38 (\8\:n35 \10\:n35) resistor r=0.1722 c=0
Rk39 (\7\:n35 \12\:n35) resistor r=0.15 c=0
Rk40 (\8\:n35 \14\:n35) resistor r=0.5945 c=0
Rk57 (\15\:n35 \16\:n35) resistor r=0.4125 c=0
Rk70 (\18\:n35 \20\:n35) resistor r=0.6609 c=0
Rk71 (\20\:n35 \21\:n35) resistor r=0.1237 c=0
Rk58 (\5\:RTb \7\:RTb) resistor r=0.529 c=0
Rk59 (\7\:RTb \8\:RTb) resistor r=0.7269 c=0
Rk60 (\8\:RTb \10\:RTb) resistor r=0.1205 c=0
Rk72 (\6\:qint \7\:qint) resistor r=0.2557 c=0
Rk73 (\7\:qint \8\:qint) resistor r=0.162 c=0
Rk74 (\7\:qint \10\:qint) resistor r=0.292 c=0
Rk78 (\2\:n41 \4\:n41) resistor r=0.7185 c=0
Rk26 (\2\:net426 \4\:net426) resistor r=0.556 c=0
Rk75 (\2\:n40 \4\:n40) resistor r=0.6299 c=0
Rk79 (\2\:n42 \4\:n42) resistor r=0.5338 c=0
Rl18 (\2\:CKN \4\:CKN) resistor r=193.945 c=0
Rl16 (\1\:CKN \2\:CKN) resistor r=63.1757 c=0
Rl17 (\2\:CKN \3\:CKN) resistor r=2.0166 c=0
Rl1 (\1\:RN \2\:RN) resistor r=62.3411 c=0
Rl3 (\2\:RN \4\:RN) resistor r=152.726 c=0
Rl2 (\2\:RN \3\:RN) resistor r=0.6051 c=0
Rl55 (\2\:RT \5\:RT) resistor r=741.185 c=0
Rl52 (\1\:RT \2\:RT) resistor r=0.6084 c=0
Rl57 (\3\:RT \7\:RT) resistor r=35.9829 c=0
Rl54 (\3\:RT \4\:RT) resistor r=273.346 c=0
Rl56 (\3\:RT \6\:RT) resistor r=195.631 c=0
Rl53 (\2\:RT \3\:RT) resistor r=206.132 c=0
Rl75 (\9\:SN \10\:SN) resistor r=237.735 c=0
Rl76 (\10\:SN \11\:SN) resistor r=491.014 c=0
Rl58 (\7\:SN \8\:SN) resistor r=131.297 c=0
Rl11 (\1\:SN \2\:SN) resistor r=37.2721 c=0
Rl39 (\3\:SN \4\:SN) resistor r=95.229 c=0
Rl41 (\4\:SN \6\:SN) resistor r=842.68 c=0
Rl40 (\4\:SN \5\:SN) resistor r=12.5751 c=0
Rl7 (\2\:D \4\:D) resistor r=107.406 c=0
Rl5 (\1\:D \2\:D) resistor r=149.714 c=0
Rl6 (\2\:D \3\:D) resistor r=5.1123 c=0
Rl38 (\1\:ExtVDD \2\:ExtVDD) resistor r=149.73 c=0
Rl21 (\6\:n20 \7\:n20) resistor r=136.213 c=0
Rl19 (\3\:n20 \4\:n20) resistor r=30.6172 c=0
Rl20 (\4\:n20 \5\:n20) resistor r=279.747 c=0
Rl4 (n20 \2\:n20) resistor r=283.74 c=0
Rl60 (\12\:CKNb \13\:CKNb) resistor r=195.656 c=0
Rl15 (\2\:CKNb \5\:CKNb) resistor r=95.9489 c=0
Rl13 (\2\:CKNb \3\:CKNb) resistor r=285.906 c=0
Rl12 (CKNb \2\:CKNb) resistor r=135.348 c=0
Rl14 (\3\:CKNb \4\:CKNb) resistor r=306.38 c=0
Rl47 (\6\:CKNb \7\:CKNb) resistor r=66.1349 c=0
Rl50 (\7\:CKNb \10\:CKNb) resistor r=762.322 c=0
Rl51 (\8\:CKNb \11\:CKNb) resistor r=60.7265 c=0
Rl49 (\8\:CKNb \9\:CKNb) resistor r=81.3209 c=0
Rl48 (\7\:CKNb \8\:CKNb) resistor r=462.851 c=0
Rl8 (mout \2\:mout) resistor r=24.2328 c=0
Rl9 (\3\:mout \4\:mout) resistor r=24.2328 c=0
Rl65 (\8\:RNb \9\:RNb) resistor r=234.8 c=0
Rl66 (\9\:RNb \10\:RNb) resistor r=259.682 c=0
Rl22 (RNb \2\:RNb) resistor r=62.7075 c=0
Rl23 (\3\:RNb \4\:RNb) resistor r=180.578 c=0
Rl26 (\5\:RNb \7\:RNb) resistor r=63.8867 c=0
Rl24 (\4\:RNb \5\:RNb) resistor r=55.666 c=0
Rl25 (\5\:RNb \6\:RNb) resistor r=470.821 c=0
Rl61 (\9\:CKNbb \10\:CKNbb) resistor r=130.93 c=0
Rl10 (CKNbb \2\:CKNbb) resistor r=168.841 c=0
Rl30 (\4\:CKNbb \7\:CKNbb) resistor r=127.816 c=0
Rl27 (\3\:CKNbb \4\:CKNbb) resistor r=337.866 c=0
Rl29 (\5\:CKNbb \6\:CKNbb) resistor r=215.834 c=0
Rl31 (\5\:CKNbb \8\:CKNbb) resistor r=5.1123 c=0
Rl28 (\4\:CKNbb \5\:CKNbb) resistor r=359.734 c=0
Rl35 (\3\:n35g \5\:n35g) resistor r=332.357 c=0
Rl33 (\2\:n35g \3\:n35g) resistor r=181.74 c=0
Rl34 (\2\:n35g \4\:n35g) resistor r=92.0109 c=0
Rl32 (n35g \2\:n35g) resistor r=2.4834 c=0
Rl67 (\6\:qbint \7\:qbint) resistor r=149.805 c=0
Rl72 (\11\:qbint \12\:qbint) resistor r=237.758 c=0
Rl74 (\13\:qbint \14\:qbint) resistor r=199.018 c=0
Rl46 (\3\:qbint \5\:qbint) resistor r=35.3072 c=0
Rl45 (\2\:qbint \4\:qbint) resistor r=70.093 c=0
Rl43 (qbint \2\:qbint) resistor r=112.732 c=0
Rl44 (\2\:qbint \3\:qbint) resistor r=152.601 c=0
Rl68 (\7\:qbint \8\:qbint) resistor r=99.804 c=0
Rl71 (\8\:qbint \11\:qbint) resistor r=180.657 c=0
Rl73 (\9\:qbint \13\:qbint) resistor r=89.4853 c=0
Rl70 (\9\:qbint \10\:qbint) resistor r=387.298 c=0
Rl69 (\8\:qbint \9\:qbint) resistor r=104.193 c=0
Rl59 (\3\:n35 \4\:n35) resistor r=232.465 c=0
Rl37 (n35 \2\:n35) resistor r=149.925 c=0
Rl42 (\3\:RTb \4\:RTb) resistor r=344.856 c=0
Rl36 (RTb \2\:RTb) resistor r=115.333 c=0
Rl63 (\2\:qint \3\:qint) resistor r=66.0494 c=0
Rl64 (\2\:qint \4\:qint) resistor r=75.4463 c=0
Rl62 (qint \2\:qint) resistor r=3.1216 c=0
Rz22 (\1\:Q \2\:Q) resistor r=37.5 c=0
Rz17 (\1\:QN \2\:QN) resistor r=37.5 c=0
Rz25 (\1\:VSS \2\:VSS) resistor r=75 c=0
Rz26 (\9\:VSS \10\:VSS) resistor r=75 c=0
Rz27 (\11\:VSS \12\:VSS) resistor r=75 c=0
Rz28 (\13\:VSS \14\:VSS) resistor r=37.5 c=0
Rz31 (\15\:VSS \16\:VSS) resistor r=37.5 c=0
Rz32 (\25\:VSS \26\:VSS) resistor r=75 c=0
Rz33 (\27\:VSS \28\:VSS) resistor r=37.5 c=0
Rz34 (\29\:VSS \30\:VSS) resistor r=75 c=0
Rz35 (\31\:VSS \32\:VSS) resistor r=75 c=0
Rz36 (\33\:VSS \34\:VSS) resistor r=75 c=0
Rz2 (\12\:n20 \13\:n20) resistor r=75 c=0
Rz3 (\14\:n20 \15\:n20) resistor r=75 c=0
Rz5 (\20\:CKNb \21\:CKNb) resistor r=75 c=0
Rz8 (\11\:mout \12\:mout) resistor r=75 c=0
Rz9 (\13\:mout \14\:mout) resistor r=75 c=0
Rz1 (\14\:RNb \15\:RNb) resistor r=75 c=0
Rz4 (\15\:CKNbb \16\:CKNbb) resistor r=75 c=0
Rz12 (\9\:n35g \10\:n35g) resistor r=75 c=0
Rz15 (\11\:n35g \12\:n35g) resistor r=75 c=0
Rz14 (\19\:qbint \20\:qbint) resistor r=75 c=0
Rz10 (\9\:n35 \10\:n35) resistor r=75 c=0
Rz11 (\11\:n35 \12\:n35) resistor r=75 c=0
Rz18 (\19\:n35 \20\:n35) resistor r=75 c=0
Rz16 (\6\:RTb \7\:RTb) resistor r=75 c=0
Rz19 (\5\:qint \6\:qint) resistor r=75 c=0
Rz6 (net426 \2\:net426) resistor r=75 c=0
Rz7 (\3\:net426 \4\:net426) resistor r=75 c=0
Rz20 (n40 \2\:n40) resistor r=75 c=0
Rz21 (\3\:n40 \4\:n40) resistor r=75 c=0
Rz23 (n42 \2\:n42) resistor r=75 c=0
Rz24 (\3\:n42 \4\:n42) resistor r=75 c=0
Ry20 (\3\:Q \4\:Q) resistor r=20.6667 c=0
Ry26 (\1\:VDD \2\:VDD) resistor r=62 c=0
Ry27 (\11\:VDD \12\:VDD) resistor r=20.6667 c=0
Ry28 (\13\:VDD \14\:VDD) resistor r=62 c=0
Ry29 (\15\:VDD \16\:VDD) resistor r=20.6667 c=0
Ry30 (\17\:VDD \18\:VDD) resistor r=62 c=0
Ry31 (\20\:VDD \21\:VDD) resistor r=62 c=0
Ry32 (\22\:VDD \23\:VDD) resistor r=62 c=0
Ry33 (\20\:VDD \25\:VDD) resistor r=62 c=0
Ry34 (\27\:VDD \28\:VDD) resistor r=62 c=0
Ry35 (\29\:VDD \30\:VDD) resistor r=62 c=0
Ry17 (\4\:QN \5\:QN) resistor r=20.6667 c=0
Ry23 (\3\:VSS \4\:VSS) resistor r=8.8571 c=0
Ry24 (\3\:VSS \6\:VSS) resistor r=5.1667 c=0
Ry25 (\3\:VSS \7\:VSS) resistor r=5.1667 c=0
Ry36 (\17\:VSS \18\:VSS) resistor r=8.8571 c=0
Ry37 (\17\:VSS \21\:VSS) resistor r=5.1667 c=0
Ry38 (\17\:VSS \24\:VSS) resistor r=5.1667 c=0
Ry11 (\3\:ExtVDD \4\:ExtVDD) resistor r=62 c=0
Ry12 (\6\:ExtVDD \7\:ExtVDD) resistor r=62 c=0
Ry13 (\11\:ExtVDD \12\:ExtVDD) resistor r=62 c=0
Ry2 (\8\:n20 \9\:n20) resistor r=62 c=0
Ry3 (\18\:n20 \19\:n20) resistor r=62 c=0
Ry5 (\18\:CKNb \19\:CKNb) resistor r=62 c=0
Ry6 (\5\:mout \6\:mout) resistor r=62 c=0
Ry7 (\15\:mout \16\:mout) resistor r=31 c=0
Ry1 (\11\:RNb \12\:RNb) resistor r=62 c=0
Ry4 (\12\:CKNbb \13\:CKNbb) resistor r=62 c=0
Ry10 (\7\:n35g \8\:n35g) resistor r=62 c=0
Ry15 (\15\:n35g \16\:n35g) resistor r=62 c=0
Ry14 (\17\:qbint \18\:qbint) resistor r=62 c=0
Ry8 (\5\:n35 \6\:n35) resistor r=62 c=0
Ry9 (\13\:n35 \14\:n35) resistor r=62 c=0
Ry18 (\17\:n35 \18\:n35) resistor r=62 c=0
Ry16 (\9\:RTb \10\:RTb) resistor r=62 c=0
Ry19 (\9\:qint \10\:qint) resistor r=62 c=0
Ry21 (n41 \2\:n41) resistor r=62 c=0
Ry22 (\3\:n41 \4\:n41) resistor r=62 c=0
Rx13 (\3\:CKN \6\:CKN) resistor r=45 c=0
Rx1 (\3\:RN \7\:RN) resistor r=45 c=0
Rx39 (\1\:RT \8\:RT) resistor r=45 c=0
Rx11 (\5\:SN \12\:SN) resistor r=45 c=0
Rx12 (\2\:SN \13\:SN) resistor r=45 c=0
Rx27 (\6\:SN \14\:SN) resistor r=45 c=0
Rx28 (\7\:SN \15\:SN) resistor r=45 c=0
Rx33 (\8\:SN \16\:SN) resistor r=45 c=0
Rx34 (\11\:SN \17\:SN) resistor r=45 c=0
Rx3 (\3\:D \5\:D) resistor r=45 c=0
Rx23 (\2\:ExtVDD \8\:ExtVDD) resistor r=15 c=0
Rx24 (\1\:ExtVDD \13\:ExtVDD) resistor r=45 c=0
Rx6 (\2\:n20 \10\:n20) resistor r=45 c=0
Rx7 (\5\:n20 \11\:n20) resistor r=45 c=0
Rx8 (n20 \17\:n20) resistor r=45 c=0
Rx15 (\4\:n20 \20\:n20) resistor r=45 c=0
Rx16 (\7\:n20 \21\:n20) resistor r=45 c=0
Rx4 (\4\:CKNb \14\:CKNb) resistor r=45 c=0
Rx5 (\9\:CKNb \15\:CKNb) resistor r=45 c=0
Rx14 (\2\:CKNb \16\:CKNb) resistor r=45 c=0
Rx35 (\13\:CKNb \22\:CKNb) resistor r=45 c=0
Rx36 (\10\:CKNb \23\:CKNb) resistor r=45 c=0
Rx19 (\4\:mout \10\:mout) resistor r=45 c=0
Rx20 (\2\:mout \17\:mout) resistor r=45 c=0
Rx2 (\6\:RNb \13\:RNb) resistor r=45 c=0
Rx17 (\4\:RNb \16\:RNb) resistor r=45 c=0
Rx18 (\2\:RNb \17\:RNb) resistor r=45 c=0
Rx42 (\10\:RNb \18\:RNb) resistor r=45 c=0
Rx43 (\3\:RNb \19\:RNb) resistor r=45 c=0
Rx9 (\8\:CKNbb \11\:CKNbb) resistor r=45 c=0
Rx10 (\2\:CKNbb \14\:CKNbb) resistor r=45 c=0
Rx40 (\3\:CKNbb \17\:CKNbb) resistor r=45 c=0
Rx41 (\10\:CKNbb \18\:CKNbb) resistor r=45 c=0
Rx22 (\5\:n35g \6\:n35g) resistor r=45 c=0
Rx26 (n35g \14\:n35g) resistor r=45 c=0
Rx25 (\3\:qbint \15\:qbint) resistor r=45 c=0
Rx37 (\10\:qbint \21\:qbint) resistor r=45 c=0
Rx38 (qbint \22\:qbint) resistor r=45 c=0
Rx21 (\2\:n35 \7\:n35) resistor r=45 c=0
Rx29 (\4\:n35 \15\:n35) resistor r=45 c=0
Rx30 (n35 \16\:n35) resistor r=45 c=0
Rx44 (\3\:n35 \21\:n35) resistor r=45 c=0
Rx31 (\2\:RTb \5\:RTb) resistor r=45 c=0
Rx32 (\3\:RTb \8\:RTb) resistor r=45 c=0
Rx45 (qint \8\:qint) resistor r=45 c=0
mn32 (\13\:mout \6\:n20 \3\:net426 VSS) g45n1svt w=(1.45e-07) l=4.5e-08 \
        nf=1 as=2.03e-14 ad=2.32e-14 ps=5.7e-07 pd=6.1e-07 nrd=1.16667 \
        nrs=1.16667 sa=8.3e-07 sb=1.4e-07 sd=160n sca=8.42104 \
        scb=0.00632542 scc=0.000106623 m=(1)
mn56 (\5\:qint \14\:qbint \27\:VSS VSS) g45n1svt w=(1.45e-07) l=4.5e-08 \
        nf=1 as=2.03e-14 ad=4.365e-14 ps=5.7e-07 pd=9e-07 nrd=1.16667 \
        nrs=1.16667 sa=3.75e-07 sb=1.4e-07 sd=160n sca=9.16682 \
        scb=0.00760686 scc=0.000164708 m=(1)
mn52 (n40 \12\:qbint n42 VSS) g45n1svt w=(1.45e-07) l=4.5e-08 nf=1 \
        as=2.32e-14 ad=2.32e-14 ps=6.1e-07 pd=6.1e-07 nrd=1.16667 \
        nrs=1.16667 sa=3.45e-07 sb=3.45e-07 sd=160n sca=8.42104 \
        scb=0.00632542 scc=0.000106623 m=(1)
mn21 (\15\:CKNbb CKNb \33\:VSS VSS) g45n1svt w=(1.45e-07) l=4.5e-08 nf=1 \
        as=2.32e-14 ad=2.03e-14 ps=6.1e-07 pd=5.7e-07 nrd=1.16667 \
        nrs=1.16667 sa=1.4e-07 sb=3.45e-07 sd=160n sca=8.0352 \
        scb=0.00565402 scc=8.19771e-05 m=(1)
mn50 (n42 \10\:SN \1\:VSS VSS) g45n1svt w=(1.45e-07) l=4.5e-08 nf=1 \
        as=2.03e-14 ad=2.32e-14 ps=5.7e-07 pd=6.1e-07 nrd=1.16667 \
        nrs=1.16667 sa=5.5e-07 sb=1.4e-07 sd=160n sca=8.42104 \
        scb=0.00632542 scc=0.000106623 m=(1)
mn20 (\20\:CKNb \1\:CKN \33\:VSS VSS) g45n1svt w=(1.45e-07) l=4.5e-08 \
        nf=1 as=2.03e-14 ad=2.32e-14 ps=5.7e-07 pd=6.1e-07 nrd=1.16667 \
        nrs=1.16667 sa=3.45e-07 sb=1.4e-07 sd=160n sca=8.0352 \
        scb=0.00565402 scc=8.19771e-05 m=(1)
mn45 (\6\:RTb \6\:RT \11\:VSS VSS) g45n1svt w=(1.45e-07) l=4.5e-08 nf=1 \
        as=2.03e-14 ad=3.81e-14 ps=5.7e-07 pd=8.5e-07 nrd=1.16667 \
        nrs=1.16667 sa=1.8e-07 sb=1.4e-07 sd=160n sca=8.42104 \
        scb=0.00632542 scc=0.000106623 m=(1)
mn26 (\14\:n20 CKNbb n21 VSS) g45n1svt w=(1.45e-07) l=4.5e-08 nf=1 \
        as=2.03e-14 ad=8.7e-15 ps=5.7e-07 pd=4.1e-07 nrd=1.16667 \
        nrs=1.16667 sa=1.4e-07 sb=2.45e-07 sd=160n sca=8.0352 \
        scb=0.00565402 scc=8.19771e-05 m=(1)
mn25 (n21 \1\:D \25\:VSS VSS) g45n1svt w=(1.45e-07) l=4.5e-08 nf=1 \
        as=8.7e-15 ad=2.03e-14 ps=4.1e-07 pd=5.7e-07 nrd=1.16667 \
        nrs=1.16667 sa=1.4e-07 sb=2.45e-07 sd=160n sca=8.0352 \
        scb=0.00565402 scc=8.19771e-05 m=(1)
mn30 (\3\:net426 \3\:SN \13\:VSS VSS) g45n1svt w=(1.45e-07) l=4.5e-08 \
        nf=1 as=2.32e-14 ad=4.858e-14 ps=6.1e-07 pd=9.6e-07 nrd=1.16667 \
        nrs=1.16667 sa=6.25e-07 sb=3.45e-07 sd=160n sca=8.42104 \
        scb=0.00632542 scc=0.000106623 m=(1)
mn51 (n40 \8\:RNb \3\:n42 VSS) g45n1svt w=(1.45e-07) l=4.5e-08 nf=1 \
        as=2.32e-14 ad=2.03e-14 ps=6.1e-07 pd=5.7e-07 nrd=1.16667 \
        nrs=1.16667 sa=1.4e-07 sb=5.5e-07 sd=160n sca=8.42104 \
        scb=0.00632542 scc=0.000106623 m=(1)
mn22 (\14\:RNb \4\:RN \9\:VSS VSS) g45n1svt w=(1.45e-07) l=4.5e-08 nf=1 \
        as=2.03e-14 ad=2.03e-14 ps=5.7e-07 pd=5.7e-07 nrd=1.16667 \
        nrs=1.16667 sa=1.4e-07 sb=1.4e-07 sd=160n sca=8.42104 \
        scb=0.00632542 scc=0.000106623 m=(1)
mn36 (\12\:n20 \11\:CKNb n30 VSS) g45n1svt w=(1.45e-07) l=4.5e-08 nf=1 \
        as=8.7e-15 ad=2.03e-14 ps=4.1e-07 pd=5.7e-07 nrd=1.16667 \
        nrs=1.16667 sa=1.4e-07 sb=8.3e-07 sd=160n sca=8.42104 \
        scb=0.00632542 scc=0.000106623 m=(1)
mn35 (n30 \3\:mout \13\:VSS VSS) g45n1svt w=(1.45e-07) l=4.5e-08 nf=1 \
        as=4.858e-14 ad=8.7e-15 ps=9.6e-07 pd=4.1e-07 nrd=1.16667 \
        nrs=1.16667 sa=2.45e-07 sb=7.25e-07 sd=160n sca=8.42104 \
        scb=0.00632542 scc=0.000106623 m=(1)
mn31 (\11\:mout RNb net426 VSS) g45n1svt w=(1.45e-07) l=4.5e-08 nf=1 \
        as=2.03e-14 ad=2.32e-14 ps=5.7e-07 pd=6.1e-07 nrd=1.16667 \
        nrs=1.16667 sa=1.4e-07 sb=3.45e-07 sd=160n sca=8.42104 \
        scb=0.00632542 scc=0.000106623 m=(1)
mn40 (\9\:n35 \6\:CKNb \11\:mout VSS) g45n1svt w=(1.45e-07) l=4.5e-08 \
        nf=1 as=2.32e-14 ad=2.03e-14 ps=6.1e-07 pd=5.7e-07 nrd=1.16667 \
        nrs=1.16667 sa=3.45e-07 sb=1.4e-07 sd=160n sca=8.42104 \
        scb=0.00632542 scc=0.000106623 m=(1)
NM0 (\9\:n35g RTb \11\:n35 VSS) g45n1svt w=(1.45e-07) l=4.5e-08 nf=1 \
        as=2.03e-14 ad=2.03e-14 ps=5.7e-07 pd=5.7e-07 nrd=1.16667 \
        nrs=1.16667 sa=1.4e-07 sb=1.4e-07 sd=160n sca=8.42104 \
        scb=0.00632542 scc=0.000106623 m=(1)
NM1 (\19\:qbint \4\:n35g \31\:VSS VSS) g45n1svt w=(1.45e-07) l=4.5e-08 \
        nf=1 as=2.03e-14 ad=2.03e-14 ps=5.7e-07 pd=5.7e-07 nrd=1.16667 \
        nrs=1.16667 sa=1.4e-07 sb=1.4e-07 sd=160n sca=9.33388 \
        scb=0.00788941 scc=0.00017958 m=(1)
NM3 (net0121 \5\:qbint \29\:VSS VSS) g45n1svt w=(1.45e-07) l=4.5e-08 \
        nf=1 as=2.03e-14 ad=8.7e-15 ps=5.7e-07 pd=4.1e-07 nrd=1.16667 \
        nrs=1.16667 sa=1.4e-07 sb=2.45e-07 sd=160n sca=9.33388 \
        scb=0.00788941 scc=0.00017958 m=(1)
NM2 (\11\:n35g \5\:RT net0121 VSS) g45n1svt w=(1.45e-07) l=4.5e-08 nf=1 \
        as=8.7e-15 ad=2.03e-14 ps=4.1e-07 pd=5.7e-07 nrd=1.16667 \
        nrs=1.16667 sa=2.45e-07 sb=1.4e-07 sd=160n sca=9.33388 \
        scb=0.00788941 scc=0.00017958 m=(1)
mn53 (\19\:n35 \9\:CKNbb \3\:n40 VSS) g45n1svt w=(1.45e-07) l=4.5e-08 \
        nf=1 as=2.03e-14 ad=2.03e-14 ps=5.7e-07 pd=5.7e-07 nrd=1.16667 \
        nrs=1.16667 sa=1.4e-07 sb=1.4e-07 sd=160n sca=8.42104 \
        scb=0.00632542 scc=0.000106623 m=(1)
mn57 (\1\:QN \4\:qint \27\:VSS VSS) g45n1svt w=(2.6e-07) l=4.5e-08 nf=1 \
        as=4.365e-14 ad=3.64e-14 ps=9e-07 pd=8e-07 nrd=1.16667 nrs=1.16667 \
        sa=1.4e-07 sb=2.71058e-07 sd=160n sca=9.50447 scb=0.0081528 \
        scc=0.00025289 m=(1)
mn55 (\1\:Q \6\:qbint \15\:VSS VSS) g45n1svt w=(2.6e-07) l=4.5e-08 nf=1 \
        as=3.64e-14 ad=3.64e-14 ps=8e-07 pd=8e-07 nrd=1.16667 nrs=1.16667 \
        sa=1.4e-07 sb=1.4e-07 sd=160n sca=9.50447 scb=0.0081528 \
        scc=0.00025289 m=(1)
mp55 (\3\:Q \7\:qbint \11\:VDD VDD) g45p1svt w=(3.9e-07) l=4.5e-08 nf=1 \
        as=5.46e-14 ad=5.46e-14 ps=1.06e-06 pd=1.06e-06 nrd=1.16667 \
        nrs=1.16667 sa=1.4e-07 sb=1.4e-07 sd=160n sca=21.7742 \
        scb=0.0219867 scc=0.00162318 m=(1)
mp57 (\4\:QN \3\:qint \15\:VDD VDD) g45p1svt w=(3.9e-07) l=4.5e-08 nf=1 \
        as=6.535e-14 ad=5.46e-14 ps=1.16e-06 pd=1.06e-06 nrd=1.16667 \
        nrs=1.16667 sa=1.4e-07 sb=2.69551e-07 sd=160n sca=35.5616 \
        scb=0.0384837 scc=0.00412627 m=(1)
ends RDFFNSRX1
// End of subcircuit definition.
