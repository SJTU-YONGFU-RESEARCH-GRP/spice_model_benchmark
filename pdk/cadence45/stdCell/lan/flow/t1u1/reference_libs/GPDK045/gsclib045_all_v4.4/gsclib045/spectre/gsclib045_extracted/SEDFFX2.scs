// Generated for: spectre (May  1 08:14:24 2013 )
// Library name: gsclib045
// Cell name: SEDFFX2
// View name: extracted

simulator lang=spectre

subckt SEDFFX2 CK D E Q QN SE SI VDD VSS
mp55 (\1\:Q net536 VDD VDD) g45p1svt w=(3.9e-07) l=4.5e-08 nf=1 \
        as=7.267e-14 ad=6.24e-14 ps=1.515e-06 pd=1.1e-06 nrd=1.16667 \
        nrs=1.16667 sa=1.4e-07 sb=5.03205e-07 sd=160n sca=43.6185 \
        scb=0.0386349 scc=0.00465805 m=(2)
mp57_1__rcx (\3\:QN \3\:net502 \4\:VDD VDD) g45p1svt w=(3.9e-07) \
        l=4.5e-08 nf=1 as=9.896e-14 ad=6.24e-14 ps=1.625e-06 pd=1.1e-06 \
        nrd=1.16667 nrs=1.16667 sa=3.40897e-07 sb=9.92244e-07 sd=160n \
        sca=18.3796 scb=0.0159892 scc=0.00159615 m=(2)
C1 (E VSS) capacitor c=2.72527e-17
C2 (SI VSS) capacitor c=1.20881e-16
C3 (D VSS) capacitor c=4.66502e-17
C4 (VDD VSS) capacitor c=6.15623e-16
C5 (CK VSS) capacitor c=5.07892e-17
C6 (QN VSS) capacitor c=6.61745e-17
C7 (SE VSS) capacitor c=2.71625e-17
C8 (net536 VSS) capacitor c=1.32469e-16
C9 (n30 VSS) capacitor c=4.38861e-17
C10 (net534 VSS) capacitor c=7.06727e-19
C11 (CKb VSS) capacitor c=2.12795e-17
C12 (mout VSS) capacitor c=6.53592e-17
C13 (CKbb VSS) capacitor c=6.05994e-17
C14 (n20 VSS) capacitor c=4.9817e-17
C15 (Dbp VSS) capacitor c=1.02232e-16
C16 (net502 VSS) capacitor c=4.0915e-17
C17 (net546 VSS) capacitor c=2.28169e-18
C18 (Db VSS) capacitor c=9.04222e-17
C19 (SEb VSS) capacitor c=4.80241e-17
C20 (net514 VSS) capacitor c=1.93422e-18
C21 (Eb VSS) capacitor c=3.95431e-17
C22 (net457 VSS) capacitor c=8.85234e-19
C23 (net437 VSS) capacitor c=1.06974e-18
C24 (net465 VSS) capacitor c=5.22461e-19
C25 (net425 VSS) capacitor c=5.02212e-18
C26 (\5\:E VSS) capacitor c=3.91443e-17
C27 (\1\:D VSS) capacitor c=5.38226e-17
C28 (\1\:E VSS) capacitor c=5.20435e-17
C29 (\5\:SE VSS) capacitor c=3.31838e-17
C30 (\6\:SE VSS) capacitor c=4.03911e-17
C31 (\2\:SEb VSS) capacitor c=6.39862e-17
C32 (\1\:SI VSS) capacitor c=6.12623e-17
C33 (\1\:CK VSS) capacitor c=3.18242e-17
C34 (\11\:net536 VSS) capacitor c=6.29425e-17
C35 (\6\:CKb VSS) capacitor c=4.11422e-17
C36 (\7\:CKbb VSS) capacitor c=3.90404e-17
C37 (\7\:CKb VSS) capacitor c=1.52378e-16
C38 (\8\:CKb VSS) capacitor c=1.21243e-16
C39 (\9\:net536 VSS) capacitor c=4.54976e-17
C40 (\3\:n30 VSS) capacitor c=5.19643e-17
C41 (\7\:E VSS) capacitor c=2.15805e-17
C42 (\3\:D VSS) capacitor c=4.06524e-17
C43 (\3\:E VSS) capacitor c=5.02822e-17
C44 (\3\:Eb VSS) capacitor c=1.04678e-16
C45 (\6\:net502 VSS) capacitor c=5.34955e-17
C46 (\1\:SE VSS) capacitor c=3.83053e-17
C47 (\3\:SEb VSS) capacitor c=2.15493e-17
C48 (\4\:SE VSS) capacitor c=4.9197e-17
C49 (\4\:SI VSS) capacitor c=3.93335e-17
C50 (\3\:CK VSS) capacitor c=3.4692e-17
C51 (\13\:net536 VSS) capacitor c=3.35962e-17
C52 (\5\:CKb VSS) capacitor c=1.97839e-17
C53 (\5\:CKbb VSS) capacitor c=8.07977e-17
C54 (\3\:mout VSS) capacitor c=6.80828e-17
C55 (\3\:n20 VSS) capacitor c=3.10018e-17
C56 (\3\:CKbb VSS) capacitor c=5.82816e-17
C57 (\9\:CKb VSS) capacitor c=1.0604e-16
C58 (\8\:net536 VSS) capacitor c=8.09696e-17
C59 (\6\:E VSS) capacitor c=3.36801e-17
C60 (\2\:D VSS) capacitor c=4.89175e-17
C61 (\2\:Eb VSS) capacitor c=9.74812e-17
C62 (\4\:E VSS) capacitor c=4.33918e-17
C63 (\2\:E VSS) capacitor c=4.1894e-17
C64 (\5\:net502 VSS) capacitor c=2.69609e-17
C65 (\2\:SE VSS) capacitor c=6.42189e-17
C66 (\5\:SEb VSS) capacitor c=3.95014e-17
C67 (\4\:SEb VSS) capacitor c=4.25699e-17
C68 (\3\:SI VSS) capacitor c=2.61903e-17
C69 (\2\:CK VSS) capacitor c=3.05381e-17
C70 (\2\:CKb VSS) capacitor c=1.52831e-17
C71 (\12\:net536 VSS) capacitor c=3.77085e-17
C72 (\8\:CKbb VSS) capacitor c=4.95114e-17
C73 (\6\:CKbb VSS) capacitor c=2.46095e-17
C74 (\2\:mout VSS) capacitor c=5.71521e-17
C75 (\2\:n20 VSS) capacitor c=3.44789e-17
C76 (\4\:CKbb VSS) capacitor c=2.28099e-17
C77 (\2\:CKbb VSS) capacitor c=6.24344e-17
C78 (\10\:net536 VSS) capacitor c=2.65484e-17
C79 (\4\:n30 VSS) capacitor c=2.25681e-17
C80 (\6\:net536 VSS) capacitor c=2.22908e-17
C81 (\8\:Eb VSS) capacitor c=1.65054e-17
C82 (\16\:VDD VSS) capacitor c=3.03409e-17
C83 (\6\:Db VSS) capacitor c=2.78948e-17
C84 (\3\:QN VSS) capacitor c=4.56745e-18
C85 (\8\:SEb VSS) capacitor c=9.1777e-17
C86 (\4\:Db VSS) capacitor c=2.09814e-16
C87 (\7\:Dbp VSS) capacitor c=3.1228e-17
C88 (\22\:VDD VSS) capacitor c=2.6407e-17
C89 (\14\:CKb VSS) capacitor c=5.03024e-17
C90 (\14\:net502 VSS) capacitor c=7.74133e-17
C91 (\24\:VDD VSS) capacitor c=5.95741e-17
C92 (\9\:CKbb VSS) capacitor c=5.86161e-17
C93 (\5\:Dbp VSS) capacitor c=3.14719e-17
C94 (\4\:n20 VSS) capacitor c=5.52853e-17
C95 (\26\:VDD VSS) capacitor c=6.72167e-17
C96 (\8\:mout VSS) capacitor c=5.72435e-17
C97 (\9\:n30 VSS) capacitor c=3.04869e-17
C98 (\28\:VDD VSS) capacitor c=3.11857e-17
C99 (\16\:net536 VSS) capacitor c=5.93946e-17
C100 (\1\:Q VSS) capacitor c=6.67255e-17
C101 (\1\:VDD VSS) capacitor c=1.00085e-16
C102 (\4\:Eb VSS) capacitor c=6.45169e-17
C103 (\1\:QN VSS) capacitor c=6.5862e-17
C104 (\11\:SEb VSS) capacitor c=4.58593e-17
C105 (\8\:Db VSS) capacitor c=1.2746e-16
C106 (\10\:CKb VSS) capacitor c=1.12793e-16
C107 (\12\:net502 VSS) capacitor c=3.61766e-16
C108 (\11\:CKbb VSS) capacitor c=7.68975e-17
C109 (\9\:Dbp VSS) capacitor c=7.18625e-17
C110 (\8\:n20 VSS) capacitor c=3.95066e-17
C111 (\6\:mout VSS) capacitor c=4.86725e-17
C112 (\5\:n30 VSS) capacitor c=6.95044e-17
C113 (\20\:net536 VSS) capacitor c=2.62325e-17
C114 (\3\:Q VSS) capacitor c=3.1524e-17
C115 (\2\:n30 VSS) capacitor c=2.53756e-17
C116 (\3\:CKb VSS) capacitor c=1.65651e-17
C117 (\4\:CKb VSS) capacitor c=6.16144e-17
C118 (\2\:SI VSS) capacitor c=4.05176e-17
C119 (\3\:SE VSS) capacitor c=9.23408e-17
C120 (\2\:net502 VSS) capacitor c=4.24947e-17
C121 (\3\:net502 VSS) capacitor c=1.26637e-16
C122 (\7\:n30 VSS) capacitor c=1.11125e-16
C123 (\8\:n30 VSS) capacitor c=6.41847e-17
C124 (\4\:mout VSS) capacitor c=7.07795e-17
C125 (\5\:mout VSS) capacitor c=6.74186e-17
C126 (\6\:n20 VSS) capacitor c=6.05771e-17
C127 (\7\:n20 VSS) capacitor c=5.87255e-17
C128 (\14\:net536 VSS) capacitor c=1.85887e-16
C129 (\15\:net536 VSS) capacitor c=2.32154e-16
C130 (\18\:net536 VSS) capacitor c=2.12504e-17
C131 (\19\:net536 VSS) capacitor c=2.23802e-17
C132 (\22\:net536 VSS) capacitor c=1.92473e-17
C133 (\13\:CKbb VSS) capacitor c=7.11877e-17
C134 (\14\:CKbb VSS) capacitor c=7.90682e-17
C135 (\15\:CKbb VSS) capacitor c=9.44218e-17
C136 (\16\:CKbb VSS) capacitor c=9.61365e-17
C137 (\17\:CKbb VSS) capacitor c=8.13413e-17
C138 (\12\:CKb VSS) capacitor c=1.65074e-16
C139 (\13\:CKb VSS) capacitor c=1.0565e-16
C140 (\4\:CK VSS) capacitor c=5.5839e-17
C141 (\3\:Dbp VSS) capacitor c=2.55434e-16
C142 (\4\:Dbp VSS) capacitor c=2.38759e-16
C143 (\6\:SEb VSS) capacitor c=6.57898e-17
C144 (\7\:SEb VSS) capacitor c=8.24585e-17
C145 (\10\:SEb VSS) capacitor c=1.11869e-16
C146 (\7\:SE VSS) capacitor c=4.84069e-17
C147 (\11\:net502 VSS) capacitor c=3.77417e-16
C148 (\3\:Db VSS) capacitor c=1.88901e-16
C149 (\4\:D VSS) capacitor c=8.52457e-17
C150 (\8\:E VSS) capacitor c=6.23039e-17
C151 (\9\:E VSS) capacitor c=1.08622e-16
C152 (\10\:E VSS) capacitor c=6.70769e-17
C153 (\6\:Eb VSS) capacitor c=7.89991e-17
C154 (\7\:Eb VSS) capacitor c=8.87308e-17
C155 (\3\:VDD VSS) capacitor c=1.87359e-17
C156 (\4\:VDD VSS) capacitor c=1.2345e-16
C157 (\7\:VDD VSS) capacitor c=5.39648e-17
C158 (\9\:VDD VSS) capacitor c=4.12271e-17
C159 (\10\:VDD VSS) capacitor c=5.224e-17
C160 (\12\:VDD VSS) capacitor c=8.31071e-18
Rk47 (\8\:E \9\:E) resistor r=0.3108 c=0
Rk49 (\10\:E E) resistor r=0.02815 c=0
Rk48 (\9\:E \10\:E) resistor r=0.5273 c=0
Rk28 (SI \5\:SI) resistor r=0.009678 c=0
Rk74 (\2\:VSS \3\:VSS) resistor r=0.233 c=0
Rk75 (\3\:VSS \4\:VSS) resistor r=0.3357 c=0
Rk77 (\3\:VSS \7\:VSS) resistor r=0.2664 c=0
Rk79 (\4\:VSS \10\:VSS) resistor r=0.8205 c=0
Rk80 (\10\:VSS \11\:VSS) resistor r=0.3835 c=0
Rk81 (\11\:VSS \12\:VSS) resistor r=0.223 c=0
Rk82 (\12\:VSS \13\:VSS) resistor r=0.6115 c=0
Rk83 (\13\:VSS \14\:VSS) resistor r=0.3685 c=0
Rk85 (\15\:VSS VSS) resistor r=0.2429 c=0
Rk84 (\14\:VSS \15\:VSS) resistor r=0.1001 c=0
Rk88 (\10\:VSS \20\:VSS) resistor r=0.2986 c=0
Rk89 (\12\:VSS \22\:VSS) resistor r=0.4021 c=0
Rk90 (\13\:VSS \24\:VSS) resistor r=0.1427 c=0
Rk91 (\15\:VSS \26\:VSS) resistor r=0.07393 c=0
Rk46 (D \4\:D) resistor r=0.01623 c=0
Rk1 (\2\:Q Q) resistor r=0.3171 c=0
Rk2 (Q \4\:Q) resistor r=0.0543 c=0
Rk53 (\2\:VDD \3\:VDD) resistor r=0.1804 c=0
Rk54 (\3\:VDD \4\:VDD) resistor r=0.4084 c=0
Rk57 (\4\:VDD \7\:VDD) resistor r=0.7961 c=0
Rk58 (\7\:VDD \8\:VDD) resistor r=0.3324 c=0
Rk59 (\8\:VDD \9\:VDD) resistor r=0.2556 c=0
Rk60 (\9\:VDD \10\:VDD) resistor r=0.5789 c=0
Rk61 (\10\:VDD \11\:VDD) resistor r=0.3685 c=0
Rk63 (\12\:VDD VDD) resistor r=0.1777 c=0
Rk62 (\11\:VDD \12\:VDD) resistor r=0.1503 c=0
Rk66 (\3\:VDD \17\:VDD) resistor r=0.2677 c=0
Rk69 (\7\:VDD \23\:VDD) resistor r=0.04331 c=0
Rk70 (\9\:VDD \25\:VDD) resistor r=0.2783 c=0
Rk71 (\10\:VDD \27\:VDD) resistor r=0.3012 c=0
Rk72 (\12\:VDD \29\:VDD) resistor r=0.1831 c=0
Rk27 (\4\:CK CK) resistor r=0.1151 c=0
Rk41 (\4\:QN QN) resistor r=0.01535 c=0
Rk40 (\2\:QN \4\:QN) resistor r=0.3371 c=0
Rk37 (SE \7\:SE) resistor r=0.04597 c=0
Rk12 (\14\:net536 \15\:net536) resistor r=1.578 c=0
Rk13 (\15\:net536 \17\:net536) resistor r=0.5162 c=0
Rk14 (\15\:net536 \18\:net536) resistor r=0.04992 c=0
Rk15 (\17\:net536 \19\:net536) resistor r=0.1996 c=0
Rk16 (\19\:net536 \21\:net536) resistor r=0.1682 c=0
Rk17 (\19\:net536 \22\:net536) resistor r=0.1014 c=0
Rk3 (\6\:n30 \7\:n30) resistor r=0.3431 c=0
Rk4 (\7\:n30 \8\:n30) resistor r=0.4995 c=0
Rk5 (\7\:n30 \10\:n30) resistor r=0.04586 c=0
Rk24 (\11\:CKb \12\:CKb) resistor r=0.6931 c=0
Rk25 (\12\:CKb \13\:CKb) resistor r=0.7748 c=0
Rk26 (\12\:CKb \15\:CKb) resistor r=0.2244 c=0
Rk6 (\4\:mout \5\:mout) resistor r=0.3294 c=0
Rk7 (\5\:mout \7\:mout) resistor r=0.2592 c=0
Rk8 (\5\:mout \9\:mout) resistor r=0.1845 c=0
Rk18 (\10\:CKbb \12\:CKbb) resistor r=0.3349 c=0
Rk19 (\12\:CKbb \13\:CKbb) resistor r=0.4311 c=0
Rk20 (\13\:CKbb \14\:CKbb) resistor r=0.2104 c=0
Rk21 (\14\:CKbb \15\:CKbb) resistor r=0.5657 c=0
Rk22 (\15\:CKbb \16\:CKbb) resistor r=0.5367 c=0
Rk23 (\13\:CKbb \17\:CKbb) resistor r=0.3812 c=0
Rk9 (\5\:n20 \6\:n20) resistor r=0.2952 c=0
Rk10 (\6\:n20 \7\:n20) resistor r=0.3078 c=0
Rk11 (\6\:n20 \9\:n20) resistor r=0.1279 c=0
Rk29 (\2\:Dbp \3\:Dbp) resistor r=0.6485 c=0
Rk30 (\3\:Dbp \4\:Dbp) resistor r=1.7477 c=0
Rk31 (\4\:Dbp \6\:Dbp) resistor r=0.1026 c=0
Rk32 (\3\:Dbp \8\:Dbp) resistor r=0.1015 c=0
Rk33 (\4\:Dbp \10\:Dbp) resistor r=0.3953 c=0
Rk38 (\11\:net502 \13\:net502) resistor r=2.8719 c=0
Rk39 (\13\:net502 \15\:net502) resistor r=0.4359 c=0
Rk42 (\2\:Db \3\:Db) resistor r=0.6775 c=0
Rk43 (\3\:Db \5\:Db) resistor r=1.246 c=0
Rk44 (\3\:Db \7\:Db) resistor r=0.1514 c=0
Rk45 (\5\:Db \9\:Db) resistor r=0.7318 c=0
Rk34 (\6\:SEb \7\:SEb) resistor r=0.3253 c=0
Rk35 (\9\:SEb \10\:SEb) resistor r=0.4384 c=0
Rk36 (\10\:SEb \12\:SEb) resistor r=0.2412 c=0
Rk50 (\5\:Eb \6\:Eb) resistor r=0.5107 c=0
Rk51 (\6\:Eb \7\:Eb) resistor r=0.5634 c=0
Rk52 (\6\:Eb \9\:Eb) resistor r=0.2315 c=0
Rl58 (\5\:E \6\:E) resistor r=171.846 c=0
Rl59 (\6\:E \7\:E) resistor r=35.3072 c=0
Rl53 (\3\:E \4\:E) resistor r=35.5399 c=0
Rl52 (\1\:E \2\:E) resistor r=24.2328 c=0
Rl32 (\1\:SI \2\:SI) resistor r=68.1104 c=0
Rl34 (\2\:SI \4\:SI) resistor r=131.572 c=0
Rl33 (\2\:SI \3\:SI) resistor r=10.9341 c=0
Rl56 (\1\:D \2\:D) resistor r=123.077 c=0
Rl57 (\2\:D \3\:D) resistor r=85.989 c=0
Rl30 (\1\:CK \2\:CK) resistor r=50.6918 c=0
Rl31 (\2\:CK \3\:CK) resistor r=133.384 c=0
Rl41 (\2\:SE \5\:SE) resistor r=58.4251 c=0
Rl38 (\1\:SE \2\:SE) resistor r=74.7951 c=0
Rl42 (\3\:SE \6\:SE) resistor r=101.157 c=0
Rl40 (\3\:SE \4\:SE) resistor r=156.492 c=0
Rl39 (\2\:SE \3\:SE) resistor r=316.222 c=0
Rl29 (\13\:net536 \11\:net536) resistor r=92.3077 c=0
Rl10 (\8\:net536 \9\:net536) resistor r=172.643 c=0
Rl28 (\12\:net536 \11\:net536) resistor r=251.9 c=0
Rl11 (\10\:net536 \9\:net536) resistor r=24.2328 c=0
Rl5 (net536 \6\:net536) resistor r=9.5287 c=0
Rl8 (\2\:n30 \3\:n30) resistor r=47.0949 c=0
Rl7 (n30 \2\:n30) resistor r=41.6119 c=0
Rl9 (\2\:n30 \4\:n30) resistor r=65.7849 c=0
Rl26 (\7\:CKb \8\:CKb) resistor r=403.412 c=0
Rl27 (\8\:CKb \9\:CKb) resistor r=210.67 c=0
Rl20 (CKb \2\:CKb) resistor r=40.3846 c=0
Rl24 (\3\:CKb \6\:CKb) resistor r=25.6632 c=0
Rl21 (\2\:CKb \3\:CKb) resistor r=9.4946 c=0
Rl25 (\4\:CKb \7\:CKb) resistor r=247.62 c=0
Rl23 (\4\:CKb \5\:CKb) resistor r=34.2969 c=0
Rl22 (\3\:CKb \4\:CKb) resistor r=150.721 c=0
Rl16 (mout \2\:mout) resistor r=49.2328 c=0
Rl17 (\2\:mout \3\:mout) resistor r=89.6174 c=0
Rl19 (\7\:CKbb \8\:CKbb) resistor r=58.3841 c=0
Rl18 (\5\:CKbb \6\:CKbb) resistor r=41.5405 c=0
Rl13 (\3\:CKbb \4\:CKbb) resistor r=41.5405 c=0
Rl12 (CKbb \2\:CKbb) resistor r=62.2302 c=0
Rl14 (n20 \2\:n20) resistor r=112.23 c=0
Rl15 (\2\:n20 \3\:n20) resistor r=29.5379 c=0
Rl43 (\2\:net502 net502) resistor r=105.003 c=0
Rl47 (\2\:net502 \6\:net502) resistor r=124.234 c=0
Rl46 (\3\:net502 \5\:net502) resistor r=3.6042 c=0
Rl44 (\3\:net502 \2\:net502) resistor r=91.3077 c=0
Rl36 (\3\:SEb \4\:SEb) resistor r=35.3482 c=0
Rl37 (\4\:SEb \5\:SEb) resistor r=107.617 c=0
Rl35 (SEb \2\:SEb) resistor r=55.01 c=0
Rl54 (Eb \2\:Eb) resistor r=24.2328 c=0
Rl55 (\2\:Eb \3\:Eb) resistor r=264.183 c=0
Rz20 (\7\:VSS \6\:VSS) resistor r=75 c=0
Rz23 (\20\:VSS \19\:VSS) resistor r=75 c=0
Rz24 (\22\:VSS \21\:VSS) resistor r=75 c=0
Rz25 (\24\:VSS \23\:VSS) resistor r=75 c=0
Rz26 (\26\:VSS \25\:VSS) resistor r=75 c=0
Rz1 (\4\:Q \3\:Q) resistor r=75 c=0
Rz16 (\2\:VDD \1\:VDD) resistor r=25 c=0
Rz17 (\4\:VDD \1\:VDD) resistor r=6.25 c=0
Rz18 (\8\:VDD \1\:VDD) resistor r=6.25 c=0
Rz19 (\11\:VDD \1\:VDD) resistor r=6.25 c=0
Rz12 (\2\:QN \1\:QN) resistor r=75 c=0
Rz5 (\21\:net536 \20\:net536) resistor r=75 c=0
Rz2 (\5\:n30 \6\:n30) resistor r=75 c=0
Rz7 (\10\:CKb \11\:CKb) resistor r=75 c=0
Rz3 (\6\:mout \7\:mout) resistor r=75 c=0
Rz6 (\11\:CKbb \12\:CKbb) resistor r=75 c=0
Rz4 (\8\:n20 \9\:n20) resistor r=75 c=0
Rz8 (Dbp \2\:Dbp) resistor r=75 c=0
Rz9 (\9\:Dbp \10\:Dbp) resistor r=75 c=0
Rz11 (\13\:net502 \12\:net502) resistor r=75 c=0
Rz13 (Db \2\:Db) resistor r=75 c=0
Rz14 (\8\:Db \9\:Db) resistor r=75 c=0
Rz10 (\11\:SEb \12\:SEb) resistor r=75 c=0
Rz15 (\4\:Eb \5\:Eb) resistor r=75 c=0
Ry25 (\2\:VSS \1\:VSS) resistor r=20.6667 c=0
Ry26 (\4\:VSS \1\:VSS) resistor r=5.1667 c=0
Ry27 (\11\:VSS \1\:VSS) resistor r=5.1667 c=0
Ry28 (\14\:VSS \1\:VSS) resistor r=5.1667 c=0
Ry1 (\2\:Q \1\:Q) resistor r=20.6667 c=0
Ry17 (\17\:VDD \16\:VDD) resistor r=62 c=0
Ry20 (\23\:VDD \22\:VDD) resistor r=62 c=0
Ry21 (\25\:VDD \24\:VDD) resistor r=62 c=0
Ry22 (\27\:VDD \26\:VDD) resistor r=62 c=0
Ry23 (\29\:VDD \28\:VDD) resistor r=62 c=0
Ry12 (\4\:QN \3\:QN) resistor r=62 c=0
Ry5 (\17\:net536 \16\:net536) resistor r=62 c=0
Ry2 (\9\:n30 \10\:n30) resistor r=62 c=0
Ry7 (\14\:CKb \15\:CKb) resistor r=62 c=0
Ry3 (\8\:mout \9\:mout) resistor r=62 c=0
Ry6 (\9\:CKbb \10\:CKbb) resistor r=62 c=0
Ry4 (\4\:n20 \5\:n20) resistor r=62 c=0
Ry8 (\5\:Dbp \6\:Dbp) resistor r=62 c=0
Ry9 (\7\:Dbp \8\:Dbp) resistor r=62 c=0
Ry11 (\15\:net502 \14\:net502) resistor r=62 c=0
Ry13 (\4\:Db \5\:Db) resistor r=62 c=0
Ry14 (\6\:Db \7\:Db) resistor r=62 c=0
Ry10 (\8\:SEb \9\:SEb) resistor r=62 c=0
Ry15 (\8\:Eb \9\:Eb) resistor r=62 c=0
Rx20 (\2\:E \8\:E) resistor r=45 c=0
Rx21 (\4\:E \9\:E) resistor r=45 c=0
Rx22 (\6\:E \10\:E) resistor r=45 c=0
Rx13 (\3\:SI \5\:SI) resistor r=45 c=0
Rx19 (\2\:D \4\:D) resistor r=45 c=0
Rx12 (\2\:CK \4\:CK) resistor r=45 c=0
Rx17 (\2\:SE \7\:SE) resistor r=45 c=0
Rx4 (\14\:net536 \12\:net536) resistor r=45 c=0
Rx5 (\18\:net536 \10\:net536) resistor r=45 c=0
Rx6 (\22\:net536 \6\:net536) resistor r=45 c=0
Rx1 (\4\:n30 \8\:n30) resistor r=45 c=0
Rx11 (\2\:CKb \13\:CKb) resistor r=45 c=0
Rx2 (\2\:mout \4\:mout) resistor r=45 c=0
Rx7 (\6\:CKbb \14\:CKbb) resistor r=45 c=0
Rx8 (\4\:CKbb \15\:CKbb) resistor r=45 c=0
Rx9 (\2\:CKbb \16\:CKbb) resistor r=45 c=0
Rx10 (\8\:CKbb \17\:CKbb) resistor r=45 c=0
Rx3 (\2\:n20 \7\:n20) resistor r=45 c=0
Rx18 (\11\:net502 \5\:net502) resistor r=45 c=0
Rx14 (\4\:SEb \6\:SEb) resistor r=45 c=0
Rx15 (SEb \7\:SEb) resistor r=45 c=0
Rx16 (\5\:SEb \10\:SEb) resistor r=45 c=0
Rx23 (\2\:Eb \7\:Eb) resistor r=45 c=0
mn55_1__rcx (\3\:Q net536 VSS VSS) g45n1svt w=(2.6e-07) l=4.5e-08 nf=1 \
        as=4.153e-14 ad=4.16e-14 ps=8.5e-07 pd=8.4e-07 nrd=1.16667 \
        nrs=1.16667 sa=1.4e-07 sb=5.17212e-07 sd=160n sca=17.5885 \
        scb=0.0172826 scc=0.00162584 m=(2)
mn57_1__rcx (\1\:QN \3\:net502 \4\:VSS VSS) g45n1svt w=(2.6e-07) \
        l=4.5e-08 nf=1 as=5.998e-14 ad=4.16e-14 ps=1.185e-06 pd=8.4e-07 \
        nrd=1.16667 nrs=1.16667 sa=3.51923e-07 sb=1.01365e-06 sd=160n \
        sca=8.65991 scb=0.00681295 scc=0.000165238 m=(2)
mn45 (\20\:net536 n30 VSS VSS) g45n1svt w=(2.05e-07) l=4.5e-08 nf=1 \
        as=4.665e-14 ad=2.53e-14 ps=9e-07 pd=6.9e-07 nrd=1.16667 \
        nrs=1.16667 sa=5.8e-07 sb=1.23415e-07 sd=160n sca=19.867 \
        scb=0.0198061 scc=0.00201945 m=(1)
mn50 (net534 \8\:net536 \25\:VSS VSS) g45n1svt w=(1.45e-07) l=4.5e-08 \
        nf=1 as=4.465e-14 ad=1.015e-14 ps=1.5e-06 pd=4.3e-07 nrd=1.16667 \
        nrs=1.16667 sa=1e-07 sb=1.54e-06 sd=160n sca=23.279 scb=0.0230742 \
        scc=0.00267719 m=(1)
mn51 (\5\:n30 \9\:CKb net534 VSS) g45n1svt w=(1.45e-07) l=4.5e-08 nf=1 \
        as=1.015e-14 ad=2.32e-14 ps=4.3e-07 pd=6.1e-07 nrd=1.16667 \
        nrs=1.16667 sa=2.15e-07 sb=1.425e-06 sd=160n sca=23.279 \
        scb=0.0230742 scc=0.00267719 m=(1)
mn40 (\6\:mout \3\:CKbb \5\:n30 VSS) g45n1svt w=(1.45e-07) l=4.5e-08 nf=1 \
        as=2.32e-14 ad=3.988e-14 ps=6.1e-07 pd=8.4e-07 nrd=1.16667 \
        nrs=1.16667 sa=4.2e-07 sb=1.22e-06 sd=160n sca=23.279 \
        scb=0.0230742 scc=0.00267719 m=(1)
mn30 (\6\:mout \3\:n20 \23\:VSS VSS) g45n1svt w=(1.45e-07) l=4.5e-08 \
        nf=1 as=7.09e-14 ad=3.988e-14 ps=1.38e-06 pd=8.4e-07 nrd=1.16667 \
        nrs=1.16667 sa=7.4e-07 sb=9e-07 sd=160n sca=23.279 scb=0.0230742 \
        scc=0.00267719 m=(1)
mn35 (net526 \3\:mout \23\:VSS VSS) g45n1svt w=(1.45e-07) l=4.5e-08 nf=1 \
        as=7.09e-14 ad=8.7e-15 ps=1.38e-06 pd=4.1e-07 nrd=1.16667 \
        nrs=1.16667 sa=1.005e-06 sb=6.35e-07 sd=160n sca=23.279 \
        scb=0.0230742 scc=0.00267719 m=(1)
mn36 (\8\:n20 \5\:CKbb net526 VSS) g45n1svt w=(1.45e-07) l=4.5e-08 nf=1 \
        as=8.7e-15 ad=5.003e-14 ps=4.1e-07 pd=9.8e-07 nrd=1.16667 \
        nrs=1.16667 sa=1.11e-06 sb=5.3e-07 sd=160n sca=23.279 \
        scb=0.0230742 scc=0.00267719 m=(1)
mn25 (\9\:Dbp \5\:CKb \8\:n20 VSS) g45n1svt w=(1.45e-07) l=4.5e-08 nf=1 \
        as=5.003e-14 ad=2.03e-14 ps=9.8e-07 pd=5.7e-07 nrd=1.16667 \
        nrs=1.16667 sa=1.5e-06 sb=1.4e-07 sd=160n sca=23.279 scb=0.0230742 \
        scc=0.00267719 m=(1)
mn21 (\11\:CKbb CKb \21\:VSS VSS) g45n1svt w=(1.45e-07) l=4.5e-08 nf=1 \
        as=2.32e-14 ad=2.03e-14 ps=6.1e-07 pd=5.7e-07 nrd=1.16667 \
        nrs=1.16667 sa=1.4e-07 sb=3.45e-07 sd=160n sca=23.279 \
        scb=0.0230742 scc=0.00267719 m=(1)
mn56 (\12\:net502 \13\:net536 \21\:VSS VSS) g45n1svt w=(1.45e-07) \
        l=4.5e-08 nf=1 as=2.32e-14 ad=2.03e-14 ps=6.1e-07 pd=5.7e-07 \
        nrd=1.16667 nrs=1.16667 sa=3.45e-07 sb=1.4e-07 sd=160n sca=23.279 \
        scb=0.0230742 scc=0.00267719 m=(1)
mn20 (\10\:CKb \3\:CK \19\:VSS VSS) g45n1svt w=(1.45e-07) l=4.5e-08 nf=1 \
        as=4.205e-14 ad=2.248e-14 ps=8.7e-07 pd=6e-07 nrd=1.16667 \
        nrs=1.16667 sa=1.55e-07 sb=9.4e-07 sd=160n sca=10.2779 \
        scb=0.00944477 scc=0.000275883 m=(1)
mn12 (net546 \4\:SI \19\:VSS VSS) g45n1svt w=(1.45e-07) l=4.5e-08 nf=1 \
        as=4.205e-14 ad=1.957e-14 ps=8.7e-07 pd=5.6e-07 nrd=1.16667 \
        nrs=1.16667 sa=4.9e-07 sb=6.05e-07 sd=160n sca=10.2779 \
        scb=0.00944477 scc=0.000275883 m=(1)
mn13 (Dbp \4\:SE net546 VSS) g45n1svt w=(1.45e-07) l=4.5e-08 nf=1 \
        as=1.957e-14 ad=3.48e-14 ps=5.6e-07 pd=7.7e-07 nrd=1.16667 \
        nrs=1.16667 sa=6.7e-07 sb=4.25e-07 sd=160n sca=10.2779 \
        scb=0.00944477 scc=0.000275883 m=(1)
mn11 (\8\:Db \3\:SEb Dbp VSS) g45n1svt w=(1.45e-07) l=4.5e-08 nf=1 \
        as=3.48e-14 ad=2.03e-14 ps=7.7e-07 pd=5.7e-07 nrd=1.16667 \
        nrs=1.16667 sa=9.55e-07 sb=1.4e-07 sd=160n sca=10.2779 \
        scb=0.00944477 scc=0.000275883 m=(1)
mn10 (\11\:SEb \1\:SE \4\:VSS VSS) g45n1svt w=(1.45e-07) l=4.5e-08 nf=1 \
        as=5.235e-14 ad=3.263e-14 ps=1.02e-06 pd=7.4e-07 nrd=1.16667 \
        nrs=1.16667 sa=2.25e-07 sb=1.835e-06 sd=160n sca=10.2779 \
        scb=0.00944477 scc=0.000275883 m=(1)
mn1 (net514 \6\:net502 \4\:VSS VSS) g45n1svt w=(1.45e-07) l=4.5e-08 nf=1 \
        as=6.76e-14 ad=8.7e-15 ps=1.35e-06 pd=4.1e-07 nrd=1.16667 \
        nrs=1.16667 sa=9.8e-07 sb=1.08e-06 sd=160n sca=10.2779 \
        scb=0.00944477 scc=0.000275883 m=(1)
mn2 (Db \3\:Eb net514 VSS) g45n1svt w=(1.45e-07) l=4.5e-08 nf=1 \
        as=8.7e-15 ad=2.465e-14 ps=4.1e-07 pd=6.3e-07 nrd=1.16667 \
        nrs=1.16667 sa=1.085e-06 sb=9.75e-07 sd=160n sca=10.2779 \
        scb=0.00944477 scc=0.000275883 m=(1)
mn4 (Db \3\:E net554 VSS) g45n1svt w=(1.45e-07) l=4.5e-08 nf=1 \
        as=1.595e-14 ad=2.465e-14 ps=5.1e-07 pd=6.3e-07 nrd=1.16667 \
        nrs=1.16667 sa=1.3e-06 sb=7.6e-07 sd=160n sca=10.2779 \
        scb=0.00944477 scc=0.000275883 m=(1)
mn3 (net554 \3\:D \6\:VSS VSS) g45n1svt w=(1.45e-07) l=4.5e-08 nf=1 \
        as=6.09e-14 ad=1.595e-14 ps=1.13e-06 pd=5.1e-07 nrd=1.16667 \
        nrs=1.16667 sa=1.455e-06 sb=6.05e-07 sd=160n sca=10.2779 \
        scb=0.00944477 scc=0.000275883 m=(1)
mn0 (\4\:Eb \7\:E \6\:VSS VSS) g45n1svt w=(1.45e-07) l=4.5e-08 nf=1 \
        as=6.09e-14 ad=2.03e-14 ps=1.13e-06 pd=5.7e-07 nrd=1.16667 \
        nrs=1.16667 sa=1.92e-06 sb=1.4e-07 sd=160n sca=10.2779 \
        scb=0.00944477 scc=0.000275883 m=(1)
mp45 (\16\:net536 \3\:n30 VDD VDD) g45p1svt w=(3.1e-07) l=4.5e-08 nf=1 \
        as=9.075e-14 ad=3.7e-14 ps=1.97e-06 pd=9e-07 nrd=1.16667 \
        nrs=1.16667 sa=5.75e-07 sb=1.19355e-07 sd=160n sca=36.7709 \
        scb=0.0239974 scc=0.00420525 m=(1)
mp50 (net457 \9\:net536 \28\:VDD VDD) g45p1svt w=(2.15e-07) l=4.5e-08 \
        nf=1 as=3.99e-14 ad=2.472e-14 ps=1.17e-06 pd=6.6e-07 nrd=1.16667 \
        nrs=1.16667 sa=1.09302e-07 sb=1.455e-06 sd=160n sca=11.9515 \
        scb=0.0105226 scc=0.000305882 m=(1)
mp51 (\9\:n30 CKbb net457 VDD) g45p1svt w=(2.15e-07) l=4.5e-08 nf=1 \
        as=2.472e-14 ad=3.762e-14 ps=6.6e-07 pd=7.8e-07 nrd=1.16667 \
        nrs=1.16667 sa=2.69302e-07 sb=1.295e-06 sd=160n sca=11.9515 \
        scb=0.0105226 scc=0.000305882 m=(1)
mp40 (\9\:n30 \8\:CKb \8\:mout VDD) g45p1svt w=(2.15e-07) l=4.5e-08 nf=1 \
        as=5.912e-14 ad=3.762e-14 ps=9.8e-07 pd=7.8e-07 nrd=1.16667 \
        nrs=1.16667 sa=4.89302e-07 sb=1.075e-06 sd=160n sca=11.9515 \
        scb=0.0105226 scc=0.000305882 m=(1)
mp30 (\8\:mout n20 \26\:VDD VDD) g45p1svt w=(2.15e-07) l=4.5e-08 nf=1 \
        as=4.73e-14 ad=5.912e-14 ps=8.7e-07 pd=9.8e-07 nrd=1.16667 \
        nrs=1.16667 sa=8.09302e-07 sb=7.55e-07 sd=160n sca=11.9515 \
        scb=0.0105226 scc=0.000305882 m=(1)
mp35 (net437 mout \26\:VDD VDD) g45p1svt w=(2.15e-07) l=4.5e-08 nf=1 \
        as=4.73e-14 ad=1.29e-14 ps=8.7e-07 pd=5.5e-07 nrd=1.16667 \
        nrs=1.16667 sa=1.0743e-06 sb=4.9e-07 sd=160n sca=11.9515 \
        scb=0.0105226 scc=0.000305882 m=(1)
mp36 (\4\:n20 \7\:CKb net437 VDD) g45p1svt w=(2.15e-07) l=4.5e-08 nf=1 \
        as=1.29e-14 ad=4.3e-14 ps=5.5e-07 pd=8.3e-07 nrd=1.16667 \
        nrs=1.16667 sa=1.1793e-06 sb=3.85e-07 sd=160n sca=11.9515 \
        scb=0.0105226 scc=0.000305882 m=(1)
mp25 (\4\:n20 \7\:CKbb \5\:Dbp VDD) g45p1svt w=(2.15e-07) l=4.5e-08 nf=1 \
        as=3.01e-14 ad=4.3e-14 ps=7.1e-07 pd=8.3e-07 nrd=1.16667 \
        nrs=1.16667 sa=1.4243e-06 sb=1.4e-07 sd=160n sca=11.9515 \
        scb=0.0105226 scc=0.000305882 m=(1)
mp21 (\9\:CKbb \6\:CKb \24\:VDD VDD) g45p1svt w=(2.15e-07) l=4.5e-08 \
        nf=1 as=8.827e-14 ad=3.01e-14 ps=1.45e-06 pd=7.1e-07 nrd=1.16667 \
        nrs=1.16667 sa=1.4e-07 sb=6.8e-07 sd=160n sca=45.7906 \
        scb=0.0283307 scc=0.00588417 m=(1)
mp56 (\14\:net502 \11\:net536 \24\:VDD VDD) g45p1svt w=(2.15e-07) \
        l=4.5e-08 nf=1 as=8.827e-14 ad=7.525e-14 ps=1.45e-06 pd=1.13e-06 \
        nrd=1.16667 nrs=1.16667 sa=4.7e-07 sb=3.5e-07 sd=160n sca=45.7906 \
        scb=0.0283307 scc=0.00588417 m=(1)
mp20 (\14\:CKb \1\:CK \22\:VDD VDD) g45p1svt w=(2.15e-07) l=4.5e-08 nf=1 \
        as=1.0435e-13 ad=3.01e-14 ps=1.71e-06 pd=7.1e-07 nrd=1.16667 \
        nrs=1.16667 sa=1.4e-07 sb=8.35e-07 sd=160n sca=13.1637 \
        scb=0.0123476 scc=0.000501177 m=(1)
mp12 (net465 \1\:SI \22\:VDD VDD) g45p1svt w=(2.15e-07) l=4.5e-08 nf=1 \
        as=1.0435e-13 ad=1.29e-14 ps=1.71e-06 pd=5.5e-07 nrd=1.16667 \
        nrs=1.16667 sa=4.75e-07 sb=5e-07 sd=160n sca=13.1637 scb=0.0123476 \
        scc=0.000501177 m=(1)
mp13 (\7\:Dbp \2\:SEb net465 VDD) g45p1svt w=(2.15e-07) l=4.5e-08 nf=1 \
        as=1.29e-14 ad=4.515e-14 ps=5.5e-07 pd=8.5e-07 nrd=1.16667 \
        nrs=1.16667 sa=5.8e-07 sb=3.95e-07 sd=160n sca=13.1637 \
        scb=0.0123476 scc=0.000501177 m=(1)
mp11 (\7\:Dbp \6\:SE \4\:Db VDD) g45p1svt w=(2.15e-07) l=4.5e-08 nf=1 \
        as=3.01e-14 ad=4.515e-14 ps=7.1e-07 pd=8.5e-07 nrd=1.16667 \
        nrs=1.16667 sa=8.35e-07 sb=1.4e-07 sd=160n sca=13.1637 \
        scb=0.0123476 scc=0.000501177 m=(1)
mp10 (\8\:SEb \5\:SE \4\:VDD VDD) g45p1svt w=(2.15e-07) l=4.5e-08 nf=1 \
        as=1.1297e-13 ad=3.01e-14 ps=1.7e-06 pd=7.1e-07 nrd=1.16667 \
        nrs=1.16667 sa=1.4e-07 sb=9.05581e-07 sd=160n sca=24.8095 \
        scb=0.0224988 scc=0.00280688 m=(1)
mp1 (net425 net502 \4\:VDD VDD) g45p1svt w=(2.15e-07) l=4.5e-08 nf=1 \
        as=8.495e-14 ad=2.902e-14 ps=1.55e-06 pd=7e-07 nrd=1.16667 \
        nrs=1.16667 sa=7.04884e-07 sb=1.08e-06 sd=160n sca=11.1138 \
        scb=0.00912362 scc=0.000187967 m=(1)
mp2 (\6\:Db \1\:E net425 VDD) g45p1svt w=(2.15e-07) l=4.5e-08 nf=1 \
        as=2.902e-14 ad=3.44e-14 ps=7e-07 pd=7.5e-07 nrd=1.16667 \
        nrs=1.16667 sa=8.84884e-07 sb=9e-07 sd=160n sca=11.1138 \
        scb=0.00912362 scc=0.000187967 m=(1)
mp4 (\6\:Db Eb net473 VDD) g45p1svt w=(2.15e-07) l=4.5e-08 nf=1 \
        as=2.58e-14 ad=3.44e-14 ps=6.7e-07 pd=7.5e-07 nrd=1.16667 \
        nrs=1.16667 sa=1.08988e-06 sb=6.95e-07 sd=160n sca=11.1829 \
        scb=0.00913745 scc=0.000187969 m=(1)
mp3 (net473 \1\:D \16\:VDD VDD) g45p1svt w=(2.15e-07) l=4.5e-08 nf=1 \
        as=7.417e-14 ad=2.58e-14 ps=1.12e-06 pd=6.7e-07 nrd=1.16667 \
        nrs=1.16667 sa=1.25488e-06 sb=5.3e-07 sd=160n sca=11.6362 \
        scb=0.00930804 scc=0.000188027 m=(1)
mp0 (\8\:Eb \5\:E \16\:VDD VDD) g45p1svt w=(2.15e-07) l=4.5e-08 nf=1 \
        as=7.417e-14 ad=3.01e-14 ps=1.12e-06 pd=7.1e-07 nrd=1.16667 \
        nrs=1.16667 sa=1.64488e-06 sb=1.4e-07 sd=160n sca=15.5174 \
        scb=0.0148358 scc=0.000265687 m=(1)
ends SEDFFX2
// End of subcircuit definition.
