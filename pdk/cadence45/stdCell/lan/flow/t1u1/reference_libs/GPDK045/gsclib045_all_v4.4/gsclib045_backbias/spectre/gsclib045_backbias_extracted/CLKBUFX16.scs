// Generated for: spectre (May  1 11:28:14 2013 )
// Library name: gsclib045_backbias
// Cell name: CLKBUFX16
// View name: extracted

simulator lang=spectre

subckt CLKBUFX16 A NW VDD VSS Y
mp1_1__rcx (Y net44 VDD NW) g45p1svt w=(4.45e-07) l=4.5e-08 nf=1 \
        as=7.033e-14 ad=7.12e-14 ps=1.20714e-06 pd=1.21e-06 nrd=1.16667 \
        nrs=1.16667 sa=1.4e-07 sb=2e-06 sd=160n sca=41.6034 scb=0.0375368 \
        scc=0.00435732 m=(14)
C1 (NW VSS) capacitor c=4.38555e-16
C2 (VDD VSS) capacitor c=1.08844e-15
C3 (A VSS) capacitor c=3.33131e-16
C4 (Y VSS) capacitor c=8.74354e-16
C5 (net44 VSS) capacitor c=1.16013e-15
C6 (\43\:net44 VSS) capacitor c=1.71748e-16
C7 (\49\:net44 VSS) capacitor c=8.49727e-17
C8 (\9\:Y VSS) capacitor c=4.80757e-16
C9 (\48\:net44 VSS) capacitor c=2.37532e-17
Rk7 (Y \9\:Y) resistor r=0.2351 c=0
Rk26 (\48\:net44 net44) resistor r=0.1464 c=0
Rk23 (\43\:net44 \48\:net44) resistor r=0.2122 c=0
Rk24 (\48\:net44 \49\:net44) resistor r=0.1301 c=0
mn1_1__rcx (\9\:Y net44 VSS VSS) g45n1svt w=(2.95e-07) l=4.5e-08 nf=1 \
        as=4.663e-14 ad=4.72e-14 ps=9.0714e-07 pd=9.1e-07 nrd=1.16667 \
        nrs=1.16667 sa=1.4e-07 sb=2e-06 sd=160n sca=16.4223 scb=0.0158966 \
        scc=0.0014413 m=(14)
mn0_1__rcx (\49\:net44 A VSS VSS) g45n1svt w=(2.6e-07) l=4.5e-08 nf=1 \
        as=4.118e-14 ad=4.16e-14 ps=8.475e-07 pd=8.4e-07 nrd=1.16667 \
        nrs=1.16667 sa=2e-06 sb=7.55e-07 sd=160n sca=17.5885 scb=0.0172826 \
        scc=0.00162584 m=(4)
mp0_1__rcx (\43\:net44 A VDD NW) g45p1svt w=(3.9e-07) l=4.5e-08 nf=1 \
        as=7.158e-14 ad=6.24e-14 ps=1.1675e-06 pd=1.1e-06 nrd=1.16667 \
        nrs=1.16667 sa=2e-06 sb=8.55e-07 sd=160n sca=18.4487 scb=0.016003 \
        scc=0.00159615 m=(4)
ends CLKBUFX16
// End of subcircuit definition.
