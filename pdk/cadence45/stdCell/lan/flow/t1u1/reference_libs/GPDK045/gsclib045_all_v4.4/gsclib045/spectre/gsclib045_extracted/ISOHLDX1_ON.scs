// Generated for: spectre (May  1 08:11:33 2013 )
// Library name: gsclib045
// Cell name: ISOHLDX1_ON
// View name: extracted

simulator lang=spectre

subckt ISOHLDX1_ON D ISO Q VDD VSS
mp0 (\11\:GNb \1\:ISO \6\:VDD VDD) g45p1svt w=(2.15e-07) l=4.5e-08 nf=1 \
        as=3.01e-14 ad=3.44e-14 ps=7.1e-07 pd=7.5e-07 nrd=1.16667 \
        nrs=1.16667 sa=1.4e-07 sb=3.45e-07 sd=160n sca=18.0983 \
        scb=0.0191571 scc=0.000483339 m=(1)
mp10 (\12\:Qint n0 \12\:VDD VDD) g45p1svt w=(2.15e-07) l=4.5e-08 nf=1 \
        as=3.01e-14 ad=3.01e-14 ps=7.1e-07 pd=7.1e-07 nrd=1.16667 \
        nrs=1.16667 sa=1.4e-07 sb=1.4e-07 sd=160n sca=10.4936 \
        scb=0.00800718 scc=0.000111754 m=(1)
mp1 (\12\:GNbb \4\:GNb \6\:VDD VDD) g45p1svt w=(2.15e-07) l=4.5e-08 nf=1 \
        as=3.01e-14 ad=3.44e-14 ps=7.1e-07 pd=7.5e-07 nrd=1.16667 \
        nrs=1.16667 sa=3.45e-07 sb=1.4e-07 sd=160n sca=12.8783 \
        scb=0.0102763 scc=0.000121633 m=(1)
mp6 (\8\:n0 GNbb net220 VDD) g45p1svt w=(2.15e-07) l=4.5e-08 nf=1 \
        as=1.29e-14 ad=3.01e-14 ps=5.5e-07 pd=7.1e-07 nrd=1.16667 \
        nrs=1.16667 sa=1.4e-07 sb=2.45e-07 sd=160n sca=10.5523 \
        scb=0.00801875 scc=0.000111755 m=(1)
mp5 (net220 \1\:D \14\:VDD VDD) g45p1svt w=(2.15e-07) l=4.5e-08 nf=1 \
        as=3.01e-14 ad=1.29e-14 ps=7.1e-07 pd=5.5e-07 nrd=1.16667 \
        nrs=1.16667 sa=2.45e-07 sb=1.4e-07 sd=160n sca=10.4936 \
        scb=0.00800718 scc=0.000111754 m=(1)
mp16 (\15\:n0 GNb net212 VDD) g45p1svt w=(2.15e-07) l=4.5e-08 nf=1 \
        as=1.29e-14 ad=3.01e-14 ps=5.5e-07 pd=7.1e-07 nrd=1.16667 \
        nrs=1.16667 sa=1.4e-07 sb=2.45e-07 sd=160n sca=10.4936 \
        scb=0.00800718 scc=0.000111754 m=(1)
mp15 (net212 \7\:Qint \10\:VDD VDD) g45p1svt w=(2.15e-07) l=4.5e-08 nf=1 \
        as=3.01e-14 ad=1.29e-14 ps=7.1e-07 pd=5.5e-07 nrd=1.16667 \
        nrs=1.16667 sa=2.45e-07 sb=1.4e-07 sd=160n sca=10.5223 \
        scb=0.00801258 scc=0.000111754 m=(1)
C1 (D VSS) capacitor c=5.44943e-17
C2 (Q VSS) capacitor c=1.93185e-17
C3 (VDD VSS) capacitor c=2.34661e-16
C4 (ISO VSS) capacitor c=7.13286e-17
C5 (GNbb VSS) capacitor c=8.25382e-17
C6 (n0 VSS) capacitor c=3.01029e-17
C7 (GNb VSS) capacitor c=1.81062e-16
C8 (Qbint VSS) capacitor c=4.11051e-17
C9 (Qint VSS) capacitor c=3.70341e-17
C10 (\7\:Qint VSS) capacitor c=6.07498e-17
C11 (\1\:D VSS) capacitor c=4.64379e-17
C12 (\4\:GNb VSS) capacitor c=4.42971e-17
C13 (\1\:ISO VSS) capacitor c=3.61602e-17
C14 (\4\:Qbint VSS) capacitor c=4.78606e-17
C15 (\5\:Qint VSS) capacitor c=4.31487e-17
C16 (\6\:Qint VSS) capacitor c=6.44534e-17
C17 (\5\:GNbb VSS) capacitor c=6.52909e-17
C18 (\7\:n0 VSS) capacitor c=3.33735e-17
C19 (\3\:D VSS) capacitor c=3.89649e-17
C20 (\7\:GNb VSS) capacitor c=8.29532e-17
C21 (\6\:GNb VSS) capacitor c=2.25859e-17
C22 (\3\:ISO VSS) capacitor c=5.96041e-17
C23 (\3\:Qbint VSS) capacitor c=2.23267e-17
C24 (\3\:n0 VSS) capacitor c=9.07905e-17
C25 (\4\:Qint VSS) capacitor c=5.37989e-17
C26 (\3\:GNbb VSS) capacitor c=1.20027e-16
C27 (\6\:GNbb VSS) capacitor c=4.93577e-17
C28 (\2\:n0 VSS) capacitor c=4.61151e-17
C29 (\5\:n0 VSS) capacitor c=2.23446e-17
C30 (\4\:D VSS) capacitor c=4.30791e-17
C31 (\2\:D VSS) capacitor c=4.06799e-17
C32 (\6\:n0 VSS) capacitor c=8.11642e-17
C33 (\2\:GNbb VSS) capacitor c=4.83739e-17
C34 (\4\:GNbb VSS) capacitor c=1.17473e-16
C35 (\3\:GNb VSS) capacitor c=5.04463e-17
C36 (\2\:ISO VSS) capacitor c=7.2396e-17
C37 (\4\:Q VSS) capacitor c=4.1109e-17
C38 (\8\:VDD VSS) capacitor c=7.68987e-17
C39 (\9\:Qbint VSS) capacitor c=6.73894e-17
C40 (\10\:VDD VSS) capacitor c=3.57845e-17
C41 (\15\:n0 VSS) capacitor c=7.75959e-17
C42 (\12\:Qint VSS) capacitor c=5.92533e-17
C43 (\14\:VDD VSS) capacitor c=6.80474e-17
C44 (\8\:n0 VSS) capacitor c=9.11978e-17
C45 (\12\:GNbb VSS) capacitor c=4.37549e-17
C46 (\6\:VDD VSS) capacitor c=7.8665e-17
C47 (\11\:GNb VSS) capacitor c=5.2652e-17
C48 (\1\:VDD VSS) capacitor c=6.42638e-17
C49 (\2\:Q VSS) capacitor c=5.77687e-17
C50 (\7\:Qbint VSS) capacitor c=6.24878e-17
C51 (\18\:n0 VSS) capacitor c=4.13621e-17
C52 (\10\:Qint VSS) capacitor c=8.30123e-17
C53 (\11\:n0 VSS) capacitor c=4.19704e-17
C54 (\10\:GNbb VSS) capacitor c=5.20972e-17
C55 (\8\:GNb VSS) capacitor c=3.89757e-17
C56 (\4\:n0 VSS) capacitor c=6.91936e-17
C57 (\2\:GNb VSS) capacitor c=1.48175e-16
C58 (\5\:GNb VSS) capacitor c=3.88306e-17
C59 (\2\:Qint VSS) capacitor c=5.73995e-17
C60 (\3\:Qint VSS) capacitor c=5.86117e-17
C61 (\2\:Qbint VSS) capacitor c=3.25199e-17
C62 (\10\:GNb VSS) capacitor c=6.41517e-17
C63 (\13\:GNb VSS) capacitor c=4.11673e-17
C64 (\7\:GNbb VSS) capacitor c=6.34893e-17
C65 (\14\:GNbb VSS) capacitor c=7.6394e-17
C66 (\10\:n0 VSS) capacitor c=9.12236e-17
C67 (\5\:D VSS) capacitor c=5.07638e-17
C68 (\6\:D VSS) capacitor c=5.37146e-17
C69 (\13\:n0 VSS) capacitor c=6.75723e-17
C70 (\14\:n0 VSS) capacitor c=7.71643e-17
C71 (\15\:GNbb VSS) capacitor c=6.05095e-17
C72 (\16\:GNbb VSS) capacitor c=7.27528e-17
C73 (\8\:Qint VSS) capacitor c=3.30234e-17
C74 (\9\:Qint VSS) capacitor c=8.57974e-17
C75 (\17\:n0 VSS) capacitor c=9.07235e-17
C76 (\5\:Qbint VSS) capacitor c=3.4022e-17
C77 (\6\:Qbint VSS) capacitor c=3.48686e-17
C78 (\1\:Q VSS) capacitor c=4.78803e-17
C79 (\3\:VDD VSS) capacitor c=1.12666e-17
C80 (\4\:VDD VSS) capacitor c=2.77171e-17
Rk13 (\5\:D D) resistor r=0.339 c=0
Rk14 (D \6\:D) resistor r=0.1252 c=0
Rk25 (Q \1\:Q) resistor r=0.03194 c=0
Rk26 (\1\:Q \3\:Q) resistor r=0.4954 c=0
Rk27 (\1\:Q \5\:Q) resistor r=0.2038 c=0
Rk28 (\2\:VDD \3\:VDD) resistor r=0.04999 c=0
Rk30 (\4\:VDD VDD) resistor r=0.463 c=0
Rk29 (\3\:VDD \4\:VDD) resistor r=0.2229 c=0
Rk31 (VDD \5\:VDD) resistor r=0.01818 c=0
Rk32 (\5\:VDD \7\:VDD) resistor r=0.6405 c=0
Rk33 (\3\:VDD \9\:VDD) resistor r=0.2916 c=0
Rk34 (\4\:VDD \11\:VDD) resistor r=0.201 c=0
Rk35 (VDD \13\:VDD) resistor r=0.0672 c=0
Rk1 (ISO \4\:ISO) resistor r=0.006492 c=0
Rk37 (\2\:VSS \3\:VSS) resistor r=0.04999 c=0
Rk39 (\4\:VSS VSS) resistor r=0.463 c=0
Rk38 (\3\:VSS \4\:VSS) resistor r=0.2229 c=0
Rk40 (VSS \5\:VSS) resistor r=0.01818 c=0
Rk41 (\5\:VSS \7\:VSS) resistor r=0.6086 c=0
Rk42 (\3\:VSS \9\:VSS) resistor r=0.2303 c=0
Rk43 (\4\:VSS \11\:VSS) resistor r=0.1734 c=0
Rk44 (\5\:VSS \13\:VSS) resistor r=0.0608 c=0
Rk6 (\7\:GNbb \8\:GNbb) resistor r=0.02474 c=0
Rk7 (\8\:GNbb \9\:GNbb) resistor r=0.2741 c=0
Rk8 (\9\:GNbb \11\:GNbb) resistor r=0.3161 c=0
Rk9 (\8\:GNbb \13\:GNbb) resistor r=0.2153 c=0
Rk10 (\9\:GNbb \14\:GNbb) resistor r=0.02474 c=0
Rk16 (\15\:GNbb \16\:GNbb) resistor r=0.2385 c=0
Rk11 (\9\:n0 \10\:n0) resistor r=0.5834 c=0
Rk12 (\10\:n0 \12\:n0) resistor r=0.2209 c=0
Rk15 (\13\:n0 \14\:n0) resistor r=0.4788 c=0
Rk20 (\16\:n0 \17\:n0) resistor r=0.5935 c=0
Rk21 (\17\:n0 \19\:n0) resistor r=0.2568 c=0
Rk3 (\9\:GNb \10\:GNb) resistor r=0.3372 c=0
Rk4 (\10\:GNb \12\:GNb) resistor r=0.4523 c=0
Rk5 (\10\:GNb \13\:GNb) resistor r=0.1657 c=0
Rk22 (\5\:Qbint \6\:Qbint) resistor r=0.1544 c=0
Rk23 (\6\:Qbint \8\:Qbint) resistor r=0.393 c=0
Rk24 (\6\:Qbint \10\:Qbint) resistor r=0.2938 c=0
Rk17 (\8\:Qint \9\:Qint) resistor r=0.07731 c=0
Rk18 (\9\:Qint \11\:Qint) resistor r=0.4576 c=0
Rk19 (\9\:Qint \13\:Qint) resistor r=0.3397 c=0
Rl5 (\3\:D \4\:D) resistor r=24.2328 c=0
Rl4 (\1\:D \2\:D) resistor r=33.3841 c=0
Rl1 (\1\:ISO \2\:ISO) resistor r=71.8665 c=0
Rl2 (\2\:ISO \3\:ISO) resistor r=228.685 c=0
Rl18 (\5\:GNbb \6\:GNbb) resistor r=85.3829 c=0
Rl3 (GNbb \2\:GNbb) resistor r=140.087 c=0
Rl7 (\3\:GNbb \4\:GNbb) resistor r=338.212 c=0
Rl6 (n0 \2\:n0) resistor r=81.2354 c=0
Rl11 (\5\:n0 \7\:n0) resistor r=73.8039 c=0
Rl8 (\3\:n0 \4\:n0) resistor r=187.823 c=0
Rl9 (\4\:n0 \5\:n0) resistor r=9.6495 c=0
Rl10 (\4\:n0 \6\:n0) resistor r=145.209 c=0
Rl12 (GNb \2\:GNb) resistor r=587.01 c=0
Rl14 (\2\:GNb \4\:GNb) resistor r=120.618 c=0
Rl13 (\2\:GNb \3\:GNb) resistor r=40.6135 c=0
Rl17 (\5\:GNb \7\:GNb) resistor r=175.127 c=0
Rl16 (\5\:GNb \6\:GNb) resistor r=36.0502 c=0
Rl15 (\3\:GNb \5\:GNb) resistor r=90.3235 c=0
Rl25 (Qbint \2\:Qbint) resistor r=70.3096 c=0
Rl27 (\2\:Qbint \4\:Qbint) resistor r=145.333 c=0
Rl26 (\2\:Qbint \3\:Qbint) resistor r=1.2301 c=0
Rl19 (Qint \2\:Qint) resistor r=72.8903 c=0
Rl22 (\2\:Qint \5\:Qint) resistor r=147.89 c=0
Rl24 (\3\:Qint \7\:Qint) resistor r=129.936 c=0
Rl23 (\3\:Qint \6\:Qint) resistor r=184.481 c=0
Rl21 (\3\:Qint \4\:Qint) resistor r=97.8063 c=0
Rl20 (\2\:Qint \3\:Qint) resistor r=141.644 c=0
Rz7 (\2\:Q \3\:Q) resistor r=37.5 c=0
Rz8 (\1\:VDD \2\:VDD) resistor r=25 c=0
Rz9 (\1\:VDD \5\:VDD) resistor r=6.25 c=0
Rz10 (\6\:VSS \7\:VSS) resistor r=75 c=0
Rz11 (\8\:VSS \9\:VSS) resistor r=37.5 c=0
Rz12 (\10\:VSS \11\:VSS) resistor r=75 c=0
Rz13 (\12\:VSS \13\:VSS) resistor r=75 c=0
Rz14 (\14\:VSS \13\:VSS) resistor r=75 c=0
Rz2 (\10\:GNbb \11\:GNbb) resistor r=75 c=0
Rz3 (\11\:n0 \12\:n0) resistor r=75 c=0
Rz5 (\18\:n0 \19\:n0) resistor r=75 c=0
Rz1 (\8\:GNb \9\:GNb) resistor r=75 c=0
Rz6 (\7\:Qbint \8\:Qbint) resistor r=37.5 c=0
Rz4 (\10\:Qint \11\:Qint) resistor r=75 c=0
Ry7 (\4\:Q \5\:Q) resistor r=20.6667 c=0
Ry8 (\6\:VDD \7\:VDD) resistor r=62 c=0
Ry9 (\8\:VDD \9\:VDD) resistor r=20.6667 c=0
Ry10 (\10\:VDD \11\:VDD) resistor r=62 c=0
Ry11 (\12\:VDD \13\:VDD) resistor r=62 c=0
Ry12 (\14\:VDD \13\:VDD) resistor r=62 c=0
Ry13 (\1\:VSS \2\:VSS) resistor r=20.6667 c=0
Ry14 (\1\:VSS \5\:VSS) resistor r=5.1667 c=0
Ry2 (\12\:GNbb \13\:GNbb) resistor r=62 c=0
Ry3 (\8\:n0 \9\:n0) resistor r=62 c=0
Ry5 (\15\:n0 \16\:n0) resistor r=62 c=0
Ry1 (\11\:GNb \12\:GNb) resistor r=62 c=0
Ry6 (\9\:Qbint \10\:Qbint) resistor r=20.6667 c=0
Ry4 (\12\:Qint \13\:Qint) resistor r=62 c=0
Rx6 (\2\:D \5\:D) resistor r=45 c=0
Rx7 (\4\:D \6\:D) resistor r=45 c=0
Rx1 (\2\:ISO \4\:ISO) resistor r=45 c=0
Rx3 (\2\:GNbb \7\:GNbb) resistor r=45 c=0
Rx4 (\4\:GNbb \14\:GNbb) resistor r=45 c=0
Rx10 (\3\:GNbb \15\:GNbb) resistor r=45 c=0
Rx11 (\6\:GNbb \16\:GNbb) resistor r=45 c=0
Rx5 (\6\:n0 \10\:n0) resistor r=45 c=0
Rx8 (\2\:n0 \13\:n0) resistor r=45 c=0
Rx9 (\5\:n0 \14\:n0) resistor r=45 c=0
Rx13 (\3\:n0 \17\:n0) resistor r=45 c=0
Rx2 (\3\:GNb \13\:GNb) resistor r=45 c=0
Rx14 (\3\:Qbint \5\:Qbint) resistor r=45 c=0
Rx12 (\4\:Qint \8\:Qint) resistor r=45 c=0
mn1 (\10\:GNbb \6\:GNb \6\:VSS VSS) g45n1svt w=(1.45e-07) l=4.5e-08 nf=1 \
        as=2.03e-14 ad=2.32e-14 ps=5.7e-07 pd=6.1e-07 nrd=1.16667 \
        nrs=1.16667 sa=3.45e-07 sb=1.4e-07 sd=160n sca=6.31271 \
        scb=0.00272743 scc=1.50943e-05 m=(1)
mn0 (\8\:GNb \3\:ISO \6\:VSS VSS) g45n1svt w=(1.45e-07) l=4.5e-08 nf=1 \
        as=2.32e-14 ad=2.03e-14 ps=6.1e-07 pd=5.7e-07 nrd=1.16667 \
        nrs=1.16667 sa=1.4e-07 sb=3.45e-07 sd=160n sca=6.31271 \
        scb=0.00272743 scc=1.50943e-05 m=(1)
mn16 (\18\:n0 \5\:GNbb net245 VSS) g45n1svt w=(1.45e-07) l=4.5e-08 nf=1 \
        as=8.7e-15 ad=2.03e-14 ps=4.1e-07 pd=5.7e-07 nrd=1.16667 \
        nrs=1.16667 sa=1.4e-07 sb=2.45e-07 sd=160n sca=6.31271 \
        scb=0.00272743 scc=1.50943e-05 m=(1)
mn6 (\11\:n0 \7\:GNb net257 VSS) g45n1svt w=(1.45e-07) l=4.5e-08 nf=1 \
        as=8.7e-15 ad=2.03e-14 ps=4.1e-07 pd=5.7e-07 nrd=1.16667 \
        nrs=1.16667 sa=1.4e-07 sb=2.45e-07 sd=160n sca=6.31271 \
        scb=0.00272743 scc=1.50943e-05 m=(1)
mn15 (net245 \6\:Qint \10\:VSS VSS) g45n1svt w=(1.45e-07) l=4.5e-08 nf=1 \
        as=2.03e-14 ad=8.7e-15 ps=5.7e-07 pd=4.1e-07 nrd=1.16667 \
        nrs=1.16667 sa=2.45e-07 sb=1.4e-07 sd=160n sca=6.31271 \
        scb=0.00272743 scc=1.50943e-05 m=(1)
mn5 (net257 \3\:D \14\:VSS VSS) g45n1svt w=(1.45e-07) l=4.5e-08 nf=1 \
        as=2.03e-14 ad=8.7e-15 ps=5.7e-07 pd=4.1e-07 nrd=1.16667 \
        nrs=1.16667 sa=2.45e-07 sb=1.4e-07 sd=160n sca=6.31271 \
        scb=0.00272743 scc=1.50943e-05 m=(1)
mn10 (\10\:Qint \7\:n0 \12\:VSS VSS) g45n1svt w=(1.45e-07) l=4.5e-08 \
        nf=1 as=2.03e-14 ad=2.03e-14 ps=5.7e-07 pd=5.7e-07 nrd=1.16667 \
        nrs=1.16667 sa=1.4e-07 sb=1.4e-07 sd=160n sca=6.31271 \
        scb=0.00272743 scc=1.50943e-05 m=(1)
mn20 (\7\:Qbint \5\:Qint \8\:VSS VSS) g45n1svt w=(2.6e-07) l=4.5e-08 \
        nf=1 as=4.16e-14 ad=3.64e-14 ps=8.4e-07 pd=8e-07 nrd=1.16667 \
        nrs=1.16667 sa=1.4e-07 sb=3.45e-07 sd=160n sca=7.39137 \
        scb=0.00470608 scc=6.95095e-05 m=(1)
mn21 (\2\:Q \4\:Qbint \8\:VSS VSS) g45n1svt w=(2.6e-07) l=4.5e-08 nf=1 \
        as=3.64e-14 ad=4.16e-14 ps=8e-07 pd=8.4e-07 nrd=1.16667 \
        nrs=1.16667 sa=3.45e-07 sb=1.4e-07 sd=160n sca=7.39137 \
        scb=0.00470608 scc=6.95095e-05 m=(1)
mp20 (\9\:Qbint Qint \8\:VDD VDD) g45p1svt w=(3.9e-07) l=4.5e-08 nf=1 \
        as=6.24e-14 ad=5.46e-14 ps=1.1e-06 pd=1.06e-06 nrd=1.16667 \
        nrs=1.16667 sa=1.4e-07 sb=3.45e-07 sd=160n sca=13.482 \
        scb=0.0113805 scc=0.000219474 m=(1)
mp21 (\4\:Q Qbint \8\:VDD VDD) g45p1svt w=(3.9e-07) l=4.5e-08 nf=1 \
        as=5.46e-14 ad=6.24e-14 ps=1.06e-06 pd=1.1e-06 nrd=1.16667 \
        nrs=1.16667 sa=3.45e-07 sb=1.4e-07 sd=160n sca=18.1719 \
        scb=0.0193935 scc=0.000499405 m=(1)
ends ISOHLDX1_ON
// End of subcircuit definition.
