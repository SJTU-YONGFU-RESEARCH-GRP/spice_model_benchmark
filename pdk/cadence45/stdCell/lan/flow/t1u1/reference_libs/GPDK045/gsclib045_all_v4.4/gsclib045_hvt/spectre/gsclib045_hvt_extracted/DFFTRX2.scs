// Generated for: spectre (May  1 09:14:57 2013 )
// Library name: gsclib045_hvt
// Cell name: DFFTRX2
// View name: extracted

simulator lang=spectre

subckt DFFTRX2 CK D Q QN RN VDD VSS
mp1 (\4\:Db \4\:D \21\:VDD VDD) g45p1hvt w=(2.15e-07) l=4.5e-08 nf=1 \
        as=3.01e-14 ad=3.548e-14 ps=7.1e-07 pd=7.6e-07 nrd=1.16667 \
        nrs=1.16667 sa=1.4e-07 sb=5.45e-07 sd=160n sca=27.2529 \
        scb=0.0321202 scc=0.00197428 m=(1)
mp0 (\4\:Db \4\:RN \19\:VDD VDD) g45p1hvt w=(2.15e-07) l=4.5e-08 nf=1 \
        as=5.515e-14 ad=3.548e-14 ps=1.45e-06 pd=7.6e-07 nrd=1.16667 \
        nrs=1.16667 sa=3.5e-07 sb=3.35e-07 sd=160n sca=19.1286 \
        scb=0.0193134 scc=0.00106338 m=(1)
mp21 (\18\:CKbb \7\:CKb \19\:VDD VDD) g45p1hvt w=(2.15e-07) l=4.5e-08 \
        nf=1 as=5.515e-14 ad=3.01e-14 ps=1.45e-06 pd=7.1e-07 nrd=1.16667 \
        nrs=1.16667 sa=5.45e-07 sb=1.4e-07 sd=160n sca=17.1675 \
        scb=0.0165438 scc=0.00103968 m=(1)
mp25 (\9\:n20 CKbb \8\:Db VDD) g45p1hvt w=(2.15e-07) l=4.5e-08 nf=1 \
        as=3.01e-14 ad=3.44e-14 ps=7.1e-07 pd=7.5e-07 nrd=1.16667 \
        nrs=1.16667 sa=1.4e-07 sb=1.775e-06 sd=160n sca=13.4114 \
        scb=0.012694 scc=0.000544005 m=(1)
mp36 (\9\:n20 \2\:CKb n26 VDD) g45p1hvt w=(2.15e-07) l=4.5e-08 nf=1 \
        as=1.505e-14 ad=3.44e-14 ps=5.7e-07 pd=7.5e-07 nrd=1.16667 \
        nrs=1.16667 sa=3.45e-07 sb=1.57e-06 sd=160n sca=13.4114 \
        scb=0.012694 scc=0.000544005 m=(1)
mp35 (n26 mout \15\:VDD VDD) g45p1hvt w=(2.15e-07) l=4.5e-08 nf=1 \
        as=8.99e-14 ad=1.505e-14 ps=1.58e-06 pd=5.7e-07 nrd=1.16667 \
        nrs=1.16667 sa=4.6e-07 sb=1.455e-06 sd=160n sca=13.4114 \
        scb=0.012694 scc=0.000544005 m=(1)
mp30 (\8\:mout n20 \15\:VDD VDD) g45p1hvt w=(2.15e-07) l=4.5e-08 nf=1 \
        as=8.99e-14 ad=8.17e-14 ps=1.58e-06 pd=1.19e-06 nrd=1.16667 \
        nrs=1.16667 sa=7.25e-07 sb=1.19e-06 sd=160n sca=13.4114 \
        scb=0.012694 scc=0.000544005 m=(1)
mp40 (\7\:n30 \9\:CKb \8\:mout VDD) g45p1hvt w=(2.15e-07) l=4.5e-08 nf=1 \
        as=8.17e-14 ad=3.44e-14 ps=1.19e-06 pd=7.5e-07 nrd=1.16667 \
        nrs=1.16667 sa=1.15e-06 sb=7.65e-07 sd=160n sca=13.4114 \
        scb=0.012694 scc=0.000544005 m=(1)
mp51 (\7\:n30 \7\:CKbb n36 VDD) g45p1hvt w=(2.15e-07) l=4.5e-08 nf=1 \
        as=2.365e-14 ad=3.44e-14 ps=6.5e-07 pd=7.5e-07 nrd=1.16667 \
        nrs=1.16667 sa=1.355e-06 sb=5.6e-07 sd=160n sca=13.4114 \
        scb=0.012694 scc=0.000544005 m=(1)
mp50 (n36 \4\:qbint \12\:VDD VDD) g45p1hvt w=(2.15e-07) l=4.5e-08 nf=1 \
        as=9.465e-14 ad=2.365e-14 ps=1.58e-06 pd=6.5e-07 nrd=1.16667 \
        nrs=1.16667 sa=1.51e-06 sb=4.05e-07 sd=160n sca=13.4114 \
        scb=0.012694 scc=0.000544005 m=(1)
mp20 (\12\:CKb \1\:CK \1\:VDD VDD) g45p1hvt w=(2.15e-07) l=4.5e-08 nf=1 \
        as=7.288e-14 ad=3.01e-14 ps=1.23e-06 pd=7.1e-07 nrd=1.16667 \
        nrs=1.16667 sa=1.4e-07 sb=1.26e-06 sd=160n sca=45.7906 \
        scb=0.0283307 scc=0.00588417 m=(1)
mp56 (\11\:qint \15\:qbint \1\:VDD VDD) g45p1hvt w=(2.15e-07) l=4.5e-08 \
        nf=1 as=6.535e-14 ad=3.01e-14 ps=1.16e-06 pd=7.1e-07 nrd=1.16667 \
        nrs=1.16667 sa=1.26e-06 sb=1.4e-07 sd=160n sca=52.4731 \
        scb=0.0379902 scc=0.00614793 m=(1)
C1 (CK VSS) capacitor c=5.08817e-17
C2 (RN VSS) capacitor c=3.45203e-17
C3 (Q VSS) capacitor c=3.14692e-17
C4 (VDD VSS) capacitor c=2.94531e-16
C5 (D VSS) capacitor c=1.6775e-17
C6 (QN VSS) capacitor c=3.84084e-17
C7 (n0 VSS) capacitor c=1.48018e-18
C8 (Db VSS) capacitor c=9.14919e-17
C9 (CKbb VSS) capacitor c=4.10531e-17
C10 (CKb VSS) capacitor c=3.03946e-17
C11 (n20 VSS) capacitor c=4.65521e-17
C12 (mout VSS) capacitor c=5.68065e-17
C13 (n30 VSS) capacitor c=6.3141e-17
C14 (qbint VSS) capacitor c=3.50083e-17
C15 (qint VSS) capacitor c=1.69919e-16
C16 (n36 VSS) capacitor c=2.01546e-18
C17 (\15\:qbint VSS) capacitor c=4.12943e-17
C18 (\5\:qbint VSS) capacitor c=4.36117e-16
C19 (\1\:CK VSS) capacitor c=2.80175e-17
C20 (\4\:qbint VSS) capacitor c=4.66423e-17
C21 (\7\:CKbb VSS) capacitor c=5.30541e-17
C22 (\9\:CKb VSS) capacitor c=6.42446e-17
C23 (\2\:CKb VSS) capacitor c=8.68408e-17
C24 (\7\:CKb VSS) capacitor c=5.55487e-17
C25 (\4\:RN VSS) capacitor c=4.01967e-17
C26 (\4\:D VSS) capacitor c=4.10443e-17
C27 (\14\:qbint VSS) capacitor c=2.81165e-17
C28 (\3\:CK VSS) capacitor c=3.24046e-17
C29 (\4\:n30 VSS) capacitor c=3.27395e-17
C30 (\3\:qbint VSS) capacitor c=7.98245e-17
C31 (\8\:CKb VSS) capacitor c=8.95288e-17
C32 (\5\:CKbb VSS) capacitor c=3.32537e-17
C33 (\4\:n20 VSS) capacitor c=3.1632e-17
C34 (\3\:mout VSS) capacitor c=7.04852e-17
C35 (\3\:CKbb VSS) capacitor c=8.11894e-17
C36 (\6\:CKb VSS) capacitor c=2.29223e-17
C37 (\5\:CKb VSS) capacitor c=3.73998e-17
C38 (\3\:RN VSS) capacitor c=7.63621e-17
C39 (\1\:D VSS) capacitor c=4.54873e-17
C40 (\13\:qbint VSS) capacitor c=2.09333e-17
C41 (\2\:CK VSS) capacitor c=3.09372e-17
C42 (\3\:n30 VSS) capacitor c=5.1587e-17
C43 (\8\:CKbb VSS) capacitor c=5.39668e-17
C44 (\10\:CKb VSS) capacitor c=2.20887e-17
C45 (\6\:CKbb VSS) capacitor c=3.98074e-17
C46 (\3\:n20 VSS) capacitor c=1.81243e-17
C47 (\2\:mout VSS) capacitor c=5.21299e-17
C48 (\4\:CKbb VSS) capacitor c=2.54393e-17
C49 (\2\:CKbb VSS) capacitor c=4.53343e-17
C50 (\1\:RN VSS) capacitor c=2.42197e-17
C51 (\3\:D VSS) capacitor c=1.04274e-17
C52 (\11\:qint VSS) capacitor c=1.75327e-17
C53 (\1\:VDD VSS) capacitor c=2.50028e-16
C54 (\3\:QN VSS) capacitor c=9.11046e-17
C55 (\1\:Q VSS) capacitor c=9.68928e-17
C56 (\12\:CKb VSS) capacitor c=1.48663e-16
C57 (\25\:qbint VSS) capacitor c=3.64392e-17
C58 (\12\:VDD VSS) capacitor c=2.47436e-17
C59 (\7\:n30 VSS) capacitor c=6.26635e-17
C60 (\8\:mout VSS) capacitor c=2.19314e-17
C61 (\15\:VDD VSS) capacitor c=1.86895e-17
C62 (\9\:n20 VSS) capacitor c=3.84288e-17
C63 (\8\:Db VSS) capacitor c=3.01991e-17
C64 (\18\:CKbb VSS) capacitor c=8.32556e-17
C65 (\19\:VDD VSS) capacitor c=1.83735e-17
C66 (\4\:Db VSS) capacitor c=1.43877e-16
C67 (\21\:VDD VSS) capacitor c=3.64184e-17
C68 (\4\:VDD VSS) capacitor c=5.51992e-17
C69 (\7\:qint VSS) capacitor c=2.47461e-17
C70 (\1\:QN VSS) capacitor c=3.93036e-17
C71 (\3\:Q VSS) capacitor c=3.62512e-17
C72 (\15\:CKb VSS) capacitor c=9.51152e-17
C73 (\19\:qbint VSS) capacitor c=1.02857e-16
C74 (\9\:n30 VSS) capacitor c=6.08835e-17
C75 (\4\:mout VSS) capacitor c=7.18634e-17
C76 (\7\:n20 VSS) capacitor c=3.947e-17
C77 (\13\:CKbb VSS) capacitor c=8.26269e-17
C78 (\6\:Db VSS) capacitor c=8.73216e-17
C79 (\2\:D VSS) capacitor c=3.23404e-17
C80 (\2\:RN VSS) capacitor c=3.26192e-17
C81 (\3\:CKb VSS) capacitor c=5.88131e-17
C82 (\4\:CKb VSS) capacitor c=4.68437e-17
C83 (\2\:n20 VSS) capacitor c=2.43801e-17
C84 (\2\:qbint VSS) capacitor c=2.79136e-17
C85 (\5\:D VSS) capacitor c=8.61399e-17
C86 (\5\:RN VSS) capacitor c=9.02639e-17
C87 (\3\:Db VSS) capacitor c=9.51859e-17
C88 (\5\:n20 VSS) capacitor c=4.98784e-17
C89 (\6\:n20 VSS) capacitor c=5.26593e-17
C90 (\6\:mout VSS) capacitor c=5.21324e-17
C91 (\7\:mout VSS) capacitor c=3.92429e-17
C92 (\9\:CKbb VSS) capacitor c=4.56254e-17
C93 (\10\:CKbb VSS) capacitor c=1.22835e-16
C94 (\11\:CKbb VSS) capacitor c=9.14299e-17
C95 (\12\:CKbb VSS) capacitor c=6.5047e-17
C96 (\15\:CKbb VSS) capacitor c=2.39355e-17
C97 (\16\:CKbb VSS) capacitor c=1.37667e-17
C98 (\17\:CKbb VSS) capacitor c=6.9775e-17
C99 (\5\:n30 VSS) capacitor c=3.32229e-17
C100 (\6\:n30 VSS) capacitor c=5.03e-17
C101 (\11\:CKb VSS) capacitor c=1.49128e-16
C102 (\14\:CKb VSS) capacitor c=6.83414e-17
C103 (\4\:CK VSS) capacitor c=7.05065e-17
C104 (\16\:qbint VSS) capacitor c=6.14544e-17
C105 (\21\:qbint VSS) capacitor c=4.80561e-17
C106 (\22\:qbint VSS) capacitor c=3.42477e-17
C107 (\9\:qint VSS) capacitor c=2.52973e-17
C108 (\10\:qint VSS) capacitor c=3.04564e-17
C109 (\11\:VDD VSS) capacitor c=4.6989e-17
C110 (\14\:VDD VSS) capacitor c=3.36558e-17
C111 (\18\:VDD VSS) capacitor c=1.87504e-17
Rk27 (CK \4\:CK) resistor r=0.07932 c=0
Rk2 (RN \5\:RN) resistor r=0.07501 c=0
Rk28 (\2\:Q Q) resistor r=0.3362 c=0
Rk29 (Q \4\:Q) resistor r=0.03326 c=0
Rk61 (\1\:VDD \11\:VDD) resistor r=0.4718 c=0
Rk62 (\11\:VDD \13\:VDD) resistor r=0.1025 c=0
Rk63 (\11\:VDD \14\:VDD) resistor r=0.5102 c=0
Rk64 (\14\:VDD \16\:VDD) resistor r=0.0433 c=0
Rk65 (\14\:VDD \17\:VDD) resistor r=0.2195 c=0
Rk68 (\18\:VDD VDD) resistor r=0.2358 c=0
Rk66 (\17\:VDD \18\:VDD) resistor r=0.3157 c=0
Rk67 (\18\:VDD \20\:VDD) resistor r=0.1439 c=0
Rk69 (VDD \22\:VDD) resistor r=0.3494 c=0
Rk1 (D \5\:D) resistor r=0.01969 c=0
Rk30 (\2\:QN QN) resistor r=0.02733 c=0
Rk31 (QN \4\:QN) resistor r=0.256 c=0
Rk46 (\1\:VSS \7\:VSS) resistor r=0.4174 c=0
Rk47 (\7\:VSS \8\:VSS) resistor r=0.5212 c=0
Rk48 (\8\:VSS \9\:VSS) resistor r=0.2054 c=0
Rk50 (\10\:VSS VSS) resistor r=0.2027 c=0
Rk49 (\9\:VSS \10\:VSS) resistor r=0.3483 c=0
Rk53 (\7\:VSS \16\:VSS) resistor r=0.3459 c=0
Rk54 (\8\:VSS \18\:VSS) resistor r=0.1025 c=0
Rk55 (\10\:VSS \20\:VSS) resistor r=0.2599 c=0
Rk3 (\2\:Db \3\:Db) resistor r=0.4146 c=0
Rk4 (\3\:Db \5\:Db) resistor r=0.5495 c=0
Rk5 (\5\:Db \7\:Db) resistor r=0.5506 c=0
Rk6 (\3\:Db \9\:Db) resistor r=0.07429 c=0
Rk13 (\9\:CKbb \10\:CKbb) resistor r=0.2231 c=0
Rk14 (\10\:CKbb \11\:CKbb) resistor r=0.8883 c=0
Rk15 (\11\:CKbb \12\:CKbb) resistor r=0.2322 c=0
Rk16 (\12\:CKbb \14\:CKbb) resistor r=0.2623 c=0
Rk17 (\10\:CKbb \15\:CKbb) resistor r=0.02784 c=0
Rk18 (\11\:CKbb \16\:CKbb) resistor r=0.02283 c=0
Rk19 (\12\:CKbb \17\:CKbb) resistor r=0.359 c=0
Rk20 (\14\:CKbb \19\:CKbb) resistor r=0.5014 c=0
Rk24 (\11\:CKb \13\:CKb) resistor r=0.9665 c=0
Rk25 (\11\:CKb \14\:CKb) resistor r=0.5498 c=0
Rk26 (\13\:CKb \16\:CKb) resistor r=0.4824 c=0
Rk7 (\5\:n20 \6\:n20) resistor r=0.2851 c=0
Rk8 (\6\:n20 \8\:n20) resistor r=0.1277 c=0
Rk9 (\6\:n20 \10\:n20) resistor r=0.2533 c=0
Rk10 (\5\:mout \6\:mout) resistor r=0.2946 c=0
Rk11 (\6\:mout \7\:mout) resistor r=0.2417 c=0
Rk12 (\6\:mout \9\:mout) resistor r=0.1176 c=0
Rk21 (\5\:n30 \6\:n30) resistor r=0.132 c=0
Rk22 (\6\:n30 \8\:n30) resistor r=0.3714 c=0
Rk23 (\6\:n30 \10\:n30) resistor r=0.2777 c=0
Rk32 (\16\:qbint \5\:qbint) resistor r=0.4971 c=0
Rk34 (\5\:qbint \20\:qbint) resistor r=0.5528 c=0
Rk35 (\20\:qbint \21\:qbint) resistor r=0.4085 c=0
Rk36 (\21\:qbint \22\:qbint) resistor r=0.1162 c=0
Rk39 (\21\:qbint \26\:qbint) resistor r=0.1458 c=0
Rk40 (\8\:qint \9\:qint) resistor r=0.1713 c=0
Rk41 (\9\:qint \10\:qint) resistor r=0.1954 c=0
Rk42 (\9\:qint \12\:qint) resistor r=0.1063 c=0
Rl30 (\1\:CK \2\:CK) resistor r=26.9231 c=0
Rl31 (\2\:CK \3\:CK) resistor r=41.7582 c=0
Rl6 (\2\:RN \4\:RN) resistor r=34.3295 c=0
Rl5 (\2\:RN \3\:RN) resistor r=157.99 c=0
Rl4 (\1\:RN \2\:RN) resistor r=0.5213 c=0
Rl3 (\2\:D \4\:D) resistor r=130.231 c=0
Rl1 (\1\:D \2\:D) resistor r=57.2019 c=0
Rl2 (\2\:D \3\:D) resistor r=4.5402 c=0
Rl21 (\7\:CKbb \8\:CKbb) resistor r=46.3695 c=0
Rl20 (\5\:CKbb \6\:CKbb) resistor r=48.7687 c=0
Rl14 (\3\:CKbb \4\:CKbb) resistor r=55.0021 c=0
Rl7 (CKbb \2\:CKbb) resistor r=62.9746 c=0
Rl22 (\8\:CKb \9\:CKb) resistor r=218.796 c=0
Rl23 (\9\:CKb \10\:CKb) resistor r=24.2328 c=0
Rl8 (CKb \2\:CKb) resistor r=24.2328 c=0
Rl9 (\2\:CKb \3\:CKb) resistor r=234.159 c=0
Rl12 (\3\:CKb \6\:CKb) resistor r=30.4507 c=0
Rl13 (\4\:CKb \7\:CKb) resistor r=99.3618 c=0
Rl11 (\4\:CKb \5\:CKb) resistor r=102.754 c=0
Rl10 (\3\:CKb \4\:CKb) resistor r=139.705 c=0
Rl17 (n20 \2\:n20) resistor r=106.572 c=0
Rl19 (\2\:n20 \4\:n20) resistor r=37.3411 c=0
Rl18 (\2\:n20 \3\:n20) resistor r=1.2301 c=0
Rl15 (mout \2\:mout) resistor r=24.2328 c=0
Rl16 (\2\:mout \3\:mout) resistor r=101.156 c=0
Rl27 (n30 \2\:n30) resistor r=123.385 c=0
Rl29 (\2\:n30 \4\:n30) resistor r=23.7402 c=0
Rl28 (\2\:n30 \3\:n30) resistor r=4.3511 c=0
Rl44 (\14\:qbint \15\:qbint) resistor r=97.6426 c=0
Rl43 (\13\:qbint \14\:qbint) resistor r=31.9846 c=0
Rl26 (\2\:qbint \4\:qbint) resistor r=37.3411 c=0
Rl25 (\2\:qbint \3\:qbint) resistor r=106.581 c=0
Rl24 (\2\:qbint qbint) resistor r=10.9374 c=0
Rz8 (\4\:Q \3\:Q) resistor r=75 c=0
Rz18 (\1\:VDD \4\:VDD) resistor r=6.25 c=0
Rz19 (\17\:VDD \4\:VDD) resistor r=6.25 c=0
Rz9 (\2\:QN \1\:QN) resistor r=75 c=0
Rz15 (\16\:VSS \15\:VSS) resistor r=75 c=0
Rz16 (\18\:VSS \17\:VSS) resistor r=75 c=0
Rz17 (\20\:VSS \19\:VSS) resistor r=75 c=0
Rz1 (Db \2\:Db) resistor r=75 c=0
Rz2 (\6\:Db \7\:Db) resistor r=75 c=0
Rz5 (\13\:CKbb \14\:CKbb) resistor r=75 c=0
Rz7 (\15\:CKb \16\:CKb) resistor r=75 c=0
Rz3 (\7\:n20 \8\:n20) resistor r=75 c=0
Rz4 (\4\:mout \5\:mout) resistor r=75 c=0
Rz6 (\9\:n30 \10\:n30) resistor r=75 c=0
Rz10 (\20\:qbint \19\:qbint) resistor r=75 c=0
Rz11 (\8\:qint \7\:qint) resistor r=75 c=0
Ry8 (\2\:Q \1\:Q) resistor r=20.6667 c=0
Ry18 (\13\:VDD \12\:VDD) resistor r=62 c=0
Ry19 (\16\:VDD \15\:VDD) resistor r=62 c=0
Ry20 (\20\:VDD \19\:VDD) resistor r=62 c=0
Ry21 (\22\:VDD \21\:VDD) resistor r=62 c=0
Ry9 (\4\:QN \3\:QN) resistor r=20.6667 c=0
Ry12 (\1\:VSS \4\:VSS) resistor r=5.1667 c=0
Ry13 (\9\:VSS \4\:VSS) resistor r=5.1667 c=0
Ry1 (\4\:Db \5\:Db) resistor r=62 c=0
Ry2 (\8\:Db \9\:Db) resistor r=62 c=0
Ry5 (\18\:CKbb \19\:CKbb) resistor r=62 c=0
Ry7 (\12\:CKb \13\:CKb) resistor r=62 c=0
Ry3 (\9\:n20 \10\:n20) resistor r=62 c=0
Ry4 (\8\:mout \9\:mout) resistor r=62 c=0
Ry6 (\7\:n30 \8\:n30) resistor r=62 c=0
Ry10 (\26\:qbint \25\:qbint) resistor r=62 c=0
Ry11 (\12\:qint \11\:qint) resistor r=62 c=0
Rx12 (\2\:CK \4\:CK) resistor r=45 c=0
Rx2 (\1\:RN \5\:RN) resistor r=45 c=0
Rx1 (\3\:D \5\:D) resistor r=45 c=0
Rx5 (\8\:CKbb \9\:CKbb) resistor r=45 c=0
Rx6 (\6\:CKbb \15\:CKbb) resistor r=45 c=0
Rx7 (\4\:CKbb \16\:CKbb) resistor r=45 c=0
Rx8 (\2\:CKbb \17\:CKbb) resistor r=45 c=0
Rx10 (\10\:CKb \11\:CKb) resistor r=45 c=0
Rx11 (CKb \14\:CKb) resistor r=45 c=0
Rx3 (\3\:n20 \5\:n20) resistor r=45 c=0
Rx4 (\2\:mout \7\:mout) resistor r=45 c=0
Rx9 (\3\:n30 \5\:n30) resistor r=45 c=0
Rx13 (\16\:qbint \13\:qbint) resistor r=45 c=0
Rx14 (\22\:qbint qbint) resistor r=45 c=0
Rx17 (\10\:qint qint) resistor r=45 c=0
mn1 (\6\:Db \1\:D n0 VSS) g45n1hvt w=(1.45e-07) l=4.5e-08 nf=1 as=8.7e-15 \
        ad=2.03e-14 ps=4.1e-07 pd=5.7e-07 nrd=1.16667 nrs=1.16667 \
        sa=1.4e-07 sb=4.5e-07 sd=160n sca=9.50767 scb=0.00818119 \
        scc=0.00019576 m=(1)
mn0 (n0 \3\:RN \19\:VSS VSS) g45n1hvt w=(1.45e-07) l=4.5e-08 nf=1 \
        as=2.32e-14 ad=8.7e-15 ps=6.1e-07 pd=4.1e-07 nrd=1.16667 \
        nrs=1.16667 sa=2.45e-07 sb=3.45e-07 sd=160n sca=9.50767 \
        scb=0.00818119 scc=0.00019576 m=(1)
mn21 (\13\:CKbb \5\:CKb \19\:VSS VSS) g45n1hvt w=(1.45e-07) l=4.5e-08 \
        nf=1 as=2.32e-14 ad=2.03e-14 ps=6.1e-07 pd=5.7e-07 nrd=1.16667 \
        nrs=1.16667 sa=4.5e-07 sb=1.4e-07 sd=160n sca=9.50767 \
        scb=0.00818119 scc=0.00019576 m=(1)
mn25 (\7\:n20 \6\:CKb Db VSS) g45n1hvt w=(1.45e-07) l=4.5e-08 nf=1 \
        as=2.03e-14 ad=4.93e-14 ps=5.7e-07 pd=9.7e-07 nrd=1.16667 \
        nrs=1.16667 sa=1.4e-07 sb=1.88e-06 sd=160n sca=23.279 \
        scb=0.0230742 scc=0.00267719 m=(1)
mn36 (\7\:n20 \3\:CKbb n25 VSS) g45n1hvt w=(1.45e-07) l=4.5e-08 nf=1 \
        as=9.43e-15 ad=4.93e-14 ps=4.2e-07 pd=9.7e-07 nrd=1.16667 \
        nrs=1.16667 sa=5.25e-07 sb=1.495e-06 sd=160n sca=23.279 \
        scb=0.0230742 scc=0.00267719 m=(1)
mn35 (n25 \3\:mout \17\:VSS VSS) g45n1hvt w=(1.45e-07) l=4.5e-08 nf=1 \
        as=8.41e-14 ad=9.43e-15 ps=1.6e-06 pd=4.2e-07 nrd=1.16667 \
        nrs=1.16667 sa=6.35e-07 sb=1.385e-06 sd=160n sca=23.279 \
        scb=0.0230742 scc=0.00267719 m=(1)
mn30 (\4\:mout \4\:n20 \17\:VSS VSS) g45n1hvt w=(1.45e-07) l=4.5e-08 \
        nf=1 as=8.41e-14 ad=3.988e-14 ps=1.6e-06 pd=8.4e-07 nrd=1.16667 \
        nrs=1.16667 sa=9e-07 sb=1.12e-06 sd=160n sca=23.279 scb=0.0230742 \
        scc=0.00267719 m=(1)
mn40 (\9\:n30 \5\:CKbb \4\:mout VSS) g45n1hvt w=(1.45e-07) l=4.5e-08 nf=1 \
        as=3.988e-14 ad=3.988e-14 ps=8.4e-07 pd=8.4e-07 nrd=1.16667 \
        nrs=1.16667 sa=1.22e-06 sb=8e-07 sd=160n sca=23.279 scb=0.0230742 \
        scc=0.00267719 m=(1)
mn51 (\9\:n30 \8\:CKb n35 VSS) g45n1hvt w=(1.45e-07) l=4.5e-08 nf=1 \
        as=8.7e-15 ad=3.988e-14 ps=4.1e-07 pd=8.4e-07 nrd=1.16667 \
        nrs=1.16667 sa=1.54e-06 sb=4.8e-07 sd=160n sca=23.279 \
        scb=0.0230742 scc=0.00267719 m=(1)
mn50 (n35 \3\:qbint \15\:VSS VSS) g45n1hvt w=(1.45e-07) l=4.5e-08 nf=1 \
        as=3.595e-14 ad=8.7e-15 ps=7.9e-07 pd=4.1e-07 nrd=1.16667 \
        nrs=1.16667 sa=1.645e-06 sb=3.75e-07 sd=160n sca=23.279 \
        scb=0.0230742 scc=0.00267719 m=(1)
mn20 (\15\:CKb \3\:CK \1\:VSS VSS) g45n1hvt w=(1.45e-07) l=4.5e-08 nf=1 \
        as=9.71e-14 ad=3.48e-14 ps=1.7e-06 pd=7.7e-07 nrd=1.16667 \
        nrs=1.16667 sa=2.4e-07 sb=1.395e-06 sd=160n sca=23.279 \
        scb=0.0230742 scc=0.00267719 m=(1)
mn56 (\7\:qint \14\:qbint \1\:VSS VSS) g45n1hvt w=(1.45e-07) l=4.5e-08 \
        nf=1 as=8.985e-14 ad=2.03e-14 ps=1.6e-06 pd=5.7e-07 nrd=1.16667 \
        nrs=1.16667 sa=1.495e-06 sb=1.4e-07 sd=160n sca=23.279 \
        scb=0.0230742 scc=0.00267719 m=(1)
mn45 (\19\:qbint \4\:n30 \15\:VSS VSS) g45n1hvt w=(2.05e-07) l=4.5e-08 \
        nf=1 as=3.595e-14 ad=2.87e-14 ps=7.9e-07 pd=6.9e-07 nrd=1.16667 \
        nrs=1.16667 sa=1.37073e-06 sb=1.4e-07 sd=160n sca=19.867 \
        scb=0.0198061 scc=0.00201945 m=(1)
mn55 (\3\:Q \5\:qbint \1\:VSS VSS) g45n1hvt w=(2.6e-07) l=4.5e-08 nf=1 \
        as=9.635e-14 ad=4.16e-14 ps=1.65e-06 pd=8.4e-07 nrd=1.16667 \
        nrs=1.16667 sa=3.84712e-07 sb=9.76058e-07 sd=160n sca=17.5885 \
        scb=0.0172826 scc=0.00162584 m=(2)
mn57 (\1\:QN qint \1\:VSS VSS) g45n1hvt w=(2.6e-07) l=4.5e-08 nf=1 \
        as=9.273e-14 ad=4.16e-14 ps=1.6e-06 pd=8.4e-07 nrd=1.16667 \
        nrs=1.16667 sa=8.54712e-07 sb=5.06058e-07 sd=160n sca=17.5885 \
        scb=0.0172826 scc=0.00162584 m=(2)
mp45 (\25\:qbint n30 \12\:VDD VDD) g45p1hvt w=(3.1e-07) l=4.5e-08 nf=1 \
        as=9.465e-14 ad=4.34e-14 ps=1.58e-06 pd=9e-07 nrd=1.16667 \
        nrs=1.16667 sa=1.28315e-06 sb=1.4e-07 sd=160n sca=12.3129 \
        scb=0.0108562 scc=0.00039161 m=(1)
mp57_1__rcx (\3\:QN qint \1\:VDD VDD) g45p1hvt w=(3.9e-07) l=4.5e-08 \
        nf=1 as=6.388e-14 ad=6.24e-14 ps=1.13e-06 pd=1.1e-06 nrd=1.16667 \
        nrs=1.16667 sa=6.98846e-07 sb=4.74551e-07 sd=160n sca=31.0979 \
        scb=0.0204275 scc=0.00336106 m=(2)
mp55_1__rcx (\1\:Q \5\:qbint \1\:VDD VDD) g45p1hvt w=(3.9e-07) l=4.5e-08 \
        nf=1 as=6.764e-14 ad=6.24e-14 ps=1.165e-06 pd=1.1e-06 nrd=1.16667 \
        nrs=1.16667 sa=2.88846e-07 sb=8.84551e-07 sd=160n sca=30.5009 \
        scb=0.0202006 scc=0.00336097 m=(2)
ends DFFTRX2
// End of subcircuit definition.
