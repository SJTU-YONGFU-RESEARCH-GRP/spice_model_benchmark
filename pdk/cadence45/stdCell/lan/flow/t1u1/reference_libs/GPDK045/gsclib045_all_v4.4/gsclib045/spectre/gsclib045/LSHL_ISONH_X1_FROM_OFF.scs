// gsclib045/LSHL_ISONH_X1_FROM_OFF/schematic

simulator lang=spectre

subckt LSHL_ISONH_X1_FROM_OFF A ISOn Y ExtVDD VSS VDD
NM3 (gatedVSS ISOn VSS VSS) g45n1svt w=(520n) l=45n nf=2 m=(1)
NM0 (Y n0 gatedVSS VSS) g45n1svt w=(260n) l=45n nf=1 m=(1)
mn0 (gatedVSS A n0 VSS) g45n1svt w=(145n) l=45n nf=1 m=(1)
PM4 (Y ISOn ExtVDD ExtVDD) g45p1svt w=(390n) l=45n nf=1 m=(1)
PM0 (Y n0 ExtVDD ExtVDD) g45p1svt w=(390n) l=45n nf=1 m=(1)
mp0 (n0 A ExtVDD ExtVDD) g45p1svt w=(215n) l=45n nf=1 m=(1)
ends LSHL_ISONH_X1_FROM_OFF
