// Generated for: spectre (May  1 09:18:10 2013 )
// Library name: gsclib045_lvt
// Cell name: OAI222X2
// View name: extracted

simulator lang=spectre

subckt OAI222X2 A0 A1 B0 B1 C0 C1 VDD VSS Y
mp0_1__rcx (1 \1\:A0 \14\:VDD VDD) g45p1lvt w=(3.9e-07) l=4.5e-08 nf=1 \
        as=5.46e-14 ad=6.825e-14 ps=1.06e-06 pd=1.13e-06 nrd=1.16667 \
        nrs=1.16667 sa=1.4e-07 sb=2e-06 sd=160n sca=19.1227 scb=0.0199265 \
        scc=0.000804362 m=(1)
mp1_1__rcx (\7\:Y \6\:A1 1 VDD) g45p1lvt w=(3.9e-07) l=4.5e-08 nf=1 \
        as=6.825e-14 ad=6.24e-14 ps=1.13e-06 pd=1.1e-06 nrd=1.16667 \
        nrs=1.16667 sa=3.6e-07 sb=2e-06 sd=160n sca=15.2793 scb=0.0134932 \
        scc=0.000650526 m=(1)
mp1 (\7\:Y \1\:A1 4 VDD) g45p1lvt w=(3.9e-07) l=4.5e-08 nf=1 as=4.485e-14 \
        ad=6.24e-14 ps=1.01e-06 pd=1.1e-06 nrd=1.16667 nrs=1.16667 \
        sa=5.65e-07 sb=2e-06 sd=160n sca=14.1076 scb=0.0123774 \
        scc=0.000647578 m=(1)
mp0 (4 \4\:A0 \12\:VDD VDD) g45p1lvt w=(3.9e-07) l=4.5e-08 nf=1 \
        as=1.911e-13 ad=4.485e-14 ps=1.76e-06 pd=1.01e-06 nrd=1.16667 \
        nrs=1.16667 sa=7.25e-07 sb=1.98e-06 sd=160n sca=13.6573 \
        scb=0.0122016 scc=0.000647515 m=(1)
mp2_1__rcx (5 \1\:B0 \12\:VDD VDD) g45p1lvt w=(3.9e-07) l=4.5e-08 nf=1 \
        as=1.911e-13 ad=4.485e-14 ps=1.76e-06 pd=1.01e-06 nrd=1.16667 \
        nrs=1.16667 sa=1.26e-06 sb=1.445e-06 sd=160n sca=13.5671 \
        scb=0.012183 scc=0.000647513 m=(1)
mp3_1__rcx (\5\:Y \5\:B1 5 VDD) g45p1lvt w=(3.9e-07) l=4.5e-08 nf=1 \
        as=4.485e-14 ad=6.24e-14 ps=1.01e-06 pd=1.1e-06 nrd=1.16667 \
        nrs=1.16667 sa=1.42e-06 sb=1.285e-06 sd=160n sca=13.5671 \
        scb=0.012183 scc=0.000647513 m=(1)
mp3 (\5\:Y \7\:B1 6 VDD) g45p1lvt w=(3.9e-07) l=4.5e-08 nf=1 \
        as=1.0725e-13 ad=6.24e-14 ps=1.33e-06 pd=1.1e-06 nrd=1.16667 \
        nrs=1.16667 sa=1.625e-06 sb=1.08e-06 sd=160n sca=13.5671 \
        scb=0.012183 scc=0.000647513 m=(1)
mp2 (6 \4\:B0 \10\:VDD VDD) g45p1lvt w=(3.9e-07) l=4.5e-08 nf=1 \
        as=6.24e-14 ad=1.0725e-13 ps=1.1e-06 pd=1.33e-06 nrd=1.16667 \
        nrs=1.16667 sa=1.945e-06 sb=7.6e-07 sd=160n sca=13.5671 \
        scb=0.012183 scc=0.000647513 m=(1)
mp4_1__rcx (7 \1\:C0 \10\:VDD VDD) g45p1lvt w=(3.9e-07) l=4.5e-08 nf=1 \
        as=6.24e-14 ad=2.34e-14 ps=1.1e-06 pd=9e-07 nrd=1.16667 \
        nrs=1.16667 sa=2e-06 sb=5.55e-07 sd=160n sca=13.5671 scb=0.012183 \
        scc=0.000647513 m=(1)
mp5_1__rcx (\3\:Y \4\:C1 7 VDD) g45p1lvt w=(3.9e-07) l=4.5e-08 nf=1 \
        as=2.34e-14 ad=6.24e-14 ps=9e-07 pd=1.1e-06 nrd=1.16667 \
        nrs=1.16667 sa=2e-06 sb=4.5e-07 sd=160n sca=13.5861 scb=0.0121865 \
        scc=0.000647513 m=(1)
mp5 (\3\:Y \6\:C1 8 VDD) g45p1lvt w=(3.9e-07) l=4.5e-08 nf=1 as=2.34e-14 \
        ad=6.24e-14 ps=9e-07 pd=1.1e-06 nrd=1.16667 nrs=1.16667 sa=2e-06 \
        sb=2.45e-07 sd=160n sca=14.1449 scb=0.0123986 scc=0.000647592 \
        m=(1)
mp4 (8 \7\:C0 \8\:VDD VDD) g45p1lvt w=(3.9e-07) l=4.5e-08 nf=1 \
        as=5.46e-14 ad=2.34e-14 ps=1.06e-06 pd=9e-07 nrd=1.16667 \
        nrs=1.16667 sa=2e-06 sb=1.4e-07 sd=160n sca=14.6385 scb=0.0127742 \
        scc=0.000648083 m=(1)
C1 (Y VSS) capacitor c=9.26337e-17
C2 (C0 VSS) capacitor c=4.20746e-16
C3 (B1 VSS) capacitor c=3.87866e-17
C4 (A0 VSS) capacitor c=8.14613e-17
C5 (C1 VSS) capacitor c=1.05737e-16
C6 (VDD VSS) capacitor c=1.67033e-16
C7 (n1 VSS) capacitor c=1.77587e-16
C8 (n0 VSS) capacitor c=1.74736e-16
C9 (1 VSS) capacitor c=4.56923e-18
C10 (4 VSS) capacitor c=4.50828e-18
C11 (5 VSS) capacitor c=4.44019e-18
C12 (6 VSS) capacitor c=1.33345e-17
C13 (7 VSS) capacitor c=2.44041e-18
C14 (8 VSS) capacitor c=2.44041e-18
C15 (\7\:C0 VSS) capacitor c=7.74245e-17
C16 (\6\:C1 VSS) capacitor c=6.61226e-17
C17 (\4\:C1 VSS) capacitor c=6.18829e-17
C18 (\1\:C0 VSS) capacitor c=7.35528e-17
C19 (\4\:B0 VSS) capacitor c=3.90272e-17
C20 (\7\:B1 VSS) capacitor c=3.03338e-17
C21 (\5\:B1 VSS) capacitor c=5.63882e-17
C22 (\1\:B0 VSS) capacitor c=4.20518e-17
C23 (\4\:A0 VSS) capacitor c=4.18267e-17
C24 (\1\:A1 VSS) capacitor c=5.58617e-17
C25 (\6\:A1 VSS) capacitor c=3.72904e-17
C26 (\1\:A0 VSS) capacitor c=3.02404e-17
C27 (\1\:C1 VSS) capacitor c=8.70309e-17
C28 (\1\:B1 VSS) capacitor c=7.6659e-17
C29 (\3\:C1 VSS) capacitor c=5.58326e-17
C30 (\2\:B0 VSS) capacitor c=3.67008e-16
C31 (\2\:A0 VSS) capacitor c=2.40882e-16
C32 (\8\:VDD VSS) capacitor c=3.24883e-17
C33 (\3\:Y VSS) capacitor c=1.77147e-16
C34 (\10\:VDD VSS) capacitor c=3.55049e-17
C35 (\5\:Y VSS) capacitor c=1.4056e-16
C36 (\12\:VDD VSS) capacitor c=4.83838e-17
C37 (\7\:Y VSS) capacitor c=1.01151e-16
C38 (\14\:VDD VSS) capacitor c=1.4379e-17
C39 (\1\:VDD VSS) capacitor c=3.92303e-17
C40 (\1\:Y VSS) capacitor c=1.45278e-16
C41 (\3\:n0 VSS) capacitor c=7.86165e-17
C42 (\7\:n0 VSS) capacitor c=8.91333e-17
C43 (\5\:n1 VSS) capacitor c=1.29071e-16
C44 (\2\:A1 VSS) capacitor c=1.23229e-16
C45 (\4\:B1 VSS) capacitor c=3.21063e-17
C46 (\7\:A1 VSS) capacitor c=3.21624e-17
C47 (\9\:A1 VSS) capacitor c=4.9416e-17
C48 (\8\:B1 VSS) capacitor c=5.93845e-17
C49 (\3\:VDD VSS) capacitor c=1.28089e-17
C50 (\4\:VDD VSS) capacitor c=2.85084e-17
C51 (\6\:VDD VSS) capacitor c=1.63573e-17
C52 (\7\:VDD VSS) capacitor c=1.45743e-17
Rk11 (\2\:B0 B0) resistor r=0.005612 c=0
Rk1 (\7\:A1 \8\:A1) resistor r=0.0129 c=0
Rk2 (A1 \9\:A1) resistor r=0.01276 c=0
Rk3 (\7\:A1 \9\:A1) resistor r=0.04398 c=0
Rk34 (\2\:VSS \3\:VSS) resistor r=0.8508 c=0
Rk38 (\4\:VSS VSS) resistor r=0.03709 c=0
Rk35 (\3\:VSS \4\:VSS) resistor r=0.08989 c=0
Rk40 (\4\:VSS \10\:VSS) resistor r=0.2021 c=0
Rk19 (\1\:Y Y) resistor r=0.3767 c=0
Rk20 (Y \4\:Y) resistor r=0.8614 c=0
Rk21 (\4\:Y \6\:Y) resistor r=0.6011 c=0
Rk22 (\6\:Y \8\:Y) resistor r=0.7364 c=0
Rk6 (B1 \8\:B1) resistor r=0.1155 c=0
Rk4 (A0 \2\:A0) resistor r=0.01196 c=0
Rk12 (\7\:C1 C1) resistor r=0.00375 c=0
Rk24 (\2\:VDD \3\:VDD) resistor r=0.03484 c=0
Rk25 (\3\:VDD \4\:VDD) resistor r=0.3099 c=0
Rk26 (\4\:VDD \5\:VDD) resistor r=0.5053 c=0
Rk27 (\5\:VDD \6\:VDD) resistor r=0.1049 c=0
Rk29 (\7\:VDD VDD) resistor r=0.06462 c=0
Rk28 (\6\:VDD \7\:VDD) resistor r=0.38 c=0
Rk30 (\3\:VDD \9\:VDD) resistor r=0.2175 c=0
Rk31 (\4\:VDD \11\:VDD) resistor r=0.2175 c=0
Rk32 (\6\:VDD \13\:VDD) resistor r=0.2175 c=0
Rk33 (\7\:VDD \15\:VDD) resistor r=0.222 c=0
Rk8 (n1 \5\:n1) resistor r=0.505 c=0
Rl18 (\2\:B0 \4\:B0) resistor r=29.5379 c=0
Rl10 (\2\:B0 \1\:B0) resistor r=44.9225 c=0
Rl3 (\2\:A1 \1\:A1) resistor r=146.132 c=0
Rl7 (\2\:A1 \6\:A1) resistor r=105.002 c=0
Rl29 (C0 \7\:C0) resistor r=100.539 c=0
Rl20 (C0 \1\:C0) resistor r=37.3411 c=0
Rl13 (\1\:B1 \3\:B1) resistor r=0.075 c=0
Rl17 (\4\:B1 \7\:B1) resistor r=107.256 c=0
Rl15 (\4\:B1 \5\:B1) resistor r=151.408 c=0
Rl14 (\4\:B1 \3\:B1) resistor r=3.9095 c=0
Rl8 (\2\:A0 \4\:A0) resistor r=41.0764 c=0
Rl1 (\2\:A0 \1\:A0) resistor r=30.7692 c=0
Rl27 (\3\:C1 \6\:C1) resistor r=82.6695 c=0
Rl25 (\3\:C1 \4\:C1) resistor r=59.5926 c=0
Rl24 (\1\:C1 \3\:C1) resistor r=58.644 c=0
Rz15 (\10\:VSS \9\:VSS) resistor r=75 c=0
Rz12 (\1\:VDD \2\:VDD) resistor r=15 c=0
Rz13 (\1\:VDD \5\:VDD) resistor r=6.25 c=0
Rz6 (n0 \3\:n0) resistor r=75 c=0
Rz8 (n0 \7\:n0) resistor r=75 c=0
Ry8 (\2\:VSS \1\:VSS) resistor r=12.4 c=0
Ry9 (\3\:VSS \1\:VSS) resistor r=5.1667 c=0
Ry1 (\4\:Y \3\:Y) resistor r=62 c=0
Ry2 (\6\:Y \5\:Y) resistor r=62 c=0
Ry3 (\8\:Y \7\:Y) resistor r=62 c=0
Ry4 (\8\:VDD \9\:VDD) resistor r=62 c=0
Ry5 (\10\:VDD \11\:VDD) resistor r=62 c=0
Ry6 (\12\:VDD \13\:VDD) resistor r=62 c=0
Ry7 (\14\:VDD \15\:VDD) resistor r=62 c=0
Rx1 (\8\:A1 \2\:A1) resistor r=45 c=0
Rx4 (\8\:B1 \3\:B1) resistor r=45 c=0
Rx7 (\7\:C1 \3\:C1) resistor r=45 c=0
mn0_1__rcx (\5\:n1 \2\:A0 \4\:VSS VSS) g45n1lvt w=(2.6e-07) l=4.5e-08 \
        nf=1 as=3.64e-14 ad=4.485e-14 ps=8e-07 pd=8.65e-07 nrd=1.16667 \
        nrs=1.16667 sa=1.4e-07 sb=7.8e-07 sd=160n sca=9.14564 \
        scb=0.00759168 scc=0.000213449 m=(2)
mn1 (\5\:n1 \2\:A1 \9\:VSS VSS) g45n1lvt w=(2.6e-07) l=4.5e-08 nf=1 \
        as=4.16e-14 ad=4.485e-14 ps=8.4e-07 pd=8.65e-07 nrd=1.16667 \
        nrs=1.16667 sa=3.45e-07 sb=5.75e-07 sd=160n sca=9.14564 \
        scb=0.00759168 scc=0.000213449 m=(2)
mn3 (\7\:n0 \1\:B1 n1 VSS) g45n1lvt w=(2.6e-07) l=4.5e-08 nf=1 \
        as=5.07e-14 ad=4.16e-14 ps=9.1e-07 pd=8.4e-07 nrd=1.16667 \
        nrs=1.16667 sa=3.45e-07 sb=1.44e-06 sd=160n sca=9.14564 \
        scb=0.00759168 scc=0.000213449 m=(2)
mn4_1__rcx (\1\:Y C0 n0 VSS) g45n1lvt w=(2.6e-07) l=4.5e-08 nf=1 \
        as=3.9e-14 ad=4.16e-14 ps=8.2e-07 pd=8.4e-07 nrd=1.16667 \
        nrs=1.16667 sa=1.03e-06 sb=7.55e-07 sd=160n sca=9.14564 \
        scb=0.00759168 scc=0.000213449 m=(2)
mn5_1__rcx (\1\:Y \1\:C1 \3\:n0 VSS) g45n1lvt w=(2.6e-07) l=4.5e-08 nf=1 \
        as=4.16e-14 ad=4.16e-14 ps=8.4e-07 pd=8.4e-07 nrd=1.16667 \
        nrs=1.16667 sa=1.235e-06 sb=5.5e-07 sd=160n sca=9.14564 \
        scb=0.00759168 scc=0.000213449 m=(2)
mn2_1__rcx (n0 \2\:B0 n1 VSS) g45n1lvt w=(2.6e-07) l=4.5e-08 nf=1 \
        as=5.07e-14 ad=3.9e-14 ps=9.1e-07 pd=8.2e-07 nrd=1.16667 \
        nrs=1.16667 sa=1.4e-07 sb=1.645e-06 sd=160n sca=9.14564 \
        scb=0.00759168 scc=0.000213449 m=(2)
ends OAI222X2
// End of subcircuit definition.
