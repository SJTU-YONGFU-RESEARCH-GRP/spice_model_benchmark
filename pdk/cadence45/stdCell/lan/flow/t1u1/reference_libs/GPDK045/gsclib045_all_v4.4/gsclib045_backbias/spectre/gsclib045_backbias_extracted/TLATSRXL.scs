// Generated for: spectre (May  1 11:33:39 2013 )
// Library name: gsclib045_backbias
// Cell name: TLATSRXL
// View name: extracted

simulator lang=spectre

subckt TLATSRXL D G NW Q QN RN SN VDD VSS
mp21 (\1\:Q \4\:Qbint \16\:VDD NW) g45p1svt w=(2.15e-07) l=4.5e-08 nf=1 \
        as=5.73e-14 ad=3.548e-14 ps=1.47e-06 pd=7.6e-07 nrd=1.16667 \
        nrs=1.16667 sa=1.65e-07 sb=3.45e-07 sd=160n sca=49.1385 \
        scb=0.0321853 scc=0.00591609 m=(1)
mp20 (\5\:Qbint \7\:Qint \16\:VDD NW) g45p1svt w=(2.15e-07) l=4.5e-08 \
        nf=1 as=5.73e-14 ad=3.01e-14 ps=1.47e-06 pd=7.1e-07 nrd=1.16667 \
        nrs=1.16667 sa=3.7e-07 sb=1.4e-07 sd=160n sca=46.9517 scb=0.029008 \
        scc=0.00588492 m=(1)
mp22 (\1\:QN Qint \14\:VDD NW) g45p1svt w=(2.15e-07) l=4.5e-08 nf=1 \
        as=6.715e-14 ad=3.655e-14 ps=1.6e-06 pd=7.7e-07 nrd=1.16667 \
        nrs=1.16667 sa=1.7e-07 sb=1.68e-06 sd=160n sca=11.7888 \
        scb=0.0102603 scc=0.000281769 m=(1)
mp10 (\12\:Qint \1\:SN \14\:VDD NW) g45p1svt w=(2.15e-07) l=4.5e-08 nf=1 \
        as=6.715e-14 ad=4.945e-14 ps=1.6e-06 pd=8.9e-07 nrd=1.16667 \
        nrs=1.16667 sa=4.15e-07 sb=1.435e-06 sd=160n sca=11.7888 \
        scb=0.0102603 scc=0.000281769 m=(1)
mp11 (\12\:Qint n5 \12\:VDD NW) g45p1svt w=(2.15e-07) l=4.5e-08 nf=1 \
        as=8.327e-14 ad=4.945e-14 ps=1.75e-06 pd=8.9e-07 nrd=1.16667 \
        nrs=1.16667 sa=6.9e-07 sb=1.16e-06 sd=160n sca=11.7888 \
        scb=0.0102603 scc=0.000281769 m=(1)
mp1 (\15\:Gb \3\:G \12\:VDD NW) g45p1svt w=(2.15e-07) l=4.5e-08 nf=1 \
        as=8.327e-14 ad=6.342e-14 ps=1.75e-06 pd=1.02e-06 nrd=1.16667 \
        nrs=1.16667 sa=1.01e-06 sb=8.4e-07 sd=160n sca=11.7888 \
        scb=0.0102603 scc=0.000281769 m=(1)
mp0 (\15\:Gb \3\:RN \10\:VDD NW) g45p1svt w=(2.15e-07) l=4.5e-08 nf=1 \
        as=5.64e-14 ad=6.342e-14 ps=1.5e-06 pd=1.02e-06 nrd=1.16667 \
        nrs=1.16667 sa=1.35e-06 sb=5e-07 sd=160n sca=11.7888 scb=0.0102603 \
        scc=0.000281769 m=(1)
mp15 (net103 \5\:RN \10\:VDD NW) g45p1svt w=(2.15e-07) l=4.5e-08 nf=1 \
        as=5.64e-14 ad=3.44e-14 ps=1.5e-06 pd=7.5e-07 nrd=1.16667 \
        nrs=1.16667 sa=1.545e-06 sb=3.05e-07 sd=160n sca=11.7888 \
        scb=0.0102603 scc=0.000281769 m=(1)
mp16 (net103 \10\:Qint \8\:VDD NW) g45p1svt w=(2.15e-07) l=4.5e-08 nf=1 \
        as=4.04e-14 ad=3.44e-14 ps=1.19e-06 pd=7.5e-07 nrd=1.16667 \
        nrs=1.16667 sa=1.75e-06 sb=1e-07 sd=160n sca=11.7888 scb=0.0102603 \
        scc=0.000281769 m=(1)
mp17 (\4\:n5 \3\:Gbb \3\:net103 NW) g45p1svt w=(2.15e-07) l=4.5e-08 nf=1 \
        as=4.37e-14 ad=3.44e-14 ps=1e-06 pd=7.5e-07 nrd=1.16667 \
        nrs=1.16667 sa=2.03256e-07 sb=7.4e-07 sd=160n sca=16.4252 \
        scb=0.0160149 scc=0.00103902 m=(1)
mp6 (\4\:n5 \3\:Gb net142 NW) g45p1svt w=(2.15e-07) l=4.5e-08 nf=1 \
        as=1.827e-14 ad=3.44e-14 ps=6e-07 pd=7.5e-07 nrd=1.16667 \
        nrs=1.16667 sa=4.08256e-07 sb=5.35e-07 sd=160n sca=17.3959 \
        scb=0.0167815 scc=0.00104031 m=(1)
mp5 (net142 \3\:D \1\:VDD NW) g45p1svt w=(2.15e-07) l=4.5e-08 nf=1 \
        as=9.47e-14 ad=1.827e-14 ps=1.66e-06 pd=6e-07 nrd=1.16667 \
        nrs=1.16667 sa=5.38256e-07 sb=4.05e-07 sd=160n sca=18.6804 \
        scb=0.0185729 scc=0.00105319 m=(1)
mp2 (\4\:Gbb \5\:Gb \1\:VDD NW) g45p1svt w=(2.15e-07) l=4.5e-08 nf=1 \
        as=9.47e-14 ad=3.01e-14 ps=1.66e-06 pd=7.1e-07 nrd=1.16667 \
        nrs=1.16667 sa=8.03256e-07 sb=1.4e-07 sd=160n sca=29.6999 \
        scb=0.0349125 scc=0.00244535 m=(1)
C1 (SN VSS) capacitor c=4.92936e-17
C2 (D VSS) capacitor c=6.4409e-17
C3 (Q VSS) capacitor c=2.29669e-17
C4 (NW VSS) capacitor c=5.45737e-16
C5 (QN VSS) capacitor c=3.00174e-17
C6 (VDD VSS) capacitor c=4.3039e-17
C7 (G VSS) capacitor c=5.95352e-17
C8 (Qbint VSS) capacitor c=2.09134e-17
C9 (Qint VSS) capacitor c=3.85216e-17
C10 (net183 VSS) capacitor c=9.46826e-20
C11 (n5 VSS) capacitor c=5.52237e-17
C12 (net159 VSS) capacitor c=1.69534e-18
C13 (Gb VSS) capacitor c=4.75112e-17
C14 (net167 VSS) capacitor c=3.21829e-18
C15 (net171 VSS) capacitor c=5.61054e-18
C16 (Gbb VSS) capacitor c=3.22935e-17
C17 (net103 VSS) capacitor c=6.67751e-17
C18 (net142 VSS) capacitor c=5.37863e-19
C19 (\5\:Gb VSS) capacitor c=4.25227e-17
C20 (\3\:D VSS) capacitor c=5.4673e-17
C21 (\3\:Gb VSS) capacitor c=5.93203e-17
C22 (\3\:Gbb VSS) capacitor c=5.56908e-17
C23 (\10\:Qint VSS) capacitor c=3.15643e-17
C24 (\5\:RN VSS) capacitor c=3.06215e-17
C25 (\3\:RN VSS) capacitor c=2.69643e-17
C26 (\3\:G VSS) capacitor c=4.30752e-17
C27 (\1\:SN VSS) capacitor c=3.68164e-17
C28 (\7\:Qint VSS) capacitor c=3.17327e-17
C29 (\4\:Qbint VSS) capacitor c=3.68953e-17
C30 (\6\:Gb VSS) capacitor c=4.94194e-17
C31 (\1\:D VSS) capacitor c=5.28287e-17
C32 (\8\:Qint VSS) capacitor c=6.3662e-17
C33 (\1\:RN VSS) capacitor c=4.40035e-17
C34 (\4\:RN VSS) capacitor c=2.47367e-17
C35 (\1\:G VSS) capacitor c=4.36216e-17
C36 (\2\:n5 VSS) capacitor c=3.66297e-17
C37 (\3\:SN VSS) capacitor c=4.56405e-17
C38 (\6\:Qint VSS) capacitor c=2.16413e-17
C39 (\4\:Qint VSS) capacitor c=3.12131e-17
C40 (\3\:Qbint VSS) capacitor c=2.72355e-17
C41 (\7\:Gb VSS) capacitor c=2.07106e-17
C42 (\2\:D VSS) capacitor c=5.70063e-17
C43 (\2\:Gbb VSS) capacitor c=6.04578e-17
C44 (\4\:Gb VSS) capacitor c=2.48722e-17
C45 (\2\:Gb VSS) capacitor c=2.30113e-17
C46 (\9\:Qint VSS) capacitor c=5.92757e-17
C47 (\2\:RN VSS) capacitor c=7.40324e-17
C48 (\2\:G VSS) capacitor c=4.58027e-17
C49 (\3\:n5 VSS) capacitor c=1.96611e-17
C50 (\2\:SN VSS) capacitor c=3.97137e-17
C51 (\5\:Qint VSS) capacitor c=1.72945e-17
C52 (\4\:Gbb VSS) capacitor c=3.85594e-17
C53 (\1\:VDD VSS) capacitor c=1.13095e-16
C54 (\4\:n5 VSS) capacitor c=7.86637e-17
C55 (\3\:net103 VSS) capacitor c=8.59632e-17
C56 (\8\:VDD VSS) capacitor c=2.89916e-17
C57 (\10\:VDD VSS) capacitor c=7.93132e-18
C58 (\15\:Gb VSS) capacitor c=7.35247e-17
C59 (\12\:VDD VSS) capacitor c=1.555e-17
C60 (\12\:Qint VSS) capacitor c=1.51137e-16
C61 (\14\:VDD VSS) capacitor c=4.02473e-18
C62 (\1\:QN VSS) capacitor c=3.96677e-17
C63 (\5\:Qbint VSS) capacitor c=2.3875e-17
C64 (\16\:VDD VSS) capacitor c=1.66102e-17
C65 (\1\:Q VSS) capacitor c=1.56144e-17
C66 (\8\:Gbb VSS) capacitor c=1.91859e-17
C67 (\6\:n5 VSS) capacitor c=2.01228e-16
C68 (\13\:Gb VSS) capacitor c=3.25072e-17
C69 (\15\:Qint VSS) capacitor c=3.02925e-17
C70 (\4\:QN VSS) capacitor c=2.42443e-17
C71 (\9\:Qbint VSS) capacitor c=4.19988e-17
C72 (\3\:Q VSS) capacitor c=4.27708e-17
C73 (\2\:Qbint VSS) capacitor c=1.34888e-17
C74 (\2\:Qint VSS) capacitor c=2.8484e-17
C75 (\3\:Qint VSS) capacitor c=3.53378e-17
C76 (\7\:Qbint VSS) capacitor c=3.45284e-17
C77 (\8\:Qbint VSS) capacitor c=3.39922e-17
C78 (\3\:QN VSS) capacitor c=5.69729e-17
C79 (\4\:SN VSS) capacitor c=6.27333e-17
C80 (\4\:G VSS) capacitor c=7.55716e-17
C81 (\6\:RN VSS) capacitor c=1.31113e-16
C82 (\11\:Qint VSS) capacitor c=1.73304e-16
C83 (\14\:Qint VSS) capacitor c=1.12022e-16
C84 (\17\:Qint VSS) capacitor c=6.71833e-17
C85 (\8\:n5 VSS) capacitor c=1.59157e-16
C86 (\4\:D VSS) capacitor c=3.02689e-17
C87 (\6\:Gbb VSS) capacitor c=3.98211e-17
C88 (\7\:Gbb VSS) capacitor c=5.82182e-17
C89 (\8\:Gb VSS) capacitor c=4.52929e-17
C90 (\9\:Gb VSS) capacitor c=1.031e-16
C91 (\10\:Gb VSS) capacitor c=1.74195e-16
C92 (\11\:Gb VSS) capacitor c=2.05946e-17
C93 (\12\:Gb VSS) capacitor c=1.55408e-16
C94 (\3\:VDD VSS) capacitor c=6.26281e-17
C95 (\4\:VDD VSS) capacitor c=5.02114e-17
C96 (\5\:VDD VSS) capacitor c=5.974e-17
C97 (\6\:VDD VSS) capacitor c=5.24971e-17
C98 (\7\:VDD VSS) capacitor c=4.97106e-17
Rk9 (SN \4\:SN) resistor r=0.1349 c=0
Rk19 (\4\:D D) resistor r=0.1484 c=0
Rk2 (\4\:Q Q) resistor r=0.0928 c=0
Rk1 (\2\:Q \4\:Q) resistor r=0.2241 c=0
Rk11 (RN \6\:RN) resistor r=0.006782 c=0
Rk40 (\2\:VSS \4\:VSS) resistor r=0.5609 c=0
Rk41 (\4\:VSS \5\:VSS) resistor r=0.2779 c=0
Rk42 (\5\:VSS \6\:VSS) resistor r=0.724 c=0
Rk43 (\5\:VSS \8\:VSS) resistor r=0.2184 c=0
Rk45 (\9\:VSS VSS) resistor r=0.2125 c=0
Rk44 (\6\:VSS \9\:VSS) resistor r=0.3386 c=0
Rk46 (\6\:VSS \11\:VSS) resistor r=0.3707 c=0
Rk47 (\9\:VSS \13\:VSS) resistor r=0.3666 c=0
Rk7 (\3\:QN QN) resistor r=0.0121 c=0
Rk6 (\2\:QN \3\:QN) resistor r=0.3016 c=0
Rk8 (\3\:QN \5\:QN) resistor r=0.07419 c=0
Rk29 (\2\:VDD \3\:VDD) resistor r=0.4691 c=0
Rk30 (\3\:VDD \4\:VDD) resistor r=0.2001 c=0
Rk31 (\4\:VDD \5\:VDD) resistor r=0.3304 c=0
Rk32 (\5\:VDD \6\:VDD) resistor r=0.2602 c=0
Rk34 (\7\:VDD VDD) resistor r=0.2276 c=0
Rk33 (\6\:VDD \7\:VDD) resistor r=0.3429 c=0
Rk35 (\3\:VDD \9\:VDD) resistor r=0.143 c=0
Rk36 (\4\:VDD \11\:VDD) resistor r=0.07334 c=0
Rk37 (\5\:VDD \13\:VDD) resistor r=0.07334 c=0
Rk38 (\6\:VDD \15\:VDD) resistor r=0.07334 c=0
Rk39 (\7\:VDD \17\:VDD) resistor r=0.2226 c=0
Rk10 (G \4\:G) resistor r=0.2005 c=0
Rk3 (\6\:Qbint \7\:Qbint) resistor r=0.1144 c=0
Rk4 (\7\:Qbint \8\:Qbint) resistor r=0.119 c=0
Rk5 (\7\:Qbint \10\:Qbint) resistor r=0.1084 c=0
Rk12 (\11\:Qint \13\:Qint) resistor r=1.2207 c=0
Rk13 (\13\:Qint \14\:Qint) resistor r=0.5552 c=0
Rk14 (\14\:Qint \16\:Qint) resistor r=0.1036 c=0
Rk15 (\14\:Qint \17\:Qint) resistor r=0.3941 c=0
Rk17 (\5\:n5 \7\:n5) resistor r=0.4493 c=0
Rk18 (\7\:n5 \8\:n5) resistor r=1.264 c=0
Rk23 (\8\:Gb \9\:Gb) resistor r=0.3764 c=0
Rk24 (\9\:Gb \10\:Gb) resistor r=0.6424 c=0
Rk25 (\9\:Gb \11\:Gb) resistor r=0.04035 c=0
Rk26 (\10\:Gb \12\:Gb) resistor r=0.7677 c=0
Rk27 (\12\:Gb \14\:Gb) resistor r=0.1156 c=0
Rk28 (\12\:Gb \16\:Gb) resistor r=0.3388 c=0
Rk20 (\5\:Gbb \6\:Gbb) resistor r=0.2728 c=0
Rk21 (\6\:Gbb \7\:Gbb) resistor r=0.2819 c=0
Rk22 (\6\:Gbb \9\:Gbb) resistor r=0.1228 c=0
Rk16 (\2\:net103 \4\:net103) resistor r=0.299 c=0
Rl10 (\1\:SN \2\:SN) resistor r=29.5379 c=0
Rl11 (\2\:SN \3\:SN) resistor r=133.384 c=0
Rl27 (\2\:D \3\:D) resistor r=51.9003 c=0
Rl26 (\1\:D \2\:D) resistor r=95.9489 c=0
Rl19 (\2\:RN \5\:RN) resistor r=81.8672 c=0
Rl17 (\2\:RN \3\:RN) resistor r=146.746 c=0
Rl16 (\1\:RN \2\:RN) resistor r=153.916 c=0
Rl18 (\2\:RN \4\:RN) resistor r=85.7134 c=0
Rl15 (\2\:G \3\:G) resistor r=137.436 c=0
Rl14 (\1\:G \2\:G) resistor r=128.593 c=0
Rl3 (\2\:Qbint \4\:Qbint) resistor r=47.791 c=0
Rl2 (\2\:Qbint \3\:Qbint) resistor r=36.2526 c=0
Rl1 (Qbint \2\:Qbint) resistor r=2.0213 c=0
Rl21 (\9\:Qint \10\:Qint) resistor r=42.9635 c=0
Rl20 (\8\:Qint \9\:Qint) resistor r=174.513 c=0
Rl8 (\5\:Qint \6\:Qint) resistor r=29.5379 c=0
Rl4 (Qint \2\:Qint) resistor r=105.003 c=0
Rl7 (\2\:Qint \5\:Qint) resistor r=24.9253 c=0
Rl9 (\3\:Qint \7\:Qint) resistor r=28.0797 c=0
Rl6 (\3\:Qint \4\:Qint) resistor r=60.772 c=0
Rl5 (\2\:Qint \3\:Qint) resistor r=170.517 c=0
Rl12 (n5 \2\:n5) resistor r=188.462 c=0
Rl13 (\2\:n5 \3\:n5) resistor r=26.1559 c=0
Rl28 (\5\:Gb \6\:Gb) resistor r=169.231 c=0
Rl29 (\5\:Gb \7\:Gb) resistor r=35.6938 c=0
Rl23 (\3\:Gb \4\:Gb) resistor r=66.5405 c=0
Rl22 (Gb \2\:Gb) resistor r=26.1559 c=0
Rl25 (\2\:Gbb \3\:Gbb) resistor r=181.433 c=0
Rl24 (Gbb \2\:Gbb) resistor r=26.098 c=0
Rz1 (\3\:Q \4\:Q) resistor r=75 c=0
Rz8 (\1\:VSS \2\:VSS) resistor r=75 c=0
Rz9 (\7\:VSS \8\:VSS) resistor r=75 c=0
Rz10 (\10\:VSS \11\:VSS) resistor r=75 c=0
Rz11 (\12\:VSS \13\:VSS) resistor r=75 c=0
Rz3 (\4\:QN \5\:QN) resistor r=75 c=0
Rz2 (\9\:Qbint \10\:Qbint) resistor r=75 c=0
Rz4 (\15\:Qint \16\:Qint) resistor r=75 c=0
Rz5 (\6\:n5 \7\:n5) resistor r=75 c=0
Rz7 (\13\:Gb \14\:Gb) resistor r=75 c=0
Rz6 (\8\:Gbb \9\:Gbb) resistor r=75 c=0
Ry1 (\1\:Q \2\:Q) resistor r=62 c=0
Ry16 (\3\:VSS \4\:VSS) resistor r=7.75 c=0
Ry17 (\3\:VSS \6\:VSS) resistor r=5.1667 c=0
Ry3 (\1\:QN \2\:QN) resistor r=62 c=0
Ry10 (\1\:VDD \2\:VDD) resistor r=62 c=0
Ry11 (\8\:VDD \9\:VDD) resistor r=62 c=0
Ry12 (\10\:VDD \11\:VDD) resistor r=62 c=0
Ry13 (\12\:VDD \13\:VDD) resistor r=62 c=0
Ry14 (\14\:VDD \15\:VDD) resistor r=62 c=0
Ry15 (\16\:VDD \17\:VDD) resistor r=62 c=0
Ry2 (\5\:Qbint \6\:Qbint) resistor r=62 c=0
Ry4 (\12\:Qint \13\:Qint) resistor r=62 c=0
Ry7 (\4\:n5 \5\:n5) resistor r=62 c=0
Ry9 (\15\:Gb \16\:Gb) resistor r=62 c=0
Ry8 (\4\:Gbb \5\:Gbb) resistor r=62 c=0
Ry5 (net103 \2\:net103) resistor r=62 c=0
Ry6 (\3\:net103 \4\:net103) resistor r=62 c=0
Rx2 (\2\:SN \4\:SN) resistor r=45 c=0
Rx8 (\2\:D \4\:D) resistor r=45 c=0
Rx4 (\2\:RN \6\:RN) resistor r=45 c=0
Rx3 (\2\:G \4\:G) resistor r=45 c=0
Rx1 (Qbint \8\:Qbint) resistor r=45 c=0
Rx5 (\9\:Qint \11\:Qint) resistor r=45 c=0
Rx6 (\5\:Qint \17\:Qint) resistor r=45 c=0
Rx7 (\3\:n5 \8\:n5) resistor r=45 c=0
Rx10 (\7\:Gb \8\:Gb) resistor r=45 c=0
Rx11 (\2\:Gb \10\:Gb) resistor r=45 c=0
Rx12 (\4\:Gb \11\:Gb) resistor r=45 c=0
Rx9 (\2\:Gbb \7\:Gbb) resistor r=45 c=0
mn21 (\3\:Q \3\:Qbint \12\:VSS VSS) g45n1svt w=(1.45e-07) l=4.5e-08 nf=1 \
        as=2.32e-14 ad=2.392e-14 ps=6.1e-07 pd=6.2e-07 nrd=1.16667 \
        nrs=1.16667 sa=1.65e-07 sb=3.45e-07 sd=160n sca=23.279 \
        scb=0.0230742 scc=0.00267719 m=(1)
mn20 (\9\:Qbint \4\:Qint \12\:VSS VSS) g45n1svt w=(1.45e-07) l=4.5e-08 \
        nf=1 as=2.32e-14 ad=2.03e-14 ps=6.1e-07 pd=5.7e-07 nrd=1.16667 \
        nrs=1.16667 sa=3.7e-07 sb=1.4e-07 sd=160n sca=23.279 scb=0.0230742 \
        scc=0.00267719 m=(1)
mn22 (\4\:QN \6\:Qint \10\:VSS VSS) g45n1svt w=(1.45e-07) l=4.5e-08 nf=1 \
        as=2.9e-14 ad=2.465e-14 ps=6.9e-07 pd=6.3e-07 nrd=1.16667 \
        nrs=1.16667 sa=1.7e-07 sb=6.6e-07 sd=160n sca=16.2011 \
        scb=0.0172667 scc=0.0012292 m=(1)
mn10 (net183 \3\:SN \10\:VSS VSS) g45n1svt w=(1.45e-07) l=4.5e-08 nf=1 \
        as=2.9e-14 ad=3.335e-14 ps=6.9e-07 pd=7.5e-07 nrd=1.16667 \
        nrs=1.16667 sa=4.15e-07 sb=4.15e-07 sd=160n sca=16.2011 \
        scb=0.0172667 scc=0.0012292 m=(1)
mn11 (\15\:Qint \2\:n5 net183 VSS) g45n1svt w=(1.45e-07) l=4.5e-08 nf=1 \
        as=3.335e-14 ad=2.03e-14 ps=7.5e-07 pd=5.7e-07 nrd=1.16667 \
        nrs=1.16667 sa=6.9e-07 sb=1.4e-07 sd=160n sca=16.2011 \
        scb=0.0172667 scc=0.0012292 m=(1)
mn1 (\13\:Gb \1\:G net159 VSS) g45n1svt w=(1.45e-07) l=4.5e-08 nf=1 \
        as=3.407e-14 ad=2.03e-14 ps=7.6e-07 pd=5.7e-07 nrd=1.16667 \
        nrs=1.16667 sa=1.4e-07 sb=1.735e-06 sd=160n sca=13.6097 \
        scb=0.014254 scc=0.000755054 m=(1)
mn0 (net159 \4\:RN \7\:VSS VSS) g45n1svt w=(1.45e-07) l=4.5e-08 nf=1 \
        as=4.75e-14 ad=3.407e-14 ps=9.9e-07 pd=7.6e-07 nrd=1.16667 \
        nrs=1.16667 sa=4.2e-07 sb=1.455e-06 sd=160n sca=13.6097 \
        scb=0.014254 scc=0.000755054 m=(1)
mn15 (net167 \1\:RN \7\:VSS VSS) g45n1svt w=(1.45e-07) l=4.5e-08 nf=1 \
        as=4.75e-14 ad=1.595e-14 ps=9.9e-07 pd=5.1e-07 nrd=1.16667 \
        nrs=1.16667 sa=6.85e-07 sb=1.19e-06 sd=160n sca=13.6097 \
        scb=0.014254 scc=0.000755054 m=(1)
mn16 (net171 \8\:Qint net167 VSS) g45n1svt w=(1.45e-07) l=4.5e-08 nf=1 \
        as=1.595e-14 ad=2.9e-14 ps=5.1e-07 pd=6.9e-07 nrd=1.16667 \
        nrs=1.16667 sa=8.4e-07 sb=1.035e-06 sd=160n sca=13.6097 \
        scb=0.014254 scc=0.000755054 m=(1)
mn17 (\6\:n5 Gb net171 VSS) g45n1svt w=(1.45e-07) l=4.5e-08 nf=1 \
        as=2.9e-14 ad=3.407e-14 ps=6.9e-07 pd=7.6e-07 nrd=1.16667 \
        nrs=1.16667 sa=1.085e-06 sb=7.9e-07 sd=160n sca=13.6097 \
        scb=0.014254 scc=0.000755054 m=(1)
mn6 (\6\:n5 Gbb net191 VSS) g45n1svt w=(1.45e-07) l=4.5e-08 nf=1 \
        as=1.74e-14 ad=3.407e-14 ps=5.3e-07 pd=7.6e-07 nrd=1.16667 \
        nrs=1.16667 sa=1.365e-06 sb=5.1e-07 sd=160n sca=13.6097 \
        scb=0.014254 scc=0.000755054 m=(1)
mn5 (net191 \1\:D \1\:VSS VSS) g45n1svt w=(1.45e-07) l=4.5e-08 nf=1 \
        as=2.32e-14 ad=1.74e-14 ps=6.1e-07 pd=5.3e-07 nrd=1.16667 \
        nrs=1.16667 sa=1.53e-06 sb=3.45e-07 sd=160n sca=13.6097 \
        scb=0.014254 scc=0.000755054 m=(1)
mn2 (\8\:Gbb \6\:Gb \1\:VSS VSS) g45n1svt w=(1.45e-07) l=4.5e-08 nf=1 \
        as=2.32e-14 ad=2.03e-14 ps=6.1e-07 pd=5.7e-07 nrd=1.16667 \
        nrs=1.16667 sa=1.735e-06 sb=1.4e-07 sd=160n sca=13.6097 \
        scb=0.014254 scc=0.000755054 m=(1)
ends TLATSRXL
// End of subcircuit definition.
