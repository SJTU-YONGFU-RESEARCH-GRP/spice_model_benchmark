// Generated for: spectre (May  1 11:27:23 2013 )
// Library name: gsclib045_backbias
// Cell name: AO22XL
// View name: extracted

simulator lang=spectre

subckt AO22XL A0 A1 B0 B1 NW VDD VSS Y
mp0 (n3 \1\:A0 \4\:VDD NW) g45p1svt w=(2.15e-07) l=4.5e-08 nf=1 \
        as=3.44e-14 ad=3.01e-14 ps=7.5e-07 pd=7.1e-07 nrd=1.16667 \
        nrs=1.16667 sa=1.4e-07 sb=7.75e-07 sd=160n sca=15.7679 \
        scb=0.0152453 scc=0.000242201 m=(1)
mp1 (\3\:n3 \1\:A1 \4\:VDD NW) g45p1svt w=(2.15e-07) l=4.5e-08 nf=1 \
        as=3.44e-14 ad=3.44e-14 ps=7.5e-07 pd=7.5e-07 nrd=1.16667 \
        nrs=1.16667 sa=3.45e-07 sb=5.7e-07 sd=160n sca=12.1773 \
        scb=0.00921403 scc=0.000102074 m=(1)
mp3 (\9\:n0 \3\:B1 \3\:n3 NW) g45p1svt w=(2.15e-07) l=4.5e-08 nf=1 \
        as=3.44e-14 ad=3.87e-14 ps=7.5e-07 pd=7.9e-07 nrd=1.16667 \
        nrs=1.16667 sa=5.5e-07 sb=3.65e-07 sd=160n sca=11.1982 \
        scb=0.00806486 scc=9.85433e-05 m=(1)
mp2 (\9\:n0 \4\:B0 \5\:n3 NW) g45p1svt w=(2.15e-07) l=4.5e-08 nf=1 \
        as=3.01e-14 ad=3.87e-14 ps=7.1e-07 pd=7.9e-07 nrd=1.16667 \
        nrs=1.16667 sa=7.75e-07 sb=1.4e-07 sd=160n sca=11.5366 \
        scb=0.00846388 scc=9.92084e-05 m=(1)
mp4 (\1\:Y n0 \1\:VDD NW) g45p1svt w=(2.15e-07) l=4.5e-08 nf=1 \
        as=4.665e-14 ad=3.01e-14 ps=1.44e-06 pd=7.1e-07 nrd=1.16667 \
        nrs=1.16667 sa=1e-07 sb=1.4e-07 sd=160n sca=55.1271 scb=0.0420653 \
        scc=0.00650135 m=(1)
C1 (NW VSS) capacitor c=2.63327e-16
C2 (A0 VSS) capacitor c=7.70524e-17
C3 (Y VSS) capacitor c=3.72564e-17
C4 (VDD VSS) capacitor c=4.09605e-17
C5 (B1 VSS) capacitor c=6.61071e-17
C6 (A1 VSS) capacitor c=1.09964e-16
C7 (n1 VSS) capacitor c=1.69272e-18
C8 (n0 VSS) capacitor c=4.8531e-17
C9 (n2 VSS) capacitor c=2.49646e-18
C10 (n3 VSS) capacitor c=4.77825e-17
C11 (\4\:B0 VSS) capacitor c=4.536e-17
C12 (\3\:B1 VSS) capacitor c=6.43596e-17
C13 (\1\:A1 VSS) capacitor c=7.01713e-17
C14 (\1\:A0 VSS) capacitor c=5.65867e-17
C15 (\4\:n0 VSS) capacitor c=2.77739e-17
C16 (\3\:B0 VSS) capacitor c=5.11868e-17
C17 (\1\:B1 VSS) capacitor c=3.4545e-17
C18 (\3\:A1 VSS) capacitor c=2.98668e-17
C19 (\3\:A0 VSS) capacitor c=2.7334e-17
C20 (\3\:n0 VSS) capacitor c=5.15818e-17
C21 (\1\:B0 VSS) capacitor c=2.44816e-17
C22 (\2\:B1 VSS) capacitor c=6.73766e-17
C23 (\2\:A1 VSS) capacitor c=7.06267e-17
C24 (\2\:A0 VSS) capacitor c=5.03587e-17
C25 (\1\:Y VSS) capacitor c=4.06069e-17
C26 (\1\:VDD VSS) capacitor c=1.1693e-16
C27 (\5\:n3 VSS) capacitor c=7.78729e-17
C28 (\9\:n0 VSS) capacitor c=7.95465e-17
C29 (\3\:n3 VSS) capacitor c=8.60925e-17
C30 (\4\:VDD VSS) capacitor c=3.44721e-17
C31 (\3\:Y VSS) capacitor c=2.88157e-17
C32 (\7\:n0 VSS) capacitor c=5.65071e-17
C33 (\2\:B0 VSS) capacitor c=4.06684e-17
C34 (\4\:B1 VSS) capacitor c=5.36142e-17
C35 (\5\:B0 VSS) capacitor c=1.06937e-16
C36 (\5\:n0 VSS) capacitor c=5.57994e-17
C37 (\6\:n0 VSS) capacitor c=8.7695e-17
C38 (\3\:VDD VSS) capacitor c=9.80634e-17
Rk6 (B0 \5\:B0) resistor r=0.0283 c=0
Rk1 (\4\:A0 A0) resistor r=0.002991 c=0
Rk10 (\2\:Y Y) resistor r=0.2466 c=0
Rk11 (Y \4\:Y) resistor r=0.1181 c=0
Rk13 (\3\:VDD VDD) resistor r=0.1699 c=0
Rk12 (\2\:VDD \3\:VDD) resistor r=0.6213 c=0
Rk14 (\3\:VDD \5\:VDD) resistor r=0.1818 c=0
Rk3 (B1 \4\:B1) resistor r=0.1166 c=0
Rk2 (\4\:A1 A1) resistor r=0.002991 c=0
Rk16 (\3\:VSS VSS) resistor r=0.06717 c=0
Rk15 (\2\:VSS \3\:VSS) resistor r=0.272 c=0
Rk17 (\3\:VSS \5\:VSS) resistor r=0.2828 c=0
Rk18 (\5\:VSS \7\:VSS) resistor r=0.414 c=0
Rk7 (\5\:n0 \6\:n0) resistor r=0.1549 c=0
Rk8 (\6\:n0 \8\:n0) resistor r=0.2578 c=0
Rk9 (\6\:n0 \10\:n0) resistor r=0.5192 c=0
Rk4 (\2\:n3 \4\:n3) resistor r=0.3844 c=0
Rk5 (\4\:n3 \6\:n3) resistor r=0.4773 c=0
Rl9 (\2\:B0 \4\:B0) resistor r=166.187 c=0
Rl8 (\2\:B0 \3\:B0) resistor r=108.495 c=0
Rl7 (\1\:B0 \2\:B0) resistor r=5.0163 c=0
Rl1 (\1\:A0 \2\:A0) resistor r=219.923 c=0
Rl2 (\2\:A0 \3\:A0) resistor r=39.1533 c=0
Rl6 (\2\:B1 \3\:B1) resistor r=216.483 c=0
Rl5 (\1\:B1 \2\:B1) resistor r=47.9962 c=0
Rl3 (\1\:A1 \2\:A1) resistor r=218.464 c=0
Rl4 (\2\:A1 \3\:A1) resistor r=37.6944 c=0
Rl10 (n0 \2\:n0) resistor r=166.216 c=0
Rl12 (\2\:n0 \4\:n0) resistor r=28.208 c=0
Rl11 (\2\:n0 \3\:n0) resistor r=14.3357 c=0
Rz2 (\3\:Y \4\:Y) resistor r=75 c=0
Rz3 (\1\:VSS \2\:VSS) resistor r=75 c=0
Rz4 (\6\:VSS \7\:VSS) resistor r=75 c=0
Rz1 (\7\:n0 \8\:n0) resistor r=75 c=0
Ry5 (\1\:Y \2\:Y) resistor r=62 c=0
Ry6 (\1\:VDD \2\:VDD) resistor r=62 c=0
Ry7 (\4\:VDD \5\:VDD) resistor r=62 c=0
Ry4 (\9\:n0 \10\:n0) resistor r=62 c=0
Ry1 (n3 \2\:n3) resistor r=62 c=0
Ry2 (\3\:n3 \4\:n3) resistor r=62 c=0
Ry3 (\5\:n3 \6\:n3) resistor r=62 c=0
Rx4 (\1\:B0 \5\:B0) resistor r=45 c=0
Rx1 (\2\:A0 \4\:A0) resistor r=45 c=0
Rx3 (\2\:B1 \4\:B1) resistor r=45 c=0
Rx2 (\2\:A1 \4\:A1) resistor r=45 c=0
Rx5 (\3\:n0 \5\:n0) resistor r=45 c=0
mn0 (n1 \3\:A0 \1\:VSS VSS) g45n1svt w=(1.45e-07) l=4.5e-08 nf=1 \
        as=2.03e-14 ad=2.32e-14 ps=5.7e-07 pd=6.1e-07 nrd=1.16667 \
        nrs=1.16667 sa=1.4e-07 sb=9.8e-07 sd=160n sca=10.4914 \
        scb=0.00978575 scc=0.000300434 m=(1)
mn1 (\7\:n0 \3\:A1 n1 VSS) g45n1svt w=(1.45e-07) l=4.5e-08 nf=1 \
        as=2.32e-14 ad=3.117e-14 ps=6.1e-07 pd=7.2e-07 nrd=1.16667 \
        nrs=1.16667 sa=3.45e-07 sb=7.75e-07 sd=160n sca=10.4914 \
        scb=0.00978575 scc=0.000300434 m=(1)
mn3 (\7\:n0 \1\:B1 n2 VSS) g45n1svt w=(1.45e-07) l=4.5e-08 nf=1 \
        as=1.812e-14 ad=3.117e-14 ps=5.4e-07 pd=7.2e-07 nrd=1.16667 \
        nrs=1.16667 sa=6.05e-07 sb=5.15e-07 sd=160n sca=10.4914 \
        scb=0.00978575 scc=0.000300434 m=(1)
mn2 (n2 \3\:B0 \6\:VSS VSS) g45n1svt w=(1.45e-07) l=4.5e-08 nf=1 \
        as=2.32e-14 ad=1.812e-14 ps=6.1e-07 pd=5.4e-07 nrd=1.16667 \
        nrs=1.16667 sa=7.75e-07 sb=3.45e-07 sd=160n sca=10.4914 \
        scb=0.00978575 scc=0.000300434 m=(1)
mn4 (\3\:Y \4\:n0 \6\:VSS VSS) g45n1svt w=(1.45e-07) l=4.5e-08 nf=1 \
        as=2.32e-14 ad=2.03e-14 ps=6.1e-07 pd=5.7e-07 nrd=1.16667 \
        nrs=1.16667 sa=9.8e-07 sb=1.4e-07 sd=160n sca=10.4914 \
        scb=0.00978575 scc=0.000300434 m=(1)
ends AO22XL
// End of subcircuit definition.
