// gsclib045/LSHL_ISONL_X1_FROM_OFF/schematic

simulator lang=spectre

subckt LSHL_ISONL_X1_FROM_OFF A ISOn Y VSS VDD ExtVDD
NM3 (GatedVSS ISOn VSS VSS) g45n1svt w=(520n) l=45n nf=2 m=(1)
NM0 (Y n0 VSS VSS) g45n1svt w=(260n) l=45n nf=1 m=(1)
mn0 (GatedVSS A n0 VSS) g45n1svt w=(145n) l=45n nf=1 m=(1)
PM2 (n0 ISOn ExtVDD ExtVDD) g45p1svt w=(215n) l=45n nf=1 m=(1)
PM0 (Y n0 ExtVDD ExtVDD) g45p1svt w=(390n) l=45n nf=1 m=(1)
mp0 (n0 A ExtVDD ExtVDD) g45p1svt w=(215n) l=45n nf=1 m=(1)
ends LSHL_ISONL_X1_FROM_OFF
