// gsclib045_backbias/MXI2XL/schematic

simulator lang=spectre

subckt MXI2XL A B S0 Y VDD VSS NW
mn3 (n5 B VSS VSS) g45n1svt w=(145n) l=45n nf=1 m=(1)
mn4 (Y S0 n5 VSS) g45n1svt w=(145n) l=45n nf=1 m=(1)
mn2 (Y S0b n3 VSS) g45n1svt w=(145n) l=45n nf=1 m=(1)
mn1 (n3 A VSS VSS) g45n1svt w=(145n) l=45n nf=1 m=(1)
mn0 (S0b S0 VSS VSS) g45n1svt w=(145n) l=45n nf=1 m=(1)
mp4 (Y S0b n6 NW) g45p1svt w=(215n) l=45n nf=1 m=(1)
mp3 (n6 B VDD NW) g45p1svt w=(215n) l=45n nf=1 m=(1)
mp2 (Y S0 n4 NW) g45p1svt w=(215n) l=45n nf=1 m=(1)
mp1 (n4 A VDD NW) g45p1svt w=(215n) l=45n nf=1 m=(1)
mp0 (S0b S0 VDD NW) g45p1svt w=(215n) l=45n nf=1 m=(1)
ends MXI2XL
