// Generated for: spectre (May  1 08:13:37 2013 )
// Library name: gsclib045
// Cell name: SDFFRHQX8
// View name: extracted

simulator lang=spectre

subckt SDFFRHQX8 CK D Q RN SE SI VDD VSS
mp55_1__rcx (Q qbint \9\:VDD VDD) g45p1svt w=(4.45e-07) l=4.5e-08 nf=1 \
        as=7.073e-14 ad=7.374e-14 ps=1.21e-06 pd=1.22143e-06 nrd=1.16667 \
        nrs=1.16667 sa=1.4e-07 sb=1.9209e-06 sd=160n sca=32.089 \
        scb=0.0262252 scc=0.00294457 m=(7)
C1 (D VSS) capacitor c=4.36773e-17
C2 (Q VSS) capacitor c=4.97233e-16
C3 (RN VSS) capacitor c=4.4247e-16
C4 (VDD VSS) capacitor c=3.92067e-16
C5 (SE VSS) capacitor c=3.12021e-17
C6 (SI VSS) capacitor c=9.64978e-17
C7 (CK VSS) capacitor c=7.19697e-17
C8 (qbint VSS) capacitor c=4.03294e-16
C9 (21 VSS) capacitor c=2.98312e-18
C10 (n30 VSS) capacitor c=4.97908e-16
C11 (22 VSS) capacitor c=2.09613e-18
C12 (23 VSS) capacitor c=3.531e-18
C13 (CKb VSS) capacitor c=4.61756e-17
C14 (net405 VSS) capacitor c=2.24031e-18
C15 (mout VSS) capacitor c=4.71584e-17
C16 (CKbb VSS) capacitor c=2.12639e-17
C17 (n20 VSS) capacitor c=4.09041e-17
C18 (net426 VSS) capacitor c=4.90915e-18
C19 (net422 VSS) capacitor c=3.3758e-18
C20 (Db VSS) capacitor c=8.81705e-17
C21 (net450 VSS) capacitor c=8.07784e-18
C22 (SEb VSS) capacitor c=4.58521e-17
C23 (net326 VSS) capacitor c=3.00682e-18
C24 (net349 VSS) capacitor c=7.65193e-17
C25 (net381 VSS) capacitor c=3.36268e-18
C26 (net373 VSS) capacitor c=4.08851e-18
C27 (\7\:SE VSS) capacitor c=4.56586e-17
C28 (\3\:SI VSS) capacitor c=5.67191e-17
C29 (\2\:SE VSS) capacitor c=5.47842e-17
C30 (\1\:D VSS) capacitor c=7.85863e-17
C31 (\8\:CKb VSS) capacitor c=3.78528e-17
C32 (\7\:CKbb VSS) capacitor c=5.1021e-17
C33 (\5\:CKb VSS) capacitor c=4.25566e-17
C34 (\12\:RN VSS) capacitor c=6.94955e-17
C35 (\3\:n20 VSS) capacitor c=4.53714e-17
C36 (\3\:CKb VSS) capacitor c=3.56591e-17
C37 (\3\:CKbb VSS) capacitor c=6.81975e-17
C38 (\28\:qbint VSS) capacitor c=5.17802e-17
C39 (\1\:CK VSS) capacitor c=4.36878e-17
C40 (\5\:SE VSS) capacitor c=3.3226e-17
C41 (\1\:SI VSS) capacitor c=8.60912e-17
C42 (\3\:SE VSS) capacitor c=7.03736e-17
C43 (\3\:SEb VSS) capacitor c=6.08609e-17
C44 (\4\:D VSS) capacitor c=3.43218e-17
C45 (\10\:CKb VSS) capacitor c=4.7833e-17
C46 (\7\:CKb VSS) capacitor c=4.43595e-17
C47 (\4\:CKbb VSS) capacitor c=4.13568e-17
C48 (\3\:mout VSS) capacitor c=4.20499e-17
C49 (\11\:RN VSS) capacitor c=7.17693e-17
C50 (\30\:qbint VSS) capacitor c=6.08039e-17
C51 (\3\:CK VSS) capacitor c=3.67995e-17
C52 (\10\:n30 VSS) capacitor c=3.99652e-17
C53 (\4\:RN VSS) capacitor c=3.55453e-17
C54 (\7\:RN VSS) capacitor c=1.98741e-17
C55 (\6\:n30 VSS) capacitor c=2.33622e-17
C56 (\5\:n30 VSS) capacitor c=3.24358e-17
C57 (\1\:RN VSS) capacitor c=4.96245e-17
C58 (\6\:SE VSS) capacitor c=3.84633e-17
C59 (\2\:SI VSS) capacitor c=5.98069e-17
C60 (\4\:SE VSS) capacitor c=4.54904e-17
C61 (\1\:SE VSS) capacitor c=4.0634e-17
C62 (\3\:D VSS) capacitor c=2.10891e-17
C63 (\9\:CKb VSS) capacitor c=2.49427e-17
C64 (\6\:CKbb VSS) capacitor c=3.3942e-17
C65 (\6\:CKb VSS) capacitor c=2.05505e-17
C66 (\5\:CKbb VSS) capacitor c=3.87167e-17
C67 (\2\:mout VSS) capacitor c=4.33721e-17
C68 (\2\:n20 VSS) capacitor c=3.72525e-17
C69 (\13\:RN VSS) capacitor c=3.48257e-17
C70 (\2\:CKbb VSS) capacitor c=5.8278e-17
C71 (\4\:CKb VSS) capacitor c=3.7717e-17
C72 (\2\:CKb VSS) capacitor c=3.96691e-17
C73 (\29\:qbint VSS) capacitor c=4.20483e-17
C74 (\2\:CK VSS) capacitor c=3.23058e-17
C75 (\9\:RN VSS) capacitor c=1.93488e-17
C76 (\7\:SEb VSS) capacitor c=9.91714e-17
C77 (\14\:VDD VSS) capacitor c=2.95803e-17
C78 (\4\:Db VSS) capacitor c=5.25251e-17
C79 (\16\:VDD VSS) capacitor c=1.16602e-17
C80 (\8\:CKbb VSS) capacitor c=7.14549e-17
C81 (\6\:Db VSS) capacitor c=1.52551e-16
C82 (\4\:n20 VSS) capacitor c=7.00472e-17
C83 (\18\:VDD VSS) capacitor c=2.04699e-17
C84 (\3\:net349 VSS) capacitor c=7.59069e-17
C85 (\20\:VDD VSS) capacitor c=7.13111e-17
C86 (\7\:mout VSS) capacitor c=6.17622e-17
C87 (\11\:n30 VSS) capacitor c=1.02517e-16
C88 (\22\:VDD VSS) capacitor c=2.39328e-17
C89 (\18\:CKb VSS) capacitor c=1.02484e-16
C90 (\33\:qbint VSS) capacitor c=2.41102e-16
C91 (\1\:VDD VSS) capacitor c=1.08069e-16
C92 (\5\:SEb VSS) capacitor c=6.10183e-17
C93 (\14\:CKbb VSS) capacitor c=9.55737e-18
C94 (\8\:Db VSS) capacitor c=1.06404e-16
C95 (\8\:n20 VSS) capacitor c=7.12402e-17
C96 (\4\:mout VSS) capacitor c=4.18506e-17
C97 (\13\:n30 VSS) capacitor c=2.4268e-16
C98 (\15\:CKb VSS) capacitor c=1.31753e-16
C99 (\39\:qbint VSS) capacitor c=7.16567e-17
C100 (\43\:qbint VSS) capacitor c=7.36372e-17
C101 (\2\:D VSS) capacitor c=2.13344e-17
C102 (\2\:SEb VSS) capacitor c=5.49094e-17
C103 (\4\:CK VSS) capacitor c=4.51965e-17
C104 (\31\:qbint VSS) capacitor c=1.38912e-16
C105 (\32\:qbint VSS) capacitor c=1.40202e-16
C106 (\45\:qbint VSS) capacitor c=4.25067e-17
C107 (\16\:RN VSS) capacitor c=1.66011e-16
C108 (\17\:RN VSS) capacitor c=1.59834e-16
C109 (\6\:mout VSS) capacitor c=1.09463e-16
C110 (\9\:mout VSS) capacitor c=1.022e-16
C111 (\6\:n20 VSS) capacitor c=1.12053e-16
C112 (\7\:n20 VSS) capacitor c=1.1437e-16
C113 (\10\:CKbb VSS) capacitor c=4.6592e-17
C114 (\11\:CKbb VSS) capacitor c=9.0122e-17
C115 (\12\:CKbb VSS) capacitor c=2.16509e-16
C116 (\13\:CKbb VSS) capacitor c=1.48812e-16
C117 (\16\:CKbb VSS) capacitor c=4.44908e-17
C118 (\11\:CKb VSS) capacitor c=7.55993e-17
C119 (\12\:CKb VSS) capacitor c=2.14287e-16
C120 (\13\:CKb VSS) capacitor c=2.39954e-16
C121 (\14\:CKb VSS) capacitor c=1.63248e-16
C122 (\17\:CKb VSS) capacitor c=6.84037e-17
C123 (\5\:D VSS) capacitor c=6.51236e-17
C124 (\3\:Db VSS) capacitor c=1.41037e-16
C125 (\8\:SE VSS) capacitor c=7.16275e-17
C126 (\9\:SE VSS) capacitor c=5.97961e-17
C127 (\10\:SE VSS) capacitor c=4.84842e-17
C128 (\4\:SI VSS) capacitor c=4.28177e-17
C129 (\9\:SEb VSS) capacitor c=7.65754e-17
C130 (\3\:VDD VSS) capacitor c=1.4584e-17
C131 (\4\:VDD VSS) capacitor c=2.47288e-17
C132 (\6\:VDD VSS) capacitor c=2.5074e-17
C133 (\7\:VDD VSS) capacitor c=4.86963e-17
C134 (\9\:VDD VSS) capacitor c=5.38265e-16
Rk51 (\5\:D D) resistor r=0.1126 c=0
Rk31 (\16\:RN \17\:RN) resistor r=1.2883 c=0
Rk84 (\2\:VDD \3\:VDD) resistor r=0.1277 c=0
Rk85 (\3\:VDD \4\:VDD) resistor r=0.3925 c=0
Rk86 (\4\:VDD \5\:VDD) resistor r=0.2297 c=0
Rk87 (\5\:VDD \6\:VDD) resistor r=0.3501 c=0
Rk88 (\6\:VDD \7\:VDD) resistor r=0.2771 c=0
Rk89 (\7\:VDD \8\:VDD) resistor r=0.5749 c=0
Rk109 (\9\:VDD VDD) resistor r=0.1651 c=0
Rk90 (\8\:VDD \9\:VDD) resistor r=0.2905 c=0
Rk95 (\3\:VDD \15\:VDD) resistor r=0.2585 c=0
Rk96 (\4\:VDD \17\:VDD) resistor r=0.04333 c=0
Rk97 (\6\:VDD \19\:VDD) resistor r=0.04333 c=0
Rk98 (\7\:VDD \21\:VDD) resistor r=0.3469 c=0
Rk99 (\8\:VDD \23\:VDD) resistor r=0.0715 c=0
Rk57 (\8\:SE \9\:SE) resistor r=0.3402 c=0
Rk59 (\10\:SE SE) resistor r=0.05396 c=0
Rk58 (\9\:SE \10\:SE) resistor r=0.2318 c=0
Rk60 (\4\:SI SI) resistor r=0.06227 c=0
Rk63 (\2\:VSS \3\:VSS) resistor r=0.0851 c=0
Rk64 (\3\:VSS \4\:VSS) resistor r=0.4211 c=0
Rk65 (\4\:VSS \5\:VSS) resistor r=0.2457 c=0
Rk66 (\5\:VSS \6\:VSS) resistor r=0.5693 c=0
Rk67 (\6\:VSS \7\:VSS) resistor r=0.6357 c=0
Rk68 (\3\:VSS \9\:VSS) resistor r=0.292 c=0
Rk69 (\4\:VSS \11\:VSS) resistor r=0.2317 c=0
Rk70 (\6\:VSS \13\:VSS) resistor r=0.18 c=0
Rk71 (\7\:VSS \14\:VSS) resistor r=0.5116 c=0
Rk77 (\15\:VSS VSS) resistor r=0.2078 c=0
Rk72 (\14\:VSS \15\:VSS) resistor r=0.4186 c=0
Rk78 (\7\:VSS \21\:VSS) resistor r=0.0715 c=0
Rk79 (\14\:VSS \23\:VSS) resistor r=0.2841 c=0
Rk17 (\4\:CK CK) resistor r=0.1298 c=0
Rk19 (\32\:qbint \33\:qbint) resistor r=0.1506 c=0
Rk18 (\31\:qbint \32\:qbint) resistor r=0.9963 c=0
Rk23 (\32\:qbint \40\:qbint) resistor r=0.4295 c=0
Rk25 (\33\:qbint \44\:qbint) resistor r=0.3434 c=0
Rk26 (\33\:qbint \45\:qbint) resistor r=0.3623 c=0
Rk28 (\14\:n30 n30) resistor r=1.3505 c=0
Rk27 (\12\:n30 \14\:n30) resistor r=0.4947 c=0
Rk45 (\11\:CKb \12\:CKb) resistor r=0.4769 c=0
Rk46 (\12\:CKb \13\:CKb) resistor r=1.4046 c=0
Rk47 (\13\:CKb \14\:CKb) resistor r=0.6599 c=0
Rk48 (\14\:CKb \16\:CKb) resistor r=0.6379 c=0
Rk49 (\13\:CKb \17\:CKb) resistor r=0.2643 c=0
Rk50 (\16\:CKb \19\:CKb) resistor r=0.5821 c=0
Rk32 (\5\:mout \6\:mout) resistor r=0.1059 c=0
Rk33 (\6\:mout \8\:mout) resistor r=0.3215 c=0
Rk34 (\6\:mout \9\:mout) resistor r=0.5477 c=0
Rk39 (\9\:CKbb \10\:CKbb) resistor r=0.3455 c=0
Rk40 (\10\:CKbb \11\:CKbb) resistor r=0.1402 c=0
Rk41 (\11\:CKbb \12\:CKbb) resistor r=0.7931 c=0
Rk42 (\12\:CKbb \13\:CKbb) resistor r=1.1085 c=0
Rk43 (\10\:CKbb \15\:CKbb) resistor r=0.1152 c=0
Rk44 (\12\:CKbb \16\:CKbb) resistor r=0.1529 c=0
Rk36 (\5\:n20 \6\:n20) resistor r=0.3056 c=0
Rk37 (\6\:n20 \7\:n20) resistor r=0.712 c=0
Rk38 (\6\:n20 \9\:n20) resistor r=0.3051 c=0
Rk52 (\2\:Db \3\:Db) resistor r=0.6178 c=0
Rk53 (\3\:Db \5\:Db) resistor r=0.149 c=0
Rk54 (\3\:Db \7\:Db) resistor r=0.6938 c=0
Rk55 (\7\:Db \9\:Db) resistor r=0.6083 c=0
Rk56 (\5\:Db \10\:Db) resistor r=0.1474 c=0
Rk61 (\6\:SEb \8\:SEb) resistor r=0.6167 c=0
Rk62 (\8\:SEb \9\:SEb) resistor r=0.4689 c=0
Rk35 (\2\:net349 \4\:net349) resistor r=0.2887 c=0
Rl63 (\1\:D \2\:D) resistor r=102.726 c=0
Rl65 (\2\:D \4\:D) resistor r=37.3411 c=0
Rl64 (\2\:D \3\:D) resistor r=6.9867 c=0
Rl53 (\11\:RN \12\:RN) resistor r=182.258 c=0
Rl35 (RN \4\:RN) resistor r=28.0797 c=0
Rl37 (RN \7\:RN) resistor r=24.2328 c=0
Rl27 (RN \1\:RN) resistor r=24.5316 c=0
Rl54 (\13\:RN \12\:RN) resistor r=189.898 c=0
Rl39 (\9\:RN RN) resistor r=24.2328 c=0
Rl74 (\6\:SE \7\:SE) resistor r=95.3297 c=0
Rl73 (\5\:SE \6\:SE) resistor r=40.3846 c=0
Rl70 (\3\:SE \4\:SE) resistor r=24.2328 c=0
Rl66 (\1\:SE \2\:SE) resistor r=33.8727 c=0
Rl72 (\2\:SI \3\:SI) resistor r=30.0268 c=0
Rl71 (\1\:SI \2\:SI) resistor r=91.6329 c=0
Rl43 (\1\:CK \2\:CK) resistor r=90.3846 c=0
Rl44 (\2\:CK \3\:CK) resistor r=39.5604 c=0
Rl45 (\29\:qbint \28\:qbint) resistor r=39.1533 c=0
Rl46 (\29\:qbint \30\:qbint) resistor r=89.1533 c=0
Rl42 (n30 \10\:n30) resistor r=26.3736 c=0
Rl33 (n30 \6\:n30) resistor r=28.0797 c=0
Rl32 (n30 \5\:n30) resistor r=28.0797 c=0
Rl62 (\8\:CKb \10\:CKb) resistor r=150 c=0
Rl59 (\5\:CKb \7\:CKb) resistor r=142.308 c=0
Rl61 (\8\:CKb \9\:CKb) resistor r=54.5379 c=0
Rl58 (\5\:CKb \6\:CKb) resistor r=37.2302 c=0
Rl48 (\3\:CKb \4\:CKb) resistor r=29.5379 c=0
Rl47 (CKb \2\:CKb) resistor r=33.3841 c=0
Rl55 (mout \2\:mout) resistor r=98.7687 c=0
Rl56 (\2\:mout \3\:mout) resistor r=29.5379 c=0
Rl60 (\6\:CKbb \7\:CKbb) resistor r=89.6769 c=0
Rl57 (\4\:CKbb \5\:CKbb) resistor r=28.079 c=0
Rl50 (\2\:CKbb \3\:CKbb) resistor r=174.12 c=0
Rl49 (CKbb \2\:CKbb) resistor r=24.2328 c=0
Rl52 (\2\:n20 \3\:n20) resistor r=35.7065 c=0
Rl51 (n20 \2\:n20) resistor r=84.4104 c=0
Rl67 (SEb \2\:SEb) resistor r=67.4757 c=0
Rl68 (\2\:SEb \3\:SEb) resistor r=138.049 c=0
Rl69 (\2\:SEb \4\:SEb) resistor r=1.2666 c=0
Rz24 (\2\:VDD \1\:VDD) resistor r=25 c=0
Rz25 (\5\:VDD \1\:VDD) resistor r=6.25 c=0
Rz26 (\8\:VDD \1\:VDD) resistor r=6.25 c=0
Rz27 (\9\:VDD \1\:VDD) resistor r=6.25 c=0
Rz15 (\9\:VSS \8\:VSS) resistor r=75 c=0
Rz16 (\11\:VSS \10\:VSS) resistor r=75 c=0
Rz17 (\13\:VSS \12\:VSS) resistor r=75 c=0
Rz18 (\21\:VSS \20\:VSS) resistor r=75 c=0
Rz19 (\23\:VSS \22\:VSS) resistor r=75 c=0
Rz5 (\40\:qbint \39\:qbint) resistor r=75 c=0
Rz6 (\44\:qbint \43\:qbint) resistor r=75 c=0
Rz7 (\14\:n30 \13\:n30) resistor r=75 c=0
Rz11 (\15\:CKb \16\:CKb) resistor r=75 c=0
Rz8 (\4\:mout \5\:mout) resistor r=75 c=0
Rz10 (\14\:CKbb \15\:CKbb) resistor r=75 c=0
Rz9 (\8\:n20 \9\:n20) resistor r=75 c=0
Rz12 (Db \2\:Db) resistor r=75 c=0
Rz13 (\8\:Db \9\:Db) resistor r=75 c=0
Rz14 (\5\:SEb \6\:SEb) resistor r=75 c=0
Ry23 (\15\:VDD \14\:VDD) resistor r=62 c=0
Ry24 (\17\:VDD \16\:VDD) resistor r=62 c=0
Ry25 (\19\:VDD \18\:VDD) resistor r=62 c=0
Ry26 (\21\:VDD \20\:VDD) resistor r=62 c=0
Ry27 (\23\:VDD \22\:VDD) resistor r=62 c=0
Ry19 (\2\:VSS \1\:VSS) resistor r=20.6667 c=0
Ry20 (\5\:VSS \1\:VSS) resistor r=5.1667 c=0
Ry21 (\7\:VSS \1\:VSS) resistor r=5.1667 c=0
Ry22 (\15\:VSS \1\:VSS) resistor r=5.1667 c=0
Ry8 (\12\:n30 \11\:n30) resistor r=62 c=0
Ry14 (\18\:CKb \19\:CKb) resistor r=62 c=0
Ry9 (\7\:mout \8\:mout) resistor r=62 c=0
Ry13 (\8\:CKbb \9\:CKbb) resistor r=62 c=0
Ry12 (\4\:n20 \5\:n20) resistor r=31 c=0
Ry15 (\4\:Db \5\:Db) resistor r=62 c=0
Ry16 (\6\:Db \7\:Db) resistor r=31 c=0
Ry17 (\4\:Db \10\:Db) resistor r=62 c=0
Ry18 (\7\:SEb \8\:SEb) resistor r=62 c=0
Ry10 (net349 \2\:net349) resistor r=62 c=0
Ry11 (\3\:net349 \4\:net349) resistor r=62 c=0
Rx19 (\3\:D \5\:D) resistor r=45 c=0
Rx8 (\16\:RN \13\:RN) resistor r=45 c=0
Rx9 (\17\:RN \9\:RN) resistor r=45 c=0
Rx20 (\1\:SE \8\:SE) resistor r=45 c=0
Rx21 (\4\:SE \9\:SE) resistor r=45 c=0
Rx22 (\6\:SE \10\:SE) resistor r=45 c=0
Rx23 (\2\:SI \4\:SI) resistor r=45 c=0
Rx3 (\2\:CK \4\:CK) resistor r=45 c=0
Rx4 (\31\:qbint \29\:qbint) resistor r=45 c=0
Rx5 (\45\:qbint qbint) resistor r=45 c=0
Rx15 (\9\:CKb \11\:CKb) resistor r=45 c=0
Rx16 (\6\:CKb \12\:CKb) resistor r=45 c=0
Rx17 (\2\:CKb \14\:CKb) resistor r=45 c=0
Rx18 (\4\:CKb \17\:CKb) resistor r=45 c=0
Rx10 (\2\:mout \9\:mout) resistor r=45 c=0
Rx12 (\6\:CKbb \11\:CKbb) resistor r=45 c=0
Rx13 (\2\:CKbb \13\:CKbb) resistor r=45 c=0
Rx14 (\5\:CKbb \16\:CKbb) resistor r=45 c=0
Rx11 (\2\:n20 \7\:n20) resistor r=45 c=0
Rx24 (\4\:SEb \9\:SEb) resistor r=45 c=0
mn55_1__rcx (Q qbint \15\:VSS VSS) g45n1svt w=(2.95e-07) l=4.5e-08 nf=1 \
        as=4.69e-14 ad=4.636e-14 ps=9.1e-07 pd=9.0429e-07 nrd=1.16667 \
        nrs=1.16667 sa=1.4e-07 sb=1.92051e-06 sd=160n sca=16.4223 \
        scb=0.0158966 scc=0.0014413 m=(7)
mn45_1__rcx (21 \1\:RN \15\:VSS VSS) g45n1svt w=(2.6e-07) l=4.5e-08 nf=1 \
        as=4.51e-14 ad=2.73e-14 ps=9.1e-07 pd=7.3e-07 nrd=1.16667 \
        nrs=1.16667 sa=1.575e-06 sb=1.12e-06 sd=160n sca=13.9783 \
        scb=0.013979 scc=0.000942864 m=(1)
mn46_1__rcx (\43\:qbint \5\:n30 21 VSS) g45n1svt w=(2.6e-07) l=4.5e-08 \
        nf=1 as=2.73e-14 ad=4.94e-14 ps=7.3e-07 pd=9e-07 nrd=1.16667 \
        nrs=1.16667 sa=1.725e-06 sb=9.7e-07 sd=160n sca=13.9783 \
        scb=0.013979 scc=0.000942864 m=(1)
mn46_2__rcx (\43\:qbint \6\:n30 22 VSS) g45n1svt w=(2.6e-07) l=4.5e-08 \
        nf=1 as=4.42e-14 ad=4.94e-14 ps=8.6e-07 pd=9e-07 nrd=1.16667 \
        nrs=1.16667 sa=1.96e-06 sb=7.35e-07 sd=160n sca=13.9783 \
        scb=0.013979 scc=0.000942864 m=(1)
mn45_2__rcx (22 \7\:RN \22\:VSS VSS) g45n1svt w=(2.6e-07) l=4.5e-08 nf=1 \
        as=4.94e-14 ad=4.42e-14 ps=9e-07 pd=8.6e-07 nrd=1.16667 \
        nrs=1.16667 sa=2e-06 sb=5.2e-07 sd=160n sca=13.9783 scb=0.013979 \
        scc=0.000942864 m=(1)
mn45 (23 \4\:RN \22\:VSS VSS) g45n1svt w=(2.6e-07) l=4.5e-08 nf=1 \
        as=4.94e-14 ad=2.21e-14 ps=9e-07 pd=6.9e-07 nrd=1.16667 \
        nrs=1.16667 sa=2e-06 sb=2.85e-07 sd=160n sca=13.9783 scb=0.013979 \
        scc=0.000942864 m=(1)
mn46 (\39\:qbint \10\:n30 23 VSS) g45n1svt w=(2.6e-07) l=4.5e-08 nf=1 \
        as=2.21e-14 ad=4.03e-14 ps=6.9e-07 pd=8.3e-07 nrd=1.16667 \
        nrs=1.16667 sa=2e-06 sb=1.55e-07 sd=160n sca=13.9783 scb=0.013979 \
        scc=0.000942864 m=(1)
mn11 (net450 \4\:D \10\:VSS VSS) g45n1svt w=(2.6e-07) l=4.5e-08 nf=1 \
        as=4.8e-14 ad=7.28e-14 ps=9.6e-07 pd=1.08e-06 nrd=1.16667 \
        nrs=1.16667 sa=3.40769e-07 sb=9.32981e-07 sd=160n sca=10.79 \
        scb=0.0100512 scc=0.000418069 m=(1)
mn12 (Db \3\:SEb net450 VSS) g45n1svt w=(2.6e-07) l=4.5e-08 nf=1 \
        as=7.28e-14 ad=4.16e-14 ps=1.08e-06 pd=8.4e-07 nrd=1.16667 \
        nrs=1.16667 sa=6.65769e-07 sb=6.07981e-07 sd=160n sca=10.79 \
        scb=0.0100512 scc=0.000418069 m=(1)
mn14 (Db \3\:SE net442 VSS) g45n1svt w=(2.6e-07) l=4.5e-08 nf=1 \
        as=1.56e-14 ad=4.16e-14 ps=6.4e-07 pd=8.4e-07 nrd=1.16667 \
        nrs=1.16667 sa=8.70769e-07 sb=4.02981e-07 sd=160n sca=10.79 \
        scb=0.0100512 scc=0.000418069 m=(1)
mn13 (net442 \1\:SI \8\:VSS VSS) g45n1svt w=(2.6e-07) l=4.5e-08 nf=1 \
        as=3.47e-14 ad=1.56e-14 ps=8.4e-07 pd=6.4e-07 nrd=1.16667 \
        nrs=1.16667 sa=9.75769e-07 sb=2.97981e-07 sd=160n sca=10.79 \
        scb=0.0100512 scc=0.000418069 m=(1)
mn20 (\15\:CKb \3\:CK \20\:VSS VSS) g45n1svt w=(1.45e-07) l=4.5e-08 nf=1 \
        as=7.33e-14 ad=4.132e-14 ps=1.37e-06 pd=8.6e-07 nrd=1.16667 \
        nrs=1.16667 sa=2.85e-07 sb=2e-06 sd=160n sca=11.4452 scb=0.0112553 \
        scc=0.00042156 m=(1)
mn21 (\14\:CKbb \10\:CKb \10\:VSS VSS) g45n1svt w=(1.45e-07) l=4.5e-08 \
        nf=1 as=4.8e-14 ad=3.407e-14 ps=9.6e-07 pd=7.6e-07 nrd=1.16667 \
        nrs=1.16667 sa=2.35e-07 sb=1.29379e-06 sd=160n sca=13.253 \
        scb=0.0137915 scc=0.000695334 m=(1)
mn10 (\5\:SEb \5\:SE \8\:VSS VSS) g45n1svt w=(1.45e-07) l=4.5e-08 nf=1 \
        as=3.47e-14 ad=3.625e-14 ps=8.4e-07 pd=7.9e-07 nrd=1.16667 \
        nrs=1.16667 sa=1.27793e-06 sb=2.5e-07 sd=160n sca=11.7118 \
        scb=0.0116498 scc=0.000458536 m=(1)
mn50 (net405 \30\:qbint \20\:VSS VSS) g45n1svt w=(2.05e-07) l=4.5e-08 \
        nf=1 as=7.33e-14 ad=2.357e-14 ps=1.37e-06 pd=6.4e-07 nrd=1.16667 \
        nrs=1.16667 sa=4.3878e-07 sb=1.99e-06 sd=160n sca=10.3195 \
        scb=0.00946099 scc=0.0003152 m=(1)
mn51 (\13\:n30 CKb net405 VSS) g45n1svt w=(2.05e-07) l=4.5e-08 nf=1 \
        as=2.357e-14 ad=4.92e-14 ps=6.4e-07 pd=8.9e-07 nrd=1.16667 \
        nrs=1.16667 sa=5.9878e-07 sb=1.83e-06 sd=160n sca=10.3195 \
        scb=0.00946099 scc=0.0003152 m=(1)
mn40 (\13\:n30 CKbb \4\:mout VSS) g45n1svt w=(2.05e-07) l=4.5e-08 nf=1 \
        as=7.073e-14 ad=4.92e-14 ps=1.1e-06 pd=8.9e-07 nrd=1.16667 \
        nrs=1.16667 sa=8.8378e-07 sb=1.545e-06 sd=160n sca=10.3195 \
        scb=0.00946099 scc=0.0003152 m=(1)
mn30 (\4\:mout n20 \12\:VSS VSS) g45n1svt w=(2.05e-07) l=4.5e-08 nf=1 \
        as=6.778e-14 ad=7.073e-14 ps=1.15e-06 pd=1.1e-06 nrd=1.16667 \
        nrs=1.16667 sa=1.27378e-06 sb=1.155e-06 sd=160n sca=10.3195 \
        scb=0.00946099 scc=0.0003152 m=(1)
mn35 (net426 \11\:RN \12\:VSS VSS) g45n1svt w=(2.05e-07) l=4.5e-08 nf=1 \
        as=6.778e-14 ad=3.178e-14 ps=1.15e-06 pd=7.2e-07 nrd=1.16667 \
        nrs=1.16667 sa=1.59378e-06 sb=8.35e-07 sd=160n sca=10.3195 \
        scb=0.00946099 scc=0.0003152 m=(1)
mn36 (net422 \3\:mout net426 VSS) g45n1svt w=(2.05e-07) l=4.5e-08 nf=1 \
        as=3.178e-14 ad=2.358e-14 ps=7.2e-07 pd=6.4e-07 nrd=1.16667 \
        nrs=1.16667 sa=1.79378e-06 sb=6.35e-07 sd=160n sca=10.3195 \
        scb=0.00946099 scc=0.0003152 m=(1)
mn37 (\8\:n20 \4\:CKbb net422 VSS) g45n1svt w=(2.05e-07) l=4.5e-08 nf=1 \
        as=2.358e-14 ad=5.945e-14 ps=6.4e-07 pd=9.9e-07 nrd=1.16667 \
        nrs=1.16667 sa=1.9078e-06 sb=4.75e-07 sd=160n sca=10.3195 \
        scb=0.00946099 scc=0.0003152 m=(1)
mn25 (\8\:n20 \7\:CKb \8\:Db VSS) g45n1svt w=(2.05e-07) l=4.5e-08 nf=1 \
        as=2.87e-14 ad=5.945e-14 ps=6.9e-07 pd=9.9e-07 nrd=1.16667 \
        nrs=1.16667 sa=2e-06 sb=1.4e-07 sd=160n sca=10.3195 scb=0.00946099 \
        scc=0.0003152 m=(1)
mp11 (net381 \1\:D \16\:VDD VDD) g45p1svt w=(3.9e-07) l=4.5e-08 nf=1 \
        as=8.695e-14 ad=3.9e-14 ps=1.91e-06 pd=9.8e-07 nrd=1.16667 \
        nrs=1.16667 sa=2.68141e-07 sb=8.19551e-07 sd=160n sca=17.2385 \
        scb=0.0152696 scc=0.00137893 m=(1)
mp12 (\4\:Db \2\:SE net381 VDD) g45p1svt w=(3.9e-07) l=4.5e-08 nf=1 \
        as=3.9e-14 ad=7.02e-14 ps=9.8e-07 pd=1.14e-06 nrd=1.16667 \
        nrs=1.16667 sa=4.13141e-07 sb=6.74551e-07 sd=160n sca=17.2385 \
        scb=0.0152696 scc=0.00137893 m=(1)
mp14 (\4\:Db SEb net373 VDD) g45p1svt w=(3.9e-07) l=4.5e-08 nf=1 \
        as=5.265e-14 ad=7.02e-14 ps=1.05e-06 pd=1.14e-06 nrd=1.16667 \
        nrs=1.16667 sa=6.38141e-07 sb=4.49551e-07 sd=160n sca=17.5238 \
        scb=0.0153466 scc=0.00137894 m=(1)
mp13 (net373 \3\:SI \14\:VDD VDD) g45p1svt w=(3.9e-07) l=4.5e-08 nf=1 \
        as=6.535e-14 ad=5.265e-14 ps=1.16e-06 pd=1.05e-06 nrd=1.16667 \
        nrs=1.16667 sa=8.18141e-07 sb=2.69551e-07 sd=160n sca=18.2259 \
        scb=0.0157849 scc=0.00137936 m=(1)
mp45_1__rcx (\9\:VDD RN \33\:qbint VDD) g45p1svt w=(3.9e-07) l=4.5e-08 \
        nf=1 as=6.37e-14 ad=7.203e-14 ps=1.10667e-06 pd=1.17667e-06 \
        nrd=1.16667 nrs=1.16667 sa=1.605e-06 sb=1.265e-06 sd=160n \
        sca=28.7024 scb=0.0198217 scc=0.00315848 m=(3)
mp46_1__rcx (\33\:qbint n30 \9\:VDD VDD) g45p1svt w=(3.9e-07) l=4.5e-08 \
        nf=1 as=8.49e-14 ad=6.37e-14 ps=1.37e-06 pd=1.10667e-06 \
        nrd=1.16667 nrs=1.16667 sa=1.81e-06 sb=1.06e-06 sd=160n \
        sca=28.7024 scb=0.0198217 scc=0.00315848 m=(3)
mp20 (\18\:CKb \1\:CK \22\:VDD VDD) g45p1svt w=(2.15e-07) l=4.5e-08 nf=1 \
        as=8.195e-14 ad=3.01e-14 ps=1.98e-06 pd=7.1e-07 nrd=1.16667 \
        nrs=1.16667 sa=1.4e-07 sb=1.735e-06 sd=160n sca=27.1298 \
        scb=0.023603 scc=0.0032399 m=(1)
mp21 (\8\:CKbb \8\:CKb \16\:VDD VDD) g45p1svt w=(2.15e-07) l=4.5e-08 \
        nf=1 as=8.695e-14 ad=3.01e-14 ps=1.91e-06 pd=7.1e-07 nrd=1.16667 \
        nrs=1.16667 sa=1.4e-07 sb=1.19e-06 sd=160n sca=22.8495 \
        scb=0.0214046 scc=0.00242442 m=(1)
mp10 (\7\:SEb \7\:SE \14\:VDD VDD) g45p1svt w=(2.15e-07) l=4.5e-08 nf=1 \
        as=6.535e-14 ad=3.01e-14 ps=1.16e-06 pd=7.1e-07 nrd=1.16667 \
        nrs=1.16667 sa=1.19e-06 sb=1.4e-07 sd=160n sca=26.1974 \
        scb=0.0252592 scc=0.00245634 m=(1)
mp50 (net326 \28\:qbint \22\:VDD VDD) g45p1svt w=(3.1e-07) l=4.5e-08 \
        nf=1 as=8.195e-14 ad=4.495e-14 ps=1.98e-06 pd=9.1e-07 nrd=1.16667 \
        nrs=1.16667 sa=2.77984e-07 sb=1.525e-06 sd=160n sca=22.2698 \
        scb=0.0192893 scc=0.0023049 m=(1)
mp51 (\11\:n30 \3\:CKbb net326 VDD) g45p1svt w=(3.1e-07) l=4.5e-08 nf=1 \
        as=4.495e-14 ad=7.595e-14 ps=9.1e-07 pd=1.11e-06 nrd=1.16667 \
        nrs=1.16667 sa=4.67984e-07 sb=1.335e-06 sd=160n sca=22.2698 \
        scb=0.0192893 scc=0.0023049 m=(1)
mp40 (\11\:n30 \3\:CKb \7\:mout VDD) g45p1svt w=(3.1e-07) l=4.5e-08 nf=1 \
        as=9.455e-14 ad=7.595e-14 ps=1.23e-06 pd=1.11e-06 nrd=1.16667 \
        nrs=1.16667 sa=7.57984e-07 sb=1.045e-06 sd=160n sca=22.2698 \
        scb=0.0192893 scc=0.0023049 m=(1)
mp30 (\7\:mout \3\:n20 \20\:VDD VDD) g45p1svt w=(3.1e-07) l=4.5e-08 nf=1 \
        as=4.96e-14 ad=9.455e-14 ps=9.4e-07 pd=1.23e-06 nrd=1.16667 \
        nrs=1.16667 sa=1.10798e-06 sb=6.95e-07 sd=160n sca=22.2698 \
        scb=0.0192893 scc=0.0023049 m=(1)
mp35 (\3\:net349 \12\:RN \20\:VDD VDD) g45p1svt w=(3.1e-07) l=4.5e-08 \
        nf=1 as=4.96e-14 ad=8.525e-14 ps=9.4e-07 pd=1.17e-06 nrd=1.16667 \
        nrs=1.16667 sa=1.31298e-06 sb=4.9e-07 sd=160n sca=22.2698 \
        scb=0.0192893 scc=0.0023049 m=(1)
mp36 (\3\:net349 mout \18\:VDD VDD) g45p1svt w=(3.1e-07) l=4.5e-08 nf=1 \
        as=9.77e-14 ad=8.525e-14 ps=1.71e-06 pd=1.17e-06 nrd=1.16667 \
        nrs=1.16667 sa=1.63298e-06 sb=1.7e-07 sd=160n sca=22.2698 \
        scb=0.0192893 scc=0.0023049 m=(1)
mp37 (\4\:n20 \5\:CKb net349 VDD) g45p1svt w=(3.1e-07) l=4.5e-08 nf=1 \
        as=4.34e-14 ad=4.96e-14 ps=9e-07 pd=9.4e-07 nrd=1.16667 \
        nrs=1.16667 sa=1.4e-07 sb=3.45e-07 sd=160n sca=29.7112 \
        scb=0.0220652 scc=0.00347629 m=(1)
mp25 (\4\:n20 \7\:CKbb \6\:Db VDD) g45p1svt w=(3.1e-07) l=4.5e-08 nf=1 \
        as=4.34e-14 ad=4.96e-14 ps=9e-07 pd=9.4e-07 nrd=1.16667 \
        nrs=1.16667 sa=3.45e-07 sb=1.4e-07 sd=160n sca=29.7112 \
        scb=0.0220652 scc=0.00347629 m=(1)
ends SDFFRHQX8
// End of subcircuit definition.
