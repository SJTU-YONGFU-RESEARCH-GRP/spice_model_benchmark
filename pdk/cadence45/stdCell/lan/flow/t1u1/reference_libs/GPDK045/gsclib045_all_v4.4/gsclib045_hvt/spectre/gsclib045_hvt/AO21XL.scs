// gsclib045_hvt/AO21XL/schematic

simulator lang=spectre

subckt AO21XL A0 A1 B0 Y VDD VSS
mp1 (n2 A1 VDD VDD) g45p1hvt w=(215n) l=45n nf=1 m=(1)
mp0 (n2 A0 VDD VDD) g45p1hvt w=(215n) l=45n nf=1 m=(1)
mp3 (Y n0 VDD VDD) g45p1hvt w=(215n) l=45n nf=1 m=(1)
mp2 (n0 B0 n2 VDD) g45p1hvt w=(215n) l=45n nf=1 m=(1)
mn1 (n0 A1 n1 VSS) g45n1hvt w=(145n) l=45n nf=1 m=(1)
mn0 (n1 A0 VSS VSS) g45n1hvt w=(145n) l=45n nf=1 m=(1)
mn3 (Y n0 VSS VSS) g45n1hvt w=(145n) l=45n nf=1 m=(1)
mn2 (n0 B0 VSS VSS) g45n1hvt w=(145n) l=45n nf=1 m=(1)
ends AO21XL
