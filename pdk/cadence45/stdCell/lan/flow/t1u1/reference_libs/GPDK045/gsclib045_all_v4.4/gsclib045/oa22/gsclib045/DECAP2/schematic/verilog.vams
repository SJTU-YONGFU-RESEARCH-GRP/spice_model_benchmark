// Verilog-AMS netlist generated by the AMS netlister, version  IC6.1.6-64b.500.6 .
// Cadence Design Systems, Inc.

`include "disciplines.vams"

(* cds_ams_schematic *)
module DECAP2 ( .VDD(\VDD! ),.VSS(\VSS! ) );

input  (*
integer inh_conn_prop_name = "VDD";
integer
inh_conn_def_value = "cds_globals.\\VDD! ";
 *)
 \VDD! ;
input  (*

integer inh_conn_prop_name = "VSS";
integer inh_conn_def_value
 = "cds_globals.\\VSS! ";
 *)
 \VSS! ;

wire (*
integer inh_conn_prop_name = "VSS";
integer inh_conn_def_value
 = "cds_globals.\\VSS! ";
 *)
\VSS! ;
wire (*
integer inh_conn_prop_name = "VDD";
integer inh_conn_def_value
 = "cds_globals.\\VDD! ";
 *)
\VDD! ;

g45n1svt #(.ad(35.7f), .nrd(549.02m), .sca(146.63643), .pd(790n), .scc(0.01802),
 .scb(0.10305), .as(35.7f), .nrs(549.02m), .m(1), .ps(790n), .w(255n),
 .sa(140n), .nf(1), .sb(140n), .sd(160n), .l(45n)) (*
integer
library_binding = "gpdk045";
integer passed_mfactor = "m";
 *)
mn0 (
\VSS! , \VDD! , \VSS! , \VSS!  );

g45p1svt #(.ad(62.3f), .nrd(314.607m), .sca(106.82293), .pd(1.17u), .scc(0.01273),
 .scb(0.08585), .as(62.3f), .nrs(314.607m), .m(1), .ps(1.17u), .w(445n),
 .sa(140n), .nf(1), .sb(140n), .sd(160n), .l(45n)) (*
integer
library_binding = "gpdk045";
integer passed_mfactor = "m";
 *)
mp0 (
\VDD! , \VSS! , \VDD! , \VDD!  );

endmodule
