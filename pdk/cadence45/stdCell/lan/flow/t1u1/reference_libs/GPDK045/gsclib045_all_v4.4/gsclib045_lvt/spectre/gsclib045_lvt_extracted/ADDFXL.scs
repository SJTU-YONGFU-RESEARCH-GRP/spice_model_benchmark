// Generated for: spectre (May  1 09:11:05 2013 )
// Library name: gsclib045_lvt
// Cell name: ADDFXL
// View name: extracted

simulator lang=spectre

subckt ADDFXL A B CI CO S VDD VSS
mp12 (\1\:CO COb \16\:VDD VDD) g45p1lvt w=(2.15e-07) l=4.5e-08 nf=1 \
        as=3.01e-14 ad=3.01e-14 ps=7.1e-07 pd=7.1e-07 nrd=1.16667 \
        nrs=1.16667 sa=1.4e-07 sb=1.4e-07 sd=160n sca=43.3093 \
        scb=0.0404867 scc=0.00500078 m=(1)
mp2 (\3\:n3 \1\:A \14\:VDD VDD) g45p1lvt w=(2.15e-07) l=4.5e-08 nf=1 \
        as=6.64e-14 ad=3.01e-14 ps=1.9e-06 pd=7.1e-07 nrd=1.16667 \
        nrs=1.16667 sa=1.4e-07 sb=4.27442e-07 sd=160n sca=46.0095 \
        scb=0.0283849 scc=0.00588417 m=(1)
mp3 (n3 \1\:B \14\:VDD VDD) g45p1lvt w=(2.15e-07) l=4.5e-08 nf=1 \
        as=6.64e-14 ad=3.44e-14 ps=1.9e-06 pd=7.5e-07 nrd=1.16667 \
        nrs=1.16667 sa=2.74884e-07 sb=3.45e-07 sd=160n sca=24.8095 \
        scb=0.0224988 scc=0.00280688 m=(1)
mp4 (\11\:COb \1\:CI n3 VDD) g45p1lvt w=(2.15e-07) l=4.5e-08 nf=1 \
        as=3.44e-14 ad=3.01e-14 ps=7.5e-07 pd=7.1e-07 nrd=1.16667 \
        nrs=1.16667 sa=4.79884e-07 sb=1.4e-07 sd=160n sca=24.8095 \
        scb=0.0224988 scc=0.00280688 m=(1)
mp1 (\8\:COb \4\:B n1 VDD) g45p1lvt w=(2.15e-07) l=4.5e-08 nf=1 \
        as=1.29e-14 ad=3.01e-14 ps=5.5e-07 pd=7.1e-07 nrd=1.16667 \
        nrs=1.16667 sa=1.4e-07 sb=5.0407e-07 sd=160n sca=12.1244 \
        scb=0.0107968 scc=0.000332109 m=(1)
mp0 (n1 \6\:A \12\:VDD VDD) g45p1lvt w=(2.15e-07) l=4.5e-08 nf=1 \
        as=6.465e-14 ad=1.29e-14 ps=1.82e-06 pd=5.5e-07 nrd=1.16667 \
        nrs=1.16667 sa=2.45e-07 sb=3.9907e-07 sd=160n sca=12.1244 \
        scb=0.0107968 scc=0.000332109 m=(1)
mp7 (\3\:n5 \7\:CI \12\:VDD VDD) g45p1lvt w=(2.15e-07) l=4.5e-08 nf=1 \
        as=6.465e-14 ad=3.44e-14 ps=1.82e-06 pd=7.5e-07 nrd=1.16667 \
        nrs=1.16667 sa=2.22093e-07 sb=4.61047e-07 sd=160n sca=25.9192 \
        scb=0.0230503 scc=0.00301683 m=(1)
mp6 (\3\:n5 \10\:B \10\:VDD VDD) g45p1lvt w=(2.15e-07) l=4.5e-08 nf=1 \
        as=7.322e-14 ad=3.44e-14 ps=2.14e-06 pd=7.5e-07 nrd=1.16667 \
        nrs=1.16667 sa=4.27093e-07 sb=2.56047e-07 sd=160n sca=25.9192 \
        scb=0.0230503 scc=0.00301683 m=(1)
mp5 (n5 \9\:A \10\:VDD VDD) g45p1lvt w=(2.15e-07) l=4.5e-08 nf=1 \
        as=7.322e-14 ad=4.407e-14 ps=2.14e-06 pd=8.4e-07 nrd=1.16667 \
        nrs=1.16667 sa=2.98256e-07 sb=4.9e-07 sd=160n sca=11.4924 \
        scb=0.00977085 scc=0.000239291 m=(1)
mp8 (\11\:Sb \6\:COb n5 VDD) g45p1lvt w=(2.15e-07) l=4.5e-08 nf=1 \
        as=4.407e-14 ad=5.16e-14 ps=8.4e-07 pd=9.1e-07 nrd=1.16667 \
        nrs=1.16667 sa=5.48256e-07 sb=2.4e-07 sd=160n sca=11.4924 \
        scb=0.00977085 scc=0.000239291 m=(1)
mp11 (\9\:Sb \11\:CI n9 VDD) g45p1lvt w=(2.15e-07) l=4.5e-08 nf=1 \
        as=1.29e-14 ad=3.01e-14 ps=5.5e-07 pd=7.1e-07 nrd=1.16667 \
        nrs=1.16667 sa=1.4e-07 sb=7.7e-07 sd=160n sca=12.7748 scb=0.011453 \
        scc=0.000391592 m=(1)
mp10 (n9 \13\:B n8 VDD) g45p1lvt w=(2.15e-07) l=4.5e-08 nf=1 as=3.332e-14 \
        ad=1.29e-14 ps=7.4e-07 pd=5.5e-07 nrd=1.16667 nrs=1.16667 \
        sa=2.45e-07 sb=6.65e-07 sd=160n sca=13.1199 scb=0.0116197 \
        scc=0.000391676 m=(1)
mp9 (n8 \12\:A \1\:VDD VDD) g45p1lvt w=(2.15e-07) l=4.5e-08 nf=1 \
        as=5.87e-14 ad=3.332e-14 ps=1.06e-06 pd=7.4e-07 nrd=1.16667 \
        nrs=1.16667 sa=4.45e-07 sb=4.65e-07 sd=160n sca=14.3514 \
        scb=0.0128708 scc=0.000395547 m=(1)
mp13 (\1\:S Sb \1\:VDD VDD) g45p1lvt w=(2.15e-07) l=4.5e-08 nf=1 \
        as=5.87e-14 ad=4.3e-14 ps=1.06e-06 pd=8.3e-07 nrd=1.16667 \
        nrs=1.16667 sa=7.1e-07 sb=2e-07 sd=160n sca=20.6331 scb=0.0233447 \
        scc=0.000832054 m=(1)
C1 (CO VSS) capacitor c=5.92304e-17
C2 (A VSS) capacitor c=1.15492e-16
C3 (VDD VSS) capacitor c=2.64157e-16
C4 (B VSS) capacitor c=3.18855e-17
C5 (CI VSS) capacitor c=4.20199e-17
C6 (S VSS) capacitor c=5.75903e-17
C7 (COb VSS) capacitor c=2.51109e-17
C8 (n2 VSS) capacitor c=7.51999e-17
C9 (n4 VSS) capacitor c=8.15732e-17
C10 (Sb VSS) capacitor c=5.08651e-17
C11 (n7 VSS) capacitor c=1.88509e-18
C12 (n6 VSS) capacitor c=3.44312e-18
C13 (n3 VSS) capacitor c=7.22101e-17
C14 (n5 VSS) capacitor c=7.12991e-17
C15 (n9 VSS) capacitor c=2.0997e-18
C16 (n8 VSS) capacitor c=4.98975e-18
C17 (\12\:A VSS) capacitor c=3.87564e-17
C18 (\13\:B VSS) capacitor c=6.57695e-17
C19 (\11\:CI VSS) capacitor c=8.73568e-17
C20 (\6\:COb VSS) capacitor c=2.85908e-17
C21 (\9\:A VSS) capacitor c=6.23304e-17
C22 (\10\:B VSS) capacitor c=4.50597e-17
C23 (\7\:CI VSS) capacitor c=7.99434e-17
C24 (\6\:A VSS) capacitor c=8.63581e-17
C25 (\4\:B VSS) capacitor c=5.89493e-17
C26 (\1\:CI VSS) capacitor c=5.00394e-17
C27 (\1\:B VSS) capacitor c=4.34131e-17
C28 (\1\:A VSS) capacitor c=4.97674e-17
C29 (\3\:Sb VSS) capacitor c=2.97086e-17
C30 (\10\:A VSS) capacitor c=6.23267e-17
C31 (\11\:B VSS) capacitor c=7.63858e-17
C32 (\8\:CI VSS) capacitor c=5.07301e-17
C33 (\4\:COb VSS) capacitor c=6.44171e-17
C34 (\7\:A VSS) capacitor c=4.34836e-17
C35 (\7\:B VSS) capacitor c=5.66274e-17
C36 (\5\:CI VSS) capacitor c=3.42303e-17
C37 (\4\:A VSS) capacitor c=5.033e-17
C38 (\6\:B VSS) capacitor c=6.38832e-17
C39 (\3\:CI VSS) capacitor c=2.73473e-17
C40 (\3\:B VSS) capacitor c=5.45484e-17
C41 (\3\:A VSS) capacitor c=3.95715e-17
C42 (\3\:COb VSS) capacitor c=2.88839e-17
C43 (\2\:Sb VSS) capacitor c=4.13492e-17
C44 (\11\:A VSS) capacitor c=5.47823e-17
C45 (\12\:B VSS) capacitor c=7.91415e-17
C46 (\10\:CI VSS) capacitor c=7.3038e-17
C47 (\5\:COb VSS) capacitor c=5.86968e-17
C48 (\8\:A VSS) capacitor c=7.30792e-17
C49 (\9\:B VSS) capacitor c=2.74972e-17
C50 (\6\:CI VSS) capacitor c=5.89715e-17
C51 (\5\:A VSS) capacitor c=8.7176e-17
C52 (\5\:B VSS) capacitor c=7.27836e-17
C53 (\4\:CI VSS) capacitor c=4.97025e-17
C54 (\2\:B VSS) capacitor c=4.09472e-17
C55 (\2\:A VSS) capacitor c=2.81591e-17
C56 (\2\:COb VSS) capacitor c=2.60978e-17
C57 (\1\:S VSS) capacitor c=3.64496e-17
C58 (\1\:VDD VSS) capacitor c=3.96127e-17
C59 (\9\:Sb VSS) capacitor c=8.44494e-17
C60 (\11\:Sb VSS) capacitor c=3.67612e-17
C61 (\10\:VDD VSS) capacitor c=1.8728e-17
C62 (\3\:n5 VSS) capacitor c=7.52154e-17
C63 (\12\:VDD VSS) capacitor c=1.28115e-17
C64 (\8\:COb VSS) capacitor c=1.40367e-16
C65 (\11\:COb VSS) capacitor c=2.03762e-17
C66 (\14\:VDD VSS) capacitor c=9.91072e-18
C67 (\3\:n3 VSS) capacitor c=6.60625e-17
C68 (\1\:CO VSS) capacitor c=4.3977e-17
C69 (\16\:VDD VSS) capacitor c=3.06328e-17
C70 (\3\:VDD VSS) capacitor c=5.81461e-17
C71 (\3\:S VSS) capacitor c=2.60826e-17
C72 (\4\:Sb VSS) capacitor c=7.29068e-17
C73 (\7\:Sb VSS) capacitor c=3.81106e-17
C74 (\3\:n4 VSS) capacitor c=7.86417e-17
C75 (\18\:COb VSS) capacitor c=4.3181e-17
C76 (\15\:COb VSS) capacitor c=4.2072e-17
C77 (\3\:n2 VSS) capacitor c=7.14556e-17
C78 (\3\:CO VSS) capacitor c=8.5862e-17
C79 (\2\:CI VSS) capacitor c=3.06318e-17
C80 (\8\:B VSS) capacitor c=4.64474e-17
C81 (\7\:COb VSS) capacitor c=1.49516e-16
C82 (\10\:COb VSS) capacitor c=1.07987e-16
C83 (\13\:COb VSS) capacitor c=1.76965e-16
C84 (\14\:COb VSS) capacitor c=1.15276e-16
C85 (\17\:COb VSS) capacitor c=4.72469e-17
C86 (\12\:CI VSS) capacitor c=1.35547e-16
C87 (\13\:CI VSS) capacitor c=1.59429e-16
C88 (\14\:CI VSS) capacitor c=5.27051e-17
C89 (\14\:B VSS) capacitor c=1.29555e-16
C90 (\15\:B VSS) capacitor c=1.56784e-16
C91 (\16\:B VSS) capacitor c=7.95157e-17
C92 (\17\:B VSS) capacitor c=7.06063e-17
C93 (\13\:A VSS) capacitor c=2.11529e-16
C94 (\14\:A VSS) capacitor c=1.62071e-16
C95 (\15\:A VSS) capacitor c=1.26854e-16
C96 (\16\:A VSS) capacitor c=2.48829e-17
C97 (\6\:Sb VSS) capacitor c=1.53234e-16
C98 (\5\:VDD VSS) capacitor c=2.67076e-17
C99 (\6\:VDD VSS) capacitor c=2.07534e-17
C100 (\8\:VDD VSS) capacitor c=1.58187e-17
C101 (\9\:VDD VSS) capacitor c=5.9958e-18
Rk1 (\2\:CO CO) resistor r=0.2529 c=0
Rk2 (CO \4\:CO) resistor r=0.52 c=0
Rk22 (A \13\:A) resistor r=0.8877 c=0
Rk23 (\13\:A \14\:A) resistor r=0.578 c=0
Rk24 (\14\:A \15\:A) resistor r=0.7117 c=0
Rk25 (A \16\:A) resistor r=0.05411 c=0
Rk42 (\2\:VDD \4\:VDD) resistor r=0.4341 c=0
Rk43 (\4\:VDD \5\:VDD) resistor r=0.5382 c=0
Rk44 (\5\:VDD \6\:VDD) resistor r=0.109 c=0
Rk45 (\6\:VDD \7\:VDD) resistor r=0.3535 c=0
Rk46 (\7\:VDD \8\:VDD) resistor r=0.1378 c=0
Rk48 (\9\:VDD VDD) resistor r=0.01962 c=0
Rk47 (\8\:VDD \9\:VDD) resistor r=0.3935 c=0
Rk49 (\5\:VDD \11\:VDD) resistor r=0.04333 c=0
Rk50 (\6\:VDD \13\:VDD) resistor r=0.08012 c=0
Rk51 (\8\:VDD \15\:VDD) resistor r=0.07416 c=0
Rk52 (\9\:VDD \17\:VDD) resistor r=0.4025 c=0
Rk18 (\14\:B \15\:B) resistor r=0.8953 c=0
Rk21 (\16\:B B) resistor r=0.05733 c=0
Rk19 (\15\:B \16\:B) resistor r=0.3853 c=0
Rk20 (\16\:B \17\:B) resistor r=0.4344 c=0
Rk16 (\13\:CI CI) resistor r=0.2408 c=0
Rk15 (\12\:CI \13\:CI) resistor r=0.8824 c=0
Rk17 (CI \14\:CI) resistor r=0.08714 c=0
Rk30 (\2\:S S) resistor r=0.3444 c=0
Rk31 (S \4\:S) resistor r=0.2115 c=0
Rk32 (\2\:VSS \4\:VSS) resistor r=0.4153 c=0
Rk33 (\4\:VSS \5\:VSS) resistor r=0.4188 c=0
Rk34 (\5\:VSS \6\:VSS) resistor r=0.2078 c=0
Rk35 (\6\:VSS \7\:VSS) resistor r=0.3761 c=0
Rk37 (\8\:VSS VSS) resistor r=0.448 c=0
Rk36 (\7\:VSS \8\:VSS) resistor r=0.1017 c=0
Rk38 (VSS \10\:VSS) resistor r=0.2036 c=0
Rk39 (\5\:VSS \12\:VSS) resistor r=0.1029 c=0
Rk40 (\6\:VSS \14\:VSS) resistor r=0.1851 c=0
Rk41 (\8\:VSS \16\:VSS) resistor r=0.04333 c=0
Rk7 (\7\:COb \9\:COb) resistor r=1.1789 c=0
Rk8 (\9\:COb \10\:COb) resistor r=0.1499 c=0
Rk9 (\10\:COb \12\:COb) resistor r=0.05483 c=0
Rk10 (\10\:COb \13\:COb) resistor r=0.9636 c=0
Rk11 (\13\:COb \14\:COb) resistor r=0.8694 c=0
Rk12 (\14\:COb \16\:COb) resistor r=0.1125 c=0
Rk13 (\13\:COb \17\:COb) resistor r=0.1933 c=0
Rk14 (\14\:COb \19\:COb) resistor r=0.1501 c=0
Rk3 (\2\:n2 \4\:n2) resistor r=0.2374 c=0
Rk6 (\2\:n4 \4\:n4) resistor r=0.2862 c=0
Rk26 (\5\:Sb \6\:Sb) resistor r=0.5258 c=0
Rk27 (\5\:Sb \8\:Sb) resistor r=0.201 c=0
Rk28 (\6\:Sb \10\:Sb) resistor r=0.9101 c=0
Rk29 (\10\:Sb \12\:Sb) resistor r=0.1293 c=0
Rk4 (\2\:n3 \4\:n3) resistor r=0.2405 c=0
Rk5 (\2\:n5 \4\:n5) resistor r=0.2806 c=0
Rl29 (\11\:A \12\:A) resistor r=39.5604 c=0
Rl28 (\10\:A \11\:A) resistor r=192.308 c=0
Rl20 (\8\:A \9\:A) resistor r=161.516 c=0
Rl19 (\7\:A \8\:A) resistor r=97.872 c=0
Rl13 (\5\:A \6\:A) resistor r=141.758 c=0
Rl12 (\4\:A \5\:A) resistor r=103.846 c=0
Rl3 (\1\:A \2\:A) resistor r=64.1533 c=0
Rl4 (\2\:A \3\:A) resistor r=29.5379 c=0
Rl27 (\12\:B \13\:B) resistor r=76.3736 c=0
Rl26 (\11\:B \12\:B) resistor r=155.769 c=0
Rl10 (\4\:B \5\:B) resistor r=69.9225 c=0
Rl11 (\5\:B \6\:B) resistor r=173.769 c=0
Rl5 (\1\:B \2\:B) resistor r=29.5379 c=0
Rl6 (\2\:B \3\:B) resistor r=92.9995 c=0
Rl18 (\8\:B \10\:B) resistor r=23.7402 c=0
Rl16 (\7\:B \8\:B) resistor r=188.77 c=0
Rl17 (\8\:B \9\:B) resistor r=5.8511 c=0
Rl15 (\6\:CI \7\:CI) resistor r=149.451 c=0
Rl14 (\5\:CI \6\:CI) resistor r=42.3077 c=0
Rl7 (\1\:CI \2\:CI) resistor r=116.541 c=0
Rl8 (\2\:CI \3\:CI) resistor r=28.0797 c=0
Rl9 (\2\:CI \4\:CI) resistor r=118.425 c=0
Rl25 (\9\:CI \11\:CI) resistor r=199.313 c=0
Rl23 (\8\:CI \9\:CI) resistor r=56.0256 c=0
Rl24 (\9\:CI \10\:CI) resistor r=8.1539 c=0
Rl22 (\5\:COb \6\:COb) resistor r=24.2328 c=0
Rl21 (\4\:COb \5\:COb) resistor r=257.246 c=0
Rl1 (COb \2\:COb) resistor r=73.7687 c=0
Rl2 (\2\:COb \3\:COb) resistor r=100.692 c=0
Rl30 (Sb \2\:Sb) resistor r=191.076 c=0
Rl31 (\2\:Sb \3\:Sb) resistor r=39.1533 c=0
Rz1 (\3\:CO \4\:CO) resistor r=75 c=0
Rz16 (\3\:VDD \4\:VDD) resistor r=9.375 c=0
Rz17 (\3\:VDD \7\:VDD) resistor r=6.25 c=0
Rz10 (\3\:S \4\:S) resistor r=75 c=0
Rz11 (\1\:VSS \2\:VSS) resistor r=75 c=0
Rz12 (\9\:VSS \10\:VSS) resistor r=75 c=0
Rz13 (\11\:VSS \12\:VSS) resistor r=75 c=0
Rz14 (\13\:VSS \14\:VSS) resistor r=75 c=0
Rz15 (\15\:VSS \16\:VSS) resistor r=75 c=0
Rz6 (\15\:COb \16\:COb) resistor r=75 c=0
Rz7 (\18\:COb \19\:COb) resistor r=75 c=0
Rz2 (n2 \2\:n2) resistor r=75 c=0
Rz3 (\3\:n2 \4\:n2) resistor r=75 c=0
Rz4 (n4 \2\:n4) resistor r=75 c=0
Rz5 (\3\:n4 \4\:n4) resistor r=75 c=0
Rz8 (\4\:Sb \5\:Sb) resistor r=75 c=0
Rz9 (\7\:Sb \8\:Sb) resistor r=75 c=0
Ry1 (\1\:CO \2\:CO) resistor r=62 c=0
Ry13 (\1\:VDD \2\:VDD) resistor r=62 c=0
Ry14 (\10\:VDD \11\:VDD) resistor r=62 c=0
Ry15 (\12\:VDD \13\:VDD) resistor r=62 c=0
Ry16 (\14\:VDD \15\:VDD) resistor r=62 c=0
Ry17 (\16\:VDD \17\:VDD) resistor r=62 c=0
Ry10 (\1\:S \2\:S) resistor r=62 c=0
Ry11 (\3\:VSS \4\:VSS) resistor r=7.75 c=0
Ry12 (\3\:VSS \7\:VSS) resistor r=5.1667 c=0
Ry6 (\8\:COb \9\:COb) resistor r=62 c=0
Ry7 (\11\:COb \12\:COb) resistor r=62 c=0
Ry8 (\9\:Sb \10\:Sb) resistor r=62 c=0
Ry9 (\11\:Sb \12\:Sb) resistor r=62 c=0
Ry2 (n3 \2\:n3) resistor r=62 c=0
Ry3 (\3\:n3 \4\:n3) resistor r=62 c=0
Ry4 (n5 \2\:n5) resistor r=62 c=0
Ry5 (\3\:n5 \4\:n5) resistor r=62 c=0
Rx10 (\8\:A \13\:A) resistor r=45 c=0
Rx11 (\5\:A \14\:A) resistor r=45 c=0
Rx12 (\2\:A \15\:A) resistor r=45 c=0
Rx13 (\11\:A \16\:A) resistor r=45 c=0
Rx6 (\12\:B \14\:B) resistor r=45 c=0
Rx7 (\9\:B \15\:B) resistor r=45 c=0
Rx8 (\5\:B \16\:B) resistor r=45 c=0
Rx9 (\2\:B \17\:B) resistor r=45 c=0
Rx3 (\10\:CI \12\:CI) resistor r=45 c=0
Rx4 (\6\:CI \13\:CI) resistor r=45 c=0
Rx5 (\4\:CI \14\:CI) resistor r=45 c=0
Rx1 (\5\:COb \7\:COb) resistor r=45 c=0
Rx2 (\2\:COb \17\:COb) resistor r=45 c=0
Rx14 (\2\:Sb \6\:Sb) resistor r=45 c=0
mn12 (\3\:CO \3\:COb \9\:VSS VSS) g45n1lvt w=(1.45e-07) l=4.5e-08 nf=1 \
        as=2.61e-14 ad=2.393e-14 ps=6.5e-07 pd=6.2e-07 nrd=1.16667 \
        nrs=1.16667 sa=1.8e-07 sb=1.65e-07 sd=160n sca=7.09016 \
        scb=0.00401586 scc=3.69756e-05 m=(1)
mn2 (\3\:n2 \3\:A \15\:VSS VSS) g45n1lvt w=(1.45e-07) l=4.5e-08 nf=1 \
        as=4.84e-14 ad=2.03e-14 ps=1.46e-06 pd=5.7e-07 nrd=1.16667 \
        nrs=1.16667 sa=1.4e-07 sb=4.7931e-07 sd=160n sca=14.3814 \
        scb=0.0152134 scc=0.00088947 m=(1)
mn3 (n2 \3\:B \15\:VSS VSS) g45n1lvt w=(1.45e-07) l=4.5e-08 nf=1 \
        as=4.84e-14 ad=2.32e-14 ps=1.46e-06 pd=6.1e-07 nrd=1.16667 \
        nrs=1.16667 sa=3.02586e-07 sb=3.45e-07 sd=160n sca=12.9138 \
        scb=0.0133404 scc=0.000640143 m=(1)
mn4 (\15\:COb \3\:CI n2 VSS) g45n1lvt w=(1.45e-07) l=4.5e-08 nf=1 \
        as=2.32e-14 ad=2.03e-14 ps=6.1e-07 pd=5.7e-07 nrd=1.16667 \
        nrs=1.16667 sa=5.07586e-07 sb=1.4e-07 sd=160n sca=12.9138 \
        scb=0.0133404 scc=0.000640143 m=(1)
mn1 (\18\:COb \6\:B n0 VSS) g45n1lvt w=(1.45e-07) l=4.5e-08 nf=1 \
        as=1.957e-14 ad=2.03e-14 ps=5.6e-07 pd=5.7e-07 nrd=1.16667 \
        nrs=1.16667 sa=1.4e-07 sb=1.23e-06 sd=160n sca=6.83173 \
        scb=0.00357784 scc=2.82929e-05 m=(1)
mn0 (n0 \4\:A \13\:VSS VSS) g45n1lvt w=(1.45e-07) l=4.5e-08 nf=1 \
        as=2.32e-14 ad=1.957e-14 ps=6.1e-07 pd=5.6e-07 nrd=1.16667 \
        nrs=1.16667 sa=3.2e-07 sb=1.05e-06 sd=160n sca=6.83173 \
        scb=0.00357784 scc=2.82929e-05 m=(1)
mn7 (\3\:n4 \5\:CI \13\:VSS VSS) g45n1lvt w=(1.45e-07) l=4.5e-08 nf=1 \
        as=2.32e-14 ad=2.392e-14 ps=6.1e-07 pd=6.2e-07 nrd=1.16667 \
        nrs=1.16667 sa=5.25e-07 sb=8.45e-07 sd=160n sca=6.83173 \
        scb=0.00357784 scc=2.82929e-05 m=(1)
mn6 (\3\:n4 \7\:B \11\:VSS VSS) g45n1lvt w=(1.45e-07) l=4.5e-08 nf=1 \
        as=5.17e-14 ad=2.392e-14 ps=1.06e-06 pd=6.2e-07 nrd=1.16667 \
        nrs=1.16667 sa=7.35e-07 sb=6.35e-07 sd=160n sca=6.83173 \
        scb=0.00357784 scc=2.82929e-05 m=(1)
mn5 (n4 \7\:A \11\:VSS VSS) g45n1lvt w=(1.45e-07) l=4.5e-08 nf=1 \
        as=5.17e-14 ad=2.682e-14 ps=1.06e-06 pd=6.6e-07 nrd=1.16667 \
        nrs=1.16667 sa=1e-06 sb=3.7e-07 sd=160n sca=6.83173 scb=0.00357784 \
        scc=2.82929e-05 m=(1)
mn8 (\7\:Sb \4\:COb n4 VSS) g45n1lvt w=(1.45e-07) l=4.5e-08 nf=1 \
        as=2.682e-14 ad=2.03e-14 ps=6.6e-07 pd=5.7e-07 nrd=1.16667 \
        nrs=1.16667 sa=1.23e-06 sb=1.4e-07 sd=160n sca=6.83173 \
        scb=0.00357784 scc=2.82929e-05 m=(1)
mn11 (\4\:Sb \8\:CI n7 VSS) g45n1lvt w=(1.45e-07) l=4.5e-08 nf=1 \
        as=8.7e-15 ad=2.03e-14 ps=4.1e-07 pd=5.7e-07 nrd=1.16667 \
        nrs=1.16667 sa=1.4e-07 sb=6.95e-07 sd=160n sca=7.27658 \
        scb=0.00433573 scc=4.41722e-05 m=(1)
mn10 (n7 \11\:B n6 VSS) g45n1lvt w=(1.45e-07) l=4.5e-08 nf=1 as=1.957e-14 \
        ad=8.7e-15 ps=5.6e-07 pd=4.1e-07 nrd=1.16667 nrs=1.16667 \
        sa=2.45e-07 sb=5.9e-07 sd=160n sca=7.27658 scb=0.00433573 \
        scc=4.41722e-05 m=(1)
mn9 (n6 \10\:A \1\:VSS VSS) g45n1lvt w=(1.45e-07) l=4.5e-08 nf=1 \
        as=2.393e-14 ad=1.958e-14 ps=6.2e-07 pd=5.6e-07 nrd=1.16667 \
        nrs=1.16667 sa=4.25e-07 sb=4.1e-07 sd=160n sca=7.27658 \
        scb=0.00433573 scc=4.41722e-05 m=(1)
mn13 (\3\:S \3\:Sb \1\:VSS VSS) g45n1lvt w=(1.45e-07) l=4.5e-08 nf=1 \
        as=2.393e-14 ad=2.9e-14 ps=6.2e-07 pd=6.9e-07 nrd=1.16667 \
        nrs=1.16667 sa=6.35e-07 sb=2e-07 sd=160n sca=7.27658 \
        scb=0.00433573 scc=4.41722e-05 m=(1)
ends ADDFXL
// End of subcircuit definition.
