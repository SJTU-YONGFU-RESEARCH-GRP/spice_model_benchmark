// Generated for: spectre (May  1 11:29:45 2013 )
// Library name: gsclib045_backbias
// Cell name: MDFFHQX8
// View name: extracted

simulator lang=spectre

subckt MDFFHQX8 CK D0 D1 NW Q S0 VDD VSS
mp55_1__rcx (Q qbint \6\:VDD NW) g45p1svt w=(4.45e-07) l=4.5e-08 nf=1 \
        as=7.271e-14 ad=6.993e-14 ps=1.21857e-06 pd=1.20429e-06 \
        nrd=1.16667 nrs=1.16667 sa=1.4e-07 sb=1.92213e-06 sd=160n \
        sca=41.6034 scb=0.0375368 scc=0.00435732 m=(7)
C1 (D0 VSS) capacitor c=6.49673e-17
C2 (S0 VSS) capacitor c=4.48209e-17
C3 (VDD VSS) capacitor c=3.52748e-17
C4 (CK VSS) capacitor c=7.54957e-17
C5 (NW VSS) capacitor c=7.78461e-16
C6 (D1 VSS) capacitor c=5.27971e-17
C7 (Q VSS) capacitor c=4.96176e-16
C8 (qbint VSS) capacitor c=3.78491e-16
C9 (n30 VSS) capacitor c=2.08232e-16
C10 (CKb VSS) capacitor c=4.87722e-17
C11 (n35 VSS) capacitor c=2.75049e-18
C12 (mout VSS) capacitor c=6.59019e-17
C13 (CKbb VSS) capacitor c=2.58852e-17
C14 (n20 VSS) capacitor c=3.8911e-17
C15 (n25 VSS) capacitor c=1.12961e-18
C16 (D0b VSS) capacitor c=9.71518e-17
C17 (n10 VSS) capacitor c=5.74422e-18
C18 (S0b VSS) capacitor c=3.48579e-17
C19 (n36 VSS) capacitor c=3.48222e-18
C20 (n26 VSS) capacitor c=3.30937e-18
C21 (n11 VSS) capacitor c=1.73603e-18
C22 (n13 VSS) capacitor c=6.99647e-18
C23 (\8\:S0 VSS) capacitor c=4.99456e-17
C24 (\1\:D1 VSS) capacitor c=5.11973e-17
C25 (\2\:S0 VSS) capacitor c=7.24253e-17
C26 (\4\:D0 VSS) capacitor c=9.27815e-17
C27 (\10\:CKb VSS) capacitor c=6.61966e-17
C28 (\7\:CKbb VSS) capacitor c=3.86159e-17
C29 (\8\:CKb VSS) capacitor c=4.00274e-17
C30 (\3\:CKb VSS) capacitor c=2.37664e-17
C31 (\3\:CKbb VSS) capacitor c=6.58069e-17
C32 (\22\:qbint VSS) capacitor c=4.91411e-17
C33 (\1\:CK VSS) capacitor c=3.51269e-17
C34 (\7\:S0 VSS) capacitor c=3.12974e-17
C35 (\3\:D1 VSS) capacitor c=8.00885e-17
C36 (\3\:S0 VSS) capacitor c=7.07879e-17
C37 (\3\:S0b VSS) capacitor c=6.82559e-17
C38 (\1\:D0 VSS) capacitor c=4.71662e-17
C39 (\5\:CKb VSS) capacitor c=2.71449e-17
C40 (\11\:CKb VSS) capacitor c=2.61405e-17
C41 (\5\:CKbb VSS) capacitor c=6.05531e-17
C42 (\4\:mout VSS) capacitor c=5.80067e-17
C43 (\3\:n20 VSS) capacitor c=4.56406e-17
C44 (\24\:qbint VSS) capacitor c=5.98316e-17
C45 (\3\:CK VSS) capacitor c=3.19822e-17
C46 (\5\:S0 VSS) capacitor c=1.77018e-17
C47 (\2\:D1 VSS) capacitor c=4.72336e-17
C48 (\4\:S0 VSS) capacitor c=4.39153e-17
C49 (\2\:S0b VSS) capacitor c=5.08214e-17
C50 (\1\:S0 VSS) capacitor c=5.66692e-17
C51 (\3\:D0 VSS) capacitor c=2.92488e-17
C52 (\8\:CKbb VSS) capacitor c=4.1837e-17
C53 (\9\:CKb VSS) capacitor c=2.73771e-17
C54 (\6\:CKbb VSS) capacitor c=4.00656e-17
C55 (\3\:mout VSS) capacitor c=1.75549e-17
C56 (\2\:n20 VSS) capacitor c=3.53188e-17
C57 (\4\:CKbb VSS) capacitor c=2.5985e-17
C58 (\4\:CKb VSS) capacitor c=3.72989e-17
C59 (\2\:CKb VSS) capacitor c=3.89957e-17
C60 (\23\:qbint VSS) capacitor c=4.71774e-17
C61 (\2\:CK VSS) capacitor c=3.18424e-17
C62 (\6\:S0b VSS) capacitor c=1.11966e-16
C63 (\1\:VDD VSS) capacitor c=1.28725e-16
C64 (\8\:D0b VSS) capacitor c=5.02821e-17
C65 (\11\:VDD VSS) capacitor c=4.47567e-17
C66 (\15\:CKbb VSS) capacitor c=8.11758e-17
C67 (\4\:D0b VSS) capacitor c=1.1283e-16
C68 (\4\:n20 VSS) capacitor c=6.06044e-17
C69 (\13\:VDD VSS) capacitor c=4.08827e-17
C70 (\9\:mout VSS) capacitor c=5.7941e-17
C71 (\14\:n30 VSS) capacitor c=1.09111e-16
C72 (\15\:VDD VSS) capacitor c=1.03065e-17
C73 (\18\:CKb VSS) capacitor c=1.03595e-16
C74 (\26\:qbint VSS) capacitor c=3.77231e-16
C75 (\4\:S0b VSS) capacitor c=8.99586e-17
C76 (\9\:CKbb VSS) capacitor c=6.43422e-17
C77 (\6\:D0b VSS) capacitor c=7.70912e-17
C78 (\8\:n20 VSS) capacitor c=7.06562e-17
C79 (\7\:mout VSS) capacitor c=5.25937e-17
C80 (\12\:n30 VSS) capacitor c=2.07422e-16
C81 (\15\:CKb VSS) capacitor c=1.54769e-16
C82 (\2\:CKbb VSS) capacitor c=4.85884e-17
C83 (\2\:mout VSS) capacitor c=3.64409e-17
C84 (\6\:CKb VSS) capacitor c=6.51288e-17
C85 (\7\:CKb VSS) capacitor c=6.62711e-17
C86 (\2\:D0 VSS) capacitor c=4.63008e-17
C87 (\6\:S0 VSS) capacitor c=2.50368e-17
C88 (\4\:CK VSS) capacitor c=3.80795e-17
C89 (\25\:qbint VSS) capacitor c=1.19782e-16
C90 (\31\:qbint VSS) capacitor c=3.04795e-17
C91 (\11\:n30 VSS) capacitor c=1.53987e-16
C92 (\5\:mout VSS) capacitor c=5.11922e-17
C93 (\6\:mout VSS) capacitor c=5.58036e-17
C94 (\12\:CKb VSS) capacitor c=5.31736e-17
C95 (\13\:CKb VSS) capacitor c=1.31129e-16
C96 (\14\:CKb VSS) capacitor c=1.5935e-16
C97 (\17\:CKb VSS) capacitor c=1.01771e-16
C98 (\6\:n20 VSS) capacitor c=7.47254e-17
C99 (\7\:n20 VSS) capacitor c=7.5359e-17
C100 (\11\:CKbb VSS) capacitor c=9.10933e-17
C101 (\12\:CKbb VSS) capacitor c=1.11671e-16
C102 (\13\:CKbb VSS) capacitor c=1.18485e-16
C103 (\14\:CKbb VSS) capacitor c=1.31394e-16
C104 (\17\:CKbb VSS) capacitor c=6.48844e-17
C105 (\5\:D0 VSS) capacitor c=4.66662e-17
C106 (\3\:D0b VSS) capacitor c=1.18035e-16
C107 (\4\:D1 VSS) capacitor c=7.8845e-17
C108 (\9\:S0 VSS) capacitor c=6.47639e-17
C109 (\10\:S0 VSS) capacitor c=8.12759e-17
C110 (\11\:S0 VSS) capacitor c=3.03286e-17
C111 (\8\:S0b VSS) capacitor c=8.57014e-17
C112 (\3\:VDD VSS) capacitor c=1.27817e-16
C113 (\4\:VDD VSS) capacitor c=1.20093e-16
C114 (\5\:VDD VSS) capacitor c=9.9602e-17
C115 (\6\:VDD VSS) capacitor c=6.78366e-16
Rk42 (\5\:D0 D0) resistor r=0.05403 c=0
Rk49 (\10\:S0 S0) resistor r=0.3407 c=0
Rk48 (\9\:S0 \10\:S0) resistor r=0.3756 c=0
Rk50 (S0 \11\:S0) resistor r=0.03909 c=0
Rk70 (\2\:VSS \4\:VSS) resistor r=0.4882 c=0
Rk71 (\4\:VSS \5\:VSS) resistor r=0.1829 c=0
Rk72 (\5\:VSS \6\:VSS) resistor r=0.6107 c=0
Rk73 (\6\:VSS \7\:VSS) resistor r=0.2572 c=0
Rk74 (\7\:VSS \8\:VSS) resistor r=0.3726 c=0
Rk81 (\9\:VSS VSS) resistor r=0.1024 c=0
Rk75 (\8\:VSS \9\:VSS) resistor r=0.4552 c=0
Rk82 (\5\:VSS \16\:VSS) resistor r=0.2341 c=0
Rk83 (\6\:VSS \18\:VSS) resistor r=0.04332 c=0
Rk84 (\8\:VSS \20\:VSS) resistor r=0.04332 c=0
Rk53 (\2\:VDD \3\:VDD) resistor r=0.637 c=0
Rk54 (\3\:VDD \4\:VDD) resistor r=0.5916 c=0
Rk55 (\4\:VDD \5\:VDD) resistor r=0.564 c=0
Rk61 (\6\:VDD VDD) resistor r=0.1024 c=0
Rk56 (\5\:VDD \6\:VDD) resistor r=0.4937 c=0
Rk62 (\3\:VDD \12\:VDD) resistor r=0.2268 c=0
Rk63 (\4\:VDD \14\:VDD) resistor r=0.2199 c=0
Rk64 (\5\:VDD \16\:VDD) resistor r=0.07405 c=0
Rk14 (\4\:CK CK) resistor r=0.1318 c=0
Rk47 (\4\:D1 D1) resistor r=0.0251 c=0
Rk15 (\25\:qbint \26\:qbint) resistor r=0.8718 c=0
Rk19 (\26\:qbint \31\:qbint) resistor r=0.1663 c=0
Rk23 (\11\:n30 \13\:n30) resistor r=1.2398 c=0
Rk24 (\13\:n30 \15\:n30) resistor r=0.4642 c=0
Rk28 (\12\:CKb \13\:CKb) resistor r=0.2504 c=0
Rk29 (\13\:CKb \14\:CKb) resistor r=0.687 c=0
Rk30 (\14\:CKb \16\:CKb) resistor r=0.637 c=0
Rk31 (\13\:CKb \17\:CKb) resistor r=0.7147 c=0
Rk32 (\16\:CKb \19\:CKb) resistor r=0.5734 c=0
Rk25 (\5\:mout \6\:mout) resistor r=0.2281 c=0
Rk26 (\6\:mout \8\:mout) resistor r=0.193 c=0
Rk27 (\6\:mout \10\:mout) resistor r=0.2421 c=0
Rk36 (\10\:CKbb \11\:CKbb) resistor r=0.3958 c=0
Rk37 (\11\:CKbb \12\:CKbb) resistor r=0.2849 c=0
Rk38 (\12\:CKbb \13\:CKbb) resistor r=0.8474 c=0
Rk39 (\11\:CKbb \14\:CKbb) resistor r=0.3429 c=0
Rk40 (\14\:CKbb \16\:CKbb) resistor r=0.6275 c=0
Rk41 (\12\:CKbb \17\:CKbb) resistor r=0.2249 c=0
Rk33 (\5\:n20 \6\:n20) resistor r=0.1647 c=0
Rk34 (\6\:n20 \7\:n20) resistor r=0.3859 c=0
Rk35 (\6\:n20 \9\:n20) resistor r=0.3046 c=0
Rk43 (\2\:D0b \3\:D0b) resistor r=0.6476 c=0
Rk44 (\3\:D0b \5\:D0b) resistor r=0.4237 c=0
Rk45 (\5\:D0b \7\:D0b) resistor r=0.4045 c=0
Rk46 (\3\:D0b \9\:D0b) resistor r=0.2015 c=0
Rk51 (\5\:S0b \7\:S0b) resistor r=0.7143 c=0
Rk52 (\7\:S0b \8\:S0b) resistor r=0.5705 c=0
Rl54 (\2\:D0 \4\:D0) resistor r=58.495 c=0
Rl52 (\1\:D0 \2\:D0) resistor r=109.984 c=0
Rl53 (\2\:D0 \3\:D0) resistor r=9.6183 c=0
Rl58 (\3\:S0 \4\:S0) resistor r=24.2328 c=0
Rl55 (\1\:S0 \2\:S0) resistor r=36.4253 c=0
Rl63 (\6\:S0 \8\:S0) resistor r=121.957 c=0
Rl62 (\6\:S0 \7\:S0) resistor r=46.9565 c=0
Rl61 (\5\:S0 \6\:S0) resistor r=13.569 c=0
Rl30 (\1\:CK \2\:CK) resistor r=96.1538 c=0
Rl31 (\2\:CK \3\:CK) resistor r=29.9451 c=0
Rl59 (\1\:D1 \2\:D1) resistor r=55.0021 c=0
Rl60 (\2\:D1 \3\:D1) resistor r=85.7713 c=0
Rl32 (\23\:qbint \22\:qbint) resistor r=65.3618 c=0
Rl33 (\23\:qbint \24\:qbint) resistor r=80.5643 c=0
Rl49 (\8\:CKb \9\:CKb) resistor r=24.2328 c=0
Rl35 (\3\:CKb \4\:CKb) resistor r=35.7713 c=0
Rl34 (CKb \2\:CKb) resistor r=33.3841 c=0
Rl50 (\6\:CKb \10\:CKb) resistor r=193.478 c=0
Rl46 (\5\:CKb \6\:CKb) resistor r=61.5164 c=0
Rl48 (\7\:CKb \8\:CKb) resistor r=139.928 c=0
Rl51 (\7\:CKb \11\:CKb) resistor r=41.9892 c=0
Rl47 (\6\:CKb \7\:CKb) resistor r=185.006 c=0
Rl41 (mout \2\:mout) resistor r=102.726 c=0
Rl43 (\2\:mout \4\:mout) resistor r=37.3411 c=0
Rl42 (\2\:mout \3\:mout) resistor r=3.7301 c=0
Rl45 (\7\:CKbb \8\:CKbb) resistor r=30.0021 c=0
Rl44 (\5\:CKbb \6\:CKbb) resistor r=37.2302 c=0
Rl37 (\2\:CKbb \3\:CKbb) resistor r=138.005 c=0
Rl36 (CKbb \2\:CKbb) resistor r=32.3738 c=0
Rl38 (\2\:CKbb \4\:CKbb) resistor r=92.233 c=0
Rl39 (n20 \2\:n20) resistor r=29.5379 c=0
Rl40 (\2\:n20 \3\:n20) resistor r=94.9225 c=0
Rl56 (S0b \2\:S0b) resistor r=24.2328 c=0
Rl57 (\2\:S0b \3\:S0b) resistor r=121.943 c=0
Rz15 (\2\:VSS \1\:VSS) resistor r=75 c=0
Rz16 (\16\:VSS \15\:VSS) resistor r=75 c=0
Rz17 (\18\:VSS \17\:VSS) resistor r=75 c=0
Rz18 (\20\:VSS \19\:VSS) resistor r=75 c=0
Rz7 (\13\:n30 \12\:n30) resistor r=75 c=0
Rz9 (\15\:CKb \16\:CKb) resistor r=75 c=0
Rz8 (\7\:mout \8\:mout) resistor r=75 c=0
Rz11 (\9\:CKbb \10\:CKbb) resistor r=75 c=0
Rz10 (\8\:n20 \9\:n20) resistor r=75 c=0
Rz12 (D0b \2\:D0b) resistor r=75 c=0
Rz13 (\6\:D0b \7\:D0b) resistor r=75 c=0
Rz14 (\4\:S0b \5\:S0b) resistor r=75 c=0
Ry24 (\4\:VSS \3\:VSS) resistor r=6.8889 c=0
Ry25 (\7\:VSS \3\:VSS) resistor r=5.1667 c=0
Ry26 (\9\:VSS \3\:VSS) resistor r=5.1667 c=0
Ry15 (\2\:VDD \1\:VDD) resistor r=62 c=0
Ry16 (\12\:VDD \11\:VDD) resistor r=62 c=0
Ry17 (\14\:VDD \13\:VDD) resistor r=62 c=0
Ry18 (\16\:VDD \15\:VDD) resistor r=62 c=0
Ry7 (\15\:n30 \14\:n30) resistor r=62 c=0
Ry9 (\18\:CKb \19\:CKb) resistor r=62 c=0
Ry8 (\9\:mout \10\:mout) resistor r=62 c=0
Ry11 (\15\:CKbb \16\:CKbb) resistor r=62 c=0
Ry10 (\4\:n20 \5\:n20) resistor r=31 c=0
Ry12 (\4\:D0b \5\:D0b) resistor r=62 c=0
Ry13 (\8\:D0b \9\:D0b) resistor r=31 c=0
Ry14 (\6\:S0b \7\:S0b) resistor r=62 c=0
Rx13 (\3\:D0 \5\:D0) resistor r=45 c=0
Rx15 (\1\:S0 \9\:S0) resistor r=45 c=0
Rx16 (\4\:S0 \10\:S0) resistor r=45 c=0
Rx17 (\5\:S0 \11\:S0) resistor r=45 c=0
Rx1 (\2\:CK \4\:CK) resistor r=45 c=0
Rx14 (\2\:D1 \4\:D1) resistor r=45 c=0
Rx2 (\25\:qbint \23\:qbint) resistor r=45 c=0
Rx3 (\31\:qbint qbint) resistor r=45 c=0
Rx4 (\11\:n30 n30) resistor r=45 c=0
Rx6 (\4\:CKb \12\:CKb) resistor r=45 c=0
Rx7 (\2\:CKb \14\:CKb) resistor r=45 c=0
Rx8 (\9\:CKb \17\:CKb) resistor r=45 c=0
Rx5 (\3\:mout \5\:mout) resistor r=45 c=0
Rx10 (\4\:CKbb \13\:CKbb) resistor r=45 c=0
Rx11 (\8\:CKbb \14\:CKbb) resistor r=45 c=0
Rx12 (\6\:CKbb \17\:CKbb) resistor r=45 c=0
Rx9 (\2\:n20 \7\:n20) resistor r=45 c=0
Rx18 (\2\:S0b \8\:S0b) resistor r=45 c=0
mn55_1__rcx (Q qbint \9\:VSS VSS) g45n1svt w=(2.95e-07) l=4.5e-08 nf=1 \
        as=4.69e-14 ad=4.636e-14 ps=9.1e-07 pd=9.0429e-07 nrd=1.16667 \
        nrs=1.16667 sa=1.4e-07 sb=1.92051e-06 sd=160n sca=16.4223 \
        scb=0.0158966 scc=0.0014413 m=(7)
mn11 (n10 \1\:D0 \15\:VSS VSS) g45n1svt w=(2.6e-07) l=4.5e-08 nf=1 \
        as=4.365e-14 ad=4.94e-14 ps=9e-07 pd=9e-07 nrd=1.16667 nrs=1.16667 \
        sa=2.71058e-07 sb=7.98365e-07 sd=160n sca=10.79 scb=0.0100512 \
        scc=0.000418069 m=(1)
mn12 (D0b \3\:S0b n10 VSS) g45n1svt w=(2.6e-07) l=4.5e-08 nf=1 \
        as=4.94e-14 ad=4.16e-14 ps=9e-07 pd=8.4e-07 nrd=1.16667 \
        nrs=1.16667 sa=5.06058e-07 sb=5.63365e-07 sd=160n sca=10.79 \
        scb=0.0100512 scc=0.000418069 m=(1)
mn14 (D0b \3\:S0 n12 VSS) g45n1svt w=(2.6e-07) l=4.5e-08 nf=1 as=1.56e-14 \
        ad=4.16e-14 ps=6.4e-07 pd=8.4e-07 nrd=1.16667 nrs=1.16667 \
        sa=7.11058e-07 sb=3.58365e-07 sd=160n sca=10.79 scb=0.0100512 \
        scc=0.000418069 m=(1)
mn13 (n12 \3\:D1 \1\:VSS VSS) g45n1svt w=(2.6e-07) l=4.5e-08 nf=1 \
        as=3.905e-14 ad=1.56e-14 ps=9e-07 pd=6.4e-07 nrd=1.16667 \
        nrs=1.16667 sa=8.16058e-07 sb=2.53365e-07 sd=160n sca=10.79 \
        scb=0.0100512 scc=0.000418069 m=(1)
mn45_1__rcx (\26\:qbint n30 \9\:VSS VSS) g45n1svt w=(2.6e-07) l=4.5e-08 \
        nf=1 as=4.797e-14 ad=4.723e-14 ps=9.0333e-07 pd=8.8333e-07 \
        nrd=1.16667 nrs=1.16667 sa=1.575e-06 sb=6.65e-07 sd=160n \
        sca=13.9783 scb=0.013979 scc=0.000942864 m=(3)
mn20 (\15\:CKb \3\:CK \19\:VSS VSS) g45n1svt w=(1.45e-07) l=4.5e-08 nf=1 \
        as=7.33e-14 ad=4.132e-14 ps=1.37e-06 pd=8.6e-07 nrd=1.16667 \
        nrs=1.16667 sa=2.85e-07 sb=2e-06 sd=160n sca=11.4452 scb=0.0112553 \
        scc=0.00042156 m=(1)
mn21 (\9\:CKbb \5\:CKb \15\:VSS VSS) g45n1svt w=(1.45e-07) l=4.5e-08 \
        nf=1 as=4.365e-14 ad=2.03e-14 ps=9e-07 pd=5.7e-07 nrd=1.16667 \
        nrs=1.16667 sa=1.4e-07 sb=1.10759e-06 sd=160n sca=13.253 \
        scb=0.0137915 scc=0.000695334 m=(1)
mn10 (\4\:S0b \7\:S0 \1\:VSS VSS) g45n1svt w=(1.45e-07) l=4.5e-08 nf=1 \
        as=3.905e-14 ad=2.03e-14 ps=9e-07 pd=5.7e-07 nrd=1.16667 \
        nrs=1.16667 sa=1.11448e-06 sb=1.4e-07 sd=160n sca=11.7118 \
        scb=0.0116498 scc=0.000458536 m=(1)
mn50 (n35 \24\:qbint \19\:VSS VSS) g45n1svt w=(2.05e-07) l=4.5e-08 nf=1 \
        as=7.33e-14 ad=2.357e-14 ps=1.37e-06 pd=6.4e-07 nrd=1.16667 \
        nrs=1.16667 sa=4.3878e-07 sb=1.95e-06 sd=160n sca=10.3195 \
        scb=0.00946099 scc=0.0003152 m=(1)
mn51 (\12\:n30 CKb n35 VSS) g45n1svt w=(2.05e-07) l=4.5e-08 nf=1 \
        as=2.357e-14 ad=3.895e-14 ps=6.4e-07 pd=7.9e-07 nrd=1.16667 \
        nrs=1.16667 sa=5.9878e-07 sb=1.79e-06 sd=160n sca=10.3195 \
        scb=0.00946099 scc=0.0003152 m=(1)
mn40 (\7\:mout CKbb \12\:n30 VSS) g45n1svt w=(2.05e-07) l=4.5e-08 nf=1 \
        as=3.895e-14 ad=1.1377e-13 ps=7.9e-07 pd=1.52e-06 nrd=1.16667 \
        nrs=1.16667 sa=8.3378e-07 sb=1.555e-06 sd=160n sca=10.3195 \
        scb=0.00946099 scc=0.0003152 m=(1)
mn30 (\7\:mout \3\:n20 \17\:VSS VSS) g45n1svt w=(2.05e-07) l=4.5e-08 \
        nf=1 as=7.63e-14 ad=1.1377e-13 ps=1.37e-06 pd=1.52e-06 nrd=1.16667 \
        nrs=1.16667 sa=1.43378e-06 sb=9.55e-07 sd=160n sca=10.3195 \
        scb=0.00946099 scc=0.0003152 m=(1)
mn35 (n25 \4\:mout \17\:VSS VSS) g45n1svt w=(2.05e-07) l=4.5e-08 nf=1 \
        as=7.63e-14 ad=1.23e-14 ps=1.37e-06 pd=5.3e-07 nrd=1.16667 \
        nrs=1.16667 sa=1.69878e-06 sb=6.9e-07 sd=160n sca=10.3195 \
        scb=0.00946099 scc=0.0003152 m=(1)
mn36 (\8\:n20 \5\:CKbb n25 VSS) g45n1svt w=(2.05e-07) l=4.5e-08 nf=1 \
        as=1.23e-14 ad=4.612e-14 ps=5.3e-07 pd=8.6e-07 nrd=1.16667 \
        nrs=1.16667 sa=1.80378e-06 sb=5.85e-07 sd=160n sca=10.3195 \
        scb=0.00946099 scc=0.0003152 m=(1)
mn25 (\6\:D0b \11\:CKb \8\:n20 VSS) g45n1svt w=(2.05e-07) l=4.5e-08 nf=1 \
        as=4.613e-14 ad=6.458e-14 ps=8.6e-07 pd=1.04e-06 nrd=1.16667 \
        nrs=1.16667 sa=1.94293e-06 sb=3.15e-07 sd=160n sca=10.3195 \
        scb=0.00946099 scc=0.0003152 m=(1)
mp11 (n11 \4\:D0 \11\:VDD NW) g45p1svt w=(3.9e-07) l=4.5e-08 nf=1 \
        as=5.19e-14 ad=2.34e-14 ps=1.1e-06 pd=9e-07 nrd=1.16667 \
        nrs=1.16667 sa=2.25321e-07 sb=8.84551e-07 sd=160n sca=13.5671 \
        scb=0.012183 scc=0.000647513 m=(1)
mp12 (\8\:D0b \2\:S0 n11 NW) g45p1svt w=(3.9e-07) l=4.5e-08 nf=1 \
        as=2.34e-14 ad=7.02e-14 ps=9e-07 pd=1.14e-06 nrd=1.16667 \
        nrs=1.16667 sa=3.30321e-07 sb=7.79551e-07 sd=160n sca=13.5671 \
        scb=0.012183 scc=0.000647513 m=(1)
mp14 (\8\:D0b S0b n13 NW) g45p1svt w=(3.9e-07) l=4.5e-08 nf=1 as=9.36e-14 \
        ad=7.02e-14 ps=1.26e-06 pd=1.14e-06 nrd=1.16667 nrs=1.16667 \
        sa=5.55321e-07 sb=5.54551e-07 sd=160n sca=13.6902 scb=0.0122097 \
        scc=0.000647516 m=(1)
mp13 (n13 \1\:D1 \1\:VDD NW) g45p1svt w=(3.9e-07) l=4.5e-08 nf=1 \
        as=6.535e-14 ad=9.36e-14 ps=1.16e-06 pd=1.26e-06 nrd=1.16667 \
        nrs=1.16667 sa=8.40321e-07 sb=2.69551e-07 sd=160n sca=14.7912 \
        scb=0.012924 scc=0.00064842 m=(1)
mp45_1__rcx (\26\:qbint n30 \6\:VDD NW) g45p1svt w=(3.9e-07) l=4.5e-08 \
        nf=1 as=6.887e-14 ad=5.98e-14 ps=1.15667e-06 pd=1.08667e-06 \
        nrd=1.16667 nrs=1.16667 sa=1.605e-06 sb=5.5e-07 sd=160n \
        sca=18.3796 scb=0.0159892 scc=0.00159615 m=(3)
mp20 (\18\:CKb \1\:CK \15\:VDD NW) g45p1svt w=(2.15e-07) l=4.5e-08 nf=1 \
        as=1.204e-13 ad=3.01e-14 ps=1.93e-06 pd=7.1e-07 nrd=1.16667 \
        nrs=1.16667 sa=1.4e-07 sb=1.99814e-06 sd=160n sca=29.9075 \
        scb=0.0247057 scc=0.00372713 m=(1)
mp21 (\15\:CKbb \10\:CKb \11\:VDD NW) g45p1svt w=(2.15e-07) l=4.5e-08 \
        nf=1 as=5.19e-14 ad=2.63e-14 ps=1.1e-06 pd=7.1e-07 nrd=1.16667 \
        nrs=1.16667 sa=1.22326e-07 sb=1.00372e-06 sd=160n sca=10.2104 \
        scb=0.00747301 scc=8.05149e-05 m=(1)
mp10 (\6\:S0b \8\:S0 \1\:VDD NW) g45p1svt w=(2.15e-07) l=4.5e-08 nf=1 \
        as=6.535e-14 ad=3.01e-14 ps=1.16e-06 pd=7.1e-07 nrd=1.16667 \
        nrs=1.16667 sa=9.8814e-07 sb=1.4e-07 sd=160n sca=20.6301 \
        scb=0.0216347 scc=0.00118997 m=(1)
mp50 (n36 \22\:qbint \15\:VDD NW) g45p1svt w=(3.1e-07) l=4.5e-08 nf=1 \
        as=1.204e-13 ad=3.1e-14 ps=1.93e-06 pd=8.2e-07 nrd=1.16667 \
        nrs=1.16667 sa=3.67661e-07 sb=1.75185e-06 sd=160n sca=24.2842 \
        scb=0.0202139 scc=0.00265344 m=(1)
mp51 (\14\:n30 \3\:CKbb n36 NW) g45p1svt w=(3.1e-07) l=4.5e-08 nf=1 \
        as=3.1e-14 ad=6.975e-14 ps=8.2e-07 pd=1.07e-06 nrd=1.16667 \
        nrs=1.16667 sa=5.12661e-07 sb=1.60685e-06 sd=160n sca=24.2842 \
        scb=0.0202139 scc=0.00265344 m=(1)
mp40 (\14\:n30 \3\:CKb \9\:mout NW) g45p1svt w=(3.1e-07) l=4.5e-08 nf=1 \
        as=1.333e-13 ad=6.975e-14 ps=1.48e-06 pd=1.07e-06 nrd=1.16667 \
        nrs=1.16667 sa=7.82661e-07 sb=1.33685e-06 sd=160n sca=24.2842 \
        scb=0.0202139 scc=0.00265344 m=(1)
mp30 (\9\:mout n20 \13\:VDD NW) g45p1svt w=(3.1e-07) l=4.5e-08 nf=1 \
        as=8.74e-14 ad=1.333e-13 ps=1.38e-06 pd=1.48e-06 nrd=1.16667 \
        nrs=1.16667 sa=1.25766e-06 sb=8.61855e-07 sd=160n sca=24.2842 \
        scb=0.0202139 scc=0.00265344 m=(1)
mp35 (n26 mout \13\:VDD NW) g45p1svt w=(3.1e-07) l=4.5e-08 nf=1 \
        as=8.74e-14 ad=4.805e-14 ps=1.38e-06 pd=9.3e-07 nrd=1.16667 \
        nrs=1.16667 sa=1.52266e-06 sb=5.96855e-07 sd=160n sca=24.2842 \
        scb=0.0202139 scc=0.00265344 m=(1)
mp36 (\4\:n20 \8\:CKb n26 NW) g45p1svt w=(3.1e-07) l=4.5e-08 nf=1 \
        as=4.805e-14 ad=5.58e-14 ps=9.3e-07 pd=9.8e-07 nrd=1.16667 \
        nrs=1.16667 sa=1.72266e-06 sb=3.96855e-07 sd=160n sca=24.2842 \
        scb=0.0202139 scc=0.00265344 m=(1)
mp25 (\4\:n20 \7\:CKbb \4\:D0b NW) g45p1svt w=(3.1e-07) l=4.5e-08 nf=1 \
        as=5.328e-14 ad=5.58e-14 ps=1.15e-06 pd=9.8e-07 nrd=1.16667 \
        nrs=1.16667 sa=1.92339e-06 sb=1.71855e-07 sd=160n sca=24.2842 \
        scb=0.0202139 scc=0.00265344 m=(1)
ends MDFFHQX8
// End of subcircuit definition.
