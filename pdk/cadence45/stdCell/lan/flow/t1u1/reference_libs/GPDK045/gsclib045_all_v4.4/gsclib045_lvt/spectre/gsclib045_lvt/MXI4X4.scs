// gsclib045_lvt/MXI4X4/schematic

simulator lang=spectre

subckt MXI4X4 A B C D S0 S1 Y VDD VSS
mp9 (n1 S0b net320 VDD) g45p1lvt w=(215n) l=45n nf=1 m=(1)
mp8 (net320 D VDD VDD) g45p1lvt w=(215n) l=45n nf=1 m=(1)
mp7 (n1 S0 net312 VDD) g45p1lvt w=(215n) l=45n nf=1 m=(1)
mp6 (net312 C VDD VDD) g45p1lvt w=(215n) l=45n nf=1 m=(1)
mp5 (n0 S0b net304 VDD) g45p1lvt w=(215n) l=45n nf=1 m=(1)
mp4 (net304 B VDD VDD) g45p1lvt w=(215n) l=45n nf=1 m=(1)
mp3 (n0 S0 net296 VDD) g45p1lvt w=(215n) l=45n nf=1 m=(1)
mp2 (net296 A VDD VDD) g45p1lvt w=(215n) l=45n nf=1 m=(1)
mp12 (net284 n1 VDD VDD) g45p1lvt w=(310n) l=45n nf=1 m=(1)
mp13 (n2 S1b net284 VDD) g45p1lvt w=(310n) l=45n nf=1 m=(1)
mp11 (n2 S1 net280 VDD) g45p1lvt w=(310n) l=45n nf=1 m=(1)
mp10 (net280 n0 VDD VDD) g45p1lvt w=(310n) l=45n nf=1 m=(1)
mp0 (S0b S0 VDD VDD) g45p1lvt w=(215n) l=45n nf=1 m=(1)
mp14 (Y n2 VDD VDD) g45p1lvt w=(1.56u) l=45n nf=1 m=(1)
mp1 (S1b S1 VDD VDD) g45p1lvt w=(215n) l=45n nf=1 m=(1)
mn8 (net377 D VSS VSS) g45n1lvt w=(145n) l=45n nf=1 m=(1)
mn9 (n1 S0 net377 VSS) g45n1lvt w=(145n) l=45n nf=1 m=(1)
mn6 (net369 C VSS VSS) g45n1lvt w=(145n) l=45n nf=1 m=(1)
mn7 (n1 S0b net369 VSS) g45n1lvt w=(145n) l=45n nf=1 m=(1)
mn4 (net361 B VSS VSS) g45n1lvt w=(145n) l=45n nf=1 m=(1)
mn5 (n0 S0 net361 VSS) g45n1lvt w=(145n) l=45n nf=1 m=(1)
mn3 (n0 S0b net349 VSS) g45n1lvt w=(145n) l=45n nf=1 m=(1)
mn2 (net349 A VSS VSS) g45n1lvt w=(145n) l=45n nf=1 m=(1)
mn12 (net345 n1 VSS VSS) g45n1lvt w=(205n) l=45n nf=1 m=(1)
mn13 (n2 S1 net345 VSS) g45n1lvt w=(205n) l=45n nf=1 m=(1)
mn11 (n2 S1b net329 VSS) g45n1lvt w=(205n) l=45n nf=1 m=(1)
mn1 (S1b S1 VSS VSS) g45n1lvt w=(145n) l=45n nf=1 m=(1)
mn10 (net329 n0 VSS VSS) g45n1lvt w=(205n) l=45n nf=1 m=(1)
mn14 (Y n2 VSS VSS) g45n1lvt w=(1.04u) l=45n nf=1 m=(1)
mn0 (S0b S0 VSS VSS) g45n1lvt w=(145n) l=45n nf=1 m=(1)
ends MXI4X4
