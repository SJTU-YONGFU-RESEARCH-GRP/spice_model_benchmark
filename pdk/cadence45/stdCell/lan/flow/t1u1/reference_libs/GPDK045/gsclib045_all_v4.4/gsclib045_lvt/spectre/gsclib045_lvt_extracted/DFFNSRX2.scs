// Generated for: spectre (May  1 09:13:34 2013 )
// Library name: gsclib045_lvt
// Cell name: DFFNSRX2
// View name: extracted

simulator lang=spectre

subckt DFFNSRX2 CKN D Q QN RN SN VDD VSS
mp20 (\21\:CKNb \3\:CKN \29\:VDD VDD) g45p1lvt w=(2.15e-07) l=4.5e-08 \
        nf=1 as=4.623e-14 ad=3.762e-14 ps=8.6e-07 pd=7.8e-07 nrd=1.16667 \
        nrs=1.16667 sa=1.75e-07 sb=7.91512e-07 sd=160n sca=17.7347 \
        scb=0.018547 scc=0.000439635 m=(1)
mp25 (n22 \1\:D \29\:VDD VDD) g45p1lvt w=(2.15e-07) l=4.5e-08 nf=1 \
        as=4.623e-14 ad=1.29e-14 ps=8.6e-07 pd=5.5e-07 nrd=1.16667 \
        nrs=1.16667 sa=4.35e-07 sb=5.31512e-07 sd=160n sca=12.132 \
        scb=0.00915419 scc=0.000101757 m=(1)
mp26 (\5\:n20 CKNb n22 VDD) g45p1lvt w=(2.15e-07) l=4.5e-08 nf=1 \
        as=1.29e-14 ad=5.56e-14 ps=5.5e-07 pd=1.23e-06 nrd=1.16667 \
        nrs=1.16667 sa=5.4e-07 sb=4.26512e-07 sd=160n sca=11.3905 \
        scb=0.00832609 scc=9.89279e-05 m=(1)
mp36 (\5\:n20 CKNbb n31 VDD) g45p1lvt w=(2.15e-07) l=4.5e-08 nf=1 \
        as=4.085e-14 ad=5.56e-14 ps=8.1e-07 pd=1.23e-06 nrd=1.16667 \
        nrs=1.16667 sa=5.4093e-07 sb=3.35e-07 sd=160n sca=10.3756 \
        scb=0.00778655 scc=9.84544e-05 m=(1)
mp35 (n31 mout \27\:VDD VDD) g45p1lvt w=(2.15e-07) l=4.5e-08 nf=1 \
        as=6.64e-14 ad=4.085e-14 ps=1.9e-06 pd=8.1e-07 nrd=1.16667 \
        nrs=1.16667 sa=7.7593e-07 sb=1e-07 sd=160n sca=10.3756 \
        scb=0.00778655 scc=9.84544e-05 m=(1)
mp21 (\8\:CKNbb \5\:CKNb \27\:VDD VDD) g45p1lvt w=(2.15e-07) l=4.5e-08 \
        nf=1 as=6.64e-14 ad=2.63e-14 ps=1.9e-06 pd=7.1e-07 nrd=1.16667 \
        nrs=1.16667 sa=1e-07 sb=1.22326e-07 sd=160n sca=45.7906 \
        scb=0.0283307 scc=0.00588417 m=(1)
mp31 (n26 RNb \25\:VDD VDD) g45p1lvt w=(2.15e-07) l=4.5e-08 nf=1 \
        as=6.14e-14 ad=1.29e-14 ps=2.03e-06 pd=5.5e-07 nrd=1.16667 \
        nrs=1.16667 sa=1.26744e-07 sb=1.335e-06 sd=160n sca=45.7906 \
        scb=0.0283307 scc=0.00588417 m=(1)
mp32 (\8\:mout \2\:n20 n26 VDD) g45p1lvt w=(2.15e-07) l=4.5e-08 nf=1 \
        as=1.29e-14 ad=9.352e-14 ps=5.5e-07 pd=1.3e-06 nrd=1.16667 \
        nrs=1.16667 sa=2.31744e-07 sb=1.23e-06 sd=160n sca=45.7906 \
        scb=0.0283307 scc=0.00588417 m=(1)
mp30 (\8\:mout \5\:SN \23\:VDD VDD) g45p1lvt w=(2.15e-07) l=4.5e-08 nf=1 \
        as=1.0787e-13 ad=9.352e-14 ps=2.33e-06 pd=1.3e-06 nrd=1.16667 \
        nrs=1.16667 sa=7.11744e-07 sb=7.5e-07 sd=160n sca=45.7906 \
        scb=0.0283307 scc=0.00588417 m=(1)
mp22 (\11\:RNb \1\:RN \23\:VDD VDD) g45p1lvt w=(2.15e-07) l=4.5e-08 nf=1 \
        as=1.0787e-13 ad=8.385e-14 ps=2.33e-06 pd=1.21e-06 nrd=1.16667 \
        nrs=1.16667 sa=1.07174e-06 sb=3.9e-07 sd=160n sca=45.7906 \
        scb=0.0283307 scc=0.00588417 m=(1)
mp40 (\8\:n35 \5\:CKNbb \4\:mout VDD) g45p1lvt w=(2.15e-07) l=4.5e-08 \
        nf=1 as=5.16e-14 ad=3.762e-14 ps=9.1e-07 pd=7.8e-07 nrd=1.16667 \
        nrs=1.16667 sa=2.4e-07 sb=3.6e-07 sd=160n sca=16.925 scb=0.0168124 \
        scc=0.00121732 m=(1)
mp53 (\3\:n41 \12\:CKNb \8\:n35 VDD) g45p1lvt w=(2.15e-07) l=4.5e-08 nf=1 \
        as=3.762e-14 ad=3.01e-14 ps=7.8e-07 pd=7.1e-07 nrd=1.16667 \
        nrs=1.16667 sa=4.6e-07 sb=1.4e-07 sd=160n sca=16.925 scb=0.0168124 \
        scc=0.00121732 m=(1)
mp50 (n41 \1\:SN \21\:VDD VDD) g45p1lvt w=(2.15e-07) l=4.5e-08 nf=1 \
        as=3.01e-14 ad=3.82e-14 ps=7.1e-07 pd=9.4e-07 nrd=1.16667 \
        nrs=1.16667 sa=1.4e-07 sb=2.95349e-07 sd=160n sca=10.8061 \
        scb=0.00857865 scc=0.000148871 m=(1)
mp52 (n41 \2\:qbint n43 VDD) g45p1lvt w=(2.15e-07) l=4.5e-08 nf=1 \
        as=1.29e-14 ad=3.82e-14 ps=5.5e-07 pd=9.4e-07 nrd=1.16667 \
        nrs=1.16667 sa=2.36744e-07 sb=2.45e-07 sd=160n sca=14.2498 \
        scb=0.0138057 scc=0.00069487 m=(1)
mp51 (n43 \6\:RNb \19\:VDD VDD) g45p1lvt w=(2.15e-07) l=4.5e-08 nf=1 \
        as=3.01e-14 ad=1.29e-14 ps=7.1e-07 pd=5.5e-07 nrd=1.16667 \
        nrs=1.16667 sa=3.41744e-07 sb=1.4e-07 sd=160n sca=14.2498 \
        scb=0.0138057 scc=0.00069487 m=(1)
mp56 (\8\:qint \10\:qbint \1\:VDD VDD) g45p1lvt w=(2.15e-07) l=4.5e-08 \
        nf=1 as=7.265e-14 ad=3.01e-14 ps=1.8e-06 pd=7.1e-07 nrd=1.16667 \
        nrs=1.16667 sa=1.39791e-06 sb=1.4e-07 sd=160n sca=38.5216 \
        scb=0.0409143 scc=0.00421269 m=(1)
C1 (RN VSS) capacitor c=5.53921e-17
C2 (SN VSS) capacitor c=6.58946e-17
C3 (Q VSS) capacitor c=8.03058e-17
C4 (D VSS) capacitor c=1.30294e-16
C5 (VDD VSS) capacitor c=5.06068e-16
C6 (CKNb VSS) capacitor c=5.84931e-17
C7 (n21 VSS) capacitor c=1.43231e-18
C8 (n20 VSS) capacitor c=7.29424e-17
C9 (CKNbb VSS) capacitor c=3.85365e-17
C10 (n30 VSS) capacitor c=3.43925e-19
C11 (mout VSS) capacitor c=8.14009e-17
C12 (RNb VSS) capacitor c=9.15604e-17
C13 (n25 VSS) capacitor c=8.04936e-17
C14 (n35 VSS) capacitor c=4.64585e-17
C15 (n40 VSS) capacitor c=1.4395e-16
C16 (n42 VSS) capacitor c=7.18668e-17
C17 (qbint VSS) capacitor c=3.90678e-17
C18 (qint VSS) capacitor c=1.70267e-16
C19 (n31 VSS) capacitor c=5.58581e-18
C20 (n26 VSS) capacitor c=8.08912e-19
C21 (n41 VSS) capacitor c=9.89377e-17
C22 (n43 VSS) capacitor c=6.39224e-19
C23 (\10\:qbint VSS) capacitor c=3.21071e-17
C24 (\4\:qbint VSS) capacitor c=4.27602e-16
C25 (\3\:n35 VSS) capacitor c=3.95971e-17
C26 (\6\:RNb VSS) capacitor c=7.55507e-17
C27 (\2\:qbint VSS) capacitor c=1.06539e-16
C28 (\1\:SN VSS) capacitor c=7.33641e-17
C29 (\12\:CKNb VSS) capacitor c=5.16436e-17
C30 (\5\:CKNbb VSS) capacitor c=6.91466e-17
C31 (\1\:RN VSS) capacitor c=3.22101e-17
C32 (\5\:SN VSS) capacitor c=3.55731e-17
C33 (\2\:n20 VSS) capacitor c=7.47943e-17
C34 (\5\:CKNb VSS) capacitor c=4.41467e-17
C35 (\1\:D VSS) capacitor c=6.09618e-17
C36 (\3\:CKN VSS) capacitor c=3.97429e-17
C37 (\12\:qbint VSS) capacitor c=3.85797e-17
C38 (\4\:RNb VSS) capacitor c=3.62288e-17
C39 (\3\:qbint VSS) capacitor c=7.18306e-17
C40 (\2\:SN VSS) capacitor c=1.39318e-16
C41 (\4\:CKNbb VSS) capacitor c=6.41462e-17
C42 (\10\:CKNb VSS) capacitor c=4.83774e-17
C43 (\3\:RN VSS) capacitor c=4.22415e-17
C44 (\3\:SN VSS) capacitor c=1.23752e-16
C45 (\2\:RNb VSS) capacitor c=6.33633e-17
C46 (\8\:CKNb VSS) capacitor c=3.42316e-17
C47 (\2\:mout VSS) capacitor c=6.76619e-17
C48 (\3\:CKNb VSS) capacitor c=3.95232e-17
C49 (\3\:CKNbb VSS) capacitor c=6.36444e-17
C50 (\3\:D VSS) capacitor c=5.67103e-17
C51 (\1\:CKN VSS) capacitor c=3.82514e-17
C52 (\11\:qbint VSS) capacitor c=4.52827e-17
C53 (\2\:n35 VSS) capacitor c=3.03916e-17
C54 (\5\:RNb VSS) capacitor c=5.74835e-17
C55 (\13\:CKNb VSS) capacitor c=2.45863e-17
C56 (\6\:CKNbb VSS) capacitor c=2.82333e-17
C57 (\11\:CKNb VSS) capacitor c=3.78582e-17
C58 (\2\:RN VSS) capacitor c=2.48899e-17
C59 (\4\:SN VSS) capacitor c=2.70435e-17
C60 (\3\:RNb VSS) capacitor c=5.08577e-17
C61 (\3\:n20 VSS) capacitor c=3.5697e-17
C62 (\9\:CKNb VSS) capacitor c=3.42444e-17
C63 (\7\:CKNb VSS) capacitor c=3.56247e-17
C64 (\3\:mout VSS) capacitor c=2.36312e-17
C65 (\2\:CKNbb VSS) capacitor c=7.13222e-17
C66 (\4\:CKNb VSS) capacitor c=4.3236e-17
C67 (\2\:CKNb VSS) capacitor c=4.78174e-17
C68 (\2\:D VSS) capacitor c=6.5676e-17
C69 (\2\:CKN VSS) capacitor c=4.88122e-17
C70 (\8\:qint VSS) capacitor c=3.91601e-17
C71 (\1\:VDD VSS) capacitor c=1.29353e-16
C72 (\3\:QN VSS) capacitor c=7.84875e-17
C73 (\1\:Q VSS) capacitor c=8.43872e-18
C74 (\16\:qbint VSS) capacitor c=5.81988e-17
C75 (\19\:VDD VSS) capacitor c=6.03378e-17
C76 (\21\:VDD VSS) capacitor c=3.34396e-17
C77 (\3\:n41 VSS) capacitor c=7.58517e-17
C78 (\8\:n35 VSS) capacitor c=3.51489e-17
C79 (\4\:mout VSS) capacitor c=2.47702e-18
C80 (\11\:RNb VSS) capacitor c=9.69723e-17
C81 (\23\:VDD VSS) capacitor c=2.9639e-17
C82 (\8\:mout VSS) capacitor c=1.73059e-16
C83 (\25\:VDD VSS) capacitor c=1.62697e-17
C84 (\8\:CKNbb VSS) capacitor c=1.94646e-16
C85 (\27\:VDD VSS) capacitor c=1.97035e-17
C86 (\5\:n20 VSS) capacitor c=1.32534e-16
C87 (\29\:VDD VSS) capacitor c=1.97139e-17
C88 (\21\:CKNb VSS) capacitor c=6.0785e-17
C89 (\4\:VDD VSS) capacitor c=1.07637e-16
C90 (\12\:qint VSS) capacitor c=1.75358e-17
C91 (\1\:QN VSS) capacitor c=5.05913e-17
C92 (\3\:Q VSS) capacitor c=5.80888e-17
C93 (\20\:qbint VSS) capacitor c=4.19853e-17
C94 (\3\:n40 VSS) capacitor c=1.32942e-16
C95 (\3\:n42 VSS) capacitor c=1.02841e-16
C96 (\6\:n35 VSS) capacitor c=5.35916e-17
C97 (\6\:mout VSS) capacitor c=6.21026e-17
C98 (\8\:RNb VSS) capacitor c=2.20997e-16
C99 (\3\:n25 VSS) capacitor c=7.4982e-17
C100 (\11\:mout VSS) capacitor c=3.27292e-17
C101 (\11\:CKNbb VSS) capacitor c=4.4282e-17
C102 (\7\:n20 VSS) capacitor c=1.18488e-16
C103 (\18\:CKNb VSS) capacitor c=2.96637e-17
C104 (\4\:CKN VSS) capacitor c=1.27279e-16
C105 (\14\:CKNb VSS) capacitor c=4.0607e-17
C106 (\15\:CKNb VSS) capacitor c=1.14499e-16
C107 (\16\:CKNb VSS) capacitor c=1.56146e-16
C108 (\17\:CKNb VSS) capacitor c=7.00771e-17
C109 (\20\:CKNb VSS) capacitor c=7.14673e-17
C110 (\4\:n20 VSS) capacitor c=9.18974e-17
C111 (\6\:SN VSS) capacitor c=3.9775e-17
C112 (\4\:RN VSS) capacitor c=5.38759e-17
C113 (\5\:mout VSS) capacitor c=1.67888e-16
C114 (\10\:mout VSS) capacitor c=1.48497e-16
C115 (\13\:mout VSS) capacitor c=1.08118e-16
C116 (\7\:CKNbb VSS) capacitor c=2.61332e-16
C117 (\10\:CKNbb VSS) capacitor c=4.76074e-17
C118 (\13\:CKNbb VSS) capacitor c=5.6063e-17
C119 (\23\:CKNb VSS) capacitor c=8.53244e-17
C120 (\24\:CKNb VSS) capacitor c=3.08787e-16
C121 (\25\:CKNb VSS) capacitor c=2.20318e-16
C122 (\26\:CKNb VSS) capacitor c=3.29617e-17
C123 (\7\:RNb VSS) capacitor c=2.89355e-16
C124 (\10\:RNb VSS) capacitor c=9.63975e-17
C125 (\4\:n35 VSS) capacitor c=1.41738e-16
C126 (\5\:n35 VSS) capacitor c=2.0602e-16
C127 (\13\:qbint VSS) capacitor c=9.87196e-17
C128 (\22\:qbint VSS) capacitor c=4.26502e-17
C129 (\10\:qint VSS) capacitor c=3.93407e-17
C130 (\11\:qint VSS) capacitor c=6.22541e-17
C131 (\7\:VDD VSS) capacitor c=3.41021e-17
C132 (\8\:VDD VSS) capacitor c=1.60875e-17
C133 (\10\:VDD VSS) capacitor c=4.83403e-17
C134 (\11\:VDD VSS) capacitor c=2.88598e-17
C135 (\12\:VDD VSS) capacitor c=7.82666e-18
C136 (\14\:VDD VSS) capacitor c=2.45043e-17
Rk13 (RN \4\:RN) resistor r=0.03585 c=0
Rk1 (\4\:CKN CKN) resistor r=0.002711 c=0
Rk12 (SN \6\:SN) resistor r=0.1632 c=0
Rk35 (Q \2\:Q) resistor r=0.003006 c=0
Rk36 (\2\:Q \4\:Q) resistor r=0.2645 c=0
Rk2 (\4\:D D) resistor r=0.0029 c=0
Rk38 (\4\:QN QN) resistor r=0.005081 c=0
Rk37 (\2\:QN \4\:QN) resistor r=0.2978 c=0
Rk72 (\1\:VSS \7\:VSS) resistor r=0.6594 c=0
Rk73 (\7\:VSS \8\:VSS) resistor r=0.3711 c=0
Rk74 (\8\:VSS \9\:VSS) resistor r=0.4137 c=0
Rk75 (\9\:VSS \10\:VSS) resistor r=0.6785 c=0
Rk76 (\10\:VSS \11\:VSS) resistor r=0.1092 c=0
Rk78 (\12\:VSS VSS) resistor r=0.1727 c=0
Rk77 (\11\:VSS \12\:VSS) resistor r=0.3786 c=0
Rk81 (\7\:VSS \18\:VSS) resistor r=0.2722 c=0
Rk82 (\9\:VSS \20\:VSS) resistor r=0.1737 c=0
Rk83 (\10\:VSS \22\:VSS) resistor r=0.04333 c=0
Rk84 (\12\:VSS \24\:VSS) resistor r=0.2952 c=0
Rk52 (\1\:VDD \7\:VDD) resistor r=0.3759 c=0
Rk53 (\7\:VDD \8\:VDD) resistor r=0.1827 c=0
Rk54 (\8\:VDD \9\:VDD) resistor r=0.4288 c=0
Rk55 (\9\:VDD \10\:VDD) resistor r=0.5006 c=0
Rk56 (\10\:VDD \11\:VDD) resistor r=0.4226 c=0
Rk57 (\11\:VDD \12\:VDD) resistor r=0.1928 c=0
Rk58 (\12\:VDD \13\:VDD) resistor r=0.0851 c=0
Rk60 (\14\:VDD VDD) resistor r=0.1451 c=0
Rk59 (\13\:VDD \14\:VDD) resistor r=0.4062 c=0
Rk63 (\7\:VDD \20\:VDD) resistor r=0.4015 c=0
Rk64 (\8\:VDD \22\:VDD) resistor r=0.2585 c=0
Rk65 (\10\:VDD \24\:VDD) resistor r=0.04333 c=0
Rk66 (\11\:VDD \26\:VDD) resistor r=0.07416 c=0
Rk67 (\12\:VDD \28\:VDD) resistor r=0.07416 c=0
Rk68 (\14\:VDD \30\:VDD) resistor r=0.1747 c=0
Rk3 (\14\:CKNb \15\:CKNb) resistor r=0.2532 c=0
Rk4 (\15\:CKNb \16\:CKNb) resistor r=0.8373 c=0
Rk5 (\16\:CKNb \17\:CKNb) resistor r=0.3708 c=0
Rk6 (\17\:CKNb \19\:CKNb) resistor r=0.1911 c=0
Rk7 (\16\:CKNb \20\:CKNb) resistor r=0.3358 c=0
Rk8 (\17\:CKNb \22\:CKNb) resistor r=0.5023 c=0
Rk23 (\23\:CKNb \24\:CKNb) resistor r=0.3797 c=0
Rk24 (\24\:CKNb \25\:CKNb) resistor r=1.8534 c=0
Rk25 (\24\:CKNb \26\:CKNb) resistor r=0.2116 c=0
Rk9 (\4\:n20 \6\:n20) resistor r=0.7465 c=0
Rk10 (\6\:n20 \8\:n20) resistor r=0.5912 c=0
Rk19 (\7\:CKNbb \9\:CKNbb) resistor r=1.8706 c=0
Rk20 (\9\:CKNbb \10\:CKNbb) resistor r=0.06271 c=0
Rk21 (\10\:CKNbb \12\:CKNbb) resistor r=0.2429 c=0
Rk22 (\10\:CKNbb \13\:CKNbb) resistor r=0.3536 c=0
Rk14 (\5\:mout \7\:mout) resistor r=0.3793 c=0
Rk15 (\5\:mout \9\:mout) resistor r=0.852 c=0
Rk16 (\9\:mout \10\:mout) resistor r=0.5887 c=0
Rk17 (\10\:mout \12\:mout) resistor r=0.09812 c=0
Rk18 (\10\:mout \13\:mout) resistor r=0.8499 c=0
Rk28 (\7\:RNb \9\:RNb) resistor r=1.8196 c=0
Rk29 (\9\:RNb \10\:RNb) resistor r=0.6065 c=0
Rk30 (\9\:RNb \12\:RNb) resistor r=0.5393 c=0
Rk11 (\2\:n25 \4\:n25) resistor r=0.4979 c=0
Rk32 (\4\:n35 \5\:n35) resistor r=1.189 c=0
Rk33 (\5\:n35 \7\:n35) resistor r=0.2576 c=0
Rk34 (\5\:n35 \9\:n35) resistor r=0.118 c=0
Rk27 (\2\:n40 \4\:n40) resistor r=0.8739 c=0
Rk31 (\2\:n42 \4\:n42) resistor r=0.3869 c=0
Rk39 (\13\:qbint \4\:qbint) resistor r=0.7617 c=0
Rk41 (\4\:qbint \17\:qbint) resistor r=0.2921 c=0
Rk44 (\4\:qbint \21\:qbint) resistor r=0.3257 c=0
Rk45 (\17\:qbint \22\:qbint) resistor r=0.343 c=0
Rk46 (\9\:qint \10\:qint) resistor r=0.2699 c=0
Rk47 (\10\:qint \11\:qint) resistor r=0.28 c=0
Rk48 (\10\:qint \13\:qint) resistor r=0.1152 c=0
Rk26 (\2\:n41 \4\:n41) resistor r=0.4249 c=0
Rl19 (\1\:RN \2\:RN) resistor r=29.5379 c=0
Rl20 (\2\:RN \3\:RN) resistor r=98.7687 c=0
Rl2 (\2\:CKN \3\:CKN) resistor r=147.253 c=0
Rl1 (\1\:CKN \2\:CKN) resistor r=105.769 c=0
Rl25 (\1\:SN \2\:SN) resistor r=242.308 c=0
Rl26 (\2\:SN \3\:SN) resistor r=899.566 c=0
Rl28 (\4\:SN \5\:SN) resistor r=87.6944 c=0
Rl27 (\3\:SN \4\:SN) resistor r=37.6944 c=0
Rl3 (\1\:D \2\:D) resistor r=73.7687 c=0
Rl4 (\2\:D \3\:D) resistor r=177.615 c=0
Rl22 (\12\:CKNb \13\:CKNb) resistor r=47.3097 c=0
Rl21 (\10\:CKNb \11\:CKNb) resistor r=31.9251 c=0
Rl8 (\3\:CKNb \4\:CKNb) resistor r=74.2328 c=0
Rl5 (CKNb \2\:CKNb) resistor r=66.5405 c=0
Rl11 (\5\:CKNb \6\:CKNb) resistor r=43.0526 c=0
Rl13 (\6\:CKNb \8\:CKNb) resistor r=39.2065 c=0
Rl14 (\6\:CKNb \9\:CKNb) resistor r=118.861 c=0
Rl12 (\6\:CKNb \7\:CKNb) resistor r=4.4327 c=0
Rl15 (n20 \2\:n20) resistor r=174.566 c=0
Rl16 (\2\:n20 \3\:n20) resistor r=96.8466 c=0
Rl23 (\4\:CKNbb \5\:CKNbb) resistor r=183.747 c=0
Rl24 (\5\:CKNbb \6\:CKNbb) resistor r=68.4636 c=0
Rl6 (CKNbb \2\:CKNbb) resistor r=70.3867 c=0
Rl7 (\2\:CKNbb \3\:CKNbb) resistor r=232.246 c=0
Rl9 (mout \2\:mout) resistor r=240.385 c=0
Rl10 (\2\:mout \3\:mout) resistor r=24.2328 c=0
Rl17 (RNb \2\:RNb) resistor r=153.846 c=0
Rl30 (\5\:RNb \6\:RNb) resistor r=93.4636 c=0
Rl29 (\4\:RNb \5\:RNb) resistor r=99.8423 c=0
Rl18 (\2\:RNb \3\:RNb) resistor r=228.823 c=0
Rl34 (\2\:n35 \3\:n35) resistor r=29.5379 c=0
Rl33 (n35 \2\:n35) resistor r=104.806 c=0
Rl32 (\3\:qbint \2\:qbint) resistor r=205.769 c=0
Rl45 (\11\:qbint \10\:qbint) resistor r=33.9954 c=0
Rl46 (\11\:qbint \12\:qbint) resistor r=95.9489 c=0
Rl31 (qbint \2\:qbint) resistor r=151.436 c=0
Rz14 (\4\:Q \3\:Q) resistor r=75 c=0
Rz15 (\2\:QN \1\:QN) resistor r=75 c=0
Rz24 (\18\:VSS \17\:VSS) resistor r=75 c=0
Rz25 (\20\:VSS \19\:VSS) resistor r=75 c=0
Rz26 (\22\:VSS \21\:VSS) resistor r=75 c=0
Rz27 (\24\:VSS \23\:VSS) resistor r=75 c=0
Rz18 (\1\:VDD \4\:VDD) resistor r=6.8182 c=0
Rz19 (\9\:VDD \4\:VDD) resistor r=6.25 c=0
Rz20 (\13\:VDD \4\:VDD) resistor r=6.25 c=0
Rz1 (\18\:CKNb \19\:CKNb) resistor r=75 c=0
Rz2 (\7\:n20 \8\:n20) resistor r=75 c=0
Rz7 (\11\:CKNbb \12\:CKNbb) resistor r=75 c=0
Rz5 (\6\:mout \7\:mout) resistor r=75 c=0
Rz6 (\11\:mout \12\:mout) resistor r=75 c=0
Rz10 (\8\:RNb \9\:RNb) resistor r=75 c=0
Rz3 (n25 \2\:n25) resistor r=75 c=0
Rz4 (\3\:n25 \4\:n25) resistor r=75 c=0
Rz13 (\6\:n35 \7\:n35) resistor r=75 c=0
Rz8 (n40 \2\:n40) resistor r=75 c=0
Rz9 (\3\:n40 \4\:n40) resistor r=75 c=0
Rz11 (n42 \2\:n42) resistor r=75 c=0
Rz12 (\3\:n42 \4\:n42) resistor r=75 c=0
Rz16 (\21\:qbint \20\:qbint) resistor r=75 c=0
Rz17 (\13\:qint \12\:qint) resistor r=75 c=0
Ry10 (\2\:Q \1\:Q) resistor r=62 c=0
Ry11 (\4\:QN \3\:QN) resistor r=62 c=0
Ry23 (\1\:VSS \4\:VSS) resistor r=5.6364 c=0
Ry24 (\8\:VSS \4\:VSS) resistor r=5.1667 c=0
Ry25 (\11\:VSS \4\:VSS) resistor r=5.1667 c=0
Ry17 (\20\:VDD \19\:VDD) resistor r=62 c=0
Ry18 (\22\:VDD \21\:VDD) resistor r=62 c=0
Ry19 (\24\:VDD \23\:VDD) resistor r=62 c=0
Ry20 (\26\:VDD \25\:VDD) resistor r=62 c=0
Ry21 (\28\:VDD \27\:VDD) resistor r=62 c=0
Ry22 (\30\:VDD \29\:VDD) resistor r=62 c=0
Ry1 (\21\:CKNb \22\:CKNb) resistor r=62 c=0
Ry2 (\5\:n20 \6\:n20) resistor r=62 c=0
Ry5 (\8\:CKNbb \9\:CKNbb) resistor r=62 c=0
Ry3 (\4\:mout \5\:mout) resistor r=62 c=0
Ry4 (\8\:mout \9\:mout) resistor r=62 c=0
Ry8 (\11\:RNb \12\:RNb) resistor r=62 c=0
Ry9 (\8\:n35 \9\:n35) resistor r=62 c=0
Ry12 (\17\:qbint \16\:qbint) resistor r=62 c=0
Ry13 (\9\:qint \8\:qint) resistor r=62 c=0
Ry6 (n41 \2\:n41) resistor r=62 c=0
Ry7 (\3\:n41 \4\:n41) resistor r=62 c=0
Rx8 (\2\:RN \4\:RN) resistor r=45 c=0
Rx1 (\2\:CKN \4\:CKN) resistor r=45 c=0
Rx7 (\4\:SN \6\:SN) resistor r=45 c=0
Rx2 (\2\:D \4\:D) resistor r=45 c=0
Rx3 (\7\:CKNb \14\:CKNb) resistor r=45 c=0
Rx4 (\4\:CKNb \15\:CKNb) resistor r=45 c=0
Rx5 (\2\:CKNb \20\:CKNb) resistor r=45 c=0
Rx12 (\11\:CKNb \23\:CKNb) resistor r=45 c=0
Rx13 (\9\:CKNb \25\:CKNb) resistor r=45 c=0
Rx14 (\13\:CKNb \26\:CKNb) resistor r=45 c=0
Rx6 (\3\:n20 \4\:n20) resistor r=45 c=0
Rx10 (\6\:CKNbb \7\:CKNbb) resistor r=45 c=0
Rx11 (\2\:CKNbb \13\:CKNbb) resistor r=45 c=0
Rx9 (\3\:mout \13\:mout) resistor r=45 c=0
Rx15 (\5\:RNb \7\:RNb) resistor r=45 c=0
Rx16 (\3\:RNb \10\:RNb) resistor r=45 c=0
Rx17 (\2\:n35 \4\:n35) resistor r=45 c=0
Rx18 (\13\:qbint \11\:qbint) resistor r=45 c=0
Rx21 (\22\:qbint qbint) resistor r=45 c=0
Rx22 (\11\:qint qint) resistor r=45 c=0
mn20 (\18\:CKNb \1\:CKN \23\:VSS VSS) g45n1lvt w=(1.45e-07) l=4.5e-08 \
        nf=1 as=2.32e-14 ad=2.03e-14 ps=6.1e-07 pd=5.7e-07 nrd=1.16667 \
        nrs=1.16667 sa=1.4e-07 sb=1.04362e-06 sd=160n sca=11.4452 \
        scb=0.0112553 scc=0.00042156 m=(1)
mn25 (n21 \3\:D \23\:VSS VSS) g45n1lvt w=(1.45e-07) l=4.5e-08 nf=1 \
        as=2.32e-14 ad=2.247e-14 ps=6.1e-07 pd=6e-07 nrd=1.16667 \
        nrs=1.16667 sa=3.45e-07 sb=8.38621e-07 sd=160n sca=11.4452 \
        scb=0.0112553 scc=0.00042156 m=(1)
mn26 (\7\:n20 \3\:CKNbb n21 VSS) g45n1lvt w=(1.45e-07) l=4.5e-08 nf=1 \
        as=2.247e-14 ad=3.045e-14 ps=6e-07 pd=7.1e-07 nrd=1.16667 \
        nrs=1.16667 sa=5.45e-07 sb=6.38621e-07 sd=160n sca=11.4452 \
        scb=0.0112553 scc=0.00042156 m=(1)
mn36 (\7\:n20 \3\:CKNb n30 VSS) g45n1lvt w=(1.45e-07) l=4.5e-08 nf=1 \
        as=2.755e-14 ad=3.045e-14 ps=6.7e-07 pd=7.1e-07 nrd=1.16667 \
        nrs=1.16667 sa=8e-07 sb=3.83621e-07 sd=160n sca=11.4452 \
        scb=0.0112553 scc=0.00042156 m=(1)
mn35 (n30 \2\:mout \21\:VSS VSS) g45n1lvt w=(1.45e-07) l=4.5e-08 nf=1 \
        as=5.79e-14 ad=2.755e-14 ps=1.7e-06 pd=6.7e-07 nrd=1.16667 \
        nrs=1.16667 sa=1.035e-06 sb=1.48621e-07 sd=160n sca=11.4452 \
        scb=0.0112553 scc=0.00042156 m=(1)
mn21 (\11\:CKNbb \8\:CKNb \21\:VSS VSS) g45n1lvt w=(1.45e-07) l=4.5e-08 \
        nf=1 as=5.79e-14 ad=2.03e-14 ps=1.7e-06 pd=5.7e-07 nrd=1.16667 \
        nrs=1.16667 sa=3.33793e-07 sb=1.4e-07 sd=160n sca=23.279 \
        scb=0.0230742 scc=0.00267719 m=(1)
mn31 (n25 \2\:RNb \11\:mout VSS) g45n1lvt w=(1.45e-07) l=4.5e-08 nf=1 \
        as=2.32e-14 ad=2.03e-14 ps=6.1e-07 pd=5.7e-07 nrd=1.16667 \
        nrs=1.16667 sa=1.4e-07 sb=1.085e-06 sd=160n sca=9.50767 \
        scb=0.00818119 scc=0.00019576 m=(1)
mn32 (\11\:mout n20 \3\:n25 VSS) g45n1lvt w=(1.45e-07) l=4.5e-08 nf=1 \
        as=4.857e-14 ad=2.32e-14 ps=9.6e-07 pd=6.1e-07 nrd=1.16667 \
        nrs=1.16667 sa=3.45e-07 sb=8.8e-07 sd=160n sca=9.50767 \
        scb=0.00818119 scc=0.00019576 m=(1)
mn30 (\3\:n25 \3\:SN \19\:VSS VSS) g45n1lvt w=(1.45e-07) l=4.5e-08 nf=1 \
        as=6.127e-14 ad=4.857e-14 ps=1.18e-06 pd=9.6e-07 nrd=1.16667 \
        nrs=1.16667 sa=7.25e-07 sb=5e-07 sd=160n sca=9.50767 \
        scb=0.00818119 scc=0.00019576 m=(1)
mn22 (\8\:RNb \3\:RN \19\:VSS VSS) g45n1lvt w=(1.45e-07) l=4.5e-08 nf=1 \
        as=6.127e-14 ad=2.03e-14 ps=1.18e-06 pd=5.7e-07 nrd=1.16667 \
        nrs=1.16667 sa=1.085e-06 sb=1.4e-07 sd=160n sca=9.50767 \
        scb=0.00818119 scc=0.00019576 m=(1)
mn40 (\6\:n35 \10\:CKNb \6\:mout VSS) g45n1lvt w=(1.45e-07) l=4.5e-08 \
        nf=1 as=3.407e-14 ad=2.61e-14 ps=7.6e-07 pd=6.5e-07 nrd=1.16667 \
        nrs=1.16667 sa=2.35e-07 sb=4.8e-07 sd=160n sca=23.279 \
        scb=0.0230742 scc=0.00267719 m=(1)
mn53 (n40 \4\:CKNbb \6\:n35 VSS) g45n1lvt w=(1.45e-07) l=4.5e-08 nf=1 \
        as=2.61e-14 ad=3.697e-14 ps=6.5e-07 pd=8e-07 nrd=1.16667 \
        nrs=1.16667 sa=4.6e-07 sb=2.55e-07 sd=160n sca=23.279 \
        scb=0.0230742 scc=0.00267719 m=(1)
mn50 (\3\:n42 \2\:SN \17\:VSS VSS) g45n1lvt w=(1.45e-07) l=4.5e-08 nf=1 \
        as=3.275e-14 ad=2.32e-14 ps=8.2e-07 pd=6.1e-07 nrd=1.16667 \
        nrs=1.16667 sa=2.17586e-07 sb=5.55e-07 sd=160n sca=9.87692 \
        scb=0.0087933 scc=0.000232488 m=(1)
mn52 (\3\:n40 \3\:qbint \3\:n42 VSS) g45n1lvt w=(1.45e-07) l=4.5e-08 nf=1 \
        as=2.32e-14 ad=2.392e-14 ps=6.1e-07 pd=6.2e-07 nrd=1.16667 \
        nrs=1.16667 sa=4.22586e-07 sb=3.5e-07 sd=160n sca=9.87692 \
        scb=0.0087933 scc=0.000232488 m=(1)
mn51 (\3\:n40 \4\:RNb n42 VSS) g45n1lvt w=(1.45e-07) l=4.5e-08 nf=1 \
        as=2.03e-14 ad=2.392e-14 ps=5.7e-07 pd=6.2e-07 nrd=1.16667 \
        nrs=1.16667 sa=6.32586e-07 sb=1.4e-07 sd=160n sca=9.87692 \
        scb=0.0087933 scc=0.000232488 m=(1)
mn56 (\12\:qint \12\:qbint \1\:VSS VSS) g45n1lvt w=(1.45e-07) l=4.5e-08 \
        nf=1 as=4.122e-14 ad=2.03e-14 ps=9.3e-07 pd=5.7e-07 nrd=1.16667 \
        nrs=1.16667 sa=1.25207e-06 sb=1.4e-07 sd=160n sca=11.4452 \
        scb=0.0112553 scc=0.00042156 m=(1)
mn45 (\20\:qbint n35 \1\:VSS VSS) g45n1lvt w=(2.05e-07) l=4.5e-08 nf=1 \
        as=3.83e-14 ad=2.87e-14 ps=8.4e-07 pd=6.9e-07 nrd=1.16667 \
        nrs=1.16667 sa=1.4e-07 sb=1.18232e-06 sd=160n sca=19.867 \
        scb=0.0198061 scc=0.00201945 m=(1)
mn55 (\3\:Q \4\:qbint \1\:VSS VSS) g45n1lvt w=(2.6e-07) l=4.5e-08 nf=1 \
        as=4.84e-14 ad=5.98e-14 ps=9.05e-07 pd=9.8e-07 nrd=1.16667 \
        nrs=1.16667 sa=2.93173e-07 sb=1.01173e-06 sd=160n sca=17.5885 \
        scb=0.0172826 scc=0.00162584 m=(2)
mn57 (\1\:QN qint \1\:VSS VSS) g45n1lvt w=(2.6e-07) l=4.5e-08 nf=1 \
        as=4.986e-14 ad=4.16e-14 ps=9.5e-07 pd=8.4e-07 nrd=1.16667 \
        nrs=1.16667 sa=8.38173e-07 sb=4.66731e-07 sd=160n sca=17.5885 \
        scb=0.0172826 scc=0.00162584 m=(2)
mp45 (\16\:qbint \3\:n35 \1\:VDD VDD) g45p1lvt w=(3.1e-07) l=4.5e-08 \
        nf=1 as=1.3095e-13 ad=4.34e-14 ps=2e-06 pd=9e-07 nrd=1.16667 \
        nrs=1.16667 sa=1.4e-07 sb=1.30629e-06 sd=160n sca=15.1875 \
        scb=0.0142433 scc=0.000935749 m=(1)
mp55_1__rcx (\1\:Q \4\:qbint \1\:VDD VDD) g45p1lvt w=(3.9e-07) l=4.5e-08 \
        nf=1 as=1.4243e-13 ad=8.97e-14 ps=2.035e-06 pd=1.24e-06 \
        nrd=1.16667 nrs=1.16667 sa=3.67692e-07 sb=9.99936e-07 sd=160n \
        sca=28.7024 scb=0.0198217 scc=0.00315848 m=(2)
mp57_1__rcx (\3\:QN qint \1\:VDD VDD) g45p1lvt w=(3.9e-07) l=4.5e-08 \
        nf=1 as=1.1327e-13 ad=6.24e-14 ps=1.935e-06 pd=1.1e-06 nrd=1.16667 \
        nrs=1.16667 sa=9.33077e-07 sb=4.34551e-07 sd=160n sca=20.2826 \
        scb=0.0171335 scc=0.00171662 m=(2)
ends DFFNSRX2
// End of subcircuit definition.
