// Generated for: spectre (May  1 09:15:52 2013 )
// Library name: gsclib045_lvt
// Cell name: INVX8
// View name: extracted

simulator lang=spectre

subckt INVX8 A VDD VSS Y
mp0 (\1\:Y \1\:A VDD VDD) g45p1lvt w=(4.45e-07) l=4.5e-08 nf=1 \
        as=6.993e-14 ad=6.993e-14 ps=1.20429e-06 pd=1.20429e-06 \
        nrd=1.16667 nrs=1.16667 sa=1.4e-07 sb=1.37e-06 sd=160n sca=41.6034 \
        scb=0.0375368 scc=0.00435732 m=(7)
C1 (A VSS) capacitor c=1.70241e-17
C2 (VDD VSS) capacitor c=3.57377e-16
C3 (Y VSS) capacitor c=1.10796e-17
C4 (\1\:A VSS) capacitor c=6.26165e-16
C5 (\23\:A VSS) capacitor c=2.06565e-17
C6 (\1\:Y VSS) capacitor c=4.45708e-16
C7 (\28\:A VSS) capacitor c=5.32629e-17
C8 (\4\:Y VSS) capacitor c=3.73396e-16
Rk4 (\28\:A A) resistor r=0.02293 c=0
Rk3 (\1\:A \28\:A) resistor r=0.4537 c=0
Rk6 (\1\:Y Y) resistor r=0.09525 c=0
Rk7 (Y \4\:Y) resistor r=0.06282 c=0
Rl22 (\1\:A \23\:A) resistor r=3.4936 c=0
Rx4 (\28\:A \23\:A) resistor r=45 c=0
mn0 (\4\:Y \1\:A VSS VSS) g45n1lvt w=(2.95e-07) l=4.5e-08 nf=1 \
        as=4.636e-14 ad=4.636e-14 ps=9.0429e-07 pd=9.0429e-07 nrd=1.16667 \
        nrs=1.16667 sa=1.4e-07 sb=1.37e-06 sd=160n sca=16.4223 \
        scb=0.0158966 scc=0.0014413 m=(7)
ends INVX8
// End of subcircuit definition.
