// Generated for: spectre (May  1 08:16:38 2013 )
// Library name: gsclib045
// Cell name: NOR4X6
// View name: extracted

simulator lang=spectre

subckt NOR4X6 A B C D VDD VSS Y
mp2_1__rcx (n2 \1\:C n1 VDD) g45p1svt w=(4.7e-07) l=4.5e-08 nf=1 \
        as=8.037e-14 ad=8.225e-14 ps=1.282e-06 pd=1.29e-06 nrd=1.16667 \
        nrs=1.16667 sa=2e-06 sb=2e-06 sd=160n sca=26.9787 scb=0.0178954 \
        scc=0.0027966 m=(5)
mp3 (\1\:Y \1\:D n2 VDD) g45p1svt w=(4.7e-07) l=4.5e-08 nf=1 as=8.225e-14 \
        ad=8.554e-14 ps=1.29e-06 pd=1.304e-06 nrd=1.16667 nrs=1.16667 \
        sa=2e-06 sb=1.025e-06 sd=160n sca=26.9787 scb=0.0178954 \
        scc=0.0027966 m=(5)
mp1_1__rcx (n1 \1\:B n0 VDD) g45p1svt w=(4.7e-07) l=4.5e-08 nf=1 \
        as=8.554e-14 ad=8.037e-14 ps=1.304e-06 pd=1.282e-06 nrd=1.16667 \
        nrs=1.16667 sa=1.165e-06 sb=2e-06 sd=160n sca=26.9787 \
        scb=0.0178954 scc=0.0027966 m=(5)
mp0_1__rcx (n0 \1\:A \4\:VDD VDD) g45p1svt w=(4.7e-07) l=4.5e-08 nf=1 \
        as=7.332e-14 ad=7.52e-14 ps=1.252e-06 pd=1.26e-06 nrd=1.16667 \
        nrs=1.16667 sa=1.4e-07 sb=2e-06 sd=160n sca=35.9918 scb=0.0311691 \
        scc=0.00336409 m=(5)
C1 (B VSS) capacitor c=2.76108e-17
C2 (D VSS) capacitor c=1.86942e-17
C3 (A VSS) capacitor c=2.02547e-17
C4 (Y VSS) capacitor c=1.65668e-17
C5 (VDD VSS) capacitor c=1.29815e-16
C6 (C VSS) capacitor c=1.87682e-17
C7 (n0 VSS) capacitor c=3.92273e-16
C8 (n1 VSS) capacitor c=3.83484e-16
C9 (n2 VSS) capacitor c=4.02522e-16
C10 (\1\:A VSS) capacitor c=3.29222e-16
C11 (\1\:D VSS) capacitor c=3.29953e-16
C12 (\1\:C VSS) capacitor c=3.93721e-16
C13 (\1\:B VSS) capacitor c=3.47481e-16
C14 (\1\:Y VSS) capacitor c=2.10696e-16
C15 (\1\:VDD VSS) capacitor c=1.86154e-16
C16 (\6\:Y VSS) capacitor c=4.27814e-16
C17 (\23\:Y VSS) capacitor c=4.34192e-16
C18 (\4\:VDD VSS) capacitor c=1.67951e-16
Rk47 (\1\:VSS \6\:VSS) resistor r=0.04743 c=0
Rk48 (\6\:VSS \7\:VSS) resistor r=0.2053 c=0
Rk53 (\7\:VSS \12\:VSS) resistor r=0.1201 c=0
Rk57 (\13\:VSS VSS) resistor r=0.02713 c=0
Rk54 (\12\:VSS \13\:VSS) resistor r=0.1126 c=0
Rk4 (\1\:B B) resistor r=0.02719 c=0
Rk16 (D \1\:D) resistor r=0.04317 c=0
Rk1 (A \1\:A) resistor r=0.03496 c=0
Rk24 (\1\:Y Y) resistor r=0.1752 c=0
Rk25 (Y \6\:Y) resistor r=0.03789 c=0
Rk36 (\6\:Y \23\:Y) resistor r=0.372 c=0
Rk68 (\2\:VDD \3\:VDD) resistor r=1.2032 c=0
Rk72 (\4\:VDD VDD) resistor r=0.02713 c=0
Rk69 (\3\:VDD \4\:VDD) resistor r=0.1126 c=0
Rk10 (C \1\:C) resistor r=0.03296 c=0
Rz22 (\2\:VDD \1\:VDD) resistor r=6.25 c=0
Rz23 (\3\:VDD \1\:VDD) resistor r=6.25 c=0
Ry20 (\6\:VSS \5\:VSS) resistor r=5.1667 c=0
Ry21 (\12\:VSS \5\:VSS) resistor r=5.1667 c=0
mn2 (\6\:Y \1\:C \7\:VSS VSS) g45n1svt w=(3.1e-07) l=4.5e-08 nf=1 \
        as=5.642e-14 ad=5.549e-14 ps=9.84e-07 pd=9.78e-07 nrd=1.16667 \
        nrs=1.16667 sa=2e-06 sb=2e-06 sd=160n sca=15.9751 scb=0.0153507 \
        scc=0.00137372 m=(5)
mn3_1__rcx (\6\:Y \1\:D \1\:VSS VSS) g45n1svt w=(3.1e-07) l=4.5e-08 nf=1 \
        as=4.836e-14 ad=5.549e-14 ps=9.32e-07 pd=9.78e-07 nrd=1.16667 \
        nrs=1.16667 sa=2e-06 sb=9.6e-07 sd=160n sca=15.9751 scb=0.0153507 \
        scc=0.00137372 m=(5)
mn1_1__rcx (\23\:Y \1\:B \7\:VSS VSS) g45n1svt w=(3.1e-07) l=4.5e-08 \
        nf=1 as=5.642e-14 ad=5.301e-14 ps=9.84e-07 pd=9.62e-07 nrd=1.16667 \
        nrs=1.16667 sa=1.22e-06 sb=2e-06 sd=160n sca=15.9751 scb=0.0153507 \
        scc=0.00137372 m=(5)
mn0 (\23\:Y \1\:A \13\:VSS VSS) g45n1svt w=(3.1e-07) l=4.5e-08 nf=1 \
        as=4.836e-14 ad=5.301e-14 ps=9.32e-07 pd=9.62e-07 nrd=1.16667 \
        nrs=1.16667 sa=1.4e-07 sb=2e-06 sd=160n sca=15.9751 scb=0.0153507 \
        scc=0.00137372 m=(5)
ends NOR4X6
// End of subcircuit definition.
