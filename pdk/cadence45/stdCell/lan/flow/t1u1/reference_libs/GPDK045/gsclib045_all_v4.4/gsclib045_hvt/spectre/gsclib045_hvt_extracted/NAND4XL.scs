// Generated for: spectre (May  1 09:17:55 2013 )
// Library name: gsclib045_hvt
// Cell name: NAND4XL
// View name: extracted

simulator lang=spectre

subckt NAND4XL A B C D VDD VSS Y
mp0 (\5\:Y \3\:A \6\:VDD VDD) g45p1hvt w=(2.15e-07) l=4.5e-08 nf=1 \
        as=4.44e-14 ad=3.44e-14 ps=1.35e-06 pd=7.5e-07 nrd=1.16667 \
        nrs=1.16667 sa=1e-07 sb=7.05e-07 sd=160n sca=65.5272 scb=0.0524355 \
        scc=0.00853103 m=(1)
mp1 (\5\:Y \1\:B \8\:VDD VDD) g45p1hvt w=(2.15e-07) l=4.5e-08 nf=1 \
        as=5.515e-14 ad=3.44e-14 ps=1.45e-06 pd=7.5e-07 nrd=1.16667 \
        nrs=1.16667 sa=3.05e-07 sb=5e-07 sd=160n sca=51.4512 scb=0.0349149 \
        scc=0.00596975 m=(1)
mp2 (\3\:Y \1\:C \8\:VDD VDD) g45p1hvt w=(2.15e-07) l=4.5e-08 nf=1 \
        as=5.515e-14 ad=3.44e-14 ps=1.45e-06 pd=7.5e-07 nrd=1.16667 \
        nrs=1.16667 sa=5e-07 sb=3.05e-07 sd=160n sca=50.5093 scb=0.0329496 \
        scc=0.00591106 m=(1)
mp3 (\3\:Y \1\:D \1\:VDD VDD) g45p1hvt w=(2.15e-07) l=4.5e-08 nf=1 \
        as=4.44e-14 ad=3.44e-14 ps=1.35e-06 pd=7.5e-07 nrd=1.16667 \
        nrs=1.16667 sa=7.05e-07 sb=1e-07 sd=160n sca=57.096 scb=0.0442069 \
        scc=0.00674539 m=(1)
C1 (Y VSS) capacitor c=4.63281e-17
C2 (B VSS) capacitor c=3.55125e-17
C3 (D VSS) capacitor c=3.72267e-17
C4 (A VSS) capacitor c=3.95921e-17
C5 (VDD VSS) capacitor c=6.178e-17
C6 (C VSS) capacitor c=2.3198e-17
C7 (n1 VSS) capacitor c=2.55518e-18
C8 (\1\:D VSS) capacitor c=2.63158e-17
C9 (\1\:C VSS) capacitor c=4.30189e-17
C10 (\1\:B VSS) capacitor c=4.23484e-17
C11 (\3\:A VSS) capacitor c=2.74092e-17
C12 (\3\:D VSS) capacitor c=3.66854e-17
C13 (\3\:C VSS) capacitor c=3.60815e-17
C14 (\3\:B VSS) capacitor c=3.34626e-17
C15 (\1\:A VSS) capacitor c=2.94146e-17
C16 (\2\:D VSS) capacitor c=2.94276e-17
C17 (\2\:C VSS) capacitor c=3.51946e-17
C18 (\2\:B VSS) capacitor c=3.52305e-17
C19 (\2\:A VSS) capacitor c=2.55357e-17
C20 (\1\:VDD VSS) capacitor c=1.0867e-17
C21 (\3\:Y VSS) capacitor c=4.87117e-17
C22 (\8\:VDD VSS) capacitor c=1.56544e-17
C23 (\5\:Y VSS) capacitor c=3.2014e-17
C24 (\6\:VDD VSS) capacitor c=4.01051e-18
C25 (\1\:Y VSS) capacitor c=6.16295e-17
C26 (\4\:A VSS) capacitor c=4.32252e-17
C27 (\4\:B VSS) capacitor c=5.53185e-17
C28 (\4\:C VSS) capacitor c=5.43796e-17
C29 (\5\:D VSS) capacitor c=5.9778e-17
C30 (\4\:VDD VSS) capacitor c=1.29976e-17
C31 (\5\:VDD VSS) capacitor c=3.70959e-18
Rk7 (\2\:Y Y) resistor r=0.2741 c=0
Rk8 (Y \4\:Y) resistor r=0.1629 c=0
Rk9 (\4\:Y \6\:Y) resistor r=0.2769 c=0
Rk2 (B \4\:B) resistor r=0.1283 c=0
Rk4 (\4\:D \5\:D) resistor r=0.001151 c=0
Rk5 (\6\:D D) resistor r=0.001266 c=0
Rk6 (\5\:D \6\:D) resistor r=0.04773 c=0
Rk1 (A \4\:A) resistor r=0.2237 c=0
Rk10 (\2\:VDD \4\:VDD) resistor r=0.3862 c=0
Rk12 (\5\:VDD VDD) resistor r=0.1646 c=0
Rk11 (\4\:VDD \5\:VDD) resistor r=0.03475 c=0
Rk13 (VDD \7\:VDD) resistor r=0.2299 c=0
Rk14 (\5\:VDD \9\:VDD) resistor r=0.221 c=0
Rk16 (VSS \4\:VSS) resistor r=0.0778 c=0
Rk3 (C \4\:C) resistor r=0.03282 c=0
Rl3 (\1\:B \2\:B) resistor r=38.4615 c=0
Rl4 (\2\:B \3\:B) resistor r=29.9451 c=0
Rl7 (\1\:D \2\:D) resistor r=28.8462 c=0
Rl8 (\2\:D \3\:D) resistor r=39.8352 c=0
Rl2 (\2\:A \3\:A) resistor r=33.7903 c=0
Rl1 (\1\:A \2\:A) resistor r=26.098 c=0
Rl5 (\1\:C \2\:C) resistor r=37.2302 c=0
Rl6 (\2\:C \3\:C) resistor r=29.5379 c=0
Rz1 (\1\:Y \2\:Y) resistor r=75 c=0
Rz3 (\3\:VSS \4\:VSS) resistor r=75 c=0
Ry1 (\3\:Y \4\:Y) resistor r=62 c=0
Ry2 (\5\:Y \6\:Y) resistor r=62 c=0
Ry3 (\1\:VDD \2\:VDD) resistor r=62 c=0
Ry4 (\6\:VDD \7\:VDD) resistor r=62 c=0
Ry5 (\8\:VDD \9\:VDD) resistor r=62 c=0
Rx2 (\2\:B \4\:B) resistor r=45 c=0
Rx4 (\2\:D \4\:D) resistor r=45 c=0
Rx1 (\2\:A \4\:A) resistor r=45 c=0
Rx3 (\2\:C \4\:C) resistor r=45 c=0
mn0 (n2 \1\:A \3\:VSS VSS) g45n1hvt w=(1.45e-07) l=4.5e-08 nf=1 \
        as=4.465e-14 ad=1.305e-14 ps=1.5e-06 pd=4.7e-07 nrd=1.16667 \
        nrs=1.16667 sa=1e-07 sb=7.35e-07 sd=160n sca=23.279 scb=0.0230742 \
        scc=0.00267719 m=(1)
mn1 (n1 \3\:B n2 VSS) g45n1hvt w=(1.45e-07) l=4.5e-08 nf=1 as=1.305e-14 \
        ad=2.973e-14 ps=4.7e-07 pd=7e-07 nrd=1.16667 nrs=1.16667 \
        sa=2.35e-07 sb=6e-07 sd=160n sca=23.279 scb=0.0230742 \
        scc=0.00267719 m=(1)
mn2 (n0 \3\:C n1 VSS) g45n1hvt w=(1.45e-07) l=4.5e-08 nf=1 as=2.973e-14 \
        ad=1.233e-14 ps=7e-07 pd=4.6e-07 nrd=1.16667 nrs=1.16667 \
        sa=4.85e-07 sb=3.5e-07 sd=160n sca=23.279 scb=0.0230742 \
        scc=0.00267719 m=(1)
mn3 (\1\:Y \3\:D n0 VSS) g45n1hvt w=(1.45e-07) l=4.5e-08 nf=1 \
        as=1.233e-14 ad=3.19e-14 ps=4.6e-07 pd=7.3e-07 nrd=1.16667 \
        nrs=1.16667 sa=6.15e-07 sb=2.2e-07 sd=160n sca=23.279 \
        scb=0.0230742 scc=0.00267719 m=(1)
ends NAND4XL
// End of subcircuit definition.
