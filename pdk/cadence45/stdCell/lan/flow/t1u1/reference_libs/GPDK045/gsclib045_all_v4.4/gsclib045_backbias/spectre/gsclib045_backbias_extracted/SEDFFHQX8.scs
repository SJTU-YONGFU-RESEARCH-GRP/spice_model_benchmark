// Generated for: spectre (May  1 11:32:51 2013 )
// Library name: gsclib045_backbias
// Cell name: SEDFFHQX8
// View name: extracted

simulator lang=spectre

subckt SEDFFHQX8 CK D E NW Q SE SI VDD VSS
mp55_1__rcx (Q qbint \8\:VDD NW) g45p1svt w=(4.45e-07) l=4.5e-08 nf=1 \
        as=7.073e-14 ad=6.993e-14 ps=1.21e-06 pd=1.20429e-06 nrd=1.16667 \
        nrs=1.16667 sa=1.4e-07 sb=1.87978e-06 sd=160n sca=40.5428 \
        scb=0.0363846 scc=0.00414682 m=(7)
C1 (D VSS) capacitor c=7.80229e-17
C2 (CK VSS) capacitor c=8.15234e-17
C3 (NW VSS) capacitor c=1.07283e-15
C4 (VDD VSS) capacitor c=3.5391e-17
C5 (SE VSS) capacitor c=6.92726e-17
C6 (E VSS) capacitor c=1.04809e-16
C7 (Q VSS) capacitor c=4.88716e-16
C8 (SI VSS) capacitor c=5.9637e-17
C9 (qbint VSS) capacitor c=3.78962e-16
C10 (n30 VSS) capacitor c=2.08611e-16
C11 (CKb VSS) capacitor c=3.56599e-17
C12 (net509 VSS) capacitor c=1.63557e-18
C13 (mout VSS) capacitor c=5.41216e-17
C14 (Ckbb VSS) capacitor c=3.5076e-17
C15 (n20 VSS) capacitor c=6.14683e-17
C16 (net501 VSS) capacitor c=1.73278e-18
C17 (Dbp VSS) capacitor c=4.50004e-17
C18 (qint VSS) capacitor c=5.30659e-17
C19 (net518 VSS) capacitor c=3.88713e-18
C20 (Db VSS) capacitor c=5.04517e-17
C21 (SEb VSS) capacitor c=4.66919e-17
C22 (net494 VSS) capacitor c=8.40528e-18
C23 (Eb VSS) capacitor c=4.80528e-17
C24 (net526 VSS) capacitor c=1.16406e-19
C25 (net426 VSS) capacitor c=8.95935e-19
C26 (net417 VSS) capacitor c=7.44544e-18
C27 (net441 VSS) capacitor c=5.18739e-19
C28 (net405 VSS) capacitor c=3.55892e-18
C29 (net449 VSS) capacitor c=4.24268e-18
C30 (\7\:E VSS) capacitor c=6.40814e-17
C31 (\3\:D VSS) capacitor c=7.29087e-17
C32 (\1\:E VSS) capacitor c=5.86825e-17
C33 (\1\:SE VSS) capacitor c=4.86177e-17
C34 (\6\:SE VSS) capacitor c=3.25241e-17
C35 (\2\:SEb VSS) capacitor c=9.02415e-17
C36 (\3\:SI VSS) capacitor c=7.89076e-17
C37 (\25\:qbint VSS) capacitor c=1.49452e-16
C38 (\7\:Ckbb VSS) capacitor c=3.78555e-17
C39 (\4\:CKb VSS) capacitor c=9.40074e-17
C40 (\5\:CKb VSS) capacitor c=1.09601e-16
C41 (\24\:qbint VSS) capacitor c=4.65029e-17
C42 (\3\:CK VSS) capacitor c=3.22731e-17
C43 (\5\:E VSS) capacitor c=3.12429e-17
C44 (\1\:D VSS) capacitor c=7.74016e-17
C45 (\3\:E VSS) capacitor c=6.49697e-17
C46 (\3\:Eb VSS) capacitor c=6.31245e-17
C47 (\4\:qint VSS) capacitor c=5.86841e-17
C48 (\5\:SE VSS) capacitor c=4.36828e-17
C49 (\3\:SEb VSS) capacitor c=3.09005e-17
C50 (\4\:SE VSS) capacitor c=6.86296e-17
C51 (\1\:SI VSS) capacitor c=3.22287e-17
C52 (\7\:CKb VSS) capacitor c=2.85349e-17
C53 (\8\:CKb VSS) capacitor c=2.99661e-17
C54 (\5\:Ckbb VSS) capacitor c=5.69314e-17
C55 (\3\:mout VSS) capacitor c=6.63669e-17
C56 (\3\:n20 VSS) capacitor c=2.70239e-17
C57 (\3\:Ckbb VSS) capacitor c=3.157e-17
C58 (\9\:CKb VSS) capacitor c=4.96095e-17
C59 (\22\:qbint VSS) capacitor c=9.33036e-17
C60 (\1\:CK VSS) capacitor c=3.81579e-17
C61 (\6\:E VSS) capacitor c=5.34491e-17
C62 (\2\:D VSS) capacitor c=8.04393e-17
C63 (\4\:E VSS) capacitor c=5.08317e-17
C64 (\2\:Eb VSS) capacitor c=7.04865e-17
C65 (\2\:E VSS) capacitor c=4.29476e-17
C66 (\3\:qint VSS) capacitor c=2.92356e-17
C67 (\2\:SE VSS) capacitor c=6.23581e-17
C68 (\4\:SEb VSS) capacitor c=4.76589e-17
C69 (\2\:SI VSS) capacitor c=4.36161e-17
C70 (\8\:Ckbb VSS) capacitor c=2.87851e-17
C71 (\6\:Ckbb VSS) capacitor c=4.72197e-17
C72 (\2\:mout VSS) capacitor c=5.17003e-17
C73 (\2\:n20 VSS) capacitor c=3.76324e-17
C74 (\4\:Ckbb VSS) capacitor c=4.02179e-17
C75 (\6\:CKb VSS) capacitor c=5.98193e-17
C76 (\2\:Ckbb VSS) capacitor c=4.77648e-17
C77 (\23\:qbint VSS) capacitor c=6.91765e-17
C78 (\2\:CK VSS) capacitor c=4.27805e-17
C79 (\6\:Eb VSS) capacitor c=1.0267e-16
C80 (\1\:VDD VSS) capacitor c=1.38281e-16
C81 (\7\:Db VSS) capacitor c=1.25734e-16
C82 (\13\:VDD VSS) capacitor c=2.7656e-17
C83 (\5\:SEb VSS) capacitor c=1.13688e-16
C84 (\5\:Db VSS) capacitor c=7.32563e-17
C85 (\4\:Dbp VSS) capacitor c=6.14088e-17
C86 (\6\:qint VSS) capacitor c=2.79438e-16
C87 (\11\:Ckbb VSS) capacitor c=6.76629e-17
C88 (\8\:Dbp VSS) capacitor c=9.5172e-17
C89 (\4\:n20 VSS) capacitor c=1.01433e-16
C90 (\19\:VDD VSS) capacitor c=6.81529e-17
C91 (\8\:mout VSS) capacitor c=5.45262e-17
C92 (\11\:n30 VSS) capacitor c=8.59052e-17
C93 (\21\:VDD VSS) capacitor c=1.30415e-17
C94 (\13\:CKb VSS) capacitor c=6.6341e-17
C95 (\34\:qbint VSS) capacitor c=3.22747e-16
C96 (\4\:Eb VSS) capacitor c=8.0021e-17
C97 (\9\:SEb VSS) capacitor c=8.34774e-17
C98 (\9\:Db VSS) capacitor c=3.54305e-17
C99 (\8\:qint VSS) capacitor c=7.30151e-17
C100 (\9\:Ckbb VSS) capacitor c=5.92846e-17
C101 (\6\:Dbp VSS) capacitor c=1.8639e-16
C102 (\8\:n20 VSS) capacitor c=1.74636e-17
C103 (\6\:mout VSS) capacitor c=3.12081e-17
C104 (\13\:n30 VSS) capacitor c=2.26812e-16
C105 (\10\:CKb VSS) capacitor c=4.49181e-17
C106 (\2\:CKb VSS) capacitor c=4.35932e-17
C107 (\3\:CKb VSS) capacitor c=6.36842e-17
C108 (\3\:SE VSS) capacitor c=7.6366e-17
C109 (\2\:qint VSS) capacitor c=4.12309e-17
C110 (\4\:CK VSS) capacitor c=4.79486e-17
C111 (\12\:CKb VSS) capacitor c=9.09034e-17
C112 (\15\:CKb VSS) capacitor c=9.5597e-17
C113 (\15\:n30 VSS) capacitor c=1.81206e-16
C114 (\4\:mout VSS) capacitor c=7.13213e-17
C115 (\5\:mout VSS) capacitor c=6.6022e-17
C116 (\6\:n20 VSS) capacitor c=7.32269e-17
C117 (\7\:n20 VSS) capacitor c=5.86108e-17
C118 (\13\:Ckbb VSS) capacitor c=9.68022e-17
C119 (\14\:Ckbb VSS) capacitor c=1.66357e-16
C120 (\15\:Ckbb VSS) capacitor c=2.13015e-16
C121 (\16\:Ckbb VSS) capacitor c=8.70042e-17
C122 (\17\:Ckbb VSS) capacitor c=6.52404e-17
C123 (\18\:Ckbb VSS) capacitor c=5.00661e-17
C124 (\19\:Ckbb VSS) capacitor c=7.79414e-17
C125 (\32\:qbint VSS) capacitor c=2.86525e-16
C126 (\33\:qbint VSS) capacitor c=4.1511e-16
C127 (\39\:qbint VSS) capacitor c=2.85477e-17
C128 (\40\:qbint VSS) capacitor c=6.81373e-17
C129 (\4\:SI VSS) capacitor c=5.49702e-17
C130 (\3\:Dbp VSS) capacitor c=2.0896e-16
C131 (\7\:SEb VSS) capacitor c=9.73722e-17
C132 (\8\:SEb VSS) capacitor c=8.05213e-17
C133 (\11\:SEb VSS) capacitor c=2.63982e-17
C134 (\7\:SE VSS) capacitor c=3.69201e-17
C135 (\5\:qint VSS) capacitor c=2.27209e-16
C136 (\3\:Db VSS) capacitor c=1.18672e-16
C137 (\4\:Db VSS) capacitor c=8.89726e-17
C138 (\4\:D VSS) capacitor c=3.2504e-17
C139 (\8\:E VSS) capacitor c=6.496e-17
C140 (\10\:E VSS) capacitor c=5.27294e-17
C141 (\8\:Eb VSS) capacitor c=6.64998e-17
C142 (\3\:VDD VSS) capacitor c=1.30487e-16
C143 (\4\:VDD VSS) capacitor c=2.89288e-16
C144 (\6\:VDD VSS) capacitor c=1.55311e-16
C145 (\7\:VDD VSS) capacitor c=1.12527e-16
C146 (\8\:VDD VSS) capacitor c=6.6301e-16
Rk62 (D \4\:D) resistor r=0.05675 c=0
Rk13 (\4\:CK CK) resistor r=0.03487 c=0
Rk68 (\2\:VSS \4\:VSS) resistor r=0.4272 c=0
Rk69 (\4\:VSS \5\:VSS) resistor r=0.2958 c=0
Rk70 (\5\:VSS \6\:VSS) resistor r=0.5941 c=0
Rk73 (\6\:VSS \9\:VSS) resistor r=0.7145 c=0
Rk74 (\9\:VSS \10\:VSS) resistor r=0.2807 c=0
Rk75 (\10\:VSS \11\:VSS) resistor r=0.3083 c=0
Rk82 (\12\:VSS VSS) resistor r=0.1074 c=0
Rk76 (\11\:VSS \12\:VSS) resistor r=0.5163 c=0
Rk83 (\5\:VSS \19\:VSS) resistor r=0.1786 c=0
Rk86 (\9\:VSS \25\:VSS) resistor r=0.2099 c=0
Rk87 (\11\:VSS \27\:VSS) resistor r=0.1429 c=0
Rk93 (\2\:VDD \3\:VDD) resistor r=0.56 c=0
Rk94 (\3\:VDD \4\:VDD) resistor r=0.696 c=0
Rk96 (\4\:VDD \6\:VDD) resistor r=0.7421 c=0
Rk97 (\6\:VDD \7\:VDD) resistor r=0.732 c=0
Rk103 (\8\:VDD VDD) resistor r=0.1074 c=0
Rk98 (\7\:VDD \8\:VDD) resistor r=0.3884 c=0
Rk104 (\3\:VDD \14\:VDD) resistor r=0.04332 c=0
Rk107 (\6\:VDD \20\:VDD) resistor r=0.2684 c=0
Rk108 (\7\:VDD \22\:VDD) resistor r=0.07405 c=0
Rk54 (\7\:SE SE) resistor r=0.04807 c=0
Rk64 (\9\:E E) resistor r=0.006309 c=0
Rk63 (\8\:E \9\:E) resistor r=0.4238 c=0
Rk65 (E \10\:E) resistor r=0.3403 c=0
Rk43 (\4\:SI SI) resistor r=0.1679 c=0
Rk34 (\33\:qbint \34\:qbint) resistor r=0.4736 c=0
Rk33 (\32\:qbint \33\:qbint) resistor r=2.7896 c=0
Rk38 (\34\:qbint \39\:qbint) resistor r=0.1663 c=0
Rk39 (\33\:qbint \40\:qbint) resistor r=0.4168 c=0
Rk17 (\12\:n30 \14\:n30) resistor r=0.4341 c=0
Rk18 (\14\:n30 \15\:n30) resistor r=1.4427 c=0
Rk14 (\11\:CKb \12\:CKb) resistor r=0.2115 c=0
Rk15 (\12\:CKb \14\:CKb) resistor r=0.2896 c=0
Rk16 (\12\:CKb \15\:CKb) resistor r=0.5678 c=0
Rk19 (\4\:mout \5\:mout) resistor r=0.3931 c=0
Rk20 (\5\:mout \7\:mout) resistor r=0.2558 c=0
Rk21 (\5\:mout \9\:mout) resistor r=0.1415 c=0
Rk25 (\10\:Ckbb \12\:Ckbb) resistor r=0.3723 c=0
Rk26 (\12\:Ckbb \13\:Ckbb) resistor r=0.4142 c=0
Rk27 (\13\:Ckbb \14\:Ckbb) resistor r=0.4289 c=0
Rk28 (\14\:Ckbb \15\:Ckbb) resistor r=0.8874 c=0
Rk29 (\15\:Ckbb \16\:Ckbb) resistor r=0.64 c=0
Rk30 (\13\:Ckbb \17\:Ckbb) resistor r=0.2555 c=0
Rk31 (\14\:Ckbb \18\:Ckbb) resistor r=0.1965 c=0
Rk32 (\15\:Ckbb \19\:Ckbb) resistor r=0.3642 c=0
Rk22 (\5\:n20 \6\:n20) resistor r=0.4855 c=0
Rk23 (\6\:n20 \7\:n20) resistor r=0.3472 c=0
Rk24 (\6\:n20 \9\:n20) resistor r=0.03466 c=0
Rk44 (\2\:Dbp \3\:Dbp) resistor r=0.1445 c=0
Rk45 (\3\:Dbp \5\:Dbp) resistor r=0.2894 c=0
Rk46 (\3\:Dbp \7\:Dbp) resistor r=1.5049 c=0
Rk47 (\7\:Dbp \9\:Dbp) resistor r=0.6037 c=0
Rk55 (\5\:qint \7\:qint) resistor r=1.6831 c=0
Rk56 (\7\:qint \9\:qint) resistor r=0.5034 c=0
Rk57 (\2\:Db \3\:Db) resistor r=0.2918 c=0
Rk58 (\3\:Db \4\:Db) resistor r=0.4428 c=0
Rk59 (\4\:Db \6\:Db) resistor r=0.4566 c=0
Rk60 (\3\:Db \8\:Db) resistor r=0.7311 c=0
Rk61 (\4\:Db \10\:Db) resistor r=0.07228 c=0
Rk48 (\6\:SEb \7\:SEb) resistor r=0.735 c=0
Rk49 (\7\:SEb \8\:SEb) resistor r=0.1539 c=0
Rk50 (\8\:SEb \10\:SEb) resistor r=0.5759 c=0
Rk51 (\8\:SEb \11\:SEb) resistor r=0.05355 c=0
Rk66 (\5\:Eb \7\:Eb) resistor r=0.7352 c=0
Rk67 (\7\:Eb \8\:Eb) resistor r=0.4553 c=0
Rl73 (\2\:D \3\:D) resistor r=96.9426 c=0
Rl72 (\1\:D \2\:D) resistor r=114.617 c=0
Rl31 (\2\:CK \3\:CK) resistor r=41.7582 c=0
Rl30 (\1\:CK \2\:CK) resistor r=90.3846 c=0
Rl60 (\1\:SE \2\:SE) resistor r=106.502 c=0
Rl63 (\2\:SE \5\:SE) resistor r=132.487 c=0
Rl64 (\3\:SE \6\:SE) resistor r=35.772 c=0
Rl62 (\3\:SE \4\:SE) resistor r=175.722 c=0
Rl61 (\2\:SE \3\:SE) resistor r=191.222 c=0
Rl75 (\6\:E \7\:E) resistor r=192.285 c=0
Rl74 (\5\:E \6\:E) resistor r=61.3335 c=0
Rl71 (\3\:E \4\:E) resistor r=49.2328 c=0
Rl68 (\1\:E \2\:E) resistor r=33.7903 c=0
Rl57 (\2\:SI \3\:SI) resistor r=78.6942 c=0
Rl56 (\1\:SI \2\:SI) resistor r=48.4455 c=0
Rl34 (\23\:qbint \24\:qbint) resistor r=24.2328 c=0
Rl33 (\23\:qbint \22\:qbint) resistor r=154.568 c=0
Rl45 (\4\:CKb \5\:CKb) resistor r=530.335 c=0
Rl46 (\5\:CKb \6\:CKb) resistor r=216.873 c=0
Rl49 (\6\:CKb \9\:CKb) resistor r=28.2967 c=0
Rl42 (CKb \2\:CKb) resistor r=121.413 c=0
Rl47 (\2\:CKb \7\:CKb) resistor r=30.4507 c=0
Rl44 (\3\:CKb \4\:CKb) resistor r=106.926 c=0
Rl48 (\3\:CKb \8\:CKb) resistor r=45.3874 c=0
Rl43 (\2\:CKb \3\:CKb) resistor r=264.3 c=0
Rl38 (mout \2\:mout) resistor r=37.5309 c=0
Rl39 (\2\:mout \3\:mout) resistor r=94.0258 c=0
Rl41 (\7\:Ckbb \8\:Ckbb) resistor r=24.2328 c=0
Rl40 (\5\:Ckbb \6\:Ckbb) resistor r=63.0341 c=0
Rl35 (\3\:Ckbb \4\:Ckbb) resistor r=53.079 c=0
Rl32 (Ckbb \2\:Ckbb) resistor r=24.2328 c=0
Rl36 (n20 \2\:n20) resistor r=103.079 c=0
Rl37 (\2\:n20 \3\:n20) resistor r=24.2328 c=0
Rl65 (\2\:qint qint) resistor r=37.3411 c=0
Rl67 (\2\:qint \4\:qint) resistor r=175.803 c=0
Rl66 (\2\:qint \3\:qint) resistor r=10.9341 c=0
Rl59 (\3\:SEb \4\:SEb) resistor r=47.3097 c=0
Rl58 (SEb \2\:SEb) resistor r=111.516 c=0
Rl69 (Eb \2\:Eb) resistor r=24.2328 c=0
Rl70 (\2\:Eb \3\:Eb) resistor r=199.326 c=0
Rz19 (\2\:VSS \1\:VSS) resistor r=75 c=0
Rz20 (\19\:VSS \18\:VSS) resistor r=75 c=0
Rz23 (\25\:VSS \24\:VSS) resistor r=75 c=0
Rz24 (\27\:VSS \26\:VSS) resistor r=75 c=0
Rz6 (\14\:n30 \13\:n30) resistor r=75 c=0
Rz5 (\10\:CKb \11\:CKb) resistor r=75 c=0
Rz7 (\6\:mout \7\:mout) resistor r=75 c=0
Rz9 (\9\:Ckbb \10\:Ckbb) resistor r=75 c=0
Rz8 (\8\:n20 \9\:n20) resistor r=75 c=0
Rz12 (Dbp \2\:Dbp) resistor r=75 c=0
Rz13 (\6\:Dbp \7\:Dbp) resistor r=75 c=0
Rz15 (\9\:qint \8\:qint) resistor r=75 c=0
Rz16 (Db \2\:Db) resistor r=75 c=0
Rz17 (\9\:Db \10\:Db) resistor r=75 c=0
Rz14 (\9\:SEb \10\:SEb) resistor r=75 c=0
Rz18 (\4\:Eb \5\:Eb) resistor r=75 c=0
Ry19 (\4\:VSS \3\:VSS) resistor r=7.75 c=0
Ry20 (\6\:VSS \3\:VSS) resistor r=5.1667 c=0
Ry21 (\10\:VSS \3\:VSS) resistor r=5.1667 c=0
Ry22 (\12\:VSS \3\:VSS) resistor r=5.1667 c=0
Ry23 (\2\:VDD \1\:VDD) resistor r=62 c=0
Ry24 (\14\:VDD \13\:VDD) resistor r=62 c=0
Ry27 (\20\:VDD \19\:VDD) resistor r=62 c=0
Ry28 (\22\:VDD \21\:VDD) resistor r=62 c=0
Ry6 (\12\:n30 \11\:n30) resistor r=62 c=0
Ry5 (\13\:CKb \14\:CKb) resistor r=62 c=0
Ry7 (\8\:mout \9\:mout) resistor r=62 c=0
Ry9 (\11\:Ckbb \12\:Ckbb) resistor r=62 c=0
Ry8 (\4\:n20 \5\:n20) resistor r=62 c=0
Ry12 (\4\:Dbp \5\:Dbp) resistor r=62 c=0
Ry13 (\8\:Dbp \9\:Dbp) resistor r=62 c=0
Ry15 (\7\:qint \6\:qint) resistor r=20.6667 c=0
Ry16 (\5\:Db \6\:Db) resistor r=62 c=0
Ry17 (\7\:Db \8\:Db) resistor r=20.6667 c=0
Ry14 (\5\:SEb \6\:SEb) resistor r=62 c=0
Ry18 (\6\:Eb \7\:Eb) resistor r=62 c=0
Rx18 (\2\:D \4\:D) resistor r=45 c=0
Rx1 (\2\:CK \4\:CK) resistor r=45 c=0
Rx16 (\2\:SE \7\:SE) resistor r=45 c=0
Rx19 (\2\:E \8\:E) resistor r=45 c=0
Rx20 (\4\:E \9\:E) resistor r=45 c=0
Rx21 (\6\:E \10\:E) resistor r=45 c=0
Rx13 (\2\:SI \4\:SI) resistor r=45 c=0
Rx10 (\32\:qbint \25\:qbint) resistor r=45 c=0
Rx11 (\39\:qbint qbint) resistor r=45 c=0
Rx12 (\40\:qbint \23\:qbint) resistor r=45 c=0
Rx3 (\15\:n30 n30) resistor r=45 c=0
Rx2 (\6\:CKb \15\:CKb) resistor r=45 c=0
Rx4 (\2\:mout \4\:mout) resistor r=45 c=0
Rx6 (\2\:Ckbb \16\:Ckbb) resistor r=45 c=0
Rx7 (\8\:Ckbb \17\:Ckbb) resistor r=45 c=0
Rx8 (\6\:Ckbb \18\:Ckbb) resistor r=45 c=0
Rx9 (\4\:Ckbb \19\:Ckbb) resistor r=45 c=0
Rx5 (\2\:n20 \7\:n20) resistor r=45 c=0
Rx17 (\5\:qint \3\:qint) resistor r=45 c=0
Rx14 (SEb \7\:SEb) resistor r=45 c=0
Rx15 (\4\:SEb \11\:SEb) resistor r=45 c=0
Rx22 (\2\:Eb \8\:Eb) resistor r=45 c=0
mn55_1__rcx (Q qbint \12\:VSS VSS) g45n1svt w=(2.95e-07) l=4.5e-08 nf=1 \
        as=4.69e-14 ad=4.636e-14 ps=9.1e-07 pd=9.0429e-07 nrd=1.16667 \
        nrs=1.16667 sa=1.4e-07 sb=1.92051e-06 sd=160n sca=16.4223 \
        scb=0.0158966 scc=0.0014413 m=(7)
mn12 (net518 \1\:SI \6\:VSS VSS) g45n1svt w=(2.6e-07) l=4.5e-08 nf=1 \
        as=7.15e-14 ad=4.42e-14 ps=1.07e-06 pd=8.6e-07 nrd=1.16667 \
        nrs=1.16667 sa=9.75192e-07 sb=6.75e-07 sd=160n sca=8.65991 \
        scb=0.00681295 scc=0.000165238 m=(1)
mn13 (Dbp \4\:SE net518 VSS) g45n1svt w=(2.6e-07) l=4.5e-08 nf=1 \
        as=4.42e-14 ad=7.15e-14 ps=8.6e-07 pd=1.07e-06 nrd=1.16667 \
        nrs=1.16667 sa=1.19019e-06 sb=4.6e-07 sd=160n sca=8.65991 \
        scb=0.00681295 scc=0.000165238 m=(1)
mn11 (\9\:Db \3\:SEb Dbp VSS) g45n1svt w=(2.6e-07) l=4.5e-08 nf=1 \
        as=7.15e-14 ad=3.64e-14 ps=1.07e-06 pd=8e-07 nrd=1.16667 \
        nrs=1.16667 sa=1.51019e-06 sb=1.4e-07 sd=160n sca=8.65991 \
        scb=0.00681295 scc=0.000165238 m=(1)
mn1 (net494 \4\:qint \18\:VSS VSS) g45n1svt w=(2.6e-07) l=4.5e-08 nf=1 \
        as=4.34e-14 ad=7.15e-14 ps=9.6e-07 pd=1.07e-06 nrd=1.16667 \
        nrs=1.16667 sa=2.70096e-07 sb=9.30769e-07 sd=160n sca=8.09546 \
        scb=0.00588493 scc=0.000117119 m=(1)
mn2 (Db \3\:Eb net494 VSS) g45n1svt w=(2.6e-07) l=4.5e-08 nf=1 \
        as=7.15e-14 ad=4.16e-14 ps=1.07e-06 pd=8.4e-07 nrd=1.16667 \
        nrs=1.16667 sa=5.90096e-07 sb=6.10769e-07 sd=160n sca=8.09546 \
        scb=0.00588493 scc=0.000117119 m=(1)
mn4 (Db \3\:E net526 VSS) g45n1svt w=(2.6e-07) l=4.5e-08 nf=1 as=1.56e-14 \
        ad=4.16e-14 ps=6.4e-07 pd=8.4e-07 nrd=1.16667 nrs=1.16667 \
        sa=7.95096e-07 sb=4.05769e-07 sd=160n sca=8.09546 scb=0.00588493 \
        scc=0.000117119 m=(1)
mn3 (net526 \1\:D \1\:VSS VSS) g45n1svt w=(2.6e-07) l=4.5e-08 nf=1 \
        as=5.138e-14 ad=1.56e-14 ps=1.07e-06 pd=6.4e-07 nrd=1.16667 \
        nrs=1.16667 sa=9.00096e-07 sb=3.00769e-07 sd=160n sca=8.09546 \
        scb=0.00588493 scc=0.000117119 m=(1)
mn45_1__rcx (\34\:qbint n30 \12\:VSS VSS) g45n1svt w=(2.6e-07) l=4.5e-08 \
        nf=1 as=4.797e-14 ad=4.723e-14 ps=9.0333e-07 pd=8.8333e-07 \
        nrd=1.16667 nrs=1.16667 sa=1.575e-06 sb=6.65e-07 sd=160n \
        sca=17.5885 scb=0.0172826 scc=0.00162584 m=(3)
mn56_1__rcx (\8\:qint \25\:qbint \6\:VSS VSS) g45n1svt w=(2.6e-07) \
        l=4.5e-08 nf=1 as=8.296e-14 ad=4.94e-14 ps=1.285e-06 pd=9e-07 \
        nrd=1.16667 nrs=1.16667 sa=4.20192e-07 sb=1.23e-06 sd=160n \
        sca=8.65991 scb=0.00681295 scc=0.000165238 m=(2)
mn20 (\10\:CKb \1\:CK \26\:VSS VSS) g45n1svt w=(1.45e-07) l=4.5e-08 nf=1 \
        as=6.787e-14 ad=2.755e-14 ps=1.24e-06 pd=6.7e-07 nrd=1.16667 \
        nrs=1.16667 sa=1.9e-07 sb=2e-06 sd=160n sca=9.33388 scb=0.00788941 \
        scc=0.00017958 m=(1)
mn21 (\9\:Ckbb \7\:CKb \6\:VSS VSS) g45n1svt w=(1.45e-07) l=4.5e-08 nf=1 \
        as=9.443e-14 ad=2.03e-14 ps=1.5e-06 pd=5.7e-07 nrd=1.16667 \
        nrs=1.16667 sa=1.4e-07 sb=1.665e-06 sd=160n sca=10.2779 \
        scb=0.00944477 scc=0.000275883 m=(1)
mn10 (\9\:SEb \5\:SE \18\:VSS VSS) g45n1svt w=(1.45e-07) l=4.5e-08 nf=1 \
        as=4.34e-14 ad=2.03e-14 ps=9.6e-07 pd=5.7e-07 nrd=1.16667 \
        nrs=1.16667 sa=1.4e-07 sb=1.06948e-06 sd=160n sca=6.75077 \
        scb=0.00344229 scc=2.58723e-05 m=(1)
mn0 (\4\:Eb \5\:E \1\:VSS VSS) g45n1svt w=(1.45e-07) l=4.5e-08 nf=1 \
        as=5.138e-14 ad=2.03e-14 ps=1.07e-06 pd=5.7e-07 nrd=1.16667 \
        nrs=1.16667 sa=1.1131e-06 sb=1.4e-07 sd=160n sca=9.50767 \
        scb=0.00818119 scc=0.00019576 m=(1)
mn50 (net509 \22\:qbint \26\:VSS VSS) g45n1svt w=(2.05e-07) l=4.5e-08 \
        nf=1 as=6.787e-14 ad=1.23e-14 ps=1.24e-06 pd=5.3e-07 nrd=1.16667 \
        nrs=1.16667 sa=4.3878e-07 sb=1.78e-06 sd=160n sca=8.54927 \
        scb=0.00659983 scc=0.000133988 m=(1)
mn51 (\13\:n30 \9\:CKb net509 VSS) g45n1svt w=(2.05e-07) l=4.5e-08 nf=1 \
        as=1.23e-14 ad=5.637e-14 ps=5.3e-07 pd=9.6e-07 nrd=1.16667 \
        nrs=1.16667 sa=5.4378e-07 sb=1.675e-06 sd=160n sca=8.54927 \
        scb=0.00659983 scc=0.000133988 m=(1)
mn40 (\13\:n30 \3\:Ckbb \6\:mout VSS) g45n1svt w=(2.05e-07) l=4.5e-08 \
        nf=1 as=1.0865e-13 ad=5.638e-14 ps=1.47e-06 pd=9.6e-07 nrd=1.16667 \
        nrs=1.16667 sa=8.6378e-07 sb=1.355e-06 sd=160n sca=8.54927 \
        scb=0.00659983 scc=0.000133988 m=(1)
mn30 (\6\:mout \3\:n20 \24\:VSS VSS) g45n1svt w=(2.05e-07) l=4.5e-08 \
        nf=1 as=3.28e-14 ad=1.0865e-13 ps=7.3e-07 pd=1.47e-06 nrd=1.16667 \
        nrs=1.16667 sa=1.43878e-06 sb=7.8e-07 sd=160n sca=8.54927 \
        scb=0.00659983 scc=0.000133988 m=(1)
mn35 (net501 \3\:mout \24\:VSS VSS) g45n1svt w=(2.05e-07) l=4.5e-08 nf=1 \
        as=3.28e-14 ad=1.742e-14 ps=7.3e-07 pd=5.8e-07 nrd=1.16667 \
        nrs=1.16667 sa=1.64378e-06 sb=5.75e-07 sd=160n sca=8.54927 \
        scb=0.00659983 scc=0.000133988 m=(1)
mn36 (\8\:n20 \5\:Ckbb net501 VSS) g45n1svt w=(2.05e-07) l=4.5e-08 nf=1 \
        as=1.743e-14 ad=3.28e-14 ps=5.8e-07 pd=7.3e-07 nrd=1.16667 \
        nrs=1.16667 sa=1.77378e-06 sb=4.45e-07 sd=160n sca=8.54927 \
        scb=0.00659983 scc=0.000133988 m=(1)
mn25 (\8\:n20 \8\:CKb \6\:Dbp VSS) g45n1svt w=(2.05e-07) l=4.5e-08 nf=1 \
        as=4.92e-14 ad=3.28e-14 ps=8.9e-07 pd=7.3e-07 nrd=1.16667 \
        nrs=1.16667 sa=1.91512e-06 sb=2.4e-07 sd=160n sca=8.54927 \
        scb=0.00659983 scc=0.000133988 m=(1)
mp12 (net441 \3\:SI \4\:VDD NW) g45p1svt w=(3.9e-07) l=4.5e-08 nf=1 \
        as=8.97e-14 ad=2.34e-14 ps=1.24e-06 pd=9e-07 nrd=1.16667 \
        nrs=1.16667 sa=8.41859e-07 sb=6.25e-07 sd=160n sca=27.1129 \
        scb=0.0194379 scc=0.00296416 m=(1)
mp13 (\4\:Dbp \2\:SEb net441 NW) g45p1svt w=(3.9e-07) l=4.5e-08 nf=1 \
        as=2.34e-14 ad=1.2675e-13 ps=9e-07 pd=1.43e-06 nrd=1.16667 \
        nrs=1.16667 sa=9.46859e-07 sb=5.2e-07 sd=160n sca=27.1129 \
        scb=0.0194379 scc=0.00296416 m=(1)
mp11 (\5\:Db \6\:SE \4\:Dbp NW) g45p1svt w=(3.9e-07) l=4.5e-08 nf=1 \
        as=1.2675e-13 ad=5.85e-14 ps=1.43e-06 pd=1.08e-06 nrd=1.16667 \
        nrs=1.16667 sa=1.31686e-06 sb=1.5e-07 sd=160n sca=27.1129 \
        scb=0.0194379 scc=0.00296416 m=(1)
mp1 (net405 qint \13\:VDD NW) g45p1svt w=(3.9e-07) l=4.5e-08 nf=1 \
        as=8.12e-14 ad=3.9e-14 ps=1.68e-06 pd=9.8e-07 nrd=1.16667 \
        nrs=1.16667 sa=2.68141e-07 sb=7.89551e-07 sd=160n sca=11.5347 \
        scb=0.00974379 scc=0.00025826 m=(1)
mp2 (\7\:Db \1\:E net405 NW) g45p1svt w=(3.9e-07) l=4.5e-08 nf=1 \
        as=3.9e-14 ad=6.24e-14 ps=9.8e-07 pd=1.1e-06 nrd=1.16667 \
        nrs=1.16667 sa=4.13141e-07 sb=6.44551e-07 sd=160n sca=11.5347 \
        scb=0.00974379 scc=0.00025826 m=(1)
mp4 (\7\:Db Eb net449 NW) g45p1svt w=(3.9e-07) l=4.5e-08 nf=1 \
        as=4.875e-14 ad=6.24e-14 ps=1.03e-06 pd=1.1e-06 nrd=1.16667 \
        nrs=1.16667 sa=6.18141e-07 sb=4.39551e-07 sd=160n sca=11.7928 \
        scb=0.00981106 scc=0.000258271 m=(1)
mp3 (net449 \3\:D \1\:VDD NW) g45p1svt w=(3.9e-07) l=4.5e-08 nf=1 \
        as=6.535e-14 ad=4.875e-14 ps=1.16e-06 pd=1.03e-06 nrd=1.16667 \
        nrs=1.16667 sa=7.88141e-07 sb=2.69551e-07 sd=160n sca=12.4181 \
        scb=0.0101715 scc=0.000258557 m=(1)
mp45 (\34\:qbint n30 \8\:VDD NW) g45p1svt w=(3.9e-07) l=4.5e-08 nf=1 \
        as=6.423e-14 ad=5.62e-14 ps=1.13667e-06 pd=1.08667e-06 nrd=1.16667 \
        nrs=1.16667 sa=1.575e-06 sb=5.22308e-07 sd=160n sca=18.3796 \
        scb=0.0159892 scc=0.00159615 m=(3)
mp56 (\6\:qint \25\:qbint \4\:VDD NW) g45p1svt w=(3.9e-07) l=4.5e-08 \
        nf=1 as=1.0797e-13 ad=6.24e-14 ps=1.8e-06 pd=1.1e-06 nrd=1.16667 \
        nrs=1.16667 sa=3.61859e-07 sb=1.105e-06 sd=160n sca=27.1129 \
        scb=0.0194379 scc=0.00296416 m=(2)
mp20 (\13\:CKb \3\:CK \21\:VDD NW) g45p1svt w=(2.15e-07) l=4.5e-08 nf=1 \
        as=8.833e-14 ad=3.77e-14 ps=2.02e-06 pd=9e-07 nrd=1.16667 \
        nrs=1.16667 sa=1.75349e-07 sb=2e-06 sd=160n sca=45.7906 \
        scb=0.0283307 scc=0.00588417 m=(1)
mp21 (\11\:Ckbb CKb \4\:VDD NW) g45p1svt w=(2.15e-07) l=4.5e-08 nf=1 \
        as=1.2625e-13 ad=3.01e-14 ps=2.36e-06 pd=7.1e-07 nrd=1.16667 \
        nrs=1.16667 sa=1.4e-07 sb=1.54e-06 sd=160n sca=39.8855 \
        scb=0.0273598 scc=0.00519679 m=(1)
mp10 (\5\:SEb \1\:SE \13\:VDD NW) g45p1svt w=(2.15e-07) l=4.5e-08 nf=1 \
        as=8.12e-14 ad=3.01e-14 ps=1.68e-06 pd=7.1e-07 nrd=1.16667 \
        nrs=1.16667 sa=1.4e-07 sb=1.1436e-06 sd=160n sca=11.9515 \
        scb=0.0105226 scc=0.000305882 m=(1)
mp0 (\6\:Eb \7\:E \1\:VDD NW) g45p1svt w=(2.15e-07) l=4.5e-08 nf=1 \
        as=6.535e-14 ad=3.01e-14 ps=1.16e-06 pd=7.1e-07 nrd=1.16667 \
        nrs=1.16667 sa=1.13872e-06 sb=1.4e-07 sd=160n sca=15.5146 \
        scb=0.0146627 scc=0.000413871 m=(1)
mp50 (net426 \24\:qbint \21\:VDD NW) g45p1svt w=(3.1e-07) l=4.5e-08 nf=1 \
        as=8.833e-14 ad=4.185e-14 ps=2.02e-06 pd=8.9e-07 nrd=1.16667 \
        nrs=1.16667 sa=3.42903e-07 sb=2e-06 sd=160n sca=35.6995 \
        scb=0.0234062 scc=0.00420468 m=(1)
mp51 (\11\:n30 Ckbb net426 NW) g45p1svt w=(3.1e-07) l=4.5e-08 nf=1 \
        as=4.185e-14 ad=1.4725e-13 ps=8.9e-07 pd=1.57e-06 nrd=1.16667 \
        nrs=1.16667 sa=5.22903e-07 sb=2e-06 sd=160n sca=35.6995 \
        scb=0.0234062 scc=0.00420468 m=(1)
mp40 (\11\:n30 \5\:CKb \8\:mout NW) g45p1svt w=(3.1e-07) l=4.5e-08 nf=1 \
        as=1.3485e-13 ad=1.4725e-13 ps=1.49e-06 pd=1.57e-06 nrd=1.16667 \
        nrs=1.16667 sa=1.0429e-06 sb=1.48e-06 sd=160n sca=35.6995 \
        scb=0.0234062 scc=0.00420468 m=(1)
mp30 (\8\:mout n20 \19\:VDD NW) g45p1svt w=(3.1e-07) l=4.5e-08 nf=1 \
        as=8.38e-14 ad=1.3485e-13 ps=1.32e-06 pd=1.49e-06 nrd=1.16667 \
        nrs=1.16667 sa=1.5229e-06 sb=1e-06 sd=160n sca=35.6995 \
        scb=0.0234062 scc=0.00420468 m=(1)
mp35 (net417 mout \19\:VDD NW) g45p1svt w=(3.1e-07) l=4.5e-08 nf=1 \
        as=8.38e-14 ad=7.13e-14 ps=1.32e-06 pd=1.08e-06 nrd=1.16667 \
        nrs=1.16667 sa=1.7879e-06 sb=7.35e-07 sd=160n sca=35.6995 \
        scb=0.0234062 scc=0.00420468 m=(1)
mp36 (\4\:n20 \4\:CKb net417 NW) g45p1svt w=(3.1e-07) l=4.5e-08 nf=1 \
        as=7.13e-14 ad=5.58e-14 ps=1.08e-06 pd=9.8e-07 nrd=1.16667 \
        nrs=1.16667 sa=1.95863e-06 sb=4.6e-07 sd=160n sca=35.6995 \
        scb=0.0234062 scc=0.00420468 m=(1)
mp25 (\4\:n20 \7\:Ckbb \8\:Dbp NW) g45p1svt w=(3.1e-07) l=4.5e-08 nf=1 \
        as=7.285e-14 ad=5.58e-14 ps=1.09e-06 pd=9.8e-07 nrd=1.16667 \
        nrs=1.16667 sa=2e-06 sb=2.35e-07 sd=160n sca=35.6995 scb=0.0234062 \
        scc=0.00420468 m=(1)
ends SEDFFHQX8
// End of subcircuit definition.
