// Generated for: spectre (May  1 11:27:53 2013 )
// Library name: gsclib045_backbias
// Cell name: AOI32X1
// View name: extracted

simulator lang=spectre

subckt AOI32X1 A0 A1 A2 B0 B1 NW VDD VSS Y
mp0 (\5\:net114 \1\:A0 \3\:VDD NW) g45p1svt w=(3.9e-07) l=4.5e-08 nf=1 \
        as=5.46e-14 ad=6.24e-14 ps=1.06e-06 pd=1.1e-06 nrd=1.16667 \
        nrs=1.16667 sa=1.4e-07 sb=9.8e-07 sd=160n sca=25.2855 \
        scb=0.0288799 scc=0.00168046 m=(1)
mp1 (\5\:net114 \1\:A1 \1\:VDD NW) g45p1svt w=(3.9e-07) l=4.5e-08 nf=1 \
        as=7.23e-14 ad=6.24e-14 ps=1.43e-06 pd=1.1e-06 nrd=1.16667 \
        nrs=1.16667 sa=3.45e-07 sb=7.75e-07 sd=160n sca=15.2518 \
        scb=0.0142072 scc=0.000315834 m=(1)
mp2 (\3\:net114 \1\:A2 \1\:VDD NW) g45p1svt w=(3.9e-07) l=4.5e-08 nf=1 \
        as=7.23e-14 ad=7.02e-14 ps=1.43e-06 pd=1.14e-06 nrd=1.16667 \
        nrs=1.16667 sa=5.5e-07 sb=5.7e-07 sd=160n sca=13.3156 \
        scb=0.0107792 scc=0.000275125 m=(1)
mp4 (\1\:Y \1\:B1 \3\:net114 NW) g45p1svt w=(3.9e-07) l=4.5e-08 nf=1 \
        as=7.02e-14 ad=6.24e-14 ps=1.14e-06 pd=1.1e-06 nrd=1.16667 \
        nrs=1.16667 sa=7.75e-07 sb=3.45e-07 sd=160n sca=13.5349 \
        scb=0.0111426 scc=0.000276613 m=(1)
mp3 (\1\:Y \1\:B0 net114 NW) g45p1svt w=(3.9e-07) l=4.5e-08 nf=1 \
        as=5.46e-14 ad=6.24e-14 ps=1.06e-06 pd=1.1e-06 nrd=1.16667 \
        nrs=1.16667 sa=9.8e-07 sb=1.4e-07 sd=160n sca=16.4194 \
        scb=0.0162738 scc=0.000375337 m=(1)
C1 (A0 VSS) capacitor c=3.57474e-17
C2 (Y VSS) capacitor c=6.78777e-17
C3 (B1 VSS) capacitor c=4.64774e-17
C4 (NW VSS) capacitor c=2.17046e-16
C5 (VDD VSS) capacitor c=5.8786e-17
C6 (A2 VSS) capacitor c=4.82748e-17
C7 (B0 VSS) capacitor c=2.90827e-17
C8 (net122 VSS) capacitor c=3.28987e-18
C9 (net126 VSS) capacitor c=2.41572e-18
C10 (net118 VSS) capacitor c=2.72112e-18
C11 (net114 VSS) capacitor c=5.75361e-17
C12 (\1\:B0 VSS) capacitor c=5.07655e-17
C13 (\1\:B1 VSS) capacitor c=5.48957e-17
C14 (\1\:A2 VSS) capacitor c=7.31357e-17
C15 (\1\:A1 VSS) capacitor c=7.29659e-17
C16 (\1\:A0 VSS) capacitor c=4.70619e-17
C17 (\3\:B0 VSS) capacitor c=3.56094e-17
C18 (\3\:B1 VSS) capacitor c=3.78726e-17
C19 (\3\:A2 VSS) capacitor c=3.26621e-17
C20 (\3\:A1 VSS) capacitor c=4.25188e-17
C21 (\4\:A0 VSS) capacitor c=3.70368e-17
C22 (\2\:B0 VSS) capacitor c=4.41035e-17
C23 (\2\:B1 VSS) capacitor c=4.83542e-17
C24 (\2\:A2 VSS) capacitor c=4.84336e-17
C25 (\2\:A1 VSS) capacitor c=6.47131e-17
C26 (\3\:A0 VSS) capacitor c=1.48462e-17
C27 (\1\:Y VSS) capacitor c=7.45183e-17
C28 (\3\:net114 VSS) capacitor c=9.34153e-17
C29 (\1\:VDD VSS) capacitor c=1.67671e-16
C30 (\5\:net114 VSS) capacitor c=7.0475e-17
C31 (\3\:VDD VSS) capacitor c=4.86214e-17
C32 (\3\:Y VSS) capacitor c=9.30802e-17
C33 (\2\:A0 VSS) capacitor c=3.4943e-17
C34 (\5\:A0 VSS) capacitor c=5.26303e-17
C35 (\4\:A1 VSS) capacitor c=6.32231e-17
C36 (\6\:A1 VSS) capacitor c=4.29539e-17
C37 (\5\:A2 VSS) capacitor c=5.75819e-17
C38 (\4\:B1 VSS) capacitor c=6.4271e-17
C39 (\5\:B0 VSS) capacitor c=2.84134e-17
Rk1 (A0 \5\:A0) resistor r=0.1767 c=0
Rk9 (\2\:Y Y) resistor r=0.249 c=0
Rk10 (Y \4\:Y) resistor r=0.4035 c=0
Rk8 (B1 \4\:B1) resistor r=0.1163 c=0
Rk17 (\4\:VSS VSS) resistor r=0.3008 c=0
Rk16 (\2\:VSS \4\:VSS) resistor r=0.5158 c=0
Rk18 (VSS \6\:VSS) resistor r=0.3131 c=0
Rk19 (\2\:VDD VDD) resistor r=0.4022 c=0
Rk20 (VDD \4\:VDD) resistor r=0.2553 c=0
Rk7 (A2 \5\:A2) resistor r=0.005989 c=0
Rk11 (\4\:B0 \5\:B0) resistor r=0.001269 c=0
Rk12 (\6\:B0 B0) resistor r=0.001396 c=0
Rk13 (\5\:B0 \6\:B0) resistor r=0.01797 c=0
Rk2 (\4\:A1 \5\:A1) resistor r=0.002562 c=0
Rk3 (A1 \6\:A1) resistor r=0.002476 c=0
Rk4 (\4\:A1 \6\:A1) resistor r=0.07567 c=0
Rk14 (\2\:net114 \4\:net114) resistor r=0.4828 c=0
Rk15 (\4\:net114 \6\:net114) resistor r=0.4341 c=0
Rl1 (\1\:A0 \2\:A0) resistor r=125.803 c=0
Rl3 (\2\:A0 \4\:A0) resistor r=37.3411 c=0
Rl2 (\2\:A0 \3\:A0) resistor r=5.013 c=0
Rl8 (\1\:B1 \2\:B1) resistor r=91.5405 c=0
Rl9 (\2\:B1 \3\:B1) resistor r=53.079 c=0
Rl6 (\1\:A2 \2\:A2) resistor r=132.246 c=0
Rl7 (\2\:A2 \3\:A2) resistor r=24.2328 c=0
Rl10 (\1\:B0 \2\:B0) resistor r=110.771 c=0
Rl11 (\2\:B0 \3\:B0) resistor r=50.3716 c=0
Rl4 (\1\:A1 \2\:A1) resistor r=117.565 c=0
Rl5 (\2\:A1 \3\:A1) resistor r=29.5379 c=0
Rz1 (\3\:Y \4\:Y) resistor r=37.5 c=0
Rz2 (\1\:VSS \2\:VSS) resistor r=37.5 c=0
Rz3 (\5\:VSS \6\:VSS) resistor r=37.5 c=0
Ry1 (\1\:Y \2\:Y) resistor r=31 c=0
Ry6 (\1\:VDD \2\:VDD) resistor r=62 c=0
Ry7 (\3\:VDD \4\:VDD) resistor r=31 c=0
Ry2 (net114 \2\:net114) resistor r=20.6667 c=0
Ry3 (\3\:net114 \4\:net114) resistor r=31 c=0
Ry4 (\5\:net114 \6\:net114) resistor r=31 c=0
Rx1 (\3\:A0 \5\:A0) resistor r=45 c=0
Rx4 (\2\:B1 \4\:B1) resistor r=45 c=0
Rx3 (\2\:A2 \5\:A2) resistor r=45 c=0
Rx5 (\2\:B0 \4\:B0) resistor r=45 c=0
Rx2 (\2\:A1 \5\:A1) resistor r=45 c=0
mn0 (net122 \4\:A0 \5\:VSS VSS) g45n1svt w=(2.6e-07) l=4.5e-08 nf=1 \
        as=3.64e-14 ad=2.99e-14 ps=8e-07 pd=7.5e-07 nrd=1.16667 \
        nrs=1.16667 sa=1.4e-07 sb=9.55e-07 sd=160n sca=13.9783 \
        scb=0.013979 scc=0.000942864 m=(1)
mn1 (net126 \3\:A1 net122 VSS) g45n1svt w=(2.6e-07) l=4.5e-08 nf=1 \
        as=2.99e-14 ad=4.03e-14 ps=7.5e-07 pd=8.3e-07 nrd=1.16667 \
        nrs=1.16667 sa=3e-07 sb=7.95e-07 sd=160n sca=13.9783 scb=0.013979 \
        scc=0.000942864 m=(1)
mn2 (\3\:Y \3\:A2 net126 VSS) g45n1svt w=(2.6e-07) l=4.5e-08 nf=1 \
        as=4.03e-14 ad=5.98e-14 ps=8.3e-07 pd=9.8e-07 nrd=1.16667 \
        nrs=1.16667 sa=5e-07 sb=5.95e-07 sd=160n sca=13.9783 scb=0.013979 \
        scc=0.000942864 m=(1)
mn4 (\3\:Y \3\:B1 net118 VSS) g45n1svt w=(2.6e-07) l=4.5e-08 nf=1 \
        as=3.51e-14 ad=5.98e-14 ps=7.9e-07 pd=9.8e-07 nrd=1.16667 \
        nrs=1.16667 sa=7.75e-07 sb=3.2e-07 sd=160n sca=13.9783 \
        scb=0.013979 scc=0.000942864 m=(1)
mn3 (net118 \3\:B0 \1\:VSS VSS) g45n1svt w=(2.6e-07) l=4.5e-08 nf=1 \
        as=3.64e-14 ad=3.51e-14 ps=8e-07 pd=7.9e-07 nrd=1.16667 \
        nrs=1.16667 sa=9.55e-07 sb=1.4e-07 sd=160n sca=13.9783 \
        scb=0.013979 scc=0.000942864 m=(1)
ends AOI32X1
// End of subcircuit definition.
