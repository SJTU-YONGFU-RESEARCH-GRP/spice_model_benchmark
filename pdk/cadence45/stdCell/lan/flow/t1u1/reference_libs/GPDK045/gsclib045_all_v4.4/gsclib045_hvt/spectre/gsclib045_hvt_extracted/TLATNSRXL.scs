// Generated for: spectre (May  1 09:20:01 2013 )
// Library name: gsclib045_hvt
// Cell name: TLATNSRXL
// View name: extracted

simulator lang=spectre

subckt TLATNSRXL D GN Q QN RN SN VDD VSS
mp21 (\1\:Q \4\:qbint \22\:VDD VDD) g45p1hvt w=(2.15e-07) l=4.5e-08 nf=1 \
        as=5.73e-14 ad=3.548e-14 ps=1.47e-06 pd=7.6e-07 nrd=1.16667 \
        nrs=1.16667 sa=1.65e-07 sb=3.45e-07 sd=160n sca=49.1385 \
        scb=0.0321853 scc=0.00591609 m=(1)
mp20 (\5\:qbint \6\:qint \22\:VDD VDD) g45p1hvt w=(2.15e-07) l=4.5e-08 \
        nf=1 as=5.73e-14 ad=3.01e-14 ps=1.47e-06 pd=7.1e-07 nrd=1.16667 \
        nrs=1.16667 sa=3.7e-07 sb=1.4e-07 sd=160n sca=46.9517 scb=0.029008 \
        scc=0.00588492 m=(1)
mp22 (\3\:QN qint \20\:VDD VDD) g45p1hvt w=(2.15e-07) l=4.5e-08 nf=1 \
        as=6.295e-14 ad=3.01e-14 ps=1.63e-06 pd=7.1e-07 nrd=1.16667 \
        nrs=1.16667 sa=1.4e-07 sb=1.01663e-06 sd=160n sca=13.6743 \
        scb=0.0130525 scc=0.000590384 m=(1)
mp10 (\10\:qint \1\:SN \20\:VDD VDD) g45p1hvt w=(2.15e-07) l=4.5e-08 \
        nf=1 as=6.295e-14 ad=5.483e-14 ps=1.63e-06 pd=9.4e-07 nrd=1.16667 \
        nrs=1.16667 sa=3.55e-07 sb=8.01628e-07 sd=160n sca=13.6743 \
        scb=0.0130525 scc=0.000590384 m=(1)
mp11 (\10\:qint n5 \18\:VDD VDD) g45p1hvt w=(2.15e-07) l=4.5e-08 nf=1 \
        as=5.865e-14 ad=5.483e-14 ps=1.59e-06 pd=9.4e-07 nrd=1.16667 \
        nrs=1.16667 sa=6.55e-07 sb=5.01628e-07 sd=160n sca=13.6743 \
        scb=0.0130525 scc=0.000590384 m=(1)
mp15 (\3\:net270 \3\:RN \18\:VDD VDD) g45p1hvt w=(2.15e-07) l=4.5e-08 \
        nf=1 as=5.865e-14 ad=3.44e-14 ps=1.59e-06 pd=7.5e-07 nrd=1.16667 \
        nrs=1.16667 sa=8.5e-07 sb=3.06628e-07 sd=160n sca=13.6743 \
        scb=0.0130525 scc=0.000590384 m=(1)
mp16 (\3\:net270 \7\:qint \16\:VDD VDD) g45p1hvt w=(2.15e-07) l=4.5e-08 \
        nf=1 as=3.565e-14 ad=3.44e-14 ps=1e-06 pd=7.5e-07 nrd=1.16667 \
        nrs=1.16667 sa=1.055e-06 sb=1.01628e-07 sd=160n sca=13.6743 \
        scb=0.0130525 scc=0.000590384 m=(1)
mp17 (\8\:n5 GNb net270 VDD) g45p1hvt w=(2.15e-07) l=4.5e-08 nf=1 \
        as=2.79e-14 ad=6.88e-14 ps=7.1e-07 pd=1.07e-06 nrd=1.16667 \
        nrs=1.16667 sa=1.29767e-07 sb=9e-07 sd=160n sca=16.4667 \
        scb=0.0163489 scc=0.00112485 m=(1)
mp6 (\8\:n5 \4\:GNbb net313 VDD) g45p1hvt w=(2.15e-07) l=4.5e-08 nf=1 \
        as=1.29e-14 ad=6.88e-14 ps=5.5e-07 pd=1.07e-06 nrd=1.16667 \
        nrs=1.16667 sa=4.94767e-07 sb=5.35e-07 sd=160n sca=16.4667 \
        scb=0.0163489 scc=0.00112485 m=(1)
mp5 (net313 \4\:D \14\:VDD VDD) g45p1hvt w=(2.15e-07) l=4.5e-08 nf=1 \
        as=4.73e-14 ad=1.29e-14 ps=8.7e-07 pd=5.5e-07 nrd=1.16667 \
        nrs=1.16667 sa=5.99767e-07 sb=4.3e-07 sd=160n sca=16.4667 \
        scb=0.0163489 scc=0.00112485 m=(1)
mp3 (\5\:GNb \3\:GNbb \14\:VDD VDD) g45p1hvt w=(2.15e-07) l=4.5e-08 nf=1 \
        as=4.73e-14 ad=3.548e-14 ps=8.7e-07 pd=7.6e-07 nrd=1.16667 \
        nrs=1.16667 sa=8.64767e-07 sb=1.65e-07 sd=160n sca=16.4667 \
        scb=0.0163489 scc=0.00112485 m=(1)
mp2 (\7\:GNbb GNbp \12\:VDD VDD) g45p1hvt w=(2.15e-07) l=4.5e-08 nf=1 \
        as=4.3e-14 ad=3.87e-14 ps=8.3e-07 pd=7.9e-07 nrd=1.16667 \
        nrs=1.16667 sa=2e-07 sb=5.95e-07 sd=160n sca=11.21 scb=0.00817575 \
        scc=9.87005e-05 m=(1)
mp1 (\7\:GNbb \4\:RN \1\:VDD VDD) g45p1hvt w=(2.15e-07) l=4.5e-08 nf=1 \
        as=3.44e-14 ad=3.87e-14 ps=7.5e-07 pd=7.9e-07 nrd=1.16667 \
        nrs=1.16667 sa=4.25e-07 sb=3.7e-07 sd=160n sca=13.0884 \
        scb=0.0105751 scc=0.000113994 m=(1)
mp0 (\6\:GNbp \1\:GN \1\:VDD VDD) g45p1hvt w=(2.15e-07) l=4.5e-08 nf=1 \
        as=3.44e-14 ad=3.548e-14 ps=7.5e-07 pd=7.6e-07 nrd=1.16667 \
        nrs=1.16667 sa=6.3e-07 sb=1.65e-07 sd=160n sca=19.3888 \
        scb=0.0210602 scc=0.000665938 m=(1)
C1 (D VSS) capacitor c=5.29099e-17
C2 (SN VSS) capacitor c=5.3813e-17
C3 (Q VSS) capacitor c=2.29681e-17
C4 (GN VSS) capacitor c=5.11373e-17
C5 (VDD VSS) capacitor c=2.88191e-16
C6 (RN VSS) capacitor c=2.28794e-16
C7 (QN VSS) capacitor c=5.17794e-17
C8 (qbint VSS) capacitor c=2.14564e-17
C9 (qint VSS) capacitor c=3.93578e-17
C10 (n5 VSS) capacitor c=3.79054e-17
C11 (net354 VSS) capacitor c=6.25151e-18
C12 (GNbb VSS) capacitor c=2.22258e-17
C13 (net366 VSS) capacitor c=2.05963e-18
C14 (GNb VSS) capacitor c=3.66579e-17
C15 (GNbp VSS) capacitor c=5.26982e-17
C16 (net270 VSS) capacitor c=6.83596e-17
C17 (\1\:GN VSS) capacitor c=4.25356e-17
C18 (\4\:RN VSS) capacitor c=5.14174e-17
C19 (\3\:GNbb VSS) capacitor c=4.75953e-17
C20 (\4\:D VSS) capacitor c=7.33356e-17
C21 (\4\:GNbb VSS) capacitor c=1.10661e-16
C22 (\7\:qint VSS) capacitor c=4.51126e-17
C23 (\3\:RN VSS) capacitor c=7.20703e-17
C24 (\1\:SN VSS) capacitor c=3.33273e-17
C25 (\6\:qint VSS) capacitor c=3.62381e-17
C26 (\4\:qbint VSS) capacitor c=3.72957e-17
C27 (\3\:GN VSS) capacitor c=3.86127e-17
C28 (\6\:RN VSS) capacitor c=4.38625e-17
C29 (\3\:GNbp VSS) capacitor c=2.33986e-17
C30 (\6\:GNbb VSS) capacitor c=3.0087e-17
C31 (\3\:D VSS) capacitor c=4.24178e-17
C32 (\3\:GNb VSS) capacitor c=5.41504e-17
C33 (\5\:GNbb VSS) capacitor c=8.57101e-17
C34 (\9\:qint VSS) capacitor c=4.45137e-17
C35 (\2\:RN VSS) capacitor c=6.42694e-17
C36 (\3\:n5 VSS) capacitor c=7.02399e-17
C37 (\3\:SN VSS) capacitor c=6.513e-17
C38 (\5\:qint VSS) capacitor c=2.30166e-17
C39 (\4\:qint VSS) capacitor c=2.25244e-17
C40 (\3\:qbint VSS) capacitor c=2.72499e-17
C41 (\2\:GN VSS) capacitor c=4.7969e-17
C42 (\5\:RN VSS) capacitor c=6.47607e-17
C43 (\2\:GNbp VSS) capacitor c=5.25548e-17
C44 (\1\:D VSS) capacitor c=1.82355e-17
C45 (\4\:GNb VSS) capacitor c=4.86324e-17
C46 (\2\:GNb VSS) capacitor c=4.16269e-17
C47 (\8\:qint VSS) capacitor c=4.06216e-17
C48 (\1\:RN VSS) capacitor c=2.73768e-17
C49 (\2\:n5 VSS) capacitor c=5.50721e-17
C50 (\2\:SN VSS) capacitor c=5.03843e-17
C51 (\2\:qint VSS) capacitor c=4.17361e-17
C52 (\6\:GNbp VSS) capacitor c=6.59308e-17
C53 (\1\:VDD VSS) capacitor c=4.70855e-17
C54 (\7\:GNbb VSS) capacitor c=8.75686e-17
C55 (\12\:VDD VSS) capacitor c=2.09465e-17
C56 (\5\:GNb VSS) capacitor c=5.3552e-17
C57 (\14\:VDD VSS) capacitor c=3.86356e-17
C58 (\8\:n5 VSS) capacitor c=5.02626e-17
C59 (\16\:VDD VSS) capacitor c=2.64529e-17
C60 (\3\:net270 VSS) capacitor c=5.65789e-17
C61 (\18\:VDD VSS) capacitor c=3.29767e-18
C62 (\10\:qint VSS) capacitor c=5.33201e-17
C63 (\20\:VDD VSS) capacitor c=1.18861e-17
C64 (\3\:QN VSS) capacitor c=2.33674e-17
C65 (\5\:qbint VSS) capacitor c=3.20073e-17
C66 (\22\:VDD VSS) capacitor c=7.49345e-18
C67 (\1\:Q VSS) capacitor c=1.56054e-17
C68 (\4\:VDD VSS) capacitor c=3.56234e-17
C69 (\8\:GNbp VSS) capacitor c=2.35816e-17
C70 (\10\:GNbb VSS) capacitor c=5.72906e-17
C71 (\10\:GNb VSS) capacitor c=1.41633e-16
C72 (\4\:n5 VSS) capacitor c=9.34192e-17
C73 (\15\:qint VSS) capacitor c=2.96554e-17
C74 (\1\:QN VSS) capacitor c=7.91024e-17
C75 (\9\:qbint VSS) capacitor c=4.01343e-17
C76 (\3\:Q VSS) capacitor c=4.28267e-17
C77 (\2\:qbint VSS) capacitor c=1.33373e-17
C78 (\3\:qint VSS) capacitor c=4.03357e-17
C79 (\2\:D VSS) capacitor c=2.72368e-17
C80 (\2\:GNbb VSS) capacitor c=3.0543e-17
C81 (\7\:qbint VSS) capacitor c=3.36986e-17
C82 (\8\:qbint VSS) capacitor c=3.40181e-17
C83 (\4\:SN VSS) capacitor c=4.8275e-17
C84 (\12\:qint VSS) capacitor c=6.93074e-17
C85 (\13\:qint VSS) capacitor c=3.96923e-17
C86 (\17\:qint VSS) capacitor c=6.87316e-17
C87 (\6\:n5 VSS) capacitor c=1.38035e-16
C88 (\7\:n5 VSS) capacitor c=6.22388e-17
C89 (\5\:D VSS) capacitor c=6.2866e-17
C90 (\8\:GNb VSS) capacitor c=9.77613e-17
C91 (\9\:GNb VSS) capacitor c=6.17767e-17
C92 (\9\:GNbb VSS) capacitor c=9.01419e-17
C93 (\7\:RN VSS) capacitor c=4.38983e-17
C94 (\8\:RN VSS) capacitor c=1.94589e-16
C95 (\4\:GN VSS) capacitor c=5.81234e-17
C96 (\4\:GNbp VSS) capacitor c=5.5146e-17
C97 (\5\:GNbp VSS) capacitor c=8.14022e-17
C98 (\3\:VDD VSS) capacitor c=1.93686e-17
C99 (\6\:VDD VSS) capacitor c=2.2747e-17
C100 (\7\:VDD VSS) capacitor c=1.8673e-17
C101 (\8\:VDD VSS) capacitor c=1.22324e-17
C102 (\11\:VDD VSS) capacitor c=1.11641e-17
Rk18 (D \5\:D) resistor r=0.02903 c=0
Rk46 (\2\:VSS \4\:VSS) resistor r=0.6892 c=0
Rk47 (\4\:VSS \5\:VSS) resistor r=0.225 c=0
Rk48 (\5\:VSS \6\:VSS) resistor r=0.6703 c=0
Rk49 (\6\:VSS \7\:VSS) resistor r=0.2557 c=0
Rk50 (\5\:VSS \9\:VSS) resistor r=0.07311 c=0
Rk51 (\6\:VSS \11\:VSS) resistor r=0.4521 c=0
Rk53 (\12\:VSS VSS) resistor r=0.2123 c=0
Rk52 (\7\:VSS \12\:VSS) resistor r=0.3376 c=0
Rk54 (\7\:VSS \14\:VSS) resistor r=0.401 c=0
Rk55 (\12\:VSS \16\:VSS) resistor r=0.3655 c=0
Rk8 (\4\:SN SN) resistor r=0.1627 c=0
Rk2 (\4\:Q Q) resistor r=0.0927 c=0
Rk1 (\2\:Q \4\:Q) resistor r=0.2238 c=0
Rk27 (GN \4\:GN) resistor r=0.06224 c=0
Rk31 (\2\:VDD \3\:VDD) resistor r=0.4183 c=0
Rk32 (\3\:VDD \5\:VDD) resistor r=0.1249 c=0
Rk33 (\5\:VDD \6\:VDD) resistor r=0.24 c=0
Rk34 (\6\:VDD \7\:VDD) resistor r=0.4225 c=0
Rk35 (\7\:VDD \8\:VDD) resistor r=0.1998 c=0
Rk36 (\8\:VDD \9\:VDD) resistor r=0.2574 c=0
Rk37 (\9\:VDD \10\:VDD) resistor r=0.02983 c=0
Rk39 (\11\:VDD VDD) resistor r=0.2273 c=0
Rk38 (\10\:VDD \11\:VDD) resistor r=0.3226 c=0
Rk40 (\3\:VDD \13\:VDD) resistor r=0.1724 c=0
Rk41 (\6\:VDD \15\:VDD) resistor r=0.3378 c=0
Rk42 (\7\:VDD \17\:VDD) resistor r=0.2352 c=0
Rk43 (\8\:VDD \19\:VDD) resistor r=0.07311 c=0
Rk44 (\9\:VDD \21\:VDD) resistor r=0.07311 c=0
Rk45 (\11\:VDD \23\:VDD) resistor r=0.222 c=0
Rk25 (\7\:RN RN) resistor r=0.2616 c=0
Rk26 (RN \8\:RN) resistor r=1.6297 c=0
Rk6 (\2\:QN QN) resistor r=0.3325 c=0
Rk7 (QN \4\:QN) resistor r=0.07502 c=0
Rk3 (\6\:qbint \7\:qbint) resistor r=0.1143 c=0
Rk4 (\7\:qbint \8\:qbint) resistor r=0.1188 c=0
Rk5 (\7\:qbint \10\:qbint) resistor r=0.1083 c=0
Rk9 (\11\:qint \12\:qint) resistor r=0.2456 c=0
Rk10 (\12\:qint \13\:qint) resistor r=0.246 c=0
Rk11 (\12\:qint \14\:qint) resistor r=0.0611 c=0
Rk12 (\14\:qint \16\:qint) resistor r=0.09803 c=0
Rk13 (\14\:qint \17\:qint) resistor r=0.4002 c=0
Rk15 (\5\:n5 \6\:n5) resistor r=0.5033 c=0
Rk16 (\6\:n5 \7\:n5) resistor r=0.4294 c=0
Rk17 (\6\:n5 \9\:n5) resistor r=0.3233 c=0
Rk23 (\8\:GNbb \9\:GNbb) resistor r=0.7038 c=0
Rk24 (\9\:GNbb \11\:GNbb) resistor r=0.1521 c=0
Rk19 (\6\:GNb \7\:GNb) resistor r=0.3439 c=0
Rk20 (\7\:GNb \8\:GNb) resistor r=0.6335 c=0
Rk21 (\8\:GNb \9\:GNb) resistor r=0.2322 c=0
Rk22 (\7\:GNb \11\:GNb) resistor r=0.0319 c=0
Rk28 (\4\:GNbp \5\:GNbp) resistor r=0.388 c=0
Rk29 (\5\:GNbp \7\:GNbp) resistor r=0.4723 c=0
Rk30 (\5\:GNbp \9\:GNbp) resistor r=0.09291 c=0
Rk14 (\2\:net270 \4\:net270) resistor r=0.2421 c=0
Rl21 (\2\:D \4\:D) resistor r=95.868 c=0
Rl20 (\2\:D \3\:D) resistor r=34.3295 c=0
Rl19 (\1\:D \2\:D) resistor r=1.2713 c=0
Rl9 (\1\:SN \2\:SN) resistor r=29.5379 c=0
Rl10 (\2\:SN \3\:SN) resistor r=102.615 c=0
Rl31 (\1\:GN \2\:GN) resistor r=131.461 c=0
Rl32 (\2\:GN \3\:GN) resistor r=100.692 c=0
Rl14 (\2\:RN \3\:RN) resistor r=174.566 c=0
Rl29 (\4\:RN \5\:RN) resistor r=130.002 c=0
Rl30 (\5\:RN \6\:RN) resistor r=99.2328 c=0
Rl13 (\1\:RN \2\:RN) resistor r=37.6944 c=0
Rl3 (\2\:qbint \4\:qbint) resistor r=47.791 c=0
Rl2 (\2\:qbint \3\:qbint) resistor r=36.2526 c=0
Rl1 (qbint \2\:qbint) resistor r=2.0213 c=0
Rl15 (\7\:qint \8\:qint) resistor r=98.7687 c=0
Rl16 (\8\:qint \9\:qint) resistor r=29.5379 c=0
Rl4 (qint \2\:qint) resistor r=97.872 c=0
Rl7 (\2\:qint \5\:qint) resistor r=25.4178 c=0
Rl8 (\3\:qint \6\:qint) resistor r=60.772 c=0
Rl6 (\3\:qint \4\:qint) resistor r=28.0797 c=0
Rl5 (\2\:qint \3\:qint) resistor r=181.607 c=0
Rl11 (n5 \2\:n5) resistor r=24.2328 c=0
Rl12 (\2\:n5 \3\:n5) resistor r=173.381 c=0
Rl24 (\3\:GNbb \4\:GNbb) resistor r=280.335 c=0
Rl25 (\4\:GNbb \5\:GNbb) resistor r=216.506 c=0
Rl23 (\2\:GNbb \3\:GNbb) resistor r=93.9449 c=0
Rl26 (\2\:GNbb \6\:GNbb) resistor r=36.2526 c=0
Rl22 (GNbb \2\:GNbb) resistor r=42.6171 c=0
Rl18 (\3\:GNb \4\:GNb) resistor r=35.7713 c=0
Rl17 (GNb \2\:GNb) resistor r=71.8456 c=0
Rl27 (GNbp \2\:GNbp) resistor r=203.079 c=0
Rl28 (\2\:GNbp \3\:GNbp) resistor r=26.1559 c=0
Rz11 (\1\:VSS \2\:VSS) resistor r=75 c=0
Rz12 (\8\:VSS \9\:VSS) resistor r=75 c=0
Rz13 (\10\:VSS \11\:VSS) resistor r=75 c=0
Rz14 (\13\:VSS \14\:VSS) resistor r=75 c=0
Rz15 (\15\:VSS \16\:VSS) resistor r=75 c=0
Rz1 (\3\:Q \4\:Q) resistor r=75 c=0
Rz9 (\4\:VDD \5\:VDD) resistor r=6.8182 c=0
Rz10 (\4\:VDD \10\:VDD) resistor r=6.25 c=0
Rz3 (\1\:QN \2\:QN) resistor r=75 c=0
Rz2 (\9\:qbint \10\:qbint) resistor r=75 c=0
Rz4 (\15\:qint \16\:qint) resistor r=75 c=0
Rz5 (\4\:n5 \5\:n5) resistor r=75 c=0
Rz7 (\10\:GNbb \11\:GNbb) resistor r=75 c=0
Rz6 (\10\:GNb \11\:GNb) resistor r=75 c=0
Rz8 (\8\:GNbp \9\:GNbp) resistor r=75 c=0
Ry18 (\3\:VSS \4\:VSS) resistor r=5.6364 c=0
Ry19 (\3\:VSS \7\:VSS) resistor r=5.1667 c=0
Ry1 (\1\:Q \2\:Q) resistor r=62 c=0
Ry11 (\1\:VDD \2\:VDD) resistor r=62 c=0
Ry12 (\12\:VDD \13\:VDD) resistor r=62 c=0
Ry13 (\14\:VDD \15\:VDD) resistor r=62 c=0
Ry14 (\16\:VDD \17\:VDD) resistor r=62 c=0
Ry15 (\18\:VDD \19\:VDD) resistor r=62 c=0
Ry16 (\20\:VDD \21\:VDD) resistor r=62 c=0
Ry17 (\22\:VDD \23\:VDD) resistor r=62 c=0
Ry3 (\3\:QN \4\:QN) resistor r=62 c=0
Ry2 (\5\:qbint \6\:qbint) resistor r=62 c=0
Ry4 (\10\:qint \11\:qint) resistor r=62 c=0
Ry7 (\8\:n5 \9\:n5) resistor r=62 c=0
Ry9 (\7\:GNbb \8\:GNbb) resistor r=62 c=0
Ry8 (\5\:GNb \6\:GNb) resistor r=62 c=0
Ry10 (\6\:GNbp \7\:GNbp) resistor r=62 c=0
Ry5 (net270 \2\:net270) resistor r=62 c=0
Ry6 (\3\:net270 \4\:net270) resistor r=62 c=0
Rx6 (\1\:D \5\:D) resistor r=45 c=0
Rx2 (\2\:SN \4\:SN) resistor r=45 c=0
Rx12 (\2\:GN \4\:GN) resistor r=45 c=0
Rx10 (\5\:RN \7\:RN) resistor r=45 c=0
Rx11 (\1\:RN \8\:RN) resistor r=45 c=0
Rx1 (qbint \8\:qbint) resistor r=45 c=0
Rx3 (\2\:qint \13\:qint) resistor r=45 c=0
Rx4 (\8\:qint \17\:qint) resistor r=45 c=0
Rx5 (\2\:n5 \7\:n5) resistor r=45 c=0
Rx9 (GNbb \9\:GNbb) resistor r=45 c=0
Rx7 (\4\:GNb \8\:GNb) resistor r=45 c=0
Rx8 (\2\:GNb \9\:GNb) resistor r=45 c=0
Rx13 (\2\:GNbp \4\:GNbp) resistor r=45 c=0
mn21 (\3\:Q \3\:qbint \15\:VSS VSS) g45n1hvt w=(1.45e-07) l=4.5e-08 nf=1 \
        as=2.32e-14 ad=2.392e-14 ps=6.1e-07 pd=6.2e-07 nrd=1.16667 \
        nrs=1.16667 sa=1.65e-07 sb=3.45e-07 sd=160n sca=23.279 \
        scb=0.0230742 scc=0.00267719 m=(1)
mn20 (\9\:qbint \4\:qint \15\:VSS VSS) g45n1hvt w=(1.45e-07) l=4.5e-08 \
        nf=1 as=2.32e-14 ad=2.03e-14 ps=6.1e-07 pd=5.7e-07 nrd=1.16667 \
        nrs=1.16667 sa=3.7e-07 sb=1.4e-07 sd=160n sca=23.279 scb=0.0230742 \
        scc=0.00267719 m=(1)
mn22 (\1\:QN \5\:qint \13\:VSS VSS) g45n1hvt w=(1.45e-07) l=4.5e-08 nf=1 \
        as=2.465e-14 ad=2.03e-14 ps=6.3e-07 pd=5.7e-07 nrd=1.16667 \
        nrs=1.16667 sa=1.4e-07 sb=4.6e-07 sd=160n sca=20.6444 \
        scb=0.0212501 scc=0.00213091 m=(1)
mn10 (net342 \3\:SN \13\:VSS VSS) g45n1hvt w=(1.45e-07) l=4.5e-08 nf=1 \
        as=2.465e-14 ad=8.7e-15 ps=6.3e-07 pd=4.1e-07 nrd=1.16667 \
        nrs=1.16667 sa=3.55e-07 sb=2.45e-07 sd=160n sca=20.6444 \
        scb=0.0212501 scc=0.00213091 m=(1)
mn11 (\15\:qint \3\:n5 net342 VSS) g45n1hvt w=(1.45e-07) l=4.5e-08 nf=1 \
        as=8.7e-15 ad=2.03e-14 ps=4.1e-07 pd=5.7e-07 nrd=1.16667 \
        nrs=1.16667 sa=4.6e-07 sb=1.4e-07 sd=160n sca=20.6444 \
        scb=0.0212501 scc=0.00213091 m=(1)
mn15 (net350 \2\:RN \10\:VSS VSS) g45n1hvt w=(1.45e-07) l=4.5e-08 nf=1 \
        as=2.03e-14 ad=8.7e-15 ps=5.7e-07 pd=4.1e-07 nrd=1.16667 \
        nrs=1.16667 sa=1.4e-07 sb=1.47e-06 sd=160n sca=22.3376 \
        scb=0.0224607 scc=0.00248252 m=(1)
mn16 (net354 \9\:qint net350 VSS) g45n1hvt w=(1.45e-07) l=4.5e-08 nf=1 \
        as=8.7e-15 ad=6.743e-14 ps=4.1e-07 pd=1.22e-06 nrd=1.16667 \
        nrs=1.16667 sa=2.45e-07 sb=1.365e-06 sd=160n sca=22.3376 \
        scb=0.0224607 scc=0.00248252 m=(1)
mn17 (\4\:n5 \5\:GNbb net354 VSS) g45n1hvt w=(1.45e-07) l=4.5e-08 nf=1 \
        as=6.743e-14 ad=2.32e-14 ps=1.22e-06 pd=6.1e-07 nrd=1.16667 \
        nrs=1.16667 sa=7.55e-07 sb=8.55e-07 sd=160n sca=22.3376 \
        scb=0.0224607 scc=0.00248252 m=(1)
mn6 (\4\:n5 \3\:GNb net366 VSS) g45n1hvt w=(1.45e-07) l=4.5e-08 nf=1 \
        as=1.668e-14 ad=2.32e-14 ps=5.2e-07 pd=6.1e-07 nrd=1.16667 \
        nrs=1.16667 sa=9.6e-07 sb=6.5e-07 sd=160n sca=22.3376 \
        scb=0.0224607 scc=0.00248252 m=(1)
mn5 (net366 \3\:D \8\:VSS VSS) g45n1hvt w=(1.45e-07) l=4.5e-08 nf=1 \
        as=8.35e-14 ad=1.668e-14 ps=1.59e-06 pd=5.2e-07 nrd=1.16667 \
        nrs=1.16667 sa=1.12e-06 sb=4.9e-07 sd=160n sca=22.3376 \
        scb=0.0224607 scc=0.00248252 m=(1)
mn3 (\10\:GNb \6\:GNbb \8\:VSS VSS) g45n1hvt w=(1.45e-07) l=4.5e-08 nf=1 \
        as=8.35e-14 ad=3.263e-14 ps=1.59e-06 pd=7.4e-07 nrd=1.16667 \
        nrs=1.16667 sa=1.385e-06 sb=2.25e-07 sd=160n sca=22.3376 \
        scb=0.0224607 scc=0.00248252 m=(1)
mn2 (\10\:GNbb \3\:GNbp net326 VSS) g45n1hvt w=(1.45e-07) l=4.5e-08 nf=1 \
        as=2.61e-14 ad=5.51e-14 ps=6.5e-07 pd=1.05e-06 nrd=1.16667 \
        nrs=1.16667 sa=3.8e-07 sb=6.25e-07 sd=160n sca=14.7993 \
        scb=0.0157101 scc=0.000964917 m=(1)
mn1 (net326 \6\:RN \1\:VSS VSS) g45n1hvt w=(1.45e-07) l=4.5e-08 nf=1 \
        as=2.32e-14 ad=2.61e-14 ps=6.1e-07 pd=6.5e-07 nrd=1.16667 \
        nrs=1.16667 sa=6.05e-07 sb=4e-07 sd=160n sca=14.7993 scb=0.0157101 \
        scc=0.000964917 m=(1)
mn0 (\8\:GNbp \3\:GN \1\:VSS VSS) g45n1hvt w=(1.45e-07) l=4.5e-08 nf=1 \
        as=2.32e-14 ad=2.828e-14 ps=6.1e-07 pd=6.8e-07 nrd=1.16667 \
        nrs=1.16667 sa=8.1e-07 sb=1.95e-07 sd=160n sca=14.7993 \
        scb=0.0157101 scc=0.000964917 m=(1)
ends TLATNSRXL
// End of subcircuit definition.
