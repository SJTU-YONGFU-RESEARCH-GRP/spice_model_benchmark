// gsclib045_backbias/SDFFSX4/schematic

simulator lang=spectre

subckt SDFFSX4 CK D Q QN SE SI SN VDD VSS NW
mn51 (net518 qbint net521 VSS) g45n1svt w=(145n) l=45n nf=1 m=(1)
mn52 (n35 CKb net518 VSS) g45n1svt w=(145n) l=45n nf=1 m=(1)
mn50 (net521 SN VSS VSS) g45n1svt w=(145n) l=45n nf=1 m=(1)
mn13 (net506 SI VSS VSS) g45n1svt w=(145n) l=45n nf=1 m=(1)
mn14 (Db SE net506 VSS) g45n1svt w=(145n) l=45n nf=1 m=(1)
mn12 (Db SEb net494 VSS) g45n1svt w=(145n) l=45n nf=1 m=(1)
mn11 (net494 D VSS VSS) g45n1svt w=(145n) l=45n nf=1 m=(1)
mn57 (QN net492 VSS VSS) g45n1svt w=(1.04u) l=45n nf=1 m=(1)
mn55 (Q qbint VSS VSS) g45n1svt w=(1.04u) l=45n nf=1 m=(1)
mn31 (mout n20 net442 VSS) g45n1svt w=(145n) l=45n nf=1 m=(1)
mn35 (net478 mout VSS VSS) g45n1svt w=(145n) l=45n nf=1 m=(1)
mn36 (n20 CKbb net478 VSS) g45n1svt w=(145n) l=45n nf=1 m=(1)
mn20 (CKb CK VSS VSS) g45n1svt w=(145n) l=45n nf=1 m=(1)
mn45 (qbint n35 VSS VSS) g45n1svt w=(410n) l=45n nf=1 m=(1)
mn56 (net492 qbint VSS VSS) g45n1svt w=(260n) l=45n nf=1 m=(1)
mn21 (CKbb CKb VSS VSS) g45n1svt w=(145n) l=45n nf=1 m=(1)
mn40 (n35 CKbb mout VSS) g45n1svt w=(145n) l=45n nf=1 m=(1)
mn10 (SEb SE VSS VSS) g45n1svt w=(145n) l=45n nf=1 m=(1)
mn25 (Db CKb n20 VSS) g45n1svt w=(145n) l=45n nf=1 m=(1)
mn30 (net442 SN VSS VSS) g45n1svt w=(145n) l=45n nf=1 m=(1)
mp14 (Db SEb net441 NW) g45p1svt w=(215n) l=45n nf=1 m=(1)
mp13 (net441 SI VDD NW) g45p1svt w=(215n) l=45n nf=1 m=(1)
mp12 (Db SE net433 NW) g45p1svt w=(215n) l=45n nf=1 m=(1)
mp11 (net433 D VDD NW) g45p1svt w=(215n) l=45n nf=1 m=(1)
mp57 (QN net492 VDD NW) g45p1svt w=(1.56u) l=45n nf=1 m=(1)
mp55 (Q qbint VDD NW) g45p1svt w=(1.56u) l=45n nf=1 m=(1)
mp36 (n20 CKb net417 NW) g45p1svt w=(215n) l=45n nf=1 m=(1)
mp35 (net417 mout VDD NW) g45p1svt w=(215n) l=45n nf=1 m=(1)
mp20 (CKb CK VDD NW) g45p1svt w=(215n) l=45n nf=1 m=(1)
mp52 (n35 CKbb net405 NW) g45p1svt w=(215n) l=45n nf=1 m=(1)
mp51 (net405 qbint VDD NW) g45p1svt w=(215n) l=45n nf=1 m=(1)
mp50 (net405 SN VDD NW) g45p1svt w=(215n) l=45n nf=1 m=(1)
mp45 (qbint n35 VDD NW) g45p1svt w=(620n) l=45n nf=1 m=(1)
mp56 (net492 qbint VDD NW) g45p1svt w=(390n) l=45n nf=1 m=(1)
mp21 (CKbb CKb VDD NW) g45p1svt w=(215n) l=45n nf=1 m=(1)
mp40 (n35 CKb mout NW) g45p1svt w=(215n) l=45n nf=1 m=(1)
mp30 (mout SN VDD NW) g45p1svt w=(215n) l=45n nf=1 m=(1)
mp31 (mout n20 VDD NW) g45p1svt w=(215n) l=45n nf=1 m=(1)
mp25 (n20 CKbb Db NW) g45p1svt w=(215n) l=45n nf=1 m=(1)
mp10 (SEb SE VDD NW) g45p1svt w=(215n) l=45n nf=1 m=(1)
ends SDFFSX4
