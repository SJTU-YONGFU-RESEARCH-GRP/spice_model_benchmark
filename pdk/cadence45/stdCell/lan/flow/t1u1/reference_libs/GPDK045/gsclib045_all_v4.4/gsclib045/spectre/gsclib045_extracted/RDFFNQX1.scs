// Generated for: spectre (May  1 08:12:06 2013 )
// Library name: gsclib045
// Cell name: RDFFNQX1
// View name: extracted

simulator lang=spectre

subckt RDFFNQX1 CKN D ExtVDD Q RT VDD VSS
mp21 (\13\:CKNbb \7\:CKNb \11\:VDD VDD) g45p1svt w=(2.15e-07) l=4.5e-08 \
        nf=1 as=3.44e-14 ad=3.01e-14 ps=7.5e-07 pd=7.1e-07 nrd=1.16667 \
        nrs=1.16667 sa=1.4e-07 sb=3.45e-07 sd=160n sca=16.9543 \
        scb=0.0169944 scc=0.00104371 m=(1)
PM3 (\15\:n35g \4\:RTb net205 ExtVDD) g45p1svt w=(2.15e-07) l=4.5e-08 \
        nf=1 as=3.01e-14 ad=1.29e-14 ps=7.1e-07 pd=5.5e-07 nrd=1.16667 \
        nrs=1.16667 sa=8.7e-07 sb=1.4e-07 sd=160n sca=25.2796 \
        scb=0.0259458 scc=0.00265434 m=(1)
mp32 (\5\:mout \3\:n20 \13\:VDD VDD) g45p1svt w=(2.15e-07) l=4.5e-08 \
        nf=1 as=3.44e-14 ad=3.44e-14 ps=7.5e-07 pd=7.5e-07 nrd=1.16667 \
        nrs=1.16667 sa=4.5e-07 sb=3.45e-07 sd=160n sca=13.5042 \
        scb=0.0131605 scc=0.000288614 m=(1)
mp35 (n31 mout \13\:VDD VDD) g45p1svt w=(2.15e-07) l=4.5e-08 nf=1 \
        as=1.29e-14 ad=3.44e-14 ps=5.5e-07 pd=7.5e-07 nrd=1.16667 \
        nrs=1.16667 sa=2.45e-07 sb=5.5e-07 sd=160n sca=11.2521 \
        scb=0.00925046 scc=0.000235422 m=(1)
mp25 (n22 \4\:D \15\:VDD VDD) g45p1svt w=(2.15e-07) l=4.5e-08 nf=1 \
        as=3.01e-14 ad=1.29e-14 ps=7.1e-07 pd=5.5e-07 nrd=1.16667 \
        nrs=1.16667 sa=1.4e-07 sb=2.45e-07 sd=160n sca=20.5104 \
        scb=0.0232403 scc=0.00120911 m=(1)
mp26 (\9\:n20 \4\:CKNb n22 VDD) g45p1svt w=(2.15e-07) l=4.5e-08 nf=1 \
        as=1.29e-14 ad=3.01e-14 ps=5.5e-07 pd=7.1e-07 nrd=1.16667 \
        nrs=1.16667 sa=2.45e-07 sb=1.4e-07 sd=160n sca=17.9596 scb=0.01876 \
        scc=0.00106467 m=(1)
mp36 (\13\:n20 \6\:CKNbb n31 VDD) g45p1svt w=(2.15e-07) l=4.5e-08 nf=1 \
        as=1.29e-14 ad=3.01e-14 ps=5.5e-07 pd=7.1e-07 nrd=1.16667 \
        nrs=1.16667 sa=1.4e-07 sb=6.55e-07 sd=160n sca=11.0284 \
        scb=0.00890057 scc=0.000234415 m=(1)
mp20 (\20\:CKNb \4\:CKN \11\:VDD VDD) g45p1svt w=(2.15e-07) l=4.5e-08 \
        nf=1 as=3.44e-14 ad=3.01e-14 ps=7.5e-07 pd=7.1e-07 nrd=1.16667 \
        nrs=1.16667 sa=3.45e-07 sb=1.4e-07 sd=160n sca=21.0614 \
        scb=0.0241824 scc=0.00125996 m=(1)
mp40 (\4\:n35 \8\:CKNbb \5\:mout VDD) g45p1svt w=(2.15e-07) l=4.5e-08 \
        nf=1 as=3.44e-14 ad=3.01e-14 ps=7.5e-07 pd=7.1e-07 nrd=1.16667 \
        nrs=1.16667 sa=6.55e-07 sb=1.4e-07 sd=160n sca=25.0692 \
        scb=0.0290985 scc=0.00202261 m=(1)
PM0 (\6\:n35g \6\:RT \10\:n35 ExtVDD) g45p1svt w=(2.15e-07) l=4.5e-08 \
        nf=1 as=3.01e-14 ad=3.01e-14 ps=7.1e-07 pd=7.1e-07 nrd=1.16667 \
        nrs=1.16667 sa=1.4e-07 sb=1.4e-07 sd=160n sca=25.8707 \
        scb=0.0268423 scc=0.00266528 m=(1)
PM1 (\14\:qbint \3\:n35g \1\:ExtVDD ExtVDD) g45p1svt w=(2.15e-07) \
        l=4.5e-08 nf=1 as=3.3457e-13 ad=3.01e-14 ps=3.53e-06 pd=7.1e-07 \
        nrd=1.16667 nrs=1.16667 sa=1.4e-07 sb=8.7e-07 sd=160n sca=25.2796 \
        scb=0.0259458 scc=0.00265434 m=(1)
PM2 (net205 \4\:qbint \1\:ExtVDD ExtVDD) g45p1svt w=(2.15e-07) l=4.5e-08 \
        nf=1 as=3.3457e-13 ad=1.29e-14 ps=3.53e-06 pd=5.5e-07 nrd=1.16667 \
        nrs=1.16667 sa=7.65e-07 sb=2.45e-07 sd=160n sca=14.5295 \
        scb=0.0144143 scc=0.000486924 m=(1)
mp45 (\6\:RTb \8\:RT \1\:ExtVDD ExtVDD) g45p1svt w=(2.15e-07) l=4.5e-08 \
        nf=1 as=3.3457e-13 ad=3.01e-14 ps=3.53e-06 pd=7.1e-07 nrd=1.16667 \
        nrs=1.16667 sa=3.1e-07 sb=1.4e-07 sd=160n sca=24.1603 \
        scb=0.0255449 scc=0.00228436 m=(1)
mp53 (\15\:n35 \14\:CKNb net082 VDD) g45p1svt w=(2.15e-07) l=4.5e-08 nf=1 \
        as=1.29e-14 ad=3.01e-14 ps=5.5e-07 pd=7.1e-07 nrd=1.16667 \
        nrs=1.16667 sa=1.4e-07 sb=2.45e-07 sd=160n sca=30.843 \
        scb=0.0336528 scc=0.00282492 m=(1)
mp52 (net082 \10\:qbint \9\:VDD VDD) g45p1svt w=(2.15e-07) l=4.5e-08 \
        nf=1 as=3.01e-14 ad=1.29e-14 ps=7.1e-07 pd=5.5e-07 nrd=1.16667 \
        nrs=1.16667 sa=2.45e-07 sb=1.4e-07 sd=160n sca=21.6956 \
        scb=0.0252605 scc=0.000723352 m=(1)
C1 (CKN VSS) capacitor c=5.51445e-17
C2 (ExtVDD VSS) capacitor c=2.21192e-16
C3 (RT VSS) capacitor c=3.58056e-17
C4 (D VSS) capacitor c=2.92319e-17
C5 (VDD VSS) capacitor c=4.26897e-16
C6 (Q VSS) capacitor c=3.59542e-17
C7 (CKNb VSS) capacitor c=2.3254e-17
C8 (n20 VSS) capacitor c=4.57422e-17
C9 (CKNbb VSS) capacitor c=5.0043e-17
C10 (mout VSS) capacitor c=5.67774e-17
C11 (n35 VSS) capacitor c=1.46575e-16
C12 (n35g VSS) capacitor c=1.8069e-17
C13 (qbint VSS) capacitor c=4.79354e-17
C14 (RTb VSS) capacitor c=4.12189e-17
C15 (\9\:qbint VSS) capacitor c=2.81469e-17
C16 (\10\:qbint VSS) capacitor c=2.00213e-16
C17 (\14\:CKNb VSS) capacitor c=8.74062e-17
C18 (\4\:RTb VSS) capacitor c=9.88336e-17
C19 (\8\:RT VSS) capacitor c=2.27172e-17
C20 (\4\:qbint VSS) capacitor c=6.90373e-17
C21 (\3\:n35g VSS) capacitor c=5.05167e-17
C22 (\6\:RT VSS) capacitor c=7.79668e-17
C23 (\8\:CKNbb VSS) capacitor c=3.01385e-17
C24 (\4\:CKN VSS) capacitor c=3.29587e-17
C25 (\3\:n20 VSS) capacitor c=5.79291e-17
C26 (\7\:CKNb VSS) capacitor c=3.03983e-17
C27 (\6\:CKNbb VSS) capacitor c=9.49006e-17
C28 (\4\:CKNb VSS) capacitor c=1.29904e-16
C29 (\4\:D VSS) capacitor c=4.94075e-17
C30 (\6\:qbint VSS) capacitor c=3.15278e-17
C31 (\11\:qbint VSS) capacitor c=9.13916e-17
C32 (\3\:CKNbb VSS) capacitor c=3.42556e-16
C33 (\7\:RT VSS) capacitor c=1.68407e-16
C34 (\1\:RT VSS) capacitor c=4.50975e-17
C35 (\5\:qbint VSS) capacitor c=3.91272e-17
C36 (\5\:n35g VSS) capacitor c=2.84973e-17
C37 (\12\:CKNb VSS) capacitor c=3.16056e-17
C38 (\1\:CKN VSS) capacitor c=4.06142e-17
C39 (\6\:n20 VSS) capacitor c=5.17594e-17
C40 (\6\:CKNb VSS) capacitor c=2.93421e-17
C41 (\3\:mout VSS) capacitor c=4.9392e-17
C42 (\13\:CKNb VSS) capacitor c=5.01877e-17
C43 (\2\:CKNbb VSS) capacitor c=7.79725e-17
C44 (\1\:D VSS) capacitor c=6.7744e-17
C45 (\15\:CKNb VSS) capacitor c=5.69401e-17
C46 (\8\:CKNb VSS) capacitor c=1.28647e-16
C47 (\8\:qbint VSS) capacitor c=1.09082e-16
C48 (\3\:RT VSS) capacitor c=1.66373e-16
C49 (\3\:RTb VSS) capacitor c=7.33659e-17
C50 (\4\:RT VSS) capacitor c=4.31935e-17
C51 (\2\:RT VSS) capacitor c=3.90797e-17
C52 (\3\:qbint VSS) capacitor c=3.57782e-17
C53 (\2\:RTb VSS) capacitor c=4.01259e-17
C54 (\2\:n35 VSS) capacitor c=1.6606e-16
C55 (\4\:n35g VSS) capacitor c=6.76908e-17
C56 (\3\:n35 VSS) capacitor c=4.0648e-17
C57 (\3\:CKN VSS) capacitor c=2.75759e-17
C58 (\2\:mout VSS) capacitor c=3.87945e-17
C59 (\4\:mout VSS) capacitor c=4.04119e-17
C60 (\7\:CKNbb VSS) capacitor c=4.26807e-17
C61 (\5\:n20 VSS) capacitor c=4.33898e-17
C62 (\2\:n20 VSS) capacitor c=4.54609e-17
C63 (\5\:CKNb VSS) capacitor c=6.1397e-17
C64 (\11\:CKNb VSS) capacitor c=3.02463e-17
C65 (\3\:D VSS) capacitor c=1.40779e-17
C66 (\1\:VDD VSS) capacitor c=4.43031e-17
C67 (\9\:VDD VSS) capacitor c=2.51518e-17
C68 (\3\:Q VSS) capacitor c=6.12378e-17
C69 (\15\:n35 VSS) capacitor c=4.30656e-17
C70 (\15\:n35g VSS) capacitor c=4.76792e-17
C71 (\6\:RTb VSS) capacitor c=5.78003e-17
C72 (\1\:ExtVDD VSS) capacitor c=2.89832e-16
C73 (\10\:n35 VSS) capacitor c=5.10813e-17
C74 (\14\:qbint VSS) capacitor c=6.75917e-17
C75 (\6\:n35g VSS) capacitor c=8.73995e-17
C76 (\4\:n35 VSS) capacitor c=4.01112e-17
C77 (\20\:CKNb VSS) capacitor c=6.24097e-17
C78 (\5\:mout VSS) capacitor c=5.93955e-17
C79 (\11\:VDD VSS) capacitor c=7.05112e-17
C80 (\13\:VDD VSS) capacitor c=5.98169e-17
C81 (\13\:CKNbb VSS) capacitor c=6.24734e-17
C82 (\13\:n20 VSS) capacitor c=4.59827e-17
C83 (\9\:n20 VSS) capacitor c=9.23114e-17
C84 (\15\:VDD VSS) capacitor c=5.4525e-17
C85 (\1\:Q VSS) capacitor c=4.00989e-17
C86 (\18\:n35 VSS) capacitor c=6.04075e-17
C87 (\11\:n35g VSS) capacitor c=2.94407e-17
C88 (\10\:RTb VSS) capacitor c=5.97219e-17
C89 (\13\:n35 VSS) capacitor c=5.57904e-17
C90 (\16\:qbint VSS) capacitor c=2.37057e-17
C91 (\9\:n35g VSS) capacitor c=7.65118e-17
C92 (\7\:n35 VSS) capacitor c=4.49992e-17
C93 (\22\:CKNb VSS) capacitor c=3.65793e-17
C94 (\10\:mout VSS) capacitor c=5.24306e-17
C95 (\9\:CKNbb VSS) capacitor c=3.73944e-17
C96 (\16\:n20 VSS) capacitor c=4.3714e-17
C97 (\7\:n20 VSS) capacitor c=6.81031e-17
C98 (\2\:D VSS) capacitor c=4.03723e-17
C99 (\2\:CKNb VSS) capacitor c=2.84289e-17
C100 (\3\:CKNb VSS) capacitor c=5.85606e-17
C101 (\4\:n20 VSS) capacitor c=4.72641e-17
C102 (\2\:CKN VSS) capacitor c=3.53825e-17
C103 (VDD VSS) capacitor c=2.41634e-16
C104 (\2\:n35g VSS) capacitor c=3.01679e-17
C105 (\2\:qbint VSS) capacitor c=4.10267e-17
C106 (\5\:RT VSS) capacitor c=5.37228e-17
C107 (\9\:CKNb VSS) capacitor c=1.09963e-16
C108 (\10\:CKNb VSS) capacitor c=4.22697e-17
C109 (\4\:CKNbb VSS) capacitor c=2.47461e-16
C110 (\5\:CKNbb VSS) capacitor c=4.20394e-17
C111 (\7\:qbint VSS) capacitor c=2.77134e-17
C112 (\16\:CKNb VSS) capacitor c=9.74788e-17
C113 (\17\:CKNb VSS) capacitor c=8.61301e-17
C114 (\6\:D VSS) capacitor c=4.17815e-17
C115 (\11\:n20 VSS) capacitor c=4.54878e-17
C116 (\12\:n20 VSS) capacitor c=5.21513e-17
C117 (\15\:n20 VSS) capacitor c=5.26182e-17
C118 (\12\:CKNbb VSS) capacitor c=8.02616e-17
C119 (\15\:CKNbb VSS) capacitor c=4.52883e-17
C120 (\7\:mout VSS) capacitor c=4.30195e-17
C121 (\8\:mout VSS) capacitor c=2.73491e-17
C122 (\9\:mout VSS) capacitor c=2.48842e-17
C123 (\12\:mout VSS) capacitor c=2.42248e-17
C124 (\7\:CKN VSS) capacitor c=4.48461e-17
C125 (\18\:CKNb VSS) capacitor c=5.62056e-17
C126 (\19\:CKNb VSS) capacitor c=4.41685e-17
C127 (\6\:n35 VSS) capacitor c=6.87249e-17
C128 (\9\:n35 VSS) capacitor c=6.19157e-17
C129 (\8\:n35g VSS) capacitor c=3.22416e-17
C130 (\12\:n35 VSS) capacitor c=6.04304e-17
C131 (\12\:qbint VSS) capacitor c=8.8693e-17
C132 (\13\:qbint VSS) capacitor c=1.10997e-16
C133 (\13\:n35g VSS) capacitor c=1.14944e-16
C134 (\14\:n35g VSS) capacitor c=1.16603e-16
C135 (\9\:RT VSS) capacitor c=6.20703e-17
C136 (\10\:RT VSS) capacitor c=6.14048e-17
C137 (\5\:RTb VSS) capacitor c=3.70072e-17
C138 (\8\:RTb VSS) capacitor c=1.11181e-16
C139 (\9\:RTb VSS) capacitor c=6.96047e-17
C140 (\11\:RT VSS) capacitor c=4.14893e-17
C141 (\18\:qbint VSS) capacitor c=1.82217e-17
C142 (\19\:qbint VSS) capacitor c=3.088e-17
C143 (\24\:CKNb VSS) capacitor c=1.32741e-16
C144 (\25\:CKNb VSS) capacitor c=9.79288e-17
C145 (\17\:n35 VSS) capacitor c=6.16376e-17
C146 (\3\:VDD VSS) capacitor c=1.16048e-17
C147 (\5\:VDD VSS) capacitor c=1.0766e-16
C148 (\6\:VDD VSS) capacitor c=7.67536e-17
C149 (\8\:VDD VSS) capacitor c=3.3255e-17
Rk19 (CKN \5\:CKN) resistor r=0.002041 c=0
Rk20 (\5\:CKN \6\:CKN) resistor r=0.004083 c=0
Rk21 (CKN \7\:CKN) resistor r=0.004083 c=0
Rk22 (\5\:CKN \7\:CKN) resistor r=0.02231 c=0
Rk35 (ExtVDD ExtVDD) resistor r=0.002059 c=0
Rk33 (\2\:ExtVDD ExtVDD) resistor r=0.02212 c=0
Rk36 (ExtVDD \5\:ExtVDD) resistor r=0.02011 c=0
Rk37 (ExtVDD \6\:ExtVDD) resistor r=0.1494 c=0
Rk38 (\7\:ExtVDD \8\:ExtVDD) resistor r=0.02873 c=0
Rk45 (\9\:RT \10\:RT) resistor r=0.4468 c=0
Rk50 (RT \11\:RT) resistor r=0.01698 c=0
Rk2 (\5\:D \6\:D) resistor r=0.006772 c=0
Rk3 (\7\:D D) resistor r=0.006772 c=0
Rk4 (\6\:D \7\:D) resistor r=0.01902 c=0
Rk68 (\2\:VDD \3\:VDD) resistor r=0.4107 c=0
Rk70 (\5\:VDD VDD) resistor r=0.9256 c=0
Rk69 (\3\:VDD \5\:VDD) resistor r=0.07282 c=0
Rk71 (VDD \6\:VDD) resistor r=0.6412 c=0
Rk76 (\8\:VDD VDD) resistor r=0.1807 c=0
Rk72 (\6\:VDD \8\:VDD) resistor r=0.05488 c=0
Rk73 (\3\:VDD \10\:VDD) resistor r=0.2962 c=0
Rk74 (\6\:VDD \12\:VDD) resistor r=0.4008 c=0
Rk75 (\8\:VDD \14\:VDD) resistor r=0.356 c=0
Rk77 (VDD \16\:VDD) resistor r=0.5148 c=0
Rk55 (\2\:Q Q) resistor r=0.1571 c=0
Rk56 (Q \4\:Q) resistor r=0.3179 c=0
Rk57 (\2\:VSS \4\:VSS) resistor r=0.675 c=0
Rk58 (\4\:VSS \5\:VSS) resistor r=0.3117 c=0
Rk60 (\6\:VSS VSS) resistor r=0.07383 c=0
Rk59 (\5\:VSS \6\:VSS) resistor r=0.2076 c=0
Rk61 (VSS \7\:VSS) resistor r=0.5449 c=0
Rk63 (\8\:VSS VSS) resistor r=0.02184 c=0
Rk62 (\7\:VSS \8\:VSS) resistor r=0.09635 c=0
Rk64 (VSS \10\:VSS) resistor r=0.5976 c=0
Rk65 (\5\:VSS \12\:VSS) resistor r=0.1888 c=0
Rk66 (\6\:VSS \14\:VSS) resistor r=0.1939 c=0
Rk67 (\8\:VSS \16\:VSS) resistor r=0.2401 c=0
Rk78 (\18\:VSS \20\:VSS) resistor r=0.6464 c=0
Rk80 (\21\:VSS VSS) resistor r=0.3288 c=0
Rk79 (\20\:VSS \21\:VSS) resistor r=0.2647 c=0
Rk82 (\22\:VSS VSS) resistor r=0.1186 c=0
Rk81 (VSS \22\:VSS) resistor r=0.5449 c=0
Rk83 (VSS \24\:VSS) resistor r=0.3453 c=0
Rk84 (\21\:VSS \26\:VSS) resistor r=0.3471 c=0
Rk1 (\16\:CKNb \17\:CKNb) resistor r=0.8341 c=0
Rk23 (\18\:CKNb \19\:CKNb) resistor r=0.2091 c=0
Rk24 (\19\:CKNb \21\:CKNb) resistor r=0.3157 c=0
Rk25 (\19\:CKNb \23\:CKNb) resistor r=0.1957 c=0
Rk52 (\24\:CKNb \25\:CKNb) resistor r=0.8714 c=0
Rk5 (\8\:n20 \10\:n20) resistor r=0.4922 c=0
Rk6 (\10\:n20 \11\:n20) resistor r=0.315 c=0
Rk7 (\12\:n20 \14\:n20) resistor r=0.2759 c=0
Rk8 (\14\:n20 \15\:n20) resistor r=0.2394 c=0
Rk9 (\12\:n20 \17\:n20) resistor r=0.2335 c=0
Rk10 (\10\:CKNbb \11\:CKNbb) resistor r=0.1981 c=0
Rk11 (\11\:CKNbb \12\:CKNbb) resistor r=0.02346 c=0
Rk12 (\11\:CKNbb \14\:CKNbb) resistor r=0.3343 c=0
Rk13 (\14\:CKNbb \15\:CKNbb) resistor r=0.272 c=0
Rk14 (\6\:mout \7\:mout) resistor r=0.3051 c=0
Rk15 (\7\:mout \8\:mout) resistor r=0.1494 c=0
Rk16 (\8\:mout \9\:mout) resistor r=0.1241 c=0
Rk17 (\7\:mout \11\:mout) resistor r=0.2735 c=0
Rk18 (\8\:mout \12\:mout) resistor r=0.1307 c=0
Rk26 (\5\:n35 \6\:n35) resistor r=0.2866 c=0
Rk27 (\6\:n35 \8\:n35) resistor r=0.2722 c=0
Rk28 (\6\:n35 \9\:n35) resistor r=0.5674 c=0
Rk31 (\11\:n35 \12\:n35) resistor r=0.2721 c=0
Rk32 (\12\:n35 \14\:n35) resistor r=0.3271 c=0
Rk53 (\16\:n35 \17\:n35) resistor r=0.1701 c=0
Rk54 (\17\:n35 \19\:n35) resistor r=0.4267 c=0
Rk29 (\7\:n35g \8\:n35g) resistor r=0.2291 c=0
Rk30 (\7\:n35g \10\:n35g) resistor r=0.6054 c=0
Rk42 (\12\:n35g \13\:n35g) resistor r=0.2425 c=0
Rk43 (\13\:n35g \14\:n35g) resistor r=0.5645 c=0
Rk44 (\13\:n35g \16\:n35g) resistor r=0.4312 c=0
Rk39 (\12\:qbint \13\:qbint) resistor r=0.4937 c=0
Rk40 (\13\:qbint \15\:qbint) resistor r=0.5662 c=0
Rk41 (\13\:qbint \17\:qbint) resistor r=0.146 c=0
Rk51 (\18\:qbint \19\:qbint) resistor r=0.2114 c=0
Rk46 (\5\:RTb \7\:RTb) resistor r=0.2262 c=0
Rk47 (\7\:RTb \8\:RTb) resistor r=0.2729 c=0
Rk48 (\8\:RTb \9\:RTb) resistor r=0.6695 c=0
Rk49 (\8\:RTb \11\:RTb) resistor r=0.3327 c=0
Rl19 (\2\:CKN \4\:CKN) resistor r=70.868 c=0
Rl17 (\1\:CKN \2\:CKN) resistor r=140.099 c=0
Rl18 (\2\:CKN \3\:CKN) resistor r=2.0166 c=0
Rl34 (\3\:RT \7\:RT) resistor r=709.9 c=0
Rl31 (\3\:RT \4\:RT) resistor r=72.2057 c=0
Rl25 (\1\:RT \2\:RT) resistor r=125.877 c=0
Rl35 (\5\:RT \8\:RT) resistor r=30.9873 c=0
Rl33 (\5\:RT \6\:RT) resistor r=273.765 c=0
Rl32 (\4\:RT \5\:RT) resistor r=78.204 c=0
Rl3 (\2\:D \4\:D) resistor r=38.1757 c=0
Rl1 (\1\:D \2\:D) resistor r=172.791 c=0
Rl2 (\2\:D \3\:D) resistor r=5.1123 c=0
Rl43 (\14\:CKNb \15\:CKNb) resistor r=115.79 c=0
Rl11 (\4\:CKNb \5\:CKNb) resistor r=246.721 c=0
Rl12 (\2\:CKNb \6\:CKNb) resistor r=73.8796 c=0
Rl8 (CKNb \2\:CKNb) resistor r=0.6084 c=0
Rl13 (\3\:CKNb \7\:CKNb) resistor r=64.6458 c=0
Rl10 (\3\:CKNb \4\:CKNb) resistor r=208.713 c=0
Rl9 (\2\:CKNb \3\:CKNb) resistor r=64.0061 c=0
Rl39 (\9\:CKNb \12\:CKNb) resistor r=64.1356 c=0
Rl36 (\8\:CKNb \9\:CKNb) resistor r=862.964 c=0
Rl40 (\10\:CKNb \13\:CKNb) resistor r=64.1356 c=0
Rl38 (\10\:CKNb \11\:CKNb) resistor r=113.909 c=0
Rl37 (\9\:CKNb \10\:CKNb) resistor r=172.374 c=0
Rl4 (n20 \2\:n20) resistor r=112.885 c=0
Rl14 (\3\:n20 \4\:n20) resistor r=103.572 c=0
Rl16 (\4\:n20 \6\:n20) resistor r=96.5354 c=0
Rl15 (\4\:n20 \5\:n20) resistor r=121.254 c=0
Rl5 (CKNbb \2\:CKNbb) resistor r=157.453 c=0
Rl44 (\3\:CKNbb \4\:CKNbb) resistor r=1441.22 c=0
Rl47 (\4\:CKNbb \7\:CKNbb) resistor r=140.831 c=0
Rl48 (\5\:CKNbb \8\:CKNbb) resistor r=66.684 c=0
Rl46 (\5\:CKNbb \6\:CKNbb) resistor r=229.379 c=0
Rl45 (\4\:CKNbb \5\:CKNbb) resistor r=112.483 c=0
Rl6 (mout \2\:mout) resistor r=24.2328 c=0
Rl7 (\3\:mout \4\:mout) resistor r=24.2328 c=0
Rl41 (n35 \2\:n35) resistor r=499.328 c=0
Rl42 (\2\:n35 \3\:n35) resistor r=104.689 c=0
Rl22 (\3\:n35g \4\:n35g) resistor r=241.174 c=0
Rl21 (\2\:n35g \3\:n35g) resistor r=181.74 c=0
Rl23 (\2\:n35g \5\:n35g) resistor r=94.1963 c=0
Rl20 (n35g \2\:n35g) resistor r=2.4834 c=0
Rl53 (\10\:qbint \11\:qbint) resistor r=235.906 c=0
Rl52 (\8\:qbint \10\:qbint) resistor r=601.135 c=0
Rl30 (\3\:qbint \5\:qbint) resistor r=35.3072 c=0
Rl29 (\2\:qbint \4\:qbint) resistor r=148.502 c=0
Rl27 (qbint \2\:qbint) resistor r=112.732 c=0
Rl28 (\2\:qbint \3\:qbint) resistor r=74.1915 c=0
Rl51 (\7\:qbint \9\:qbint) resistor r=68.607 c=0
Rl49 (\6\:qbint \7\:qbint) resistor r=78.0039 c=0
Rl50 (\7\:qbint \8\:qbint) resistor r=166.462 c=0
Rl26 (\3\:RTb \4\:RTb) resistor r=242.199 c=0
Rl24 (RTb \2\:RTb) resistor r=124.312 c=0
Rz14 (\1\:Q \2\:Q) resistor r=37.5 c=0
Rz15 (\1\:VSS \2\:VSS) resistor r=37.5 c=0
Rz16 (\9\:VSS \10\:VSS) resistor r=75 c=0
Rz17 (\11\:VSS \12\:VSS) resistor r=75 c=0
Rz18 (\13\:VSS \14\:VSS) resistor r=75 c=0
Rz19 (\15\:VSS \16\:VSS) resistor r=75 c=0
Rz22 (\17\:VSS \18\:VSS) resistor r=75 c=0
Rz23 (\23\:VSS \24\:VSS) resistor r=75 c=0
Rz24 (\25\:VSS \26\:VSS) resistor r=75 c=0
Rz5 (\22\:CKNb \23\:CKNb) resistor r=75 c=0
Rz1 (\7\:n20 \8\:n20) resistor r=75 c=0
Rz2 (\16\:n20 \17\:n20) resistor r=75 c=0
Rz3 (\9\:CKNbb \10\:CKNbb) resistor r=75 c=0
Rz4 (\10\:mout \11\:mout) resistor r=75 c=0
Rz6 (\7\:n35 \8\:n35) resistor r=75 c=0
Rz8 (\13\:n35 \14\:n35) resistor r=75 c=0
Rz13 (\18\:n35 \19\:n35) resistor r=75 c=0
Rz7 (\9\:n35g \10\:n35g) resistor r=75 c=0
Rz11 (\11\:n35g \12\:n35g) resistor r=75 c=0
Rz10 (\16\:qbint \17\:qbint) resistor r=75 c=0
Rz12 (\10\:RTb \11\:RTb) resistor r=75 c=0
Ry9 (\1\:ExtVDD \2\:ExtVDD) resistor r=62 c=0
Ry10 (\1\:ExtVDD \5\:ExtVDD) resistor r=62 c=0
Ry11 (\1\:ExtVDD \6\:ExtVDD) resistor r=62 c=0
Ry12 (\1\:ExtVDD \7\:ExtVDD) resistor r=62 c=0
Ry13 (\1\:ExtVDD \8\:ExtVDD) resistor r=62 c=0
Ry21 (\1\:VDD \2\:VDD) resistor r=20.6667 c=0
Ry22 (\9\:VDD \10\:VDD) resistor r=62 c=0
Ry23 (\11\:VDD \12\:VDD) resistor r=62 c=0
Ry24 (\13\:VDD \14\:VDD) resistor r=62 c=0
Ry25 (\15\:VDD \16\:VDD) resistor r=62 c=0
Ry18 (\3\:Q \4\:Q) resistor r=20.6667 c=0
Ry19 (\3\:VSS \4\:VSS) resistor r=5.6364 c=0
Ry20 (\3\:VSS \7\:VSS) resistor r=5.1667 c=0
Ry26 (\19\:VSS \20\:VSS) resistor r=5.6364 c=0
Ry27 (\19\:VSS \22\:VSS) resistor r=5.1667 c=0
Ry5 (\20\:CKNb \21\:CKNb) resistor r=62 c=0
Ry1 (\9\:n20 \10\:n20) resistor r=62 c=0
Ry2 (\13\:n20 \14\:n20) resistor r=62 c=0
Ry3 (\13\:CKNbb \14\:CKNbb) resistor r=62 c=0
Ry4 (\5\:mout \6\:mout) resistor r=62 c=0
Ry6 (\4\:n35 \5\:n35) resistor r=62 c=0
Ry8 (\10\:n35 \11\:n35) resistor r=62 c=0
Ry17 (\15\:n35 \16\:n35) resistor r=62 c=0
Ry7 (\6\:n35g \7\:n35g) resistor r=62 c=0
Ry15 (\15\:n35g \16\:n35g) resistor r=62 c=0
Ry14 (\14\:qbint \15\:qbint) resistor r=62 c=0
Ry16 (\6\:RTb \7\:RTb) resistor r=62 c=0
Rx11 (\3\:CKN \6\:CKN) resistor r=45 c=0
Rx18 (\4\:RT \9\:RT) resistor r=45 c=0
Rx19 (\2\:RT \10\:RT) resistor r=45 c=0
Rx22 (\3\:RT \11\:RT) resistor r=45 c=0
Rx3 (\3\:D \5\:D) resistor r=45 c=0
Rx1 (\5\:CKNb \16\:CKNb) resistor r=45 c=0
Rx2 (\11\:CKNb \17\:CKNb) resistor r=45 c=0
Rx12 (CKNb \18\:CKNb) resistor r=45 c=0
Rx25 (\15\:CKNb \24\:CKNb) resistor r=45 c=0
Rx26 (\8\:CKNb \25\:CKNb) resistor r=45 c=0
Rx4 (\2\:n20 \11\:n20) resistor r=45 c=0
Rx5 (\5\:n20 \12\:n20) resistor r=45 c=0
Rx6 (n20 \15\:n20) resistor r=45 c=0
Rx7 (CKNbb \12\:CKNbb) resistor r=45 c=0
Rx8 (\7\:CKNbb \15\:CKNbb) resistor r=45 c=0
Rx9 (\4\:mout \9\:mout) resistor r=45 c=0
Rx10 (\2\:mout \12\:mout) resistor r=45 c=0
Rx13 (\3\:n35 \9\:n35) resistor r=45 c=0
Rx15 (\2\:n35 \12\:n35) resistor r=45 c=0
Rx27 (n35 \17\:n35) resistor r=45 c=0
Rx14 (\4\:n35g \8\:n35g) resistor r=45 c=0
Rx17 (n35g \14\:n35g) resistor r=45 c=0
Rx16 (\3\:qbint \12\:qbint) resistor r=45 c=0
Rx23 (\8\:qbint \18\:qbint) resistor r=45 c=0
Rx24 (qbint \19\:qbint) resistor r=45 c=0
Rx20 (\3\:RTb \5\:RTb) resistor r=45 c=0
Rx21 (\2\:RTb \9\:RTb) resistor r=45 c=0
mn21 (\9\:CKNbb \6\:CKNb \15\:VSS VSS) g45n1svt w=(1.45e-07) l=4.5e-08 \
        nf=1 as=2.32e-14 ad=2.03e-14 ps=6.1e-07 pd=5.7e-07 nrd=1.16667 \
        nrs=1.16667 sa=1.4e-07 sb=3.45e-07 sd=160n sca=8.0352 \
        scb=0.00565402 scc=8.19771e-05 m=(1)
mn35 (n30 \3\:mout \23\:VSS VSS) g45n1svt w=(1.45e-07) l=4.5e-08 nf=1 \
        as=2.32e-14 ad=8.7e-15 ps=6.1e-07 pd=4.1e-07 nrd=1.16667 \
        nrs=1.16667 sa=2.45e-07 sb=5.5e-07 sd=160n sca=11.1906 \
        scb=0.0108717 scc=0.000387468 m=(1)
mn20 (\22\:CKNb \1\:CKN \15\:VSS VSS) g45n1svt w=(1.45e-07) l=4.5e-08 \
        nf=1 as=2.03e-14 ad=2.32e-14 ps=5.7e-07 pd=6.1e-07 nrd=1.16667 \
        nrs=1.16667 sa=3.45e-07 sb=1.4e-07 sd=160n sca=8.0352 \
        scb=0.00565402 scc=8.19771e-05 m=(1)
mn32 (\10\:mout \6\:n20 \23\:VSS VSS) g45n1svt w=(1.45e-07) l=4.5e-08 \
        nf=1 as=2.32e-14 ad=2.32e-14 ps=6.1e-07 pd=6.1e-07 nrd=1.16667 \
        nrs=1.16667 sa=4.5e-07 sb=3.45e-07 sd=160n sca=11.1906 \
        scb=0.0108717 scc=0.000387468 m=(1)
mn26 (\7\:n20 \2\:CKNbb n21 VSS) g45n1svt w=(1.45e-07) l=4.5e-08 nf=1 \
        as=2.03e-14 ad=8.7e-15 ps=5.7e-07 pd=4.1e-07 nrd=1.16667 \
        nrs=1.16667 sa=2.45e-07 sb=1.4e-07 sd=160n sca=8.0352 \
        scb=0.00565402 scc=8.19771e-05 m=(1)
mn25 (n21 \1\:D \9\:VSS VSS) g45n1svt w=(1.45e-07) l=4.5e-08 nf=1 \
        as=8.7e-15 ad=2.03e-14 ps=4.1e-07 pd=5.7e-07 nrd=1.16667 \
        nrs=1.16667 sa=2.45e-07 sb=1.4e-07 sd=160n sca=8.0352 \
        scb=0.00565402 scc=8.19771e-05 m=(1)
mn40 (\7\:n35 \12\:CKNb \10\:mout VSS) g45n1svt w=(1.45e-07) l=4.5e-08 \
        nf=1 as=2.03e-14 ad=2.32e-14 ps=5.7e-07 pd=6.1e-07 nrd=1.16667 \
        nrs=1.16667 sa=6.55e-07 sb=1.4e-07 sd=160n sca=11.1906 \
        scb=0.0108717 scc=0.000387468 m=(1)
mn36 (\16\:n20 \13\:CKNb n30 VSS) g45n1svt w=(1.45e-07) l=4.5e-08 nf=1 \
        as=8.7e-15 ad=2.03e-14 ps=4.1e-07 pd=5.7e-07 nrd=1.16667 \
        nrs=1.16667 sa=1.4e-07 sb=6.55e-07 sd=160n sca=11.1906 \
        scb=0.0108717 scc=0.000387468 m=(1)
NM0 (\9\:n35g RTb \13\:n35 VSS) g45n1svt w=(1.45e-07) l=4.5e-08 nf=1 \
        as=2.03e-14 ad=2.03e-14 ps=5.7e-07 pd=5.7e-07 nrd=1.16667 \
        nrs=1.16667 sa=1.4e-07 sb=1.4e-07 sd=160n sca=17.8702 \
        scb=0.0189183 scc=0.00156031 m=(1)
NM1 (\16\:qbint \5\:n35g \13\:VSS VSS) g45n1svt w=(1.45e-07) l=4.5e-08 \
        nf=1 as=2.03e-14 ad=2.03e-14 ps=5.7e-07 pd=5.7e-07 nrd=1.16667 \
        nrs=1.16667 sa=1.4e-07 sb=1.4e-07 sd=160n sca=9.33388 \
        scb=0.00788941 scc=0.00017958 m=(1)
NM3 (net0121 \5\:qbint \11\:VSS VSS) g45n1svt w=(1.45e-07) l=4.5e-08 \
        nf=1 as=2.03e-14 ad=8.7e-15 ps=5.7e-07 pd=4.1e-07 nrd=1.16667 \
        nrs=1.16667 sa=1.4e-07 sb=2.45e-07 sd=160n sca=9.33388 \
        scb=0.00788941 scc=0.00017958 m=(1)
mn45 (\10\:RTb \1\:RT \25\:VSS VSS) g45n1svt w=(1.45e-07) l=4.5e-08 nf=1 \
        as=2.03e-14 ad=2.03e-14 ps=5.7e-07 pd=5.7e-07 nrd=1.16667 \
        nrs=1.16667 sa=1.4e-07 sb=1.4e-07 sd=160n sca=17.8702 \
        scb=0.0189183 scc=0.00156031 m=(1)
NM2 (\11\:n35g \7\:RT net0121 VSS) g45n1svt w=(1.45e-07) l=4.5e-08 nf=1 \
        as=8.7e-15 ad=2.03e-14 ps=4.1e-07 pd=5.7e-07 nrd=1.16667 \
        nrs=1.16667 sa=2.45e-07 sb=1.4e-07 sd=160n sca=9.33388 \
        scb=0.00788941 scc=0.00017958 m=(1)
mn53 (\18\:n35 \3\:CKNbb net095 VSS) g45n1svt w=(1.45e-07) l=4.5e-08 nf=1 \
        as=8.7e-15 ad=2.03e-14 ps=4.1e-07 pd=5.7e-07 nrd=1.16667 \
        nrs=1.16667 sa=1.4e-07 sb=2.45e-07 sd=160n sca=8.42104 \
        scb=0.00632542 scc=0.000106623 m=(1)
mn52 (net095 \11\:qbint \17\:VSS VSS) g45n1svt w=(1.45e-07) l=4.5e-08 \
        nf=1 as=2.03e-14 ad=8.7e-15 ps=5.7e-07 pd=4.1e-07 nrd=1.16667 \
        nrs=1.16667 sa=2.45e-07 sb=1.4e-07 sd=160n sca=8.42104 \
        scb=0.00632542 scc=0.000106623 m=(1)
mn55 (\1\:Q \6\:qbint \1\:VSS VSS) g45n1svt w=(2.6e-07) l=4.5e-08 nf=1 \
        as=3.64e-14 ad=3.64e-14 ps=8e-07 pd=8e-07 nrd=1.16667 nrs=1.16667 \
        sa=1.4e-07 sb=1.4e-07 sd=160n sca=9.50447 scb=0.0081528 \
        scc=0.00025289 m=(1)
mp55 (\3\:Q \9\:qbint \1\:VDD VDD) g45p1svt w=(3.9e-07) l=4.5e-08 nf=1 \
        as=5.46e-14 ad=5.46e-14 ps=1.06e-06 pd=1.06e-06 nrd=1.16667 \
        nrs=1.16667 sa=1.4e-07 sb=1.4e-07 sd=160n sca=28.7703 \
        scb=0.0323565 scc=0.00200479 m=(1)
ends RDFFNQX1
// End of subcircuit definition.
