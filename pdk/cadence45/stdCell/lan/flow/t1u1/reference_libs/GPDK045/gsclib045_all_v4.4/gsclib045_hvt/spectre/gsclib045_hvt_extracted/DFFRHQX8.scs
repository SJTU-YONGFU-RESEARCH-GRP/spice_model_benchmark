// Generated for: spectre (May  1 09:14:33 2013 )
// Library name: gsclib045_hvt
// Cell name: DFFRHQX8
// View name: extracted

simulator lang=spectre

subckt DFFRHQX8 CK D Q RN VDD VSS
mp55_1__rcx (Q qbint \8\:VDD VDD) g45p1hvt w=(4.45e-07) l=4.5e-08 nf=1 \
        as=7.435e-14 ad=7.056e-14 ps=1.22857e-06 pd=1.20714e-06 \
        nrd=1.16667 nrs=1.16667 sa=1.4e-07 sb=1.90096e-06 sd=160n \
        sca=41.6034 scb=0.0375368 scc=0.00435732 m=(7)
C1 (RN VSS) capacitor c=4.59962e-16
C2 (VDD VSS) capacitor c=3.47222e-16
C3 (CK VSS) capacitor c=4.50305e-17
C4 (D VSS) capacitor c=3.57527e-17
C5 (Q VSS) capacitor c=4.97564e-16
C6 (qbint VSS) capacitor c=3.64144e-16
C7 (16 VSS) capacitor c=1.21854e-18
C8 (n30 VSS) capacitor c=5.93366e-16
C9 (17 VSS) capacitor c=4.69791e-18
C10 (18 VSS) capacitor c=9.60058e-19
C11 (CKb VSS) capacitor c=4.12355e-17
C12 (CKbb VSS) capacitor c=6.83983e-17
C13 (mout VSS) capacitor c=4.97291e-17
C14 (n20 VSS) capacitor c=2.22271e-17
C15 (n27 VSS) capacitor c=1.62034e-18
C16 (n25 VSS) capacitor c=2.4065e-18
C17 (n21 VSS) capacitor c=2.59276e-18
C18 (n41 VSS) capacitor c=2.18324e-18
C19 (n26 VSS) capacitor c=8.39168e-17
C20 (n22 VSS) capacitor c=3.74072e-20
C21 (\3\:CK VSS) capacitor c=4.97808e-17
C22 (\1\:D VSS) capacitor c=9.16872e-17
C23 (\7\:CKbb VSS) capacitor c=9.24547e-17
C24 (\11\:CKb VSS) capacitor c=3.57187e-17
C25 (\12\:RN VSS) capacitor c=8.17093e-17
C26 (\4\:n20 VSS) capacitor c=4.69247e-17
C27 (\4\:CKb VSS) capacitor c=3.29774e-17
C28 (\22\:qbint VSS) capacitor c=1.04048e-16
C29 (\1\:CK VSS) capacitor c=3.14425e-17
C30 (\3\:D VSS) capacitor c=2.61293e-17
C31 (\9\:CKb VSS) capacitor c=4.3337e-17
C32 (\5\:CKbb VSS) capacitor c=3.83352e-17
C33 (\3\:mout VSS) capacitor c=6.81352e-17
C34 (\11\:RN VSS) capacitor c=9.60582e-17
C35 (\3\:n20 VSS) capacitor c=4.14361e-17
C36 (\3\:CKbb VSS) capacitor c=2.65076e-17
C37 (\8\:CKb VSS) capacitor c=3.07063e-17
C38 (\24\:qbint VSS) capacitor c=3.58842e-17
C39 (\3\:CKb VSS) capacitor c=3.52114e-17
C40 (\10\:n30 VSS) capacitor c=6.70896e-17
C41 (\4\:RN VSS) capacitor c=4.69958e-17
C42 (\7\:RN VSS) capacitor c=2.09183e-17
C43 (\6\:n30 VSS) capacitor c=2.53745e-17
C44 (\5\:n30 VSS) capacitor c=3.53831e-17
C45 (\1\:RN VSS) capacitor c=4.48559e-17
C46 (\4\:CK VSS) capacitor c=1.59124e-17
C47 (\2\:D VSS) capacitor c=5.31665e-17
C48 (\8\:CKbb VSS) capacitor c=7.64868e-17
C49 (\10\:CKb VSS) capacitor c=3.81517e-17
C50 (\12\:CKb VSS) capacitor c=2.21108e-17
C51 (\6\:CKbb VSS) capacitor c=3.95899e-17
C52 (\2\:mout VSS) capacitor c=7.13404e-17
C53 (\13\:RN VSS) capacitor c=2.85876e-17
C54 (\7\:CKb VSS) capacitor c=2.82601e-17
C55 (\4\:CKbb VSS) capacitor c=4.65939e-17
C56 (\2\:CKbb VSS) capacitor c=4.30031e-17
C57 (\6\:CKb VSS) capacitor c=5.03836e-17
C58 (\23\:qbint VSS) capacitor c=5.37371e-17
C59 (\2\:CKb VSS) capacitor c=2.75036e-17
C60 (\9\:RN VSS) capacitor c=2.05763e-17
C61 (\21\:CKb VSS) capacitor c=2.89478e-17
C62 (\1\:VDD VSS) capacitor c=3.46952e-17
C63 (\5\:n20 VSS) capacitor c=6.3929e-17
C64 (\16\:VDD VSS) capacitor c=1.92721e-17
C65 (\3\:n26 VSS) capacitor c=8.56186e-17
C66 (\18\:VDD VSS) capacitor c=5.87954e-17
C67 (\6\:mout VSS) capacitor c=7.30119e-17
C68 (\15\:n30 VSS) capacitor c=1.49919e-16
C69 (\20\:VDD VSS) capacitor c=3.47664e-17
C70 (\13\:CKbb VSS) capacitor c=1.30471e-16
C71 (\28\:qbint VSS) capacitor c=3.1328e-16
C72 (\3\:VDD VSS) capacitor c=9.499e-17
C73 (\17\:CKb VSS) capacitor c=6.80173e-17
C74 (\9\:n20 VSS) capacitor c=6.64563e-17
C75 (\8\:mout VSS) capacitor c=4.73962e-17
C76 (\17\:n30 VSS) capacitor c=9.97588e-17
C77 (\15\:CKbb VSS) capacitor c=7.07157e-17
C78 (\26\:qbint VSS) capacitor c=8.93605e-17
C79 (\32\:qbint VSS) capacitor c=1.05612e-16
C80 (\5\:CKb VSS) capacitor c=4.58431e-17
C81 (\2\:n20 VSS) capacitor c=2.46398e-17
C82 (\2\:CK VSS) capacitor c=3.54218e-17
C83 (\25\:qbint VSS) capacitor c=8.19394e-17
C84 (\35\:qbint VSS) capacitor c=5.4676e-17
C85 (\13\:CKb VSS) capacitor c=7.66252e-17
C86 (\14\:CKb VSS) capacitor c=7.53816e-17
C87 (\16\:RN VSS) capacitor c=1.40075e-16
C88 (\17\:RN VSS) capacitor c=1.41715e-16
C89 (\4\:mout VSS) capacitor c=8.52561e-17
C90 (\5\:mout VSS) capacitor c=8.61065e-17
C91 (\15\:CKb VSS) capacitor c=1.89088e-16
C92 (\16\:CKb VSS) capacitor c=1.64637e-16
C93 (\7\:n20 VSS) capacitor c=1.35125e-16
C94 (\8\:n20 VSS) capacitor c=9.11673e-17
C95 (\9\:CKbb VSS) capacitor c=9.89913e-17
C96 (\10\:CKbb VSS) capacitor c=1.67564e-16
C97 (\11\:CKbb VSS) capacitor c=1.77462e-16
C98 (\12\:CKbb VSS) capacitor c=1.66389e-16
C99 (\17\:CKbb VSS) capacitor c=4.03836e-17
C100 (\18\:CKbb VSS) capacitor c=6.54119e-17
C101 (\4\:D VSS) capacitor c=8.46385e-17
C102 (\19\:CKb VSS) capacitor c=1.13518e-16
C103 (\20\:CKb VSS) capacitor c=9.27916e-17
C104 (\5\:CK VSS) capacitor c=4.60985e-17
C105 (\5\:VDD VSS) capacitor c=1.88042e-17
C106 (\6\:VDD VSS) capacitor c=3.88364e-17
C107 (\8\:VDD VSS) capacitor c=5.55753e-16
Rk28 (\16\:RN \17\:RN) resistor r=1.1387 c=0
Rk49 (\2\:VSS \3\:VSS) resistor r=0.342 c=0
Rk50 (\3\:VSS \5\:VSS) resistor r=0.1127 c=0
Rk51 (\5\:VSS \6\:VSS) resistor r=0.4314 c=0
Rk52 (\6\:VSS \7\:VSS) resistor r=0.6221 c=0
Rk53 (\7\:VSS \8\:VSS) resistor r=0.09922 c=0
Rk54 (\8\:VSS \9\:VSS) resistor r=0.4127 c=0
Rk60 (\10\:VSS VSS) resistor r=0.1074 c=0
Rk55 (\9\:VSS \10\:VSS) resistor r=0.4814 c=0
Rk61 (\3\:VSS \16\:VSS) resistor r=0.2084 c=0
Rk62 (\6\:VSS \18\:VSS) resistor r=0.172 c=0
Rk63 (\8\:VSS \20\:VSS) resistor r=0.04334 c=0
Rk64 (\9\:VSS \22\:VSS) resistor r=0.2715 c=0
Rk69 (\2\:VDD \4\:VDD) resistor r=0.4343 c=0
Rk70 (\4\:VDD \5\:VDD) resistor r=0.2247 c=0
Rk71 (\5\:VDD \6\:VDD) resistor r=0.2772 c=0
Rk72 (\6\:VDD \7\:VDD) resistor r=0.5499 c=0
Rk81 (\8\:VDD VDD) resistor r=0.1024 c=0
Rk73 (\7\:VDD \8\:VDD) resistor r=0.2931 c=0
Rk82 (\5\:VDD \17\:VDD) resistor r=0.04334 c=0
Rk83 (\6\:VDD \19\:VDD) resistor r=0.2682 c=0
Rk84 (\7\:VDD \21\:VDD) resistor r=0.07151 c=0
Rk48 (\5\:CK CK) resistor r=0.2394 c=0
Rk44 (D \4\:D) resistor r=0.03877 c=0
Rk17 (\27\:qbint \28\:qbint) resistor r=0.4135 c=0
Rk16 (\25\:qbint \27\:qbint) resistor r=0.5351 c=0
Rk21 (\28\:qbint \35\:qbint) resistor r=0.3289 c=0
Rk26 (n30 \16\:n30) resistor r=0.8935 c=0
Rk27 (\16\:n30 \18\:n30) resistor r=0.4297 c=0
Rk23 (\13\:CKb \14\:CKb) resistor r=0.3079 c=0
Rk33 (\15\:CKb \16\:CKb) resistor r=1.3472 c=0
Rk45 (\18\:CKb \19\:CKb) resistor r=0.4985 c=0
Rk46 (\19\:CKb \20\:CKb) resistor r=0.5278 c=0
Rk47 (\19\:CKb \22\:CKb) resistor r=0.3024 c=0
Rk37 (\9\:CKbb \10\:CKbb) resistor r=0.7757 c=0
Rk38 (\10\:CKbb \11\:CKbb) resistor r=0.8188 c=0
Rk39 (\11\:CKbb \12\:CKbb) resistor r=0.6677 c=0
Rk40 (\12\:CKbb \14\:CKbb) resistor r=0.6165 c=0
Rk41 (\14\:CKbb \16\:CKbb) resistor r=0.3494 c=0
Rk42 (\10\:CKbb \17\:CKbb) resistor r=0.1685 c=0
Rk43 (\11\:CKbb \18\:CKbb) resistor r=0.2674 c=0
Rk29 (\4\:mout \5\:mout) resistor r=0.4754 c=0
Rk30 (\5\:mout \7\:mout) resistor r=0.2669 c=0
Rk31 (\5\:mout \9\:mout) resistor r=0.09549 c=0
Rk34 (\6\:n20 \7\:n20) resistor r=0.3854 c=0
Rk35 (\7\:n20 \8\:n20) resistor r=0.5859 c=0
Rk36 (\7\:n20 \10\:n20) resistor r=0.3536 c=0
Rk32 (\2\:n26 \4\:n26) resistor r=0.2663 c=0
Rl51 (\11\:RN \12\:RN) resistor r=247.643 c=0
Rl29 (RN \4\:RN) resistor r=35.772 c=0
Rl31 (RN \7\:RN) resistor r=33.8482 c=0
Rl21 (RN \1\:RN) resistor r=30.7692 c=0
Rl52 (\13\:RN \12\:RN) resistor r=172.59 c=0
Rl33 (\9\:RN RN) resistor r=32.2114 c=0
Rl63 (\2\:CK \3\:CK) resistor r=216.817 c=0
Rl62 (\1\:CK \2\:CK) resistor r=86.0004 c=0
Rl64 (\2\:CK \4\:CK) resistor r=9.6389 c=0
Rl60 (\1\:D \2\:D) resistor r=143.464 c=0
Rl61 (\2\:D \3\:D) resistor r=24.2328 c=0
Rl40 (\23\:qbint \22\:qbint) resistor r=158.356 c=0
Rl41 (\23\:qbint \24\:qbint) resistor r=26.098 c=0
Rl36 (n30 \10\:n30) resistor r=83.0007 c=0
Rl27 (n30 \6\:n30) resistor r=66.3231 c=0
Rl26 (n30 \5\:n30) resistor r=55.0028 c=0
Rl57 (\10\:CKb \11\:CKb) resistor r=39.1533 c=0
Rl56 (\9\:CKb \10\:CKb) resistor r=114.153 c=0
Rl58 (\11\:CKb \12\:CKb) resistor r=24.2328 c=0
Rl47 (\6\:CKb \8\:CKb) resistor r=30.5643 c=0
Rl38 (CKb \2\:CKb) resistor r=28.1713 c=0
Rl39 (\2\:CKb \3\:CKb) resistor r=37.1321 c=0
Rl44 (\4\:CKb \5\:CKb) resistor r=41.9892 c=0
Rl46 (\5\:CKb \7\:CKb) resistor r=40.3099 c=0
Rl45 (\5\:CKb \6\:CKb) resistor r=176.878 c=0
Rl59 (\7\:CKbb \8\:CKbb) resistor r=119.768 c=0
Rl55 (\5\:CKbb \6\:CKbb) resistor r=51.1559 c=0
Rl43 (\3\:CKbb \4\:CKbb) resistor r=45.3867 c=0
Rl42 (CKbb \2\:CKbb) resistor r=29.5379 c=0
Rl53 (mout \2\:mout) resistor r=116.106 c=0
Rl54 (\2\:mout \3\:mout) resistor r=74.2328 c=0
Rl50 (\2\:n20 \4\:n20) resistor r=34.3295 c=0
Rl49 (\2\:n20 \3\:n20) resistor r=117.022 c=0
Rl48 (n20 \2\:n20) resistor r=5.1171 c=0
Rz12 (\2\:VSS \1\:VSS) resistor r=75 c=0
Rz13 (\16\:VSS \15\:VSS) resistor r=75 c=0
Rz14 (\18\:VSS \17\:VSS) resistor r=75 c=0
Rz15 (\20\:VSS \19\:VSS) resistor r=75 c=0
Rz16 (\22\:VSS \21\:VSS) resistor r=75 c=0
Rz21 (\4\:VDD \3\:VDD) resistor r=8.3333 c=0
Rz22 (\7\:VDD \3\:VDD) resistor r=6.25 c=0
Rz23 (\8\:VDD \3\:VDD) resistor r=6.25 c=0
Rz6 (\28\:qbint \32\:qbint) resistor r=75 c=0
Rz5 (\27\:qbint \26\:qbint) resistor r=75 c=0
Rz7 (\18\:n30 \17\:n30) resistor r=75 c=0
Rz11 (\17\:CKb \18\:CKb) resistor r=75 c=0
Rz10 (\15\:CKbb \16\:CKbb) resistor r=75 c=0
Rz8 (\8\:mout \9\:mout) resistor r=75 c=0
Rz9 (\9\:n20 \10\:n20) resistor r=75 c=0
Ry15 (\5\:VSS \4\:VSS) resistor r=6.8889 c=0
Ry16 (\7\:VSS \4\:VSS) resistor r=5.1667 c=0
Ry17 (\10\:VSS \4\:VSS) resistor r=5.1667 c=0
Ry18 (\2\:VDD \1\:VDD) resistor r=62 c=0
Ry19 (\17\:VDD \16\:VDD) resistor r=62 c=0
Ry20 (\19\:VDD \18\:VDD) resistor r=62 c=0
Ry21 (\21\:VDD \20\:VDD) resistor r=62 c=0
Ry8 (\16\:n30 \15\:n30) resistor r=62 c=0
Ry14 (\21\:CKb \22\:CKb) resistor r=62 c=0
Ry13 (\13\:CKbb \14\:CKbb) resistor r=62 c=0
Ry9 (\6\:mout \7\:mout) resistor r=62 c=0
Ry12 (\5\:n20 \6\:n20) resistor r=62 c=0
Ry10 (n26 \2\:n26) resistor r=62 c=0
Ry11 (\3\:n26 \4\:n26) resistor r=62 c=0
Rx9 (\16\:RN \13\:RN) resistor r=45 c=0
Rx10 (\17\:RN \9\:RN) resistor r=45 c=0
Rx21 (\4\:CK \5\:CK) resistor r=45 c=0
Rx19 (\2\:D \4\:D) resistor r=45 c=0
Rx3 (\25\:qbint \23\:qbint) resistor r=45 c=0
Rx4 (\35\:qbint qbint) resistor r=45 c=0
Rx5 (\6\:CKb \13\:CKb) resistor r=45 c=0
Rx6 (\2\:CKb \14\:CKb) resistor r=45 c=0
Rx12 (\12\:CKb \15\:CKb) resistor r=45 c=0
Rx13 (\7\:CKb \16\:CKb) resistor r=45 c=0
Rx20 (\10\:CKb \20\:CKb) resistor r=45 c=0
Rx15 (\8\:CKbb \9\:CKbb) resistor r=45 c=0
Rx16 (\2\:CKbb \12\:CKbb) resistor r=45 c=0
Rx17 (\6\:CKbb \17\:CKbb) resistor r=45 c=0
Rx18 (\4\:CKbb \18\:CKbb) resistor r=45 c=0
Rx11 (\2\:mout \4\:mout) resistor r=45 c=0
Rx14 (n20 \8\:n20) resistor r=45 c=0
mn55_1__rcx (Q qbint \10\:VSS VSS) g45n1hvt w=(2.95e-07) l=4.5e-08 nf=1 \
        as=4.857e-14 ad=5.226e-14 ps=9.2286e-07 pd=9.4429e-07 nrd=1.16667 \
        nrs=1.16667 sa=1.4e-07 sb=1.92881e-06 sd=160n sca=16.4223 \
        scb=0.0158966 scc=0.0014413 m=(7)
mn45_1__rcx (16 \1\:RN \10\:VSS VSS) g45n1hvt w=(2.6e-07) l=4.5e-08 nf=1 \
        as=5.68e-14 ad=2.73e-14 ps=1e-06 pd=7.3e-07 nrd=1.16667 \
        nrs=1.16667 sa=1.69e-06 sb=1.16e-06 sd=160n sca=13.9783 \
        scb=0.013979 scc=0.000942864 m=(1)
mn46_1__rcx (\32\:qbint \5\:n30 16 VSS) g45n1hvt w=(2.6e-07) l=4.5e-08 \
        nf=1 as=2.73e-14 ad=4.55e-14 ps=7.3e-07 pd=8.7e-07 nrd=1.16667 \
        nrs=1.16667 sa=1.84e-06 sb=1.01e-06 sd=160n sca=13.9783 \
        scb=0.013979 scc=0.000942864 m=(1)
mn46_2__rcx (\32\:qbint \6\:n30 17 VSS) g45n1hvt w=(2.6e-07) l=4.5e-08 \
        nf=1 as=5.2e-14 ad=4.55e-14 ps=9.2e-07 pd=8.7e-07 nrd=1.16667 \
        nrs=1.16667 sa=2e-06 sb=7.9e-07 sd=160n sca=13.9783 scb=0.013979 \
        scc=0.000942864 m=(1)
mn45_2__rcx (17 \7\:RN \21\:VSS VSS) g45n1hvt w=(2.6e-07) l=4.5e-08 nf=1 \
        as=6.63e-14 ad=5.2e-14 ps=1.03e-06 pd=9.2e-07 nrd=1.16667 \
        nrs=1.16667 sa=2e-06 sb=5.45e-07 sd=160n sca=13.9783 scb=0.013979 \
        scc=0.000942864 m=(1)
mn45 (18 \4\:RN \21\:VSS VSS) g45n1hvt w=(2.6e-07) l=4.5e-08 nf=1 \
        as=6.63e-14 ad=1.56e-14 ps=1.03e-06 pd=6.4e-07 nrd=1.16667 \
        nrs=1.16667 sa=2e-06 sb=2.45e-07 sd=160n sca=13.9783 scb=0.013979 \
        scc=0.000942864 m=(1)
mn46 (\26\:qbint \10\:n30 18 VSS) g45n1hvt w=(2.6e-07) l=4.5e-08 nf=1 \
        as=1.56e-14 ad=3.64e-14 ps=6.4e-07 pd=8e-07 nrd=1.16667 \
        nrs=1.16667 sa=2e-06 sb=1.4e-07 sd=160n sca=13.9783 scb=0.013979 \
        scc=0.000942864 m=(1)
mn21 (\15\:CKbb \3\:CKb \19\:VSS VSS) g45n1hvt w=(1.45e-07) l=4.5e-08 \
        nf=1 as=7.485e-14 ad=2.973e-14 ps=1.6e-06 pd=7e-07 nrd=1.16667 \
        nrs=1.16667 sa=2.05e-07 sb=1e-07 sd=160n sca=23.279 scb=0.0230742 \
        scc=0.00267719 m=(1)
mn20 (\17\:CKb \1\:CK \1\:VSS VSS) g45n1hvt w=(1.45e-07) l=4.5e-08 nf=1 \
        as=2.972e-14 ad=2.03e-14 ps=7e-07 pd=5.7e-07 nrd=1.16667 \
        nrs=1.16667 sa=2.05e-07 sb=1.4e-07 sd=160n sca=6.91521 \
        scb=0.00371851 scc=3.09367e-05 m=(1)
mn50 (n40 \24\:qbint \19\:VSS VSS) g45n1hvt w=(2.05e-07) l=4.5e-08 nf=1 \
        as=7.485e-14 ad=3.075e-14 ps=1.6e-06 pd=7.1e-07 nrd=1.16667 \
        nrs=1.16667 sa=1.7e-07 sb=2e-06 sd=160n sca=8.27167 scb=0.00612996 \
        scc=0.000112653 m=(1)
mn51 (\17\:n30 \8\:CKb n40 VSS) g45n1hvt w=(2.05e-07) l=4.5e-08 nf=1 \
        as=3.075e-14 ad=9.737e-14 ps=7.1e-07 pd=1.36e-06 nrd=1.16667 \
        nrs=1.16667 sa=3.65e-07 sb=2e-06 sd=160n sca=8.27167 \
        scb=0.00612996 scc=0.000112653 m=(1)
mn40 (\17\:n30 \3\:CKbb \8\:mout VSS) g45n1hvt w=(2.05e-07) l=4.5e-08 \
        nf=1 as=4.92e-14 ad=9.737e-14 ps=8.9e-07 pd=1.36e-06 nrd=1.16667 \
        nrs=1.16667 sa=8.85e-07 sb=1.745e-06 sd=160n sca=8.27167 \
        scb=0.00612996 scc=0.000112653 m=(1)
mn30 (\8\:mout \3\:n20 \17\:VSS VSS) g45n1hvt w=(2.05e-07) l=4.5e-08 \
        nf=1 as=8.083e-14 ad=4.92e-14 ps=1.24e-06 pd=8.9e-07 nrd=1.16667 \
        nrs=1.16667 sa=1.17e-06 sb=1.46e-06 sd=160n sca=8.27167 \
        scb=0.00612996 scc=0.000112653 m=(1)
mn35 (n27 \11\:RN \17\:VSS VSS) g45n1hvt w=(2.05e-07) l=4.5e-08 nf=1 \
        as=8.083e-14 ad=1.23e-14 ps=1.24e-06 pd=5.3e-07 nrd=1.16667 \
        nrs=1.16667 sa=1.58e-06 sb=1.05e-06 sd=160n sca=8.27167 \
        scb=0.00612996 scc=0.000112653 m=(1)
mn36 (n25 \3\:mout n27 VSS) g45n1hvt w=(2.05e-07) l=4.5e-08 nf=1 \
        as=1.23e-14 ad=2.768e-14 ps=5.3e-07 pd=6.8e-07 nrd=1.16667 \
        nrs=1.16667 sa=1.685e-06 sb=9.45e-07 sd=160n sca=8.27167 \
        scb=0.00612996 scc=0.000112653 m=(1)
mn37 (\9\:n20 \5\:CKbb n25 VSS) g45n1hvt w=(2.05e-07) l=4.5e-08 nf=1 \
        as=2.767e-14 ad=6.047e-14 ps=6.8e-07 pd=1e-06 nrd=1.16667 \
        nrs=1.16667 sa=1.865e-06 sb=7.65e-07 sd=160n sca=8.27167 \
        scb=0.00612996 scc=0.000112653 m=(1)
mn26 (\9\:n20 \9\:CKb n21 VSS) g45n1hvt w=(2.05e-07) l=4.5e-08 nf=1 \
        as=4.92e-14 ad=6.047e-14 ps=8.9e-07 pd=1e-06 nrd=1.16667 \
        nrs=1.16667 sa=2e-06 sb=4.25e-07 sd=160n sca=8.27167 \
        scb=0.00612996 scc=0.000112653 m=(1)
mn25 (n21 \3\:D \15\:VSS VSS) g45n1hvt w=(2.05e-07) l=4.5e-08 nf=1 \
        as=2.87e-14 ad=4.92e-14 ps=6.9e-07 pd=8.9e-07 nrd=1.16667 \
        nrs=1.16667 sa=2e-06 sb=1.4e-07 sd=160n sca=8.27167 scb=0.00612996 \
        scc=0.000112653 m=(1)
mp45_1__rcx (\28\:qbint RN \8\:VDD VDD) g45p1hvt w=(3.9e-07) l=4.5e-08 \
        nf=1 as=9.878e-14 ad=6.695e-14 ps=1.36e-06 pd=1.12333e-06 \
        nrd=1.16667 nrs=1.16667 sa=1.645e-06 sb=1.15577e-06 sd=160n \
        sca=19.0259 scb=0.0163587 scc=0.00171562 m=(3)
mp46_1__rcx (\28\:qbint n30 \8\:VDD VDD) g45p1hvt w=(3.9e-07) l=4.5e-08 \
        nf=1 as=7.253e-14 ad=6.695e-14 ps=1.44e-06 pd=1.12333e-06 \
        nrd=1.16667 nrs=1.16667 sa=1.85e-06 sb=9.50769e-07 sd=160n \
        sca=19.0259 scb=0.0163587 scc=0.00171562 m=(3)
mp21 (\13\:CKbb CKb \20\:VDD VDD) g45p1hvt w=(2.15e-07) l=4.5e-08 nf=1 \
        as=1.3643e-13 ad=2.63e-14 ps=2.11e-06 pd=7.1e-07 nrd=1.16667 \
        nrs=1.16667 sa=1.22326e-07 sb=1.53395e-06 sd=160n sca=45.7906 \
        scb=0.0283307 scc=0.00588417 m=(1)
mp20 (\21\:CKb \3\:CK \1\:VDD VDD) g45p1hvt w=(2.15e-07) l=4.5e-08 nf=1 \
        as=6.97e-14 ad=3.01e-14 ps=1.18e-06 pd=7.1e-07 nrd=1.16667 \
        nrs=1.16667 sa=7.23721e-07 sb=1.4e-07 sd=160n sca=15.9567 \
        scb=0.015497 scc=0.000381994 m=(1)
mp50 (n41 \22\:qbint \20\:VDD VDD) g45p1hvt w=(3.1e-07) l=4.5e-08 nf=1 \
        as=1.3643e-13 ad=1.86e-14 ps=2.11e-06 pd=7.4e-07 nrd=1.16667 \
        nrs=1.16667 sa=3.93548e-07 sb=1.28532e-06 sd=160n sca=35.6995 \
        scb=0.0234062 scc=0.00420468 m=(1)
mp51 (\15\:n30 CKbb n41 VDD) g45p1hvt w=(3.1e-07) l=4.5e-08 nf=1 \
        as=1.86e-14 ad=7.595e-14 ps=7.4e-07 pd=1.11e-06 nrd=1.16667 \
        nrs=1.16667 sa=4.98548e-07 sb=1.18032e-06 sd=160n sca=35.6995 \
        scb=0.0234062 scc=0.00420468 m=(1)
mp40 (\15\:n30 \4\:CKb \6\:mout VDD) g45p1hvt w=(3.1e-07) l=4.5e-08 nf=1 \
        as=1.1315e-13 ad=7.595e-14 ps=1.35e-06 pd=1.11e-06 nrd=1.16667 \
        nrs=1.16667 sa=7.88548e-07 sb=8.90323e-07 sd=160n sca=35.6995 \
        scb=0.0234062 scc=0.00420468 m=(1)
mp30 (\6\:mout \4\:n20 \18\:VDD VDD) g45p1hvt w=(3.1e-07) l=4.5e-08 nf=1 \
        as=7.47e-14 ad=1.1315e-13 ps=1.32e-06 pd=1.35e-06 nrd=1.16667 \
        nrs=1.16667 sa=1.19855e-06 sb=4.80323e-07 sd=160n sca=35.6995 \
        scb=0.0234062 scc=0.00420468 m=(1)
mp35 (\3\:n26 \12\:RN \18\:VDD VDD) g45p1hvt w=(3.1e-07) l=4.5e-08 nf=1 \
        as=7.47e-14 ad=8.525e-14 ps=1.32e-06 pd=1.17e-06 nrd=1.16667 \
        nrs=1.16667 sa=8.73548e-07 sb=4.9e-07 sd=160n sca=13.6224 \
        scb=0.0125368 scc=0.000630866 m=(1)
mp36 (\3\:n26 mout \16\:VDD VDD) g45p1hvt w=(3.1e-07) l=4.5e-08 nf=1 \
        as=8.75e-14 ad=8.525e-14 ps=1.54e-06 pd=1.17e-06 nrd=1.16667 \
        nrs=1.16667 sa=1.19355e-06 sb=1.7e-07 sd=160n sca=13.6224 \
        scb=0.0125368 scc=0.000630866 m=(1)
mp37 (\5\:n20 \11\:CKb n26 VDD) g45p1hvt w=(3.1e-07) l=4.5e-08 nf=1 \
        as=4.34e-14 ad=5.14e-14 ps=9e-07 pd=1.03e-06 nrd=1.16667 \
        nrs=1.16667 sa=1.4e-07 sb=5.65161e-07 sd=160n sca=21.39 \
        scb=0.0188316 scc=0.00214554 m=(1)
mp26 (\5\:n20 \7\:CKbb n22 VDD) g45p1hvt w=(3.1e-07) l=4.5e-08 nf=1 \
        as=1.86e-14 ad=5.14e-14 ps=7.4e-07 pd=1.03e-06 nrd=1.16667 \
        nrs=1.16667 sa=3.09435e-07 sb=4.58145e-07 sd=160n sca=16.2905 \
        scb=0.015087 scc=0.00109315 m=(1)
mp25 (n22 \1\:D \1\:VDD VDD) g45p1hvt w=(3.1e-07) l=4.5e-08 nf=1 \
        as=6.97e-14 ad=1.86e-14 ps=1.18e-06 pd=7.4e-07 nrd=1.16667 \
        nrs=1.16667 sa=4.14435e-07 sb=3.53145e-07 sd=160n sca=16.6546 \
        scb=0.0152768 scc=0.00109326 m=(1)
ends DFFRHQX8
// End of subcircuit definition.
