// gsclib045_hvt/ADDHX4/schematic

simulator lang=spectre

subckt ADDHX4 A B CO S VDD VSS
mp8 (CO COb VDD VDD) g45p1hvt w=(1.56u) l=45n nf=1 m=(1)
mp5 (S Sb VDD VDD) g45p1hvt w=(1.56u) l=45n nf=1 m=(1)
mp2 (n3 n0 VDD VDD) g45p1hvt w=(390n) l=45n nf=1 m=(1)
mp3 (Sb n1 n3 VDD) g45p1hvt w=(390n) l=45n nf=1 m=(1)
mp4 (Sb B n0 VDD) g45p1hvt w=(390n) l=45n nf=1 m=(1)
mp1 (n1 B VDD VDD) g45p1hvt w=(215n) l=45n nf=1 m=(1)
mp7 (COb B VDD VDD) g45p1hvt w=(390n) l=45n nf=1 m=(1)
mp0 (n0 A VDD VDD) g45p1hvt w=(215n) l=45n nf=1 m=(1)
mp6 (COb A VDD VDD) g45p1hvt w=(390n) l=45n nf=1 m=(1)
mn8 (CO COb VSS VSS) g45n1hvt w=(1.04u) l=45n nf=1 m=(1)
mn7 (COb B n4 VSS) g45n1hvt w=(260n) l=45n nf=1 m=(1)
mn6 (n4 A VSS VSS) g45n1hvt w=(260n) l=45n nf=1 m=(1)
mn5 (S Sb VSS VSS) g45n1hvt w=(1.04u) l=45n nf=1 m=(1)
mn3 (Sb B n2 VSS) g45n1hvt w=(260n) l=45n nf=1 m=(1)
mn2 (n2 n0 VSS VSS) g45n1hvt w=(260n) l=45n nf=1 m=(1)
mn1 (n1 B VSS VSS) g45n1hvt w=(145n) l=45n nf=1 m=(1)
mn4 (Sb n1 n0 VSS) g45n1hvt w=(260n) l=45n nf=1 m=(1)
mn0 (n0 A VSS VSS) g45n1hvt w=(145n) l=45n nf=1 m=(1)
ends ADDHX4
