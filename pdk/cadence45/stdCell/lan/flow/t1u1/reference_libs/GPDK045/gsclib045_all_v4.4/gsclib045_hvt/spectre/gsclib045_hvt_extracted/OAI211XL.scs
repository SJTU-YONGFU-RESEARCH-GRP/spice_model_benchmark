// Generated for: spectre (May  1 09:18:46 2013 )
// Library name: gsclib045_hvt
// Cell name: OAI211XL
// View name: extracted

simulator lang=spectre

subckt OAI211XL A0 A1 B0 C0 VDD VSS Y
mp0 (n2 \1\:A0 \6\:VDD VDD) g45p1hvt w=(2.15e-07) l=4.5e-08 nf=1 \
        as=4.44e-14 ad=2.15e-14 ps=1.35e-06 pd=6.3e-07 nrd=1.16667 \
        nrs=1.16667 sa=1e-07 sb=7.9e-07 sd=160n sca=16.7249 scb=0.0166366 \
        scc=0.000331722 m=(1)
mp1 (\5\:Y \3\:A1 n2 VDD) g45p1hvt w=(2.15e-07) l=4.5e-08 nf=1 \
        as=2.15e-14 ad=4.623e-14 ps=6.3e-07 pd=8.6e-07 nrd=1.16667 \
        nrs=1.16667 sa=2.45e-07 sb=6.45e-07 sd=160n sca=14.2593 \
        scb=0.0117802 scc=0.000198925 m=(1)
mp2 (\5\:Y \1\:B0 \1\:VDD VDD) g45p1hvt w=(2.15e-07) l=4.5e-08 nf=1 \
        as=5.515e-14 ad=4.623e-14 ps=1.45e-06 pd=8.6e-07 nrd=1.16667 \
        nrs=1.16667 sa=5.05e-07 sb=3.85e-07 sd=160n sca=14.4951 \
        scb=0.0122555 scc=0.000205064 m=(1)
mp3 (\3\:Y \1\:C0 \1\:VDD VDD) g45p1hvt w=(2.15e-07) l=4.5e-08 nf=1 \
        as=5.515e-14 ad=4.085e-14 ps=1.45e-06 pd=8.1e-07 nrd=1.16667 \
        nrs=1.16667 sa=7e-07 sb=1.9e-07 sd=160n sca=19.8673 scb=0.021958 \
        scc=0.00070962 m=(1)
C1 (B0 VSS) capacitor c=9.11027e-17
C2 (Y VSS) capacitor c=1.65011e-17
C3 (A1 VSS) capacitor c=1.23687e-16
C4 (VDD VSS) capacitor c=9.60935e-17
C5 (C0 VSS) capacitor c=6.15609e-17
C6 (A0 VSS) capacitor c=4.23146e-17
C7 (n0 VSS) capacitor c=4.7561e-17
C8 (\1\:C0 VSS) capacitor c=3.68429e-17
C9 (\1\:B0 VSS) capacitor c=6.14629e-17
C10 (\3\:A1 VSS) capacitor c=4.88174e-17
C11 (\1\:A0 VSS) capacitor c=4.10968e-17
C12 (\3\:C0 VSS) capacitor c=6.48189e-17
C13 (\3\:B0 VSS) capacitor c=5.23225e-17
C14 (\1\:A1 VSS) capacitor c=5.09184e-17
C15 (\3\:A0 VSS) capacitor c=4.59325e-17
C16 (\2\:C0 VSS) capacitor c=5.71333e-17
C17 (\2\:B0 VSS) capacitor c=6.56255e-17
C18 (\2\:A1 VSS) capacitor c=6.27665e-17
C19 (\2\:A0 VSS) capacitor c=5.2846e-17
C20 (\3\:Y VSS) capacitor c=7.99802e-17
C21 (\1\:VDD VSS) capacitor c=2.64432e-17
C22 (\5\:Y VSS) capacitor c=4.58441e-17
C23 (\6\:VDD VSS) capacitor c=1.78482e-17
C24 (\1\:Y VSS) capacitor c=6.92182e-17
C25 (\3\:n0 VSS) capacitor c=7.13063e-17
C26 (\4\:A0 VSS) capacitor c=4.15873e-17
C27 (\4\:B0 VSS) capacitor c=4.17237e-17
C28 (\4\:C0 VSS) capacitor c=6.98254e-17
C29 (\4\:VDD VSS) capacitor c=1.71001e-17
C30 (\5\:VDD VSS) capacitor c=3.72658e-18
Rk6 (\4\:B0 B0) resistor r=0.08091 c=0
Rk10 (\4\:Y Y) resistor r=0.03755 c=0
Rk8 (\2\:Y \4\:Y) resistor r=0.585 c=0
Rk9 (\4\:Y \6\:Y) resistor r=0.3026 c=0
Rk2 (\4\:A1 A1) resistor r=0.002987 c=0
Rk16 (\3\:VSS VSS) resistor r=0.1671 c=0
Rk17 (\3\:VSS \5\:VSS) resistor r=0.1994 c=0
Rk11 (\2\:VDD \4\:VDD) resistor r=0.2114 c=0
Rk13 (\5\:VDD VDD) resistor r=0.08707 c=0
Rk12 (\4\:VDD \5\:VDD) resistor r=0.1623 c=0
Rk14 (\5\:VDD \7\:VDD) resistor r=0.073 c=0
Rk7 (C0 \4\:C0) resistor r=0.2091 c=0
Rk1 (A0 \4\:A0) resistor r=0.224 c=0
Rk3 (\2\:n0 \4\:n0) resistor r=0.4489 c=0
Rl5 (\1\:B0 \2\:B0) resistor r=144.923 c=0
Rl6 (\2\:B0 \3\:B0) resistor r=102.615 c=0
Rl4 (\2\:A1 \3\:A1) resistor r=93.4066 c=0
Rl3 (\1\:A1 \2\:A1) resistor r=155.769 c=0
Rl7 (\1\:C0 \2\:C0) resistor r=30.7692 c=0
Rl8 (\2\:C0 \3\:C0) resistor r=218.407 c=0
Rl1 (\1\:A0 \2\:A0) resistor r=85.7134 c=0
Rl2 (\2\:A0 \3\:A0) resistor r=154.944 c=0
Rz3 (\1\:Y \2\:Y) resistor r=75 c=0
Rz5 (\4\:VSS \5\:VSS) resistor r=75 c=0
Rz1 (n0 \2\:n0) resistor r=75 c=0
Rz2 (\3\:n0 \4\:n0) resistor r=75 c=0
Ry1 (\3\:Y \4\:Y) resistor r=62 c=0
Ry2 (\5\:Y \6\:Y) resistor r=62 c=0
Ry3 (\1\:VDD \2\:VDD) resistor r=62 c=0
Ry4 (\6\:VDD \7\:VDD) resistor r=62 c=0
Rx3 (\2\:B0 \4\:B0) resistor r=45 c=0
Rx2 (\2\:A1 \4\:A1) resistor r=45 c=0
Rx4 (\2\:C0 \4\:C0) resistor r=45 c=0
Rx1 (\2\:A0 \4\:A0) resistor r=45 c=0
mn0 (n0 \3\:A0 \4\:VSS VSS) g45n1hvt w=(1.45e-07) l=4.5e-08 nf=1 \
        as=2.32e-14 ad=2.03e-14 ps=6.1e-07 pd=5.7e-07 nrd=1.16667 \
        nrs=1.16667 sa=1.4e-07 sb=7.75e-07 sd=160n sca=7.27658 \
        scb=0.00433573 scc=4.41722e-05 m=(1)
mn1 (\3\:n0 \1\:A1 \4\:VSS VSS) g45n1hvt w=(1.45e-07) l=4.5e-08 nf=1 \
        as=2.32e-14 ad=2.32e-14 ps=6.1e-07 pd=6.1e-07 nrd=1.16667 \
        nrs=1.16667 sa=3.45e-07 sb=5.7e-07 sd=160n sca=7.27658 \
        scb=0.00433573 scc=4.41722e-05 m=(1)
mn2 (n1 \3\:B0 \3\:n0 VSS) g45n1hvt w=(1.45e-07) l=4.5e-08 nf=1 \
        as=2.32e-14 ad=1.377e-14 ps=6.1e-07 pd=4.8e-07 nrd=1.16667 \
        nrs=1.16667 sa=5.5e-07 sb=3.65e-07 sd=160n sca=7.27658 \
        scb=0.00433573 scc=4.41722e-05 m=(1)
mn3 (\1\:Y \3\:C0 n1 VSS) g45n1hvt w=(1.45e-07) l=4.5e-08 nf=1 \
        as=1.378e-14 ad=3.263e-14 ps=4.8e-07 pd=7.4e-07 nrd=1.16667 \
        nrs=1.16667 sa=6.9e-07 sb=2.25e-07 sd=160n sca=7.27658 \
        scb=0.00433573 scc=4.41722e-05 m=(1)
ends OAI211XL
// End of subcircuit definition.
