// Generated for: spectre (May  1 11:30:33 2013 )
// Library name: gsclib045_backbias
// Cell name: NAND4BX2
// View name: extracted

simulator lang=spectre

subckt NAND4BX2 AN B C D NW VDD VSS Y
mp0 (\12\:net118 \1\:AN \16\:VDD NW) g45p1svt w=(2.15e-07) l=4.5e-08 \
        nf=1 as=3.01e-14 ad=5.15e-14 ps=7.1e-07 pd=1.13e-06 nrd=1.16667 \
        nrs=1.16667 sa=1.4e-07 sb=2.39535e-07 sd=160n sca=56.1973 \
        scb=0.0435219 scc=0.00667686 m=(1)
C1 (NW VSS) capacitor c=3.5732e-16
C2 (B VSS) capacitor c=5.39623e-17
C3 (AN VSS) capacitor c=4.4054e-17
C4 (D VSS) capacitor c=5.64104e-17
C5 (VDD VSS) capacitor c=2.11433e-17
C6 (net118 VSS) capacitor c=8.03951e-17
C7 (net122 VSS) capacitor c=1.91762e-16
C8 (net126 VSS) capacitor c=1.19285e-16
C9 (net130 VSS) capacitor c=1.72087e-16
C10 (\1\:B VSS) capacitor c=1.01467e-16
C11 (\1\:AN VSS) capacitor c=2.57826e-17
C12 (\1\:D VSS) capacitor c=7.47157e-17
C13 (\1\:C VSS) capacitor c=8.97864e-17
C14 (\3\:AN VSS) capacitor c=1.88707e-17
C15 (\3\:D VSS) capacitor c=9.06592e-17
C16 (\3\:C VSS) capacitor c=1.05799e-16
C17 (\3\:net118 VSS) capacitor c=1.26799e-17
C18 (\2\:AN VSS) capacitor c=1.67243e-17
C19 (\1\:VDD VSS) capacitor c=4.59426e-16
C20 (\1\:Y VSS) capacitor c=8.28142e-17
C21 (\8\:Y VSS) capacitor c=3.60059e-17
C22 (\10\:Y VSS) capacitor c=4.03483e-17
C23 (\6\:Y VSS) capacitor c=5.30136e-17
C24 (\12\:net118 VSS) capacitor c=1.07192e-17
C25 (\16\:VDD VSS) capacitor c=3.33685e-17
C26 (\12\:Y VSS) capacitor c=1.91665e-16
C27 (\3\:net126 VSS) capacitor c=1.16215e-16
C28 (\10\:net118 VSS) capacitor c=4.88389e-17
C29 (\5\:net118 VSS) capacitor c=7.09194e-17
C30 (\3\:B VSS) capacitor c=8.60787e-17
C31 (\4\:AN VSS) capacitor c=3.97349e-17
C32 (\8\:net118 VSS) capacitor c=1.87691e-17
C33 (\9\:net118 VSS) capacitor c=2.70231e-17
C34 (\7\:B VSS) capacitor c=4.9822e-17
C35 (\7\:C VSS) capacitor c=6.40368e-17
C36 (\9\:C VSS) capacitor c=6.87063e-17
C37 (\3\:Y VSS) capacitor c=6.88987e-17
C38 (\4\:Y VSS) capacitor c=3.29356e-17
C39 (\5\:Y VSS) capacitor c=1.54122e-16
C40 (\7\:D VSS) capacitor c=3.77066e-17
C41 (\7\:VDD VSS) capacitor c=4.29735e-17
Rk34 (\2\:VSS \3\:VSS) resistor r=0.6523 c=0
Rk35 (\3\:VSS \4\:VSS) resistor r=0.193 c=0
Rk37 (\5\:VSS VSS) resistor r=0.03718 c=0
Rk36 (\4\:VSS \5\:VSS) resistor r=0.3207 c=0
Rk38 (\4\:VSS \7\:VSS) resistor r=0.1952 c=0
Rk39 (\5\:VSS \9\:VSS) resistor r=0.07416 c=0
Rk9 (\7\:C \8\:C) resistor r=0.002116 c=0
Rk10 (C \9\:C) resistor r=0.002116 c=0
Rk11 (\7\:C \9\:C) resistor r=0.04922 c=0
Rk12 (\2\:Y \3\:Y) resistor r=0.3759 c=0
Rk17 (\4\:Y Y) resistor r=0.03368 c=0
Rk13 (\3\:Y \4\:Y) resistor r=0.338 c=0
Rk14 (\4\:Y \5\:Y) resistor r=0.09266 c=0
Rk15 (\5\:Y \7\:Y) resistor r=0.2859 c=0
Rk16 (\3\:Y \9\:Y) resistor r=0.05819 c=0
Rk18 (Y \11\:Y) resistor r=0.01112 c=0
Rk19 (\5\:Y \13\:Y) resistor r=1.2418 c=0
Rk7 (\7\:B B) resistor r=0.03181 c=0
Rk1 (AN \4\:AN) resistor r=0.09243 c=0
Rk22 (\7\:D D) resistor r=0.02957 c=0
Rk28 (\7\:VDD VDD) resistor r=0.01711 c=0
Rk27 (\1\:VDD \7\:VDD) resistor r=0.2881 c=0
Rk33 (\7\:VDD \17\:VDD) resistor r=0.4193 c=0
Rk2 (\8\:net118 \9\:net118) resistor r=0.08653 c=0
Rk3 (\9\:net118 \11\:net118) resistor r=0.2283 c=0
Rk4 (\9\:net118 \13\:net118) resistor r=0.06384 c=0
Rk8 (\2\:net126 \4\:net126) resistor r=0.395 c=0
Rl15 (\3\:C \1\:C) resistor r=75.3894 c=0
Rl10 (\3\:B \1\:B) resistor r=81.1008 c=0
Rl1 (\1\:AN \2\:AN) resistor r=39.6174 c=0
Rl2 (\2\:AN \3\:AN) resistor r=24.2328 c=0
Rl20 (\3\:D \1\:D) resistor r=27.8457 c=0
Rl4 (net118 \3\:net118) resistor r=15.8314 c=0
Rl6 (\5\:net118 \3\:net118) resistor r=36.6223 c=0
Rz11 (\7\:VSS \6\:VSS) resistor r=75 c=0
Rz12 (\9\:VSS \8\:VSS) resistor r=75 c=0
Rz7 (\13\:Y \12\:Y) resistor r=75 c=0
Rz1 (\11\:net118 \10\:net118) resistor r=75 c=0
Rz5 (\2\:net126 net126) resistor r=75 c=0
Rz6 (\4\:net126 \3\:net126) resistor r=75 c=0
Ry12 (\2\:VSS \1\:VSS) resistor r=62 c=0
Ry13 (\3\:VSS \1\:VSS) resistor r=5.1667 c=0
Ry2 (\2\:Y \1\:Y) resistor r=31 c=0
Ry3 (\7\:Y \6\:Y) resistor r=31 c=0
Ry4 (\9\:Y \8\:Y) resistor r=31 c=0
Ry5 (\11\:Y \10\:Y) resistor r=31 c=0
Ry11 (\17\:VDD \16\:VDD) resistor r=62 c=0
Ry1 (\13\:net118 \12\:net118) resistor r=62 c=0
Rx4 (\8\:C \3\:C) resistor r=45 c=0
Rx3 (\7\:B \1\:B) resistor r=45 c=0
Rx1 (\2\:AN \4\:AN) resistor r=45 c=0
Rx5 (\7\:D \3\:D) resistor r=45 c=0
Rx2 (\8\:net118 \3\:net118) resistor r=45 c=0
mn0 (\10\:net118 \3\:AN \8\:VSS VSS) g45n1svt w=(1.45e-07) l=4.5e-08 \
        nf=1 as=4.465e-14 ad=2.755e-14 ps=1.5e-06 pd=6.7e-07 nrd=1.16667 \
        nrs=1.16667 sa=1e-07 sb=1.9e-07 sd=160n sca=23.279 scb=0.0230742 \
        scc=0.00267719 m=(1)
mn3 (net130 \1\:C net126 VSS) g45n1svt w=(2.6e-07) l=4.5e-08 nf=1 \
        as=4.16e-14 ad=4.095e-14 ps=8.4e-07 pd=8.35e-07 nrd=1.16667 \
        nrs=1.16667 sa=1.55e-07 sb=7.55e-07 sd=160n sca=9.50447 \
        scb=0.0081528 scc=0.00025289 m=(2)
mn1 (net122 \5\:net118 \6\:VSS VSS) g45n1svt w=(2.6e-07) l=4.5e-08 nf=1 \
        as=4.16e-14 ad=3.9e-14 ps=8.4e-07 pd=8.2e-07 nrd=1.16667 \
        nrs=1.16667 sa=1.4e-07 sb=7.7e-07 sd=160n sca=8.51051 \
        scb=0.00656948 scc=0.000151659 m=(2)
mn4 (\12\:Y \1\:D net130 VSS) g45n1svt w=(2.6e-07) l=4.5e-08 nf=1 \
        as=3.9e-14 ad=4.16e-14 ps=8.2e-07 pd=8.4e-07 nrd=1.16667 \
        nrs=1.16667 sa=5.65e-07 sb=3.45e-07 sd=160n sca=9.50447 \
        scb=0.0081528 scc=0.00025289 m=(2)
mn2_1__rcx (\3\:net126 \3\:B net122 VSS) g45n1svt w=(2.6e-07) l=4.5e-08 \
        nf=1 as=3.9e-14 ad=4.55e-14 ps=8.2e-07 pd=8.7e-07 nrd=1.16667 \
        nrs=1.16667 sa=5.5e-07 sb=3.6e-07 sd=160n sca=8.51051 \
        scb=0.00656948 scc=0.000151659 m=(2)
mp2_1__rcx (\10\:Y \1\:B \1\:VDD NW) g45p1svt w=(3.9e-07) l=4.5e-08 nf=1 \
        as=6.24e-14 ad=6.24e-14 ps=1.1e-06 pd=1.1e-06 nrd=1.16667 \
        nrs=1.16667 sa=5.22308e-07 sb=1.165e-06 sd=160n sca=14.1011 \
        scb=0.0127228 scc=0.000754417 m=(2)
mp4_1__rcx (\1\:Y \3\:D \1\:VDD NW) g45p1svt w=(3.9e-07) l=4.5e-08 nf=1 \
        as=5.85e-14 ad=6.24e-14 ps=1.08e-06 pd=1.1e-06 nrd=1.16667 \
        nrs=1.16667 sa=1.34231e-06 sb=3.45e-07 sd=160n sca=15.7702 \
        scb=0.0139777 scc=0.000757166 m=(2)
mp1_1__rcx (\6\:Y net118 \1\:VDD NW) g45p1svt w=(3.9e-07) l=4.5e-08 nf=1 \
        as=5.31e-14 ad=6.24e-14 ps=1.08e-06 pd=1.1e-06 nrd=1.16667 \
        nrs=1.16667 sa=1.12308e-07 sb=1.575e-06 sd=160n sca=14.4586 \
        scb=0.0128281 scc=0.000754439 m=(2)
mp3_1__rcx (\8\:Y \3\:C \1\:VDD NW) g45p1svt w=(3.9e-07) l=4.5e-08 nf=1 \
        as=6.24e-14 ad=6.24e-14 ps=1.1e-06 pd=1.1e-06 nrd=1.16667 \
        nrs=1.16667 sa=9.32308e-07 sb=7.55e-07 sd=160n sca=14.1011 \
        scb=0.0127228 scc=0.000754417 m=(2)
ends NAND4BX2
// End of subcircuit definition.
