// Generated for: spectre (May  1 11:33:04 2013 )
// Library name: gsclib045_backbias
// Cell name: TBUFX1
// View name: extracted

simulator lang=spectre

subckt TBUFX1 A NW OE VDD VSS Y
mp4 (\4\:pon \3\:OE \7\:VDD NW) g45p1svt w=(2.15e-07) l=4.5e-08 nf=1 \
        as=3.225e-14 ad=3.44e-14 ps=7.3e-07 pd=7.5e-07 nrd=1.16667 \
        nrs=1.16667 sa=1.5e-07 sb=6.1e-07 sd=160n sca=20.0544 \
        scb=0.0221539 scc=0.000755314 m=(1)
mp3 (\4\:pon \1\:A \5\:VDD NW) g45p1svt w=(2.15e-07) l=4.5e-08 nf=1 \
        as=7.97e-14 ad=3.44e-14 ps=1.41e-06 pd=7.5e-07 nrd=1.16667 \
        nrs=1.16667 sa=3.55e-07 sb=4.05e-07 sd=160n sca=13.5021 \
        scb=0.0113243 scc=0.000155139 m=(1)
mp0 (\6\:OEb \4\:OE \5\:VDD NW) g45p1svt w=(2.15e-07) l=4.5e-08 nf=1 \
        as=7.97e-14 ad=3.01e-14 ps=1.41e-06 pd=7.1e-07 nrd=1.16667 \
        nrs=1.16667 sa=6.2e-07 sb=1.4e-07 sd=160n sca=11.3955 \
        scb=0.00869667 scc=0.000138257 m=(1)
mp2 (\5\:non OEb net127 NW) g45p1svt w=(2.15e-07) l=4.5e-08 nf=1 \
        as=1.29e-14 ad=3.01e-14 ps=5.5e-07 pd=7.1e-07 nrd=1.16667 \
        nrs=1.16667 sa=1.4e-07 sb=6.35e-07 sd=160n sca=40.6729 \
        scb=0.0277136 scc=0.00519699 m=(1)
mp1 (net127 \4\:A \1\:VDD NW) g45p1svt w=(2.15e-07) l=4.5e-08 nf=1 \
        as=9.652e-14 ad=1.29e-14 ps=1.45e-06 pd=5.5e-07 nrd=1.16667 \
        nrs=1.16667 sa=2.45e-07 sb=5.3e-07 sd=160n sca=41.2802 \
        scb=0.0282849 scc=0.00519823 m=(1)
C1 (OE VSS) capacitor c=3.19083e-17
C2 (NW VSS) capacitor c=3.36354e-16
C3 (Y VSS) capacitor c=2.90149e-17
C4 (VDD VSS) capacitor c=2.10725e-17
C5 (A VSS) capacitor c=1.80935e-16
C6 (pon VSS) capacitor c=3.17892e-17
C7 (OEb VSS) capacitor c=6.27973e-17
C8 (non VSS) capacitor c=4.07077e-17
C9 (\4\:A VSS) capacitor c=7.88736e-17
C10 (\4\:OE VSS) capacitor c=4.71427e-17
C11 (\1\:A VSS) capacitor c=3.82211e-17
C12 (\3\:OE VSS) capacitor c=3.72557e-17
C13 (\5\:A VSS) capacitor c=5.47959e-17
C14 (\3\:OEb VSS) capacitor c=3.03392e-17
C15 (\7\:OE VSS) capacitor c=4.03986e-17
C16 (\3\:A VSS) capacitor c=5.96017e-17
C17 (\1\:OE VSS) capacitor c=3.94766e-17
C18 (\2\:pon VSS) capacitor c=2.31867e-17
C19 (\2\:non VSS) capacitor c=3.77254e-17
C20 (\6\:A VSS) capacitor c=2.56838e-17
C21 (\2\:OEb VSS) capacitor c=3.93687e-17
C22 (\6\:OE VSS) capacitor c=1.64668e-17
C23 (\2\:A VSS) capacitor c=5.57982e-17
C24 (\2\:OE VSS) capacitor c=4.13914e-17
C25 (\3\:Y VSS) capacitor c=8.17094e-17
C26 (\1\:VDD VSS) capacitor c=1.94252e-16
C27 (\5\:non VSS) capacitor c=5.16376e-17
C28 (\6\:OEb VSS) capacitor c=8.13831e-17
C29 (\5\:VDD VSS) capacitor c=2.01122e-17
C30 (\4\:pon VSS) capacitor c=2.2541e-16
C31 (\7\:VDD VSS) capacitor c=4.07056e-17
C32 (\1\:Y VSS) capacitor c=2.532e-17
C33 (\7\:non VSS) capacitor c=3.71587e-17
C34 (\8\:OEb VSS) capacitor c=3.74256e-17
C35 (\6\:pon VSS) capacitor c=6.02899e-17
C36 (\5\:OE VSS) capacitor c=2.36132e-17
C37 (\8\:OE VSS) capacitor c=3.31319e-17
C38 (\9\:OE VSS) capacitor c=3.59562e-17
C39 (\10\:OE VSS) capacitor c=3.35569e-17
C40 (\4\:OEb VSS) capacitor c=2.95043e-17
C41 (\5\:OEb VSS) capacitor c=7.42675e-17
C42 (\7\:A VSS) capacitor c=3.57166e-17
C43 (\8\:A VSS) capacitor c=1.33564e-16
C44 (\3\:non VSS) capacitor c=3.17615e-17
C45 (\4\:non VSS) capacitor c=4.0434e-17
C46 (\3\:pon VSS) capacitor c=1.88167e-16
C47 (\3\:VDD VSS) capacitor c=1.03208e-16
C48 (\4\:VDD VSS) capacitor c=3.03031e-17
Rk3 (\9\:OE OE) resistor r=0.09855 c=0
Rk1 (\8\:OE \9\:OE) resistor r=0.09991 c=0
Rk2 (\9\:OE \10\:OE) resistor r=0.1315 c=0
Rk14 (Y \2\:Y) resistor r=0.06799 c=0
Rk15 (Y \4\:Y) resistor r=0.4085 c=0
Rk16 (\2\:VDD \3\:VDD) resistor r=0.9495 c=0
Rk18 (\4\:VDD VDD) resistor r=0.01962 c=0
Rk17 (\3\:VDD \4\:VDD) resistor r=0.2244 c=0
Rk19 (\3\:VDD \6\:VDD) resistor r=0.04333 c=0
Rk20 (\4\:VDD \8\:VDD) resistor r=0.2629 c=0
Rk7 (\7\:A A) resistor r=0.1512 c=0
Rk8 (A \8\:A) resistor r=1.1058 c=0
Rk21 (\2\:VSS \4\:VSS) resistor r=0.5098 c=0
Rk23 (\5\:VSS VSS) resistor r=0.2454 c=0
Rk22 (\4\:VSS \5\:VSS) resistor r=0.2055 c=0
Rk24 (\4\:VSS \7\:VSS) resistor r=0.0715 c=0
Rk25 (\5\:VSS \9\:VSS) resistor r=0.2849 c=0
Rk12 (\3\:pon \5\:pon) resistor r=1.4482 c=0
Rk13 (\5\:pon \7\:pon) resistor r=0.6071 c=0
Rk4 (\4\:OEb \5\:OEb) resistor r=0.09504 c=0
Rk5 (\5\:OEb \7\:OEb) resistor r=0.5608 c=0
Rk6 (\5\:OEb \9\:OEb) resistor r=0.1516 c=0
Rk9 (\3\:non \4\:non) resistor r=0.1125 c=0
Rk10 (\4\:non \6\:non) resistor r=0.2942 c=0
Rk11 (\4\:non \8\:non) resistor r=0.1776 c=0
Rl2 (\2\:OE \3\:OE) resistor r=87.6374 c=0
Rl1 (\1\:OE \2\:OE) resistor r=90.3846 c=0
Rl5 (\4\:OE \5\:OE) resistor r=107.406 c=0
Rl7 (\5\:OE \7\:OE) resistor r=86.2526 c=0
Rl6 (\5\:OE \6\:OE) resistor r=2.0166 c=0
Rl10 (\4\:A \5\:A) resistor r=134.615 c=0
Rl11 (\5\:A \6\:A) resistor r=24.2328 c=0
Rl3 (\1\:A \2\:A) resistor r=26.098 c=0
Rl4 (\2\:A \3\:A) resistor r=143.406 c=0
Rl13 (pon \2\:pon) resistor r=26.098 c=0
Rl8 (OEb \2\:OEb) resistor r=103.823 c=0
Rl9 (\2\:OEb \3\:OEb) resistor r=24.7951 c=0
Rl12 (non \2\:non) resistor r=59.1284 c=0
Rz4 (\1\:Y \2\:Y) resistor r=75 c=0
Rz5 (\1\:VSS \2\:VSS) resistor r=75 c=0
Rz6 (\6\:VSS \7\:VSS) resistor r=75 c=0
Rz7 (\8\:VSS \9\:VSS) resistor r=75 c=0
Rz3 (\6\:pon \7\:pon) resistor r=75 c=0
Rz1 (\8\:OEb \9\:OEb) resistor r=75 c=0
Rz2 (\7\:non \8\:non) resistor r=75 c=0
Ry4 (\3\:Y \4\:Y) resistor r=20.6667 c=0
Ry5 (\1\:VDD \2\:VDD) resistor r=31 c=0
Ry6 (\5\:VDD \6\:VDD) resistor r=62 c=0
Ry7 (\7\:VDD \8\:VDD) resistor r=62 c=0
Ry3 (\4\:pon \5\:pon) resistor r=62 c=0
Ry1 (\6\:OEb \7\:OEb) resistor r=62 c=0
Ry2 (\5\:non \6\:non) resistor r=62 c=0
Rx1 (\6\:OE \8\:OE) resistor r=45 c=0
Rx2 (\2\:OE \10\:OE) resistor r=45 c=0
Rx4 (\2\:A \7\:A) resistor r=45 c=0
Rx5 (\6\:A \8\:A) resistor r=45 c=0
Rx7 (\2\:pon \3\:pon) resistor r=45 c=0
Rx3 (\2\:OEb \4\:OEb) resistor r=45 c=0
Rx6 (\2\:non \3\:non) resistor r=45 c=0
mn4 (\6\:pon \1\:OE net144 VSS) g45n1svt w=(1.45e-07) l=4.5e-08 nf=1 \
        as=1.522e-14 ad=2.03e-14 ps=5e-07 pd=5.7e-07 nrd=1.16667 \
        nrs=1.16667 sa=1.4e-07 sb=6.7e-07 sd=160n sca=17.28 scb=0.0183577 \
        scc=0.00144167 m=(1)
mn3 (net144 \3\:A \8\:VSS VSS) g45n1svt w=(1.45e-07) l=4.5e-08 nf=1 \
        as=4.33e-14 ad=1.522e-14 ps=9.2e-07 pd=5e-07 nrd=1.16667 \
        nrs=1.16667 sa=2.9e-07 sb=5.2e-07 sd=160n sca=17.28 scb=0.0183577 \
        scc=0.00144167 m=(1)
mn0 (\8\:OEb \7\:OE \8\:VSS VSS) g45n1svt w=(1.45e-07) l=4.5e-08 nf=1 \
        as=4.33e-14 ad=3.698e-14 ps=9.2e-07 pd=8e-07 nrd=1.16667 \
        nrs=1.16667 sa=5.55e-07 sb=2.55e-07 sd=160n sca=17.28 \
        scb=0.0183577 scc=0.00144167 m=(1)
mn2 (\7\:non \3\:OEb \6\:VSS VSS) g45n1svt w=(1.45e-07) l=4.5e-08 nf=1 \
        as=3.965e-14 ad=2.32e-14 ps=1.3e-06 pd=6.1e-07 nrd=1.16667 \
        nrs=1.16667 sa=1e-07 sb=6e-07 sd=160n sca=12.2839 scb=0.0124725 \
        scc=0.000542081 m=(1)
mn1 (\7\:non \5\:A \1\:VSS VSS) g45n1svt w=(1.45e-07) l=4.5e-08 nf=1 \
        as=4.655e-14 ad=2.32e-14 ps=9.4e-07 pd=6.1e-07 nrd=1.16667 \
        nrs=1.16667 sa=3.05e-07 sb=3.95e-07 sd=160n sca=12.2839 \
        scb=0.0124725 scc=0.000542081 m=(1)
mn5 (\1\:Y non \1\:VSS VSS) g45n1svt w=(2.6e-07) l=4.5e-08 nf=1 \
        as=4.655e-14 ad=3.64e-14 ps=9.4e-07 pd=8e-07 nrd=1.16667 \
        nrs=1.16667 sa=3.74231e-07 sb=1.4e-07 sd=160n sca=10.104 \
        scb=0.00906063 scc=0.000325539 m=(1)
mp5 (\3\:Y pon \1\:VDD NW) g45p1svt w=(3.9e-07) l=4.5e-08 nf=1 \
        as=9.652e-14 ad=5.85e-14 ps=1.45e-06 pd=1.08e-06 nrd=1.16667 \
        nrs=1.16667 sa=4.07372e-07 sb=1.5e-07 sd=160n sca=39.7153 \
        scb=0.0373018 scc=0.00416002 m=(1)
ends TBUFX1
// End of subcircuit definition.
