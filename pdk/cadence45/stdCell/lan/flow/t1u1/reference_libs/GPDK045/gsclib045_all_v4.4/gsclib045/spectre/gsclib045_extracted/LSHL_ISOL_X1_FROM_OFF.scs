// Generated for: spectre (May  1 08:11:45 2013 )
// Library name: gsclib045
// Cell name: LSHL_ISOL_X1_FROM_OFF
// View name: extracted

simulator lang=spectre

subckt LSHL_ISOL_X1_FROM_OFF A ExtVDD ISO VSS Y
mp0 (\10\:n0 \1\:A \3\:ExtVDD ExtVDD) g45p1svt w=(2.15e-07) l=4.5e-08 \
        nf=1 as=3.01e-14 ad=3.44e-14 ps=7.1e-07 pd=7.5e-07 nrd=1.16667 \
        nrs=1.16667 sa=3.45e-07 sb=1.4e-07 sd=160n sca=10.3748 \
        scb=0.0076556 scc=9.01214e-05 m=(1)
PM2 (\12\:n0 ison \1\:ExtVDD ExtVDD) g45p1svt w=(2.15e-07) l=4.5e-08 \
        nf=1 as=6.535e-14 ad=3.01e-14 ps=1.16e-06 pd=7.1e-07 nrd=1.16667 \
        nrs=1.16667 sa=1.4e-07 sb=3.75e-07 sd=160n sca=9.77243 \
        scb=0.00646231 scc=5.51311e-05 m=(1)
PM1 (\9\:ison \1\:ISO \3\:ExtVDD ExtVDD) g45p1svt w=(2.15e-07) l=4.5e-08 \
        nf=1 as=3.01e-14 ad=3.44e-14 ps=7.1e-07 pd=7.5e-07 nrd=1.16667 \
        nrs=1.16667 sa=1.4e-07 sb=3.45e-07 sd=160n sca=24.9384 \
        scb=0.0256412 scc=0.00265206 m=(1)
C1 (VDD VSS) capacitor c=1.04747e-16
C2 (Y VSS) capacitor c=4.52345e-17
C3 (ExtVDD VSS) capacitor c=1.64458e-16
C4 (ISO VSS) capacitor c=5.57917e-17
C5 (A VSS) capacitor c=4.44721e-17
C6 (n0 VSS) capacitor c=3.95536e-17
C7 (ison VSS) capacitor c=6.59482e-17
C8 (GatedVSS VSS) capacitor c=1.77225e-16
C9 (\4\:n0 VSS) capacitor c=4.58485e-17
C10 (\1\:A VSS) capacitor c=6.21124e-17
C11 (\1\:ISO VSS) capacitor c=8.8691e-17
C12 (\4\:A VSS) capacitor c=3.64941e-17
C13 (\4\:ISO VSS) capacitor c=4.38942e-17
C14 (\3\:n0 VSS) capacitor c=4.05316e-17
C15 (\4\:ison VSS) capacitor c=1.73926e-17
C16 (\3\:A VSS) capacitor c=8.4282e-17
C17 (\3\:ISO VSS) capacitor c=1.57166e-17
C18 (\3\:Y VSS) capacitor c=6.31988e-17
C19 (\1\:ExtVDD VSS) capacitor c=1.52298e-16
C20 (\12\:n0 VSS) capacitor c=3.34608e-17
C21 (\10\:n0 VSS) capacitor c=3.61729e-17
C22 (\3\:ExtVDD VSS) capacitor c=1.21178e-16
C23 (\9\:ison VSS) capacitor c=1.43527e-16
C24 (\1\:Y VSS) capacitor c=3.72968e-17
C25 (\5\:GatedVSS VSS) capacitor c=5.43164e-17
C26 (\7\:n0 VSS) capacitor c=1.39398e-16
C27 (\7\:ison VSS) capacitor c=1.38227e-16
C28 (ExtVDD VSS) capacitor c=1.19351e-16
C29 (\2\:ISO VSS) capacitor c=6.08222e-17
C30 (VDD VSS) capacitor c=2.21342e-16
C31 (\2\:ison VSS) capacitor c=1.14207e-16
C32 (\7\:A VSS) capacitor c=2.97304e-17
C33 (\6\:ison VSS) capacitor c=1.18238e-16
C34 (\5\:n0 VSS) capacitor c=4.64164e-17
C35 (\6\:n0 VSS) capacitor c=1.43778e-16
C36 (\9\:n0 VSS) capacitor c=3.11687e-17
Rk29 (VDD VDD) resistor r=0.407 c=0
Rk22 (\3\:VSS VSS) resistor r=0.1531 c=0
Rk21 (\2\:VSS \3\:VSS) resistor r=0.4312 c=0
Rk23 (VSS \4\:VSS) resistor r=0.06343 c=0
Rk25 (\5\:VSS VSS) resistor r=0.3654 c=0
Rk24 (\4\:VSS \5\:VSS) resistor r=0.03393 c=0
Rk26 (VSS \7\:VSS) resistor r=0.4332 c=0
Rk27 (\3\:VSS \9\:VSS) resistor r=0.2567 c=0
Rk28 (\4\:VSS \11\:VSS) resistor r=0.209 c=0
Rk30 (\13\:VSS VSS) resistor r=0.5847 c=0
Rk32 (\14\:VSS VSS) resistor r=0.3654 c=0
Rk31 (VSS \14\:VSS) resistor r=0.09774 c=0
Rk19 (\2\:Y Y) resistor r=0.1618 c=0
Rk20 (Y \4\:Y) resistor r=0.3688 c=0
Rk12 (ExtVDD ExtVDD) resistor r=0.00388 c=0
Rk11 (\4\:ExtVDD ExtVDD) resistor r=0.2736 c=0
Rk10 (\2\:ExtVDD \4\:ExtVDD) resistor r=0.8519 c=0
Rk1 (\5\:ISO ISO) resistor r=0.01211 c=0
Rk5 (A \7\:A) resistor r=0.01179 c=0
Rk4 (\6\:A \7\:A) resistor r=0.006737 c=0
Rk14 (\5\:n0 \6\:n0) resistor r=0.242 c=0
Rk15 (\6\:n0 \8\:n0) resistor r=0.8405 c=0
Rk16 (\6\:n0 \9\:n0) resistor r=0.2588 c=0
Rk17 (\9\:n0 \11\:n0) resistor r=0.02663 c=0
Rk18 (\9\:n0 \13\:n0) resistor r=0.03226 c=0
Rk6 (\6\:ison \8\:ison) resistor r=0.6356 c=0
Rk7 (\8\:ison \10\:ison) resistor r=0.8662 c=0
Rk9 (GatedVSS \6\:GatedVSS) resistor r=0.08685 c=0
Rl1 (\1\:ISO \2\:ISO) resistor r=245.671 c=0
Rl3 (\2\:ISO \4\:ISO) resistor r=203.048 c=0
Rl2 (\2\:ISO \3\:ISO) resistor r=21.3506 c=0
Rl4 (\1\:A \2\:A) resistor r=213.712 c=0
Rl6 (\2\:A \4\:A) resistor r=145.474 c=0
Rl5 (\2\:A \3\:A) resistor r=5.8309 c=0
Rl13 (\2\:n0 \4\:n0) resistor r=55.4393 c=0
Rl11 (n0 \2\:n0) resistor r=113.624 c=0
Rl12 (\2\:n0 \3\:n0) resistor r=0.6051 c=0
Rl7 (\2\:ison ison) resistor r=257.877 c=0
Rl9 (\4\:ison \2\:ison) resistor r=77.0076 c=0
Rz8 (\7\:VSS \6\:VSS) resistor r=75 c=0
Rz9 (\9\:VSS \8\:VSS) resistor r=37.5 c=0
Rz10 (\11\:VSS \10\:VSS) resistor r=75 c=0
Rz7 (\1\:Y \2\:Y) resistor r=37.5 c=0
Rz6 (\7\:n0 \8\:n0) resistor r=75 c=0
Rz1 (\8\:ison \7\:ison) resistor r=75 c=0
Rz4 (\6\:GatedVSS \5\:GatedVSS) resistor r=75 c=0
Ry7 (\2\:VSS \1\:VSS) resistor r=31 c=0
Ry8 (\5\:VSS \1\:VSS) resistor r=5.1667 c=0
Ry9 (\13\:VSS \12\:VSS) resistor r=31 c=0
Ry10 (\14\:VSS \12\:VSS) resistor r=5.1667 c=0
Ry6 (\3\:Y \4\:Y) resistor r=20.6667 c=0
Ry2 (\1\:ExtVDD \2\:ExtVDD) resistor r=20.6667 c=0
Ry3 (\3\:ExtVDD \4\:ExtVDD) resistor r=62 c=0
Ry4 (\10\:n0 \11\:n0) resistor r=62 c=0
Ry5 (\12\:n0 \13\:n0) resistor r=62 c=0
Ry1 (\10\:ison \9\:ison) resistor r=62 c=0
Rx1 (\3\:ISO \5\:ISO) resistor r=45 c=0
Rx2 (\3\:A \6\:A) resistor r=45 c=0
Rx4 (\3\:n0 \5\:n0) resistor r=45 c=0
Rx3 (\6\:ison \4\:ison) resistor r=45 c=0
NM1 (\6\:VSS \4\:ISO \7\:ison VSS) g45n1svt w=(1.45e-07) l=4.5e-08 nf=1 \
        as=2.03e-14 ad=2.03e-14 ps=5.7e-07 pd=5.7e-07 nrd=1.16667 \
        nrs=1.16667 sa=1.4e-07 sb=1.4e-07 sd=160n sca=3.6606 \
        scb=0.000125236 scc=4.16931e-09 m=(1)
mn0 (\5\:GatedVSS \4\:A \7\:n0 VSS) g45n1svt w=(1.45e-07) l=4.5e-08 nf=1 \
        as=2.03e-14 ad=2.03e-14 ps=5.7e-07 pd=5.7e-07 nrd=1.16667 \
        nrs=1.16667 sa=1.4e-07 sb=1.4e-07 sd=160n sca=5.84043 \
        scb=0.00267512 scc=0.000297469 m=(1)
NM0 (\1\:Y n0 \8\:VSS VSS) g45n1svt w=(2.6e-07) l=4.5e-08 nf=1 \
        as=3.64e-14 ad=3.64e-14 ps=8e-07 pd=8e-07 nrd=1.16667 nrs=1.16667 \
        sa=1.4e-07 sb=1.4e-07 sd=160n sca=17.5885 scb=0.0172826 \
        scc=0.00162584 m=(1)
NM3 (GatedVSS \2\:ison \10\:VSS VSS) g45n1svt w=(2.6e-07) l=4.5e-08 nf=1 \
        as=3.64e-14 ad=4.16e-14 ps=8e-07 pd=8.4e-07 nrd=1.16667 \
        nrs=1.16667 sa=1.4e-07 sb=3.45e-07 sd=160n sca=17.5885 \
        scb=0.0172826 scc=0.00162584 m=(2)
PM0 (\3\:Y \4\:n0 \1\:ExtVDD ExtVDD) g45p1svt w=(3.9e-07) l=4.5e-08 nf=1 \
        as=5.46e-14 ad=6.535e-14 ps=1.06e-06 pd=1.16e-06 nrd=1.16667 \
        nrs=1.16667 sa=2.69551e-07 sb=1.4e-07 sd=160n sca=26.2933 \
        scb=0.0280245 scc=0.00271307 m=(1)
ends LSHL_ISOL_X1_FROM_OFF
// End of subcircuit definition.
