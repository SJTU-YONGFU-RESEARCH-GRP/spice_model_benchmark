// Generated for: spectre (May  1 08:09:07 2013 )
// Library name: gsclib045
// Cell name: AOI33X4
// View name: extracted

simulator lang=spectre

subckt AOI33X4 A0 A1 A2 B0 B1 B2 VDD VSS Y
mp0_1__rcx (net124 \2\:A0 \4\:VDD VDD) g45p1svt w=(3.9e-07) l=4.5e-08 \
        nf=1 as=6.386e-14 ad=6.24e-14 ps=1.1075e-06 pd=1.1e-06 nrd=1.16667 \
        nrs=1.16667 sa=1.4e-07 sb=2e-06 sd=160n sca=20.4303 scb=0.0198654 \
        scc=0.00125373 m=(4)
mp1_1__rcx (net124 \2\:A1 \4\:VDD VDD) g45p1svt w=(3.9e-07) l=4.5e-08 \
        nf=1 as=6.386e-14 ad=6.435e-14 ps=1.1075e-06 pd=1.11e-06 \
        nrd=1.16667 nrs=1.16667 sa=3.45e-07 sb=2e-06 sd=160n sca=17.6981 \
        scb=0.0155463 scc=0.00119019 m=(4)
mp2_1__rcx (net124 \3\:A2 \4\:VDD VDD) g45p1svt w=(3.9e-07) l=4.5e-08 \
        nf=1 as=6.24e-14 ad=6.435e-14 ps=1.1e-06 pd=1.11e-06 nrd=1.16667 \
        nrs=1.16667 sa=5.5e-07 sb=2e-06 sd=160n sca=16.6869 scb=0.0147126 \
        scc=0.00118865 m=(4)
mp3_1__rcx (\10\:Y B0 net124 VDD) g45p1svt w=(3.9e-07) l=4.5e-08 nf=1 \
        as=6.24e-14 ad=6.24e-14 ps=1.1e-06 pd=1.1e-06 nrd=1.16667 \
        nrs=1.16667 sa=2e-06 sb=2e-06 sd=160n sca=16.2669 scb=0.0145797 \
        scc=0.00118861 m=(4)
mp4_1__rcx (\10\:Y B1 net124 VDD) g45p1svt w=(3.9e-07) l=4.5e-08 nf=1 \
        as=6.24e-14 ad=6.24e-14 ps=1.1e-06 pd=1.1e-06 nrd=1.16667 \
        nrs=1.16667 sa=2e-06 sb=2e-06 sd=160n sca=16.2669 scb=0.0145797 \
        scc=0.00118861 m=(4)
mp5_1__rcx (\10\:Y \1\:B2 net124 VDD) g45p1svt w=(3.9e-07) l=4.5e-08 nf=1 \
        as=6.24e-14 ad=6.24e-14 ps=1.1e-06 pd=1.1e-06 nrd=1.16667 \
        nrs=1.16667 sa=2e-06 sb=1.985e-06 sd=160n sca=16.2669 \
        scb=0.0145797 scc=0.00118861 m=(4)
C1 (A1 VSS) capacitor c=2.30892e-17
C2 (B1 VSS) capacitor c=8.30224e-16
C3 (Y VSS) capacitor c=8.67823e-17
C4 (B2 VSS) capacitor c=2.85609e-17
C5 (B0 VSS) capacitor c=8.383e-16
C6 (A0 VSS) capacitor c=1.4332e-16
C7 (VDD VSS) capacitor c=2.24541e-16
C8 (11 VSS) capacitor c=1.36221e-18
C9 (12 VSS) capacitor c=5.31602e-18
C10 (13 VSS) capacitor c=2.24904e-18
C11 (14 VSS) capacitor c=4.21276e-18
C12 (15 VSS) capacitor c=4.07685e-18
C13 (16 VSS) capacitor c=4.08884e-18
C14 (17 VSS) capacitor c=6.90979e-18
C15 (18 VSS) capacitor c=4.75885e-18
C16 (19 VSS) capacitor c=5.88913e-18
C17 (20 VSS) capacitor c=6.93724e-18
C18 (21 VSS) capacitor c=6.57774e-18
C19 (22 VSS) capacitor c=6.94548e-18
C20 (23 VSS) capacitor c=4.22752e-18
C21 (24 VSS) capacitor c=2.24904e-18
C22 (25 VSS) capacitor c=5.90293e-18
C23 (26 VSS) capacitor c=1.36221e-18
C24 (net124 VSS) capacitor c=9.96178e-16
C25 (\1\:B2 VSS) capacitor c=4.60492e-16
C26 (\12\:B0 VSS) capacitor c=5.00748e-17
C27 (\12\:B1 VSS) capacitor c=7.18668e-17
C28 (\12\:B2 VSS) capacitor c=2.79434e-17
C29 (\10\:B2 VSS) capacitor c=5.65528e-17
C30 (\9\:B1 VSS) capacitor c=7.11445e-17
C31 (\4\:B0 VSS) capacitor c=5.23511e-17
C32 (\6\:B0 VSS) capacitor c=2.69448e-17
C33 (\6\:B1 VSS) capacitor c=4.38265e-17
C34 (\6\:B2 VSS) capacitor c=2.7506e-17
C35 (\4\:B2 VSS) capacitor c=4.0815e-17
C36 (\3\:B1 VSS) capacitor c=4.08911e-17
C37 (\3\:B0 VSS) capacitor c=3.72782e-17
C38 (\13\:A0 VSS) capacitor c=3.88589e-17
C39 (\13\:A1 VSS) capacitor c=4.03927e-17
C40 (\12\:A2 VSS) capacitor c=2.5655e-17
C41 (\10\:A2 VSS) capacitor c=4.65951e-17
C42 (\9\:A1 VSS) capacitor c=6.29216e-17
C43 (\9\:A0 VSS) capacitor c=3.41201e-17
C44 (\7\:A0 VSS) capacitor c=4.89975e-17
C45 (\6\:A1 VSS) capacitor c=7.21389e-17
C46 (\1\:A2 VSS) capacitor c=5.24522e-17
C47 (\5\:A2 VSS) capacitor c=2.35643e-17
C48 (\1\:A1 VSS) capacitor c=7.10513e-17
C49 (\1\:A0 VSS) capacitor c=5.00983e-17
C50 (\3\:A2 VSS) capacitor c=5.17161e-16
C51 (\2\:A1 VSS) capacitor c=8.09452e-16
C52 (\2\:A0 VSS) capacitor c=7.0128e-16
C53 (\10\:Y VSS) capacitor c=5.05965e-16
C54 (\1\:VDD VSS) capacitor c=1.29151e-16
C55 (\1\:Y VSS) capacitor c=1.27656e-16
C56 (\3\:Y VSS) capacitor c=1.64155e-16
C57 (\6\:Y VSS) capacitor c=1.47371e-16
C58 (\8\:Y VSS) capacitor c=1.17464e-16
C59 (\2\:A2 VSS) capacitor c=3.74763e-17
C60 (\9\:A2 VSS) capacitor c=3.37687e-17
C61 (\3\:B2 VSS) capacitor c=2.20978e-17
C62 (\9\:B2 VSS) capacitor c=4.53673e-17
C63 (\5\:Y VSS) capacitor c=1.23161e-16
C64 (\4\:VDD VSS) capacitor c=3.57908e-16
Rk6 (\2\:A1 A1) resistor r=0.01617 c=0
Rk22 (Y \10\:Y) resistor r=0.3024 c=0
Rk17 (\2\:Y \4\:Y) resistor r=0.8483 c=0
Rk21 (\5\:Y Y) resistor r=0.3287 c=0
Rk18 (\4\:Y \5\:Y) resistor r=0.5468 c=0
Rk19 (\5\:Y \7\:Y) resistor r=0.4541 c=0
Rk20 (\7\:Y \9\:Y) resistor r=0.7852 c=0
Rk49 (\2\:VSS \3\:VSS) resistor r=0.04331 c=0
Rk50 (\3\:VSS \5\:VSS) resistor r=0.5305 c=0
Rk51 (\3\:VSS \6\:VSS) resistor r=0.2195 c=0
Rk52 (\6\:VSS \7\:VSS) resistor r=0.4478 c=0
Rk53 (\7\:VSS \8\:VSS) resistor r=0.5946 c=0
Rk54 (\8\:VSS \9\:VSS) resistor r=0.1568 c=0
Rk56 (\10\:VSS VSS) resistor r=0.1475 c=0
Rk55 (\9\:VSS \10\:VSS) resistor r=0.4036 c=0
Rk57 (\5\:VSS \12\:VSS) resistor r=0.2426 c=0
Rk58 (\7\:VSS \14\:VSS) resistor r=0.04331 c=0
Rk59 (\8\:VSS \16\:VSS) resistor r=0.04331 c=0
Rk60 (\10\:VSS \18\:VSS) resistor r=0.1995 c=0
Rk2 (\3\:A2 A2) resistor r=0.009678 c=0
Rk12 (\1\:B2 B2) resistor r=0.02372 c=0
Rk7 (A0 \2\:A0) resistor r=0.01801 c=0
Rk61 (\2\:VDD \3\:VDD) resistor r=0.7524 c=0
Rk69 (\4\:VDD VDD) resistor r=0.1927 c=0
Rk62 (\3\:VDD \4\:VDD) resistor r=0.5164 c=0
Rl26 (\2\:A1 \13\:A1) resistor r=52.7257 c=0
Rl18 (\2\:A1 \9\:A1) resistor r=87.6374 c=0
Rl11 (\2\:A1 \6\:A1) resistor r=56.461 c=0
Rl3 (\2\:A1 \1\:A1) resistor r=92.1028 c=0
Rl54 (B1 \12\:B1) resistor r=102.615 c=0
Rl47 (B1 \9\:B1) resistor r=52.6149 c=0
Rl40 (B1 \6\:B1) resistor r=53.0211 c=0
Rl33 (B1 \3\:B1) resistor r=44.9225 c=0
Rl5 (\2\:A2 \1\:A2) resistor r=73.0548 c=0
Rl8 (\2\:A2 \5\:A2) resistor r=59.5933 c=0
Rl6 (\2\:A2 \3\:A2) resistor r=71.9912 c=0
Rl23 (\9\:A2 \12\:A2) resistor r=47.4088 c=0
Rl21 (\9\:A2 \10\:A2) resistor r=94.2087 c=0
Rl20 (\9\:A2 \3\:A2) resistor r=69.6756 c=0
Rl35 (\3\:B2 \1\:B2) resistor r=70.1824 c=0
Rl38 (\3\:B2 \6\:B2) resistor r=35.772 c=0
Rl36 (\3\:B2 \4\:B2) resistor r=100.426 c=0
Rl49 (\9\:B2 \1\:B2) resistor r=6.7128 c=0
Rl52 (\9\:B2 \12\:B2) resistor r=129.305 c=0
Rl50 (\9\:B2 \10\:B2) resistor r=106.228 c=0
Rl56 (B0 \12\:B0) resistor r=24.7951 c=0
Rl41 (B0 \4\:B0) resistor r=96.595 c=0
Rl42 (B0 \6\:B0) resistor r=21.8676 c=0
Rl31 (B0 \3\:B0) resistor r=24.2328 c=0
Rl29 (\2\:A0 \13\:A0) resistor r=23.7402 c=0
Rl16 (\2\:A0 \9\:A0) resistor r=24.2328 c=0
Rl14 (\2\:A0 \7\:A0) resistor r=98.3529 c=0
Rl1 (\2\:A0 \1\:A0) resistor r=30.2349 c=0
Rz1 (\2\:Y \1\:Y) resistor r=75 c=0
Rz2 (\4\:Y \3\:Y) resistor r=75 c=0
Rz3 (\7\:Y \6\:Y) resistor r=75 c=0
Rz4 (\9\:Y \8\:Y) resistor r=75 c=0
Rz5 (\1\:VSS \2\:VSS) resistor r=75 c=0
Rz6 (\11\:VSS \12\:VSS) resistor r=75 c=0
Rz7 (\13\:VSS \14\:VSS) resistor r=75 c=0
Rz8 (\15\:VSS \16\:VSS) resistor r=75 c=0
Rz9 (\17\:VSS \18\:VSS) resistor r=75 c=0
Rz10 (\2\:VDD \1\:VDD) resistor r=25 c=0
Rz11 (\3\:VDD \1\:VDD) resistor r=6.25 c=0
Rz12 (\4\:VDD \1\:VDD) resistor r=6.25 c=0
Ry22 (\4\:VSS \5\:VSS) resistor r=20.6667 c=0
Ry23 (\4\:VSS \6\:VSS) resistor r=5.1667 c=0
Ry24 (\4\:VSS \9\:VSS) resistor r=5.1667 c=0
mn0_1__rcx (11 \1\:A0 \17\:VSS VSS) g45n1svt w=(2.6e-07) l=4.5e-08 nf=1 \
        as=3.64e-14 ad=1.56e-14 ps=8e-07 pd=6.4e-07 nrd=1.16667 \
        nrs=1.16667 sa=1.4e-07 sb=2e-06 sd=160n sca=9.14564 scb=0.00759168 \
        scc=0.000213449 m=(1)
mn1_1__rcx (11 \1\:A1 12 VSS) g45n1svt w=(2.6e-07) l=4.5e-08 nf=1 \
        as=6.11e-14 ad=1.56e-14 ps=9.9e-07 pd=6.4e-07 nrd=1.16667 \
        nrs=1.16667 sa=2.45e-07 sb=2e-06 sd=160n sca=9.14564 \
        scb=0.00759168 scc=0.000213449 m=(1)
mn2_1__rcx (\8\:Y \5\:A2 12 VSS) g45n1svt w=(2.6e-07) l=4.5e-08 nf=1 \
        as=6.11e-14 ad=4.16e-14 ps=9.9e-07 pd=8.4e-07 nrd=1.16667 \
        nrs=1.16667 sa=5.25e-07 sb=2e-06 sd=160n sca=9.14564 \
        scb=0.00759168 scc=0.000213449 m=(1)
mn2_2__rcx (\8\:Y \1\:A2 13 VSS) g45n1svt w=(2.6e-07) l=4.5e-08 nf=1 \
        as=1.56e-14 ad=4.16e-14 ps=6.4e-07 pd=8.4e-07 nrd=1.16667 \
        nrs=1.16667 sa=7.3e-07 sb=2e-06 sd=160n sca=9.14564 scb=0.00759168 \
        scc=0.000213449 m=(1)
mn1_2__rcx (13 \6\:A1 14 VSS) g45n1svt w=(2.6e-07) l=4.5e-08 nf=1 \
        as=2.99e-14 ad=1.56e-14 ps=7.5e-07 pd=6.4e-07 nrd=1.16667 \
        nrs=1.16667 sa=8.35e-07 sb=2e-06 sd=160n sca=9.14564 \
        scb=0.00759168 scc=0.000213449 m=(1)
mn0_2__rcx (14 \7\:A0 \15\:VSS VSS) g45n1svt w=(2.6e-07) l=4.5e-08 nf=1 \
        as=8.06e-14 ad=2.99e-14 ps=1.35e-06 pd=7.5e-07 nrd=1.16667 \
        nrs=1.16667 sa=9.95e-07 sb=2e-06 sd=160n sca=9.14564 \
        scb=0.00759168 scc=0.000213449 m=(1)
mn0_3__rcx (15 \9\:A0 \15\:VSS VSS) g45n1svt w=(2.6e-07) l=4.5e-08 nf=1 \
        as=8.06e-14 ad=2.73e-14 ps=1.35e-06 pd=7.3e-07 nrd=1.16667 \
        nrs=1.16667 sa=1.26e-06 sb=2e-06 sd=160n sca=9.14564 \
        scb=0.00759168 scc=0.000213449 m=(1)
mn1_3__rcx (15 \9\:A1 16 VSS) g45n1svt w=(2.6e-07) l=4.5e-08 nf=1 \
        as=2.99e-14 ad=2.73e-14 ps=7.5e-07 pd=7.3e-07 nrd=1.16667 \
        nrs=1.16667 sa=1.41e-06 sb=2e-06 sd=160n sca=9.14564 \
        scb=0.00759168 scc=0.000213449 m=(1)
mn2_3__rcx (\6\:Y \10\:A2 16 VSS) g45n1svt w=(2.6e-07) l=4.5e-08 nf=1 \
        as=2.99e-14 ad=4.16e-14 ps=7.5e-07 pd=8.4e-07 nrd=1.16667 \
        nrs=1.16667 sa=1.57e-06 sb=2e-06 sd=160n sca=9.14564 \
        scb=0.00759168 scc=0.000213449 m=(1)
mn2 (\6\:Y \12\:A2 17 VSS) g45n1svt w=(2.6e-07) l=4.5e-08 nf=1 \
        as=4.16e-14 ad=4.16e-14 ps=8.4e-07 pd=8.4e-07 nrd=1.16667 \
        nrs=1.16667 sa=1.775e-06 sb=2e-06 sd=160n sca=9.14564 \
        scb=0.00759168 scc=0.000213449 m=(1)
mn1 (17 \13\:A1 18 VSS) g45n1svt w=(2.6e-07) l=4.5e-08 nf=1 as=4.16e-14 \
        ad=4.16e-14 ps=8.4e-07 pd=8.4e-07 nrd=1.16667 nrs=1.16667 \
        sa=1.98e-06 sb=2e-06 sd=160n sca=9.14564 scb=0.00759168 \
        scc=0.000213449 m=(1)
mn0 (18 \13\:A0 \13\:VSS VSS) g45n1svt w=(2.6e-07) l=4.5e-08 nf=1 \
        as=9.62e-14 ad=4.16e-14 ps=1.47e-06 pd=8.4e-07 nrd=1.16667 \
        nrs=1.16667 sa=2e-06 sb=2e-06 sd=160n sca=9.14564 scb=0.00759168 \
        scc=0.000213449 m=(1)
mn3_1__rcx (19 \3\:B0 \13\:VSS VSS) g45n1svt w=(2.6e-07) l=4.5e-08 nf=1 \
        as=9.62e-14 ad=4.16e-14 ps=1.47e-06 pd=8.4e-07 nrd=1.16667 \
        nrs=1.16667 sa=2e-06 sb=2e-06 sd=160n sca=9.14564 scb=0.00759168 \
        scc=0.000213449 m=(1)
mn4_1__rcx (19 \3\:B1 20 VSS) g45n1svt w=(2.6e-07) l=4.5e-08 nf=1 \
        as=4.16e-14 ad=4.16e-14 ps=8.4e-07 pd=8.4e-07 nrd=1.16667 \
        nrs=1.16667 sa=2e-06 sb=2e-06 sd=160n sca=9.14564 scb=0.00759168 \
        scc=0.000213449 m=(1)
mn5_1__rcx (\3\:Y \4\:B2 20 VSS) g45n1svt w=(2.6e-07) l=4.5e-08 nf=1 \
        as=4.16e-14 ad=4.16e-14 ps=8.4e-07 pd=8.4e-07 nrd=1.16667 \
        nrs=1.16667 sa=2e-06 sb=1.885e-06 sd=160n sca=9.14564 \
        scb=0.00759168 scc=0.000213449 m=(1)
mn5_2__rcx (\3\:Y \6\:B2 21 VSS) g45n1svt w=(2.6e-07) l=4.5e-08 nf=1 \
        as=3.77e-14 ad=4.16e-14 ps=8.1e-07 pd=8.4e-07 nrd=1.16667 \
        nrs=1.16667 sa=2e-06 sb=1.68e-06 sd=160n sca=9.14564 \
        scb=0.00759168 scc=0.000213449 m=(1)
mn4_2__rcx (21 \6\:B1 22 VSS) g45n1svt w=(2.6e-07) l=4.5e-08 nf=1 \
        as=4.16e-14 ad=3.77e-14 ps=8.4e-07 pd=8.1e-07 nrd=1.16667 \
        nrs=1.16667 sa=2e-06 sb=1.49e-06 sd=160n sca=9.14564 \
        scb=0.00759168 scc=0.000213449 m=(1)
mn3_2__rcx (22 \6\:B0 \1\:VSS VSS) g45n1svt w=(2.6e-07) l=4.5e-08 nf=1 \
        as=8.06e-14 ad=4.16e-14 ps=1.35e-06 pd=8.4e-07 nrd=1.16667 \
        nrs=1.16667 sa=2e-06 sb=1.285e-06 sd=160n sca=9.14564 \
        scb=0.00759168 scc=0.000213449 m=(1)
mn3_3__rcx (23 \4\:B0 \1\:VSS VSS) g45n1svt w=(2.6e-07) l=4.5e-08 nf=1 \
        as=8.06e-14 ad=2.99e-14 ps=1.35e-06 pd=7.5e-07 nrd=1.16667 \
        nrs=1.16667 sa=2e-06 sb=1.02e-06 sd=160n sca=9.14564 \
        scb=0.00759168 scc=0.000213449 m=(1)
mn4_3__rcx (23 \9\:B1 24 VSS) g45n1svt w=(2.6e-07) l=4.5e-08 nf=1 \
        as=1.56e-14 ad=2.99e-14 ps=6.4e-07 pd=7.5e-07 nrd=1.16667 \
        nrs=1.16667 sa=2e-06 sb=8.6e-07 sd=160n sca=9.14564 scb=0.00759168 \
        scc=0.000213449 m=(1)
mn5_3__rcx (\1\:Y \10\:B2 24 VSS) g45n1svt w=(2.6e-07) l=4.5e-08 nf=1 \
        as=1.56e-14 ad=4.16e-14 ps=6.4e-07 pd=8.4e-07 nrd=1.16667 \
        nrs=1.16667 sa=2e-06 sb=7.55e-07 sd=160n sca=9.14564 \
        scb=0.00759168 scc=0.000213449 m=(1)
mn5 (\1\:Y \12\:B2 25 VSS) g45n1svt w=(2.6e-07) l=4.5e-08 nf=1 \
        as=6.76e-14 ad=4.16e-14 ps=1.04e-06 pd=8.4e-07 nrd=1.16667 \
        nrs=1.16667 sa=2e-06 sb=5.5e-07 sd=160n sca=9.14564 scb=0.00759168 \
        scc=0.000213449 m=(1)
mn4 (25 \12\:B1 26 VSS) g45n1svt w=(2.6e-07) l=4.5e-08 nf=1 as=1.56e-14 \
        ad=6.76e-14 ps=6.4e-07 pd=1.04e-06 nrd=1.16667 nrs=1.16667 \
        sa=2e-06 sb=2.45e-07 sd=160n sca=9.14564 scb=0.00759168 \
        scc=0.000213449 m=(1)
mn3 (26 \12\:B0 \11\:VSS VSS) g45n1svt w=(2.6e-07) l=4.5e-08 nf=1 \
        as=3.64e-14 ad=1.56e-14 ps=8e-07 pd=6.4e-07 nrd=1.16667 \
        nrs=1.16667 sa=2e-06 sb=1.4e-07 sd=160n sca=9.14564 scb=0.00759168 \
        scc=0.000213449 m=(1)
ends AOI33X4
// End of subcircuit definition.
