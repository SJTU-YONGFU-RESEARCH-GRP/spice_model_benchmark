// gsclib045_backbias/AO21X4/schematic

simulator lang=spectre

subckt AO21X4 A0 A1 B0 Y VDD VSS NW
mn1 (net100 A1 net104 VSS) g45n1svt w=(260n) l=45n nf=1 m=(1)
mn0 (net104 A0 VSS VSS) g45n1svt w=(260n) l=45n nf=1 m=(1)
mn3 (Y net100 VSS VSS) g45n1svt w=(1.04u) l=45n nf=1 m=(1)
mn2 (net100 B0 VSS VSS) g45n1svt w=(260n) l=45n nf=1 m=(1)
mp1 (net88 A1 VDD NW) g45p1svt w=(390n) l=45n nf=1 m=(1)
mp0 (net88 A0 VDD NW) g45p1svt w=(390n) l=45n nf=1 m=(1)
mp3 (Y net100 VDD NW) g45p1svt w=(1.56u) l=45n nf=1 m=(1)
mp2 (net100 B0 net88 NW) g45p1svt w=(390n) l=45n nf=1 m=(1)
ends AO21X4
