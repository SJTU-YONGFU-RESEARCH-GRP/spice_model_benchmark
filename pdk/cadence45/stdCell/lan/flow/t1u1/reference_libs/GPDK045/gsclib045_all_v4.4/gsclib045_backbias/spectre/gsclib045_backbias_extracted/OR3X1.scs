// Generated for: spectre (May  1 11:31:56 2013 )
// Library name: gsclib045_backbias
// Cell name: OR3X1
// View name: extracted

simulator lang=spectre

subckt OR3X1 A B C NW VDD VSS Y
mp2 (\11\:n0 \1\:C n2 NW) g45p1svt w=(2.15e-07) l=4.5e-08 nf=1 \
        as=3.44e-14 ad=3.01e-14 ps=7.5e-07 pd=7.1e-07 nrd=1.16667 \
        nrs=1.16667 sa=1.4e-07 sb=8e-07 sd=160n sca=25.9711 scb=0.030099 \
        scc=0.00176698 m=(1)
mp1 (n2 \1\:B n1 NW) g45p1svt w=(2.15e-07) l=4.5e-08 nf=1 as=3.548e-14 \
        ad=3.44e-14 ps=7.6e-07 pd=7.5e-07 nrd=1.16667 nrs=1.16667 \
        sa=3.45e-07 sb=5.95e-07 sd=160n sca=16.3573 scb=0.0155593 \
        scc=0.000402391 m=(1)
mp0 (n1 \1\:A \1\:VDD NW) g45p1svt w=(2.15e-07) l=4.5e-08 nf=1 \
        as=6.75e-14 ad=3.548e-14 ps=1.18e-06 pd=7.6e-07 nrd=1.16667 \
        nrs=1.16667 sa=5.55e-07 sb=3.85e-07 sd=160n sca=15.0007 \
        scb=0.0128338 scc=0.000363258 m=(1)
C1 (Y VSS) capacitor c=1.96131e-17
C2 (C VSS) capacitor c=3.48191e-17
C3 (NW VSS) capacitor c=1.95535e-16
C4 (A VSS) capacitor c=4.57733e-17
C5 (VDD VSS) capacitor c=8.13897e-17
C6 (n0 VSS) capacitor c=4.91402e-17
C7 (n2 VSS) capacitor c=9.47701e-18
C8 (n1 VSS) capacitor c=6.32316e-18
C9 (\1\:A VSS) capacitor c=5.29623e-17
C10 (\1\:B VSS) capacitor c=3.84031e-17
C11 (\1\:C VSS) capacitor c=4.98552e-17
C12 (\3\:n0 VSS) capacitor c=3.61473e-17
C13 (\3\:A VSS) capacitor c=4.1036e-17
C14 (\4\:B VSS) capacitor c=5.28242e-17
C15 (\4\:C VSS) capacitor c=3.50314e-17
C16 (\2\:n0 VSS) capacitor c=2.50258e-17
C17 (\2\:A VSS) capacitor c=4.75731e-17
C18 (\3\:B VSS) capacitor c=2.49307e-17
C19 (\3\:C VSS) capacitor c=1.39237e-17
C20 (\3\:Y VSS) capacitor c=6.54793e-17
C21 (\1\:VDD VSS) capacitor c=1.25983e-16
C22 (\11\:n0 VSS) capacitor c=8.51405e-17
C23 (\1\:Y VSS) capacitor c=7.06836e-17
C24 (\9\:n0 VSS) capacitor c=2.99653e-17
C25 (\7\:n0 VSS) capacitor c=5.85463e-17
C26 (\2\:C VSS) capacitor c=4.26937e-17
C27 (\2\:B VSS) capacitor c=4.12838e-17
C28 (\5\:C VSS) capacitor c=1.88198e-17
C29 (\5\:B VSS) capacitor c=3.19861e-17
C30 (\7\:B VSS) capacitor c=4.91384e-17
C31 (\4\:A VSS) capacitor c=4.71826e-17
C32 (\4\:n0 VSS) capacitor c=7.91122e-17
C33 (\6\:n0 VSS) capacitor c=1.48934e-16
Rk11 (Y \2\:Y) resistor r=0.05713 c=0
Rk12 (\2\:Y \4\:Y) resistor r=0.4047 c=0
Rk1 (C \5\:C) resistor r=0.01625 c=0
Rk5 (A \4\:A) resistor r=0.09354 c=0
Rk13 (\2\:VDD VDD) resistor r=0.6451 c=0
Rk14 (\2\:VSS \4\:VSS) resistor r=0.3022 c=0
Rk16 (\5\:VSS VSS) resistor r=0.1023 c=0
Rk15 (\4\:VSS \5\:VSS) resistor r=0.1477 c=0
Rk17 (\5\:VSS \7\:VSS) resistor r=0.2428 c=0
Rk2 (\5\:B \6\:B) resistor r=0.005209 c=0
Rk3 (B \7\:B) resistor r=0.005093 c=0
Rk4 (\5\:B \7\:B) resistor r=0.07853 c=0
Rk6 (\4\:n0 \5\:n0) resistor r=0.3674 c=0
Rk7 (\5\:n0 \6\:n0) resistor r=0.04641 c=0
Rk8 (\6\:n0 \8\:n0) resistor r=0.3505 c=0
Rk9 (\5\:n0 \10\:n0) resistor r=0.07643 c=0
Rk10 (\6\:n0 \12\:n0) resistor r=0.7331 c=0
Rl1 (\1\:C \2\:C) resistor r=141.187 c=0
Rl3 (\2\:C \4\:C) resistor r=85.4181 c=0
Rl2 (\2\:C \3\:C) resistor r=5.6709 c=0
Rl7 (\1\:A \2\:A) resistor r=133.384 c=0
Rl8 (\2\:A \3\:A) resistor r=77.6149 c=0
Rl4 (\1\:B \2\:B) resistor r=68.1104 c=0
Rl6 (\2\:B \4\:B) resistor r=158.495 c=0
Rl5 (\2\:B \3\:B) resistor r=1.8551 c=0
Rl9 (n0 \2\:n0) resistor r=66.0764 c=0
Rl10 (\2\:n0 \3\:n0) resistor r=33.3841 c=0
Rz3 (\1\:Y \2\:Y) resistor r=37.5 c=0
Rz4 (\1\:VSS \2\:VSS) resistor r=75 c=0
Rz5 (\6\:VSS \7\:VSS) resistor r=75 c=0
Rz1 (\7\:n0 \8\:n0) resistor r=75 c=0
Rz2 (\9\:n0 \10\:n0) resistor r=75 c=0
Ry2 (\3\:Y \4\:Y) resistor r=20.6667 c=0
Ry3 (\1\:VDD \2\:VDD) resistor r=62 c=0
Ry1 (\11\:n0 \12\:n0) resistor r=62 c=0
Rx1 (\3\:C \5\:C) resistor r=45 c=0
Rx3 (\2\:A \4\:A) resistor r=45 c=0
Rx2 (\3\:B \6\:B) resistor r=45 c=0
Rx4 (\2\:n0 \4\:n0) resistor r=45 c=0
mn2 (\7\:n0 \4\:C \6\:VSS VSS) g45n1svt w=(1.45e-07) l=4.5e-08 nf=1 \
        as=2.32e-14 ad=2.03e-14 ps=6.1e-07 pd=5.7e-07 nrd=1.16667 \
        nrs=1.16667 sa=1.4e-07 sb=8e-07 sd=160n sca=8.55924 scb=0.0065649 \
        scc=0.000116351 m=(1)
mn1 (\9\:n0 \4\:B \6\:VSS VSS) g45n1svt w=(1.45e-07) l=4.5e-08 nf=1 \
        as=2.32e-14 ad=2.392e-14 ps=6.1e-07 pd=6.2e-07 nrd=1.16667 \
        nrs=1.16667 sa=3.45e-07 sb=5.95e-07 sd=160n sca=8.55924 \
        scb=0.0065649 scc=0.000116351 m=(1)
mn0 (\9\:n0 \3\:A \1\:VSS VSS) g45n1svt w=(1.45e-07) l=4.5e-08 nf=1 \
        as=4.05e-14 ad=2.393e-14 ps=9.2e-07 pd=6.2e-07 nrd=1.16667 \
        nrs=1.16667 sa=5.55e-07 sb=3.85e-07 sd=160n sca=8.55924 \
        scb=0.0065649 scc=0.000116351 m=(1)
mn3 (\1\:Y \3\:n0 \1\:VSS VSS) g45n1svt w=(2.6e-07) l=4.5e-08 nf=1 \
        as=4.05e-14 ad=3.64e-14 ps=9.2e-07 pd=8e-07 nrd=1.16667 \
        nrs=1.16667 sa=4.90385e-07 sb=1.4e-07 sd=160n sca=11.3041 \
        scb=0.010759 scc=0.000493236 m=(1)
mp3 (\3\:Y n0 \1\:VDD NW) g45p1svt w=(3.9e-07) l=4.5e-08 nf=1 \
        as=6.75e-14 ad=5.46e-14 ps=1.18e-06 pd=1.06e-06 nrd=1.16667 \
        nrs=1.16667 sa=5.03846e-07 sb=1.4e-07 sd=160n sca=32.724 \
        scb=0.0269508 scc=0.00310791 m=(1)
ends OR3X1
// End of subcircuit definition.
