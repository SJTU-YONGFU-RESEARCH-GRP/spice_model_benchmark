// Generated for: spectre (May  1 11:28:21 2013 )
// Library name: gsclib045_backbias
// Cell name: CLKINVX16
// View name: extracted

simulator lang=spectre

subckt CLKINVX16 A NW VDD VSS Y
mp0 (Y \1\:A \1\:VDD NW) g45p1svt w=(4.45e-07) l=4.5e-08 nf=1 \
        as=6.993e-14 ad=7.12e-14 ps=1.20429e-06 pd=1.21e-06 nrd=1.16667 \
        nrs=1.16667 sa=1.4e-07 sb=2e-06 sd=160n sca=33.496 scb=0.0262642 \
        scc=0.00310781 m=(14)
C1 (A VSS) capacitor c=2.1506e-17
C2 (Y VSS) capacitor c=6.75593e-16
C3 (NW VSS) capacitor c=3.57454e-16
C4 (VDD VSS) capacitor c=2.77361e-17
C5 (\1\:A VSS) capacitor c=9.45395e-16
C6 (\1\:VDD VSS) capacitor c=7.00766e-16
C7 (\17\:Y VSS) capacitor c=4.05981e-16
Rk54 (\1\:VSS VSS) resistor r=0.06474 c=0
Rk8 (\1\:A A) resistor r=0.01234 c=0
Rk19 (Y \17\:Y) resistor r=0.2528 c=0
Rk37 (\1\:VDD VDD) resistor r=0.06474 c=0
mn0 (\17\:Y \1\:A \1\:VSS VSS) g45n1svt w=(2.95e-07) l=4.5e-08 nf=1 \
        as=4.636e-14 ad=4.72e-14 ps=9.0429e-07 pd=9.1e-07 nrd=1.16667 \
        nrs=1.16667 sa=1.4e-07 sb=2e-06 sd=160n sca=16.4223 scb=0.0158966 \
        scc=0.0014413 m=(14)
ends CLKINVX16
// End of subcircuit definition.
