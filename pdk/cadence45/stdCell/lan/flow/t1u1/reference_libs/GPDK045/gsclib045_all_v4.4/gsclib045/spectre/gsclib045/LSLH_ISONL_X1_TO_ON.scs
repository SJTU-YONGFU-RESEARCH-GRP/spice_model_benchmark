// gsclib045/LSLH_ISONL_X1_TO_ON/schematic

simulator lang=spectre

subckt LSLH_ISONL_X1_TO_ON A ISOn Y VDD VSS ExtVDD
mn0 (Y Ybint VSS VSS) g45n1svt w=(260n) l=45n nf=1 m=(1)
NM3 (GatedVSS ISOn VSS VSS) g45n1svt w=(1.04u) l=45n nf=4 m=(1)
NM2 (GatedVSS A Ab VSS) g45n1svt w=(145n) l=45n nf=1 m=(1)
NM0 (Ybint A GatedVSS VSS) g45n1svt w=(780n) l=45n nf=3 m=(1)
NM1 (Yint Ab GatedVSS VSS) g45n1svt w=(780n) l=45n nf=3 m=(1)
PM0 (Ybint Yint VDD VDD) g45p1svt w=(215n) l=45n nf=1 m=(1)
PM3 (Ybint ISOn VDD VDD) g45p1svt w=(215n) l=45n nf=1 m=(1)
PM1 (Yint Ybint VDD VDD) g45p1svt w=(215n) l=45n nf=1 m=(1)
mp0 (Y Ybint VDD VDD) g45p1svt w=(390n) l=45n nf=1 m=(1)
PM2 (Ab A ExtVDD ExtVDD) g45p1svt w=(215n) l=45n nf=1 m=(1)
ends LSLH_ISONL_X1_TO_ON
