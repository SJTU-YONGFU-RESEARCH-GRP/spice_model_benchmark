// gsclib045_backbias/TLATSRX4/schematic

simulator lang=spectre

subckt TLATSRX4 D G Q QN RN SN VSS VDD NW
mn5 (net191 D VSS VSS) g45n1svt w=(145n) l=45n nf=1 m=(1)
mn6 (n5 Gbb net191 VSS) g45n1svt w=(145n) l=45n nf=1 m=(1)
mn10 (net183 SN VSS VSS) g45n1svt w=(410n) l=45n nf=1 m=(1)
mn11 (Qint n5 net183 VSS) g45n1svt w=(410n) l=45n nf=1 m=(1)
mn17 (n5 Gb net171 VSS) g45n1svt w=(145n) l=45n nf=1 m=(1)
mn16 (net171 Qint net167 VSS) g45n1svt w=(145n) l=45n nf=1 m=(1)
mn15 (net167 RN VSS VSS) g45n1svt w=(145n) l=45n nf=1 m=(1)
mn1 (Gb G net159 VSS) g45n1svt w=(145n) l=45n nf=1 m=(1)
mn0 (net159 RN VSS VSS) g45n1svt w=(145n) l=45n nf=1 m=(1)
mn22 (QN Qint VSS VSS) g45n1svt w=(1.04u) l=45n nf=1 m=(1)
mn21 (Q Qbint VSS VSS) g45n1svt w=(1.04u) l=45n nf=1 m=(1)
mn2 (Gbb Gb VSS VSS) g45n1svt w=(145n) l=45n nf=1 m=(1)
mn20 (Qbint Qint VSS VSS) g45n1svt w=(1.04u) l=45n nf=1 m=(1)
mp6 (n5 Gb net142 NW) g45p1svt w=(215n) l=45n nf=1 m=(1)
mp5 (net142 D VDD NW) g45p1svt w=(215n) l=45n nf=1 m=(1)
mp10 (Qint SN VDD NW) g45p1svt w=(620n) l=45n nf=1 m=(1)
mp1 (Gb G VDD NW) g45p1svt w=(215n) l=45n nf=1 m=(1)
mp22 (QN Qint VDD NW) g45p1svt w=(1.56u) l=45n nf=1 m=(1)
mp21 (Q Qbint VDD NW) g45p1svt w=(1.56u) l=45n nf=1 m=(1)
mp2 (Gbb Gb VDD NW) g45p1svt w=(215n) l=45n nf=1 m=(1)
mp17 (n5 Gbb net103 NW) g45p1svt w=(215n) l=45n nf=1 m=(1)
mp16 (net103 Qint VDD NW) g45p1svt w=(215n) l=45n nf=1 m=(1)
mp15 (net103 RN VDD NW) g45p1svt w=(215n) l=45n nf=1 m=(1)
mp0 (Gb RN VDD NW) g45p1svt w=(215n) l=45n nf=1 m=(1)
mp20 (Qbint Qint VDD NW) g45p1svt w=(1.56u) l=45n nf=1 m=(1)
mp11 (Qint n5 VDD NW) g45p1svt w=(620n) l=45n nf=1 m=(1)
ends TLATSRX4
