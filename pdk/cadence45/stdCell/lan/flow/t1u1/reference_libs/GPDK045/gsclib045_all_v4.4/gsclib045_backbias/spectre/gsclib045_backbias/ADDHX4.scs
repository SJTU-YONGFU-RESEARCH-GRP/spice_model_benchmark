// gsclib045_backbias/ADDHX4/schematic

simulator lang=spectre

subckt ADDHX4 A B CO S NW VSS VDD
mn8 (CO COb VSS VSS) g45n1svt w=(1.04u) l=45n nf=1 m=(1)
mn7 (COb B n4 VSS) g45n1svt w=(260n) l=45n nf=1 m=(1)
mn6 (n4 A VSS VSS) g45n1svt w=(260n) l=45n nf=1 m=(1)
mn5 (S Sb VSS VSS) g45n1svt w=(1.04u) l=45n nf=1 m=(1)
mn3 (Sb B n2 VSS) g45n1svt w=(260n) l=45n nf=1 m=(1)
mn2 (n2 n0 VSS VSS) g45n1svt w=(260n) l=45n nf=1 m=(1)
mn1 (n1 B VSS VSS) g45n1svt w=(145n) l=45n nf=1 m=(1)
mn4 (Sb n1 n0 VSS) g45n1svt w=(260n) l=45n nf=1 m=(1)
mn0 (n0 A VSS VSS) g45n1svt w=(145n) l=45n nf=1 m=(1)
mp8 (CO COb VDD NW) g45p1svt w=(1.56u) l=45n nf=1 m=(1)
mp5 (S Sb VDD NW) g45p1svt w=(1.56u) l=45n nf=1 m=(1)
mp2 (n3 n0 VDD NW) g45p1svt w=(390n) l=45n nf=1 m=(1)
mp3 (Sb n1 n3 NW) g45p1svt w=(390n) l=45n nf=1 m=(1)
mp4 (Sb B n0 NW) g45p1svt w=(390n) l=45n nf=1 m=(1)
mp1 (n1 B VDD NW) g45p1svt w=(215n) l=45n nf=1 m=(1)
mp7 (COb B VDD NW) g45p1svt w=(390n) l=45n nf=1 m=(1)
mp0 (n0 A VDD NW) g45p1svt w=(215n) l=45n nf=1 m=(1)
mp6 (COb A VDD NW) g45p1svt w=(390n) l=45n nf=1 m=(1)
ends ADDHX4
