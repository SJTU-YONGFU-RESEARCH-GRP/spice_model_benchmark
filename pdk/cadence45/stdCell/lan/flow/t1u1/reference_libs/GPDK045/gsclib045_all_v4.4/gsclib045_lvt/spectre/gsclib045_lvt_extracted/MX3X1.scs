// Generated for: spectre (May  1 09:16:02 2013 )
// Library name: gsclib045_lvt
// Cell name: MX3X1
// View name: extracted

simulator lang=spectre

subckt MX3X1 A B C S0 S1 VDD VSS Y
mp9 (\1\:Y n1 \11\:VDD VDD) g45p1lvt w=(3.9e-07) l=4.5e-08 nf=1 \
        as=7.18e-14 ad=5.46e-14 ps=1.22e-06 pd=1.06e-06 nrd=1.16667 \
        nrs=1.16667 sa=1.4e-07 sb=5.53462e-07 sd=160n sca=27.0845 \
        scb=0.0288142 scc=0.0021178 m=(1)
C1 (A VSS) capacitor c=1.31599e-16
C2 (C VSS) capacitor c=3.07539e-17
C3 (VDD VSS) capacitor c=2.13668e-16
C4 (B VSS) capacitor c=3.97371e-17
C5 (S0 VSS) capacitor c=4.72491e-17
C6 (Y VSS) capacitor c=7.83284e-17
C7 (S1 VSS) capacitor c=4.57309e-17
C8 (n1 VSS) capacitor c=5.21839e-17
C9 (n0 VSS) capacitor c=9.77913e-17
C10 (S1b VSS) capacitor c=4.98868e-17
C11 (net234 VSS) capacitor c=3.56205e-18
C12 (S0b VSS) capacitor c=4.01446e-17
C13 (\6\:S0 VSS) capacitor c=2.84631e-17
C14 (\3\:A VSS) capacitor c=6.52756e-17
C15 (\1\:S0 VSS) capacitor c=4.71224e-17
C16 (\3\:B VSS) capacitor c=6.3578e-17
C17 (\6\:S1 VSS) capacitor c=4.65371e-17
C18 (\7\:S1 VSS) capacitor c=3.51906e-17
C19 (\2\:S1b VSS) capacitor c=6.98266e-17
C20 (\1\:C VSS) capacitor c=5.45086e-17
C21 (\4\:S0 VSS) capacitor c=4.876e-17
C22 (\1\:A VSS) capacitor c=6.67728e-17
C23 (\3\:S0b VSS) capacitor c=6.5531e-17
C24 (\3\:S0 VSS) capacitor c=6.82451e-17
C25 (\1\:B VSS) capacitor c=3.94369e-17
C26 (\1\:S1 VSS) capacitor c=2.79623e-17
C27 (\3\:S1b VSS) capacitor c=2.4713e-17
C28 (\5\:S1 VSS) capacitor c=9.51732e-17
C29 (\3\:C VSS) capacitor c=7.63404e-17
C30 (\3\:n1 VSS) capacitor c=3.35642e-17
C31 (\5\:S0 VSS) capacitor c=4.2343e-17
C32 (\2\:A VSS) capacitor c=6.7182e-17
C33 (\4\:S0b VSS) capacitor c=5.23334e-17
C34 (\2\:S0 VSS) capacitor c=7.05269e-17
C35 (\2\:S0b VSS) capacitor c=4.60892e-17
C36 (\2\:B VSS) capacitor c=5.69619e-17
C37 (\3\:S1 VSS) capacitor c=2.46366e-17
C38 (\4\:S1b VSS) capacitor c=4.75588e-17
C39 (\2\:C VSS) capacitor c=6.12251e-17
C40 (\2\:n1 VSS) capacitor c=3.01236e-17
C41 (\10\:S0b VSS) capacitor c=7.66435e-17
C42 (\7\:VDD VSS) capacitor c=3.07601e-17
C43 (\6\:n0 VSS) capacitor c=4.69648e-17
C44 (\9\:VDD VSS) capacitor c=4.1845e-17
C45 (\10\:S1b VSS) capacitor c=9.57974e-17
C46 (\4\:n0 VSS) capacitor c=1.35248e-16
C47 (\8\:n1 VSS) capacitor c=7.86587e-17
C48 (\11\:VDD VSS) capacitor c=3.30708e-17
C49 (\1\:Y VSS) capacitor c=5.0074e-17
C50 (\1\:VDD VSS) capacitor c=5.17006e-17
C51 (\5\:S0b VSS) capacitor c=2.24262e-17
C52 (\5\:S1b VSS) capacitor c=1.32652e-16
C53 (\8\:n0 VSS) capacitor c=1.06197e-16
C54 (\6\:n1 VSS) capacitor c=3.24483e-17
C55 (\2\:S1 VSS) capacitor c=5.04746e-17
C56 (\4\:S1 VSS) capacitor c=7.95087e-17
C57 (\4\:C VSS) capacitor c=6.67889e-17
C58 (\4\:n1 VSS) capacitor c=7.32645e-17
C59 (\5\:n1 VSS) capacitor c=6.69473e-17
C60 (\8\:S1 VSS) capacitor c=7.04027e-17
C61 (\7\:S1b VSS) capacitor c=1.39273e-16
C62 (\9\:S1b VSS) capacitor c=1.17891e-16
C63 (\4\:B VSS) capacitor c=7.33147e-17
C64 (\3\:n0 VSS) capacitor c=1.27458e-16
C65 (\7\:S0 VSS) capacitor c=4.62065e-17
C66 (\8\:S0 VSS) capacitor c=5.77639e-17
C67 (\7\:S0b VSS) capacitor c=8.27479e-17
C68 (\8\:S0b VSS) capacitor c=1.09211e-16
C69 (\9\:S0b VSS) capacitor c=6.43272e-17
C70 (\3\:VDD VSS) capacitor c=1.75688e-17
C71 (\4\:VDD VSS) capacitor c=2.20622e-17
C72 (\6\:VDD VSS) capacitor c=1.40264e-17
Rk17 (\4\:A A) resistor r=0.004385 c=0
Rk3 (C \4\:C) resistor r=0.114 c=0
Rk24 (\2\:VSS \3\:VSS) resistor r=0.1252 c=0
Rk25 (\3\:VSS \4\:VSS) resistor r=0.3883 c=0
Rk26 (\4\:VSS \5\:VSS) resistor r=0.238 c=0
Rk28 (\6\:VSS VSS) resistor r=0.1174 c=0
Rk27 (\5\:VSS \6\:VSS) resistor r=0.4336 c=0
Rk29 (\3\:VSS \8\:VSS) resistor r=0.2699 c=0
Rk30 (\4\:VSS \10\:VSS) resistor r=0.2948 c=0
Rk31 (\6\:VSS \12\:VSS) resistor r=0.1993 c=0
Rk32 (\2\:VDD \3\:VDD) resistor r=0.1578 c=0
Rk33 (\3\:VDD \4\:VDD) resistor r=0.3933 c=0
Rk34 (\4\:VDD \5\:VDD) resistor r=0.2004 c=0
Rk36 (\6\:VDD VDD) resistor r=0.1324 c=0
Rk35 (\5\:VDD \6\:VDD) resistor r=0.4185 c=0
Rk37 (\3\:VDD \8\:VDD) resistor r=0.254 c=0
Rk38 (\4\:VDD \10\:VDD) resistor r=0.2584 c=0
Rk39 (\6\:VDD \12\:VDD) resistor r=0.2684 c=0
Rk12 (\4\:B B) resistor r=0.09819 c=0
Rk18 (S0 \7\:S0) resistor r=0.08731 c=0
Rk19 (\7\:S0 \8\:S0) resistor r=0.2524 c=0
Rk1 (\2\:Y Y) resistor r=0.5031 c=0
Rk2 (Y \4\:Y) resistor r=0.01452 c=0
Rk7 (S1 \8\:S1) resistor r=0.111 c=0
Rk4 (\4\:n1 \5\:n1) resistor r=0.3394 c=0
Rk5 (\5\:n1 \7\:n1) resistor r=0.09065 c=0
Rk6 (\5\:n1 \9\:n1) resistor r=0.4248 c=0
Rk13 (\2\:n0 \3\:n0) resistor r=0.7164 c=0
Rk14 (\3\:n0 \5\:n0) resistor r=0.5029 c=0
Rk15 (\3\:n0 \7\:n0) resistor r=0.2271 c=0
Rk16 (\5\:n0 \9\:n0) resistor r=0.6093 c=0
Rk8 (\6\:S1b \7\:S1b) resistor r=0.8529 c=0
Rk9 (\7\:S1b \8\:S1b) resistor r=0.2218 c=0
Rk10 (\8\:S1b \9\:S1b) resistor r=0.01531 c=0
Rk11 (\8\:S1b \11\:S1b) resistor r=0.7038 c=0
Rk20 (\6\:S0b \7\:S0b) resistor r=0.2634 c=0
Rk21 (\7\:S0b \8\:S0b) resistor r=0.486 c=0
Rk22 (\8\:S0b \9\:S0b) resistor r=0.3832 c=0
Rk23 (\7\:S0b \11\:S0b) resistor r=0.5822 c=0
Rl20 (\2\:A \3\:A) resistor r=101.718 c=0
Rl19 (\1\:A \2\:A) resistor r=109.879 c=0
Rl3 (\1\:C \2\:C) resistor r=24.2328 c=0
Rl4 (\2\:C \3\:C) resistor r=147.31 c=0
Rl14 (\2\:B \3\:B) resistor r=128.207 c=0
Rl13 (\1\:B \2\:B) resistor r=111.516 c=0
Rl22 (\5\:S0 \6\:S0) resistor r=29.9451 c=0
Rl21 (\4\:S0 \5\:S0) resistor r=184.615 c=0
Rl16 (\1\:S0 \2\:S0) resistor r=34.6154 c=0
Rl17 (\2\:S0 \3\:S0) resistor r=183.738 c=0
Rl11 (\2\:S1 \6\:S1) resistor r=170.387 c=0
Rl7 (\1\:S1 \2\:S1) resistor r=75.7223 c=0
Rl8 (\2\:S1 \3\:S1) resistor r=59.9887 c=0
Rl12 (\4\:S1 \7\:S1) resistor r=91.9892 c=0
Rl10 (\4\:S1 \5\:S1) resistor r=234.593 c=0
Rl9 (\3\:S1 \4\:S1) resistor r=94.1561 c=0
Rl1 (n1 \2\:n1) resistor r=108.848 c=0
Rl2 (\2\:n1 \3\:n1) resistor r=24.2328 c=0
Rl6 (\3\:S1b \4\:S1b) resistor r=51.2042 c=0
Rl5 (S1b \2\:S1b) resistor r=105.282 c=0
Rl18 (\3\:S0b \4\:S0b) resistor r=32.5403 c=0
Rl15 (S0b \2\:S0b) resistor r=74.2328 c=0
Rz7 (\7\:VSS \8\:VSS) resistor r=75 c=0
Rz8 (\9\:VSS \10\:VSS) resistor r=75 c=0
Rz9 (\11\:VSS \12\:VSS) resistor r=75 c=0
Rz10 (\1\:VDD \2\:VDD) resistor r=25 c=0
Rz11 (\1\:VDD \5\:VDD) resistor r=6.25 c=0
Rz1 (\3\:Y \4\:Y) resistor r=75 c=0
Rz2 (\6\:n1 \7\:n1) resistor r=75 c=0
Rz4 (n0 \2\:n0) resistor r=75 c=0
Rz5 (\8\:n0 \9\:n0) resistor r=75 c=0
Rz3 (\5\:S1b \6\:S1b) resistor r=75 c=0
Rz6 (\5\:S0b \6\:S0b) resistor r=75 c=0
Ry7 (\1\:VSS \2\:VSS) resistor r=20.6667 c=0
Ry8 (\1\:VSS \5\:VSS) resistor r=5.1667 c=0
Ry9 (\7\:VDD \8\:VDD) resistor r=62 c=0
Ry10 (\9\:VDD \10\:VDD) resistor r=62 c=0
Ry11 (\11\:VDD \12\:VDD) resistor r=62 c=0
Ry1 (\1\:Y \2\:Y) resistor r=20.6667 c=0
Ry2 (\8\:n1 \9\:n1) resistor r=62 c=0
Ry4 (\4\:n0 \5\:n0) resistor r=62 c=0
Ry5 (\6\:n0 \7\:n0) resistor r=62 c=0
Ry3 (\10\:S1b \11\:S1b) resistor r=62 c=0
Ry6 (\10\:S0b \11\:S0b) resistor r=62 c=0
Rx7 (\2\:A \4\:A) resistor r=45 c=0
Rx1 (\2\:C \4\:C) resistor r=45 c=0
Rx6 (\2\:B \4\:B) resistor r=45 c=0
Rx8 (\5\:S0 \7\:S0) resistor r=45 c=0
Rx9 (\2\:S0 \8\:S0) resistor r=45 c=0
Rx3 (\3\:S1 \8\:S1) resistor r=45 c=0
Rx2 (\2\:n1 \4\:n1) resistor r=45 c=0
Rx4 (\4\:S1b \7\:S1b) resistor r=45 c=0
Rx5 (S1b \9\:S1b) resistor r=45 c=0
Rx10 (\4\:S0b \8\:S0b) resistor r=45 c=0
Rx11 (\2\:S0b \9\:S0b) resistor r=45 c=0
mn9 (\3\:Y \3\:n1 \11\:VSS VSS) g45n1lvt w=(2.6e-07) l=4.5e-08 nf=1 \
        as=4.4e-14 ad=3.64e-14 ps=9.6e-07 pd=8e-07 nrd=1.16667 nrs=1.16667 \
        sa=1.4e-07 sb=5.42885e-07 sd=160n sca=9.14564 scb=0.00759168 \
        scc=0.000213449 m=(1)
mn7 (net245 \3\:C \11\:VSS VSS) g45n1lvt w=(1.45e-07) l=4.5e-08 nf=1 \
        as=4.4e-14 ad=8.7e-15 ps=9.6e-07 pd=4.1e-07 nrd=1.16667 \
        nrs=1.16667 sa=4.05e-07 sb=6.25e-07 sd=160n sca=7.688 \
        scb=0.00504888 scc=6.29443e-05 m=(1)
mn8 (\6\:n1 \5\:S1 net245 VSS) g45n1lvt w=(1.45e-07) l=4.5e-08 nf=1 \
        as=8.7e-15 ad=4.857e-14 ps=4.1e-07 pd=9.6e-07 nrd=1.16667 \
        nrs=1.16667 sa=5.1e-07 sb=5.2e-07 sd=160n sca=7.688 scb=0.00504888 \
        scc=6.29443e-05 m=(1)
mn6 (\6\:n1 \3\:S1b \8\:n0 VSS) g45n1lvt w=(1.45e-07) l=4.5e-08 nf=1 \
        as=2.03e-14 ad=4.857e-14 ps=5.7e-07 pd=9.6e-07 nrd=1.16667 \
        nrs=1.16667 sa=8.9e-07 sb=1.4e-07 sd=160n sca=7.688 scb=0.00504888 \
        scc=6.29443e-05 m=(1)
mn1 (\5\:S1b \1\:S1 \9\:VSS VSS) g45n1lvt w=(1.45e-07) l=4.5e-08 nf=1 \
        as=2.32e-14 ad=2.03e-14 ps=6.1e-07 pd=5.7e-07 nrd=1.16667 \
        nrs=1.16667 sa=1.4e-07 sb=1.15e-06 sd=160n sca=10.4914 \
        scb=0.00978575 scc=0.000300434 m=(1)
mn4 (net234 \1\:B \9\:VSS VSS) g45n1lvt w=(1.45e-07) l=4.5e-08 nf=1 \
        as=2.32e-14 ad=3.552e-14 ps=6.1e-07 pd=7.8e-07 nrd=1.16667 \
        nrs=1.16667 sa=3.45e-07 sb=9.45e-07 sd=160n sca=10.4914 \
        scb=0.00978575 scc=0.000300434 m=(1)
mn5 (n0 \3\:S0 net234 VSS) g45n1lvt w=(1.45e-07) l=4.5e-08 nf=1 \
        as=3.552e-14 ad=2.32e-14 ps=7.8e-07 pd=6.1e-07 nrd=1.16667 \
        nrs=1.16667 sa=6.35e-07 sb=6.55e-07 sd=160n sca=10.4914 \
        scb=0.00978575 scc=0.000300434 m=(1)
mn3 (n0 \3\:S0b net229 VSS) g45n1lvt w=(1.45e-07) l=4.5e-08 nf=1 \
        as=8.7e-15 ad=2.32e-14 ps=4.1e-07 pd=6.1e-07 nrd=1.16667 \
        nrs=1.16667 sa=8.4e-07 sb=4.5e-07 sd=160n sca=10.4914 \
        scb=0.00978575 scc=0.000300434 m=(1)
mn2 (net229 \1\:A \7\:VSS VSS) g45n1lvt w=(1.45e-07) l=4.5e-08 nf=1 \
        as=2.32e-14 ad=8.7e-15 ps=6.1e-07 pd=4.1e-07 nrd=1.16667 \
        nrs=1.16667 sa=9.45e-07 sb=3.45e-07 sd=160n sca=10.4914 \
        scb=0.00978575 scc=0.000300434 m=(1)
mn0 (\5\:S0b \4\:S0 \7\:VSS VSS) g45n1lvt w=(1.45e-07) l=4.5e-08 nf=1 \
        as=2.32e-14 ad=2.03e-14 ps=6.1e-07 pd=5.7e-07 nrd=1.16667 \
        nrs=1.16667 sa=1.15e-06 sb=1.4e-07 sd=160n sca=10.4914 \
        scb=0.00978575 scc=0.000300434 m=(1)
mp7 (net202 \1\:C \11\:VDD VDD) g45p1lvt w=(2.15e-07) l=4.5e-08 nf=1 \
        as=7.18e-14 ad=1.29e-14 ps=1.22e-06 pd=5.5e-07 nrd=1.16667 \
        nrs=1.16667 sa=4.05e-07 sb=6.25e-07 sd=160n sca=26.7541 \
        scb=0.0241209 scc=0.00281164 m=(1)
mp8 (\8\:n1 \2\:S1b net202 VDD) g45p1lvt w=(2.15e-07) l=4.5e-08 nf=1 \
        as=1.29e-14 ad=7.095e-14 ps=5.5e-07 pd=1.09e-06 nrd=1.16667 \
        nrs=1.16667 sa=5.1e-07 sb=5.2e-07 sd=160n sca=25.94 scb=0.0231463 \
        scc=0.00280756 m=(1)
mp6 (\4\:n0 \7\:S1 \8\:n1 VDD) g45p1lvt w=(2.15e-07) l=4.5e-08 nf=1 \
        as=7.095e-14 ad=3.118e-14 ps=1.09e-06 pd=7.2e-07 nrd=1.16667 \
        nrs=1.16667 sa=8.85e-07 sb=1.45e-07 sd=160n sca=24.8095 \
        scb=0.0224988 scc=0.00280688 m=(1)
mp1 (\10\:S1b \6\:S1 \9\:VDD VDD) g45p1lvt w=(2.15e-07) l=4.5e-08 nf=1 \
        as=3.44e-14 ad=3.01e-14 ps=7.5e-07 pd=7.1e-07 nrd=1.16667 \
        nrs=1.16667 sa=1.4e-07 sb=1.17e-06 sd=160n sca=10.718 \
        scb=0.00841932 scc=0.00013813 m=(1)
mp4 (net190 \3\:B \9\:VDD VDD) g45p1lvt w=(2.15e-07) l=4.5e-08 nf=1 \
        as=3.44e-14 ad=3.548e-14 ps=7.5e-07 pd=7.6e-07 nrd=1.16667 \
        nrs=1.16667 sa=3.45e-07 sb=9.65e-07 sd=160n sca=10.718 \
        scb=0.00841932 scc=0.00013813 m=(1)
mp5 (\6\:n0 S0b net190 VDD) g45p1lvt w=(2.15e-07) l=4.5e-08 nf=1 \
        as=3.548e-14 ad=4.515e-14 ps=7.6e-07 pd=8.5e-07 nrd=1.16667 \
        nrs=1.16667 sa=5.55e-07 sb=7.55e-07 sd=160n sca=10.718 \
        scb=0.00841932 scc=0.00013813 m=(1)
mp3 (\6\:n0 \1\:S0 net189 VDD) g45p1lvt w=(2.15e-07) l=4.5e-08 nf=1 \
        as=1.505e-14 ad=4.515e-14 ps=5.7e-07 pd=8.5e-07 nrd=1.16667 \
        nrs=1.16667 sa=8.1e-07 sb=5e-07 sd=160n sca=11.0172 scb=0.0085015 \
        scc=0.000138145 m=(1)
mp2 (net189 \3\:A \7\:VDD VDD) g45p1lvt w=(2.15e-07) l=4.5e-08 nf=1 \
        as=4.3e-14 ad=1.505e-14 ps=8.3e-07 pd=5.7e-07 nrd=1.16667 \
        nrs=1.16667 sa=9.25e-07 sb=3.85e-07 sd=160n sca=11.4166 \
        scb=0.00871068 scc=0.00013827 m=(1)
mp0 (\10\:S0b \6\:S0 \7\:VDD VDD) g45p1lvt w=(2.15e-07) l=4.5e-08 nf=1 \
        as=4.3e-14 ad=3.01e-14 ps=8.3e-07 pd=7.1e-07 nrd=1.16667 \
        nrs=1.16667 sa=1.17e-06 sb=1.4e-07 sd=160n sca=13.294 \
        scb=0.0109881 scc=0.000151098 m=(1)
ends MX3X1
// End of subcircuit definition.
