// Generated for: spectre (May  1 09:17:35 2013 )
// Library name: gsclib045_hvt
// Cell name: NAND3X2
// View name: extracted

simulator lang=spectre

subckt NAND3X2 A B C VDD VSS Y
mp2 (\9\:Y \3\:C \1\:VDD VDD) g45p1hvt w=(3.9e-07) l=4.5e-08 nf=1 \
        as=6.24e-14 ad=6.24e-14 ps=1.1e-06 pd=1.1e-06 nrd=1.16667 \
        nrs=1.16667 sa=5.5e-07 sb=7.55e-07 sd=160n sca=20.6186 \
        scb=0.0170876 scc=0.00184289 m=(2)
mp0 (\1\:Y \2\:A \1\:VDD VDD) g45p1hvt w=(3.9e-07) l=4.5e-08 nf=1 \
        as=5.46e-14 ad=6.24e-14 ps=1.06e-06 pd=1.1e-06 nrd=1.16667 \
        nrs=1.16667 sa=1.4e-07 sb=1.165e-06 sd=160n sca=26.6291 \
        scb=0.0267491 scc=0.00213017 m=(2)
mp1 (\1\:Y \1\:B \1\:VDD VDD) g45p1hvt w=(3.9e-07) l=4.5e-08 nf=1 \
        as=6.24e-14 ad=6.24e-14 ps=1.1e-06 pd=1.1e-06 nrd=1.16667 \
        nrs=1.16667 sa=3.45e-07 sb=9.6e-07 sd=160n sca=21.9392 \
        scb=0.0187361 scc=0.00185024 m=(2)
C1 (VDD VSS) capacitor c=6.17693e-17
C2 (C VSS) capacitor c=5.70583e-17
C3 (A VSS) capacitor c=1.48687e-17
C4 (Y VSS) capacitor c=9.03707e-17
C5 (B VSS) capacitor c=3.04309e-17
C6 (7 VSS) capacitor c=3.65106e-18
C7 (8 VSS) capacitor c=6.67144e-18
C8 (9 VSS) capacitor c=4.80329e-18
C9 (10 VSS) capacitor c=4.5835e-18
C10 (\1\:B VSS) capacitor c=3.70937e-16
C11 (\6\:A VSS) capacitor c=4.59253e-17
C12 (\6\:B VSS) capacitor c=6.03643e-17
C13 (\1\:C VSS) capacitor c=4.92448e-17
C14 (\5\:C VSS) capacitor c=2.38554e-17
C15 (\3\:B VSS) capacitor c=4.73601e-17
C16 (\1\:A VSS) capacitor c=3.9275e-17
C17 (\3\:C VSS) capacitor c=9.31457e-17
C18 (\2\:A VSS) capacitor c=4.09357e-16
C19 (\1\:VDD VSS) capacitor c=2.15342e-16
C20 (\1\:Y VSS) capacitor c=2.07701e-16
C21 (\9\:Y VSS) capacitor c=3.46321e-17
C22 (\7\:Y VSS) capacitor c=1.3211e-16
C23 (\2\:C VSS) capacitor c=1.61194e-17
C24 (\7\:C VSS) capacitor c=6.48355e-17
Rk16 (\1\:VDD VDD) resistor r=0.0472 c=0
Rk1 (C \7\:C) resistor r=0.03835 c=0
Rk5 (\2\:A A) resistor r=0.01817 c=0
Rk20 (\2\:VSS \4\:VSS) resistor r=0.3341 c=0
Rk22 (\5\:VSS VSS) resistor r=0.06726 c=0
Rk21 (\4\:VSS \5\:VSS) resistor r=0.2832 c=0
Rk23 (\5\:VSS \7\:VSS) resistor r=0.2196 c=0
Rk9 (\1\:Y Y) resistor r=0.2013 c=0
Rk10 (Y \8\:Y) resistor r=0.9494 c=0
Rk11 (\1\:Y \10\:Y) resistor r=0.05797 c=0
Rk2 (B \1\:B) resistor r=0.08407 c=0
Rl5 (\2\:C \1\:C) resistor r=100.426 c=0
Rl8 (\2\:C \5\:C) resistor r=35.772 c=0
Rl6 (\2\:C \3\:C) resistor r=54.2356 c=0
Rl13 (\2\:A \6\:A) resistor r=24.7951 c=0
Rl1 (\2\:A \1\:A) resistor r=24.7951 c=0
Rl11 (\1\:B \6\:B) resistor r=44.9225 c=0
Rl4 (\1\:B \3\:B) resistor r=33.3841 c=0
Rz3 (\1\:VSS \2\:VSS) resistor r=75 c=0
Rz4 (\6\:VSS \7\:VSS) resistor r=75 c=0
Rz1 (\8\:Y \7\:Y) resistor r=75 c=0
Ry3 (\10\:Y \9\:Y) resistor r=31 c=0
Rx1 (\7\:C \3\:C) resistor r=45 c=0
mn0_1__rcx (7 \1\:A \6\:VSS VSS) g45n1hvt w=(2.6e-07) l=4.5e-08 nf=1 \
        as=3.64e-14 ad=2.34e-14 ps=8e-07 pd=7e-07 nrd=1.16667 nrs=1.16667 \
        sa=1.4e-07 sb=1.045e-06 sd=160n sca=10.3222 scb=0.00938145 \
        scc=0.000353946 m=(1)
mn1_1__rcx (7 \3\:B 8 VSS) g45n1hvt w=(2.6e-07) l=4.5e-08 nf=1 \
        as=5.33e-14 ad=2.34e-14 ps=9.3e-07 pd=7e-07 nrd=1.16667 \
        nrs=1.16667 sa=2.75e-07 sb=9.1e-07 sd=160n sca=10.3222 \
        scb=0.00938145 scc=0.000353946 m=(1)
mn2_1__rcx (\7\:Y \5\:C 8 VSS) g45n1hvt w=(2.6e-07) l=4.5e-08 nf=1 \
        as=5.33e-14 ad=4.16e-14 ps=9.3e-07 pd=8.4e-07 nrd=1.16667 \
        nrs=1.16667 sa=5.25e-07 sb=6.6e-07 sd=160n sca=10.3222 \
        scb=0.00938145 scc=0.000353946 m=(1)
mn2 (\7\:Y \1\:C 9 VSS) g45n1hvt w=(2.6e-07) l=4.5e-08 nf=1 as=2.99e-14 \
        ad=4.16e-14 ps=7.5e-07 pd=8.4e-07 nrd=1.16667 nrs=1.16667 \
        sa=7.3e-07 sb=4.55e-07 sd=160n sca=10.3222 scb=0.00938145 \
        scc=0.000353946 m=(1)
mn1 (9 \6\:B 10 VSS) g45n1hvt w=(2.6e-07) l=4.5e-08 nf=1 as=2.08e-14 \
        ad=2.99e-14 ps=6.8e-07 pd=7.5e-07 nrd=1.16667 nrs=1.16667 \
        sa=8.9e-07 sb=2.95e-07 sd=160n sca=10.3222 scb=0.00938145 \
        scc=0.000353946 m=(1)
mn0 (10 \6\:A \1\:VSS VSS) g45n1hvt w=(2.6e-07) l=4.5e-08 nf=1 \
        as=7.12e-14 ad=2.08e-14 ps=1.31e-06 pd=6.8e-07 nrd=1.16667 \
        nrs=1.16667 sa=1.015e-06 sb=1.7e-07 sd=160n sca=10.3222 \
        scb=0.00938145 scc=0.000353946 m=(1)
ends NAND3X2
// End of subcircuit definition.
