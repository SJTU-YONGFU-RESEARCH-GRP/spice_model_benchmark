// Generated for: spectre (May  1 09:14:39 2013 )
// Library name: gsclib045_lvt
// Cell name: SDFFNSRX4
// View name: extracted

simulator lang=spectre

subckt SDFFNSRX4 CKN D Q QN RN SE SI SN VDD VSS
mp10 (\8\:SEb \1\:SE \39\:VDD VDD) g45p1lvt w=(2.15e-07) l=4.5e-08 nf=1 \
        as=3.44e-14 ad=3.01e-14 ps=7.5e-07 pd=7.1e-07 nrd=1.16667 \
        nrs=1.16667 sa=1.4e-07 sb=9.80233e-07 sd=160n sca=12.896 \
        scb=0.0102095 scc=9.31837e-05 m=(1)
mp13 (net453 \1\:SI \39\:VDD VDD) g45p1lvt w=(2.15e-07) l=4.5e-08 nf=1 \
        as=3.44e-14 ad=1.29e-14 ps=7.5e-07 pd=5.5e-07 nrd=1.16667 \
        nrs=1.16667 sa=3.45e-07 sb=7.75233e-07 sd=160n sca=11.1175 \
        scb=0.00789061 scc=7.80015e-05 m=(1)
mp14 (\5\:Db \3\:SEb net453 VDD) g45p1lvt w=(2.15e-07) l=4.5e-08 nf=1 \
        as=1.29e-14 ad=6.128e-14 ps=5.5e-07 pd=1e-06 nrd=1.16667 \
        nrs=1.16667 sa=4.5e-07 sb=6.70233e-07 sd=160n sca=10.6702 \
        scb=0.0075867 scc=7.76926e-05 m=(1)
mp12 (\5\:Db \6\:SE net461 VDD) g45p1lvt w=(2.15e-07) l=4.5e-08 nf=1 \
        as=2.473e-14 ad=6.128e-14 ps=6.6e-07 pd=1e-06 nrd=1.16667 \
        nrs=1.16667 sa=7.8e-07 sb=3.40233e-07 sd=160n sca=10.1832 \
        scb=0.00742094 scc=7.76436e-05 m=(1)
mp11 (net461 \1\:D \35\:VDD VDD) g45p1lvt w=(2.15e-07) l=4.5e-08 nf=1 \
        as=6.215e-14 ad=2.473e-14 ps=1.73e-06 pd=6.6e-07 nrd=1.16667 \
        nrs=1.16667 sa=9.4e-07 sb=1.80233e-07 sd=160n sca=10.1832 \
        scb=0.00742094 scc=7.76436e-05 m=(1)
mp20 (\21\:CKNb \1\:CKN \35\:VDD VDD) g45p1lvt w=(2.15e-07) l=4.5e-08 \
        nf=1 as=6.215e-14 ad=3.44e-14 ps=1.73e-06 pd=7.5e-07 nrd=1.16667 \
        nrs=1.16667 sa=3.61628e-07 sb=1.6e-07 sd=160n sca=12.7104 \
        scb=0.0116911 scc=0.00042519 m=(1)
mp25 (\5\:n20 CKNb \3\:Db VDD) g45p1lvt w=(2.15e-07) l=4.5e-08 nf=1 \
        as=3.01e-14 ad=4.73e-14 ps=7.1e-07 pd=8.7e-07 nrd=1.16667 \
        nrs=1.16667 sa=1.4e-07 sb=7.73488e-07 sd=160n sca=11.7888 \
        scb=0.0102603 scc=0.000281769 m=(1)
mp36 (\5\:n20 CKNbb net486 VDD) g45p1lvt w=(2.15e-07) l=4.5e-08 nf=1 \
        as=2.902e-14 ad=4.73e-14 ps=7e-07 pd=8.7e-07 nrd=1.16667 \
        nrs=1.16667 sa=4.05e-07 sb=5.08488e-07 sd=160n sca=11.7888 \
        scb=0.0102603 scc=0.000281769 m=(1)
mp35 (net486 mout \32\:VDD VDD) g45p1lvt w=(2.15e-07) l=4.5e-08 nf=1 \
        as=8.86e-14 ad=2.903e-14 ps=1.64e-06 pd=7e-07 nrd=1.16667 \
        nrs=1.16667 sa=5.85e-07 sb=3.28488e-07 sd=160n sca=11.7888 \
        scb=0.0102603 scc=0.000281769 m=(1)
mp21 (\8\:CKNbb \9\:CKNb \32\:VDD VDD) g45p1lvt w=(2.15e-07) l=4.5e-08 \
        nf=1 as=8.86e-14 ad=3.01e-14 ps=1.64e-06 pd=7.1e-07 nrd=1.16667 \
        nrs=1.16667 sa=6.05814e-07 sb=1.4e-07 sd=160n sca=15.2551 \
        scb=0.0150251 scc=0.000885438 m=(1)
mp31 (net478 RNb \29\:VDD VDD) g45p1lvt w=(2.15e-07) l=4.5e-08 nf=1 \
        as=8.205e-14 ad=1.29e-14 ps=2.66e-06 pd=5.5e-07 nrd=1.16667 \
        nrs=1.16667 sa=1.83721e-07 sb=1.11e-06 sd=160n sca=45.7906 \
        scb=0.0283307 scc=0.00588417 m=(1)
mp32 (\8\:mout n20 net478 VDD) g45p1lvt w=(2.15e-07) l=4.5e-08 nf=1 \
        as=1.29e-14 ad=3.44e-14 ps=5.5e-07 pd=7.5e-07 nrd=1.16667 \
        nrs=1.16667 sa=2.88721e-07 sb=1.005e-06 sd=160n sca=45.7906 \
        scb=0.0283307 scc=0.00588417 m=(1)
mp30 (\8\:mout \5\:SN \25\:VDD VDD) g45p1lvt w=(2.15e-07) l=4.5e-08 nf=1 \
        as=1.6557e-13 ad=3.44e-14 ps=2.79e-06 pd=7.5e-07 nrd=1.16667 \
        nrs=1.16667 sa=4.93721e-07 sb=8e-07 sd=160n sca=45.7906 \
        scb=0.0283307 scc=0.00588417 m=(1)
mp22 (\11\:RNb \3\:RN \25\:VDD VDD) g45p1lvt w=(2.15e-07) l=4.5e-08 nf=1 \
        as=1.6557e-13 ad=3.44e-14 ps=2.79e-06 pd=7.5e-07 nrd=1.16667 \
        nrs=1.16667 sa=1.13372e-06 sb=1.6e-07 sd=160n sca=45.7906 \
        scb=0.0283307 scc=0.00588417 m=(1)
mp40 (\12\:n35 \5\:CKNbb \6\:mout VDD) g45p1lvt w=(2.15e-07) l=4.5e-08 \
        nf=1 as=5.482e-14 ad=3.44e-14 ps=9.4e-07 pd=7.5e-07 nrd=1.16667 \
        nrs=1.16667 sa=2.55e-07 sb=3.45e-07 sd=160n sca=15.6338 \
        scb=0.015455 scc=0.000959319 m=(1)
mp53 (\12\:n35 \14\:CKNb \3\:net566 VDD) g45p1lvt w=(2.15e-07) l=4.5e-08 \
        nf=1 as=3.01e-14 ad=3.44e-14 ps=7.1e-07 pd=7.5e-07 nrd=1.16667 \
        nrs=1.16667 sa=4.6e-07 sb=1.4e-07 sd=160n sca=15.6338 scb=0.015455 \
        scc=0.000959319 m=(1)
mp51 (net414 \4\:RNb \22\:VDD VDD) g45p1lvt w=(2.15e-07) l=4.5e-08 nf=1 \
        as=3.01e-14 ad=1.29e-14 ps=7.1e-07 pd=5.5e-07 nrd=1.16667 \
        nrs=1.16667 sa=1.4e-07 sb=2e-06 sd=160n sca=12.1244 scb=0.0107968 \
        scc=0.000332109 m=(1)
mp52 (net566 qbint net414 VDD) g45p1lvt w=(2.15e-07) l=4.5e-08 nf=1 \
        as=1.29e-14 ad=3.44e-14 ps=5.5e-07 pd=7.5e-07 nrd=1.16667 \
        nrs=1.16667 sa=2.45e-07 sb=2e-06 sd=160n sca=12.1244 scb=0.0107968 \
        scc=0.000332109 m=(1)
mp50 (net566 \1\:SN \1\:VDD VDD) g45p1lvt w=(2.15e-07) l=4.5e-08 nf=1 \
        as=6.863e-14 ad=3.44e-14 ps=1.17e-06 pd=7.5e-07 nrd=1.16667 \
        nrs=1.16667 sa=4.5e-07 sb=2e-06 sd=160n sca=12.1244 scb=0.0107968 \
        scc=0.000332109 m=(1)
C1 (D VSS) capacitor c=6.42218e-17
C2 (RN VSS) capacitor c=6.42486e-17
C3 (Q VSS) capacitor c=1.72582e-17
C4 (SN VSS) capacitor c=5.22756e-17
C5 (QN VSS) capacitor c=1.73932e-17
C6 (VDD VSS) capacitor c=6.18817e-16
C7 (SE VSS) capacitor c=9.74158e-17
C8 (SI VSS) capacitor c=6.15335e-17
C9 (CKN VSS) capacitor c=7.65273e-17
C10 (SEb VSS) capacitor c=7.36246e-17
C11 (net538 VSS) capacitor c=7.30944e-19
C12 (Db VSS) capacitor c=9.43388e-17
C13 (net546 VSS) capacitor c=1.37725e-18
C14 (CKNb VSS) capacitor c=3.4432e-17
C15 (n20 VSS) capacitor c=8.36975e-17
C16 (CKNbb VSS) capacitor c=3.34707e-17
C17 (net582 VSS) capacitor c=1.44418e-19
C18 (mout VSS) capacitor c=7.17029e-17
C19 (RNb VSS) capacitor c=7.53824e-17
C20 (net521 VSS) capacitor c=9.21558e-17
C21 (n35 VSS) capacitor c=1.95548e-16
C22 (net0363 VSS) capacitor c=7.9362e-17
C23 (net498 VSS) capacitor c=8.80294e-17
C24 (qbint VSS) capacitor c=8.72438e-17
C25 (qint VSS) capacitor c=2.64546e-16
C26 (net461 VSS) capacitor c=4.43802e-18
C27 (net478 VSS) capacitor c=2.70109e-19
C28 (net566 VSS) capacitor c=1.05001e-16
C29 (net414 VSS) capacitor c=3.22857e-18
C30 (\19\:qbint VSS) capacitor c=5.02992e-17
C31 (\1\:SN VSS) capacitor c=6.9977e-17
C32 (\4\:RNb VSS) capacitor c=7.55898e-17
C33 (\14\:CKNb VSS) capacitor c=5.54139e-17
C34 (\5\:CKNbb VSS) capacitor c=6.45328e-17
C35 (\3\:RN VSS) capacitor c=2.95802e-17
C36 (\5\:SN VSS) capacitor c=3.67715e-17
C37 (\9\:CKNb VSS) capacitor c=3.80829e-17
C38 (\1\:CKN VSS) capacitor c=4.27673e-17
C39 (\1\:D VSS) capacitor c=7.21185e-17
C40 (\6\:SE VSS) capacitor c=4.33579e-17
C41 (\3\:SEb VSS) capacitor c=4.74268e-17
C42 (\1\:SI VSS) capacitor c=8.41357e-17
C43 (\1\:SE VSS) capacitor c=5.94087e-17
C44 (\17\:qbint VSS) capacitor c=2.39121e-17
C45 (\4\:qbint VSS) capacitor c=2.58566e-16
C46 (\2\:SN VSS) capacitor c=1.66785e-16
C47 (\3\:qbint VSS) capacitor c=3.99157e-17
C48 (\6\:RNb VSS) capacitor c=4.19874e-17
C49 (\4\:CKNbb VSS) capacitor c=5.69194e-17
C50 (\11\:CKNb VSS) capacitor c=5.21788e-17
C51 (\1\:RN VSS) capacitor c=3.9034e-17
C52 (\3\:SN VSS) capacitor c=1.42416e-16
C53 (\3\:n20 VSS) capacitor c=6.15918e-17
C54 (\2\:RNb VSS) capacitor c=6.87677e-17
C55 (\5\:CKNb VSS) capacitor c=2.9526e-17
C56 (\2\:mout VSS) capacitor c=6.1026e-17
C57 (\3\:CKNb VSS) capacitor c=4.87282e-17
C58 (\3\:CKNbb VSS) capacitor c=6.24291e-17
C59 (\3\:CKN VSS) capacitor c=2.87635e-17
C60 (\3\:D VSS) capacitor c=3.47485e-17
C61 (\4\:SE VSS) capacitor c=5.55685e-17
C62 (\3\:SI VSS) capacitor c=6.07037e-17
C63 (\3\:SE VSS) capacitor c=2.45633e-17
C64 (\18\:qbint VSS) capacitor c=3.76e-17
C65 (\2\:qbint VSS) capacitor c=5.89612e-17
C66 (\5\:RNb VSS) capacitor c=5.66502e-17
C67 (\13\:CKNb VSS) capacitor c=2.15393e-17
C68 (\6\:CKNbb VSS) capacitor c=2.06479e-17
C69 (\12\:CKNb VSS) capacitor c=3.49485e-17
C70 (\2\:RN VSS) capacitor c=3.0054e-17
C71 (\3\:RNb VSS) capacitor c=4.37972e-17
C72 (\4\:SN VSS) capacitor c=4.95094e-17
C73 (\2\:n20 VSS) capacitor c=2.96714e-17
C74 (\10\:CKNb VSS) capacitor c=2.78802e-17
C75 (\7\:CKNb VSS) capacitor c=1.83288e-17
C76 (\3\:mout VSS) capacitor c=2.71542e-17
C77 (\4\:CKNb VSS) capacitor c=4.71999e-17
C78 (\2\:CKNbb VSS) capacitor c=6.04122e-17
C79 (\2\:CKNb VSS) capacitor c=3.19431e-17
C80 (\2\:CKN VSS) capacitor c=4.09455e-17
C81 (\2\:D VSS) capacitor c=6.15375e-17
C82 (\7\:SE VSS) capacitor c=5.22459e-17
C83 (\2\:SEb VSS) capacitor c=8.09315e-17
C84 (\5\:SE VSS) capacitor c=4.29107e-17
C85 (\2\:SI VSS) capacitor c=6.18264e-17
C86 (\2\:SE VSS) capacitor c=5.93405e-17
C87 (\20\:qint VSS) capacitor c=4.13888e-17
C88 (\1\:VDD VSS) capacitor c=4.3825e-16
C89 (\25\:qbint VSS) capacitor c=6.53879e-17
C90 (\22\:VDD VSS) capacitor c=4.40913e-17
C91 (\3\:net566 VSS) capacitor c=1.0094e-16
C92 (\12\:n35 VSS) capacitor c=4.0498e-17
C93 (\6\:mout VSS) capacitor c=1.73679e-16
C94 (\11\:RNb VSS) capacitor c=5.60103e-17
C95 (\25\:VDD VSS) capacitor c=3.90786e-17
C96 (\8\:mout VSS) capacitor c=1.62729e-16
C97 (\29\:VDD VSS) capacitor c=2.21101e-17
C98 (\8\:CKNbb VSS) capacitor c=2.5564e-16
C99 (\32\:VDD VSS) capacitor c=2.7287e-17
C100 (\5\:n20 VSS) capacitor c=1.76501e-16
C101 (\3\:Db VSS) capacitor c=1.39382e-16
C102 (\21\:CKNb VSS) capacitor c=9.49731e-17
C103 (\35\:VDD VSS) capacitor c=1.69096e-17
C104 (\5\:Db VSS) capacitor c=1.41045e-16
C105 (\39\:VDD VSS) capacitor c=2.93744e-17
C106 (\8\:SEb VSS) capacitor c=1.4483e-17
C107 (\3\:VDD VSS) capacitor c=1.19947e-16
C108 (\16\:qint VSS) capacitor c=3.08873e-17
C109 (\1\:QN VSS) capacitor c=1.23912e-16
C110 (\1\:Q VSS) capacitor c=1.21022e-16
C111 (\27\:qbint VSS) capacitor c=2.05519e-17
C112 (\3\:net0363 VSS) capacitor c=1.04504e-16
C113 (\3\:net498 VSS) capacitor c=8.57221e-17
C114 (\10\:n35 VSS) capacitor c=5.9381e-17
C115 (\4\:mout VSS) capacitor c=8.93314e-17
C116 (\8\:RNb VSS) capacitor c=2.16771e-16
C117 (\3\:net521 VSS) capacitor c=9.78222e-17
C118 (\11\:mout VSS) capacitor c=6.42177e-17
C119 (\12\:CKNbb VSS) capacitor c=4.64986e-17
C120 (\7\:n20 VSS) capacitor c=9.84671e-17
C121 (\18\:CKNb VSS) capacitor c=1.02813e-16
C122 (\7\:Db VSS) capacitor c=1.16748e-16
C123 (\6\:SEb VSS) capacitor c=6.88981e-17
C124 (\6\:CKNb VSS) capacitor c=1.08972e-17
C125 (\8\:CKNb VSS) capacitor c=1.79124e-17
C126 (\4\:SI VSS) capacitor c=4.00693e-17
C127 (\4\:SEb VSS) capacitor c=5.58488e-17
C128 (\5\:SEb VSS) capacitor c=7.74855e-17
C129 (\8\:SE VSS) capacitor c=1.35824e-16
C130 (\9\:SE VSS) capacitor c=4.69934e-17
C131 (\10\:SE VSS) capacitor c=4.93628e-17
C132 (\11\:SE VSS) capacitor c=3.70699e-17
C133 (\4\:D VSS) capacitor c=6.98215e-17
C134 (\4\:CKN VSS) capacitor c=5.91308e-17
C135 (\15\:CKNb VSS) capacitor c=4.78038e-17
C136 (\16\:CKNb VSS) capacitor c=8.34531e-17
C137 (\17\:CKNb VSS) capacitor c=1.16214e-16
C138 (\20\:CKNb VSS) capacitor c=7.87267e-17
C139 (\4\:n20 VSS) capacitor c=1.86823e-16
C140 (\6\:SN VSS) capacitor c=6.69779e-17
C141 (\4\:RN VSS) capacitor c=5.32951e-17
C142 (\10\:mout VSS) capacitor c=1.41901e-16
C143 (\13\:mout VSS) capacitor c=1.01291e-16
C144 (\7\:CKNbb VSS) capacitor c=2.65851e-16
C145 (\10\:CKNbb VSS) capacitor c=6.7937e-17
C146 (\11\:CKNbb VSS) capacitor c=6.92929e-17
C147 (\23\:CKNb VSS) capacitor c=8.28708e-17
C148 (\24\:CKNb VSS) capacitor c=3.21511e-16
C149 (\25\:CKNb VSS) capacitor c=2.54781e-16
C150 (\26\:CKNb VSS) capacitor c=6.07637e-17
C151 (\7\:RNb VSS) capacitor c=1.99056e-16
C152 (\10\:RNb VSS) capacitor c=8.12504e-17
C153 (\8\:n35 VSS) capacitor c=1.43078e-16
C154 (\9\:n35 VSS) capacitor c=1.71532e-16
C155 (\6\:Q VSS) capacitor c=1.69627e-16
C156 (\5\:QN VSS) capacitor c=1.50759e-16
C157 (\20\:qbint VSS) capacitor c=2.64519e-16
C158 (\21\:qbint VSS) capacitor c=2.00179e-16
C159 (\22\:qbint VSS) capacitor c=3.78077e-17
C160 (\23\:qbint VSS) capacitor c=5.88604e-17
C161 (\24\:qbint VSS) capacitor c=2.36708e-17
C162 (\29\:qbint VSS) capacitor c=1.69173e-17
C163 (\18\:qint VSS) capacitor c=5.40428e-17
C164 (\19\:qint VSS) capacitor c=3.37088e-17
C165 (\21\:VDD VSS) capacitor c=5.10466e-17
C166 (\24\:VDD VSS) capacitor c=6.41638e-17
C167 (\28\:VDD VSS) capacitor c=2.2392e-17
C168 (\31\:VDD VSS) capacitor c=3.67832e-17
C169 (\34\:VDD VSS) capacitor c=2.99091e-17
C170 (\38\:VDD VSS) capacitor c=2.61329e-17
Rk9 (D \4\:D) resistor r=0.2014 c=0
Rk23 (\4\:RN RN) resistor r=0.2629 c=0
Rk47 (\1\:Q Q) resistor r=0.218 c=0
Rk48 (Q \6\:Q) resistor r=0.03303 c=0
Rk22 (SN \6\:SN) resistor r=0.1163 c=0
Rk52 (\1\:QN QN) resistor r=0.2356 c=0
Rk53 (QN \5\:QN) resistor r=0.0584 c=0
Rk99 (\1\:VDD \20\:VDD) resistor r=0.2206 c=0
Rk100 (\20\:VDD \21\:VDD) resistor r=0.05249 c=0
Rk101 (\21\:VDD \23\:VDD) resistor r=0.2872 c=0
Rk102 (\21\:VDD \24\:VDD) resistor r=0.9705 c=0
Rk103 (\24\:VDD \26\:VDD) resistor r=0.1029 c=0
Rk104 (\24\:VDD \27\:VDD) resistor r=0.1804 c=0
Rk105 (\27\:VDD \28\:VDD) resistor r=0.2723 c=0
Rk106 (\28\:VDD \30\:VDD) resistor r=0.04333 c=0
Rk107 (\28\:VDD \31\:VDD) resistor r=0.2144 c=0
Rk108 (\31\:VDD \33\:VDD) resistor r=0.1029 c=0
Rk109 (\31\:VDD \34\:VDD) resistor r=0.6167 c=0
Rk110 (\34\:VDD \36\:VDD) resistor r=0.07416 c=0
Rk111 (\34\:VDD \37\:VDD) resistor r=0.09764 c=0
Rk114 (\38\:VDD VDD) resistor r=0.2329 c=0
Rk112 (\37\:VDD \38\:VDD) resistor r=0.3184 c=0
Rk113 (\38\:VDD \40\:VDD) resistor r=0.1914 c=0
Rk5 (\8\:SE SE) resistor r=0.8605 c=0
Rk6 (SE \9\:SE) resistor r=0.03995 c=0
Rk7 (\9\:SE \10\:SE) resistor r=0.2597 c=0
Rk8 (\9\:SE \11\:SE) resistor r=0.1343 c=0
Rk1 (\4\:SI SI) resistor r=0.04057 c=0
Rk10 (CKN \4\:CKN) resistor r=0.1714 c=0
Rk71 (\1\:VSS \9\:VSS) resistor r=0.2206 c=0
Rk72 (\9\:VSS \10\:VSS) resistor r=0.7449 c=0
Rk73 (\10\:VSS \11\:VSS) resistor r=0.4589 c=0
Rk74 (\11\:VSS \12\:VSS) resistor r=0.4404 c=0
Rk75 (\12\:VSS \13\:VSS) resistor r=0.6961 c=0
Rk76 (\13\:VSS \14\:VSS) resistor r=0.06503 c=0
Rk78 (\15\:VSS VSS) resistor r=0.1526 c=0
Rk77 (\14\:VSS \15\:VSS) resistor r=0.3987 c=0
Rk84 (\10\:VSS \27\:VSS) resistor r=0.228 c=0
Rk85 (\12\:VSS \29\:VSS) resistor r=0.04333 c=0
Rk86 (\13\:VSS \31\:VSS) resistor r=0.3246 c=0
Rk87 (\15\:VSS \33\:VSS) resistor r=0.2463 c=0
Rk2 (\4\:SEb \5\:SEb) resistor r=0.3683 c=0
Rk3 (\5\:SEb \7\:SEb) resistor r=0.6748 c=0
Rk4 (\5\:SEb \9\:SEb) resistor r=0.04813 c=0
Rk11 (\2\:Db \4\:Db) resistor r=0.488 c=0
Rk12 (\4\:Db \6\:Db) resistor r=0.7845 c=0
Rk13 (\6\:Db \8\:Db) resistor r=0.5667 c=0
Rk14 (\15\:CKNb \16\:CKNb) resistor r=0.2499 c=0
Rk15 (\16\:CKNb \17\:CKNb) resistor r=0.481 c=0
Rk16 (\17\:CKNb \19\:CKNb) resistor r=0.3538 c=0
Rk17 (\17\:CKNb \20\:CKNb) resistor r=0.3732 c=0
Rk18 (\19\:CKNb \22\:CKNb) resistor r=0.5788 c=0
Rk33 (\23\:CKNb \24\:CKNb) resistor r=0.3685 c=0
Rk34 (\24\:CKNb \25\:CKNb) resistor r=1.7794 c=0
Rk35 (\24\:CKNb \26\:CKNb) resistor r=0.422 c=0
Rk19 (\4\:n20 \6\:n20) resistor r=1.3129 c=0
Rk20 (\6\:n20 \8\:n20) resistor r=0.4705 c=0
Rk29 (\7\:CKNbb \9\:CKNbb) resistor r=1.9431 c=0
Rk30 (\9\:CKNbb \10\:CKNbb) resistor r=0.1391 c=0
Rk31 (\10\:CKNbb \11\:CKNbb) resistor r=0.3859 c=0
Rk32 (\10\:CKNbb \13\:CKNbb) resistor r=0.2541 c=0
Rk24 (\5\:mout \7\:mout) resistor r=0.4434 c=0
Rk25 (\7\:mout \9\:mout) resistor r=0.8606 c=0
Rk26 (\9\:mout \10\:mout) resistor r=0.4776 c=0
Rk27 (\10\:mout \12\:mout) resistor r=0.2253 c=0
Rk28 (\10\:mout \13\:mout) resistor r=0.8518 c=0
Rk36 (\7\:RNb \9\:RNb) resistor r=1.2189 c=0
Rk37 (\9\:RNb \10\:RNb) resistor r=0.7067 c=0
Rk38 (\9\:RNb \12\:RNb) resistor r=0.3508 c=0
Rk21 (\2\:net521 \4\:net521) resistor r=0.4636 c=0
Rk42 (\8\:n35 \9\:n35) resistor r=1.0156 c=0
Rk43 (\9\:n35 \11\:n35) resistor r=0.25 c=0
Rk44 (\9\:n35 \13\:n35) resistor r=0.1305 c=0
Rk39 (\2\:net0363 \4\:net0363) resistor r=0.3236 c=0
Rk40 (\2\:net498 \4\:net498) resistor r=0.4095 c=0
Rk56 (\20\:qbint \21\:qbint) resistor r=2.0416 c=0
Rk57 (\21\:qbint \22\:qbint) resistor r=0.08306 c=0
Rk58 (\22\:qbint \23\:qbint) resistor r=0.3426 c=0
Rk59 (\21\:qbint \24\:qbint) resistor r=0.09617 c=0
Rk60 (\24\:qbint \26\:qbint) resistor r=0.2737 c=0
Rk61 (\22\:qbint \28\:qbint) resistor r=0.05853 c=0
Rk62 (\24\:qbint \29\:qbint) resistor r=0.2041 c=0
Rk63 (\17\:qint \18\:qint) resistor r=0.3995 c=0
Rk64 (\18\:qint \19\:qint) resistor r=0.2082 c=0
Rk65 (\18\:qint \21\:qint) resistor r=0.1833 c=0
Rk41 (\2\:net566 \4\:net566) resistor r=0.679 c=0
Rl9 (\1\:D \2\:D) resistor r=186.333 c=0
Rl10 (\2\:D \3\:D) resistor r=43.7671 c=0
Rl29 (\2\:RN \3\:RN) resistor r=60.7713 c=0
Rl28 (\1\:RN \2\:RN) resistor r=45.708 c=0
Rl38 (\1\:SN \2\:SN) resistor r=223.077 c=0
Rl39 (\2\:SN \3\:SN) resistor r=928.412 c=0
Rl41 (\4\:SN \5\:SN) resistor r=60.7713 c=0
Rl40 (\3\:SN \4\:SN) resistor r=189.939 c=0
Rl8 (\6\:SE \7\:SE) resistor r=79.5379 c=0
Rl5 (\4\:SE \5\:SE) resistor r=47.3097 c=0
Rl1 (\1\:SE \2\:SE) resistor r=251.489 c=0
Rl2 (\2\:SE \3\:SE) resistor r=39.5604 c=0
Rl3 (\1\:SI \2\:SI) resistor r=144.923 c=0
Rl4 (\2\:SI \3\:SI) resistor r=85.3072 c=0
Rl11 (\1\:CKN \2\:CKN) resistor r=109.615 c=0
Rl12 (\2\:CKN \3\:CKN) resistor r=59.0659 c=0
Rl7 (\2\:SEb \3\:SEb) resistor r=24.2328 c=0
Rl6 (SEb \2\:SEb) resistor r=263.567 c=0
Rl33 (\13\:CKNb \14\:CKNb) resistor r=120.667 c=0
Rl30 (\11\:CKNb \12\:CKNb) resistor r=37.6944 c=0
Rl16 (\3\:CKNb \4\:CKNb) resistor r=29.5379 c=0
Rl13 (CKNb \2\:CKNb) resistor r=64.1533 c=0
Rl19 (\5\:CKNb \6\:CKNb) resistor r=49.7141 c=0
Rl20 (\6\:CKNb \7\:CKNb) resistor r=1.2666 c=0
Rl22 (\8\:CKNb \9\:CKNb) resistor r=35.7866 c=0
Rl23 (\8\:CKNb \10\:CKNb) resistor r=92.8494 c=0
Rl21 (\6\:CKNb \8\:CKNb) resistor r=44.8859 c=0
Rl25 (n20 \3\:n20) resistor r=123.077 c=0
Rl24 (n20 \2\:n20) resistor r=139.617 c=0
Rl31 (\4\:CKNbb \5\:CKNbb) resistor r=176.054 c=0
Rl32 (\5\:CKNbb \6\:CKNbb) resistor r=64.1533 c=0
Rl14 (CKNbb \2\:CKNbb) resistor r=24.7951 c=0
Rl15 (\2\:CKNbb \3\:CKNbb) resistor r=172.62 c=0
Rl17 (mout \2\:mout) resistor r=169.231 c=0
Rl18 (\2\:mout \3\:mout) resistor r=24.2328 c=0
Rl26 (RNb \2\:RNb) resistor r=143.796 c=0
Rl34 (\4\:RNb \5\:RNb) resistor r=138.439 c=0
Rl35 (\5\:RNb \6\:RNb) resistor r=80.5643 c=0
Rl27 (\2\:RNb \3\:RNb) resistor r=249.513 c=0
Rl75 (\18\:qbint \19\:qbint) resistor r=110.555 c=0
Rl74 (\18\:qbint \17\:qbint) resistor r=34.6284 c=0
Rl36 (\2\:qbint qbint) resistor r=164.153 c=0
Rl37 (\2\:qbint \3\:qbint) resistor r=33.3841 c=0
Rz33 (\1\:VDD \3\:VDD) resistor r=6.8182 c=0
Rz34 (\20\:VDD \3\:VDD) resistor r=6.25 c=0
Rz35 (\27\:VDD \3\:VDD) resistor r=6.25 c=0
Rz36 (\37\:VDD \3\:VDD) resistor r=6.25 c=0
Rz29 (\27\:VSS \26\:VSS) resistor r=75 c=0
Rz30 (\29\:VSS \28\:VSS) resistor r=75 c=0
Rz31 (\31\:VSS \30\:VSS) resistor r=75 c=0
Rz32 (\33\:VSS \32\:VSS) resistor r=75 c=0
Rz1 (\6\:SEb \7\:SEb) resistor r=75 c=0
Rz2 (Db \2\:Db) resistor r=75 c=0
Rz3 (\7\:Db \8\:Db) resistor r=75 c=0
Rz4 (\18\:CKNb \19\:CKNb) resistor r=75 c=0
Rz5 (\7\:n20 \8\:n20) resistor r=75 c=0
Rz10 (\12\:CKNbb \13\:CKNbb) resistor r=75 c=0
Rz8 (\4\:mout \5\:mout) resistor r=75 c=0
Rz9 (\11\:mout \12\:mout) resistor r=75 c=0
Rz11 (\8\:RNb \9\:RNb) resistor r=75 c=0
Rz6 (net521 \2\:net521) resistor r=75 c=0
Rz7 (\3\:net521 \4\:net521) resistor r=75 c=0
Rz16 (\11\:n35 \10\:n35) resistor r=75 c=0
Rz12 (net0363 \2\:net0363) resistor r=75 c=0
Rz13 (\3\:net0363 \4\:net0363) resistor r=75 c=0
Rz14 (net498 \2\:net498) resistor r=75 c=0
Rz15 (\3\:net498 \4\:net498) resistor r=75 c=0
Rz21 (\28\:qbint \27\:qbint) resistor r=75 c=0
Rz22 (\17\:qint \16\:qint) resistor r=75 c=0
Ry30 (\23\:VDD \22\:VDD) resistor r=62 c=0
Ry31 (\26\:VDD \25\:VDD) resistor r=62 c=0
Ry32 (\30\:VDD \29\:VDD) resistor r=62 c=0
Ry33 (\33\:VDD \32\:VDD) resistor r=62 c=0
Ry34 (\36\:VDD \35\:VDD) resistor r=62 c=0
Ry35 (\40\:VDD \39\:VDD) resistor r=62 c=0
Ry19 (\1\:VSS \3\:VSS) resistor r=5.6364 c=0
Ry20 (\9\:VSS \3\:VSS) resistor r=5.1667 c=0
Ry21 (\11\:VSS \3\:VSS) resistor r=5.1667 c=0
Ry22 (\14\:VSS \3\:VSS) resistor r=5.1667 c=0
Ry1 (\8\:SEb \9\:SEb) resistor r=62 c=0
Ry2 (\3\:Db \4\:Db) resistor r=62 c=0
Ry3 (\5\:Db \6\:Db) resistor r=62 c=0
Ry4 (\21\:CKNb \22\:CKNb) resistor r=62 c=0
Ry5 (\5\:n20 \6\:n20) resistor r=62 c=0
Ry8 (\8\:CKNbb \9\:CKNbb) resistor r=62 c=0
Ry6 (\6\:mout \7\:mout) resistor r=62 c=0
Ry7 (\8\:mout \9\:mout) resistor r=62 c=0
Ry9 (\11\:RNb \12\:RNb) resistor r=62 c=0
Ry12 (\13\:n35 \12\:n35) resistor r=62 c=0
Ry17 (\26\:qbint \25\:qbint) resistor r=31 c=0
Ry18 (\21\:qint \20\:qint) resistor r=20.6667 c=0
Ry10 (net566 \2\:net566) resistor r=62 c=0
Ry11 (\3\:net566 \4\:net566) resistor r=62 c=0
Rx6 (\2\:D \4\:D) resistor r=45 c=0
Rx13 (\2\:RN \4\:RN) resistor r=45 c=0
Rx12 (\4\:SN \6\:SN) resistor r=45 c=0
Rx3 (\7\:SE \8\:SE) resistor r=45 c=0
Rx4 (\2\:SE \10\:SE) resistor r=45 c=0
Rx5 (\5\:SE \11\:SE) resistor r=45 c=0
Rx1 (\2\:SI \4\:SI) resistor r=45 c=0
Rx7 (\2\:CKN \4\:CKN) resistor r=45 c=0
Rx2 (\2\:SEb \4\:SEb) resistor r=45 c=0
Rx8 (\7\:CKNb \15\:CKNb) resistor r=45 c=0
Rx9 (\4\:CKNb \16\:CKNb) resistor r=45 c=0
Rx10 (\2\:CKNb \20\:CKNb) resistor r=45 c=0
Rx17 (\12\:CKNb \23\:CKNb) resistor r=45 c=0
Rx18 (\10\:CKNb \25\:CKNb) resistor r=45 c=0
Rx19 (\13\:CKNb \26\:CKNb) resistor r=45 c=0
Rx11 (\2\:n20 \4\:n20) resistor r=45 c=0
Rx15 (\6\:CKNbb \7\:CKNbb) resistor r=45 c=0
Rx16 (\2\:CKNbb \11\:CKNbb) resistor r=45 c=0
Rx14 (\3\:mout \13\:mout) resistor r=45 c=0
Rx20 (\5\:RNb \7\:RNb) resistor r=45 c=0
Rx21 (\3\:RNb \10\:RNb) resistor r=45 c=0
Rx22 (\8\:n35 n35) resistor r=45 c=0
Rx23 (\20\:qbint \18\:qbint) resistor r=45 c=0
Rx24 (\23\:qbint \2\:qbint) resistor r=45 c=0
Rx25 (\29\:qbint \4\:qbint) resistor r=45 c=0
Rx26 (\19\:qint qint) resistor r=45 c=0
mn10 (\6\:SEb \3\:SE \32\:VSS VSS) g45n1lvt w=(1.45e-07) l=4.5e-08 nf=1 \
        as=3.88e-14 ad=2.465e-14 ps=1.12e-06 pd=6.3e-07 nrd=1.16667 \
        nrs=1.16667 sa=1.7e-07 sb=5.43448e-07 sd=160n sca=8.85152 \
        scb=0.00706865 scc=0.000138481 m=(1)
mn13 (net538 \3\:SI \32\:VSS VSS) g45n1lvt w=(1.45e-07) l=4.5e-08 nf=1 \
        as=3.88e-14 ad=8.7e-15 ps=1.12e-06 pd=4.1e-07 nrd=1.16667 \
        nrs=1.16667 sa=2.5e-07 sb=9.45e-07 sd=160n sca=13.253 \
        scb=0.0137915 scc=0.000695334 m=(1)
mn14 (\7\:Db \4\:SE net538 VSS) g45n1lvt w=(1.45e-07) l=4.5e-08 nf=1 \
        as=8.7e-15 ad=3.698e-14 ps=4.1e-07 pd=8e-07 nrd=1.16667 \
        nrs=1.16667 sa=3.55e-07 sb=8.4e-07 sd=160n sca=13.253 \
        scb=0.0137915 scc=0.000695334 m=(1)
mn12 (\7\:Db SEb net546 VSS) g45n1lvt w=(1.45e-07) l=4.5e-08 nf=1 \
        as=1.595e-14 ad=3.698e-14 ps=5.1e-07 pd=8e-07 nrd=1.16667 \
        nrs=1.16667 sa=6.55e-07 sb=5.4e-07 sd=160n sca=13.253 \
        scb=0.0137915 scc=0.000695334 m=(1)
mn11 (net546 \3\:D \30\:VSS VSS) g45n1lvt w=(1.45e-07) l=4.5e-08 nf=1 \
        as=2.9e-14 ad=1.595e-14 ps=6.9e-07 pd=5.1e-07 nrd=1.16667 \
        nrs=1.16667 sa=8.1e-07 sb=3.85e-07 sd=160n sca=13.253 \
        scb=0.0137915 scc=0.000695334 m=(1)
mn20 (\18\:CKNb \3\:CKN \30\:VSS VSS) g45n1lvt w=(1.45e-07) l=4.5e-08 \
        nf=1 as=2.9e-14 ad=2.03e-14 ps=6.9e-07 pd=5.7e-07 nrd=1.16667 \
        nrs=1.16667 sa=1.055e-06 sb=1.4e-07 sd=160n sca=13.253 \
        scb=0.0137915 scc=0.000695334 m=(1)
mn25 (Db \3\:CKNbb \7\:n20 VSS) g45n1lvt w=(1.45e-07) l=4.5e-08 nf=1 \
        as=3.045e-14 ad=3.698e-14 ps=7.1e-07 pd=8e-07 nrd=1.16667 \
        nrs=1.16667 sa=2.55e-07 sb=8.25e-07 sd=160n sca=23.279 \
        scb=0.0230742 scc=0.00267719 m=(1)
mn36 (\7\:n20 \3\:CKNb net582 VSS) g45n1lvt w=(1.45e-07) l=4.5e-08 nf=1 \
        as=1.667e-14 ad=3.045e-14 ps=5.2e-07 pd=7.1e-07 nrd=1.16667 \
        nrs=1.16667 sa=5.1e-07 sb=5.7e-07 sd=160n sca=23.279 scb=0.0230742 \
        scc=0.00267719 m=(1)
mn35 (net582 \2\:mout \28\:VSS VSS) g45n1lvt w=(1.45e-07) l=4.5e-08 nf=1 \
        as=6.877e-14 ad=1.667e-14 ps=1.85e-06 pd=5.2e-07 nrd=1.16667 \
        nrs=1.16667 sa=6.7e-07 sb=4.1e-07 sd=160n sca=23.279 scb=0.0230742 \
        scc=0.00267719 m=(1)
mn21 (\12\:CKNbb \5\:CKNb \28\:VSS VSS) g45n1lvt w=(1.45e-07) l=4.5e-08 \
        nf=1 as=6.877e-14 ad=2.03e-14 ps=1.85e-06 pd=5.7e-07 nrd=1.16667 \
        nrs=1.16667 sa=9.4e-07 sb=1.4e-07 sd=160n sca=23.279 scb=0.0230742 \
        scc=0.00267719 m=(1)
mn31 (\11\:mout \2\:RNb net521 VSS) g45n1lvt w=(1.45e-07) l=4.5e-08 nf=1 \
        as=3.045e-14 ad=2.32e-14 ps=7.1e-07 pd=6.1e-07 nrd=1.16667 \
        nrs=1.16667 sa=2.1e-07 sb=1.24e-06 sd=160n sca=13.6097 \
        scb=0.014254 scc=0.000755054 m=(1)
mn32 (\11\:mout \3\:n20 \3\:net521 VSS) g45n1lvt w=(1.45e-07) l=4.5e-08 \
        nf=1 as=8.482e-14 ad=2.32e-14 ps=1.46e-06 pd=6.1e-07 nrd=1.16667 \
        nrs=1.16667 sa=4.15e-07 sb=1.035e-06 sd=160n sca=13.6097 \
        scb=0.014254 scc=0.000755054 m=(1)
mn30 (\3\:net521 \3\:SN \26\:VSS VSS) g45n1lvt w=(1.45e-07) l=4.5e-08 \
        nf=1 as=4.75e-14 ad=8.482e-14 ps=9.9e-07 pd=1.46e-06 nrd=1.16667 \
        nrs=1.16667 sa=1.045e-06 sb=4.05e-07 sd=160n sca=13.6097 \
        scb=0.014254 scc=0.000755054 m=(1)
mn22 (\8\:RNb \1\:RN \26\:VSS VSS) g45n1lvt w=(1.45e-07) l=4.5e-08 nf=1 \
        as=4.75e-14 ad=2.03e-14 ps=9.9e-07 pd=5.7e-07 nrd=1.16667 \
        nrs=1.16667 sa=1.31e-06 sb=1.4e-07 sd=160n sca=13.6097 \
        scb=0.014254 scc=0.000755054 m=(1)
mn40 (\4\:mout \11\:CKNb \10\:n35 VSS) g45n1lvt w=(1.45e-07) l=4.5e-08 \
        nf=1 as=2.32e-14 ad=2.03e-14 ps=6.1e-07 pd=5.7e-07 nrd=1.16667 \
        nrs=1.16667 sa=1.4e-07 sb=4.8e-07 sd=160n sca=23.279 scb=0.0230742 \
        scc=0.00267719 m=(1)
mn53 (\10\:n35 \4\:CKNbb net0363 VSS) g45n1lvt w=(1.45e-07) l=4.5e-08 \
        nf=1 as=3.987e-14 ad=2.32e-14 ps=8.4e-07 pd=6.1e-07 nrd=1.16667 \
        nrs=1.16667 sa=3.45e-07 sb=2.75e-07 sd=160n sca=23.279 \
        scb=0.0230742 scc=0.00267719 m=(1)
mn51 (\3\:net0363 \6\:RNb \3\:net498 VSS) g45n1lvt w=(1.45e-07) l=4.5e-08 \
        nf=1 as=2.9e-14 ad=2.392e-14 ps=6.9e-07 pd=6.2e-07 nrd=1.16667 \
        nrs=1.16667 sa=2e-07 sb=2e-06 sd=160n sca=9.87692 scb=0.0087933 \
        scc=0.000232488 m=(1)
mn52 (\3\:net0363 \3\:qbint net498 VSS) g45n1lvt w=(1.45e-07) l=4.5e-08 \
        nf=1 as=2.32e-14 ad=2.392e-14 ps=6.1e-07 pd=6.2e-07 nrd=1.16667 \
        nrs=1.16667 sa=4.1e-07 sb=2e-06 sd=160n sca=9.87692 scb=0.0087933 \
        scc=0.000232488 m=(1)
mn50 (net498 \2\:SN \1\:VSS VSS) g45n1lvt w=(1.45e-07) l=4.5e-08 nf=1 \
        as=2.92e-14 ad=2.32e-14 ps=7.3e-07 pd=6.1e-07 nrd=1.16667 \
        nrs=1.16667 sa=6.15e-07 sb=2e-06 sd=160n sca=9.87692 scb=0.0087933 \
        scc=0.000232488 m=(1)
mn45_1__rcx (\27\:qbint n35 \1\:VSS VSS) g45n1lvt w=(2.05e-07) l=4.5e-08 \
        nf=1 as=4.861e-14 ad=3.28e-14 ps=9.3e-07 pd=7.3e-07 nrd=1.16667 \
        nrs=1.16667 sa=6.09268e-07 sb=2e-06 sd=160n sca=11.535 \
        scb=0.0112489 scc=0.00047927 m=(2)
mn56 (\16\:qint \17\:qbint \1\:VSS VSS) g45n1lvt w=(2.6e-07) l=4.5e-08 \
        nf=1 as=7.93e-14 ad=3.64e-14 ps=1.13e-06 pd=8e-07 nrd=1.16667 \
        nrs=1.16667 sa=2e-06 sb=1.4e-07 sd=160n sca=10.5507 scb=0.0097116 \
        scc=0.000384728 m=(1)
mn55_1__rcx (\1\:Q \4\:qbint \1\:VSS VSS) g45n1lvt w=(2.6e-07) l=4.5e-08 \
        nf=1 as=8.061e-14 ad=4.16e-14 ps=1.3475e-06 pd=8.4e-07 nrd=1.16667 \
        nrs=1.16667 sa=9.39135e-07 sb=2e-06 sd=160n sca=10.5507 \
        scb=0.0097116 scc=0.000384728 m=(4)
mn57_1__rcx (\1\:QN qint \1\:VSS VSS) g45n1lvt w=(2.6e-07) l=4.5e-08 \
        nf=1 as=8.342e-14 ad=4.16e-14 ps=1.3475e-06 pd=8.4e-07 nrd=1.16667 \
        nrs=1.16667 sa=1.70346e-06 sb=1.165e-06 sd=160n sca=10.5507 \
        scb=0.0097116 scc=0.000384728 m=(4)
mp45_1__rcx (\25\:qbint n35 \1\:VDD VDD) g45p1lvt w=(3.1e-07) l=4.5e-08 \
        nf=1 as=6.776e-14 ad=4.96e-14 ps=1.165e-06 pd=9.4e-07 nrd=1.16667 \
        nrs=1.16667 sa=5.64677e-07 sb=2e-06 sd=160n sca=15.9771 \
        scb=0.0149994 scc=0.00109313 m=(2)
mp56 (\20\:qint \19\:qbint \1\:VDD VDD) g45p1lvt w=(3.9e-07) l=4.5e-08 \
        nf=1 as=6.24e-14 ad=5.46e-14 ps=1.1e-06 pd=1.06e-06 nrd=1.16667 \
        nrs=1.16667 sa=1.96308e-06 sb=1.4e-07 sd=160n sca=27.1678 \
        scb=0.0200607 scc=0.00278 m=(1)
mp55_1__rcx (\6\:Q \4\:qbint \1\:VDD VDD) g45p1lvt w=(3.9e-07) l=4.5e-08 \
        nf=1 as=6.353e-14 ad=7.312e-14 ps=1.115e-06 pd=1.155e-06 \
        nrd=1.16667 nrs=1.16667 sa=8.19103e-07 sb=1.86e-06 sd=160n \
        sca=25.6993 scb=0.0190507 scc=0.00277827 m=(4)
mp57_1__rcx (\5\:QN qint \1\:VDD VDD) g45p1lvt w=(3.9e-07) l=4.5e-08 \
        nf=1 as=6.24e-14 ad=6.727e-14 ps=1.1e-06 pd=1.125e-06 nrd=1.16667 \
        nrs=1.16667 sa=1.64724e-06 sb=9.85e-07 sd=160n sca=25.6993 \
        scb=0.0190507 scc=0.00277827 m=(4)
ends SDFFNSRX4
// End of subcircuit definition.
