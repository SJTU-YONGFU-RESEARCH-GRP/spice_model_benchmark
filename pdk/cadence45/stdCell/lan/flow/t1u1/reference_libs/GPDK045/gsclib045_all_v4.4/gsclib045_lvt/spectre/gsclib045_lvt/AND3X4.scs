// gsclib045_lvt/AND3X4/schematic

simulator lang=spectre

subckt AND3X4 A B C Y VSS VDD
mp1 (net95 B VDD VDD) g45p1lvt w=(390n) l=45n nf=1 m=(1)
mp2 (net95 C VDD VDD) g45p1lvt w=(390n) l=45n nf=1 m=(1)
mp0 (net95 A VDD VDD) g45p1lvt w=(390n) l=45n nf=1 m=(1)
mp3 (Y net95 VDD VDD) g45p1lvt w=(1.56u) l=45n nf=1 m=(1)
mn3 (Y net95 VSS VSS) g45n1lvt w=(1.04u) l=45n nf=1 m=(1)
mn1 (net111 B net107 VSS) g45n1lvt w=(260n) l=45n nf=1 m=(1)
mn0 (net107 A VSS VSS) g45n1lvt w=(260n) l=45n nf=1 m=(1)
mn2 (net95 C net111 VSS) g45n1lvt w=(260n) l=45n nf=1 m=(1)
ends AND3X4
