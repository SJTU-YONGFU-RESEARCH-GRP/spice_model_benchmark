// Generated for: spectre (May  1 11:30:44 2013 )
// Library name: gsclib045_backbias
// Cell name: NOR2X2
// View name: extracted

simulator lang=spectre

subckt NOR2X2 A B NW VDD VSS Y
mp0_1__rcx (2 \1\:A \4\:VDD NW) g45p1svt w=(3.9e-07) l=4.5e-08 nf=1 \
        as=5.46e-14 ad=2.34e-14 ps=1.06e-06 pd=9e-07 nrd=1.16667 \
        nrs=1.16667 sa=1.4e-07 sb=5.55e-07 sd=160n sca=20.7977 \
        scb=0.0219422 scc=0.000863938 m=(1)
mp1_1__rcx (\6\:Y \6\:B 2 NW) g45p1svt w=(3.9e-07) l=4.5e-08 nf=1 \
        as=2.34e-14 ad=6.24e-14 ps=9e-07 pd=1.1e-06 nrd=1.16667 \
        nrs=1.16667 sa=2.45e-07 sb=4.5e-07 sd=160n sca=18.3517 \
        scb=0.0171974 scc=0.00064315 m=(1)
mp1 (\6\:Y \1\:B 3 NW) g45p1svt w=(3.9e-07) l=4.5e-08 nf=1 as=2.34e-14 \
        ad=6.24e-14 ps=9e-07 pd=1.1e-06 nrd=1.16667 nrs=1.16667 sa=4.5e-07 \
        sb=2.45e-07 sd=160n sca=18.6339 scb=0.0177874 scc=0.000660551 \
        m=(1)
mp0 (3 \6\:A \1\:VDD NW) g45p1svt w=(3.9e-07) l=4.5e-08 nf=1 as=5.46e-14 \
        ad=2.34e-14 ps=1.06e-06 pd=9e-07 nrd=1.16667 nrs=1.16667 \
        sa=5.55e-07 sb=1.4e-07 sd=160n sca=21.6313 scb=0.0233702 \
        scc=0.000971691 m=(1)
C1 (A VSS) capacitor c=3.65644e-17
C2 (VDD VSS) capacitor c=2.74295e-17
C3 (B VSS) capacitor c=6.23833e-17
C4 (NW VSS) capacitor c=1.71691e-16
C5 (Y VSS) capacitor c=7.88658e-17
C6 (2 VSS) capacitor c=9.37954e-19
C7 (3 VSS) capacitor c=3.72699e-18
C8 (\6\:A VSS) capacitor c=7.25006e-17
C9 (\1\:B VSS) capacitor c=6.20797e-17
C10 (\6\:B VSS) capacitor c=5.66349e-17
C11 (\1\:A VSS) capacitor c=7.41277e-17
C12 (\2\:A VSS) capacitor c=3.26198e-16
C13 (\1\:VDD VSS) capacitor c=1.08911e-16
C14 (\6\:Y VSS) capacitor c=1.39843e-16
C15 (\4\:VDD VSS) capacitor c=4.83074e-17
C16 (\1\:Y VSS) capacitor c=1.81136e-16
C17 (\2\:B VSS) capacitor c=1.38445e-16
C18 (\7\:B VSS) capacitor c=3.55348e-17
C19 (\3\:VDD VSS) capacitor c=5.48467e-17
Rk3 (\2\:A A) resistor r=0.1014 c=0
Rk13 (\3\:VDD VDD) resistor r=0.04977 c=0
Rk12 (\2\:VDD \3\:VDD) resistor r=0.6155 c=0
Rk14 (\3\:VDD \5\:VDD) resistor r=0.3144 c=0
Rk10 (VSS \6\:VSS) resistor r=0.3274 c=0
Rk1 (\7\:B B) resistor r=0.05499 c=0
Rk6 (\1\:Y Y) resistor r=0.09399 c=0
Rk7 (Y \7\:Y) resistor r=0.7537 c=0
Rl9 (\2\:A \6\:A) resistor r=72.5275 c=0
Rl1 (\2\:A \1\:A) resistor r=75.1972 c=0
Rl3 (\2\:B \1\:B) resistor r=47.3105 c=0
Rl7 (\2\:B \6\:B) resistor r=24.2328 c=0
Rz4 (\6\:VSS \5\:VSS) resistor r=75 c=0
Ry3 (\1\:VDD \2\:VDD) resistor r=20.6667 c=0
Ry4 (\4\:VDD \5\:VDD) resistor r=20.6667 c=0
Ry1 (\7\:Y \6\:Y) resistor r=31 c=0
Rx1 (\7\:B \2\:B) resistor r=45 c=0
mn0 (\1\:Y \2\:A VSS VSS) g45n1svt w=(2.6e-07) l=4.5e-08 nf=1 \
        as=4.265e-14 ad=4.16e-14 ps=1.12e-06 pd=8.4e-07 nrd=1.16667 \
        nrs=1.16667 sa=1.4e-07 sb=7.15e-07 sd=160n sca=14.4034 \
        scb=0.0144248 scc=0.00102063 m=(2)
mn1 (\1\:Y \2\:B \5\:VSS VSS) g45n1svt w=(2.6e-07) l=4.5e-08 nf=1 \
        as=4.16e-14 ad=4.16e-14 ps=8.4e-07 pd=8.4e-07 nrd=1.16667 \
        nrs=1.16667 sa=3.45e-07 sb=5.1e-07 sd=160n sca=14.4034 \
        scb=0.0144248 scc=0.00102063 m=(2)
ends NOR2X2
// End of subcircuit definition.
