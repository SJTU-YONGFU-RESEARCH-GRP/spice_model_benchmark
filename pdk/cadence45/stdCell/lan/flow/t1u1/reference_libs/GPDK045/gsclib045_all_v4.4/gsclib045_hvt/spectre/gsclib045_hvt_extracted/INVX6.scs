// Generated for: spectre (May  1 09:16:39 2013 )
// Library name: gsclib045_hvt
// Cell name: INVX6
// View name: extracted

simulator lang=spectre

subckt INVX6 A VDD VSS Y
mp0 (\1\:Y \1\:A VDD VDD) g45p1hvt w=(4.7e-07) l=4.5e-08 nf=1 \
        as=7.332e-14 ad=7.332e-14 ps=1.252e-06 pd=1.252e-06 nrd=1.16667 \
        nrs=1.16667 sa=1.4e-07 sb=9.6e-07 sd=160n sca=40.6416 \
        scb=0.0369115 scc=0.00420297 m=(5)
C1 (A VSS) capacitor c=1.70375e-17
C2 (Y VSS) capacitor c=1.17759e-17
C3 (VDD VSS) capacitor c=2.8255e-16
C4 (\1\:A VSS) capacitor c=2.52638e-16
C5 (\9\:A VSS) capacitor c=2.06753e-17
C6 (\1\:Y VSS) capacitor c=3.29362e-16
C7 (\19\:A VSS) capacitor c=8.16692e-17
C8 (\20\:A VSS) capacitor c=1.02402e-16
C9 (\21\:A VSS) capacitor c=4.01831e-17
C10 (\4\:Y VSS) capacitor c=2.56229e-16
Rk1 (\19\:A \20\:A) resistor r=0.417 c=0
Rk3 (\21\:A A) resistor r=0.0229 c=0
Rk2 (\20\:A \21\:A) resistor r=0.3307 c=0
Rk5 (\1\:Y Y) resistor r=0.09507 c=0
Rk6 (Y \4\:Y) resistor r=0.06503 c=0
Rl8 (\1\:A \9\:A) resistor r=3.4936 c=0
Rx1 (\19\:A \1\:A) resistor r=45 c=0
Rx2 (\20\:A \1\:A) resistor r=45 c=0
Rx3 (\21\:A \9\:A) resistor r=45 c=0
mn0 (\4\:Y \1\:A VSS VSS) g45n1hvt w=(3.1e-07) l=4.5e-08 nf=1 \
        as=4.836e-14 ad=4.836e-14 ps=9.32e-07 pd=9.32e-07 nrd=1.16667 \
        nrs=1.16667 sa=1.4e-07 sb=9.6e-07 sd=160n sca=15.9751 \
        scb=0.0153507 scc=0.00137372 m=(5)
ends INVX6
// End of subcircuit definition.
