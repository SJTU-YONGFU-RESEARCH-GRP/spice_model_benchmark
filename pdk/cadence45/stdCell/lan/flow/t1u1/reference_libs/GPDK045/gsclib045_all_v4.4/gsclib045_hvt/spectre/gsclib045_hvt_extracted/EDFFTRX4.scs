// Generated for: spectre (May  1 09:15:12 2013 )
// Library name: gsclib045_hvt
// Cell name: EDFFTRX4
// View name: extracted

simulator lang=spectre

subckt EDFFTRX4 CK D E Q QN RN VDD VSS
mp1 (\5\:Db \1\:D \24\:VDD VDD) g45p1hvt w=(2.15e-07) l=4.5e-08 nf=1 \
        as=1.001e-13 ad=3.01e-14 ps=1.75e-06 pd=7.1e-07 nrd=1.16667 \
        nrs=1.16667 sa=1.4e-07 sb=4.05e-07 sd=160n sca=22.8473 \
        scb=0.0215844 scc=0.00209118 m=(1)
mp0 (\7\:Eb \1\:E \24\:VDD VDD) g45p1hvt w=(2.15e-07) l=4.5e-08 nf=1 \
        as=1.001e-13 ad=3.01e-14 ps=1.75e-06 pd=7.1e-07 nrd=1.16667 \
        nrs=1.16667 sa=4.05e-07 sb=1.4e-07 sd=160n sca=21.5061 \
        scb=0.0204227 scc=0.00208845 m=(1)
mp7 (\13\:Dp \2\:Db \3\:n3 VDD) g45p1hvt w=(2.15e-07) l=4.5e-08 nf=1 \
        as=7.203e-14 ad=3.01e-14 ps=1.1e-06 pd=7.1e-07 nrd=1.16667 \
        nrs=1.16667 sa=1.4e-07 sb=5.2e-07 sd=160n sca=19.0975 \
        scb=0.0187686 scc=0.00166224 m=(1)
mp6 (\11\:Dp \4\:E \3\:n3 VDD) g45p1hvt w=(2.15e-07) l=4.5e-08 nf=1 \
        as=7.203e-14 ad=3.01e-14 ps=1.1e-06 pd=7.1e-07 nrd=1.16667 \
        nrs=1.16667 sa=5.2e-07 sb=1.4e-07 sd=160n sca=19.0975 \
        scb=0.0187686 scc=0.00166224 m=(1)
mp4 (n3 Eb \3\:n2 VDD) g45p1hvt w=(2.15e-07) l=4.5e-08 nf=1 as=3.01e-14 \
        ad=3.44e-14 ps=7.1e-07 pd=7.5e-07 nrd=1.16667 nrs=1.16667 \
        sa=1.4e-07 sb=5.1e-07 sd=160n sca=19.0975 scb=0.0187686 \
        scc=0.00166224 m=(1)
mp5 (n3 \2\:qbint n2 VDD) g45p1hvt w=(2.15e-07) l=4.5e-08 nf=1 \
        as=3.44e-14 ad=3.44e-14 ps=7.5e-07 pd=7.5e-07 nrd=1.16667 \
        nrs=1.16667 sa=3.45e-07 sb=3.05e-07 sd=160n sca=19.0975 \
        scb=0.0187686 scc=0.00166224 m=(1)
mp3 (n2 RNb \22\:VDD VDD) g45p1hvt w=(2.15e-07) l=4.5e-08 nf=1 \
        as=5.115e-14 ad=3.44e-14 ps=1.62e-06 pd=7.5e-07 nrd=1.16667 \
        nrs=1.16667 sa=5.5e-07 sb=1e-07 sd=160n sca=19.0975 scb=0.0187686 \
        scc=0.00166224 m=(1)
mp2 (\4\:RNb \1\:RN \20\:VDD VDD) g45p1hvt w=(2.15e-07) l=4.5e-08 nf=1 \
        as=6.14e-14 ad=2.77e-14 ps=1.7e-06 pd=7.1e-07 nrd=1.16667 \
        nrs=1.16667 sa=1.28837e-07 sb=2e-06 sd=160n sca=17.9376 \
        scb=0.0177709 scc=0.00142383 m=(1)
mp25 (n22 Dp \20\:VDD VDD) g45p1hvt w=(2.15e-07) l=4.5e-08 nf=1 \
        as=6.14e-14 ad=3.87e-14 ps=1.7e-06 pd=7.9e-07 nrd=1.16667 \
        nrs=1.16667 sa=3.23837e-07 sb=2e-06 sd=160n sca=17.9376 \
        scb=0.0177709 scc=0.00142383 m=(1)
mp26 (\6\:n20 \5\:CKbb n22 VDD) g45p1hvt w=(2.15e-07) l=4.5e-08 nf=1 \
        as=3.87e-14 ad=5.052e-14 ps=7.9e-07 pd=9e-07 nrd=1.16667 \
        nrs=1.16667 sa=5.48837e-07 sb=1.84e-06 sd=160n sca=17.9376 \
        scb=0.0177709 scc=0.00142383 m=(1)
mp36 (\6\:n20 \3\:CKb net427 VDD) g45p1hvt w=(2.15e-07) l=4.5e-08 nf=1 \
        as=2.58e-14 ad=5.052e-14 ps=6.7e-07 pd=9e-07 nrd=1.16667 \
        nrs=1.16667 sa=8.28837e-07 sb=1.56e-06 sd=160n sca=17.9376 \
        scb=0.0177709 scc=0.00142383 m=(1)
mp35 (net427 mout \18\:VDD VDD) g45p1hvt w=(2.15e-07) l=4.5e-08 nf=1 \
        as=9.71e-14 ad=2.58e-14 ps=1.7e-06 pd=6.7e-07 nrd=1.16667 \
        nrs=1.16667 sa=9.93837e-07 sb=1.395e-06 sd=160n sca=17.9376 \
        scb=0.0177709 scc=0.00142383 m=(1)
mp30 (\4\:mout n20 \18\:VDD VDD) g45p1hvt w=(2.15e-07) l=4.5e-08 nf=1 \
        as=9.71e-14 ad=4.515e-14 ps=1.7e-06 pd=8.5e-07 nrd=1.16667 \
        nrs=1.16667 sa=1.25884e-06 sb=1.13e-06 sd=160n sca=17.9376 \
        scb=0.0177709 scc=0.00142383 m=(1)
mp40 (\8\:n30 \5\:CKb \4\:mout VDD) g45p1hvt w=(2.15e-07) l=4.5e-08 nf=1 \
        as=4.515e-14 ad=6.558e-14 ps=8.5e-07 pd=1.04e-06 nrd=1.16667 \
        nrs=1.16667 sa=1.51384e-06 sb=8.75e-07 sd=160n sca=17.9376 \
        scb=0.0177709 scc=0.00142383 m=(1)
mp51 (\8\:n30 CKbb net411 VDD) g45p1hvt w=(2.15e-07) l=4.5e-08 nf=1 \
        as=2.903e-14 ad=6.558e-14 ps=7e-07 pd=1.04e-06 nrd=1.16667 \
        nrs=1.16667 sa=1.86384e-06 sb=5.25e-07 sd=160n sca=17.9376 \
        scb=0.0177709 scc=0.00142383 m=(1)
mp50 (net411 \5\:qbint \16\:VDD VDD) g45p1hvt w=(2.15e-07) l=4.5e-08 \
        nf=1 as=6.355e-14 ad=2.903e-14 ps=1.72e-06 pd=7e-07 nrd=1.16667 \
        nrs=1.16667 sa=2e-06 sb=3.45e-07 sd=160n sca=17.9376 scb=0.0177709 \
        scc=0.00142383 m=(1)
mp21 (\10\:CKbb \9\:CKb \16\:VDD VDD) g45p1hvt w=(2.15e-07) l=4.5e-08 \
        nf=1 as=6.355e-14 ad=3.01e-14 ps=1.72e-06 pd=7.1e-07 nrd=1.16667 \
        nrs=1.16667 sa=2e-06 sb=1.4e-07 sd=160n sca=17.9376 scb=0.0177709 \
        scc=0.00142383 m=(1)
mp20 (\12\:CKb \1\:CK \1\:VDD VDD) g45p1hvt w=(2.15e-07) l=4.5e-08 nf=1 \
        as=7.115e-14 ad=3.01e-14 ps=1.9e-06 pd=7.1e-07 nrd=1.16667 \
        nrs=1.16667 sa=1.4e-07 sb=2e-06 sd=160n sca=29.9075 scb=0.0247057 \
        scc=0.00372713 m=(1)
C1 (D VSS) capacitor c=5.97348e-17
C2 (Q VSS) capacitor c=1.32289e-17
C3 (CK VSS) capacitor c=8.0465e-17
C4 (RN VSS) capacitor c=5.6902e-17
C5 (QN VSS) capacitor c=1.94601e-17
C6 (VDD VSS) capacitor c=5.57681e-16
C7 (E VSS) capacitor c=2.58064e-17
C8 (Db VSS) capacitor c=6.74227e-17
C9 (Eb VSS) capacitor c=7.61084e-17
C10 (n1 VSS) capacitor c=7.13171e-19
C11 (Dp VSS) capacitor c=6.86934e-17
C12 (qbint VSS) capacitor c=3.64959e-17
C13 (RNb VSS) capacitor c=4.66417e-17
C14 (n20 VSS) capacitor c=4.60631e-17
C15 (CKb VSS) capacitor c=3.6454e-17
C16 (net516 VSS) capacitor c=1.19036e-18
C17 (CKbb VSS) capacitor c=3.81858e-17
C18 (mout VSS) capacitor c=4.15395e-17
C19 (n30 VSS) capacitor c=1.81162e-16
C20 (net496 VSS) capacitor c=4.27756e-20
C21 (qint VSS) capacitor c=2.97049e-16
C22 (n3 VSS) capacitor c=7.95066e-17
C23 (n2 VSS) capacitor c=6.49255e-17
C24 (n22 VSS) capacitor c=1.09542e-18
C25 (net427 VSS) capacitor c=5.75394e-19
C26 (net411 VSS) capacitor c=9.50992e-19
C27 (\20\:qbint VSS) capacitor c=4.43847e-17
C28 (\1\:CK VSS) capacitor c=5.07557e-17
C29 (\9\:CKb VSS) capacitor c=5.99285e-17
C30 (\5\:qbint VSS) capacitor c=6.21687e-17
C31 (\5\:CKb VSS) capacitor c=4.05778e-17
C32 (\3\:CKb VSS) capacitor c=4.72894e-17
C33 (\5\:CKbb VSS) capacitor c=7.3632e-17
C34 (\1\:RN VSS) capacitor c=4.73402e-17
C35 (\2\:qbint VSS) capacitor c=5.92619e-17
C36 (\4\:E VSS) capacitor c=4.09236e-17
C37 (\2\:Db VSS) capacitor c=4.43156e-17
C38 (\1\:E VSS) capacitor c=3.45877e-17
C39 (\1\:D VSS) capacitor c=3.47681e-17
C40 (\22\:qbint VSS) capacitor c=4.1752e-17
C41 (\7\:qbint VSS) capacitor c=2.70769e-16
C42 (\3\:CK VSS) capacitor c=2.89423e-17
C43 (\10\:CKb VSS) capacitor c=2.33195e-17
C44 (\6\:qbint VSS) capacitor c=8.1393e-17
C45 (\7\:CKb VSS) capacitor c=6.51551e-17
C46 (\3\:CKbb VSS) capacitor c=9.51407e-17
C47 (\3\:n20 VSS) capacitor c=3.78865e-17
C48 (\3\:mout VSS) capacitor c=5.3262e-17
C49 (\4\:CKbb VSS) capacitor c=1.15703e-16
C50 (\2\:CKb VSS) capacitor c=7.19075e-17
C51 (\2\:Dp VSS) capacitor c=4.94397e-17
C52 (\3\:RN VSS) capacitor c=4.92389e-17
C53 (\3\:RNb VSS) capacitor c=5.42397e-17
C54 (\3\:qbint VSS) capacitor c=8.95147e-17
C55 (\2\:Eb VSS) capacitor c=4.20091e-17
C56 (\6\:E VSS) capacitor c=5.92767e-17
C57 (\3\:E VSS) capacitor c=3.04403e-17
C58 (\3\:D VSS) capacitor c=3.36672e-17
C59 (\21\:qbint VSS) capacitor c=4.97795e-17
C60 (\2\:CK VSS) capacitor c=2.85558e-17
C61 (\11\:CKb VSS) capacitor c=2.10575e-17
C62 (\4\:qbint VSS) capacitor c=2.47457e-17
C63 (\2\:CKbb VSS) capacitor c=7.43667e-17
C64 (\8\:CKb VSS) capacitor c=3.3669e-17
C65 (\6\:CKb VSS) capacitor c=4.11753e-17
C66 (\2\:n20 VSS) capacitor c=3.41315e-17
C67 (\2\:mout VSS) capacitor c=4.37175e-17
C68 (\4\:CKb VSS) capacitor c=4.29438e-17
C69 (\3\:Dp VSS) capacitor c=2.9269e-17
C70 (\2\:RN VSS) capacitor c=4.20582e-17
C71 (\2\:RNb VSS) capacitor c=4.25848e-17
C72 (\3\:Eb VSS) capacitor c=2.78559e-17
C73 (\5\:E VSS) capacitor c=3.80477e-17
C74 (\3\:Db VSS) capacitor c=2.47022e-17
C75 (\2\:E VSS) capacitor c=3.24023e-17
C76 (\2\:D VSS) capacitor c=2.90769e-17
C77 (\16\:qint VSS) capacitor c=5.65457e-17
C78 (\1\:QN VSS) capacitor c=1.13627e-16
C79 (\26\:qbint VSS) capacitor c=3.99003e-17
C80 (\1\:VDD VSS) capacitor c=2.79989e-16
C81 (\12\:CKb VSS) capacitor c=1.46798e-16
C82 (\10\:CKbb VSS) capacitor c=3.77139e-17
C83 (\16\:VDD VSS) capacitor c=2.48171e-17
C84 (\8\:n30 VSS) capacitor c=2.24188e-16
C85 (\4\:mout VSS) capacitor c=2.46749e-17
C86 (\18\:VDD VSS) capacitor c=1.05414e-17
C87 (\6\:n20 VSS) capacitor c=1.26413e-16
C88 (\20\:VDD VSS) capacitor c=9.2039e-18
C89 (\4\:RNb VSS) capacitor c=7.72682e-17
C90 (\22\:VDD VSS) capacitor c=1.12254e-17
C91 (\3\:n2 VSS) capacitor c=7.56665e-17
C92 (\11\:Dp VSS) capacitor c=4.52421e-17
C93 (\3\:n3 VSS) capacitor c=7.75664e-17
C94 (\13\:Dp VSS) capacitor c=5.49462e-17
C95 (\7\:Eb VSS) capacitor c=6.19183e-17
C96 (\24\:VDD VSS) capacitor c=2.74349e-17
C97 (\5\:Db VSS) capacitor c=1.64554e-16
C98 (\6\:VDD VSS) capacitor c=1.02744e-16
C99 (\20\:qint VSS) capacitor c=8.65904e-18
C100 (\5\:QN VSS) capacitor c=7.57422e-17
C101 (\1\:Q VSS) capacitor c=7.09336e-17
C102 (\29\:qbint VSS) capacitor c=2.28699e-17
C103 (\14\:CKb VSS) capacitor c=1.20857e-16
C104 (\6\:CKbb VSS) capacitor c=5.8199e-17
C105 (\10\:n30 VSS) capacitor c=8.43931e-17
C106 (\8\:mout VSS) capacitor c=6.73439e-17
C107 (\4\:n20 VSS) capacitor c=7.17946e-17
C108 (\8\:RNb VSS) capacitor c=2.83938e-17
C109 (\5\:Dp VSS) capacitor c=1.16994e-16
C110 (\9\:Dp VSS) capacitor c=3.84513e-17
C111 (\5\:Eb VSS) capacitor c=1.51215e-16
C112 (\7\:Db VSS) capacitor c=8.17174e-17
C113 (\4\:D VSS) capacitor c=5.80391e-17
C114 (\4\:Db VSS) capacitor c=1.13705e-16
C115 (\7\:E VSS) capacitor c=5.78143e-17
C116 (\8\:E VSS) capacitor c=1.04617e-16
C117 (\9\:E VSS) capacitor c=1.09202e-16
C118 (\4\:Eb VSS) capacitor c=1.49283e-16
C119 (\6\:RNb VSS) capacitor c=3.72766e-17
C120 (\7\:RNb VSS) capacitor c=1.14678e-17
C121 (\4\:Dp VSS) capacitor c=6.76808e-17
C122 (\7\:Dp VSS) capacitor c=9.97974e-17
C123 (\8\:Dp VSS) capacitor c=6.57916e-17
C124 (\4\:RN VSS) capacitor c=4.79088e-17
C125 (\8\:n20 VSS) capacitor c=1.22036e-16
C126 (\6\:mout VSS) capacitor c=4.80014e-17
C127 (\7\:mout VSS) capacitor c=6.01673e-17
C128 (\8\:CKbb VSS) capacitor c=6.01609e-17
C129 (\9\:CKbb VSS) capacitor c=6.21538e-17
C130 (\16\:CKb VSS) capacitor c=1.40392e-16
C131 (\17\:CKb VSS) capacitor c=1.15438e-16
C132 (\18\:CKb VSS) capacitor c=3.36718e-17
C133 (\19\:CKb VSS) capacitor c=1.2207e-16
C134 (\20\:CKb VSS) capacitor c=1.05948e-16
C135 (\21\:CKb VSS) capacitor c=3.17257e-17
C136 (\22\:CKb VSS) capacitor c=8.00221e-17
C137 (\23\:CKb VSS) capacitor c=6.04718e-17
C138 (\4\:CK VSS) capacitor c=5.72979e-17
C139 (\7\:n30 VSS) capacitor c=2.52947e-16
C140 (\4\:Q VSS) capacitor c=1.19178e-16
C141 (\23\:qbint VSS) capacitor c=2.25575e-16
C142 (\24\:qbint VSS) capacitor c=3.17113e-16
C143 (\25\:qbint VSS) capacitor c=3.45088e-16
C144 (\28\:qbint VSS) capacitor c=4.03747e-17
C145 (\31\:qbint VSS) capacitor c=2.02481e-16
C146 (\32\:qbint VSS) capacitor c=2.39208e-17
C147 (\18\:qint VSS) capacitor c=4.05985e-17
C148 (\19\:qint VSS) capacitor c=4.45224e-17
C149 (\4\:VDD VSS) capacitor c=5.14149e-17
C150 (\5\:VDD VSS) capacitor c=2.63483e-17
C151 (\8\:VDD VSS) capacitor c=1.84005e-17
C152 (\9\:VDD VSS) capacitor c=3.69001e-17
C153 (\11\:VDD VSS) capacitor c=2.49049e-17
Rk1 (\4\:D D) resistor r=0.1053 c=0
Rk42 (\1\:Q Q) resistor r=0.1911 c=0
Rk43 (Q \4\:Q) resistor r=0.04541 c=0
Rk93 (\1\:VSS \11\:VSS) resistor r=0.5313 c=0
Rk94 (\11\:VSS \12\:VSS) resistor r=0.5112 c=0
Rk95 (\12\:VSS \13\:VSS) resistor r=0.05999 c=0
Rk96 (\13\:VSS \14\:VSS) resistor r=0.4227 c=0
Rk97 (\14\:VSS \15\:VSS) resistor r=0.2168 c=0
Rk98 (\15\:VSS \16\:VSS) resistor r=0.3306 c=0
Rk99 (\16\:VSS \17\:VSS) resistor r=0.07986 c=0
Rk100 (\17\:VSS \18\:VSS) resistor r=0.1503 c=0
Rk102 (\19\:VSS VSS) resistor r=0.2804 c=0
Rk101 (\18\:VSS \19\:VSS) resistor r=0.2706 c=0
Rk108 (\11\:VSS \31\:VSS) resistor r=0.3927 c=0
Rk109 (\12\:VSS \33\:VSS) resistor r=0.2571 c=0
Rk110 (\14\:VSS \35\:VSS) resistor r=0.04331 c=0
Rk111 (\15\:VSS \37\:VSS) resistor r=0.07393 c=0
Rk112 (\16\:VSS \39\:VSS) resistor r=0.2739 c=0
Rk113 (\17\:VSS \41\:VSS) resistor r=0.2734 c=0
Rk114 (\19\:VSS \43\:VSS) resistor r=0.3824 c=0
Rk38 (\4\:CK CK) resistor r=0.04731 c=0
Rk20 (\4\:RN RN) resistor r=0.03934 c=0
Rk48 (\1\:QN QN) resistor r=0.07077 c=0
Rk49 (QN \5\:QN) resistor r=0.2435 c=0
Rk62 (\1\:VDD \4\:VDD) resistor r=0.4491 c=0
Rk63 (\4\:VDD \5\:VDD) resistor r=0.5253 c=0
Rk64 (\5\:VDD \7\:VDD) resistor r=0.1177 c=0
Rk65 (\7\:VDD \8\:VDD) resistor r=0.3158 c=0
Rk66 (\8\:VDD \9\:VDD) resistor r=0.1977 c=0
Rk67 (\9\:VDD \10\:VDD) resistor r=0.6895 c=0
Rk69 (\11\:VDD VDD) resistor r=0.2945 c=0
Rk68 (\10\:VDD \11\:VDD) resistor r=0.2547 c=0
Rk73 (\4\:VDD \17\:VDD) resistor r=0.04331 c=0
Rk74 (\5\:VDD \19\:VDD) resistor r=0.07393 c=0
Rk75 (\8\:VDD \21\:VDD) resistor r=0.07393 c=0
Rk76 (\9\:VDD \23\:VDD) resistor r=0.07393 c=0
Rk77 (\11\:VDD \25\:VDD) resistor r=0.04331 c=0
Rk5 (\8\:E E) resistor r=0.02565 c=0
Rk4 (\7\:E \8\:E) resistor r=0.2497 c=0
Rk6 (\8\:E \9\:E) resistor r=0.7111 c=0
Rk2 (\4\:Db \6\:Db) resistor r=0.7537 c=0
Rk3 (\6\:Db \8\:Db) resistor r=0.8054 c=0
Rk7 (\4\:Eb \6\:Eb) resistor r=1.037 c=0
Rk8 (\6\:Eb \8\:Eb) resistor r=0.342 c=0
Rk14 (\4\:Dp \6\:Dp) resistor r=0.6651 c=0
Rk15 (\6\:Dp \7\:Dp) resistor r=0.4335 c=0
Rk16 (\7\:Dp \8\:Dp) resistor r=0.4498 c=0
Rk17 (\8\:Dp \10\:Dp) resistor r=0.09733 c=0
Rk18 (\7\:Dp \12\:Dp) resistor r=0.2091 c=0
Rk19 (\8\:Dp \14\:Dp) resistor r=0.249 c=0
Rk51 (\23\:qbint \24\:qbint) resistor r=1.7888 c=0
Rk52 (\24\:qbint \25\:qbint) resistor r=1.0893 c=0
Rk53 (\24\:qbint \27\:qbint) resistor r=0.05684 c=0
Rk54 (\27\:qbint \28\:qbint) resistor r=0.3137 c=0
Rk55 (\28\:qbint \30\:qbint) resistor r=0.1511 c=0
Rk56 (\25\:qbint \31\:qbint) resistor r=1.7824 c=0
Rk57 (\28\:qbint \32\:qbint) resistor r=0.1983 c=0
Rk11 (\5\:RNb \6\:RNb) resistor r=0.3873 c=0
Rk12 (\6\:RNb \7\:RNb) resistor r=0.03421 c=0
Rk13 (\6\:RNb \9\:RNb) resistor r=0.1231 c=0
Rk21 (\5\:n20 \7\:n20) resistor r=0.4259 c=0
Rk22 (\7\:n20 \8\:n20) resistor r=0.6927 c=0
Rk29 (\13\:CKb \15\:CKb) resistor r=0.839 c=0
Rk30 (\15\:CKb \16\:CKb) resistor r=0.5402 c=0
Rk31 (\16\:CKb \17\:CKb) resistor r=0.7864 c=0
Rk32 (\17\:CKb \18\:CKb) resistor r=0.08968 c=0
Rk33 (\17\:CKb \19\:CKb) resistor r=0.1764 c=0
Rk34 (\19\:CKb \20\:CKb) resistor r=0.7273 c=0
Rk35 (\20\:CKb \21\:CKb) resistor r=0.1849 c=0
Rk36 (\19\:CKb \22\:CKb) resistor r=0.3637 c=0
Rk37 (\20\:CKb \23\:CKb) resistor r=0.2555 c=0
Rk26 (\7\:CKbb \8\:CKbb) resistor r=0.2466 c=0
Rk27 (\8\:CKbb \9\:CKbb) resistor r=0.3602 c=0
Rk28 (\8\:CKbb \11\:CKbb) resistor r=0.1695 c=0
Rk23 (\5\:mout \6\:mout) resistor r=0.07763 c=0
Rk24 (\6\:mout \7\:mout) resistor r=0.2448 c=0
Rk25 (\6\:mout \9\:mout) resistor r=0.2879 c=0
Rk39 (\7\:n30 \9\:n30) resistor r=1.5052 c=0
Rk40 (\9\:n30 \11\:n30) resistor r=0.3575 c=0
Rk58 (\17\:qint \18\:qint) resistor r=0.4787 c=0
Rk59 (\18\:qint \19\:qint) resistor r=0.2487 c=0
Rk60 (\18\:qint \21\:qint) resistor r=0.03792 c=0
Rk9 (\2\:n3 \4\:n3) resistor r=0.5224 c=0
Rk10 (\2\:n2 \4\:n2) resistor r=0.3324 c=0
Rl1 (\1\:D \2\:D) resistor r=31.461 c=0
Rl2 (\2\:D \3\:D) resistor r=64.1533 c=0
Rl35 (\1\:CK \2\:CK) resistor r=81.461 c=0
Rl36 (\2\:CK \3\:CK) resistor r=39.1533 c=0
Rl15 (\1\:RN \2\:RN) resistor r=45.3867 c=0
Rl16 (\2\:RN \3\:RN) resistor r=102.463 c=0
Rl7 (\4\:E \5\:E) resistor r=103.4 c=0
Rl8 (\5\:E \6\:E) resistor r=91.1062 c=0
Rl3 (\1\:E \2\:E) resistor r=35.3066 c=0
Rl4 (\2\:E \3\:E) resistor r=61.3335 c=0
Rl5 (Db \2\:Db) resistor r=123.889 c=0
Rl6 (\2\:Db \3\:Db) resistor r=64.1533 c=0
Rl9 (Eb \2\:Eb) resistor r=145.72 c=0
Rl10 (\2\:Eb \3\:Eb) resistor r=24.2328 c=0
Rl17 (Dp \2\:Dp) resistor r=132.539 c=0
Rl18 (\2\:Dp \3\:Dp) resistor r=29.5379 c=0
Rl32 (\6\:qbint \5\:qbint) resistor r=145.72 c=0
Rl12 (\3\:qbint \2\:qbint) resistor r=166.439 c=0
Rl68 (\21\:qbint \20\:qbint) resistor r=65.3618 c=0
Rl69 (\21\:qbint \22\:qbint) resistor r=63.2566 c=0
Rl31 (\4\:qbint \5\:qbint) resistor r=58.3841 c=0
Rl11 (qbint \2\:qbint) resistor r=31.0981 c=0
Rl13 (RNb \2\:RNb) resistor r=68.4636 c=0
Rl14 (\2\:RNb \3\:RNb) resistor r=97.631 c=0
Rl23 (n20 \2\:n20) resistor r=76.9231 c=0
Rl24 (\2\:n20 \3\:n20) resistor r=29.9451 c=0
Rl33 (\9\:CKb \10\:CKb) resistor r=130.769 c=0
Rl34 (\10\:CKb \11\:CKb) resistor r=29.5379 c=0
Rl26 (\7\:CKb \8\:CKb) resistor r=94.9225 c=0
Rl25 (\5\:CKb \6\:CKb) resistor r=28.079 c=0
Rl20 (\3\:CKb \4\:CKb) resistor r=54.5567 c=0
Rl19 (CKb \2\:CKb) resistor r=64.0094 c=0
Rl30 (\4\:CKbb \5\:CKbb) resistor r=186.104 c=0
Rl29 (\3\:CKbb \4\:CKbb) resistor r=447.643 c=0
Rl27 (CKbb \2\:CKbb) resistor r=24.2328 c=0
Rl28 (\2\:CKbb \3\:CKbb) resistor r=195.274 c=0
Rl21 (mout \2\:mout) resistor r=24.2328 c=0
Rl22 (\2\:mout \3\:mout) resistor r=93.0293 c=0
Rz27 (\31\:VSS \30\:VSS) resistor r=75 c=0
Rz28 (\33\:VSS \32\:VSS) resistor r=75 c=0
Rz29 (\35\:VSS \34\:VSS) resistor r=75 c=0
Rz30 (\37\:VSS \36\:VSS) resistor r=75 c=0
Rz31 (\39\:VSS \38\:VSS) resistor r=75 c=0
Rz32 (\41\:VSS \40\:VSS) resistor r=75 c=0
Rz33 (\43\:VSS \42\:VSS) resistor r=75 c=0
Rz20 (\1\:VDD \6\:VDD) resistor r=4.1667 c=0
Rz17 (\7\:VDD \6\:VDD) resistor r=6.25 c=0
Rz18 (\10\:VDD \6\:VDD) resistor r=6.25 c=0
Rz1 (\7\:Db \8\:Db) resistor r=75 c=0
Rz2 (\5\:Eb \6\:Eb) resistor r=75 c=0
Rz4 (\5\:Dp \6\:Dp) resistor r=75 c=0
Rz5 (\9\:Dp \10\:Dp) resistor r=75 c=0
Rz15 (\30\:qbint \29\:qbint) resistor r=75 c=0
Rz3 (\8\:RNb \9\:RNb) resistor r=75 c=0
Rz6 (\4\:n20 \5\:n20) resistor r=75 c=0
Rz9 (\14\:CKb \15\:CKb) resistor r=75 c=0
Rz8 (\6\:CKbb \7\:CKbb) resistor r=75 c=0
Rz7 (\8\:mout \9\:mout) resistor r=75 c=0
Rz10 (\11\:n30 \10\:n30) resistor r=75 c=0
Rz16 (\21\:qint \20\:qint) resistor r=75 c=0
Ry33 (\1\:VSS \3\:VSS) resistor r=3.4444 c=0
Ry34 (\13\:VSS \3\:VSS) resistor r=5.1667 c=0
Ry35 (\18\:VSS \3\:VSS) resistor r=5.1667 c=0
Ry23 (\17\:VDD \16\:VDD) resistor r=62 c=0
Ry24 (\19\:VDD \18\:VDD) resistor r=62 c=0
Ry25 (\21\:VDD \20\:VDD) resistor r=62 c=0
Ry26 (\23\:VDD \22\:VDD) resistor r=62 c=0
Ry27 (\25\:VDD \24\:VDD) resistor r=62 c=0
Ry1 (\5\:Db \6\:Db) resistor r=62 c=0
Ry2 (\7\:Eb \8\:Eb) resistor r=62 c=0
Ry8 (\11\:Dp \12\:Dp) resistor r=62 c=0
Ry9 (\13\:Dp \14\:Dp) resistor r=62 c=0
Ry19 (\27\:qbint \26\:qbint) resistor r=31 c=0
Ry7 (\4\:RNb \5\:RNb) resistor r=62 c=0
Ry10 (\6\:n20 \7\:n20) resistor r=62 c=0
Ry13 (\12\:CKb \13\:CKb) resistor r=62 c=0
Ry12 (\10\:CKbb \11\:CKbb) resistor r=62 c=0
Ry11 (\4\:mout \5\:mout) resistor r=62 c=0
Ry14 (\9\:n30 \8\:n30) resistor r=62 c=0
Ry20 (\17\:qint \16\:qint) resistor r=20.6667 c=0
Ry3 (n3 \2\:n3) resistor r=62 c=0
Ry4 (\3\:n3 \4\:n3) resistor r=62 c=0
Ry5 (n2 \2\:n2) resistor r=62 c=0
Ry6 (\3\:n2 \4\:n2) resistor r=62 c=0
Rx1 (\2\:D \4\:D) resistor r=45 c=0
Rx17 (\2\:CK \4\:CK) resistor r=45 c=0
Rx8 (\2\:RN \4\:RN) resistor r=45 c=0
Rx3 (\2\:E \7\:E) resistor r=45 c=0
Rx4 (\5\:E \9\:E) resistor r=45 c=0
Rx2 (\3\:Db \4\:Db) resistor r=45 c=0
Rx5 (\3\:Eb \4\:Eb) resistor r=45 c=0
Rx7 (\3\:Dp \4\:Dp) resistor r=45 c=0
Rx19 (\23\:qbint \21\:qbint) resistor r=45 c=0
Rx20 (\25\:qbint \4\:qbint) resistor r=45 c=0
Rx21 (\31\:qbint qbint) resistor r=45 c=0
Rx22 (\32\:qbint \7\:qbint) resistor r=45 c=0
Rx6 (\2\:RNb \7\:RNb) resistor r=45 c=0
Rx9 (\2\:n20 \8\:n20) resistor r=45 c=0
Rx12 (\11\:CKb \16\:CKb) resistor r=45 c=0
Rx13 (\8\:CKb \18\:CKb) resistor r=45 c=0
Rx14 (CKb \21\:CKb) resistor r=45 c=0
Rx15 (\6\:CKb \22\:CKb) resistor r=45 c=0
Rx16 (\4\:CKb \23\:CKb) resistor r=45 c=0
Rx11 (\2\:CKbb \9\:CKbb) resistor r=45 c=0
Rx10 (\2\:mout \7\:mout) resistor r=45 c=0
Rx18 (\7\:n30 n30) resistor r=45 c=0
Rx23 (\19\:qint qint) resistor r=45 c=0
mn1 (\7\:Db \3\:D \42\:VSS VSS) g45n1hvt w=(1.45e-07) l=4.5e-08 nf=1 \
        as=2.32e-14 ad=2.03e-14 ps=6.1e-07 pd=5.7e-07 nrd=1.16667 \
        nrs=1.16667 sa=1.4e-07 sb=3.45e-07 sd=160n sca=23.279 \
        scb=0.0230742 scc=0.00267719 m=(1)
mn0 (\5\:Eb \3\:E \42\:VSS VSS) g45n1hvt w=(1.45e-07) l=4.5e-08 nf=1 \
        as=2.32e-14 ad=2.03e-14 ps=6.1e-07 pd=5.7e-07 nrd=1.16667 \
        nrs=1.16667 sa=3.45e-07 sb=1.4e-07 sd=160n sca=23.279 \
        scb=0.0230742 scc=0.00267719 m=(1)
mn7 (\9\:Dp Db n1 VSS) g45n1hvt w=(1.45e-07) l=4.5e-08 nf=1 as=8.7e-15 \
        ad=2.61e-14 ps=4.1e-07 pd=6.5e-07 nrd=1.16667 nrs=1.16667 \
        sa=1.8e-07 sb=2.75e-07 sd=160n sca=23.279 scb=0.0230742 \
        scc=0.00267719 m=(1)
mn6 (n1 \6\:E \40\:VSS VSS) g45n1hvt w=(1.45e-07) l=4.5e-08 nf=1 \
        as=4.445e-14 ad=8.7e-15 ps=9.6e-07 pd=4.1e-07 nrd=1.16667 \
        nrs=1.16667 sa=2.85e-07 sb=1.7e-07 sd=160n sca=23.279 \
        scb=0.0230742 scc=0.00267719 m=(1)
mn4 (n0 \2\:Eb \38\:VSS VSS) g45n1hvt w=(1.45e-07) l=4.5e-08 nf=1 \
        as=6.137e-14 ad=8.7e-15 ps=1.19e-06 pd=4.1e-07 nrd=1.16667 \
        nrs=1.16667 sa=2.95e-07 sb=4.1e-07 sd=160n sca=21.4614 \
        scb=0.0218523 scc=0.00230065 m=(1)
mn5 (\5\:Dp \3\:qbint n0 VSS) g45n1hvt w=(1.45e-07) l=4.5e-08 nf=1 \
        as=8.7e-15 ad=2.32e-14 ps=4.1e-07 pd=6.1e-07 nrd=1.16667 \
        nrs=1.16667 sa=4e-07 sb=3.05e-07 sd=160n sca=21.4614 scb=0.0218523 \
        scc=0.00230065 m=(1)
mn3 (\5\:Dp \3\:RNb \36\:VSS VSS) g45n1hvt w=(1.45e-07) l=4.5e-08 nf=1 \
        as=4.415e-14 ad=2.32e-14 ps=1.48e-06 pd=6.1e-07 nrd=1.16667 \
        nrs=1.16667 sa=6.05e-07 sb=1e-07 sd=160n sca=21.4614 scb=0.0218523 \
        scc=0.00230065 m=(1)
mn2 (\8\:RNb \3\:RN \34\:VSS VSS) g45n1hvt w=(1.45e-07) l=4.5e-08 nf=1 \
        as=1.0078e-13 ad=2.03e-14 ps=1.83e-06 pd=5.7e-07 nrd=1.16667 \
        nrs=1.16667 sa=1.4e-07 sb=2e-06 sd=160n sca=23.279 scb=0.0230742 \
        scc=0.00267719 m=(1)
mn25 (n21 \2\:Dp \34\:VSS VSS) g45n1hvt w=(1.45e-07) l=4.5e-08 nf=1 \
        as=1.0078e-13 ad=8.7e-15 ps=1.83e-06 pd=4.1e-07 nrd=1.16667 \
        nrs=1.16667 sa=5.2e-07 sb=2e-06 sd=160n sca=23.279 scb=0.0230742 \
        scc=0.00267719 m=(1)
mn26 (\4\:n20 \2\:CKb n21 VSS) g45n1hvt w=(1.45e-07) l=4.5e-08 nf=1 \
        as=8.7e-15 ad=4.277e-14 ps=4.1e-07 pd=8.8e-07 nrd=1.16667 \
        nrs=1.16667 sa=6.25e-07 sb=2e-06 sd=160n sca=23.279 scb=0.0230742 \
        scc=0.00267719 m=(1)
mn36 (\4\:n20 \4\:CKbb net516 VSS) g45n1hvt w=(1.45e-07) l=4.5e-08 nf=1 \
        as=1.812e-14 ad=4.277e-14 ps=5.4e-07 pd=8.8e-07 nrd=1.16667 \
        nrs=1.16667 sa=9.65e-07 sb=1.71e-06 sd=160n sca=23.279 \
        scb=0.0230742 scc=0.00267719 m=(1)
mn35 (net516 \3\:mout \32\:VSS VSS) g45n1hvt w=(1.45e-07) l=4.5e-08 nf=1 \
        as=5.485e-14 ad=1.812e-14 ps=1.1e-06 pd=5.4e-07 nrd=1.16667 \
        nrs=1.16667 sa=1.135e-06 sb=1.54e-06 sd=160n sca=23.279 \
        scb=0.0230742 scc=0.00267719 m=(1)
mn30 (\8\:mout \3\:n20 \32\:VSS VSS) g45n1hvt w=(1.45e-07) l=4.5e-08 \
        nf=1 as=5.485e-14 ad=3.552e-14 ps=1.1e-06 pd=7.8e-07 nrd=1.16667 \
        nrs=1.16667 sa=1.43e-06 sb=1.245e-06 sd=160n sca=23.279 \
        scb=0.0230742 scc=0.00267719 m=(1)
mn40 (\10\:n30 \3\:CKbb \8\:mout VSS) g45n1hvt w=(1.45e-07) l=4.5e-08 \
        nf=1 as=3.552e-14 ad=4.567e-14 ps=7.8e-07 pd=9.2e-07 nrd=1.16667 \
        nrs=1.16667 sa=1.72e-06 sb=9.55e-07 sd=160n sca=23.279 \
        scb=0.0230742 scc=0.00267719 m=(1)
mn51 (\10\:n30 \7\:CKb net496 VSS) g45n1hvt w=(1.45e-07) l=4.5e-08 nf=1 \
        as=8.7e-15 ad=4.567e-14 ps=4.1e-07 pd=9.2e-07 nrd=1.16667 \
        nrs=1.16667 sa=2e-06 sb=5.95e-07 sd=160n sca=23.279 scb=0.0230742 \
        scc=0.00267719 m=(1)
mn50 (net496 \6\:qbint \30\:VSS VSS) g45n1hvt w=(1.45e-07) l=4.5e-08 \
        nf=1 as=3.552e-14 ad=8.7e-15 ps=7.8e-07 pd=4.1e-07 nrd=1.16667 \
        nrs=1.16667 sa=2e-06 sb=4.9e-07 sd=160n sca=23.279 scb=0.0230742 \
        scc=0.00267719 m=(1)
mn21 (\6\:CKbb \10\:CKb \30\:VSS VSS) g45n1hvt w=(1.45e-07) l=4.5e-08 \
        nf=1 as=3.552e-14 ad=2.9e-14 ps=7.8e-07 pd=6.9e-07 nrd=1.16667 \
        nrs=1.16667 sa=2e-06 sb=2e-07 sd=160n sca=23.279 scb=0.0230742 \
        scc=0.00267719 m=(1)
mn20 (\14\:CKb \3\:CK \1\:VSS VSS) g45n1hvt w=(1.45e-07) l=4.5e-08 nf=1 \
        as=3.812e-14 ad=2.03e-14 ps=8.2e-07 pd=5.7e-07 nrd=1.16667 \
        nrs=1.16667 sa=1.4e-07 sb=2e-06 sd=160n sca=11.9911 scb=0.0120555 \
        scc=0.000498628 m=(1)
mn45_1__rcx (\29\:qbint n30 \1\:VSS VSS) g45n1hvt w=(2.05e-07) l=4.5e-08 \
        nf=1 as=4.444e-14 ad=3.895e-14 ps=8.8e-07 pd=7.9e-07 nrd=1.16667 \
        nrs=1.16667 sa=3.16829e-07 sb=2e-06 sd=160n sca=10.7727 \
        scb=0.0101457 scc=0.000373012 m=(2)
mn56 (\20\:qint \22\:qbint \1\:VSS VSS) g45n1hvt w=(2.6e-07) l=4.5e-08 \
        nf=1 as=4.16e-14 ad=3.64e-14 ps=8.4e-07 pd=8e-07 nrd=1.16667 \
        nrs=1.16667 sa=1.95452e-06 sb=1.4e-07 sd=160n sca=9.89531 \
        scb=0.00874901 scc=0.000299334 m=(1)
mn55_1__rcx (\1\:Q \7\:qbint \1\:VSS VSS) g45n1hvt w=(2.6e-07) l=4.5e-08 \
        nf=1 as=4.389e-14 ad=4.16e-14 ps=8.65e-07 pd=8.4e-07 nrd=1.16667 \
        nrs=1.16667 sa=6.65769e-07 sb=1.785e-06 sd=160n sca=9.89531 \
        scb=0.00874901 scc=0.000299334 m=(4)
mn57_1__rcx (\5\:QN qint \1\:VSS VSS) g45n1hvt w=(2.6e-07) l=4.5e-08 \
        nf=1 as=4.16e-14 ad=4.225e-14 ps=8.4e-07 pd=8.45e-07 nrd=1.16667 \
        nrs=1.16667 sa=1.48577e-06 sb=9.65e-07 sd=160n sca=9.89531 \
        scb=0.00874901 scc=0.000299334 m=(4)
mp45 (\26\:qbint n30 \1\:VDD VDD) g45p1hvt w=(3.1e-07) l=4.5e-08 nf=1 \
        as=7.948e-14 ad=4.96e-14 ps=1.61e-06 pd=9.4e-07 nrd=1.16667 \
        nrs=1.16667 sa=2.62984e-07 sb=2e-06 sd=160n sca=35.6995 \
        scb=0.0234062 scc=0.00420468 m=(2)
mp56 (\16\:qint \20\:qbint \1\:VDD VDD) g45p1hvt w=(3.9e-07) l=4.5e-08 \
        nf=1 as=9.18e-14 ad=5.46e-14 ps=1.32e-06 pd=1.06e-06 nrd=1.16667 \
        nrs=1.16667 sa=2e-06 sb=1.4e-07 sd=160n sca=44.1638 scb=0.0392167 \
        scc=0.00476734 m=(1)
mp55_1__rcx (\4\:Q \7\:qbint \1\:VDD VDD) g45p1hvt w=(3.9e-07) l=4.5e-08 \
        nf=1 as=9.08e-14 ad=6.24e-14 ps=1.32e-06 pd=1.1e-06 nrd=1.16667 \
        nrs=1.16667 sa=6.175e-07 sb=2e-06 sd=160n sca=30.5009 \
        scb=0.0202006 scc=0.00336097 m=(4)
mp57_1__rcx (\1\:QN qint \1\:VDD VDD) g45p1hvt w=(3.9e-07) l=4.5e-08 \
        nf=1 as=9.18e-14 ad=6.24e-14 ps=1.32e-06 pd=1.1e-06 nrd=1.16667 \
        nrs=1.16667 sa=1.5575e-06 sb=1.08e-06 sd=160n sca=30.5009 \
        scb=0.0202006 scc=0.00336097 m=(4)
ends EDFFTRX4
// End of subcircuit definition.
