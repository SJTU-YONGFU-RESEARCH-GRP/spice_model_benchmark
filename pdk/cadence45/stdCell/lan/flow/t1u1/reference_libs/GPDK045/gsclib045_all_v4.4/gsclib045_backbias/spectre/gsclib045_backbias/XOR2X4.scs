// gsclib045_backbias/XOR2X4/schematic

simulator lang=spectre

subckt XOR2X4 A B Y VDD VSS NW
mn1 (n2 B VSS VSS) g45n1svt w=(145n) l=45n nf=1 m=(1)
mn0 (n1 A VSS VSS) g45n1svt w=(145n) l=45n nf=1 m=(1)
mn5 (Y n0 VSS VSS) g45n1svt w=(1.04u) l=45n nf=1 m=(1)
mn3 (n0 B net131 VSS) g45n1svt w=(260n) l=45n nf=1 m=(1)
mn4 (n0 n2 n1 VSS) g45n1svt w=(260n) l=45n nf=1 m=(1)
mn2 (net131 n1 VSS VSS) g45n1svt w=(260n) l=45n nf=1 m=(1)
mp3 (n0 n2 net130 NW) g45p1svt w=(390n) l=45n nf=1 m=(1)
mp1 (n2 B VDD NW) g45p1svt w=(215n) l=45n nf=1 m=(1)
mp4 (n1 B n0 NW) g45p1svt w=(390n) l=45n nf=1 m=(1)
mp0 (n1 A VDD NW) g45p1svt w=(215n) l=45n nf=1 m=(1)
mp5 (Y n0 VDD NW) g45p1svt w=(1.56u) l=45n nf=1 m=(1)
mp2 (net130 n1 VDD NW) g45p1svt w=(390n) l=45n nf=1 m=(1)
ends XOR2X4
