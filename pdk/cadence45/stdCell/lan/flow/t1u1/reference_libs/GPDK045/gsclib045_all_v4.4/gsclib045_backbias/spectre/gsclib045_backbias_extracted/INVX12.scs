// Generated for: spectre (May  1 11:29:35 2013 )
// Library name: gsclib045_backbias
// Cell name: INVX12
// View name: extracted

simulator lang=spectre

subckt INVX12 A NW VDD VSS Y
mp0 (\1\:Y \1\:A VDD NW) g45p1svt w=(4.7e-07) l=4.5e-08 nf=1 \
        as=7.332e-14 ad=7.52e-14 ps=1.252e-06 pd=1.26e-06 nrd=1.16667 \
        nrs=1.16667 sa=1.4e-07 sb=1.985e-06 sd=160n sca=40.6416 \
        scb=0.0369115 scc=0.00420297 m=(10)
C1 (A VSS) capacitor c=2.14951e-17
C2 (VDD VSS) capacitor c=6.56268e-16
C3 (NW VSS) capacitor c=2.69734e-16
C4 (Y VSS) capacitor c=3.05473e-17
C5 (\1\:A VSS) capacitor c=8.53899e-16
C6 (\16\:A VSS) capacitor c=2.26462e-17
C7 (\1\:Y VSS) capacitor c=6.37263e-16
C8 (\40\:A VSS) capacitor c=4.39399e-17
C9 (\4\:Y VSS) capacitor c=1.18726e-17
C10 (\5\:Y VSS) capacitor c=5.02575e-16
Rk5 (\40\:A A) resistor r=0.01622 c=0
Rk4 (\1\:A \40\:A) resistor r=0.2896 c=0
Rk17 (\4\:Y Y) resistor r=0.112 c=0
Rk7 (\1\:Y \4\:Y) resistor r=0.1589 c=0
Rk8 (\4\:Y \5\:Y) resistor r=0.07485 c=0
Rl15 (\1\:A \16\:A) resistor r=3.1164 c=0
Rx5 (\40\:A \16\:A) resistor r=45 c=0
mn0 (\5\:Y \1\:A VSS VSS) g45n1svt w=(3.1e-07) l=4.5e-08 nf=1 \
        as=4.836e-14 ad=4.96e-14 ps=9.32e-07 pd=9.4e-07 nrd=1.16667 \
        nrs=1.16667 sa=1.4e-07 sb=1.985e-06 sd=160n sca=15.9751 \
        scb=0.0153507 scc=0.00137372 m=(10)
ends INVX12
// End of subcircuit definition.
