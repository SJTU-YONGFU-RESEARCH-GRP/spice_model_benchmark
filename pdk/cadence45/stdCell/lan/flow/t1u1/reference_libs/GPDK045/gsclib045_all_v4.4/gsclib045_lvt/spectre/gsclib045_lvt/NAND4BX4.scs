// gsclib045_lvt/NAND4BX4/schematic

simulator lang=spectre

subckt NAND4BX4 AN B C D Y VSS VDD
mp4 (Y D VDD VDD) g45p1lvt w=(1.56u) l=45n nf=1 m=(1)
mp1 (Y net118 VDD VDD) g45p1lvt w=(1.56u) l=45n nf=1 m=(1)
mp2 (Y B VDD VDD) g45p1lvt w=(1.56u) l=45n nf=1 m=(1)
mp0 (net118 AN VDD VDD) g45p1lvt w=(390n) l=45n nf=1 m=(1)
mp3 (Y C VDD VDD) g45p1lvt w=(1.56u) l=45n nf=1 m=(1)
mn4 (Y D net130 VSS) g45n1lvt w=(1.04u) l=45n nf=1 m=(1)
mn2 (net126 B net122 VSS) g45n1lvt w=(1.04u) l=45n nf=1 m=(1)
mn1 (net122 net118 VSS VSS) g45n1lvt w=(1.04u) l=45n nf=1 m=(1)
mn0 (net118 AN VSS VSS) g45n1lvt w=(260n) l=45n nf=1 m=(1)
mn3 (net130 C net126 VSS) g45n1lvt w=(1.04u) l=45n nf=1 m=(1)
ends NAND4BX4
