// gsclib045_hvt/TBUFX16/schematic

simulator lang=spectre

subckt TBUFX16 A OE Y VDD VSS
mp2 (non OEb net127 VDD) g45p1hvt w=(1.55u) l=45n nf=1 m=(1)
mp1 (net127 A VDD VDD) g45p1hvt w=(1.55u) l=45n nf=1 m=(1)
mp5 (Y pon VDD VDD) g45p1hvt w=(6.24u) l=45n nf=1 m=(1)
mp3 (pon A VDD VDD) g45p1hvt w=(1.55u) l=45n nf=1 m=(1)
mp4 (pon OE VDD VDD) g45p1hvt w=(1.55u) l=45n nf=1 m=(1)
mp0 (OEb OE VDD VDD) g45p1hvt w=(390n) l=45n nf=1 m=(1)
mn5 (Y non VSS VSS) g45n1hvt w=(4.16u) l=45n nf=1 m=(1)
mn3 (net144 A VSS VSS) g45n1hvt w=(1.025u) l=45n nf=1 m=(1)
mn0 (OEb OE VSS VSS) g45n1hvt w=(260n) l=45n nf=1 m=(1)
mn4 (pon OE net144 VSS) g45n1hvt w=(1.025u) l=45n nf=1 m=(1)
mn2 (non OEb VSS VSS) g45n1hvt w=(1.025u) l=45n nf=1 m=(1)
mn1 (non A VSS VSS) g45n1hvt w=(1.025u) l=45n nf=1 m=(1)
ends TBUFX16
