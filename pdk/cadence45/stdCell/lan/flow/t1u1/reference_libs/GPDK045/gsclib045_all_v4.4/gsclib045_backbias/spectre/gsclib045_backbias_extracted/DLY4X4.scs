// Generated for: spectre (May  1 11:29:22 2013 )
// Library name: gsclib045_backbias
// Cell name: DLY4X4
// View name: extracted

simulator lang=spectre

subckt DLY4X4 A NW VDD VSS Y
mp15 (\18\:net333 \3\:net345 \25\:VDD NW) g45p1svt w=(3.9e-07) l=4.5e-08 \
        nf=1 as=9.18e-14 ad=5.46e-14 ps=1.32e-06 pd=1.06e-06 nrd=1.16667 \
        nrs=1.16667 sa=1.4e-07 sb=1.37481e-06 sd=160n sca=40.9076 \
        scb=0.0353918 scc=0.00415366 m=(1)
mp16 (Y net333 \25\:VDD NW) g45p1svt w=(3.9e-07) l=4.5e-08 nf=1 \
        as=9.078e-14 ad=6.728e-14 ps=1.3375e-06 pd=1.125e-06 nrd=1.16667 \
        nrs=1.16667 sa=4.05e-07 sb=1.10981e-06 sd=160n sca=32.7095 \
        scb=0.022203 scc=0.00336849 m=(4)
C1 (NW VSS) capacitor c=7.80886e-16
C2 (Y VSS) capacitor c=1.8102e-16
C3 (VDD VSS) capacitor c=3.66723e-17
C4 (A VSS) capacitor c=5.34184e-17
C5 (net345 VSS) capacitor c=3.72745e-17
C6 (net333 VSS) capacitor c=2.76534e-16
C7 (net341 VSS) capacitor c=1.63061e-18
C8 (net353 VSS) capacitor c=3.39164e-17
C9 (net349 VSS) capacitor c=7.21012e-19
C10 (net361 VSS) capacitor c=1.04931e-16
C11 (net357 VSS) capacitor c=1.7865e-18
C12 (net369 VSS) capacitor c=6.15605e-17
C13 (net365 VSS) capacitor c=1.51928e-18
C14 (net377 VSS) capacitor c=5.49572e-17
C15 (net385 VSS) capacitor c=3.03357e-17
C16 (net393 VSS) capacitor c=7.64964e-17
C17 (net389 VSS) capacitor c=1.51142e-18
C18 (net397 VSS) capacitor c=2.9114e-17
C19 (net276 VSS) capacitor c=1.81242e-18
C20 (net284 VSS) capacitor c=1.38779e-18
C21 (net300 VSS) capacitor c=2.11386e-18
C22 (net292 VSS) capacitor c=2.32516e-18
C23 (net308 VSS) capacitor c=2.74416e-18
C24 (\1\:A VSS) capacitor c=2.52785e-17
C25 (\3\:net397 VSS) capacitor c=7.07782e-17
C26 (\2\:net377 VSS) capacitor c=6.57527e-17
C27 (\2\:net353 VSS) capacitor c=5.42966e-17
C28 (\3\:net345 VSS) capacitor c=4.37248e-17
C29 (\3\:A VSS) capacitor c=4.04423e-17
C30 (\12\:VDD VSS) capacitor c=5.30134e-17
C31 (\15\:VDD VSS) capacitor c=3.27191e-17
C32 (\2\:net393 VSS) capacitor c=5.04401e-17
C33 (\3\:net385 VSS) capacitor c=5.59653e-17
C34 (\10\:VDD VSS) capacitor c=4.97458e-17
C35 (\9\:VDD VSS) capacitor c=4.8575e-17
C36 (\3\:net377 VSS) capacitor c=3.56305e-17
C37 (\5\:net369 VSS) capacitor c=3.04624e-17
C38 (\3\:VDD VSS) capacitor c=3.21384e-17
C39 (\8\:VDD VSS) capacitor c=5.56835e-17
C40 (\2\:net361 VSS) capacitor c=1.25085e-16
C41 (\1\:VDD VSS) capacitor c=5.4745e-17
C42 (\3\:net353 VSS) capacitor c=5.96793e-17
C43 (\2\:A VSS) capacitor c=3.99632e-17
C44 (\2\:net397 VSS) capacitor c=4.61732e-17
C45 (\14\:VDD VSS) capacitor c=6.51823e-17
C46 (\3\:net393 VSS) capacitor c=3.55978e-17
C47 (\2\:net385 VSS) capacitor c=4.29577e-17
C48 (\11\:VDD VSS) capacitor c=3.21943e-17
C49 (\2\:net369 VSS) capacitor c=6.86908e-17
C50 (\4\:net377 VSS) capacitor c=3.28363e-17
C51 (\4\:net369 VSS) capacitor c=2.85708e-17
C52 (\4\:net361 VSS) capacitor c=3.60267e-17
C53 (\7\:VDD VSS) capacitor c=2.50893e-17
C54 (\3\:net361 VSS) capacitor c=4.25941e-17
C55 (\6\:VDD VSS) capacitor c=4.66952e-17
C56 (\2\:VDD VSS) capacitor c=3.86708e-17
C57 (\2\:net345 VSS) capacitor c=4.60749e-17
C58 (\4\:net397 VSS) capacitor c=3.96184e-17
C59 (\18\:VDD VSS) capacitor c=1.09316e-16
C60 (\7\:net393 VSS) capacitor c=7.12302e-17
C61 (\8\:net385 VSS) capacitor c=1.90426e-17
C62 (\28\:VDD VSS) capacitor c=3.19343e-17
C63 (\5\:net377 VSS) capacitor c=2.73352e-17
C64 (\8\:net361 VSS) capacitor c=1.8484e-16
C65 (\32\:VDD VSS) capacitor c=2.00897e-17
C66 (\6\:net369 VSS) capacitor c=4.63575e-17
C67 (\6\:net353 VSS) capacitor c=1.47005e-16
C68 (\35\:VDD VSS) capacitor c=2.39439e-17
C69 (\6\:net345 VSS) capacitor c=1.77254e-16
C70 (\18\:net333 VSS) capacitor c=5.05922e-17
C71 (\8\:net397 VSS) capacitor c=1.96095e-17
C72 (\5\:net393 VSS) capacitor c=1.06268e-16
C73 (\4\:net385 VSS) capacitor c=5.44833e-17
C74 (\9\:net377 VSS) capacitor c=9.68706e-17
C75 (\9\:net369 VSS) capacitor c=1.02783e-16
C76 (\5\:net361 VSS) capacitor c=5.38217e-17
C77 (\4\:net353 VSS) capacitor c=1.20713e-16
C78 (\4\:net345 VSS) capacitor c=7.00664e-17
C79 (\16\:net333 VSS) capacitor c=5.27077e-17
C80 (\4\:VDD VSS) capacitor c=3.20354e-17
C81 (\5\:VDD VSS) capacitor c=2.29242e-17
C82 (\3\:net369 VSS) capacitor c=4.27329e-17
C83 (\15\:net333 VSS) capacitor c=6.53176e-17
C84 (\8\:net345 VSS) capacitor c=1.55252e-16
C85 (\16\:VDD VSS) capacitor c=4.313e-17
C86 (\17\:VDD VSS) capacitor c=6.34297e-17
C87 (\8\:net353 VSS) capacitor c=5.93104e-17
C88 (\7\:net361 VSS) capacitor c=5.7521e-17
C89 (\8\:net369 VSS) capacitor c=7.17707e-17
C90 (\10\:net361 VSS) capacitor c=1.97815e-16
C91 (\11\:net369 VSS) capacitor c=1.10956e-16
C92 (\7\:net377 VSS) capacitor c=9.79847e-17
C93 (\8\:net377 VSS) capacitor c=1.80301e-16
C94 (\11\:net377 VSS) capacitor c=1.178e-16
C95 (\6\:net385 VSS) capacitor c=6.63164e-17
C96 (\7\:net385 VSS) capacitor c=6.09835e-17
C97 (\4\:net393 VSS) capacitor c=5.58303e-17
C98 (\4\:A VSS) capacitor c=4.5774e-17
C99 (\6\:net397 VSS) capacitor c=3.79822e-17
C100 (\7\:net397 VSS) capacitor c=4.22337e-17
C101 (\20\:VDD VSS) capacitor c=6.8076e-17
C102 (\21\:VDD VSS) capacitor c=7.5234e-17
C103 (\22\:VDD VSS) capacitor c=8.53112e-17
C104 (\23\:VDD VSS) capacitor c=7.43816e-17
C105 (\24\:VDD VSS) capacitor c=6.84884e-17
C106 (\25\:VDD VSS) capacitor c=2.41624e-16
C107 (\30\:VDD VSS) capacitor c=1.1753e-16
C108 (\31\:VDD VSS) capacitor c=6.6541e-17
C109 (\34\:VDD VSS) capacitor c=5.37467e-17
Rk11 (\16\:VDD \17\:VDD) resistor r=0.2376 c=0
Rk31 (\19\:VDD \20\:VDD) resistor r=0.6254 c=0
Rk32 (\20\:VDD \21\:VDD) resistor r=0.1124 c=0
Rk33 (\21\:VDD \22\:VDD) resistor r=0.5159 c=0
Rk34 (\22\:VDD \23\:VDD) resistor r=0.3956 c=0
Rk35 (\23\:VDD \24\:VDD) resistor r=0.4081 c=0
Rk39 (\25\:VDD VDD) resistor r=0.1198 c=0
Rk36 (\24\:VDD \25\:VDD) resistor r=0.2853 c=0
Rk40 (\20\:VDD \29\:VDD) resistor r=0.4415 c=0
Rk41 (\21\:VDD \30\:VDD) resistor r=0.7453 c=0
Rk42 (\30\:VDD \31\:VDD) resistor r=0.3716 c=0
Rk43 (\22\:VDD \33\:VDD) resistor r=0.1021 c=0
Rk44 (\23\:VDD \34\:VDD) resistor r=0.3891 c=0
Rk45 (\24\:VDD \36\:VDD) resistor r=0.1652 c=0
Rk27 (\4\:A A) resistor r=0.1301 c=0
Rk49 (\15\:VSS \16\:VSS) resistor r=0.4094 c=0
Rk50 (\16\:VSS \18\:VSS) resistor r=0.04491 c=0
Rk51 (\18\:VSS \19\:VSS) resistor r=0.3532 c=0
Rk52 (\19\:VSS \20\:VSS) resistor r=0.2126 c=0
Rk53 (\20\:VSS \21\:VSS) resistor r=0.2602 c=0
Rk54 (\21\:VSS \22\:VSS) resistor r=0.1251 c=0
Rk55 (\22\:VSS \23\:VSS) resistor r=0.06998 c=0
Rk56 (\23\:VSS \24\:VSS) resistor r=0.2803 c=0
Rk57 (\24\:VSS \25\:VSS) resistor r=0.2803 c=0
Rk58 (\25\:VSS \26\:VSS) resistor r=0.07981 c=0
Rk59 (\26\:VSS \27\:VSS) resistor r=0.3179 c=0
Rk64 (\28\:VSS VSS) resistor r=0.1925 c=0
Rk60 (\27\:VSS \28\:VSS) resistor r=0.1199 c=0
Rk65 (\16\:VSS \32\:VSS) resistor r=0.5497 c=0
Rk66 (\19\:VSS \34\:VSS) resistor r=0.07346 c=0
Rk67 (\20\:VSS \35\:VSS) resistor r=0.5399 c=0
Rk68 (\21\:VSS \36\:VSS) resistor r=0.5358 c=0
Rk69 (\23\:VSS \38\:VSS) resistor r=0.2852 c=0
Rk70 (\24\:VSS \39\:VSS) resistor r=0.606 c=0
Rk71 (\25\:VSS \40\:VSS) resistor r=0.7999 c=0
Rk72 (\26\:VSS \42\:VSS) resistor r=0.2972 c=0
Rk73 (\27\:VSS \43\:VSS) resistor r=0.5033 c=0
Rk9 (\5\:net345 \7\:net345) resistor r=0.3646 c=0
Rk10 (\7\:net345 \8\:net345) resistor r=1.2909 c=0
Rk1 (\15\:net333 \17\:net333) resistor r=0.2722 c=0
Rk2 (\17\:net333 \19\:net333) resistor r=0.4353 c=0
Rk12 (\5\:net353 \7\:net353) resistor r=0.7607 c=0
Rk13 (\7\:net353 \8\:net353) resistor r=0.5269 c=0
Rk14 (\6\:net361 \7\:net361) resistor r=0.2137 c=0
Rk16 (\9\:net361 \10\:net361) resistor r=1.3148 c=0
Rk15 (\7\:net369 \8\:net369) resistor r=0.1917 c=0
Rk17 (\10\:net369 \11\:net369) resistor r=0.6325 c=0
Rk18 (\6\:net377 \7\:net377) resistor r=0.1104 c=0
Rk19 (\7\:net377 \8\:net377) resistor r=0.642 c=0
Rk20 (\7\:net377 \10\:net377) resistor r=0.4381 c=0
Rk21 (\8\:net377 \11\:net377) resistor r=0.5967 c=0
Rk22 (\5\:net385 \6\:net385) resistor r=0.3443 c=0
Rk23 (\6\:net385 \7\:net385) resistor r=0.3303 c=0
Rk24 (\6\:net385 \9\:net385) resistor r=0.06751 c=0
Rk25 (\4\:net393 \6\:net393) resistor r=0.4226 c=0
Rk26 (\6\:net393 \8\:net393) resistor r=0.4284 c=0
Rk28 (\5\:net397 \6\:net397) resistor r=0.3134 c=0
Rk29 (\6\:net397 \7\:net397) resistor r=0.2071 c=0
Rk30 (\6\:net397 \9\:net397) resistor r=0.1 c=0
Rl38 (\9\:VDD \10\:VDD) resistor r=295.719 c=0
Rl39 (\11\:VDD \10\:VDD) resistor r=29.5379 c=0
Rl19 (\2\:VDD \1\:VDD) resistor r=128.359 c=0
Rl21 (\4\:VDD \3\:VDD) resistor r=126.901 c=0
Rl24 (\4\:VDD \7\:VDD) resistor r=127.296 c=0
Rl25 (\5\:VDD \8\:VDD) resistor r=72.7584 c=0
Rl23 (\5\:VDD \6\:VDD) resistor r=53.7715 c=0
Rl22 (\5\:VDD \4\:VDD) resistor r=113.852 c=0
Rl44 (\13\:VDD \12\:VDD) resistor r=180.432 c=0
Rl46 (\13\:VDD \15\:VDD) resistor r=26.0821 c=0
Rl45 (\13\:VDD \14\:VDD) resistor r=14.7598 c=0
Rl51 (\1\:A \2\:A) resistor r=33.9954 c=0
Rl52 (\2\:A \3\:A) resistor r=97.6085 c=0
Rl47 (\12\:VSS \11\:VSS) resistor r=41.5405 c=0
Rl48 (\12\:VSS \13\:VSS) resistor r=221.693 c=0
Rl37 (\10\:VSS \9\:VSS) resistor r=62.9746 c=0
Rl36 (\8\:VSS \7\:VSS) resistor r=110.771 c=0
Rl29 (\6\:VSS \5\:VSS) resistor r=147.59 c=0
Rl20 (\4\:VSS \3\:VSS) resistor r=66.5405 c=0
Rl18 (\2\:VSS \1\:VSS) resistor r=59.8789 c=0
Rl2 (\2\:net345 \3\:net345) resistor r=65.3618 c=0
Rl1 (net345 \2\:net345) resistor r=51.4546 c=0
Rl17 (\2\:net353 \3\:net353) resistor r=155.769 c=0
Rl16 (net353 \2\:net353) resistor r=30.3481 c=0
Rl26 (net361 \2\:net361) resistor r=324.566 c=0
Rl27 (\2\:net361 \3\:net361) resistor r=168.744 c=0
Rl28 (\3\:net361 \4\:net361) resistor r=172.537 c=0
Rl31 (net369 \2\:net369) resistor r=50.6918 c=0
Rl34 (\3\:net369 \5\:net369) resistor r=98.7402 c=0
Rl32 (\2\:net369 \3\:net369) resistor r=155.239 c=0
Rl33 (\3\:net369 \4\:net369) resistor r=10.5426 c=0
Rl35 (\3\:net377 \4\:net377) resistor r=56.9251 c=0
Rl30 (net377 \2\:net377) resistor r=42.1309 c=0
Rl40 (net385 \2\:net385) resistor r=24.2328 c=0
Rl41 (\2\:net385 \3\:net385) resistor r=89.6174 c=0
Rl42 (net393 \2\:net393) resistor r=142.308 c=0
Rl43 (\2\:net393 \3\:net393) resistor r=26.1559 c=0
Rl50 (\2\:net397 \3\:net397) resistor r=99.1367 c=0
Rl49 (net397 \2\:net397) resistor r=29.5379 c=0
Rz12 (\15\:VSS \14\:VSS) resistor r=75 c=0
Rz13 (\34\:VSS \33\:VSS) resistor r=75 c=0
Rz14 (\38\:VSS \37\:VSS) resistor r=75 c=0
Rz15 (\42\:VSS \41\:VSS) resistor r=75 c=0
Rz4 (\4\:net345 \5\:net345) resistor r=75 c=0
Rz1 (\17\:net333 \16\:net333) resistor r=75 c=0
Rz5 (\4\:net353 \5\:net353) resistor r=75 c=0
Rz6 (\5\:net361 \6\:net361) resistor r=75 c=0
Rz7 (\9\:net369 \10\:net369) resistor r=75 c=0
Rz8 (\9\:net377 \10\:net377) resistor r=75 c=0
Rz9 (\4\:net385 \5\:net385) resistor r=75 c=0
Rz10 (\5\:net393 \6\:net393) resistor r=75 c=0
Rz11 (\8\:net397 \9\:net397) resistor r=75 c=0
Ry12 (\19\:VDD \18\:VDD) resistor r=62 c=0
Ry13 (\29\:VDD \28\:VDD) resistor r=62 c=0
Ry14 (\33\:VDD \32\:VDD) resistor r=62 c=0
Ry15 (\36\:VDD \35\:VDD) resistor r=62 c=0
Ry19 (\18\:VSS \17\:VSS) resistor r=8.8571 c=0
Ry20 (\22\:VSS \17\:VSS) resistor r=5.1667 c=0
Ry21 (\28\:VSS \17\:VSS) resistor r=5.1667 c=0
Ry4 (\6\:net345 \7\:net345) resistor r=62 c=0
Ry1 (\19\:net333 \18\:net333) resistor r=20.6667 c=0
Ry5 (\6\:net353 \7\:net353) resistor r=62 c=0
Ry7 (\8\:net361 \9\:net361) resistor r=62 c=0
Ry6 (\6\:net369 \7\:net369) resistor r=62 c=0
Ry8 (\5\:net377 \6\:net377) resistor r=62 c=0
Ry9 (\8\:net385 \9\:net385) resistor r=62 c=0
Ry10 (\7\:net393 \8\:net393) resistor r=62 c=0
Ry11 (\4\:net397 \5\:net397) resistor r=62 c=0
Rx3 (\16\:VDD \6\:VDD) resistor r=45 c=0
Rx4 (\17\:VDD \2\:VDD) resistor r=45 c=0
Rx16 (\30\:VDD \11\:VDD) resistor r=45 c=0
Rx17 (\31\:VDD \14\:VDD) resistor r=45 c=0
Rx18 (\34\:VDD \7\:VDD) resistor r=45 c=0
Rx14 (\2\:A \4\:A) resistor r=45 c=0
Rx19 (\32\:VSS \12\:VSS) resistor r=45 c=0
Rx20 (\35\:VSS \10\:VSS) resistor r=45 c=0
Rx21 (\36\:VSS \8\:VSS) resistor r=45 c=0
Rx22 (\39\:VSS \6\:VSS) resistor r=45 c=0
Rx23 (\40\:VSS \4\:VSS) resistor r=45 c=0
Rx24 (\43\:VSS \2\:VSS) resistor r=45 c=0
Rx2 (\2\:net345 \8\:net345) resistor r=45 c=0
Rx1 (\15\:net333 net333) resistor r=45 c=0
Rx5 (net353 \8\:net353) resistor r=45 c=0
Rx6 (\3\:net361 \7\:net361) resistor r=45 c=0
Rx8 (\4\:net361 \10\:net361) resistor r=45 c=0
Rx7 (\4\:net369 \8\:net369) resistor r=45 c=0
Rx9 (\2\:net369 \11\:net369) resistor r=45 c=0
Rx10 (net377 \8\:net377) resistor r=45 c=0
Rx11 (\4\:net377 \11\:net377) resistor r=45 c=0
Rx12 (\2\:net385 \7\:net385) resistor r=45 c=0
Rx13 (\3\:net393 \4\:net393) resistor r=45 c=0
Rx15 (\2\:net397 \7\:net397) resistor r=45 c=0
mn15 (\16\:net333 net345 \28\:VSS VSS) g45n1svt w=(2.6e-07) l=4.5e-08 \
        nf=1 as=4.16e-14 ad=3.64e-14 ps=8.4e-07 pd=8e-07 nrd=1.16667 \
        nrs=1.16667 sa=1.4e-07 sb=1.18212e-06 sd=160n sca=12.8392 \
        scb=0.0126987 scc=0.00074151 m=(1)
mn16_1__rcx (Y net333 \28\:VSS VSS) g45n1svt w=(2.6e-07) l=4.5e-08 nf=1 \
        as=4.223e-14 ad=4.16e-14 ps=8.725e-07 pd=8.4e-07 nrd=1.16667 \
        nrs=1.16667 sa=3.45e-07 sb=9.77115e-07 sd=160n sca=12.8392 \
        scb=0.0126987 scc=0.00074151 m=(4)
mn13 (net341 \3\:net353 \28\:VSS VSS) g45n1svt w=(1.45e-07) l=4.5e-08 \
        nf=1 as=4.413e-14 ad=1.668e-14 ps=9.7e-07 pd=5.2e-07 nrd=1.16667 \
        nrs=1.16667 sa=1.23e-06 sb=3e-07 sd=160n sca=9.33388 \
        scb=0.00788941 scc=0.00017958 m=(1)
mn14 (\4\:net345 \1\:VDD net341 VSS) g45n1svt w=(1.45e-07) l=4.5e-08 \
        nf=1 as=1.668e-14 ad=2.03e-14 ps=5.2e-07 pd=5.7e-07 nrd=1.16667 \
        nrs=1.16667 sa=1.39e-06 sb=1.4e-07 sd=160n sca=9.33388 \
        scb=0.00788941 scc=0.00017958 m=(1)
mn11 (net349 \2\:net361 \41\:VSS VSS) g45n1svt w=(1.45e-07) l=4.5e-08 \
        nf=1 as=2.03e-14 ad=8.7e-15 ps=5.7e-07 pd=4.1e-07 nrd=1.16667 \
        nrs=1.16667 sa=1.4e-07 sb=2.85e-07 sd=160n sca=10.2779 \
        scb=0.00944477 scc=0.000275883 m=(1)
mn12 (\4\:net353 \8\:VDD net349 VSS) g45n1svt w=(1.45e-07) l=4.5e-08 \
        nf=1 as=8.7e-15 ad=2.61e-14 ps=4.1e-07 pd=6.5e-07 nrd=1.16667 \
        nrs=1.16667 sa=2.45e-07 sb=1.8e-07 sd=160n sca=10.2779 \
        scb=0.00944477 scc=0.000275883 m=(1)
mn10 (\5\:net361 \3\:VDD net357 VSS) g45n1svt w=(1.45e-07) l=4.5e-08 \
        nf=1 as=5.003e-14 ad=2.03e-14 ps=9.8e-07 pd=5.7e-07 nrd=1.16667 \
        nrs=1.16667 sa=1.4e-07 sb=1.205e-06 sd=160n sca=10.2779 \
        scb=0.00944477 scc=0.000275883 m=(1)
mn9 (net357 \5\:net369 \37\:VSS VSS) g45n1svt w=(1.45e-07) l=4.5e-08 \
        nf=1 as=6.365e-14 ad=5.003e-14 ps=1.18e-06 pd=9.8e-07 nrd=1.16667 \
        nrs=1.16667 sa=5.3e-07 sb=8.15e-07 sd=160n sca=10.2779 \
        scb=0.00944477 scc=0.000275883 m=(1)
mn7 (net365 \3\:net377 \37\:VSS VSS) g45n1svt w=(1.45e-07) l=4.5e-08 \
        nf=1 as=6.365e-14 ad=2.538e-14 ps=1.18e-06 pd=6.4e-07 nrd=1.16667 \
        nrs=1.16667 sa=9.85e-07 sb=3.6e-07 sd=160n sca=10.2779 \
        scb=0.00944477 scc=0.000275883 m=(1)
mn8 (\9\:net369 \9\:VDD net365 VSS) g45n1svt w=(1.45e-07) l=4.5e-08 nf=1 \
        as=2.538e-14 ad=2.03e-14 ps=6.4e-07 pd=5.7e-07 nrd=1.16667 \
        nrs=1.16667 sa=1.205e-06 sb=1.4e-07 sd=160n sca=10.2779 \
        scb=0.00944477 scc=0.000275883 m=(1)
mn6 (\9\:net377 \10\:VDD net373 VSS) g45n1svt w=(1.45e-07) l=4.5e-08 \
        nf=1 as=1.668e-14 ad=4.785e-14 ps=5.2e-07 pd=9.5e-07 nrd=1.16667 \
        nrs=1.16667 sa=3.3e-07 sb=7.65e-07 sd=160n sca=11.4452 \
        scb=0.0112553 scc=0.00042156 m=(1)
mn5 (net373 \3\:net385 \33\:VSS VSS) g45n1svt w=(1.45e-07) l=4.5e-08 \
        nf=1 as=7.175e-14 ad=1.668e-14 ps=1.39e-06 pd=5.2e-07 nrd=1.16667 \
        nrs=1.16667 sa=4.9e-07 sb=6.05e-07 sd=160n sca=11.4452 \
        scb=0.0112553 scc=0.00042156 m=(1)
mn3 (net381 \2\:net393 \33\:VSS VSS) g45n1svt w=(1.45e-07) l=4.5e-08 \
        nf=1 as=7.175e-14 ad=2.103e-14 ps=1.39e-06 pd=5.8e-07 nrd=1.16667 \
        nrs=1.16667 sa=7.65e-07 sb=3.3e-07 sd=160n sca=11.4452 \
        scb=0.0112553 scc=0.00042156 m=(1)
mn4 (\4\:net385 \15\:VDD net381 VSS) g45n1svt w=(1.45e-07) l=4.5e-08 \
        nf=1 as=2.103e-14 ad=2.03e-14 ps=5.8e-07 pd=5.7e-07 nrd=1.16667 \
        nrs=1.16667 sa=9.55e-07 sb=1.4e-07 sd=160n sca=11.4452 \
        scb=0.0112553 scc=0.00042156 m=(1)
mn2 (\5\:net393 \12\:VDD net389 VSS) g45n1svt w=(1.45e-07) l=4.5e-08 \
        nf=1 as=2.537e-14 ad=2.03e-14 ps=6.4e-07 pd=5.7e-07 nrd=1.16667 \
        nrs=1.16667 sa=1.4e-07 sb=5.65e-07 sd=160n sca=10.4914 \
        scb=0.00978575 scc=0.000300434 m=(1)
mn1 (net389 net397 \14\:VSS VSS) g45n1svt w=(1.45e-07) l=4.5e-08 nf=1 \
        as=2.32e-14 ad=2.537e-14 ps=6.1e-07 pd=6.4e-07 nrd=1.16667 \
        nrs=1.16667 sa=3.6e-07 sb=3.45e-07 sd=160n sca=10.4914 \
        scb=0.00978575 scc=0.000300434 m=(1)
mn0 (\8\:net397 \3\:A \14\:VSS VSS) g45n1svt w=(1.45e-07) l=4.5e-08 nf=1 \
        as=2.32e-14 ad=2.03e-14 ps=6.1e-07 pd=5.7e-07 nrd=1.16667 \
        nrs=1.16667 sa=5.65e-07 sb=1.4e-07 sd=160n sca=10.4914 \
        scb=0.00978575 scc=0.000300434 m=(1)
mp13 (net276 \2\:net353 \25\:VDD NW) g45p1svt w=(2.15e-07) l=4.5e-08 \
        nf=1 as=8.772e-14 ad=3.225e-14 ps=1.39e-06 pd=7.3e-07 nrd=1.16667 \
        nrs=1.16667 sa=1.375e-06 sb=3.35e-07 sd=160n sca=45.7906 \
        scb=0.0283307 scc=0.00588417 m=(1)
mp14 (\6\:net345 \1\:VSS net276 NW) g45p1svt w=(2.15e-07) l=4.5e-08 nf=1 \
        as=3.225e-14 ad=3.01e-14 ps=7.3e-07 pd=7.1e-07 nrd=1.16667 \
        nrs=1.16667 sa=1.57e-06 sb=1.4e-07 sd=160n sca=45.7906 \
        scb=0.0283307 scc=0.00588417 m=(1)
mp11 (net284 net361 \35\:VDD NW) g45p1svt w=(2.15e-07) l=4.5e-08 nf=1 \
        as=4.555e-14 ad=1.29e-14 ps=9.2e-07 pd=5.5e-07 nrd=1.16667 \
        nrs=1.16667 sa=1.7e-07 sb=2.45e-07 sd=160n sca=10.1832 \
        scb=0.00742094 scc=7.76436e-05 m=(1)
mp12 (\6\:net353 \3\:VSS net284 NW) g45p1svt w=(2.15e-07) l=4.5e-08 nf=1 \
        as=1.29e-14 ad=3.01e-14 ps=5.5e-07 pd=7.1e-07 nrd=1.16667 \
        nrs=1.16667 sa=2.75e-07 sb=1.4e-07 sd=160n sca=10.1832 \
        scb=0.00742094 scc=7.76436e-05 m=(1)
mp8 (\6\:net369 \5\:VSS net300 NW) g45p1svt w=(2.15e-07) l=4.5e-08 nf=1 \
        as=1.29e-14 ad=3.01e-14 ps=5.5e-07 pd=7.1e-07 nrd=1.16667 \
        nrs=1.16667 sa=1.4e-07 sb=6.8e-07 sd=160n sca=12.7104 \
        scb=0.0116911 scc=0.00042519 m=(1)
mp7 (net300 \2\:net377 \32\:VDD NW) g45p1svt w=(2.15e-07) l=4.5e-08 nf=1 \
        as=1.0208e-13 ad=1.29e-14 ps=1.68e-06 pd=5.5e-07 nrd=1.16667 \
        nrs=1.16667 sa=2.45e-07 sb=5.75e-07 sd=160n sca=12.7104 \
        scb=0.0116911 scc=0.00042519 m=(1)
mp9 (net292 net369 \32\:VDD NW) g45p1svt w=(2.15e-07) l=4.5e-08 nf=1 \
        as=1.0208e-13 ad=1.29e-14 ps=1.68e-06 pd=5.5e-07 nrd=1.16667 \
        nrs=1.16667 sa=5.75e-07 sb=2.45e-07 sd=160n sca=12.7104 \
        scb=0.0116911 scc=0.00042519 m=(1)
mp10 (\8\:net361 \7\:VSS net292 NW) g45p1svt w=(2.15e-07) l=4.5e-08 nf=1 \
        as=1.29e-14 ad=3.01e-14 ps=5.5e-07 pd=7.1e-07 nrd=1.16667 \
        nrs=1.16667 sa=6.8e-07 sb=1.4e-07 sd=160n sca=12.7104 \
        scb=0.0116911 scc=0.00042519 m=(1)
mp6 (\5\:net377 \9\:VSS net308 NW) g45p1svt w=(2.15e-07) l=4.5e-08 nf=1 \
        as=3.332e-14 ad=3.225e-14 ps=7.4e-07 pd=7.3e-07 nrd=1.16667 \
        nrs=1.16667 sa=1.5e-07 sb=7.2e-07 sd=160n sca=37.431 scb=0.0268495 \
        scc=0.00487383 m=(1)
mp5 (net308 net385 \28\:VDD NW) g45p1svt w=(2.15e-07) l=4.5e-08 nf=1 \
        as=4.945e-14 ad=3.332e-14 ps=8.9e-07 pd=7.4e-07 nrd=1.16667 \
        nrs=1.16667 sa=3.5e-07 sb=5.2e-07 sd=160n sca=37.431 scb=0.0268495 \
        scc=0.00487383 m=(1)
mp3 (net316 net393 \28\:VDD NW) g45p1svt w=(2.15e-07) l=4.5e-08 nf=1 \
        as=4.945e-14 ad=1.29e-14 ps=8.9e-07 pd=5.5e-07 nrd=1.16667 \
        nrs=1.16667 sa=6.25e-07 sb=2.45e-07 sd=160n sca=37.431 \
        scb=0.0268495 scc=0.00487383 m=(1)
mp4 (\8\:net385 \13\:VSS net316 NW) g45p1svt w=(2.15e-07) l=4.5e-08 nf=1 \
        as=1.29e-14 ad=3.01e-14 ps=5.5e-07 pd=7.1e-07 nrd=1.16667 \
        nrs=1.16667 sa=7.3e-07 sb=1.4e-07 sd=160n sca=37.431 scb=0.0268495 \
        scc=0.00487383 m=(1)
mp2 (\7\:net393 \11\:VSS net324 NW) g45p1svt w=(2.15e-07) l=4.5e-08 nf=1 \
        as=1.29e-14 ad=3.01e-14 ps=5.5e-07 pd=7.1e-07 nrd=1.16667 \
        nrs=1.16667 sa=1.4e-07 sb=5.1e-07 sd=160n sca=31.4533 \
        scb=0.0258077 scc=0.00372922 m=(1)
mp1 (net324 \3\:net397 \18\:VDD NW) g45p1svt w=(2.15e-07) l=4.5e-08 nf=1 \
        as=1.049e-13 ad=1.29e-14 ps=1.83e-06 pd=5.5e-07 nrd=1.16667 \
        nrs=1.16667 sa=2.45e-07 sb=4.05e-07 sd=160n sca=32.5509 \
        scb=0.0273823 scc=0.00374133 m=(1)
mp0 (\4\:net397 \1\:A \18\:VDD NW) g45p1svt w=(2.15e-07) l=4.5e-08 nf=1 \
        as=1.049e-13 ad=3.01e-14 ps=1.83e-06 pd=7.1e-07 nrd=1.16667 \
        nrs=1.16667 sa=5.1e-07 sb=1.4e-07 sd=160n sca=43.5704 \
        scb=0.0437218 scc=0.0051335 m=(1)
ends DLY4X4
// End of subcircuit definition.
