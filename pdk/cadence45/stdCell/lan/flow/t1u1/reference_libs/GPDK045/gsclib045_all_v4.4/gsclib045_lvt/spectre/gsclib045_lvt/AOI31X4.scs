// gsclib045_lvt/AOI31X4/schematic

simulator lang=spectre

subckt AOI31X4 A0 A1 A2 B0 Y VSS VDD
mp2 (net89 A2 VDD VDD) g45p1lvt w=(1.56u) l=45n nf=1 m=(1)
mp3 (Y B0 net89 VDD) g45p1lvt w=(1.56u) l=45n nf=1 m=(1)
mp1 (net89 A1 VDD VDD) g45p1lvt w=(1.56u) l=45n nf=1 m=(1)
mp0 (net89 A0 VDD VDD) g45p1lvt w=(1.56u) l=45n nf=1 m=(1)
mn3 (Y B0 VSS VSS) g45n1lvt w=(1.04u) l=45n nf=1 m=(1)
mn1 (net101 A1 net97 VSS) g45n1lvt w=(1.04u) l=45n nf=1 m=(1)
mn2 (Y A2 net101 VSS) g45n1lvt w=(1.04u) l=45n nf=1 m=(1)
mn0 (net97 A0 VSS VSS) g45n1lvt w=(1.04u) l=45n nf=1 m=(1)
ends AOI31X4
