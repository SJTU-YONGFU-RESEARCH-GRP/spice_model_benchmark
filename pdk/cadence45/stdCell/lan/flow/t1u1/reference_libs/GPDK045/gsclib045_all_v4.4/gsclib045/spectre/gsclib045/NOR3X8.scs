// gsclib045/NOR3X8/schematic

simulator lang=spectre

subckt NOR3X8 A B C Y VSS VDD
mn0 (Y A VSS VSS) g45n1svt w=(2.065u) l=45n nf=1 m=(1)
mn1 (Y B VSS VSS) g45n1svt w=(2.065u) l=45n nf=1 m=(1)
mn2 (Y C VSS VSS) g45n1svt w=(2.065u) l=45n nf=1 m=(1)
mp1 (n1 B n0 VDD) g45p1svt w=(3.115u) l=45n nf=1 m=(1)
mp2 (Y C n1 VDD) g45p1svt w=(3.115u) l=45n nf=1 m=(1)
mp0 (n0 A VDD VDD) g45p1svt w=(3.115u) l=45n nf=1 m=(1)
ends NOR3X8
