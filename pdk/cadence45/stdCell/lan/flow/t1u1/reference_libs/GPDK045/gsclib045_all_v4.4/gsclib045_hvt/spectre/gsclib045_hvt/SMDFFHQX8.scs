// gsclib045_hvt/SMDFFHQX8/schematic

simulator lang=spectre

subckt SMDFFHQX8 CK D0 D1 Q S0 SE SI VDD VSS
mp3 (net429 D1 VDD VDD) g45p1hvt w=(390n) l=45n nf=1 m=(1)
mp4 (db S0b net429 VDD) g45p1hvt w=(390n) l=45n nf=1 m=(1)
mp2 (db S0 net425 VDD) g45p1hvt w=(390n) l=45n nf=1 m=(1)
mp1 (net425 D0 VDD VDD) g45p1hvt w=(390n) l=45n nf=1 m=(1)
mp13 (dbp SEb net417 VDD) g45p1hvt w=(390n) l=45n nf=1 m=(1)
mp12 (net417 SI VDD VDD) g45p1hvt w=(390n) l=45n nf=1 m=(1)
mp51 (n30 CKbb net409 VDD) g45p1hvt w=(310n) l=45n nf=1 m=(1)
mp50 (net409 qbint VDD VDD) g45p1hvt w=(310n) l=45n nf=1 m=(1)
mp55 (Q qbint VDD VDD) g45p1hvt w=(3.115u) l=45n nf=1 m=(1)
mp35 (net393 mout VDD VDD) g45p1hvt w=(310n) l=45n nf=1 m=(1)
mp36 (n20 CKb net393 VDD) g45p1hvt w=(310n) l=45n nf=1 m=(1)
mp20 (CKb CK VDD VDD) g45p1hvt w=(215n) l=45n nf=1 m=(1)
mp45 (qbint n30 VDD VDD) g45p1hvt w=(1.17u) l=45n nf=1 m=(1)
mp0 (S0b S0 VDD VDD) g45p1hvt w=(215n) l=45n nf=1 m=(1)
mp40 (n30 CKb mout VDD) g45p1hvt w=(310n) l=45n nf=1 m=(1)
mp21 (CKbb CKb VDD VDD) g45p1hvt w=(215n) l=45n nf=1 m=(1)
mp30 (mout n20 VDD VDD) g45p1hvt w=(310n) l=45n nf=1 m=(1)
mp10 (SEb SE VDD VDD) g45p1hvt w=(215n) l=45n nf=1 m=(1)
mp11 (dbp SE db VDD) g45p1hvt w=(390n) l=45n nf=1 m=(1)
mp25 (n20 CKbb dbp VDD) g45p1hvt w=(310n) l=45n nf=1 m=(1)
mn3 (net510 D1 VSS VSS) g45n1hvt w=(260n) l=45n nf=1 m=(1)
mn4 (db S0 net510 VSS) g45n1hvt w=(260n) l=45n nf=1 m=(1)
mn2 (db S0b net498 VSS) g45n1hvt w=(260n) l=45n nf=1 m=(1)
mn1 (net498 D0 VSS VSS) g45n1hvt w=(260n) l=45n nf=1 m=(1)
mn13 (dbp SE net490 VSS) g45n1hvt w=(260n) l=45n nf=1 m=(1)
mn12 (net490 SI VSS VSS) g45n1hvt w=(260n) l=45n nf=1 m=(1)
mn55 (Q qbint VSS VSS) g45n1hvt w=(2.065u) l=45n nf=1 m=(1)
mn50 (net482 qbint VSS VSS) g45n1hvt w=(205n) l=45n nf=1 m=(1)
mn51 (n30 CKb net482 VSS) g45n1hvt w=(205n) l=45n nf=1 m=(1)
mn35 (net474 mout VSS VSS) g45n1hvt w=(205n) l=45n nf=1 m=(1)
mn36 (n20 CKbb net474 VSS) g45n1hvt w=(205n) l=45n nf=1 m=(1)
mn20 (CKb CK VSS VSS) g45n1hvt w=(145n) l=45n nf=1 m=(1)
mn45 (qbint n30 VSS VSS) g45n1hvt w=(780n) l=45n nf=1 m=(1)
mn10 (SEb SE VSS VSS) g45n1hvt w=(145n) l=45n nf=1 m=(1)
mn0 (S0b S0 VSS VSS) g45n1hvt w=(145n) l=45n nf=1 m=(1)
mn11 (db SEb dbp VSS) g45n1hvt w=(260n) l=45n nf=1 m=(1)
mn40 (mout CKbb n30 VSS) g45n1hvt w=(205n) l=45n nf=1 m=(1)
mn25 (dbp CKb n20 VSS) g45n1hvt w=(205n) l=45n nf=1 m=(1)
mn30 (mout n20 VSS VSS) g45n1hvt w=(205n) l=45n nf=1 m=(1)
mn21 (CKbb CKb VSS VSS) g45n1hvt w=(145n) l=45n nf=1 m=(1)
ends SMDFFHQX8
