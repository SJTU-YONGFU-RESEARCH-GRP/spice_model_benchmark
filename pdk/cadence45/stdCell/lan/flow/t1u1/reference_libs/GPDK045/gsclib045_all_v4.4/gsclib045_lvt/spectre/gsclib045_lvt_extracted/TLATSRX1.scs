// Generated for: spectre (May  1 09:19:30 2013 )
// Library name: gsclib045_lvt
// Cell name: TLATSRX1
// View name: extracted

simulator lang=spectre

subckt TLATSRX1 D G Q QN RN SN VDD VSS
mp21 (\1\:Q \4\:Qbint \19\:VDD VDD) g45p1lvt w=(3.9e-07) l=4.5e-08 nf=1 \
        as=6.24e-14 ad=6.435e-14 ps=1.1e-06 pd=1.11e-06 nrd=1.16667 \
        nrs=1.16667 sa=1.65e-07 sb=3.17308e-07 sd=160n sca=34.23 \
        scb=0.0247192 scc=0.00340661 m=(1)
mp20 (\5\:Qbint \8\:Qint \19\:VDD VDD) g45p1lvt w=(3.9e-07) l=4.5e-08 \
        nf=1 as=6.24e-14 ad=4.38e-14 ps=1.1e-06 pd=1.06e-06 nrd=1.16667 \
        nrs=1.16667 sa=3.7e-07 sb=1.12308e-07 sd=160n sca=31.7909 \
        scb=0.0210107 scc=0.00336206 m=(1)
mp22 (\1\:QN \7\:Qint \17\:VDD VDD) g45p1lvt w=(3.9e-07) l=4.5e-08 nf=1 \
        as=5.512e-14 ad=5.34e-14 ps=1.13e-06 pd=1.06e-06 nrd=1.16667 \
        nrs=1.16667 sa=1.36923e-07 sb=8.74551e-07 sd=160n sca=24.4353 \
        scb=0.0186618 scc=0.00260099 m=(1)
C1 (D VSS) capacitor c=4.78837e-17
C2 (QN VSS) capacitor c=6.57641e-17
C3 (RN VSS) capacitor c=5.6683e-17
C4 (Q VSS) capacitor c=2.35523e-17
C5 (VDD VSS) capacitor c=2.56475e-16
C6 (Qbint VSS) capacitor c=2.22955e-17
C7 (Qint VSS) capacitor c=1.43331e-17
C8 (net183 VSS) capacitor c=1.35824e-18
C9 (n5 VSS) capacitor c=7.24971e-17
C10 (net159 VSS) capacitor c=1.48418e-18
C11 (Gb VSS) capacitor c=4.79243e-17
C12 (net167 VSS) capacitor c=3.60468e-18
C13 (net171 VSS) capacitor c=5.50835e-18
C14 (Gbb VSS) capacitor c=3.39687e-17
C15 (net103 VSS) capacitor c=7.77759e-17
C16 (net142 VSS) capacitor c=6.87895e-19
C17 (\5\:Gb VSS) capacitor c=3.8721e-17
C18 (\3\:D VSS) capacitor c=5.05589e-17
C19 (\3\:Gb VSS) capacitor c=6.11192e-17
C20 (\3\:Gbb VSS) capacitor c=5.67155e-17
C21 (\11\:Qint VSS) capacitor c=3.36588e-17
C22 (\7\:RN VSS) capacitor c=2.78432e-17
C23 (\6\:RN VSS) capacitor c=3.0937e-17
C24 (\3\:G VSS) capacitor c=3.8959e-17
C25 (\3\:SN VSS) capacitor c=4.54677e-17
C26 (\7\:Qint VSS) capacitor c=4.67178e-17
C27 (\8\:Qint VSS) capacitor c=3.46324e-17
C28 (\4\:Qbint VSS) capacitor c=4.07462e-17
C29 (\6\:Gb VSS) capacitor c=5.07484e-17
C30 (\1\:D VSS) capacitor c=5.64546e-17
C31 (\9\:Qint VSS) capacitor c=6.15737e-17
C32 (\1\:RN VSS) capacitor c=4.52747e-17
C33 (\4\:RN VSS) capacitor c=1.9727e-17
C34 (\1\:G VSS) capacitor c=5.86801e-17
C35 (\2\:n5 VSS) capacitor c=7.0242e-17
C36 (\1\:SN VSS) capacitor c=7.28402e-17
C37 (\6\:Qint VSS) capacitor c=3.58995e-17
C38 (\5\:Qint VSS) capacitor c=3.6595e-17
C39 (\3\:Qbint VSS) capacitor c=3.23056e-17
C40 (\7\:Gb VSS) capacitor c=2.07725e-17
C41 (\2\:D VSS) capacitor c=5.16076e-17
C42 (\2\:Gbb VSS) capacitor c=6.06019e-17
C43 (\4\:Gb VSS) capacitor c=2.54856e-17
C44 (\2\:Gb VSS) capacitor c=2.323e-17
C45 (\10\:Qint VSS) capacitor c=5.59836e-17
C46 (\3\:RN VSS) capacitor c=2.42116e-17
C47 (\2\:G VSS) capacitor c=5.12048e-17
C48 (\3\:n5 VSS) capacitor c=2.68963e-17
C49 (\2\:SN VSS) capacitor c=5.46683e-17
C50 (\4\:Gbb VSS) capacitor c=4.11271e-17
C51 (\1\:VDD VSS) capacitor c=3.87369e-17
C52 (\4\:n5 VSS) capacitor c=8.18966e-17
C53 (\3\:net103 VSS) capacitor c=9.11789e-17
C54 (\11\:VDD VSS) capacitor c=2.78661e-17
C55 (\13\:VDD VSS) capacitor c=1.60508e-17
C56 (\15\:Gb VSS) capacitor c=5.74622e-17
C57 (\15\:VDD VSS) capacitor c=1.97241e-17
C58 (\13\:Qint VSS) capacitor c=1.89921e-16
C59 (\17\:VDD VSS) capacitor c=2.94231e-17
C60 (\1\:QN VSS) capacitor c=3.72301e-17
C61 (\5\:Qbint VSS) capacitor c=3.70597e-17
C62 (\19\:VDD VSS) capacitor c=7.32522e-17
C63 (\1\:Q VSS) capacitor c=6.27213e-17
C64 (\3\:VDD VSS) capacitor c=4.6199e-17
C65 (\8\:Gbb VSS) capacitor c=1.94255e-17
C66 (\6\:n5 VSS) capacitor c=2.19492e-16
C67 (\13\:Gb VSS) capacitor c=2.67352e-17
C68 (\15\:Qint VSS) capacitor c=1.15119e-16
C69 (\3\:QN VSS) capacitor c=2.96276e-17
C70 (\9\:Qbint VSS) capacitor c=2.8943e-17
C71 (\3\:Q VSS) capacitor c=3.86781e-17
C72 (\2\:Qbint VSS) capacitor c=1.25965e-17
C73 (\2\:Qint VSS) capacitor c=9.68253e-18
C74 (\3\:Qint VSS) capacitor c=1.87106e-17
C75 (\4\:Qint VSS) capacitor c=3.17732e-17
C76 (\2\:RN VSS) capacitor c=2.22016e-17
C77 (\5\:RN VSS) capacitor c=1.62931e-17
C78 (\7\:Qbint VSS) capacitor c=2.90554e-17
C79 (\8\:Qbint VSS) capacitor c=3.89985e-17
C80 (\4\:SN VSS) capacitor c=1.13414e-16
C81 (\4\:G VSS) capacitor c=1.14739e-16
C82 (\8\:RN VSS) capacitor c=7.06551e-17
C83 (\12\:Qint VSS) capacitor c=1.88947e-16
C84 (\17\:Qint VSS) capacitor c=7.28331e-17
C85 (\8\:n5 VSS) capacitor c=1.5319e-16
C86 (\4\:D VSS) capacitor c=6.34875e-17
C87 (\6\:Gbb VSS) capacitor c=3.95523e-17
C88 (\7\:Gbb VSS) capacitor c=6.07325e-17
C89 (\8\:Gb VSS) capacitor c=4.66909e-17
C90 (\9\:Gb VSS) capacitor c=1.13027e-16
C91 (\10\:Gb VSS) capacitor c=1.6803e-16
C92 (\11\:Gb VSS) capacitor c=1.76142e-17
C93 (\12\:Gb VSS) capacitor c=1.33494e-16
C94 (\5\:VDD VSS) capacitor c=1.80575e-17
C95 (\6\:VDD VSS) capacitor c=2.0672e-17
C96 (\7\:VDD VSS) capacitor c=2.18822e-17
C97 (\9\:VDD VSS) capacitor c=7.63165e-18
C98 (\10\:VDD VSS) capacitor c=1.11175e-17
Rk8 (\4\:SN SN) resistor r=0.03189 c=0
Rk17 (\4\:D D) resistor r=0.01227 c=0
Rk40 (\2\:VSS \4\:VSS) resistor r=0.493 c=0
Rk41 (\4\:VSS \5\:VSS) resistor r=0.3359 c=0
Rk42 (\5\:VSS \6\:VSS) resistor r=0.6167 c=0
Rk43 (\6\:VSS \7\:VSS) resistor r=0.04244 c=0
Rk45 (\8\:VSS VSS) resistor r=0.2027 c=0
Rk44 (\7\:VSS \8\:VSS) resistor r=0.3056 c=0
Rk46 (\5\:VSS \10\:VSS) resistor r=0.2036 c=0
Rk47 (\7\:VSS \12\:VSS) resistor r=0.2009 c=0
Rk48 (\8\:VSS \14\:VSS) resistor r=0.2901 c=0
Rk6 (\2\:QN QN) resistor r=0.2469 c=0
Rk7 (QN \4\:QN) resistor r=0.1396 c=0
Rk10 (\8\:RN RN) resistor r=0.05736 c=0
Rk2 (\4\:Q Q) resistor r=0.08444 c=0
Rk1 (\2\:Q \4\:Q) resistor r=0.38 c=0
Rk9 (G \4\:G) resistor r=0.002841 c=0
Rk27 (\2\:VDD \4\:VDD) resistor r=0.2291 c=0
Rk28 (\4\:VDD \5\:VDD) resistor r=0.2757 c=0
Rk29 (\5\:VDD \6\:VDD) resistor r=0.2002 c=0
Rk30 (\6\:VDD \7\:VDD) resistor r=0.2905 c=0
Rk31 (\7\:VDD \8\:VDD) resistor r=0.1854 c=0
Rk32 (\8\:VDD \9\:VDD) resistor r=0.04244 c=0
Rk34 (\10\:VDD VDD) resistor r=0.2027 c=0
Rk33 (\9\:VDD \10\:VDD) resistor r=0.3056 c=0
Rk35 (\5\:VDD \12\:VDD) resistor r=0.1474 c=0
Rk36 (\6\:VDD \14\:VDD) resistor r=0.07393 c=0
Rk37 (\7\:VDD \16\:VDD) resistor r=0.07393 c=0
Rk38 (\9\:VDD \18\:VDD) resistor r=0.2997 c=0
Rk39 (\10\:VDD \20\:VDD) resistor r=0.4004 c=0
Rk3 (\6\:Qbint \7\:Qbint) resistor r=0.1238 c=0
Rk4 (\7\:Qbint \8\:Qbint) resistor r=0.1194 c=0
Rk5 (\7\:Qbint \10\:Qbint) resistor r=0.09978 c=0
Rk11 (\12\:Qint \14\:Qint) resistor r=1.2613 c=0
Rk12 (\14\:Qint \16\:Qint) resistor r=0.6756 c=0
Rk13 (\16\:Qint \17\:Qint) resistor r=0.3784 c=0
Rk15 (\5\:n5 \7\:n5) resistor r=0.4836 c=0
Rk16 (\7\:n5 \8\:n5) resistor r=1.3354 c=0
Rk21 (\8\:Gb \9\:Gb) resistor r=0.3878 c=0
Rk22 (\9\:Gb \10\:Gb) resistor r=0.6655 c=0
Rk23 (\9\:Gb \11\:Gb) resistor r=0.02785 c=0
Rk24 (\10\:Gb \12\:Gb) resistor r=0.7561 c=0
Rk25 (\12\:Gb \14\:Gb) resistor r=0.1164 c=0
Rk26 (\12\:Gb \16\:Gb) resistor r=0.3623 c=0
Rk18 (\5\:Gbb \6\:Gbb) resistor r=0.2915 c=0
Rk19 (\6\:Gbb \7\:Gbb) resistor r=0.2917 c=0
Rk20 (\6\:Gbb \9\:Gbb) resistor r=0.1237 c=0
Rk14 (\2\:net103 \4\:net103) resistor r=0.3419 c=0
Rl12 (\2\:SN \3\:SN) resistor r=74.1758 c=0
Rl11 (\1\:SN \2\:SN) resistor r=119.231 c=0
Rl30 (\2\:D \3\:D) resistor r=29.9451 c=0
Rl29 (\1\:D \2\:D) resistor r=125 c=0
Rl17 (\1\:RN \2\:RN) resistor r=123.503 c=0
Rl19 (\2\:RN \4\:RN) resistor r=35.772 c=0
Rl18 (\2\:RN \3\:RN) resistor r=62.6951 c=0
Rl22 (\5\:RN \7\:RN) resistor r=35.772 c=0
Rl21 (\5\:RN \6\:RN) resistor r=96.5797 c=0
Rl20 (\3\:RN \5\:RN) resistor r=44.5632 c=0
Rl16 (\2\:G \3\:G) resistor r=81.9251 c=0
Rl15 (\1\:G \2\:G) resistor r=219.952 c=0
Rl3 (\2\:Qbint \4\:Qbint) resistor r=49.7141 c=0
Rl2 (\2\:Qbint \3\:Qbint) resistor r=34.3295 c=0
Rl1 (Qbint \2\:Qbint) resistor r=2.0213 c=0
Rl24 (\10\:Qint \11\:Qint) resistor r=54.1337 c=0
Rl23 (\9\:Qint \10\:Qint) resistor r=184.128 c=0
Rl8 (\2\:Qint \6\:Qint) resistor r=37.3411 c=0
Rl4 (Qint \2\:Qint) resistor r=1.2334 c=0
Rl9 (\3\:Qint \7\:Qint) resistor r=35.772 c=0
Rl5 (\2\:Qint \3\:Qint) resistor r=63.4977 c=0
Rl10 (\4\:Qint \8\:Qint) resistor r=28.0797 c=0
Rl7 (\4\:Qint \5\:Qint) resistor r=60.772 c=0
Rl6 (\3\:Qint \4\:Qint) resistor r=141.671 c=0
Rl13 (n5 \2\:n5) resistor r=216.873 c=0
Rl14 (\2\:n5 \3\:n5) resistor r=26.1559 c=0
Rl31 (\5\:Gb \6\:Gb) resistor r=178.846 c=0
Rl32 (\5\:Gb \7\:Gb) resistor r=35.6938 c=0
Rl26 (\3\:Gb \4\:Gb) resistor r=56.9251 c=0
Rl25 (Gb \2\:Gb) resistor r=26.1559 c=0
Rl28 (\2\:Gbb \3\:Gbb) resistor r=181.433 c=0
Rl27 (Gbb \2\:Gbb) resistor r=35.7134 c=0
Rz10 (\1\:VSS \2\:VSS) resistor r=75 c=0
Rz11 (\9\:VSS \10\:VSS) resistor r=75 c=0
Rz12 (\11\:VSS \12\:VSS) resistor r=75 c=0
Rz13 (\13\:VSS \14\:VSS) resistor r=75 c=0
Rz3 (\3\:QN \4\:QN) resistor r=75 c=0
Rz1 (\3\:Q \4\:Q) resistor r=75 c=0
Rz8 (\3\:VDD \4\:VDD) resistor r=10.7143 c=0
Rz9 (\3\:VDD \8\:VDD) resistor r=6.25 c=0
Rz2 (\9\:Qbint \10\:Qbint) resistor r=75 c=0
Rz4 (\15\:Qint \16\:Qint) resistor r=75 c=0
Rz5 (\6\:n5 \7\:n5) resistor r=75 c=0
Rz7 (\13\:Gb \14\:Gb) resistor r=75 c=0
Rz6 (\8\:Gbb \9\:Gbb) resistor r=75 c=0
Ry16 (\3\:VSS \4\:VSS) resistor r=8.8571 c=0
Ry17 (\3\:VSS \6\:VSS) resistor r=5.1667 c=0
Ry3 (\1\:QN \2\:QN) resistor r=62 c=0
Ry1 (\1\:Q \2\:Q) resistor r=20.6667 c=0
Ry10 (\1\:VDD \2\:VDD) resistor r=62 c=0
Ry11 (\11\:VDD \12\:VDD) resistor r=62 c=0
Ry12 (\13\:VDD \14\:VDD) resistor r=62 c=0
Ry13 (\15\:VDD \16\:VDD) resistor r=62 c=0
Ry14 (\17\:VDD \18\:VDD) resistor r=62 c=0
Ry15 (\19\:VDD \20\:VDD) resistor r=20.6667 c=0
Ry2 (\5\:Qbint \6\:Qbint) resistor r=62 c=0
Ry4 (\13\:Qint \14\:Qint) resistor r=62 c=0
Ry7 (\4\:n5 \5\:n5) resistor r=62 c=0
Ry9 (\15\:Gb \16\:Gb) resistor r=62 c=0
Ry8 (\4\:Gbb \5\:Gbb) resistor r=62 c=0
Ry5 (net103 \2\:net103) resistor r=62 c=0
Ry6 (\3\:net103 \4\:net103) resistor r=62 c=0
Rx2 (\2\:SN \4\:SN) resistor r=45 c=0
Rx8 (\2\:D \4\:D) resistor r=45 c=0
Rx4 (\3\:RN \8\:RN) resistor r=45 c=0
Rx3 (\2\:G \4\:G) resistor r=45 c=0
Rx1 (Qbint \8\:Qbint) resistor r=45 c=0
Rx5 (\10\:Qint \12\:Qint) resistor r=45 c=0
Rx6 (Qint \17\:Qint) resistor r=45 c=0
Rx7 (\3\:n5 \8\:n5) resistor r=45 c=0
Rx10 (\7\:Gb \8\:Gb) resistor r=45 c=0
Rx11 (\2\:Gb \10\:Gb) resistor r=45 c=0
Rx12 (\4\:Gb \11\:Gb) resistor r=45 c=0
Rx9 (\2\:Gbb \7\:Gbb) resistor r=45 c=0
mn21 (\3\:Q \3\:Qbint \13\:VSS VSS) g45n1lvt w=(2.6e-07) l=4.5e-08 nf=1 \
        as=4.16e-14 ad=4.29e-14 ps=8.4e-07 pd=8.5e-07 nrd=1.16667 \
        nrs=1.16667 sa=1.65e-07 sb=3.45e-07 sd=160n sca=17.5885 \
        scb=0.0172826 scc=0.00162584 m=(1)
mn20 (\9\:Qbint \5\:Qint \13\:VSS VSS) g45n1lvt w=(2.6e-07) l=4.5e-08 \
        nf=1 as=4.16e-14 ad=3.64e-14 ps=8.4e-07 pd=8e-07 nrd=1.16667 \
        nrs=1.16667 sa=3.7e-07 sb=1.4e-07 sd=160n sca=17.5885 \
        scb=0.0172826 scc=0.00162584 m=(1)
mn22 (\3\:QN \6\:Qint \11\:VSS VSS) g45n1lvt w=(2.6e-07) l=4.5e-08 nf=1 \
        as=4.945e-14 ad=3.64e-14 ps=9.8e-07 pd=8e-07 nrd=1.16667 \
        nrs=1.16667 sa=1.4e-07 sb=3.51923e-07 sd=160n sca=8.97712 \
        scb=0.00732387 scc=0.000196032 m=(1)
mn10 (net183 \1\:SN \11\:VSS VSS) g45n1lvt w=(1.45e-07) l=4.5e-08 nf=1 \
        as=4.945e-14 ad=8.7e-15 ps=9.8e-07 pd=4.1e-07 nrd=1.16667 \
        nrs=1.16667 sa=4.15e-07 sb=2.45e-07 sd=160n sca=10.7143 \
        scb=0.0101371 scc=0.000327098 m=(1)
mn11 (\15\:Qint \2\:n5 net183 VSS) g45n1lvt w=(1.45e-07) l=4.5e-08 nf=1 \
        as=8.7e-15 ad=2.03e-14 ps=4.1e-07 pd=5.7e-07 nrd=1.16667 \
        nrs=1.16667 sa=5.2e-07 sb=1.4e-07 sd=160n sca=10.7143 \
        scb=0.0101371 scc=0.000327098 m=(1)
mn1 (\13\:Gb \1\:G net159 VSS) g45n1lvt w=(1.45e-07) l=4.5e-08 nf=1 \
        as=2.827e-14 ad=2.03e-14 ps=6.8e-07 pd=5.7e-07 nrd=1.16667 \
        nrs=1.16667 sa=1.4e-07 sb=1.71e-06 sd=160n sca=11.7118 \
        scb=0.0116498 scc=0.000458536 m=(1)
mn0 (net159 \4\:RN \9\:VSS VSS) g45n1lvt w=(1.45e-07) l=4.5e-08 nf=1 \
        as=4.75e-14 ad=2.827e-14 ps=9.9e-07 pd=6.8e-07 nrd=1.16667 \
        nrs=1.16667 sa=3.8e-07 sb=1.47e-06 sd=160n sca=11.7118 \
        scb=0.0116498 scc=0.000458536 m=(1)
mn15 (net167 \1\:RN \9\:VSS VSS) g45n1lvt w=(1.45e-07) l=4.5e-08 nf=1 \
        as=4.75e-14 ad=1.812e-14 ps=9.9e-07 pd=5.4e-07 nrd=1.16667 \
        nrs=1.16667 sa=6.45e-07 sb=1.205e-06 sd=160n sca=11.7118 \
        scb=0.0116498 scc=0.000458536 m=(1)
mn16 (net171 \9\:Qint net167 VSS) g45n1lvt w=(1.45e-07) l=4.5e-08 nf=1 \
        as=1.812e-14 ad=2.9e-14 ps=5.4e-07 pd=6.9e-07 nrd=1.16667 \
        nrs=1.16667 sa=8.15e-07 sb=1.035e-06 sd=160n sca=11.7118 \
        scb=0.0116498 scc=0.000458536 m=(1)
mn17 (\6\:n5 Gb net171 VSS) g45n1lvt w=(1.45e-07) l=4.5e-08 nf=1 \
        as=2.9e-14 ad=3.407e-14 ps=6.9e-07 pd=7.6e-07 nrd=1.16667 \
        nrs=1.16667 sa=1.06e-06 sb=7.9e-07 sd=160n sca=11.7118 \
        scb=0.0116498 scc=0.000458536 m=(1)
mn6 (\6\:n5 Gbb net191 VSS) g45n1lvt w=(1.45e-07) l=4.5e-08 nf=1 \
        as=1.74e-14 ad=3.407e-14 ps=5.3e-07 pd=7.6e-07 nrd=1.16667 \
        nrs=1.16667 sa=1.34e-06 sb=5.1e-07 sd=160n sca=11.7118 \
        scb=0.0116498 scc=0.000458536 m=(1)
mn5 (net191 \1\:D \1\:VSS VSS) g45n1lvt w=(1.45e-07) l=4.5e-08 nf=1 \
        as=2.32e-14 ad=1.74e-14 ps=6.1e-07 pd=5.3e-07 nrd=1.16667 \
        nrs=1.16667 sa=1.505e-06 sb=3.45e-07 sd=160n sca=11.7118 \
        scb=0.0116498 scc=0.000458536 m=(1)
mn2 (\8\:Gbb \6\:Gb \1\:VSS VSS) g45n1lvt w=(1.45e-07) l=4.5e-08 nf=1 \
        as=2.32e-14 ad=2.03e-14 ps=6.1e-07 pd=5.7e-07 nrd=1.16667 \
        nrs=1.16667 sa=1.71e-06 sb=1.4e-07 sd=160n sca=11.7118 \
        scb=0.0116498 scc=0.000458536 m=(1)
mp10 (\13\:Qint \3\:SN \17\:VDD VDD) g45p1lvt w=(2.15e-07) l=4.5e-08 \
        nf=1 as=5.512e-14 ad=3.44e-14 ps=1.13e-06 pd=7.5e-07 nrd=1.16667 \
        nrs=1.16667 sa=3.6e-07 sb=1.285e-06 sd=160n sca=11.9515 \
        scb=0.0105226 scc=0.000305882 m=(1)
mp11 (\13\:Qint n5 \15\:VDD VDD) g45p1lvt w=(2.15e-07) l=4.5e-08 nf=1 \
        as=6.417e-14 ad=3.44e-14 ps=1.58e-06 pd=7.5e-07 nrd=1.16667 \
        nrs=1.16667 sa=5.65e-07 sb=1.08e-06 sd=160n sca=11.9515 \
        scb=0.0105226 scc=0.000305882 m=(1)
mp1 (\15\:Gb \3\:G \15\:VDD VDD) g45p1lvt w=(2.15e-07) l=4.5e-08 nf=1 \
        as=6.417e-14 ad=6.558e-14 ps=1.58e-06 pd=1.04e-06 nrd=1.16667 \
        nrs=1.16667 sa=7.95e-07 sb=8.5e-07 sd=160n sca=11.9515 \
        scb=0.0105226 scc=0.000305882 m=(1)
mp0 (\15\:Gb \6\:RN \13\:VDD VDD) g45p1lvt w=(2.15e-07) l=4.5e-08 nf=1 \
        as=5.665e-14 ad=6.558e-14 ps=1.51e-06 pd=1.04e-06 nrd=1.16667 \
        nrs=1.16667 sa=1.145e-06 sb=5e-07 sd=160n sca=11.9515 \
        scb=0.0105226 scc=0.000305882 m=(1)
mp15 (net103 \7\:RN \13\:VDD VDD) g45p1lvt w=(2.15e-07) l=4.5e-08 nf=1 \
        as=5.665e-14 ad=3.44e-14 ps=1.51e-06 pd=7.5e-07 nrd=1.16667 \
        nrs=1.16667 sa=1.34e-06 sb=3.05e-07 sd=160n sca=11.9515 \
        scb=0.0105226 scc=0.000305882 m=(1)
mp16 (net103 \11\:Qint \11\:VDD VDD) g45p1lvt w=(2.15e-07) l=4.5e-08 \
        nf=1 as=4.04e-14 ad=3.44e-14 ps=1.19e-06 pd=7.5e-07 nrd=1.16667 \
        nrs=1.16667 sa=1.545e-06 sb=1e-07 sd=160n sca=11.9515 \
        scb=0.0105226 scc=0.000305882 m=(1)
mp17 (\4\:n5 \3\:Gbb \3\:net103 VDD) g45p1lvt w=(2.15e-07) l=4.5e-08 nf=1 \
        as=4.37e-14 ad=3.44e-14 ps=1e-06 pd=7.5e-07 nrd=1.16667 \
        nrs=1.16667 sa=2.03256e-07 sb=7.4e-07 sd=160n sca=16.8549 \
        scb=0.0164675 scc=0.00112488 m=(1)
mp6 (\4\:n5 \3\:Gb net142 VDD) g45p1lvt w=(2.15e-07) l=4.5e-08 nf=1 \
        as=1.827e-14 ad=3.44e-14 ps=6e-07 pd=7.5e-07 nrd=1.16667 \
        nrs=1.16667 sa=4.08256e-07 sb=5.35e-07 sd=160n sca=17.8256 \
        scb=0.0172341 scc=0.00112617 m=(1)
mp5 (net142 \3\:D \1\:VDD VDD) g45p1lvt w=(2.15e-07) l=4.5e-08 nf=1 \
        as=9.53e-14 ad=1.827e-14 ps=1.67e-06 pd=6e-07 nrd=1.16667 \
        nrs=1.16667 sa=5.38256e-07 sb=4.05e-07 sd=160n sca=19.1101 \
        scb=0.0190255 scc=0.00113905 m=(1)
mp2 (\4\:Gbb \5\:Gb \1\:VDD VDD) g45p1lvt w=(2.15e-07) l=4.5e-08 nf=1 \
        as=9.53e-14 ad=3.01e-14 ps=1.67e-06 pd=7.1e-07 nrd=1.16667 \
        nrs=1.16667 sa=8.03256e-07 sb=1.4e-07 sd=160n sca=30.1296 \
        scb=0.035365 scc=0.00253121 m=(1)
ends TLATSRX1
// End of subcircuit definition.
