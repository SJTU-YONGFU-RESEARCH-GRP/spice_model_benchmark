// Generated for: spectre (May  1 09:17:18 2013 )
// Library name: gsclib045_hvt
// Cell name: NAND2BX2
// View name: extracted

simulator lang=spectre

subckt NAND2BX2 AN B VDD VSS Y
mp1 (\1\:Y \2\:n0 VDD VDD) g45p1hvt w=(3.9e-07) l=4.5e-08 nf=1 \
        as=5.998e-14 ad=6.24e-14 ps=1.11e-06 pd=1.1e-06 nrd=1.16667 \
        nrs=1.16667 sa=1.4e-07 sb=8.76346e-07 sd=160n sca=24.5042 \
        scb=0.0279724 scc=0.00152894 m=(2)
mp2 (\1\:Y \3\:B \8\:VDD VDD) g45p1hvt w=(3.9e-07) l=4.5e-08 nf=1 \
        as=6.24e-14 ad=6.24e-14 ps=1.1e-06 pd=1.1e-06 nrd=1.16667 \
        nrs=1.16667 sa=3.45e-07 sb=6.71346e-07 sd=160n sca=14.919 \
        scb=0.0137126 scc=0.000270031 m=(2)
C1 (Y VSS) capacitor c=1.43786e-16
C2 (B VSS) capacitor c=6.07611e-17
C3 (VDD VSS) capacitor c=2.43031e-16
C4 (n0 VSS) capacitor c=5.82454e-17
C5 (\1\:AN VSS) capacitor c=3.77466e-17
C6 (\3\:AN VSS) capacitor c=4.28264e-17
C7 (\6\:n0 VSS) capacitor c=6.8651e-17
C8 (\1\:B VSS) capacitor c=7.56426e-17
C9 (\4\:B VSS) capacitor c=5.22912e-17
C10 (\2\:AN VSS) capacitor c=4.29526e-17
C11 (\3\:B VSS) capacitor c=1.20981e-16
C12 (\2\:n0 VSS) capacitor c=3.69608e-16
C13 (\12\:n0 VSS) capacitor c=5.95005e-17
C14 (\1\:Y VSS) capacitor c=3.08045e-16
C15 (\8\:VDD VSS) capacitor c=6.34416e-17
C16 (\7\:n0 VSS) capacitor c=3.76398e-17
C17 (\6\:Y VSS) capacitor c=9.20654e-17
C18 (\2\:B VSS) capacitor c=4.05061e-17
C19 (\7\:B VSS) capacitor c=8.32838e-17
C20 (\9\:n0 VSS) capacitor c=7.50018e-17
C21 (\4\:AN VSS) capacitor c=3.80332e-17
C22 (\6\:AN VSS) capacitor c=1.85818e-17
Rk3 (\1\:Y Y) resistor r=0.9015 c=0
Rk5 (Y \7\:Y) resistor r=0.5334 c=0
Rk1 (\7\:B B) resistor r=0.2271 c=0
Rk18 (\2\:VSS \4\:VSS) resistor r=0.3423 c=0
Rk20 (\5\:VSS VSS) resistor r=0.1024 c=0
Rk19 (\4\:VSS \5\:VSS) resistor r=0.198 c=0
Rk21 (\5\:VSS \7\:VSS) resistor r=0.2283 c=0
Rk17 (VDD \9\:VDD) resistor r=0.2371 c=0
Rk10 (\4\:AN \5\:AN) resistor r=0.004659 c=0
Rk11 (AN \6\:AN) resistor r=0.004659 c=0
Rk12 (\4\:AN \6\:AN) resistor r=0.01774 c=0
Rk7 (\9\:n0 \2\:n0) resistor r=0.0382 c=0
Rk6 (\8\:n0 \9\:n0) resistor r=0.339 c=0
Rk9 (\9\:n0 \13\:n0) resistor r=0.4918 c=0
Rl3 (\2\:B \1\:B) resistor r=113.956 c=0
Rl5 (\2\:B \4\:B) resistor r=57.6674 c=0
Rl4 (\2\:B \3\:B) resistor r=96.1289 c=0
Rl10 (\1\:AN \2\:AN) resistor r=68.4636 c=0
Rl11 (\2\:AN \3\:AN) resistor r=126.156 c=0
Rl9 (\2\:n0 \6\:n0) resistor r=60.3072 c=0
Rl1 (\2\:n0 n0) resistor r=56.8672 c=0
Rz1 (\7\:Y \6\:Y) resistor r=37.5 c=0
Rz4 (\1\:VSS \2\:VSS) resistor r=37.5 c=0
Rz5 (\6\:VSS \7\:VSS) resistor r=37.5 c=0
Rz2 (\8\:n0 \7\:n0) resistor r=75 c=0
Ry6 (\9\:VDD \8\:VDD) resistor r=31 c=0
Ry3 (\13\:n0 \12\:n0) resistor r=62 c=0
Rx1 (\7\:B \3\:B) resistor r=45 c=0
Rx4 (\2\:AN \5\:AN) resistor r=45 c=0
mn1_1__rcx (7 n0 \6\:VSS VSS) g45n1hvt w=(2.6e-07) l=4.5e-08 nf=1 \
        as=3.64e-14 ad=1.56e-14 ps=8e-07 pd=6.4e-07 nrd=1.16667 \
        nrs=1.16667 sa=1.4e-07 sb=6.86058e-07 sd=160n sca=8.36684 \
        scb=0.00633377 scc=0.000139167 m=(1)
mn2_1__rcx (\6\:Y \4\:B 7 VSS) g45n1hvt w=(2.6e-07) l=4.5e-08 nf=1 \
        as=1.56e-14 ad=4.16e-14 ps=6.4e-07 pd=8.4e-07 nrd=1.16667 \
        nrs=1.16667 sa=2.45e-07 sb=5.81058e-07 sd=160n sca=8.36684 \
        scb=0.00633377 scc=0.000139167 m=(1)
mn2 (\6\:Y \1\:B 8 VSS) g45n1hvt w=(2.6e-07) l=4.5e-08 nf=1 as=1.56e-14 \
        ad=4.16e-14 ps=6.4e-07 pd=8.4e-07 nrd=1.16667 nrs=1.16667 \
        sa=4.5e-07 sb=3.76058e-07 sd=160n sca=8.36684 scb=0.00633377 \
        scc=0.000139167 m=(1)
mn1 (8 \6\:n0 \1\:VSS VSS) g45n1hvt w=(2.6e-07) l=4.5e-08 nf=1 \
        as=4.365e-14 ad=1.56e-14 ps=9e-07 pd=6.4e-07 nrd=1.16667 \
        nrs=1.16667 sa=5.55e-07 sb=2.71058e-07 sd=160n sca=8.36684 \
        scb=0.00633377 scc=0.000139167 m=(1)
mn0 (\7\:n0 \3\:AN \1\:VSS VSS) g45n1hvt w=(1.45e-07) l=4.5e-08 nf=1 \
        as=4.365e-14 ad=2.03e-14 ps=9e-07 pd=5.7e-07 nrd=1.16667 \
        nrs=1.16667 sa=7.9e-07 sb=1.4e-07 sd=160n sca=9.87692 \
        scb=0.0087933 scc=0.000232488 m=(1)
mp0 (\12\:n0 \1\:AN VDD VDD) g45p1hvt w=(2.15e-07) l=4.5e-08 nf=1 \
        as=6.535e-14 ad=2.69e-14 ps=1.16e-06 pd=7.1e-07 nrd=1.16667 \
        nrs=1.16667 sa=9.9e-07 sb=1.25116e-07 sd=160n sca=17.3594 \
        scb=0.0179801 scc=0.000463826 m=(1)
ends NAND2BX2
// End of subcircuit definition.
