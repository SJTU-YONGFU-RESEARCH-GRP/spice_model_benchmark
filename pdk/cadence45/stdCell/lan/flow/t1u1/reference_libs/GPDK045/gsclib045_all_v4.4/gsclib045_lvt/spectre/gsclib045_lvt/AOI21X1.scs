// gsclib045_lvt/AOI21X1/schematic

simulator lang=spectre

subckt AOI21X1 A0 A1 B0 Y VDD VSS
mp2 (Y B0 net62 VDD) g45p1lvt w=(390n) l=45n nf=1 m=(1)
mp1 (net62 A1 VDD VDD) g45p1lvt w=(390n) l=45n nf=1 m=(1)
mp0 (net62 A0 VDD VDD) g45p1lvt w=(390n) l=45n nf=1 m=(1)
mn2 (Y B0 VSS VSS) g45n1lvt w=(260n) l=45n nf=1 m=(1)
mn0 (net78 A0 VSS VSS) g45n1lvt w=(260n) l=45n nf=1 m=(1)
mn1 (Y A1 net78 VSS) g45n1lvt w=(260n) l=45n nf=1 m=(1)
ends AOI21X1
