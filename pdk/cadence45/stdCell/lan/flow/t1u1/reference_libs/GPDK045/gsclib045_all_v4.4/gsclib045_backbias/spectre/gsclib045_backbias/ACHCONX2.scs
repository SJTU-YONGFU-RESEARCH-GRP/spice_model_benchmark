// gsclib045_backbias/ACHCONX2/schematic

simulator lang=spectre

subckt ACHCONX2 A B CI CON NW VSS VDD
mn6 (n15 A VSS VSS) g45n1svt w=(390n) l=45n nf=1 m=(1)
mn10 (net0370 CI VSS VSS) g45n1svt w=(390n) l=45n nf=1 m=(1)
mn11 (n13 B VSS VSS) g45n1svt w=(390n) l=45n nf=1 m=(1)
mn7 (n12 B VSS VSS) g45n1svt w=(390n) l=45n nf=1 m=(1)
mn8 (net0370 n10 CON VSS) g45n1svt w=(390n) l=45n nf=1 m=(1)
mn3 (n9 n13 n15 VSS) g45n1svt w=(390n) l=45n nf=1 m=(1)
mn1 (n10 n13 n11 VSS) g45n1svt w=(310n) l=45n nf=1 m=(1)
mn4 (n11 B n9 VSS) g45n1svt w=(310n) l=45n nf=1 m=(1)
mn5 (n11 n15 VSS VSS) g45n1svt w=(310n) l=45n nf=1 m=(1)
mn2 (n15 B n10 VSS) g45n1svt w=(390n) l=45n nf=1 m=(1)
mn9 (n12 n9 CON VSS) g45n1svt w=(390n) l=45n nf=1 m=(1)
mp6 (n15 A VDD NW) g45p1svt w=(770n) l=45n nf=1 m=(1)
mp10 (net0370 CI VDD NW) g45p1svt w=(770n) l=45n nf=1 m=(1)
mp8 (net0370 n9 CON NW) g45p1svt w=(770n) l=45n nf=1 m=(1)
mp7 (n12 B VDD NW) g45p1svt w=(770n) l=45n nf=1 m=(1)
mp5 (n11 n15 VDD NW) g45p1svt w=(520n) l=45n nf=1 m=(1)
mp1 (n10 B n11 NW) g45p1svt w=(520n) l=45n nf=1 m=(1)
mp2 (n15 n13 n10 NW) g45p1svt w=(770n) l=45n nf=1 m=(1)
mp11 (n13 B VDD NW) g45p1svt w=(770n) l=45n nf=1 m=(1)
mp4 (n11 n13 n9 NW) g45p1svt w=(520n) l=45n nf=1 m=(1)
mp3 (n9 B n15 NW) g45p1svt w=(770n) l=45n nf=1 m=(1)
mp9 (n12 n10 CON NW) g45p1svt w=(770n) l=45n nf=1 m=(1)
ends ACHCONX2
