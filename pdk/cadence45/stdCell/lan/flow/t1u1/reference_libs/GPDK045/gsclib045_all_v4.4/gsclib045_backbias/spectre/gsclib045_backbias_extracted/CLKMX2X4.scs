// Generated for: spectre (May  1 11:28:30 2013 )
// Library name: gsclib045_backbias
// Cell name: CLKMX2X4
// View name: extracted

simulator lang=spectre

subckt CLKMX2X4 A B NW S0 VDD VSS Y
mp0 (\10\:S0b \1\:S0 \10\:VDD NW) g45p1svt w=(2.15e-07) l=4.5e-08 nf=1 \
        as=4.713e-14 ad=3.01e-14 ps=9.7e-07 pd=7.1e-07 nrd=1.16667 \
        nrs=1.16667 sa=1.4e-07 sb=1.87e-06 sd=160n sca=15.7679 \
        scb=0.0152453 scc=0.000242201 m=(1)
C1 (S0 VSS) capacitor c=1.13994e-16
C2 (Y VSS) capacitor c=4.10688e-17
C3 (VDD VSS) capacitor c=4.53739e-17
C4 (NW VSS) capacitor c=3.74731e-16
C5 (B VSS) capacitor c=6.49146e-17
C6 (S0b VSS) capacitor c=4.66755e-17
C7 (n0 VSS) capacitor c=3.24935e-16
C8 (net140 VSS) capacitor c=2.39347e-18
C9 (net123 VSS) capacitor c=3.94347e-18
C10 (net115 VSS) capacitor c=3.57588e-18
C11 (\3\:B VSS) capacitor c=5.27198e-17
C12 (\3\:S0b VSS) capacitor c=4.52502e-17
C13 (\6\:S0 VSS) capacitor c=5.23534e-17
C14 (\3\:A VSS) capacitor c=7.27047e-17
C15 (\1\:S0 VSS) capacitor c=4.28813e-17
C16 (\1\:B VSS) capacitor c=7.31339e-17
C17 (\4\:S0 VSS) capacitor c=9.0366e-17
C18 (\2\:S0b VSS) capacitor c=4.41485e-17
C19 (\1\:A VSS) capacitor c=5.83532e-17
C20 (\3\:S0 VSS) capacitor c=5.62444e-17
C21 (\4\:B VSS) capacitor c=2.82765e-17
C22 (\4\:S0b VSS) capacitor c=4.75276e-17
C23 (\5\:S0 VSS) capacitor c=9.1698e-17
C24 (\2\:A VSS) capacitor c=6.0245e-17
C25 (\2\:S0 VSS) capacitor c=5.65806e-17
C26 (\1\:VDD VSS) capacitor c=3.22982e-16
C27 (\1\:Y VSS) capacitor c=1.56525e-16
C28 (\16\:n0 VSS) capacitor c=9.01848e-17
C29 (\10\:VDD VSS) capacitor c=3.99015e-17
C30 (\10\:S0b VSS) capacitor c=1.03783e-16
C31 (\18\:n0 VSS) capacitor c=5.96136e-17
C32 (\8\:S0b VSS) capacitor c=1.32478e-17
C33 (\2\:B VSS) capacitor c=4.769e-17
C34 (\4\:A VSS) capacitor c=1.17239e-16
C35 (\8\:S0 VSS) capacitor c=9.3998e-17
C36 (\5\:S0b VSS) capacitor c=6.51227e-17
C37 (\6\:S0b VSS) capacitor c=9.60327e-17
C38 (\7\:S0b VSS) capacitor c=9.91324e-17
C39 (\5\:B VSS) capacitor c=5.32146e-17
C40 (\14\:n0 VSS) capacitor c=4.45405e-17
C41 (\15\:n0 VSS) capacitor c=1.09431e-16
C42 (\4\:Y VSS) capacitor c=7.8567e-17
C43 (\5\:VDD VSS) capacitor c=6.22292e-17
Rk2 (\7\:S0 S0) resistor r=0.002995 c=0
Rk3 (S0 \8\:S0) resistor r=0.6145 c=0
Rk13 (\1\:Y Y) resistor r=0.001906 c=0
Rk14 (Y \4\:Y) resistor r=0.3586 c=0
Rk1 (\4\:A A) resistor r=0.002995 c=0
Rk29 (\8\:VSS VSS) resistor r=0.185 c=0
Rk28 (\1\:VSS \8\:VSS) resistor r=0.3657 c=0
Rk31 (\8\:VSS \12\:VSS) resistor r=0.1864 c=0
Rk21 (\5\:VDD VDD) resistor r=0.1765 c=0
Rk20 (\1\:VDD \5\:VDD) resistor r=0.4072 c=0
Rk24 (\5\:VDD \11\:VDD) resistor r=0.1185 c=0
Rk8 (\5\:B B) resistor r=0.06791 c=0
Rk4 (\5\:S0b \6\:S0b) resistor r=0.3117 c=0
Rk5 (\6\:S0b \7\:S0b) resistor r=0.4883 c=0
Rk6 (\7\:S0b \9\:S0b) resistor r=0.05422 c=0
Rk7 (\7\:S0b \11\:S0b) resistor r=0.7841 c=0
Rk9 (\14\:n0 \15\:n0) resistor r=0.2366 c=0
Rk10 (\15\:n0 \17\:n0) resistor r=0.5687 c=0
Rk11 (\15\:n0 \19\:n0) resistor r=0.348 c=0
Rl8 (\5\:S0 \6\:S0) resistor r=74.2328 c=0
Rl7 (\4\:S0 \5\:S0) resistor r=266.862 c=0
Rl1 (\1\:S0 \2\:S0) resistor r=73.7687 c=0
Rl2 (\2\:S0 \3\:S0) resistor r=212.23 c=0
Rl4 (\2\:A \3\:A) resistor r=118.644 c=0
Rl3 (\1\:A \2\:A) resistor r=134.226 c=0
Rl10 (\2\:B \3\:B) resistor r=78.3537 c=0
Rl9 (\1\:B \2\:B) resistor r=187.375 c=0
Rl11 (\2\:B \4\:B) resistor r=5.7469 c=0
Rl6 (\3\:S0b \4\:S0b) resistor r=41.3047 c=0
Rl5 (S0b \2\:S0b) resistor r=60.6943 c=0
Rz8 (\12\:VSS \11\:VSS) resistor r=75 c=0
Rz1 (\8\:S0b \9\:S0b) resistor r=75 c=0
Rz2 (\19\:n0 \18\:n0) resistor r=75 c=0
Ry8 (\11\:VDD \10\:VDD) resistor r=62 c=0
Ry1 (\10\:S0b \11\:S0b) resistor r=62 c=0
Ry2 (\17\:n0 \16\:n0) resistor r=62 c=0
Rx2 (\2\:S0 \7\:S0) resistor r=45 c=0
Rx3 (\5\:S0 \8\:S0) resistor r=45 c=0
Rx1 (\2\:A \4\:A) resistor r=45 c=0
Rx6 (\4\:B \5\:B) resistor r=45 c=0
Rx4 (\4\:S0b \5\:S0b) resistor r=45 c=0
Rx5 (S0b \6\:S0b) resistor r=45 c=0
Rx7 (\14\:n0 n0) resistor r=45 c=0
mn0 (\8\:S0b \3\:S0 \11\:VSS VSS) g45n1svt w=(1.45e-07) l=4.5e-08 nf=1 \
        as=3.595e-14 ad=2.03e-14 ps=7.9e-07 pd=5.7e-07 nrd=1.16667 \
        nrs=1.16667 sa=1.4e-07 sb=1.87e-06 sd=160n sca=8.15925 \
        scb=0.00587019 scc=8.94977e-05 m=(1)
mn1 (net148 \1\:A \11\:VSS VSS) g45n1svt w=(2.05e-07) l=4.5e-08 nf=1 \
        as=3.595e-14 ad=3.69e-14 ps=7.9e-07 pd=7.7e-07 nrd=1.16667 \
        nrs=1.16667 sa=3.0622e-07 sb=1.635e-06 sd=160n sca=7.55029 \
        scb=0.00489727 scc=6.6688e-05 m=(1)
mn2 (\18\:n0 \2\:S0b net148 VSS) g45n1svt w=(2.05e-07) l=4.5e-08 nf=1 \
        as=3.69e-14 ad=3.28e-14 ps=7.7e-07 pd=7.3e-07 nrd=1.16667 \
        nrs=1.16667 sa=5.3122e-07 sb=1.41e-06 sd=160n sca=7.55029 \
        scb=0.00489727 scc=6.6688e-05 m=(1)
mn4 (\18\:n0 \4\:S0 net140 VSS) g45n1svt w=(2.05e-07) l=4.5e-08 nf=1 \
        as=2.46e-14 ad=3.28e-14 ps=6.5e-07 pd=7.3e-07 nrd=1.16667 \
        nrs=1.16667 sa=7.3622e-07 sb=1.205e-06 sd=160n sca=7.55029 \
        scb=0.00489727 scc=6.6688e-05 m=(1)
mn3 (net140 \1\:B \1\:VSS VSS) g45n1svt w=(2.05e-07) l=4.5e-08 nf=1 \
        as=3.83e-14 ad=2.46e-14 ps=8.4e-07 pd=6.5e-07 nrd=1.16667 \
        nrs=1.16667 sa=9.0122e-07 sb=1.04e-06 sd=160n sca=7.55029 \
        scb=0.00489727 scc=6.6688e-05 m=(1)
mn5_1__rcx (\4\:Y n0 \1\:VSS VSS) g45n1svt w=(2.6e-07) l=4.5e-08 nf=1 \
        as=3.948e-14 ad=5.2e-14 ps=8.3e-07 pd=9.2e-07 nrd=1.16667 \
        nrs=1.16667 sa=8.93365e-07 sb=8.35e-07 sd=160n sca=8.36684 \
        scb=0.00633377 scc=0.000139167 m=(4)
mp1 (net123 \3\:A \10\:VDD NW) g45p1svt w=(3.1e-07) l=4.5e-08 nf=1 \
        as=4.713e-14 ad=4.185e-14 ps=9.7e-07 pd=8.9e-07 nrd=1.16667 \
        nrs=1.16667 sa=2.80323e-07 sb=1.65e-06 sd=160n sca=12.241 \
        scb=0.00942952 scc=0.00011999 m=(1)
mp2 (\16\:n0 \6\:S0 net123 NW) g45p1svt w=(3.1e-07) l=4.5e-08 nf=1 \
        as=4.185e-14 ad=4.96e-14 ps=8.9e-07 pd=9.4e-07 nrd=1.16667 \
        nrs=1.16667 sa=4.60323e-07 sb=1.47e-06 sd=160n sca=11.1885 \
        scb=0.00841332 scc=0.000117337 m=(1)
mp4 (\16\:n0 \3\:S0b net115 NW) g45p1svt w=(3.1e-07) l=4.5e-08 nf=1 \
        as=4.65e-14 ad=4.96e-14 ps=9.2e-07 pd=9.4e-07 nrd=1.16667 \
        nrs=1.16667 sa=6.65323e-07 sb=1.265e-06 sd=160n sca=10.6105 \
        scb=0.00818197 scc=0.000117242 m=(1)
mp3 (net115 \3\:B \1\:VDD NW) g45p1svt w=(3.1e-07) l=4.5e-08 nf=1 \
        as=7.01e-14 ad=4.65e-14 ps=1.16e-06 pd=9.2e-07 nrd=1.16667 \
        nrs=1.16667 sa=8.60323e-07 sb=1.07e-06 sd=160n sca=10.5719 \
        scb=0.0081746 scc=0.000117241 m=(1)
mp5_1__rcx (\1\:Y n0 \1\:VDD NW) g45p1svt w=(3.9e-07) l=4.5e-08 nf=1 \
        as=6.238e-14 ad=7.8e-14 ps=1.105e-06 pd=1.18e-06 nrd=1.16667 \
        nrs=1.16667 sa=8.99359e-07 sb=8.35e-07 sd=160n sca=11.3866 \
        scb=0.00953811 scc=0.000231855 m=(4)
ends CLKMX2X4
// End of subcircuit definition.
