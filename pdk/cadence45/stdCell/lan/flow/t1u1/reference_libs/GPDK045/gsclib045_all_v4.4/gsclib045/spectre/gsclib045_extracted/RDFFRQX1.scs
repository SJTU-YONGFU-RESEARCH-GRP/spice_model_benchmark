// Generated for: spectre (May  1 08:12:17 2013 )
// Library name: gsclib045
// Cell name: RDFFRQX1
// View name: extracted

simulator lang=spectre

subckt RDFFRQX1 CK D ExtVDD Q RN RT VDD VSS
mp20 (\17\:CKb \4\:CK \20\:VDD VDD) g45p1svt w=(2.15e-07) l=4.5e-08 nf=1 \
        as=3.01e-14 ad=3.44e-14 ps=7.1e-07 pd=7.5e-07 nrd=1.16667 \
        nrs=1.16667 sa=3.45e-07 sb=1.4e-07 sd=160n sca=15.0986 \
        scb=0.0152901 scc=0.00103801 m=(1)
mp21 (\18\:CKbb \5\:CKb \20\:VDD VDD) g45p1svt w=(2.15e-07) l=4.5e-08 \
        nf=1 as=3.44e-14 ad=3.01e-14 ps=7.5e-07 pd=7.1e-07 nrd=1.16667 \
        nrs=1.16667 sa=1.4e-07 sb=3.45e-07 sd=160n sca=14.7851 \
        scb=0.0152025 scc=0.00103799 m=(1)
mp25 (n22 \3\:D \12\:VDD VDD) g45p1svt w=(2.15e-07) l=4.5e-08 nf=1 \
        as=3.01e-14 ad=1.29e-14 ps=7.1e-07 pd=5.5e-07 nrd=1.16667 \
        nrs=1.16667 sa=1.4e-07 sb=2.45e-07 sd=160n sca=20.3407 \
        scb=0.022946 scc=0.00119484 m=(1)
mp26 (\15\:n20 \2\:CKbb n22 VDD) g45p1svt w=(2.15e-07) l=4.5e-08 nf=1 \
        as=1.29e-14 ad=3.01e-14 ps=5.5e-07 pd=7.1e-07 nrd=1.16667 \
        nrs=1.16667 sa=2.45e-07 sb=1.4e-07 sd=160n sca=17.8768 \
        scb=0.0186195 scc=0.00106238 m=(1)
mp36 (\7\:n20 \7\:CKb n31 VDD) g45p1svt w=(2.15e-07) l=4.5e-08 nf=1 \
        as=1.29e-14 ad=3.01e-14 ps=5.5e-07 pd=7.1e-07 nrd=1.16667 \
        nrs=1.16667 sa=1.4e-07 sb=2.45e-07 sd=160n sca=6.79882 \
        scb=0.00278203 scc=1.42286e-05 m=(1)
mp35 (n31 mout \22\:VDD VDD) g45p1svt w=(2.15e-07) l=4.5e-08 nf=1 \
        as=3.01e-14 ad=1.29e-14 ps=7.1e-07 pd=5.5e-07 nrd=1.16667 \
        nrs=1.16667 sa=2.45e-07 sb=1.4e-07 sd=160n sca=6.42122 \
        scb=0.00257522 scc=1.4095e-05 m=(1)
mp32 (\17\:mout \3\:n20 net402 VDD) g45p1svt w=(2.15e-07) l=4.5e-08 nf=1 \
        as=1.29e-14 ad=3.01e-14 ps=5.5e-07 pd=7.1e-07 nrd=1.16667 \
        nrs=1.16667 sa=1.4e-07 sb=2.45e-07 sd=160n sca=6.63763 \
        scb=0.00268079 scc=1.41468e-05 m=(1)
mp31 (net402 \5\:RNb \18\:VDD VDD) g45p1svt w=(2.15e-07) l=4.5e-08 nf=1 \
        as=3.01e-14 ad=1.29e-14 ps=7.1e-07 pd=5.5e-07 nrd=1.16667 \
        nrs=1.16667 sa=2.45e-07 sb=1.4e-07 sd=160n sca=7.12147 \
        scb=0.00304089 scc=1.45946e-05 m=(1)
mp22 (\11\:RNb \4\:RN \16\:VDD VDD) g45p1svt w=(2.15e-07) l=4.5e-08 nf=1 \
        as=3.01e-14 ad=3.01e-14 ps=7.1e-07 pd=7.1e-07 nrd=1.16667 \
        nrs=1.16667 sa=1.4e-07 sb=1.4e-07 sd=160n sca=17.717 scb=0.0191019 \
        scc=0.000880768 m=(1)
mp40 (\4\:n35 \9\:CKb \5\:mout VDD) g45p1svt w=(2.15e-07) l=4.5e-08 nf=1 \
        as=3.01e-14 ad=3.01e-14 ps=7.1e-07 pd=7.1e-07 nrd=1.16667 \
        nrs=1.16667 sa=1.4e-07 sb=1.4e-07 sd=160n sca=19.7416 \
        scb=0.0214921 scc=0.00142044 m=(1)
PM0 (\6\:n35g \5\:RT \9\:n35 ExtVDD) g45p1svt w=(2.15e-07) l=4.5e-08 nf=1 \
        as=3.01e-14 ad=3.01e-14 ps=7.1e-07 pd=7.1e-07 nrd=1.16667 \
        nrs=1.16667 sa=1.4e-07 sb=1.4e-07 sd=160n sca=26.0836 \
        scb=0.0271848 scc=0.00267095 m=(1)
PM1 (\14\:qbint \3\:n35g \1\:ExtVDD ExtVDD) g45p1svt w=(2.15e-07) \
        l=4.5e-08 nf=1 as=3.5882e-13 ad=3.01e-14 ps=3.6e-06 pd=7.1e-07 \
        nrd=1.16667 nrs=1.16667 sa=1.4e-07 sb=8.7e-07 sd=160n sca=25.2796 \
        scb=0.0259458 scc=0.00265434 m=(1)
PM2 (net205 \4\:qbint \1\:ExtVDD ExtVDD) g45p1svt w=(2.15e-07) l=4.5e-08 \
        nf=1 as=3.5882e-13 ad=1.29e-14 ps=3.6e-06 pd=5.5e-07 nrd=1.16667 \
        nrs=1.16667 sa=7.65e-07 sb=2.45e-07 sd=160n sca=14.5295 \
        scb=0.0144143 scc=0.000486924 m=(1)
mp45 (\6\:RTb \6\:RT \1\:ExtVDD ExtVDD) g45p1svt w=(2.15e-07) l=4.5e-08 \
        nf=1 as=3.5882e-13 ad=3.01e-14 ps=3.6e-06 pd=7.1e-07 nrd=1.16667 \
        nrs=1.16667 sa=3.3e-07 sb=1.4e-07 sd=160n sca=24.3731 \
        scb=0.0258873 scc=0.00229004 m=(1)
PM3 (\15\:n35g \4\:RTb net205 ExtVDD) g45p1svt w=(2.15e-07) l=4.5e-08 \
        nf=1 as=1.29e-14 ad=3.01e-14 ps=5.5e-07 pd=7.1e-07 nrd=1.16667 \
        nrs=1.16667 sa=8.7e-07 sb=1.4e-07 sd=160n sca=25.2796 \
        scb=0.0259458 scc=0.00265434 m=(1)
mp53 (\14\:n35 \10\:CKbb \3\:net097 VDD) g45p1svt w=(2.15e-07) l=4.5e-08 \
        nf=1 as=3.01e-14 ad=3.01e-14 ps=7.1e-07 pd=7.1e-07 nrd=1.16667 \
        nrs=1.16667 sa=1.4e-07 sb=1.4e-07 sd=160n sca=28.502 scb=0.031227 \
        scc=0.00281308 m=(1)
mp51 (n43 \2\:RNb \14\:VDD VDD) g45p1svt w=(2.15e-07) l=4.5e-08 nf=1 \
        as=3.01e-14 ad=1.29e-14 ps=7.1e-07 pd=5.5e-07 nrd=1.16667 \
        nrs=1.16667 sa=1.4e-07 sb=2.45e-07 sd=160n sca=13.263 \
        scb=0.0113871 scc=0.000191708 m=(1)
mp52 (net097 \7\:qbint n43 VDD) g45p1svt w=(2.15e-07) l=4.5e-08 nf=1 \
        as=1.29e-14 ad=3.01e-14 ps=5.5e-07 pd=7.1e-07 nrd=1.16667 \
        nrs=1.16667 sa=2.45e-07 sb=1.4e-07 sd=160n sca=15.1571 \
        scb=0.0152095 scc=0.00032323 m=(1)
C1 (RT VSS) capacitor c=3.68527e-17
C2 (RN VSS) capacitor c=3.44319e-17
C3 (D VSS) capacitor c=5.0564e-17
C4 (VDD VSS) capacitor c=6.18502e-16
C5 (ExtVDD VSS) capacitor c=1.9061e-16
C6 (Q VSS) capacitor c=2.01112e-17
C7 (CKbb VSS) capacitor c=5.7139e-17
C8 (mout VSS) capacitor c=5.03299e-17
C9 (CKb VSS) capacitor c=2.34698e-17
C10 (n20 VSS) capacitor c=8.24366e-17
C11 (RNb VSS) capacitor c=5.65726e-17
C12 (n35g VSS) capacitor c=1.80972e-17
C13 (qbint VSS) capacitor c=4.50185e-17
C14 (RTb VSS) capacitor c=4.52604e-17
C15 (n35 VSS) capacitor c=1.81927e-16
C16 (net097 VSS) capacitor c=6.26144e-17
C17 (n40 VSS) capacitor c=7.49826e-17
C18 (\7\:qbint VSS) capacitor c=1.25822e-16
C19 (\2\:RNb VSS) capacitor c=3.01889e-16
C20 (\10\:qbint VSS) capacitor c=3.42065e-17
C21 (\10\:CKbb VSS) capacitor c=7.26025e-17
C22 (\4\:RTb VSS) capacitor c=9.89931e-17
C23 (\6\:RT VSS) capacitor c=2.34299e-17
C24 (\4\:qbint VSS) capacitor c=5.41658e-17
C25 (\3\:n35g VSS) capacitor c=6.37017e-17
C26 (\5\:RT VSS) capacitor c=8.6027e-17
C27 (\9\:CKb VSS) capacitor c=1.03808e-16
C28 (\4\:RN VSS) capacitor c=3.23917e-17
C29 (\5\:RNb VSS) capacitor c=6.43347e-17
C30 (\3\:n20 VSS) capacitor c=7.4544e-17
C31 (\4\:CK VSS) capacitor c=5.79813e-17
C32 (\5\:CKb VSS) capacitor c=2.98571e-17
C33 (\7\:CKb VSS) capacitor c=8.99496e-17
C34 (\2\:CKbb VSS) capacitor c=1.56239e-16
C35 (\3\:D VSS) capacitor c=5.64826e-17
C36 (\6\:qbint VSS) capacitor c=5.84087e-17
C37 (\11\:qbint VSS) capacitor c=4.11239e-17
C38 (\11\:CKb VSS) capacitor c=1.95986e-16
C39 (\7\:RT VSS) capacitor c=1.20065e-16
C40 (\2\:RT VSS) capacitor c=5.70341e-17
C41 (\5\:qbint VSS) capacitor c=3.87694e-17
C42 (\5\:n35g VSS) capacitor c=3.49043e-17
C43 (\2\:RTb VSS) capacitor c=5.13883e-17
C44 (\4\:CKbb VSS) capacitor c=3.43089e-17
C45 (\1\:RN VSS) capacitor c=3.43426e-17
C46 (\7\:RNb VSS) capacitor c=6.18372e-17
C47 (\1\:CK VSS) capacitor c=2.85387e-17
C48 (\6\:n20 VSS) capacitor c=6.33352e-17
C49 (\8\:CKb VSS) capacitor c=2.58532e-17
C50 (\3\:mout VSS) capacitor c=5.04497e-17
C51 (\9\:CKbb VSS) capacitor c=4.99683e-17
C52 (\4\:CKb VSS) capacitor c=8.52506e-17
C53 (\1\:D VSS) capacitor c=6.59513e-17
C54 (\9\:qbint VSS) capacitor c=8.24239e-17
C55 (\11\:CKbb VSS) capacitor c=7.35103e-17
C56 (\8\:RT VSS) capacitor c=1.52591e-16
C57 (\8\:CKbb VSS) capacitor c=1.43459e-16
C58 (\3\:RT VSS) capacitor c=5.74257e-17
C59 (\1\:RT VSS) capacitor c=4.86946e-17
C60 (\3\:RTb VSS) capacitor c=7.51381e-17
C61 (\3\:qbint VSS) capacitor c=4.44185e-17
C62 (\2\:n35 VSS) capacitor c=2.63587e-16
C63 (\4\:n35g VSS) capacitor c=7.15763e-17
C64 (\10\:CKb VSS) capacitor c=5.61759e-17
C65 (\12\:CKb VSS) capacitor c=2.31473e-16
C66 (\3\:n35 VSS) capacitor c=1.2108e-16
C67 (\6\:RNb VSS) capacitor c=8.09656e-17
C68 (\3\:RN VSS) capacitor c=4.95059e-17
C69 (\3\:CK VSS) capacitor c=2.37872e-17
C70 (\2\:mout VSS) capacitor c=3.99539e-17
C71 (\4\:mout VSS) capacitor c=3.90906e-17
C72 (\5\:n20 VSS) capacitor c=4.02932e-17
C73 (\2\:n20 VSS) capacitor c=7.16616e-17
C74 (\3\:CKbb VSS) capacitor c=8.289e-17
C75 (\7\:CKbb VSS) capacitor c=3.21327e-17
C76 (\2\:D VSS) capacitor c=5.14002e-17
C77 (\1\:VDD VSS) capacitor c=4.7404e-17
C78 (\14\:VDD VSS) capacitor c=4.92907e-17
C79 (\4\:Q VSS) capacitor c=5.60961e-17
C80 (\3\:net097 VSS) capacitor c=9.82725e-17
C81 (\14\:n35 VSS) capacitor c=4.39637e-17
C82 (\15\:n35g VSS) capacitor c=5.86348e-17
C83 (\6\:RTb VSS) capacitor c=8.46217e-17
C84 (\1\:ExtVDD VSS) capacitor c=2.81191e-16
C85 (\9\:n35 VSS) capacitor c=5.49032e-17
C86 (\14\:qbint VSS) capacitor c=7.04015e-17
C87 (\6\:n35g VSS) capacitor c=9.19037e-17
C88 (\4\:n35 VSS) capacitor c=5.58548e-17
C89 (\11\:RNb VSS) capacitor c=2.80529e-17
C90 (\5\:mout VSS) capacitor c=7.05525e-17
C91 (\16\:VDD VSS) capacitor c=5.14313e-17
C92 (\18\:VDD VSS) capacitor c=4.39791e-17
C93 (\17\:CKb VSS) capacitor c=4.55386e-17
C94 (\17\:mout VSS) capacitor c=3.49926e-17
C95 (\20\:VDD VSS) capacitor c=6.01011e-17
C96 (\22\:VDD VSS) capacitor c=4.62087e-17
C97 (\18\:CKbb VSS) capacitor c=4.10235e-17
C98 (\7\:n20 VSS) capacitor c=4.09999e-17
C99 (\15\:n20 VSS) capacitor c=6.78331e-17
C100 (\12\:VDD VSS) capacitor c=4.59893e-17
C101 (\1\:Q VSS) capacitor c=3.84311e-17
C102 (\3\:n40 VSS) capacitor c=7.8616e-17
C103 (\17\:n35 VSS) capacitor c=4.88928e-17
C104 (\11\:n35g VSS) capacitor c=2.71897e-17
C105 (\10\:RTb VSS) capacitor c=4.83839e-17
C106 (\12\:n35 VSS) capacitor c=6.15551e-17
C107 (\16\:qbint VSS) capacitor c=2.31983e-17
C108 (\9\:n35g VSS) capacitor c=7.79787e-17
C109 (\7\:n35 VSS) capacitor c=4.56768e-17
C110 (\8\:RNb VSS) capacitor c=3.97934e-17
C111 (\13\:mout VSS) capacitor c=5.53449e-17
C112 (\13\:CKb VSS) capacitor c=6.05029e-17
C113 (\15\:mout VSS) capacitor c=3.61893e-17
C114 (\14\:CKbb VSS) capacitor c=5.01255e-17
C115 (\11\:n20 VSS) capacitor c=6.1652e-17
C116 (\13\:n20 VSS) capacitor c=5.6184e-17
C117 (\2\:CK VSS) capacitor c=3.46795e-17
C118 (\4\:n20 VSS) capacitor c=6.80991e-17
C119 (\2\:CKb VSS) capacitor c=2.79517e-17
C120 (\3\:CKb VSS) capacitor c=5.75096e-17
C121 (\6\:CKb VSS) capacitor c=9.42518e-17
C122 (VDD VSS) capacitor c=2.40252e-16
C123 (\2\:n35g VSS) capacitor c=3.33134e-17
C124 (ExtVDD VSS) capacitor c=3.93909e-17
C125 (\4\:RT VSS) capacitor c=7.53549e-17
C126 (\2\:qbint VSS) capacitor c=4.17038e-17
C127 (\5\:CKbb VSS) capacitor c=1.25277e-16
C128 (\6\:CKbb VSS) capacitor c=6.33462e-17
C129 (\3\:RNb VSS) capacitor c=4.97918e-16
C130 (\4\:RNb VSS) capacitor c=1.14121e-16
C131 (\12\:CKbb VSS) capacitor c=6.33403e-17
C132 (\13\:CKbb VSS) capacitor c=7.37081e-17
C133 (\8\:qbint VSS) capacitor c=9.87855e-17
C134 (\9\:n20 VSS) capacitor c=2.98874e-17
C135 (\10\:n20 VSS) capacitor c=4.95397e-17
C136 (\17\:n20 VSS) capacitor c=3.11273e-17
C137 (\17\:CKbb VSS) capacitor c=7.43915e-17
C138 (\5\:CK VSS) capacitor c=4.80745e-17
C139 (\6\:CK VSS) capacitor c=3.69628e-17
C140 (\15\:CKb VSS) capacitor c=6.49216e-17
C141 (\16\:CKb VSS) capacitor c=4.98168e-17
C142 (\5\:RN VSS) capacitor c=4.54388e-17
C143 (\7\:mout VSS) capacitor c=5.48028e-17
C144 (\8\:mout VSS) capacitor c=4.7052e-17
C145 (\9\:mout VSS) capacitor c=1.13432e-17
C146 (\10\:mout VSS) capacitor c=2.79544e-17
C147 (\11\:mout VSS) capacitor c=1.4925e-17
C148 (\12\:mout VSS) capacitor c=2.93313e-17
C149 (\10\:RNb VSS) capacitor c=6.29319e-17
C150 (\6\:n35 VSS) capacitor c=5.94843e-17
C151 (\19\:CKb VSS) capacitor c=3.32936e-17
C152 (\20\:CKb VSS) capacitor c=3.22833e-17
C153 (\8\:n35g VSS) capacitor c=3.24371e-17
C154 (\11\:n35 VSS) capacitor c=6.19851e-17
C155 (\12\:qbint VSS) capacitor c=8.81086e-17
C156 (\13\:qbint VSS) capacitor c=1.04822e-16
C157 (\13\:n35g VSS) capacitor c=1.06138e-16
C158 (\14\:n35g VSS) capacitor c=1.16492e-16
C159 (\5\:RTb VSS) capacitor c=4.76778e-17
C160 (\8\:RTb VSS) capacitor c=8.7885e-17
C161 (\9\:RTb VSS) capacitor c=5.17894e-17
C162 (\20\:CKbb VSS) capacitor c=9.69371e-17
C163 (\21\:CKbb VSS) capacitor c=9.42263e-17
C164 (\18\:qbint VSS) capacitor c=1.9823e-17
C165 (\19\:qbint VSS) capacitor c=2.98898e-17
C166 (\9\:RT VSS) capacitor c=1.0657e-16
C167 (\10\:RT VSS) capacitor c=1.18623e-16
C168 (\11\:RT VSS) capacitor c=5.39254e-17
C169 (\16\:n35 VSS) capacitor c=4.41844e-17
C170 (\3\:Q VSS) capacitor c=1.51619e-17
C171 (\3\:VDD VSS) capacitor c=4.01819e-17
C172 (\5\:VDD VSS) capacitor c=1.31179e-16
C173 (\6\:VDD VSS) capacitor c=6.01292e-17
C174 (\7\:VDD VSS) capacitor c=8.26296e-18
C175 (\9\:VDD VSS) capacitor c=2.17008e-17
C176 (\10\:VDD VSS) capacitor c=1.47348e-17
C177 (\11\:VDD VSS) capacitor c=2.36856e-17
Rk53 (RT \9\:RT) resistor r=0.1902 c=0
Rk54 (\9\:RT \10\:RT) resistor r=0.6402 c=0
Rk55 (RT \11\:RT) resistor r=0.008131 c=0
Rk17 (RN \5\:RN) resistor r=0.0381 c=0
Rk2 (\4\:D D) resistor r=0.006804 c=0
Rk88 (\2\:VDD \3\:VDD) resistor r=0.4044 c=0
Rk90 (\5\:VDD VDD) resistor r=1.0522 c=0
Rk89 (\3\:VDD \5\:VDD) resistor r=0.06659 c=0
Rk91 (VDD \6\:VDD) resistor r=0.6271 c=0
Rk92 (\6\:VDD \7\:VDD) resistor r=0.0293 c=0
Rk93 (\7\:VDD \9\:VDD) resistor r=0.1012 c=0
Rk94 (\9\:VDD \10\:VDD) resistor r=0.08885 c=0
Rk96 (\11\:VDD VDD) resistor r=0.195 c=0
Rk95 (\10\:VDD \11\:VDD) resistor r=0.08124 c=0
Rk97 (VDD \13\:VDD) resistor r=0.5101 c=0
Rk98 (\3\:VDD \15\:VDD) resistor r=0.2921 c=0
Rk99 (\6\:VDD \17\:VDD) resistor r=0.3582 c=0
Rk100 (\7\:VDD \19\:VDD) resistor r=0.201 c=0
Rk101 (\10\:VDD \21\:VDD) resistor r=0.3788 c=0
Rk102 (\11\:VDD \23\:VDD) resistor r=0.201 c=0
Rk38 (ExtVDD ExtVDD) resistor r=0.002057 c=0
Rk36 (\2\:ExtVDD ExtVDD) resistor r=0.0221 c=0
Rk39 (ExtVDD \5\:ExtVDD) resistor r=0.0201 c=0
Rk40 (ExtVDD \6\:ExtVDD) resistor r=0.1054 c=0
Rk11 (CK \5\:CK) resistor r=0.004344 c=0
Rk13 (\5\:CK \6\:CK) resistor r=0.01403 c=0
Rk12 (\6\:CK \7\:CK) resistor r=0.004525 c=0
Rk59 (\3\:Q Q) resistor r=0.003941 c=0
Rk58 (\2\:Q \3\:Q) resistor r=0.2887 c=0
Rk60 (\3\:Q \5\:Q) resistor r=0.3259 c=0
Rk63 (\2\:VSS \4\:VSS) resistor r=0.3543 c=0
Rk64 (\4\:VSS \5\:VSS) resistor r=0.08885 c=0
Rk67 (\6\:VSS VSS) resistor r=0.3961 c=0
Rk65 (\5\:VSS \6\:VSS) resistor r=0.7025 c=0
Rk66 (\5\:VSS \8\:VSS) resistor r=0.2456 c=0
Rk68 (VSS \9\:VSS) resistor r=0.705 c=0
Rk70 (\10\:VSS VSS) resistor r=0.121 c=0
Rk69 (\9\:VSS \10\:VSS) resistor r=0.08638 c=0
Rk71 (VSS \12\:VSS) resistor r=0.2962 c=0
Rk72 (\6\:VSS \14\:VSS) resistor r=0.2882 c=0
Rk73 (\9\:VSS \16\:VSS) resistor r=0.2393 c=0
Rk74 (\18\:VSS \20\:VSS) resistor r=0.3052 c=0
Rk75 (\20\:VSS \21\:VSS) resistor r=0.7921 c=0
Rk76 (\21\:VSS \22\:VSS) resistor r=0.06659 c=0
Rk77 (\22\:VSS \24\:VSS) resistor r=0.1887 c=0
Rk80 (\25\:VSS VSS) resistor r=0.1208 c=0
Rk78 (\22\:VSS \25\:VSS) resistor r=0.2074 c=0
Rk79 (\25\:VSS \27\:VSS) resistor r=0.1938 c=0
Rk81 (VSS \28\:VSS) resistor r=0.6283 c=0
Rk82 (\28\:VSS \30\:VSS) resistor r=0.2353 c=0
Rk84 (\31\:VSS VSS) resistor r=0.01954 c=0
Rk83 (\28\:VSS \31\:VSS) resistor r=0.1631 c=0
Rk85 (VSS \32\:VSS) resistor r=0.03716 c=0
Rk86 (\32\:VSS \34\:VSS) resistor r=0.2358 c=0
Rk87 (\32\:VSS \36\:VSS) resistor r=0.6564 c=0
Rk1 (\12\:CKbb \13\:CKbb) resistor r=0.6826 c=0
Rk8 (\15\:CKbb \16\:CKbb) resistor r=0.3389 c=0
Rk9 (\16\:CKbb \17\:CKbb) resistor r=0.0151 c=0
Rk10 (\16\:CKbb \19\:CKbb) resistor r=0.2128 c=0
Rk51 (\20\:CKbb \21\:CKbb) resistor r=0.7171 c=0
Rk18 (\6\:mout \7\:mout) resistor r=0.4253 c=0
Rk19 (\7\:mout \8\:mout) resistor r=0.3621 c=0
Rk20 (\8\:mout \9\:mout) resistor r=0.1413 c=0
Rk21 (\9\:mout \10\:mout) resistor r=0.1929 c=0
Rk22 (\7\:mout \11\:mout) resistor r=0.1185 c=0
Rk23 (\11\:mout \12\:mout) resistor r=0.2157 c=0
Rk24 (\8\:mout \14\:mout) resistor r=0.3227 c=0
Rk25 (\9\:mout \16\:mout) resistor r=0.1036 c=0
Rk26 (\11\:mout \18\:mout) resistor r=0.1202 c=0
Rk14 (\14\:CKb \15\:CKb) resistor r=0.3397 c=0
Rk15 (\15\:CKb \16\:CKb) resistor r=0.1628 c=0
Rk16 (\15\:CKb \18\:CKb) resistor r=0.2061 c=0
Rk31 (\19\:CKb \20\:CKb) resistor r=0.2958 c=0
Rk3 (\8\:n20 \9\:n20) resistor r=0.2062 c=0
Rk4 (\8\:n20 \10\:n20) resistor r=0.2091 c=0
Rk5 (\10\:n20 \12\:n20) resistor r=0.4399 c=0
Rk6 (\14\:n20 \16\:n20) resistor r=0.4876 c=0
Rk7 (\16\:n20 \17\:n20) resistor r=0.1574 c=0
Rk27 (\9\:RNb \10\:RNb) resistor r=0.3424 c=0
Rk28 (\10\:RNb \12\:RNb) resistor r=0.1478 c=0
Rk32 (\7\:n35g \8\:n35g) resistor r=0.2401 c=0
Rk33 (\7\:n35g \10\:n35g) resistor r=0.6898 c=0
Rk44 (\12\:n35g \13\:n35g) resistor r=0.2424 c=0
Rk45 (\13\:n35g \14\:n35g) resistor r=0.5641 c=0
Rk46 (\13\:n35g \16\:n35g) resistor r=0.4309 c=0
Rk41 (\12\:qbint \13\:qbint) resistor r=0.4933 c=0
Rk42 (\13\:qbint \15\:qbint) resistor r=0.5658 c=0
Rk43 (\13\:qbint \17\:qbint) resistor r=0.1459 c=0
Rk52 (\18\:qbint \19\:qbint) resistor r=0.2113 c=0
Rk47 (\5\:RTb \7\:RTb) resistor r=0.2157 c=0
Rk48 (\7\:RTb \8\:RTb) resistor r=0.5203 c=0
Rk49 (\8\:RTb \9\:RTb) resistor r=0.3878 c=0
Rk50 (\8\:RTb \11\:RTb) resistor r=0.2011 c=0
Rk29 (\5\:n35 \6\:n35) resistor r=0.3193 c=0
Rk30 (\6\:n35 \8\:n35) resistor r=0.4233 c=0
Rk34 (\10\:n35 \11\:n35) resistor r=0.3178 c=0
Rk35 (\11\:n35 \13\:n35) resistor r=0.3869 c=0
Rk56 (\15\:n35 \16\:n35) resistor r=0.2315 c=0
Rk57 (\16\:n35 \18\:n35) resistor r=0.3583 c=0
Rk62 (\2\:net097 \4\:net097) resistor r=0.7055 c=0
Rk61 (\2\:n40 \4\:n40) resistor r=0.6241 c=0
Rl45 (\7\:RT \8\:RT) resistor r=650.933 c=0
Rl32 (\1\:RT \2\:RT) resistor r=169.515 c=0
Rl35 (\4\:RT \6\:RT) resistor r=21.372 c=0
Rl34 (\4\:RT \5\:RT) resistor r=264.027 c=0
Rl33 (\3\:RT \4\:RT) resistor r=96.114 c=0
Rl16 (\2\:RN \4\:RN) resistor r=62.3411 c=0
Rl14 (\1\:RN \2\:RN) resistor r=152.726 c=0
Rl15 (\2\:RN \3\:RN) resistor r=0.6051 c=0
Rl2 (\2\:D \3\:D) resistor r=43.4636 c=0
Rl1 (\1\:D \2\:D) resistor r=135.391 c=0
Rl10 (\2\:CK \4\:CK) resistor r=147.791 c=0
Rl8 (\1\:CK \2\:CK) resistor r=63.1757 c=0
Rl9 (\2\:CK \3\:CK) resistor r=2.0166 c=0
Rl48 (\10\:CKbb \11\:CKbb) resistor r=159.438 c=0
Rl4 (CKbb \2\:CKbb) resistor r=172.517 c=0
Rl5 (\2\:CKbb \3\:CKbb) resistor r=349.426 c=0
Rl40 (\4\:CKbb \5\:CKbb) resistor r=66.1349 c=0
Rl43 (\5\:CKbb \8\:CKbb) resistor r=820.277 c=0
Rl44 (\6\:CKbb \9\:CKbb) resistor r=66.8717 c=0
Rl42 (\6\:CKbb \7\:CKbb) resistor r=132.647 c=0
Rl41 (\5\:CKbb \6\:CKbb) resistor r=339.792 c=0
Rl6 (mout \2\:mout) resistor r=24.2328 c=0
Rl7 (\3\:mout \4\:mout) resistor r=24.2328 c=0
Rl25 (\9\:CKb \10\:CKb) resistor r=177.372 c=0
Rl49 (\11\:CKb \12\:CKb) resistor r=908.226 c=0
Rl20 (\2\:CKb \5\:CKb) resistor r=60.4181 c=0
Rl17 (CKb \2\:CKb) resistor r=1.2334 c=0
Rl23 (\3\:CKb \8\:CKb) resistor r=69.2058 c=0
Rl19 (\3\:CKb \4\:CKb) resistor r=236.258 c=0
Rl18 (\2\:CKb \3\:CKb) resistor r=75.7777 c=0
Rl24 (\6\:CKb \9\:CKb) resistor r=422.837 c=0
Rl21 (\5\:CKb \6\:CKb) resistor r=86.9066 c=0
Rl22 (\6\:CKb \7\:CKb) resistor r=236.429 c=0
Rl3 (n20 \2\:n20) resistor r=205.495 c=0
Rl11 (\3\:n20 \4\:n20) resistor r=154.568 c=0
Rl13 (\4\:n20 \6\:n20) resistor r=191.976 c=0
Rl12 (\4\:n20 \5\:n20) resistor r=128.737 c=0
Rl50 (RNb \2\:RNb) resistor r=234.8 c=0
Rl51 (\2\:RNb \3\:RNb) resistor r=1125.6 c=0
Rl54 (\3\:RNb \6\:RNb) resistor r=707.521 c=0
Rl53 (\4\:RNb \5\:RNb) resistor r=106.884 c=0
Rl55 (\4\:RNb \7\:RNb) resistor r=197.09 c=0
Rl52 (\3\:RNb \4\:RNb) resistor r=336.011 c=0
Rl28 (\3\:n35g \4\:n35g) resistor r=250.512 c=0
Rl27 (\2\:n35g \3\:n35g) resistor r=181.74 c=0
Rl29 (\2\:n35g \5\:n35g) resistor r=94.1963 c=0
Rl26 (n35g \2\:n35g) resistor r=2.4834 c=0
Rl56 (\6\:qbint \7\:qbint) resistor r=237.758 c=0
Rl60 (\10\:qbint \11\:qbint) resistor r=149.805 c=0
Rl39 (\3\:qbint \5\:qbint) resistor r=35.3072 c=0
Rl38 (\2\:qbint \4\:qbint) resistor r=70.093 c=0
Rl36 (qbint \2\:qbint) resistor r=112.732 c=0
Rl37 (\2\:qbint \3\:qbint) resistor r=152.601 c=0
Rl57 (\7\:qbint \8\:qbint) resistor r=252.339 c=0
Rl59 (\8\:qbint \10\:qbint) resistor r=60.508 c=0
Rl58 (\8\:qbint \9\:qbint) resistor r=419.685 c=0
Rl31 (\3\:RTb \4\:RTb) resistor r=239.402 c=0
Rl30 (RTb \2\:RTb) resistor r=121.113 c=0
Rl46 (n35 \2\:n35) resistor r=508.667 c=0
Rl47 (\2\:n35 \3\:n35) resistor r=358.667 c=0
Rz16 (\1\:Q \2\:Q) resistor r=37.5 c=0
Rz19 (\1\:VSS \2\:VSS) resistor r=75 c=0
Rz20 (\7\:VSS \8\:VSS) resistor r=75 c=0
Rz21 (\11\:VSS \12\:VSS) resistor r=75 c=0
Rz22 (\13\:VSS \14\:VSS) resistor r=75 c=0
Rz23 (\15\:VSS \16\:VSS) resistor r=75 c=0
Rz24 (\17\:VSS \18\:VSS) resistor r=37.5 c=0
Rz25 (\23\:VSS \24\:VSS) resistor r=75 c=0
Rz26 (\26\:VSS \27\:VSS) resistor r=75 c=0
Rz27 (\29\:VSS \30\:VSS) resistor r=75 c=0
Rz28 (\33\:VSS \34\:VSS) resistor r=75 c=0
Rz29 (\35\:VSS \36\:VSS) resistor r=75 c=0
Rz3 (\14\:CKbb \15\:CKbb) resistor r=75 c=0
Rz5 (\13\:mout \14\:mout) resistor r=75 c=0
Rz6 (\15\:mout \16\:mout) resistor r=75 c=0
Rz4 (\13\:CKb \14\:CKb) resistor r=75 c=0
Rz1 (\11\:n20 \12\:n20) resistor r=75 c=0
Rz2 (\13\:n20 \14\:n20) resistor r=75 c=0
Rz7 (\8\:RNb \9\:RNb) resistor r=75 c=0
Rz9 (\9\:n35g \10\:n35g) resistor r=75 c=0
Rz13 (\11\:n35g \12\:n35g) resistor r=75 c=0
Rz12 (\16\:qbint \17\:qbint) resistor r=75 c=0
Rz14 (\10\:RTb \11\:RTb) resistor r=75 c=0
Rz8 (\7\:n35 \8\:n35) resistor r=75 c=0
Rz10 (\12\:n35 \13\:n35) resistor r=75 c=0
Rz15 (\17\:n35 \18\:n35) resistor r=75 c=0
Rz17 (n40 \2\:n40) resistor r=75 c=0
Rz18 (\3\:n40 \4\:n40) resistor r=75 c=0
Ry27 (\1\:VDD \2\:VDD) resistor r=20.6667 c=0
Ry28 (\12\:VDD \13\:VDD) resistor r=62 c=0
Ry29 (\14\:VDD \15\:VDD) resistor r=62 c=0
Ry30 (\16\:VDD \17\:VDD) resistor r=62 c=0
Ry31 (\18\:VDD \19\:VDD) resistor r=62 c=0
Ry32 (\20\:VDD \21\:VDD) resistor r=62 c=0
Ry33 (\22\:VDD \23\:VDD) resistor r=62 c=0
Ry11 (\1\:ExtVDD \2\:ExtVDD) resistor r=62 c=0
Ry12 (\1\:ExtVDD \5\:ExtVDD) resistor r=62 c=0
Ry13 (\1\:ExtVDD \6\:ExtVDD) resistor r=62 c=0
Ry18 (\4\:Q \5\:Q) resistor r=20.6667 c=0
Ry21 (\3\:VSS \4\:VSS) resistor r=15.5 c=0
Ry22 (\3\:VSS \6\:VSS) resistor r=5.1667 c=0
Ry23 (\3\:VSS \10\:VSS) resistor r=5.1667 c=0
Ry24 (\19\:VSS \20\:VSS) resistor r=15.5 c=0
Ry25 (\19\:VSS \21\:VSS) resistor r=5.1667 c=0
Ry26 (\19\:VSS \31\:VSS) resistor r=5.1667 c=0
Ry3 (\18\:CKbb \19\:CKbb) resistor r=62 c=0
Ry5 (\5\:mout \6\:mout) resistor r=62 c=0
Ry6 (\17\:mout \18\:mout) resistor r=62 c=0
Ry4 (\17\:CKb \18\:CKb) resistor r=62 c=0
Ry1 (\7\:n20 \8\:n20) resistor r=62 c=0
Ry2 (\15\:n20 \16\:n20) resistor r=62 c=0
Ry7 (\11\:RNb \12\:RNb) resistor r=62 c=0
Ry9 (\6\:n35g \7\:n35g) resistor r=62 c=0
Ry15 (\15\:n35g \16\:n35g) resistor r=62 c=0
Ry14 (\14\:qbint \15\:qbint) resistor r=62 c=0
Ry16 (\6\:RTb \7\:RTb) resistor r=62 c=0
Ry8 (\4\:n35 \5\:n35) resistor r=62 c=0
Ry10 (\9\:n35 \10\:n35) resistor r=62 c=0
Ry17 (\14\:n35 \15\:n35) resistor r=62 c=0
Ry19 (net097 \2\:net097) resistor r=62 c=0
Ry20 (\3\:net097 \4\:net097) resistor r=62 c=0
Rx27 (\3\:RT \9\:RT) resistor r=45 c=0
Rx28 (\1\:RT \10\:RT) resistor r=45 c=0
Rx29 (\8\:RT \11\:RT) resistor r=45 c=0
Rx10 (\3\:RN \5\:RN) resistor r=45 c=0
Rx3 (\2\:D \4\:D) resistor r=45 c=0
Rx8 (\3\:CK \7\:CK) resistor r=45 c=0
Rx1 (\3\:CKbb \12\:CKbb) resistor r=45 c=0
Rx2 (\7\:CKbb \13\:CKbb) resistor r=45 c=0
Rx7 (CKbb \17\:CKbb) resistor r=45 c=0
Rx23 (\11\:CKbb \20\:CKbb) resistor r=45 c=0
Rx24 (\8\:CKbb \21\:CKbb) resistor r=45 c=0
Rx11 (\4\:mout \10\:mout) resistor r=45 c=0
Rx12 (\2\:mout \12\:mout) resistor r=45 c=0
Rx9 (CKb \16\:CKb) resistor r=45 c=0
Rx15 (\10\:CKb \19\:CKb) resistor r=45 c=0
Rx16 (\12\:CKb \20\:CKb) resistor r=45 c=0
Rx4 (\2\:n20 \9\:n20) resistor r=45 c=0
Rx5 (\5\:n20 \10\:n20) resistor r=45 c=0
Rx6 (n20 \17\:n20) resistor r=45 c=0
Rx13 (\6\:RNb \10\:RNb) resistor r=45 c=0
Rx17 (\4\:n35g \8\:n35g) resistor r=45 c=0
Rx20 (n35g \14\:n35g) resistor r=45 c=0
Rx19 (\3\:qbint \12\:qbint) resistor r=45 c=0
Rx25 (\9\:qbint \18\:qbint) resistor r=45 c=0
Rx26 (qbint \19\:qbint) resistor r=45 c=0
Rx21 (\3\:RTb \5\:RTb) resistor r=45 c=0
Rx22 (RTb \9\:RTb) resistor r=45 c=0
Rx14 (\3\:n35 \6\:n35) resistor r=45 c=0
Rx18 (\2\:n35 \11\:n35) resistor r=45 c=0
Rx30 (n35 \16\:n35) resistor r=45 c=0
mn26 (\13\:n20 \4\:CKb n21 VSS) g45n1svt w=(1.45e-07) l=4.5e-08 nf=1 \
        as=8.7e-15 ad=2.03e-14 ps=4.1e-07 pd=5.7e-07 nrd=1.16667 \
        nrs=1.16667 sa=2.45e-07 sb=1.4e-07 sd=160n sca=8.0352 \
        scb=0.00565402 scc=8.19771e-05 m=(1)
mn25 (n21 \1\:D \35\:VSS VSS) g45n1svt w=(1.45e-07) l=4.5e-08 nf=1 \
        as=2.03e-14 ad=8.7e-15 ps=5.7e-07 pd=4.1e-07 nrd=1.16667 \
        nrs=1.16667 sa=2.45e-07 sb=1.4e-07 sd=160n sca=8.0352 \
        scb=0.00565402 scc=8.19771e-05 m=(1)
NM3 (net0121 \5\:qbint \23\:VSS VSS) g45n1svt w=(1.45e-07) l=4.5e-08 \
        nf=1 as=8.7e-15 ad=2.03e-14 ps=4.1e-07 pd=5.7e-07 nrd=1.16667 \
        nrs=1.16667 sa=1.4e-07 sb=2.45e-07 sd=160n sca=9.33388 \
        scb=0.00788941 scc=0.00017958 m=(1)
mn35 (n30 \3\:mout \11\:VSS VSS) g45n1svt w=(1.45e-07) l=4.5e-08 nf=1 \
        as=2.32e-14 ad=8.7e-15 ps=6.1e-07 pd=4.1e-07 nrd=1.16667 \
        nrs=1.16667 sa=2.45e-07 sb=3.45e-07 sd=160n sca=8.42104 \
        scb=0.00632542 scc=0.000106623 m=(1)
mn52 (n40 \6\:qbint \1\:VSS VSS) g45n1svt w=(1.45e-07) l=4.5e-08 nf=1 \
        as=2.03e-14 ad=2.32e-14 ps=5.7e-07 pd=6.1e-07 nrd=1.16667 \
        nrs=1.16667 sa=3.45e-07 sb=1.4e-07 sd=160n sca=8.42104 \
        scb=0.00632542 scc=0.000106623 m=(1)
mn51 (n40 RNb \7\:VSS VSS) g45n1svt w=(1.45e-07) l=4.5e-08 nf=1 \
        as=2.32e-14 ad=2.03e-14 ps=6.1e-07 pd=5.7e-07 nrd=1.16667 \
        nrs=1.16667 sa=1.4e-07 sb=3.45e-07 sd=160n sca=8.42104 \
        scb=0.00632542 scc=0.000106623 m=(1)
mn36 (\11\:n20 \9\:CKbb n30 VSS) g45n1svt w=(1.45e-07) l=4.5e-08 nf=1 \
        as=8.7e-15 ad=2.03e-14 ps=4.1e-07 pd=5.7e-07 nrd=1.16667 \
        nrs=1.16667 sa=1.4e-07 sb=4.5e-07 sd=160n sca=8.42104 \
        scb=0.00632542 scc=0.000106623 m=(1)
mn21 (\14\:CKbb \8\:CKb \33\:VSS VSS) g45n1svt w=(1.45e-07) l=4.5e-08 \
        nf=1 as=2.32e-14 ad=2.03e-14 ps=6.1e-07 pd=5.7e-07 nrd=1.16667 \
        nrs=1.16667 sa=1.4e-07 sb=3.45e-07 sd=160n sca=8.0352 \
        scb=0.00565402 scc=8.19771e-05 m=(1)
mn32 (\15\:mout \6\:n20 \11\:VSS VSS) g45n1svt w=(1.45e-07) l=4.5e-08 \
        nf=1 as=2.32e-14 ad=2.03e-14 ps=6.1e-07 pd=5.7e-07 nrd=1.16667 \
        nrs=1.16667 sa=4.5e-07 sb=1.4e-07 sd=160n sca=8.42104 \
        scb=0.00632542 scc=0.000106623 m=(1)
mn20 (\13\:CKb \1\:CK \33\:VSS VSS) g45n1svt w=(1.45e-07) l=4.5e-08 nf=1 \
        as=2.32e-14 ad=2.03e-14 ps=6.1e-07 pd=5.7e-07 nrd=1.16667 \
        nrs=1.16667 sa=3.45e-07 sb=1.4e-07 sd=160n sca=8.0352 \
        scb=0.00565402 scc=8.19771e-05 m=(1)
mn31 (\13\:mout \7\:RNb \15\:VSS VSS) g45n1svt w=(1.45e-07) l=4.5e-08 \
        nf=1 as=2.03e-14 ad=2.32e-14 ps=5.7e-07 pd=6.1e-07 nrd=1.16667 \
        nrs=1.16667 sa=1.4e-07 sb=3.45e-07 sd=160n sca=8.42104 \
        scb=0.00632542 scc=0.000106623 m=(1)
mn22 (\8\:RNb \1\:RN \29\:VSS VSS) g45n1svt w=(1.45e-07) l=4.5e-08 nf=1 \
        as=2.03e-14 ad=2.03e-14 ps=5.7e-07 pd=5.7e-07 nrd=1.16667 \
        nrs=1.16667 sa=1.4e-07 sb=1.4e-07 sd=160n sca=8.0352 \
        scb=0.00565402 scc=8.19771e-05 m=(1)
mn40 (\7\:n35 \4\:CKbb \13\:mout VSS) g45n1svt w=(1.45e-07) l=4.5e-08 \
        nf=1 as=2.32e-14 ad=2.03e-14 ps=6.1e-07 pd=5.7e-07 nrd=1.16667 \
        nrs=1.16667 sa=3.45e-07 sb=1.4e-07 sd=160n sca=8.42104 \
        scb=0.00632542 scc=0.000106623 m=(1)
NM0 (\9\:n35g \2\:RTb \12\:n35 VSS) g45n1svt w=(1.45e-07) l=4.5e-08 nf=1 \
        as=2.03e-14 ad=2.03e-14 ps=5.7e-07 pd=5.7e-07 nrd=1.16667 \
        nrs=1.16667 sa=1.4e-07 sb=1.4e-07 sd=160n sca=8.42104 \
        scb=0.00632542 scc=0.000106623 m=(1)
NM1 (\16\:qbint \5\:n35g \26\:VSS VSS) g45n1svt w=(1.45e-07) l=4.5e-08 \
        nf=1 as=2.03e-14 ad=2.03e-14 ps=5.7e-07 pd=5.7e-07 nrd=1.16667 \
        nrs=1.16667 sa=1.4e-07 sb=1.4e-07 sd=160n sca=9.33388 \
        scb=0.00788941 scc=0.00017958 m=(1)
mn45 (\10\:RTb \2\:RT \13\:VSS VSS) g45n1svt w=(1.45e-07) l=4.5e-08 nf=1 \
        as=2.03e-14 ad=2.03e-14 ps=5.7e-07 pd=5.7e-07 nrd=1.16667 \
        nrs=1.16667 sa=1.4e-07 sb=1.4e-07 sd=160n sca=8.42104 \
        scb=0.00632542 scc=0.000106623 m=(1)
NM2 (\11\:n35g \7\:RT net0121 VSS) g45n1svt w=(1.45e-07) l=4.5e-08 nf=1 \
        as=8.7e-15 ad=2.03e-14 ps=4.1e-07 pd=5.7e-07 nrd=1.16667 \
        nrs=1.16667 sa=2.45e-07 sb=1.4e-07 sd=160n sca=9.33388 \
        scb=0.00788941 scc=0.00017958 m=(1)
mn53 (\17\:n35 \11\:CKb \3\:n40 VSS) g45n1svt w=(1.45e-07) l=4.5e-08 nf=1 \
        as=2.03e-14 ad=2.03e-14 ps=5.7e-07 pd=5.7e-07 nrd=1.16667 \
        nrs=1.16667 sa=1.4e-07 sb=1.4e-07 sd=160n sca=8.42104 \
        scb=0.00632542 scc=0.000106623 m=(1)
mn55 (\1\:Q \11\:qbint \17\:VSS VSS) g45n1svt w=(2.6e-07) l=4.5e-08 nf=1 \
        as=3.64e-14 ad=3.64e-14 ps=8e-07 pd=8e-07 nrd=1.16667 nrs=1.16667 \
        sa=1.4e-07 sb=1.4e-07 sd=160n sca=9.50447 scb=0.0081528 \
        scc=0.00025289 m=(1)
mp55 (\4\:Q \10\:qbint \1\:VDD VDD) g45p1svt w=(3.9e-07) l=4.5e-08 nf=1 \
        as=5.46e-14 ad=5.46e-14 ps=1.06e-06 pd=1.06e-06 nrd=1.16667 \
        nrs=1.16667 sa=1.4e-07 sb=1.4e-07 sd=160n sca=20.1325 \
        scb=0.0179115 scc=0.00149096 m=(1)
ends RDFFRQX1
// End of subcircuit definition.
