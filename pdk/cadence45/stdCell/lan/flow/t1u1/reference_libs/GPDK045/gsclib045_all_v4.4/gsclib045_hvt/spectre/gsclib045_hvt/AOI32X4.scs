// gsclib045_hvt/AOI32X4/schematic

simulator lang=spectre

subckt AOI32X4 A0 A1 A2 B0 B1 Y VDD VSS
mp3 (Y B0 net106 VDD) g45p1hvt w=(1.56u) l=45n nf=1 m=(1)
mp4 (Y B1 net106 VDD) g45p1hvt w=(1.56u) l=45n nf=1 m=(1)
mp2 (net106 A2 VDD VDD) g45p1hvt w=(1.56u) l=45n nf=1 m=(1)
mp1 (net106 A1 VDD VDD) g45p1hvt w=(1.56u) l=45n nf=1 m=(1)
mp0 (net106 A0 VDD VDD) g45p1hvt w=(1.56u) l=45n nf=1 m=(1)
mn3 (net118 B0 VSS VSS) g45n1hvt w=(1.04u) l=45n nf=1 m=(1)
mn2 (Y A2 net126 VSS) g45n1hvt w=(1.04u) l=45n nf=1 m=(1)
mn0 (net122 A0 VSS VSS) g45n1hvt w=(1.04u) l=45n nf=1 m=(1)
mn1 (net126 A1 net122 VSS) g45n1hvt w=(1.04u) l=45n nf=1 m=(1)
mn4 (Y B1 net118 VSS) g45n1hvt w=(1.04u) l=45n nf=1 m=(1)
ends AOI32X4
