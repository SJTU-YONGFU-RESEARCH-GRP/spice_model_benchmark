// Generated for: spectre (May  1 09:14:43 2013 )
// Library name: gsclib045_lvt
// Cell name: SDFFQX2
// View name: extracted

simulator lang=spectre

subckt SDFFQX2 CK D Q SE SI VDD VSS
mp55 (\1\:Q qbint VDD VDD) g45p1lvt w=(3.9e-07) l=4.5e-08 nf=1 \
        as=6.131e-14 ad=6.24e-14 ps=1.155e-06 pd=1.1e-06 nrd=1.16667 \
        nrs=1.16667 sa=1.4e-07 sb=5.03462e-07 sd=160n sca=41.3017 \
        scb=0.035902 scc=0.00422214 m=(2)
C1 (D VSS) capacitor c=8.23404e-17
C2 (Q VSS) capacitor c=9.95983e-18
C3 (VDD VSS) capacitor c=4.15132e-16
C4 (CK VSS) capacitor c=6.14053e-17
C5 (SE VSS) capacitor c=7.29167e-17
C6 (SI VSS) capacitor c=9.16053e-17
C7 (qbint VSS) capacitor c=1.56826e-16
C8 (CKb VSS) capacitor c=4.46433e-17
C9 (n30 VSS) capacitor c=3.13291e-17
C10 (n7 VSS) capacitor c=4.3707e-18
C11 (mout VSS) capacitor c=7.98878e-17
C12 (CKbb VSS) capacitor c=2.24207e-17
C13 (n20 VSS) capacitor c=3.98344e-17
C14 (Db VSS) capacitor c=9.89004e-17
C15 (n1 VSS) capacitor c=8.18964e-18
C16 (SEb VSS) capacitor c=4.61206e-17
C17 (n8 VSS) capacitor c=7.52667e-18
C18 (\7\:SE VSS) capacitor c=5.30738e-17
C19 (\3\:SI VSS) capacitor c=6.70719e-17
C20 (\1\:SE VSS) capacitor c=4.09547e-17
C21 (\1\:D VSS) capacitor c=4.77043e-17
C22 (\5\:CKb VSS) capacitor c=6.60561e-17
C23 (\6\:CKbb VSS) capacitor c=3.80815e-17
C24 (\8\:CKb VSS) capacitor c=7.29569e-17
C25 (\3\:CKb VSS) capacitor c=5.08638e-17
C26 (\3\:CKbb VSS) capacitor c=5.04766e-17
C27 (\8\:qbint VSS) capacitor c=3.17411e-17
C28 (\3\:n30 VSS) capacitor c=5.20787e-17
C29 (\1\:CK VSS) capacitor c=4.31994e-17
C30 (\5\:SE VSS) capacitor c=2.69637e-17
C31 (\1\:SI VSS) capacitor c=6.6106e-17
C32 (\3\:SE VSS) capacitor c=6.90755e-17
C33 (\3\:SEb VSS) capacitor c=5.72057e-17
C34 (\3\:D VSS) capacitor c=3.73797e-17
C35 (\9\:CKb VSS) capacitor c=2.89953e-17
C36 (\10\:CKb VSS) capacitor c=3.97685e-17
C37 (\5\:CKbb VSS) capacitor c=7.69291e-17
C38 (\3\:mout VSS) capacitor c=5.41802e-17
C39 (\3\:n20 VSS) capacitor c=4.07163e-17
C40 (\10\:qbint VSS) capacitor c=4.90569e-17
C41 (\3\:CK VSS) capacitor c=4.14367e-17
C42 (\6\:SE VSS) capacitor c=5.32148e-17
C43 (\2\:SI VSS) capacitor c=6.47576e-17
C44 (\4\:SE VSS) capacitor c=4.58003e-17
C45 (\2\:SEb VSS) capacitor c=5.36606e-17
C46 (\2\:SE VSS) capacitor c=4.05473e-17
C47 (\2\:D VSS) capacitor c=7.93409e-17
C48 (\7\:CKbb VSS) capacitor c=3.86547e-17
C49 (\4\:CKbb VSS) capacitor c=4.01971e-17
C50 (\11\:CKb VSS) capacitor c=2.95247e-17
C51 (\2\:mout VSS) capacitor c=5.45636e-17
C52 (\2\:n20 VSS) capacitor c=3.95852e-17
C53 (\4\:CKb VSS) capacitor c=2.58449e-17
C54 (\2\:CKbb VSS) capacitor c=4.86643e-17
C55 (\2\:CKb VSS) capacitor c=3.65034e-17
C56 (\9\:qbint VSS) capacitor c=4.13417e-17
C57 (\2\:CK VSS) capacitor c=3.99274e-17
C58 (\6\:qbint VSS) capacitor c=1.92255e-17
C59 (\8\:SEb VSS) capacitor c=1.32792e-17
C60 (\1\:VDD VSS) capacitor c=5.43488e-17
C61 (\6\:Db VSS) capacitor c=4.63818e-17
C62 (\12\:VDD VSS) capacitor c=4.2214e-17
C63 (\8\:CKbb VSS) capacitor c=7.26385e-17
C64 (\4\:Db VSS) capacitor c=1.08193e-16
C65 (\4\:n20 VSS) capacitor c=3.5093e-17
C66 (\14\:VDD VSS) capacitor c=1.69382e-17
C67 (\6\:mout VSS) capacitor c=3.98309e-17
C68 (\9\:n30 VSS) capacitor c=6.94064e-17
C69 (\16\:VDD VSS) capacitor c=3.6134e-17
C70 (\12\:qbint VSS) capacitor c=6.66254e-17
C71 (\15\:CKb VSS) capacitor c=1.12457e-16
C72 (\1\:Q VSS) capacitor c=7.81297e-17
C73 (\3\:VDD VSS) capacitor c=3.84875e-17
C74 (\4\:SEb VSS) capacitor c=7.0487e-17
C75 (\14\:CKbb VSS) capacitor c=5.45417e-17
C76 (\8\:Db VSS) capacitor c=8.16808e-17
C77 (\8\:n20 VSS) capacitor c=5.54677e-17
C78 (\8\:mout VSS) capacitor c=3.61048e-17
C79 (\5\:n30 VSS) capacitor c=2.30163e-17
C80 (\14\:qbint VSS) capacitor c=1.29402e-16
C81 (\18\:CKb VSS) capacitor c=1.10546e-16
C82 (\4\:Q VSS) capacitor c=2.52576e-17
C83 (\2\:n30 VSS) capacitor c=3.00211e-17
C84 (\6\:CKb VSS) capacitor c=6.61939e-17
C85 (\7\:CKb VSS) capacitor c=6.23714e-17
C86 (\3\:Q VSS) capacitor c=3.77131e-17
C87 (\4\:CK VSS) capacitor c=4.44514e-17
C88 (\11\:qbint VSS) capacitor c=4.14683e-17
C89 (\16\:qbint VSS) capacitor c=1.35297e-16
C90 (\7\:n30 VSS) capacitor c=7.37072e-17
C91 (\8\:n30 VSS) capacitor c=8.17195e-17
C92 (\4\:mout VSS) capacitor c=4.96698e-17
C93 (\5\:mout VSS) capacitor c=4.73387e-17
C94 (\12\:CKb VSS) capacitor c=6.03114e-17
C95 (\13\:CKb VSS) capacitor c=8.62768e-17
C96 (\14\:CKb VSS) capacitor c=9.42376e-17
C97 (\17\:CKb VSS) capacitor c=5.5349e-17
C98 (\6\:n20 VSS) capacitor c=6.03379e-17
C99 (\7\:n20 VSS) capacitor c=5.10599e-17
C100 (\10\:CKbb VSS) capacitor c=1.24229e-16
C101 (\11\:CKbb VSS) capacitor c=6.76084e-17
C102 (\12\:CKbb VSS) capacitor c=7.6037e-17
C103 (\13\:CKbb VSS) capacitor c=1.08485e-16
C104 (\4\:D VSS) capacitor c=3.43108e-17
C105 (\3\:Db VSS) capacitor c=1.30711e-16
C106 (\8\:SE VSS) capacitor c=4.6792e-17
C107 (\10\:SE VSS) capacitor c=7.73041e-17
C108 (\4\:SI VSS) capacitor c=4.35436e-17
C109 (\6\:SEb VSS) capacitor c=1.06983e-16
C110 (\7\:SEb VSS) capacitor c=6.16172e-17
C111 (\5\:VDD VSS) capacitor c=2.2975e-17
C112 (\6\:VDD VSS) capacitor c=5.86569e-17
C113 (\7\:VDD VSS) capacitor c=2.5896e-17
Rk27 (\4\:D D) resistor r=0.06529 c=0
Rk2 (\3\:Q Q) resistor r=0.002419 c=0
Rk1 (\2\:Q \3\:Q) resistor r=0.3231 c=0
Rk3 (\3\:Q \5\:Q) resistor r=0.1898 c=0
Rk51 (\2\:VDD \4\:VDD) resistor r=0.6041 c=0
Rk52 (\4\:VDD \5\:VDD) resistor r=0.05746 c=0
Rk53 (\5\:VDD \6\:VDD) resistor r=0.5486 c=0
Rk54 (\6\:VDD \7\:VDD) resistor r=0.5637 c=0
Rk56 (\8\:VDD VDD) resistor r=0.3307 c=0
Rk55 (\7\:VDD \8\:VDD) resistor r=0.03239 c=0
Rk59 (\5\:VDD \13\:VDD) resistor r=0.2584 c=0
Rk60 (\6\:VDD \15\:VDD) resistor r=0.07369 c=0
Rk61 (\7\:VDD \17\:VDD) resistor r=0.209 c=0
Rk4 (CK \4\:CK) resistor r=0.1109 c=0
Rk32 (\8\:SE SE) resistor r=0.2343 c=0
Rk34 (SE \10\:SE) resistor r=0.3782 c=0
Rk35 (\4\:SI SI) resistor r=0.1351 c=0
Rk39 (\2\:VSS \4\:VSS) resistor r=0.6634 c=0
Rk40 (\4\:VSS \5\:VSS) resistor r=0.05746 c=0
Rk41 (\5\:VSS \6\:VSS) resistor r=0.5477 c=0
Rk42 (\6\:VSS \7\:VSS) resistor r=0.5961 c=0
Rk43 (\5\:VSS \9\:VSS) resistor r=0.2966 c=0
Rk44 (\6\:VSS \11\:VSS) resistor r=0.04329 c=0
Rk47 (\12\:VSS VSS) resistor r=0.0151 c=0
Rk45 (\7\:VSS \12\:VSS) resistor r=0.3307 c=0
Rk48 (\7\:VSS \15\:VSS) resistor r=0.3674 c=0
Rk5 (\11\:qbint \13\:qbint) resistor r=0.2244 c=0
Rk6 (\13\:qbint \15\:qbint) resistor r=0.3633 c=0
Rk7 (\15\:qbint \16\:qbint) resistor r=0.835 c=0
Rk14 (\12\:CKb \13\:CKb) resistor r=0.464 c=0
Rk15 (\13\:CKb \14\:CKb) resistor r=0.3948 c=0
Rk16 (\14\:CKb \16\:CKb) resistor r=0.4697 c=0
Rk17 (\14\:CKb \17\:CKb) resistor r=0.2686 c=0
Rk18 (\16\:CKb \19\:CKb) resistor r=0.6422 c=0
Rk8 (\6\:n30 \7\:n30) resistor r=0.06409 c=0
Rk9 (\7\:n30 \8\:n30) resistor r=0.432 c=0
Rk10 (\7\:n30 \10\:n30) resistor r=0.3852 c=0
Rk11 (\4\:mout \5\:mout) resistor r=0.2532 c=0
Rk12 (\5\:mout \7\:mout) resistor r=0.2422 c=0
Rk13 (\5\:mout \9\:mout) resistor r=0.1387 c=0
Rk22 (\9\:CKbb \10\:CKbb) resistor r=0.5321 c=0
Rk23 (\10\:CKbb \11\:CKbb) resistor r=0.3682 c=0
Rk24 (\11\:CKbb \12\:CKbb) resistor r=0.1381 c=0
Rk25 (\12\:CKbb \13\:CKbb) resistor r=0.78 c=0
Rk26 (\11\:CKbb \15\:CKbb) resistor r=0.2499 c=0
Rk19 (\5\:n20 \6\:n20) resistor r=0.1397 c=0
Rk20 (\6\:n20 \7\:n20) resistor r=0.2722 c=0
Rk21 (\6\:n20 \9\:n20) resistor r=0.1974 c=0
Rk28 (\2\:Db \3\:Db) resistor r=0.6893 c=0
Rk29 (\3\:Db \5\:Db) resistor r=0.4325 c=0
Rk30 (\3\:Db \7\:Db) resistor r=0.271 c=0
Rk31 (\5\:Db \9\:Db) resistor r=0.48 c=0
Rk36 (\5\:SEb \6\:SEb) resistor r=0.7076 c=0
Rk37 (\6\:SEb \7\:SEb) resistor r=0.4859 c=0
Rk38 (\6\:SEb \9\:SEb) resistor r=0.04776 c=0
Rl30 (\1\:D \2\:D) resistor r=119.488 c=0
Rl31 (\2\:D \3\:D) resistor r=123.334 c=0
Rl7 (\1\:CK \2\:CK) resistor r=139.56 c=0
Rl8 (\2\:CK \3\:CK) resistor r=53.0211 c=0
Rl39 (\6\:SE \7\:SE) resistor r=166.483 c=0
Rl38 (\5\:SE \6\:SE) resistor r=36.5385 c=0
Rl35 (\3\:SE \4\:SE) resistor r=35.3072 c=0
Rl32 (\1\:SE \2\:SE) resistor r=79.5379 c=0
Rl37 (\2\:SI \3\:SI) resistor r=104.104 c=0
Rl36 (\1\:SI \2\:SI) resistor r=96.8456 c=0
Rl12 (\9\:qbint \8\:qbint) resistor r=30.1196 c=0
Rl13 (\9\:qbint \10\:qbint) resistor r=94.0258 c=0
Rl5 (qbint \6\:qbint) resistor r=4.8851 c=0
Rl29 (\8\:CKb \11\:CKb) resistor r=24.2328 c=0
Rl17 (\3\:CKb \4\:CKb) resistor r=37.6944 c=0
Rl14 (CKb \2\:CKb) resistor r=53.079 c=0
Rl24 (\5\:CKb \6\:CKb) resistor r=148.799 c=0
Rl27 (\6\:CKb \9\:CKb) resistor r=81.4915 c=0
Rl26 (\7\:CKb \8\:CKb) resistor r=186.082 c=0
Rl28 (\7\:CKb \10\:CKb) resistor r=30.4507 c=0
Rl25 (\6\:CKb \7\:CKb) resistor r=164.3 c=0
Rl10 (\2\:n30 \3\:n30) resistor r=52.8616 c=0
Rl9 (n30 \2\:n30) resistor r=37.477 c=0
Rl11 (\2\:n30 \4\:n30) resistor r=6.1589 c=0
Rl20 (mout \2\:mout) resistor r=93.4636 c=0
Rl21 (\2\:mout \3\:mout) resistor r=33.8482 c=0
Rl23 (\6\:CKbb \7\:CKbb) resistor r=41.5405 c=0
Rl22 (\4\:CKbb \5\:CKbb) resistor r=40.8563 c=0
Rl16 (\2\:CKbb \3\:CKbb) resistor r=138.016 c=0
Rl15 (CKbb \2\:CKbb) resistor r=24.2328 c=0
Rl18 (n20 \2\:n20) resistor r=31.9251 c=0
Rl19 (\2\:n20 \3\:n20) resistor r=95.3867 c=0
Rl33 (SEb \2\:SEb) resistor r=76.9231 c=0
Rl34 (\2\:SEb \3\:SEb) resistor r=127.421 c=0
Rz1 (\5\:Q \4\:Q) resistor r=75 c=0
Rz17 (\4\:VDD \3\:VDD) resistor r=6.25 c=0
Rz18 (\8\:VDD \3\:VDD) resistor r=6.25 c=0
Rz11 (\2\:VSS \1\:VSS) resistor r=75 c=0
Rz12 (\9\:VSS \8\:VSS) resistor r=75 c=0
Rz13 (\11\:VSS \10\:VSS) resistor r=75 c=0
Rz14 (\15\:VSS \14\:VSS) resistor r=75 c=0
Rz2 (\15\:qbint \14\:qbint) resistor r=75 c=0
Rz5 (\18\:CKb \19\:CKb) resistor r=75 c=0
Rz3 (\5\:n30 \6\:n30) resistor r=75 c=0
Rz4 (\8\:mout \9\:mout) resistor r=75 c=0
Rz7 (\14\:CKbb \15\:CKbb) resistor r=75 c=0
Rz6 (\8\:n20 \9\:n20) resistor r=75 c=0
Rz8 (Db \2\:Db) resistor r=75 c=0
Rz9 (\8\:Db \9\:Db) resistor r=75 c=0
Rz10 (\4\:SEb \5\:SEb) resistor r=75 c=0
Ry1 (\2\:Q \1\:Q) resistor r=20.6667 c=0
Ry13 (\2\:VDD \1\:VDD) resistor r=62 c=0
Ry15 (\13\:VDD \12\:VDD) resistor r=62 c=0
Ry16 (\15\:VDD \14\:VDD) resistor r=62 c=0
Ry17 (\17\:VDD \16\:VDD) resistor r=62 c=0
Ry11 (\4\:VSS \3\:VSS) resistor r=5.1667 c=0
Ry12 (\7\:VSS \3\:VSS) resistor r=5.1667 c=0
Ry2 (\13\:qbint \12\:qbint) resistor r=62 c=0
Ry5 (\15\:CKb \16\:CKb) resistor r=62 c=0
Ry3 (\9\:n30 \10\:n30) resistor r=62 c=0
Ry4 (\6\:mout \7\:mout) resistor r=62 c=0
Ry7 (\8\:CKbb \9\:CKbb) resistor r=62 c=0
Ry6 (\4\:n20 \5\:n20) resistor r=62 c=0
Ry8 (\4\:Db \5\:Db) resistor r=62 c=0
Ry9 (\6\:Db \7\:Db) resistor r=62 c=0
Ry10 (\8\:SEb \9\:SEb) resistor r=62 c=0
Rx13 (\2\:D \4\:D) resistor r=45 c=0
Rx1 (\2\:CK \4\:CK) resistor r=45 c=0
Rx15 (\4\:SE SE) resistor r=45 c=0
Rx14 (\6\:SE \8\:SE) resistor r=45 c=0
Rx16 (\2\:SE \10\:SE) resistor r=45 c=0
Rx17 (\2\:SI \4\:SI) resistor r=45 c=0
Rx2 (\11\:qbint \9\:qbint) resistor r=45 c=0
Rx3 (\16\:qbint \6\:qbint) resistor r=45 c=0
Rx6 (\11\:CKb \12\:CKb) resistor r=45 c=0
Rx7 (\4\:CKb \13\:CKb) resistor r=45 c=0
Rx8 (\2\:CKb \17\:CKb) resistor r=45 c=0
Rx4 (\4\:n30 \8\:n30) resistor r=45 c=0
Rx5 (\2\:mout \4\:mout) resistor r=45 c=0
Rx10 (\7\:CKbb \10\:CKbb) resistor r=45 c=0
Rx11 (\4\:CKbb \12\:CKbb) resistor r=45 c=0
Rx12 (\2\:CKbb \13\:CKbb) resistor r=45 c=0
Rx9 (\2\:n20 \7\:n20) resistor r=45 c=0
Rx18 (\2\:SEb \7\:SEb) resistor r=45 c=0
mn55_1__rcx (\4\:Q qbint \12\:VSS VSS) g45n1lvt w=(2.6e-07) l=4.5e-08 \
        nf=1 as=4.003e-14 ad=4.16e-14 ps=8.5e-07 pd=8.4e-07 nrd=1.16667 \
        nrs=1.16667 sa=1.4e-07 sb=5.29038e-07 sd=160n sca=7.84363 \
        scb=0.00546499 scc=9.84911e-05 m=(2)
mn20 (\18\:CKb \3\:CK \12\:VSS VSS) g45n1lvt w=(1.45e-07) l=4.5e-08 nf=1 \
        as=4.365e-14 ad=3.407e-14 ps=9e-07 pd=7.6e-07 nrd=1.16667 \
        nrs=1.16667 sa=5.8e-07 sb=2.35e-07 sd=160n sca=9.16682 \
        scb=0.00760686 scc=0.000164708 m=(1)
mn50 (n7 \10\:qbint \14\:VSS VSS) g45n1lvt w=(1.45e-07) l=4.5e-08 nf=1 \
        as=3.595e-14 ad=2.682e-14 ps=7.9e-07 pd=6.6e-07 nrd=1.16667 \
        nrs=1.16667 sa=3.75e-07 sb=1.705e-06 sd=160n sca=23.279 \
        scb=0.0230742 scc=0.00267719 m=(1)
mn51 (\5\:n30 CKb n7 VSS) g45n1lvt w=(1.45e-07) l=4.5e-08 nf=1 \
        as=2.682e-14 ad=3.335e-14 ps=6.6e-07 pd=7.5e-07 nrd=1.16667 \
        nrs=1.16667 sa=6.05e-07 sb=1.475e-06 sd=160n sca=23.279 \
        scb=0.0230742 scc=0.00267719 m=(1)
mn40 (\8\:mout CKbb \5\:n30 VSS) g45n1lvt w=(1.45e-07) l=4.5e-08 nf=1 \
        as=3.335e-14 ad=4.277e-14 ps=7.5e-07 pd=8.8e-07 nrd=1.16667 \
        nrs=1.16667 sa=8.8e-07 sb=1.2e-06 sd=160n sca=23.279 scb=0.0230742 \
        scc=0.00267719 m=(1)
mn30 (\8\:mout \3\:n20 \10\:VSS VSS) g45n1lvt w=(1.45e-07) l=4.5e-08 \
        nf=1 as=8.41e-14 ad=4.278e-14 ps=1.6e-06 pd=8.8e-07 nrd=1.16667 \
        nrs=1.16667 sa=1.22e-06 sb=8.6e-07 sd=160n sca=23.279 \
        scb=0.0230742 scc=0.00267719 m=(1)
mn36 (n5 \3\:mout \10\:VSS VSS) g45n1lvt w=(1.45e-07) l=4.5e-08 nf=1 \
        as=8.41e-14 ad=8.7e-15 ps=1.6e-06 pd=4.1e-07 nrd=1.16667 \
        nrs=1.16667 sa=1.485e-06 sb=5.95e-07 sd=160n sca=23.279 \
        scb=0.0230742 scc=0.00267719 m=(1)
mn35 (\8\:n20 \5\:CKbb n5 VSS) g45n1lvt w=(1.45e-07) l=4.5e-08 nf=1 \
        as=8.7e-15 ad=2.973e-14 ps=4.1e-07 pd=7e-07 nrd=1.16667 \
        nrs=1.16667 sa=1.59e-06 sb=4.9e-07 sd=160n sca=23.279 \
        scb=0.0230742 scc=0.00267719 m=(1)
mn25 (\8\:Db \10\:CKb \8\:n20 VSS) g45n1lvt w=(1.45e-07) l=4.5e-08 nf=1 \
        as=2.973e-14 ad=3.48e-14 ps=7e-07 pd=7.7e-07 nrd=1.16667 \
        nrs=1.16667 sa=1.84e-06 sb=2.4e-07 sd=160n sca=23.279 \
        scb=0.0230742 scc=0.00267719 m=(1)
mn21 (\14\:CKbb \9\:CKb \8\:VSS VSS) g45n1lvt w=(1.45e-07) l=4.5e-08 \
        nf=1 as=2.32e-14 ad=2.03e-14 ps=6.1e-07 pd=5.7e-07 nrd=1.16667 \
        nrs=1.16667 sa=1.4e-07 sb=1.205e-06 sd=160n sca=11.7118 \
        scb=0.0116498 scc=0.000458536 m=(1)
mn11 (n1 \3\:D \8\:VSS VSS) g45n1lvt w=(1.45e-07) l=4.5e-08 nf=1 \
        as=2.32e-14 ad=4.205e-14 ps=6.1e-07 pd=8.7e-07 nrd=1.16667 \
        nrs=1.16667 sa=3.45e-07 sb=1e-06 sd=160n sca=11.7118 scb=0.0116498 \
        scc=0.000458536 m=(1)
mn12 (Db \3\:SEb n1 VSS) g45n1lvt w=(1.45e-07) l=4.5e-08 nf=1 \
        as=4.205e-14 ad=2.32e-14 ps=8.7e-07 pd=6.1e-07 nrd=1.16667 \
        nrs=1.16667 sa=6.8e-07 sb=6.65e-07 sd=160n sca=11.7118 \
        scb=0.0116498 scc=0.000458536 m=(1)
mn14 (Db \3\:SE n3 VSS) g45n1lvt w=(1.45e-07) l=4.5e-08 nf=1 as=8.7e-15 \
        ad=2.32e-14 ps=4.1e-07 pd=6.1e-07 nrd=1.16667 nrs=1.16667 \
        sa=8.85e-07 sb=4.6e-07 sd=160n sca=11.7118 scb=0.0116498 \
        scc=0.000458536 m=(1)
mn13 (n3 \1\:SI \1\:VSS VSS) g45n1lvt w=(1.45e-07) l=4.5e-08 nf=1 \
        as=2.465e-14 ad=8.7e-15 ps=6.3e-07 pd=4.1e-07 nrd=1.16667 \
        nrs=1.16667 sa=9.9e-07 sb=3.55e-07 sd=160n sca=11.7118 \
        scb=0.0116498 scc=0.000458536 m=(1)
mn10 (\4\:SEb \5\:SE \1\:VSS VSS) g45n1lvt w=(1.45e-07) l=4.5e-08 nf=1 \
        as=2.465e-14 ad=2.03e-14 ps=6.3e-07 pd=5.7e-07 nrd=1.16667 \
        nrs=1.16667 sa=1.205e-06 sb=1.4e-07 sd=160n sca=11.7118 \
        scb=0.0116498 scc=0.000458536 m=(1)
mn45 (\14\:qbint n30 \14\:VSS VSS) g45n1lvt w=(2.05e-07) l=4.5e-08 nf=1 \
        as=3.595e-14 ad=2.87e-14 ps=7.9e-07 pd=6.9e-07 nrd=1.16667 \
        nrs=1.16667 sa=1.4e-07 sb=1.41317e-06 sd=160n sca=19.867 \
        scb=0.0198061 scc=0.00201945 m=(1)
mp20 (\15\:CKb \1\:CK VDD VDD) g45p1lvt w=(2.15e-07) l=4.5e-08 nf=1 \
        as=6.802e-14 ad=3.87e-14 ps=1.25e-06 pd=7.9e-07 nrd=1.16667 \
        nrs=1.16667 sa=6.25e-07 sb=1.8e-07 sd=160n sca=13.4091 \
        scb=0.0119825 scc=0.00042533 m=(1)
mp50 (n8 \8\:qbint \16\:VDD VDD) g45p1lvt w=(2.15e-07) l=4.5e-08 nf=1 \
        as=7.71e-14 ad=7.202e-14 ps=1.48e-06 pd=1.1e-06 nrd=1.16667 \
        nrs=1.16667 sa=3.28488e-07 sb=1.69e-06 sd=160n sca=13.1637 \
        scb=0.0123476 scc=0.000501177 m=(1)
mp51 (\9\:n30 \3\:CKbb n8 VDD) g45p1lvt w=(2.15e-07) l=4.5e-08 nf=1 \
        as=7.202e-14 ad=3.44e-14 ps=1.1e-06 pd=7.5e-07 nrd=1.16667 \
        nrs=1.16667 sa=7.08488e-07 sb=1.31e-06 sd=160n sca=13.1637 \
        scb=0.0123476 scc=0.000501177 m=(1)
mp40 (\9\:n30 \3\:CKb \6\:mout VDD) g45p1lvt w=(2.15e-07) l=4.5e-08 nf=1 \
        as=4.3e-14 ad=3.44e-14 ps=8.3e-07 pd=7.5e-07 nrd=1.16667 \
        nrs=1.16667 sa=9.13488e-07 sb=1.105e-06 sd=160n sca=13.1637 \
        scb=0.0123476 scc=0.000501177 m=(1)
mp30 (\6\:mout n20 \14\:VDD VDD) g45p1lvt w=(2.15e-07) l=4.5e-08 nf=1 \
        as=8.93e-14 ad=4.3e-14 ps=1.57e-06 pd=8.3e-07 nrd=1.16667 \
        nrs=1.16667 sa=1.15849e-06 sb=8.6e-07 sd=160n sca=13.1637 \
        scb=0.0123476 scc=0.000501177 m=(1)
mp35 (n6 mout \14\:VDD VDD) g45p1lvt w=(2.15e-07) l=4.5e-08 nf=1 \
        as=8.93e-14 ad=1.29e-14 ps=1.57e-06 pd=5.5e-07 nrd=1.16667 \
        nrs=1.16667 sa=1.42349e-06 sb=5.95e-07 sd=160n sca=13.1637 \
        scb=0.0123476 scc=0.000501177 m=(1)
mp36 (\4\:n20 \8\:CKb n6 VDD) g45p1lvt w=(2.15e-07) l=4.5e-08 nf=1 \
        as=1.29e-14 ad=4.515e-14 ps=5.5e-07 pd=8.5e-07 nrd=1.16667 \
        nrs=1.16667 sa=1.52849e-06 sb=4.9e-07 sd=160n sca=13.1637 \
        scb=0.0123476 scc=0.000501177 m=(1)
mp25 (\4\:n20 \6\:CKbb \4\:Db VDD) g45p1lvt w=(2.15e-07) l=4.5e-08 nf=1 \
        as=5.052e-14 ad=4.515e-14 ps=9e-07 pd=8.5e-07 nrd=1.16667 \
        nrs=1.16667 sa=1.78349e-06 sb=2.35e-07 sd=160n sca=13.1637 \
        scb=0.0123476 scc=0.000501177 m=(1)
mp21 (\8\:CKbb \5\:CKb \12\:VDD VDD) g45p1lvt w=(2.15e-07) l=4.5e-08 \
        nf=1 as=3.44e-14 ad=3.01e-14 ps=7.5e-07 pd=7.1e-07 nrd=1.16667 \
        nrs=1.16667 sa=1.4e-07 sb=1.15e-06 sd=160n sca=10.8061 \
        scb=0.00857865 scc=0.000148871 m=(1)
mp11 (n2 \1\:D \12\:VDD VDD) g45p1lvt w=(2.15e-07) l=4.5e-08 nf=1 \
        as=3.44e-14 ad=3.762e-14 ps=7.5e-07 pd=7.8e-07 nrd=1.16667 \
        nrs=1.16667 sa=3.45e-07 sb=9.45e-07 sd=160n sca=10.8061 \
        scb=0.00857865 scc=0.000148871 m=(1)
mp12 (\6\:Db \1\:SE n2 VDD) g45p1lvt w=(2.15e-07) l=4.5e-08 nf=1 \
        as=3.762e-14 ad=3.87e-14 ps=7.8e-07 pd=7.9e-07 nrd=1.16667 \
        nrs=1.16667 sa=5.65e-07 sb=7.25e-07 sd=160n sca=10.8061 \
        scb=0.00857865 scc=0.000148871 m=(1)
mp14 (\6\:Db SEb n4 VDD) g45p1lvt w=(2.15e-07) l=4.5e-08 nf=1 \
        as=2.365e-14 ad=3.87e-14 ps=6.5e-07 pd=7.9e-07 nrd=1.16667 \
        nrs=1.16667 sa=7.9e-07 sb=5e-07 sd=160n sca=11.3106 scb=0.00875354 \
        scc=0.000148925 m=(1)
mp13 (n4 \3\:SI \1\:VDD VDD) g45p1lvt w=(2.15e-07) l=4.5e-08 nf=1 \
        as=3.44e-14 ad=2.365e-14 ps=7.5e-07 pd=6.5e-07 nrd=1.16667 \
        nrs=1.16667 sa=9.45e-07 sb=3.45e-07 sd=160n sca=12.0628 \
        scb=0.00935347 scc=0.000149867 m=(1)
mp10 (\8\:SEb \7\:SE \1\:VDD VDD) g45p1lvt w=(2.15e-07) l=4.5e-08 nf=1 \
        as=3.44e-14 ad=3.01e-14 ps=7.5e-07 pd=7.1e-07 nrd=1.16667 \
        nrs=1.16667 sa=1.15e-06 sb=1.4e-07 sd=160n sca=14.4353 \
        scb=0.0129221 scc=0.000190612 m=(1)
mp45 (\12\:qbint \3\:n30 \16\:VDD VDD) g45p1lvt w=(3.1e-07) l=4.5e-08 \
        nf=1 as=7.71e-14 ad=4.34e-14 ps=1.48e-06 pd=9e-07 nrd=1.16667 \
        nrs=1.16667 sa=1.4e-07 sb=9.67661e-07 sd=160n sca=35.6995 \
        scb=0.0234062 scc=0.00420468 m=(1)
ends SDFFQX2
// End of subcircuit definition.
