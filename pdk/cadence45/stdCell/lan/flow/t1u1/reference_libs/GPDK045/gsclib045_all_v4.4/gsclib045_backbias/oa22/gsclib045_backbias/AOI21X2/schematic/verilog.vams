// Verilog-AMS netlist generated by the AMS netlister, version  ICADV12.1-64b.341 .
// Cadence Design Systems, Inc.

`include "disciplines.vams"

(* cds_ams_schematic *)
module AOI21X2 ( Y,B0,.VDD(\VDD! ),A1,A0,.NW(
\NW! ),.VSS(\VSS! ) );

output   Y;
input   B0;
input  (*
integer inh_conn_prop_name
 = "VDD";
integer inh_conn_def_value = "cds_globals.\\VDD! ";
 *)

 \VDD! ;
input   A1;
input   A0;
input  (*
integer inh_conn_prop_name
 = "NW";
integer inh_conn_def_value = "cds_globals.\\NW! ";
integer
supplySensitivity = "VDD";
 *)
 \NW! ;
input  (*
integer
inh_conn_prop_name = "VSS";
integer inh_conn_def_value
 = "cds_globals.\\VSS! ";
 *)
 \VSS! ;

wire Y;
wire B0;
wire (*
integer inh_conn_prop_name = "VSS";
integer inh_conn_def_value
 = "cds_globals.\\VSS! ";
 *)
\VSS! ;
wire A1;
wire A0;
wire net74;
wire (*
integer inh_conn_prop_name = "VDD";
integer inh_conn_def_value
 = "cds_globals.\\VDD! ";
 *)
\VDD! ;

g45n1svt #(.ad(72.8f), .nrd(269.231m), .sca(98.28759), .pd(1.32u), .scc(0.01166),
 .scb(0.08111), .as(72.8f), .nrs(269.231m), .m(1), .ps(1.32u), .w(520n),
 .sa(140n), .nf(1), .sb(140n), .sd(160n), .l(45n)) (*
integer
library_binding = "gpdk045";
integer passed_mfactor = "m";
 *)
mn2 ( Y,
B0, \VSS! , \VSS!  );
g45n1svt #(.ad(72.8f), .nrd(269.231m), .sca(98.28759), .pd(1.32u), .scc(0.01166),
 .scb(0.08111), .as(72.8f), .nrs(269.231m), .m(1), .ps(1.32u), .w(520n),
 .sa(140n), .nf(1), .sb(140n), .sd(160n), .l(45n)) (*
integer
library_binding = "gpdk045";
integer passed_mfactor = "m";
 *)
mn0 (
net74, A0, \VSS! , \VSS!  );
g45n1svt #(.ad(72.8f), .nrd(269.231m), .sca(98.28759), .pd(1.32u), .scc(0.01166),
 .scb(0.08111), .as(72.8f), .nrs(269.231m), .m(1), .ps(1.32u), .w(520n),
 .sa(140n), .nf(1), .sb(140n), .sd(160n), .l(45n)) (*
integer
library_binding = "gpdk045";
integer passed_mfactor = "m";
 *)
mn1 ( Y,
A1, net74, \VSS!  );

g45p1svt #(.ad(109.2f), .nrd(179.487m), .sca(80.49887), .pd(1.84u), .scc(0.00954),
 .scb(0.07059), .as(109.2f), .nrs(179.487m), .m(1), .ps(1.84u), .w(780n),
 .sa(140n), .nf(1), .sb(140n), .sd(160n), .l(45n)) (*
integer
library_binding = "gpdk045";
integer passed_mfactor = "m";
 *)
mp2 ( Y,
B0, net70, \NW!  );
g45p1svt #(.ad(109.2f), .nrd(179.487m), .sca(80.49887), .pd(1.84u), .scc(0.00954),
 .scb(0.07059), .as(109.2f), .nrs(179.487m), .m(1), .ps(1.84u), .w(780n),
 .sa(140n), .nf(1), .sb(140n), .sd(160n), .l(45n)) (*
integer
library_binding = "gpdk045";
integer passed_mfactor = "m";
 *)
mp1 (
net70, A1, \VDD! , \NW!  );
g45p1svt #(.ad(109.2f), .nrd(179.487m), .sca(80.49887), .pd(1.84u), .scc(0.00954),
 .scb(0.07059), .as(109.2f), .nrs(179.487m), .m(1), .ps(1.84u), .w(780n),
 .sa(140n), .nf(1), .sb(140n), .sd(160n), .l(45n)) (*
integer
library_binding = "gpdk045";
integer passed_mfactor = "m";
 *)
mp0 (
net70, A0, \VDD! , \NW!  );

endmodule
