// Generated for: spectre (May  1 09:12:40 2013 )
// Library name: gsclib045_lvt
// Cell name: TBUFX4
// View name: extracted

simulator lang=spectre

subckt TBUFX4 A OE VDD VSS Y
mp4 (\9\:pon \1\:OE \16\:VDD VDD) g45p1lvt w=(3.9e-07) l=4.5e-08 nf=1 \
        as=5.46e-14 ad=6.24e-14 ps=1.06e-06 pd=1.1e-06 nrd=1.16667 \
        nrs=1.16667 sa=1.4e-07 sb=5.07308e-07 sd=160n sca=21.9686 \
        scb=0.0221039 scc=0.00141228 m=(1)
mp3 (\9\:pon \1\:A \14\:VDD VDD) g45p1lvt w=(3.9e-07) l=4.5e-08 nf=1 \
        as=8.412e-14 ad=6.24e-14 ps=1.33e-06 pd=1.1e-06 nrd=1.16667 \
        nrs=1.16667 sa=3.45e-07 sb=3.02308e-07 sd=160n sca=18.49 \
        scb=0.0162883 scc=0.00128386 m=(1)
mp2 (\11\:non OEb net127 VDD) g45p1lvt w=(3.9e-07) l=4.5e-08 nf=1 \
        as=2.34e-14 ad=5.46e-14 ps=9e-07 pd=1.06e-06 nrd=1.16667 \
        nrs=1.16667 sa=1.4e-07 sb=1.235e-06 sd=160n sca=20.5009 \
        scb=0.0171135 scc=0.00197772 m=(1)
mp1 (net127 \4\:A \1\:VDD VDD) g45p1lvt w=(3.9e-07) l=4.5e-08 nf=1 \
        as=1.014e-13 ad=2.34e-14 ps=1.3e-06 pd=9e-07 nrd=1.16667 \
        nrs=1.16667 sa=2.45e-07 sb=1.13e-06 sd=160n sca=20.5009 \
        scb=0.0171135 scc=0.00197772 m=(1)
mp5_1__rcx (\1\:Y pon \1\:VDD VDD) g45p1lvt w=(3.9e-07) l=4.5e-08 nf=1 \
        as=7.02e-14 ad=7.605e-14 ps=1.14e-06 pd=1.17e-06 nrd=1.16667 \
        nrs=1.16667 sa=5.5e-07 sb=8.25e-07 sd=160n sca=20.6353 \
        scb=0.0171431 scc=0.00197772 m=(4)
C1 (OE VSS) capacitor c=4.31668e-17
C2 (Y VSS) capacitor c=3.27362e-17
C3 (VDD VSS) capacitor c=1.35175e-16
C4 (A VSS) capacitor c=2.01907e-17
C5 (pon VSS) capacitor c=1.60181e-16
C6 (OEb VSS) capacitor c=8.70002e-17
C7 (non VSS) capacitor c=1.40894e-16
C8 (net127 VSS) capacitor c=3.89141e-18
C9 (\4\:A VSS) capacitor c=8.34227e-17
C10 (\4\:OE VSS) capacitor c=5.17027e-17
C11 (\1\:A VSS) capacitor c=5.40719e-17
C12 (\1\:OE VSS) capacitor c=4.6791e-17
C13 (\6\:A VSS) capacitor c=2.79496e-17
C14 (\4\:OEb VSS) capacitor c=3.65203e-17
C15 (\7\:OE VSS) capacitor c=3.41722e-17
C16 (\3\:A VSS) capacitor c=6.24173e-17
C17 (\3\:OE VSS) capacitor c=4.28931e-17
C18 (\5\:non VSS) capacitor c=2.67676e-17
C19 (\5\:A VSS) capacitor c=5.04083e-17
C20 (\3\:OEb VSS) capacitor c=1.38888e-17
C21 (\6\:OE VSS) capacitor c=2.18283e-17
C22 (\2\:A VSS) capacitor c=4.54516e-17
C23 (\2\:OE VSS) capacitor c=3.4116e-17
C24 (\1\:VDD VSS) capacitor c=1.69111e-16
C25 (\1\:Y VSS) capacitor c=1.374e-16
C26 (\11\:non VSS) capacitor c=4.52813e-17
C27 (\7\:OEb VSS) capacitor c=6.80612e-17
C28 (\14\:VDD VSS) capacitor c=3.63584e-17
C29 (\9\:pon VSS) capacitor c=2.094e-16
C30 (\16\:VDD VSS) capacitor c=2.81659e-17
C31 (\3\:VDD VSS) capacitor c=2.90347e-17
C32 (\13\:non VSS) capacitor c=6.3602e-17
C33 (\9\:OEb VSS) capacitor c=4.71348e-17
C34 (\11\:pon VSS) capacitor c=7.49417e-17
C35 (\5\:OE VSS) capacitor c=1.88729e-17
C36 (\2\:OEb VSS) capacitor c=3.31956e-17
C37 (\8\:OE VSS) capacitor c=3.24715e-17
C38 (\9\:OE VSS) capacitor c=3.27217e-17
C39 (\5\:OEb VSS) capacitor c=1.52632e-17
C40 (\6\:OEb VSS) capacitor c=4.4537e-17
C41 (\7\:A VSS) capacitor c=1.48533e-16
C42 (\8\:A VSS) capacitor c=1.57673e-16
C43 (\9\:A VSS) capacitor c=7.27974e-17
C44 (\9\:non VSS) capacitor c=7.18427e-17
C45 (\10\:non VSS) capacitor c=5.97279e-17
C46 (\8\:pon VSS) capacitor c=1.99117e-16
C47 (\4\:Y VSS) capacitor c=7.90216e-17
C48 (\8\:VDD VSS) capacitor c=1.5406e-17
C49 (\9\:VDD VSS) capacitor c=7.43772e-18
Rk1 (\8\:OE OE) resistor r=0.09997 c=0
Rk2 (OE \9\:OE) resistor r=0.1038 c=0
Rk15 (\1\:Y Y) resistor r=0.0738 c=0
Rk16 (Y \4\:Y) resistor r=0.21 c=0
Rk23 (\1\:VDD \7\:VDD) resistor r=0.2554 c=0
Rk24 (\7\:VDD \8\:VDD) resistor r=0.2755 c=0
Rk26 (\9\:VDD VDD) resistor r=0.06973 c=0
Rk25 (\8\:VDD \9\:VDD) resistor r=0.2051 c=0
Rk29 (\8\:VDD \15\:VDD) resistor r=0.2151 c=0
Rk30 (\9\:VDD \17\:VDD) resistor r=0.2573 c=0
Rk8 (\8\:A A) resistor r=0.003669 c=0
Rk6 (\7\:A \8\:A) resistor r=1.01 c=0
Rk7 (\8\:A \9\:A) resistor r=0.4051 c=0
Rk34 (\1\:VSS \7\:VSS) resistor r=0.286 c=0
Rk36 (\8\:VSS VSS) resistor r=0.2401 c=0
Rk35 (\7\:VSS \8\:VSS) resistor r=0.3113 c=0
Rk39 (\7\:VSS \14\:VSS) resistor r=0.07143 c=0
Rk40 (\8\:VSS \16\:VSS) resistor r=0.2329 c=0
Rk12 (\8\:pon \10\:pon) resistor r=1.3384 c=0
Rk13 (\10\:pon \12\:pon) resistor r=0.7152 c=0
Rk3 (\5\:OEb \6\:OEb) resistor r=0.05422 c=0
Rk4 (\6\:OEb \8\:OEb) resistor r=0.3249 c=0
Rk5 (\6\:OEb \10\:OEb) resistor r=0.179 c=0
Rk9 (\9\:non \10\:non) resistor r=0.3628 c=0
Rk10 (\10\:non \12\:non) resistor r=0.1488 c=0
Rk11 (\10\:non \14\:non) resistor r=0.238 c=0
Rl1 (\1\:OE \2\:OE) resistor r=87.2302 c=0
Rl2 (\2\:OE \3\:OE) resistor r=37.2302 c=0
Rl5 (\4\:OE \5\:OE) resistor r=118.464 c=0
Rl7 (\5\:OE \7\:OE) resistor r=28.0797 c=0
Rl6 (\5\:OE \6\:OE) resistor r=31.5487 c=0
Rl11 (\4\:A \5\:A) resistor r=99.1749 c=0
Rl12 (\5\:A \6\:A) resistor r=26.098 c=0
Rl3 (\1\:A \2\:A) resistor r=28.1965 c=0
Rl4 (\2\:A \3\:A) resistor r=90.1797 c=0
Rl8 (OEb \2\:OEb) resistor r=119.539 c=0
Rl10 (\2\:OEb \4\:OEb) resistor r=71.8171 c=0
Rl9 (\2\:OEb \3\:OEb) resistor r=14.532 c=0
Rl16 (non \5\:non) resistor r=24.9253 c=0
Rz6 (\1\:VDD \3\:VDD) resistor r=37.5 c=0
Rz7 (\7\:VDD \3\:VDD) resistor r=6.25 c=0
Rz11 (\14\:VSS \13\:VSS) resistor r=75 c=0
Rz12 (\16\:VSS \15\:VSS) resistor r=75 c=0
Rz3 (\12\:pon \11\:pon) resistor r=75 c=0
Rz1 (\9\:OEb \10\:OEb) resistor r=75 c=0
Rz2 (\14\:non \13\:non) resistor r=75 c=0
Ry9 (\15\:VDD \14\:VDD) resistor r=62 c=0
Ry10 (\17\:VDD \16\:VDD) resistor r=62 c=0
Ry11 (\1\:VSS \3\:VSS) resistor r=31 c=0
Ry12 (\7\:VSS \3\:VSS) resistor r=5.1667 c=0
Ry3 (\10\:pon \9\:pon) resistor r=20.6667 c=0
Ry1 (\7\:OEb \8\:OEb) resistor r=62 c=0
Ry2 (\12\:non \11\:non) resistor r=62 c=0
Rx1 (\6\:OE \8\:OE) resistor r=45 c=0
Rx2 (\2\:OE \9\:OE) resistor r=45 c=0
Rx4 (\5\:A \7\:A) resistor r=45 c=0
Rx5 (\2\:A \9\:A) resistor r=45 c=0
Rx7 (\8\:pon pon) resistor r=45 c=0
Rx3 (\3\:OEb \5\:OEb) resistor r=45 c=0
Rx6 (\9\:non \5\:non) resistor r=45 c=0
mn4 (\11\:pon \3\:OE net144 VSS) g45n1lvt w=(2.6e-07) l=4.5e-08 nf=1 \
        as=2.34e-14 ad=3.64e-14 ps=7e-07 pd=8e-07 nrd=1.16667 nrs=1.16667 \
        sa=1.4e-07 sb=5.39904e-07 sd=160n sca=11.0409 scb=0.0104003 \
        scc=0.000454168 m=(1)
mn3 (net144 \3\:A \15\:VSS VSS) g45n1lvt w=(2.6e-07) l=4.5e-08 nf=1 \
        as=5.887e-14 ad=2.34e-14 ps=1.11e-06 pd=7e-07 nrd=1.16667 \
        nrs=1.16667 sa=2.75e-07 sb=4.04904e-07 sd=160n sca=11.0409 \
        scb=0.0104003 scc=0.000454168 m=(1)
mn2 (\13\:non \4\:OEb \13\:VSS VSS) g45n1lvt w=(2.6e-07) l=4.5e-08 nf=1 \
        as=4.39e-14 ad=4.94e-14 ps=1.24e-06 pd=9e-07 nrd=1.16667 \
        nrs=1.16667 sa=1e-07 sb=1.31e-06 sd=160n sca=8.97712 \
        scb=0.00732387 scc=0.000196032 m=(1)
mn1 (\13\:non \6\:A \1\:VSS VSS) g45n1lvt w=(2.6e-07) l=4.5e-08 nf=1 \
        as=7.15e-14 ad=4.94e-14 ps=1.07e-06 pd=9e-07 nrd=1.16667 \
        nrs=1.16667 sa=3.35e-07 sb=1.075e-06 sd=160n sca=8.97712 \
        scb=0.00732387 scc=0.000196032 m=(1)
mn5_1__rcx (\4\:Y non \1\:VSS VSS) g45n1lvt w=(2.6e-07) l=4.5e-08 nf=1 \
        as=4.777e-14 ad=4.16e-14 ps=8.875e-07 pd=8.4e-07 nrd=1.16667 \
        nrs=1.16667 sa=6.55e-07 sb=7.55e-07 sd=160n sca=8.97712 \
        scb=0.00732387 scc=0.000196032 m=(4)
mn0 (\9\:OEb \7\:OE \15\:VSS VSS) g45n1lvt w=(1.45e-07) l=4.5e-08 nf=1 \
        as=5.887e-14 ad=3.987e-14 ps=1.11e-06 pd=8.4e-07 nrd=1.16667 \
        nrs=1.16667 sa=6.15e-07 sb=2.75e-07 sd=160n sca=13.6097 \
        scb=0.014254 scc=0.000755054 m=(1)
mp0 (\7\:OEb \4\:OE \14\:VDD VDD) g45p1lvt w=(2.15e-07) l=4.5e-08 nf=1 \
        as=8.412e-14 ad=3.01e-14 ps=1.33e-06 pd=7.1e-07 nrd=1.16667 \
        nrs=1.16667 sa=6.15e-07 sb=1.4e-07 sd=160n sca=22.3241 \
        scb=0.0209633 scc=0.0022509 m=(1)
ends TBUFX4
// End of subcircuit definition.
