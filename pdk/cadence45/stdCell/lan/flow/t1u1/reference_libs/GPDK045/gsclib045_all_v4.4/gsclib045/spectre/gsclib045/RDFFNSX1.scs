// gsclib045/RDFFNSX1/schematic

simulator lang=spectre

subckt RDFFNSX1 CKN D Q QN RT SN ExtVDD VDD VSS
NM3 (net0121 qbint VSS VSS) g45n1svt w=(145n) l=45n nf=1 m=(1)
NM2 (n35g RT net0121 VSS) g45n1svt w=(145n) l=45n nf=1 m=(1)
NM1 (qbint n35g VSS VSS) g45n1svt w=(145n) l=45n nf=1 m=(1)
NM0 (n35g RTb n35 VSS) g45n1svt w=(145n) l=45n nf=1 m=(1)
mn26 (n20 CKNbb n21 VSS) g45n1svt w=(145n) l=45n nf=1 m=(1)
mn25 (n21 D VSS VSS) g45n1svt w=(145n) l=45n nf=1 m=(1)
mn57 (QN qint VSS VSS) g45n1svt w=(260n) l=45n nf=1 m=(1)
mn55 (Q qbint VSS VSS) g45n1svt w=(260n) l=45n nf=1 m=(1)
mn35 (n30 mout VSS VSS) g45n1svt w=(145n) l=45n nf=1 m=(1)
mn36 (n20 CKNb n30 VSS) g45n1svt w=(145n) l=45n nf=1 m=(1)
mn20 (CKNb CKN VSS VSS) g45n1svt w=(145n) l=45n nf=1 m=(1)
mn45 (RTb RT VSS VSS) g45n1svt w=(145n) l=45n nf=1 m=(1)
mn56 (qint qbint VSS VSS) g45n1svt w=(145n) l=45n nf=1 m=(1)
mn52 (net095 qbint n42 VSS) g45n1svt w=(145n) l=45n nf=1 m=(1)
mn50 (n42 SN VSS VSS) g45n1svt w=(145n) l=45n nf=1 m=(1)
mn53 (n35 CKNbb net095 VSS) g45n1svt w=(145n) l=45n nf=1 m=(1)
mn21 (CKNbb CKNb VSS VSS) g45n1svt w=(145n) l=45n nf=1 m=(1)
mn32 (mout n20 net426 VSS) g45n1svt w=(145n) l=45n nf=1 m=(1)
mn40 (n35 CKNb mout VSS) g45n1svt w=(145n) l=45n nf=1 m=(1)
mn30 (net426 SN VSS VSS) g45n1svt w=(145n) l=45n nf=1 m=(1)
PM3 (n35g RTb net205 ExtVDD) g45p1svt w=(215n) l=45n nf=1 m=(1)
PM2 (net205 qbint ExtVDD ExtVDD) g45p1svt w=(215n) l=45n nf=1 m=(1)
PM1 (qbint n35g ExtVDD ExtVDD) g45p1svt w=(215n) l=45n nf=1 m=(1)
PM0 (n35g RT n35 ExtVDD) g45p1svt w=(215n) l=45n nf=1 m=(1)
mp26 (n20 CKNb n22 VDD) g45p1svt w=(215n) l=45n nf=1 m=(1)
mp25 (n22 D VDD VDD) g45p1svt w=(215n) l=45n nf=1 m=(1)
mp52 (n41 qbint VDD VDD) g45p1svt w=(215n) l=45n nf=1 m=(1)
mp57 (QN qint VDD VDD) g45p1svt w=(390n) l=45n nf=1 m=(1)
mp55 (Q qbint VDD VDD) g45p1svt w=(390n) l=45n nf=1 m=(1)
mp36 (n20 CKNbb n31 VDD) g45p1svt w=(215n) l=45n nf=1 m=(1)
mp35 (n31 mout VDD VDD) g45p1svt w=(215n) l=45n nf=1 m=(1)
mp32 (mout n20 VDD VDD) g45p1svt w=(215n) l=45n nf=1 m=(1)
mp20 (CKNb CKN VDD VDD) g45p1svt w=(215n) l=45n nf=1 m=(1)
mp53 (n35 CKNb n41 VDD) g45p1svt w=(215n) l=45n nf=1 m=(1)
mp50 (n41 SN VDD VDD) g45p1svt w=(215n) l=45n nf=1 m=(1)
mp45 (RTb RT ExtVDD ExtVDD) g45p1svt w=(215n) l=45n nf=1 m=(1)
mp56 (qint qbint VDD VDD) g45p1svt w=(215n) l=45n nf=1 m=(1)
mp21 (CKNbb CKNb VDD VDD) g45p1svt w=(215n) l=45n nf=1 m=(1)
mp30 (mout SN VDD VDD) g45p1svt w=(215n) l=45n nf=1 m=(1)
mp40 (n35 CKNbb mout VDD) g45p1svt w=(215n) l=45n nf=1 m=(1)
ends RDFFNSX1
