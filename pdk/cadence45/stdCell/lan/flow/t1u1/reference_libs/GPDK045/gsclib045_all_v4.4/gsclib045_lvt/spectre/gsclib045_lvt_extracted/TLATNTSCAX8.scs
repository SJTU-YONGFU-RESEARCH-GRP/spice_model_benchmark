// Generated for: spectre (May  1 09:19:25 2013 )
// Library name: gsclib045_lvt
// Cell name: TLATNTSCAX8
// View name: extracted

simulator lang=spectre

subckt TLATNTSCAX8 CK E ECK SE VDD VSS
mp1 (\5\:Eb \1\:E net246 VDD) g45p1lvt w=(2.15e-07) l=4.5e-08 nf=1 \
        as=1.29e-14 ad=3.01e-14 ps=5.5e-07 pd=7.1e-07 nrd=1.16667 \
        nrs=1.16667 sa=1.4e-07 sb=6.25e-07 sd=160n sca=18.4859 \
        scb=0.0197569 scc=0.000618499 m=(1)
mp0 (net246 \1\:SE \27\:VDD VDD) g45p1lvt w=(2.15e-07) l=4.5e-08 nf=1 \
        as=3.87e-14 ad=1.29e-14 ps=7.9e-07 pd=5.5e-07 nrd=1.16667 \
        nrs=1.16667 sa=2.45e-07 sb=5.2e-07 sd=160n sca=16.022 \
        scb=0.0154303 scc=0.000486038 m=(1)
mp2 (\14\:CKb \1\:CK \27\:VDD VDD) g45p1lvt w=(2.15e-07) l=4.5e-08 nf=1 \
        as=3.87e-14 ad=6.342e-14 ps=7.9e-07 pd=1.02e-06 nrd=1.16667 \
        nrs=1.16667 sa=4.7e-07 sb=2.95e-07 sd=160n sca=13.8909 \
        scb=0.0125053 scc=0.000462042 m=(1)
mp5 (\8\:n5 \3\:CKbb \7\:Eb VDD) g45p1lvt w=(2.15e-07) l=4.5e-08 nf=1 \
        as=4.408e-14 ad=3.44e-14 ps=8.4e-07 pd=7.5e-07 nrd=1.16667 \
        nrs=1.16667 sa=2.05e-07 sb=8.3e-07 sd=160n sca=11.1138 \
        scb=0.00912362 scc=0.000187967 m=(1)
mp16 (\8\:n5 \3\:CKb net234 VDD) g45p1lvt w=(2.15e-07) l=4.5e-08 nf=1 \
        as=1.29e-14 ad=3.44e-14 ps=5.5e-07 pd=7.5e-07 nrd=1.16667 \
        nrs=1.16667 sa=4.1e-07 sb=6.25e-07 sd=160n sca=11.1138 \
        scb=0.00912362 scc=0.000187967 m=(1)
mp15 (net234 \3\:Eint \25\:VDD VDD) g45p1lvt w=(2.15e-07) l=4.5e-08 nf=1 \
        as=7.203e-14 ad=1.29e-14 ps=1.1e-06 pd=5.5e-07 nrd=1.16667 \
        nrs=1.16667 sa=5.15e-07 sb=5.2e-07 sd=160n sca=11.1138 \
        scb=0.00912362 scc=0.000187967 m=(1)
mp3 (\14\:CKbb \5\:CKb \25\:VDD VDD) g45p1lvt w=(2.15e-07) l=4.5e-08 \
        nf=1 as=7.203e-14 ad=3.01e-14 ps=1.1e-06 pd=7.1e-07 nrd=1.16667 \
        nrs=1.16667 sa=8.95e-07 sb=1.4e-07 sd=160n sca=11.1138 \
        scb=0.00912362 scc=0.000187967 m=(1)
C1 (VDD VSS) capacitor c=2.9952e-16
C2 (ECK VSS) capacitor c=4.78297e-16
C3 (E VSS) capacitor c=3.56572e-17
C4 (Eb VSS) capacitor c=7.41745e-17
C5 (CKb VSS) capacitor c=3.04815e-17
C6 (n5 VSS) capacitor c=4.91195e-17
C7 (net263 VSS) capacitor c=1.22737e-18
C8 (CKbb VSS) capacitor c=2.36076e-17
C9 (Eint VSS) capacitor c=3.56375e-17
C10 (ECKb VSS) capacitor c=3.56022e-16
C11 (17 VSS) capacitor c=3.34753e-18
C12 (net246 VSS) capacitor c=1.44649e-18
C13 (net234 VSS) capacitor c=1.33092e-18
C14 (\3\:n5 VSS) capacitor c=4.05851e-17
C15 (\5\:CKb VSS) capacitor c=4.87859e-17
C16 (\3\:Eint VSS) capacitor c=7.02051e-17
C17 (\3\:CKb VSS) capacitor c=6.30284e-17
C18 (\3\:CKbb VSS) capacitor c=6.3097e-17
C19 (\1\:CK VSS) capacitor c=4.23026e-17
C20 (\1\:SE VSS) capacitor c=9.34513e-17
C21 (\1\:E VSS) capacitor c=9.26006e-17
C22 (\10\:Eint VSS) capacitor c=8.45392e-17
C23 (\4\:CKbb VSS) capacitor c=5.29633e-17
C24 (\9\:CKbb VSS) capacitor c=3.72695e-17
C25 (\4\:Eint VSS) capacitor c=6.3097e-17
C26 (\6\:CKb VSS) capacitor c=5.33847e-17
C27 (\3\:CK VSS) capacitor c=3.80093e-17
C28 (\3\:SE VSS) capacitor c=3.21754e-17
C29 (\4\:E VSS) capacitor c=2.6131e-17
C30 (\9\:ECKb VSS) capacitor c=3.52747e-17
C31 (\5\:Eint VSS) capacitor c=3.74535e-16
C32 (\2\:n5 VSS) capacitor c=4.2796e-17
C33 (\7\:CKb VSS) capacitor c=1.60315e-17
C34 (\2\:Eint VSS) capacitor c=8.35647e-17
C35 (\2\:CKbb VSS) capacitor c=8.27033e-17
C36 (\4\:CKb VSS) capacitor c=5.57285e-17
C37 (\2\:CKb VSS) capacitor c=1.8753e-17
C38 (\2\:CK VSS) capacitor c=4.39311e-17
C39 (\2\:SE VSS) capacitor c=7.77118e-17
C40 (\3\:E VSS) capacitor c=1.21546e-17
C41 (\23\:ECKb VSS) capacitor c=2.15593e-16
C42 (\21\:VDD VSS) capacitor c=4.02102e-17
C43 (\18\:Eint VSS) capacitor c=6.47695e-17
C44 (\14\:CKbb VSS) capacitor c=1.13538e-16
C45 (\25\:VDD VSS) capacitor c=5.54966e-17
C46 (\8\:n5 VSS) capacitor c=1.33958e-17
C47 (\7\:Eb VSS) capacitor c=2.07286e-17
C48 (\14\:CKb VSS) capacitor c=1.04234e-16
C49 (\27\:VDD VSS) capacitor c=4.80667e-17
C50 (\5\:Eb VSS) capacitor c=1.19892e-17
C51 (\1\:VDD VSS) capacitor c=5.15569e-17
C52 (\29\:ECKb VSS) capacitor c=4.93685e-17
C53 (\14\:Eint VSS) capacitor c=5.31525e-17
C54 (\11\:CKbb VSS) capacitor c=1.97581e-16
C55 (\6\:n5 VSS) capacitor c=8.08367e-17
C56 (\11\:CKb VSS) capacitor c=9.45205e-17
C57 (\9\:Eb VSS) capacitor c=8.7526e-17
C58 (\2\:E VSS) capacitor c=5.88619e-17
C59 (\5\:CKbb VSS) capacitor c=1.55703e-16
C60 (\5\:E VSS) capacitor c=4.61534e-17
C61 (\4\:SE VSS) capacitor c=1.28917e-16
C62 (\4\:CK VSS) capacitor c=1.18975e-16
C63 (\3\:Eb VSS) capacitor c=1.15829e-16
C64 (\4\:Eb VSS) capacitor c=1.46204e-16
C65 (\8\:CKb VSS) capacitor c=7.76923e-17
C66 (\9\:CKb VSS) capacitor c=9.36447e-17
C67 (\10\:CKb VSS) capacitor c=4.73999e-17
C68 (\13\:CKb VSS) capacitor c=9.73781e-17
C69 (\4\:n5 VSS) capacitor c=1.56921e-16
C70 (\5\:n5 VSS) capacitor c=1.97524e-16
C71 (\10\:CKbb VSS) capacitor c=1.25145e-16
C72 (\13\:CKbb VSS) capacitor c=1.66443e-16
C73 (\13\:Eint VSS) capacitor c=3.36811e-17
C74 (\16\:Eint VSS) capacitor c=6.04926e-17
C75 (\17\:Eint VSS) capacitor c=7.92064e-17
C76 (\26\:ECKb VSS) capacitor c=9.55457e-17
C77 (\3\:VDD VSS) capacitor c=4.29139e-16
C78 (\10\:VDD VSS) capacitor c=3.00671e-17
C79 (\12\:VDD VSS) capacitor c=1.68549e-17
Rk3 (CK \4\:CK) resistor r=0.0026 c=0
Rk42 (\2\:VDD \3\:VDD) resistor r=0.1327 c=0
Rk49 (\3\:VDD \10\:VDD) resistor r=0.436 c=0
Rk50 (\10\:VDD \11\:VDD) resistor r=0.3083 c=0
Rk52 (\12\:VDD VDD) resistor r=0.2353 c=0
Rk51 (\11\:VDD \12\:VDD) resistor r=0.3158 c=0
Rk57 (\3\:VDD \22\:VDD) resistor r=0.2343 c=0
Rk59 (\10\:VDD \26\:VDD) resistor r=0.2679 c=0
Rk60 (\12\:VDD \28\:VDD) resistor r=0.3046 c=0
Rk2 (SE \4\:SE) resistor r=0.003157 c=0
Rk1 (E \5\:E) resistor r=0.2247 c=0
Rk61 (\2\:VSS \3\:VSS) resistor r=0.1327 c=0
Rk66 (\3\:VSS \8\:VSS) resistor r=0.3206 c=0
Rk67 (\8\:VSS \9\:VSS) resistor r=0.431 c=0
Rk68 (\9\:VSS \10\:VSS) resistor r=0.396 c=0
Rk70 (\11\:VSS VSS) resistor r=0.2206 c=0
Rk69 (\10\:VSS \11\:VSS) resistor r=0.3308 c=0
Rk71 (VSS \13\:VSS) resistor r=0.1826 c=0
Rk76 (\8\:VSS \23\:VSS) resistor r=0.2945 c=0
Rk77 (\9\:VSS \25\:VSS) resistor r=0.1895 c=0
Rk78 (\11\:VSS \27\:VSS) resistor r=0.1763 c=0
Rk4 (\2\:Eb \3\:Eb) resistor r=0.4479 c=0
Rk5 (\3\:Eb \4\:Eb) resistor r=0.7504 c=0
Rk6 (\4\:Eb \6\:Eb) resistor r=0.1114 c=0
Rk7 (\3\:Eb \8\:Eb) resistor r=0.04435 c=0
Rk8 (\4\:Eb \10\:Eb) resistor r=0.5701 c=0
Rk9 (\8\:CKb \9\:CKb) resistor r=0.3353 c=0
Rk10 (\9\:CKb \10\:CKb) resistor r=0.3119 c=0
Rk11 (\10\:CKb \12\:CKb) resistor r=0.2729 c=0
Rk12 (\9\:CKb \13\:CKb) resistor r=0.4926 c=0
Rk13 (\12\:CKb \15\:CKb) resistor r=0.5503 c=0
Rk14 (\4\:n5 \5\:n5) resistor r=1.1857 c=0
Rk15 (\5\:n5 \7\:n5) resistor r=0.4734 c=0
Rk16 (\5\:n5 \9\:n5) resistor r=0.0279 c=0
Rk17 (\10\:CKbb \12\:CKbb) resistor r=0.9808 c=0
Rk18 (\12\:CKbb \13\:CKbb) resistor r=0.5898 c=0
Rk19 (\13\:CKbb \15\:CKbb) resistor r=0.6545 c=0
Rk21 (\5\:Eint \13\:Eint) resistor r=0.2174 c=0
Rk22 (\13\:Eint \15\:Eint) resistor r=0.1815 c=0
Rk23 (\13\:Eint \16\:Eint) resistor r=0.1259 c=0
Rk24 (\16\:Eint \17\:Eint) resistor r=0.3976 c=0
Rk25 (\16\:Eint \19\:Eint) resistor r=0.2359 c=0
Rk27 (\23\:ECKb \26\:ECKb) resistor r=0.4253 c=0
Rk29 (\26\:ECKb \30\:ECKb) resistor r=0.3739 c=0
Rl6 (\1\:CK \2\:CK) resistor r=144.923 c=0
Rl7 (\2\:CK \3\:CK) resistor r=96.8456 c=0
Rl4 (\1\:SE \2\:SE) resistor r=201.156 c=0
Rl5 (\2\:SE \3\:SE) resistor r=37.6944 c=0
Rl1 (\1\:E \2\:E) resistor r=249.51 c=0
Rl3 (\2\:E \4\:E) resistor r=24.4619 c=0
Rl2 (\2\:E \3\:E) resistor r=9.6389 c=0
Rl14 (\5\:CKb \6\:CKb) resistor r=195.72 c=0
Rl15 (\6\:CKb \7\:CKb) resistor r=29.5379 c=0
Rl9 (\3\:CKb \4\:CKb) resistor r=74.4182 c=0
Rl8 (CKb \2\:CKb) resistor r=74.2328 c=0
Rl17 (\2\:n5 \3\:n5) resistor r=26.3736 c=0
Rl16 (n5 \2\:n5) resistor r=149.566 c=0
Rl11 (\2\:CKbb \3\:CKbb) resistor r=224.554 c=0
Rl10 (\2\:CKbb CKbb) resistor r=24.2328 c=0
Rl20 (\5\:CKbb \4\:CKbb) resistor r=78.824 c=0
Rl24 (\5\:CKbb \9\:CKbb) resistor r=24.7951 c=0
Rl27 (\5\:Eint \10\:Eint) resistor r=106.708 c=0
Rl18 (\5\:Eint \4\:Eint) resistor r=105.746 c=0
Rl13 (\2\:Eint \3\:Eint) resistor r=146.817 c=0
Rl12 (\2\:Eint Eint) resistor r=37.6365 c=0
Rl35 (ECKb \9\:ECKb) resistor r=6.6042 c=0
Rz12 (\2\:VDD \1\:VDD) resistor r=37.5 c=0
Rz13 (\3\:VDD \1\:VDD) resistor r=6.25 c=0
Rz14 (\11\:VDD \1\:VDD) resistor r=6.25 c=0
Rz15 (\13\:VSS \12\:VSS) resistor r=75 c=0
Rz20 (\23\:VSS \22\:VSS) resistor r=75 c=0
Rz21 (\25\:VSS \24\:VSS) resistor r=75 c=0
Rz22 (\27\:VSS \26\:VSS) resistor r=75 c=0
Rz1 (Eb \2\:Eb) resistor r=75 c=0
Rz2 (\9\:Eb \10\:Eb) resistor r=75 c=0
Rz3 (\11\:CKb \12\:CKb) resistor r=75 c=0
Rz4 (\6\:n5 \7\:n5) resistor r=75 c=0
Rz5 (\12\:CKbb \11\:CKbb) resistor r=75 c=0
Rz6 (\15\:Eint \14\:Eint) resistor r=75 c=0
Rz7 (\30\:ECKb \29\:ECKb) resistor r=75 c=0
Ry17 (\22\:VDD \21\:VDD) resistor r=62 c=0
Ry19 (\26\:VDD \25\:VDD) resistor r=62 c=0
Ry20 (\28\:VDD \27\:VDD) resistor r=62 c=0
Ry21 (\2\:VSS \1\:VSS) resistor r=31 c=0
Ry22 (\3\:VSS \1\:VSS) resistor r=5.1667 c=0
Ry23 (\10\:VSS \1\:VSS) resistor r=5.1667 c=0
Ry1 (\5\:Eb \6\:Eb) resistor r=62 c=0
Ry2 (\7\:Eb \8\:Eb) resistor r=62 c=0
Ry3 (\14\:CKb \15\:CKb) resistor r=62 c=0
Ry4 (\8\:n5 \9\:n5) resistor r=62 c=0
Ry5 (\15\:CKbb \14\:CKbb) resistor r=62 c=0
Ry6 (\19\:Eint \18\:Eint) resistor r=62 c=0
Rx3 (\2\:CK \4\:CK) resistor r=45 c=0
Rx2 (\2\:SE \4\:SE) resistor r=45 c=0
Rx1 (\3\:E \5\:E) resistor r=45 c=0
Rx4 (\4\:CKb \8\:CKb) resistor r=45 c=0
Rx5 (\2\:CKb \10\:CKb) resistor r=45 c=0
Rx6 (\7\:CKb \13\:CKb) resistor r=45 c=0
Rx7 (\2\:n5 \4\:n5) resistor r=45 c=0
Rx8 (\10\:CKbb \5\:CKbb) resistor r=45 c=0
Rx9 (\13\:CKbb \2\:CKbb) resistor r=45 c=0
Rx12 (\17\:Eint \2\:Eint) resistor r=45 c=0
Rx13 (\26\:ECKb \9\:ECKb) resistor r=45 c=0
mn1 (\9\:Eb \4\:E \12\:VSS VSS) g45n1lvt w=(1.45e-07) l=4.5e-08 nf=1 \
        as=2.03e-14 ad=2.61e-14 ps=5.7e-07 pd=6.5e-07 nrd=1.16667 \
        nrs=1.16667 sa=1.4e-07 sb=6.7e-07 sd=160n sca=6.59604 \
        scb=0.00318587 scc=2.16275e-05 m=(1)
mn0 (\9\:Eb \3\:SE \26\:VSS VSS) g45n1lvt w=(1.45e-07) l=4.5e-08 nf=1 \
        as=2.61e-14 ad=2.61e-14 ps=6.5e-07 pd=6.5e-07 nrd=1.16667 \
        nrs=1.16667 sa=3.65e-07 sb=4.45e-07 sd=160n sca=6.59604 \
        scb=0.00318587 scc=2.16275e-05 m=(1)
mn2 (\11\:CKb \3\:CK \26\:VSS VSS) g45n1lvt w=(1.45e-07) l=4.5e-08 nf=1 \
        as=2.61e-14 ad=3.19e-14 ps=6.5e-07 pd=7.3e-07 nrd=1.16667 \
        nrs=1.16667 sa=5.9e-07 sb=2.2e-07 sd=160n sca=6.59604 \
        scb=0.00318587 scc=2.16275e-05 m=(1)
mn5 (Eb CKb \6\:n5 VSS) g45n1lvt w=(1.45e-07) l=4.5e-08 nf=1 as=5.365e-14 \
        ad=2.03e-14 ps=1.03e-06 pd=5.7e-07 nrd=1.16667 nrs=1.16667 \
        sa=1.4e-07 sb=1.115e-06 sd=160n sca=23.279 scb=0.0230742 \
        scc=0.00267719 m=(1)
mn16 (\6\:n5 CKbb net263 VSS) g45n1lvt w=(1.45e-07) l=4.5e-08 nf=1 \
        as=1.957e-14 ad=5.365e-14 ps=5.6e-07 pd=1.03e-06 nrd=1.16667 \
        nrs=1.16667 sa=5.55e-07 sb=7e-07 sd=160n sca=23.279 scb=0.0230742 \
        scc=0.00267719 m=(1)
mn15 (net263 Eint \24\:VSS VSS) g45n1lvt w=(1.45e-07) l=4.5e-08 nf=1 \
        as=7.12e-14 ad=1.957e-14 ps=1.36e-06 pd=5.6e-07 nrd=1.16667 \
        nrs=1.16667 sa=7.35e-07 sb=5.2e-07 sd=160n sca=23.279 \
        scb=0.0230742 scc=0.00267719 m=(1)
mn3 (\11\:CKbb \6\:CKb \24\:VSS VSS) g45n1lvt w=(1.45e-07) l=4.5e-08 \
        nf=1 as=7.12e-14 ad=2.827e-14 ps=1.36e-06 pd=6.8e-07 nrd=1.16667 \
        nrs=1.16667 sa=1.06e-06 sb=1.95e-07 sd=160n sca=23.279 \
        scb=0.0230742 scc=0.00267719 m=(1)
mn10 (\14\:Eint n5 \22\:VSS VSS) g45n1lvt w=(2.05e-07) l=4.5e-08 nf=1 \
        as=6.187e-14 ad=2.87e-14 ps=1.07e-06 pd=6.9e-07 nrd=1.16667 \
        nrs=1.16667 sa=1.4e-07 sb=2e-06 sd=160n sca=13.4389 scb=0.0137383 \
        scc=0.000784938 m=(1)
mn20_1__rcx (16 \4\:Eint \22\:VSS VSS) g45n1lvt w=(2.6e-07) l=4.5e-08 \
        nf=1 as=6.187e-14 ad=2.08e-14 ps=1.07e-06 pd=6.8e-07 nrd=1.16667 \
        nrs=1.16667 sa=3.83846e-07 sb=2e-06 sd=160n sca=12.1772 \
        scb=0.0118935 scc=0.000630577 m=(1)
mn21_1__rcx (\29\:ECKb \9\:CKbb 16 VSS) g45n1lvt w=(2.6e-07) l=4.5e-08 \
        nf=1 as=2.08e-14 ad=4.16e-14 ps=6.8e-07 pd=8.4e-07 nrd=1.16667 \
        nrs=1.16667 sa=5.08846e-07 sb=1.9e-06 sd=160n sca=12.1772 \
        scb=0.0118935 scc=0.000630577 m=(1)
mn21 (\29\:ECKb \4\:CKbb 17 VSS) g45n1lvt w=(2.6e-07) l=4.5e-08 nf=1 \
        as=1.56e-14 ad=4.16e-14 ps=6.4e-07 pd=8.4e-07 nrd=1.16667 \
        nrs=1.16667 sa=7.13846e-07 sb=1.695e-06 sd=160n sca=12.1772 \
        scb=0.0118935 scc=0.000630577 m=(1)
mn20 (17 \10\:Eint \3\:VSS VSS) g45n1lvt w=(2.6e-07) l=4.5e-08 nf=1 \
        as=4.51e-14 ad=1.56e-14 ps=9.1e-07 pd=6.4e-07 nrd=1.16667 \
        nrs=1.16667 sa=8.18846e-07 sb=1.59e-06 sd=160n sca=12.1772 \
        scb=0.0118935 scc=0.000630577 m=(1)
mn22_1__rcx (ECK ECKb \3\:VSS VSS) g45n1lvt w=(2.95e-07) l=4.5e-08 nf=1 \
        as=4.69e-14 ad=4.762e-14 ps=9.1e-07 pd=9.1286e-07 nrd=1.16667 \
        nrs=1.16667 sa=9.14237e-07 sb=1.385e-06 sd=160n sca=13.9473 \
        scb=0.0136631 scc=0.00097867 m=(7)
mp10 (\18\:Eint \3\:n5 \3\:VDD VDD) g45p1lvt w=(3.1e-07) l=4.5e-08 nf=1 \
        as=8.705e-14 ad=4.96e-14 ps=1.29e-06 pd=9.4e-07 nrd=1.16667 \
        nrs=1.16667 sa=1.6e-07 sb=2e-06 sd=160n sca=11.3312 scb=0.00941412 \
        scc=0.000228915 m=(1)
mp20_1__rcx (\23\:ECKb \5\:Eint \3\:VDD VDD) g45p1lvt w=(3.9e-07) \
        l=4.5e-08 nf=1 as=7.747e-14 ad=6.24e-14 ps=1.25e-06 pd=1.1e-06 \
        nrd=1.16667 nrs=1.16667 sa=3.86154e-07 sb=2e-06 sd=160n \
        sca=13.5671 scb=0.012183 scc=0.000647513 m=(2)
mp21 (\23\:ECKb \5\:CKbb \21\:VDD VDD) g45p1lvt w=(3.9e-07) l=4.5e-08 \
        nf=1 as=6.24e-14 ad=6.24e-14 ps=1.1e-06 pd=1.1e-06 nrd=1.16667 \
        nrs=1.16667 sa=5.91154e-07 sb=1.985e-06 sd=160n sca=13.5671 \
        scb=0.012183 scc=0.000647513 m=(2)
mp22_1__rcx (ECK ECKb \3\:VDD VDD) g45p1lvt w=(4.45e-07) l=4.5e-08 nf=1 \
        as=7.073e-14 ad=6.993e-14 ps=1.21e-06 pd=1.20429e-06 nrd=1.16667 \
        nrs=1.16667 sa=1.06944e-06 sb=1.37e-06 sd=160n sca=16.8284 \
        scb=0.0145775 scc=0.00130846 m=(7)
ends TLATNTSCAX8
// End of subcircuit definition.
