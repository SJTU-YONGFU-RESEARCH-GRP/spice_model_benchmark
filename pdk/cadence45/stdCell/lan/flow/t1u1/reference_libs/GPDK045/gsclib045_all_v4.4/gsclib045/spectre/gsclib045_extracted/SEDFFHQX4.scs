// Generated for: spectre (May  1 08:14:15 2013 )
// Library name: gsclib045
// Cell name: SEDFFHQX4
// View name: extracted

simulator lang=spectre

subckt SEDFFHQX4 CK D E Q SE SI VDD VSS
mp56 (\8\:qint \18\:qbint \22\:VDD VDD) g45p1svt w=(3.9e-07) l=4.5e-08 \
        nf=1 as=9.28e-14 ad=1.521e-13 ps=1.37e-06 pd=1.56e-06 nrd=1.16667 \
        nrs=1.16667 sa=3.57628e-07 sb=3.9e-07 sd=160n sca=30.5009 \
        scb=0.0202006 scc=0.00336097 m=(1)
mp12 (net441 \4\:SI \20\:VDD VDD) g45p1svt w=(3.9e-07) l=4.5e-08 nf=1 \
        as=1.0105e-13 ad=2.34e-14 ps=1.62e-06 pd=9e-07 nrd=1.16667 \
        nrs=1.16667 sa=2.99551e-07 sb=5.65e-07 sd=160n sca=12.53 \
        scb=0.0110214 scc=0.000443901 m=(1)
mp13 (\4\:Dbp \2\:SEb net441 VDD) g45p1svt w=(3.9e-07) l=4.5e-08 nf=1 \
        as=2.34e-14 ad=7.41e-14 ps=9e-07 pd=1.16e-06 nrd=1.16667 \
        nrs=1.16667 sa=4.04551e-07 sb=4.6e-07 sd=160n sca=12.53 \
        scb=0.0110214 scc=0.000443901 m=(1)
mp11 (\5\:Db \6\:SE \4\:Dbp VDD) g45p1svt w=(3.9e-07) l=4.5e-08 nf=1 \
        as=7.41e-14 ad=8.775e-14 ps=1.16e-06 pd=1.23e-06 nrd=1.16667 \
        nrs=1.16667 sa=6.39551e-07 sb=2.25e-07 sd=160n sca=12.53 \
        scb=0.0110214 scc=0.000443901 m=(1)
mp1 (net405 qint \18\:VDD VDD) g45p1svt w=(3.9e-07) l=4.5e-08 nf=1 \
        as=5.995e-14 ad=2.34e-14 ps=1.16e-06 pd=9e-07 nrd=1.16667 \
        nrs=1.16667 sa=2.55705e-07 sb=9.69295e-07 sd=160n sca=16.7336 \
        scb=0.0149207 scc=0.00128056 m=(1)
mp2 (\7\:Db \2\:E net405 VDD) g45p1svt w=(3.9e-07) l=4.5e-08 nf=1 \
        as=2.34e-14 ad=7.02e-14 ps=9e-07 pd=1.14e-06 nrd=1.16667 \
        nrs=1.16667 sa=3.60705e-07 sb=8.64295e-07 sd=160n sca=16.7336 \
        scb=0.0149207 scc=0.00128056 m=(1)
mp4 (\7\:Db Eb net449 VDD) g45p1svt w=(3.9e-07) l=4.5e-08 nf=1 \
        as=8.58e-14 ad=7.02e-14 ps=1.22e-06 pd=1.14e-06 nrd=1.16667 \
        nrs=1.16667 sa=5.85705e-07 sb=6.39295e-07 sd=160n sca=16.7336 \
        scb=0.0149207 scc=0.00128056 m=(1)
mp3 (net449 \1\:D \16\:VDD VDD) g45p1svt w=(3.9e-07) l=4.5e-08 nf=1 \
        as=1.062e-13 ad=8.58e-14 ps=1.54e-06 pd=1.22e-06 nrd=1.16667 \
        nrs=1.16667 sa=8.50705e-07 sb=3.74295e-07 sd=160n sca=17.4538 \
        scb=0.0152267 scc=0.00128072 m=(1)
mp55_1__rcx (Q qbint VDD VDD) g45p1svt w=(3.9e-07) l=4.5e-08 nf=1 \
        as=6.235e-14 ad=6.24e-14 ps=1.11e-06 pd=1.1e-06 nrd=1.16667 \
        nrs=1.16667 sa=1.4e-07 sb=1.73641e-06 sd=160n sca=31.4485 \
        scb=0.0346421 scc=0.00289038 m=(4)
C1 (D VSS) capacitor c=1.42812e-16
C2 (Q VSS) capacitor c=2.57234e-16
C3 (CK VSS) capacitor c=4.37042e-17
C4 (VDD VSS) capacitor c=7.60459e-16
C5 (SE VSS) capacitor c=7.36724e-17
C6 (E VSS) capacitor c=6.56155e-17
C7 (SI VSS) capacitor c=5.70435e-17
C8 (qbint VSS) capacitor c=2.29569e-16
C9 (n30 VSS) capacitor c=1.88649e-16
C10 (net509 VSS) capacitor c=2.29117e-18
C11 (CKb VSS) capacitor c=2.42788e-17
C12 (mout VSS) capacitor c=5.32717e-17
C13 (Ckbb VSS) capacitor c=5.03907e-17
C14 (n20 VSS) capacitor c=3.99401e-17
C15 (net501 VSS) capacitor c=3.92598e-19
C16 (Dbp VSS) capacitor c=9.38008e-17
C17 (qint VSS) capacitor c=1.05836e-16
C18 (net518 VSS) capacitor c=4.02074e-18
C19 (Db VSS) capacitor c=9.42209e-17
C20 (SEb VSS) capacitor c=5.69769e-17
C21 (net494 VSS) capacitor c=7.29788e-18
C22 (Eb VSS) capacitor c=3.69975e-17
C23 (net426 VSS) capacitor c=4.31478e-18
C24 (net417 VSS) capacitor c=3.63511e-18
C25 (net441 VSS) capacitor c=2.40277e-18
C26 (net405 VSS) capacitor c=2.4314e-18
C27 (net449 VSS) capacitor c=6.67059e-18
C28 (\7\:E VSS) capacitor c=3.62009e-17
C29 (\1\:D VSS) capacitor c=4.31914e-17
C30 (\2\:E VSS) capacitor c=7.17544e-17
C31 (\1\:SE VSS) capacitor c=4.08992e-17
C32 (\6\:SE VSS) capacitor c=4.68449e-17
C33 (\2\:SEb VSS) capacitor c=7.03513e-17
C34 (\4\:SI VSS) capacitor c=6.84902e-17
C35 (\1\:CK VSS) capacitor c=2.41071e-17
C36 (\18\:qbint VSS) capacitor c=4.72578e-17
C37 (\7\:CKb VSS) capacitor c=2.18736e-17
C38 (\7\:Ckbb VSS) capacitor c=3.57881e-17
C39 (\4\:CKb VSS) capacitor c=1.07108e-16
C40 (\5\:CKb VSS) capacitor c=8.82931e-17
C41 (\14\:qbint VSS) capacitor c=4.5532e-17
C42 (\5\:E VSS) capacitor c=2.06363e-17
C43 (\3\:D VSS) capacitor c=6.91879e-17
C44 (\3\:E VSS) capacitor c=7.09038e-17
C45 (\3\:Eb VSS) capacitor c=6.40125e-17
C46 (\4\:qint VSS) capacitor c=2.81098e-17
C47 (\5\:SE VSS) capacitor c=3.93394e-17
C48 (\3\:SEb VSS) capacitor c=3.13543e-17
C49 (\4\:SE VSS) capacitor c=6.48711e-17
C50 (\1\:SI VSS) capacitor c=4.99463e-17
C51 (\3\:CK VSS) capacitor c=3.87561e-17
C52 (\20\:qbint VSS) capacitor c=4.41282e-17
C53 (\8\:CKb VSS) capacitor c=2.82543e-17
C54 (\5\:Ckbb VSS) capacitor c=5.95916e-17
C55 (\4\:mout VSS) capacitor c=5.55758e-17
C56 (\3\:n20 VSS) capacitor c=3.88756e-17
C57 (\3\:Ckbb VSS) capacitor c=3.33105e-17
C58 (\6\:CKb VSS) capacitor c=6.4441e-17
C59 (\17\:qbint VSS) capacitor c=3.841e-17
C60 (\6\:E VSS) capacitor c=2.57354e-17
C61 (\2\:D VSS) capacitor c=4.06323e-17
C62 (\4\:E VSS) capacitor c=4.64328e-17
C63 (\1\:E VSS) capacitor c=4.72399e-17
C64 (\3\:qint VSS) capacitor c=2.55575e-17
C65 (\2\:SE VSS) capacitor c=7.85904e-17
C66 (\5\:SEb VSS) capacitor c=3.78165e-17
C67 (\4\:SEb VSS) capacitor c=3.95696e-17
C68 (\3\:SI VSS) capacitor c=2.54846e-17
C69 (\2\:CK VSS) capacitor c=3.54205e-17
C70 (\2\:CKb VSS) capacitor c=3.69686e-17
C71 (\19\:qbint VSS) capacitor c=3.0732e-17
C72 (\8\:Ckbb VSS) capacitor c=3.29668e-17
C73 (\6\:Ckbb VSS) capacitor c=4.27648e-17
C74 (\3\:mout VSS) capacitor c=2.35477e-17
C75 (\2\:n20 VSS) capacitor c=3.33874e-17
C76 (\4\:Ckbb VSS) capacitor c=2.8974e-17
C77 (\2\:Ckbb VSS) capacitor c=3.44994e-17
C78 (\16\:qbint VSS) capacitor c=2.79274e-17
C79 (\8\:qbint VSS) capacitor c=1.99353e-17
C80 (\7\:Eb VSS) capacitor c=1.01398e-16
C81 (\16\:VDD VSS) capacitor c=3.67865e-17
C82 (\7\:Db VSS) capacitor c=5.60763e-17
C83 (\18\:VDD VSS) capacitor c=4.11068e-17
C84 (\9\:SEb VSS) capacitor c=9.28764e-17
C85 (\5\:Db VSS) capacitor c=4.53421e-17
C86 (\4\:Dbp VSS) capacitor c=5.44263e-17
C87 (\20\:VDD VSS) capacitor c=2.05931e-17
C88 (\13\:CKb VSS) capacitor c=5.6802e-17
C89 (\8\:qint VSS) capacitor c=8.28028e-17
C90 (\22\:VDD VSS) capacitor c=6.46831e-17
C91 (\9\:Ckbb VSS) capacitor c=6.6158e-17
C92 (\10\:Dbp VSS) capacitor c=4.32015e-17
C93 (\4\:n20 VSS) capacitor c=6.24892e-17
C94 (\24\:VDD VSS) capacitor c=4.99971e-17
C95 (\9\:mout VSS) capacitor c=5.25073e-17
C96 (\7\:n30 VSS) capacitor c=2.91211e-17
C97 (\26\:qbint VSS) capacitor c=3.99166e-17
C98 (\1\:VDD VSS) capacitor c=1.10141e-16
C99 (\5\:Eb VSS) capacitor c=4.79193e-17
C100 (\6\:SEb VSS) capacitor c=6.29787e-17
C101 (\9\:Db VSS) capacitor c=7.57205e-17
C102 (\9\:CKb VSS) capacitor c=8.91886e-17
C103 (\6\:qint VSS) capacitor c=2.69097e-16
C104 (\11\:Ckbb VSS) capacitor c=7.80353e-17
C105 (\7\:Dbp VSS) capacitor c=7.23899e-17
C106 (\8\:n20 VSS) capacitor c=7.49663e-17
C107 (\7\:mout VSS) capacitor c=5.52002e-17
C108 (\11\:n30 VSS) capacitor c=8.33719e-17
C109 (\28\:qbint VSS) capacitor c=3.38555e-17
C110 (\15\:qbint VSS) capacitor c=3.12907e-17
C111 (\2\:mout VSS) capacitor c=3.497e-17
C112 (\3\:CKb VSS) capacitor c=6.45748e-17
C113 (\2\:SI VSS) capacitor c=3.72236e-17
C114 (\3\:SE VSS) capacitor c=7.29359e-17
C115 (\2\:qint VSS) capacitor c=2.38444e-17
C116 (\9\:n30 VSS) capacitor c=9.65347e-17
C117 (\10\:n30 VSS) capacitor c=9.27899e-17
C118 (\2\:Eb VSS) capacitor c=5.12911e-17
C119 (\5\:mout VSS) capacitor c=6.52896e-17
C120 (\6\:mout VSS) capacitor c=4.56282e-17
C121 (\6\:n20 VSS) capacitor c=8.43628e-17
C122 (\7\:n20 VSS) capacitor c=8.41085e-17
C123 (\13\:Ckbb VSS) capacitor c=1.07936e-16
C124 (\14\:Ckbb VSS) capacitor c=1.29558e-16
C125 (\15\:Ckbb VSS) capacitor c=1.34144e-16
C126 (\16\:Ckbb VSS) capacitor c=9.19873e-17
C127 (\17\:Ckbb VSS) capacitor c=7.28414e-17
C128 (\18\:Ckbb VSS) capacitor c=4.13122e-17
C129 (\19\:Ckbb VSS) capacitor c=5.14172e-17
C130 (\21\:qbint VSS) capacitor c=2.5675e-16
C131 (\22\:qbint VSS) capacitor c=2.4549e-16
C132 (\23\:qbint VSS) capacitor c=2.42832e-17
C133 (\24\:qbint VSS) capacitor c=3.05722e-17
C134 (\25\:qbint VSS) capacitor c=2.35956e-17
C135 (\11\:CKb VSS) capacitor c=1.67879e-16
C136 (\12\:CKb VSS) capacitor c=9.91113e-17
C137 (\4\:CK VSS) capacitor c=7.26217e-17
C138 (\5\:SI VSS) capacitor c=8.75724e-17
C139 (\3\:Dbp VSS) capacitor c=2.47862e-16
C140 (\6\:Dbp VSS) capacitor c=2.56556e-16
C141 (\8\:SEb VSS) capacitor c=5.15438e-17
C142 (\11\:SEb VSS) capacitor c=1.21341e-16
C143 (\12\:SEb VSS) capacitor c=4.02108e-17
C144 (\13\:SEb VSS) capacitor c=4.17474e-17
C145 (\5\:qint VSS) capacitor c=2.99209e-16
C146 (\7\:SE VSS) capacitor c=5.04509e-17
C147 (\3\:Db VSS) capacitor c=1.48872e-16
C148 (\4\:Db VSS) capacitor c=9.48019e-17
C149 (\8\:E VSS) capacitor c=6.82223e-17
C150 (\9\:E VSS) capacitor c=6.24321e-17
C151 (\10\:E VSS) capacitor c=3.24864e-17
C152 (\9\:Eb VSS) capacitor c=1.09596e-16
C153 (\3\:VDD VSS) capacitor c=1.39991e-17
C154 (\4\:VDD VSS) capacitor c=3.15254e-17
C155 (\6\:VDD VSS) capacitor c=4.55517e-17
C156 (\7\:VDD VSS) capacitor c=3.84391e-17
C157 (\9\:VDD VSS) capacitor c=6.40935e-17
Rk53 (D \4\:D) resistor r=0.00509 c=0
Rk33 (CK \4\:CK) resistor r=0.1025 c=0
Rk59 (\2\:VDD \3\:VDD) resistor r=0.05499 c=0
Rk60 (\3\:VDD \4\:VDD) resistor r=0.4009 c=0
Rk61 (\4\:VDD \5\:VDD) resistor r=0.3961 c=0
Rk62 (\5\:VDD \6\:VDD) resistor r=0.356 c=0
Rk63 (\6\:VDD \7\:VDD) resistor r=0.6543 c=0
Rk64 (\7\:VDD \8\:VDD) resistor r=0.1929 c=0
Rk66 (\9\:VDD VDD) resistor r=0.6518 c=0
Rk65 (\8\:VDD \9\:VDD) resistor r=0.4513 c=0
Rk72 (\3\:VDD \17\:VDD) resistor r=0.2547 c=0
Rk73 (\4\:VDD \19\:VDD) resistor r=0.2554 c=0
Rk74 (\6\:VDD \21\:VDD) resistor r=0.07405 c=0
Rk75 (\7\:VDD \23\:VDD) resistor r=0.2723 c=0
Rk76 (\9\:VDD \25\:VDD) resistor r=0.2637 c=0
Rk47 (SE \7\:SE) resistor r=0.02065 c=0
Rk55 (\9\:E E) resistor r=0.2611 c=0
Rk54 (\8\:E \9\:E) resistor r=0.3114 c=0
Rk56 (E \10\:E) resistor r=0.1412 c=0
Rk34 (SI \5\:SI) resistor r=0.0691 c=0
Rk80 (\2\:VSS \3\:VSS) resistor r=0.05499 c=0
Rk81 (\3\:VSS \4\:VSS) resistor r=0.436 c=0
Rk82 (\4\:VSS \5\:VSS) resistor r=0.361 c=0
Rk83 (\5\:VSS \6\:VSS) resistor r=0.3459 c=0
Rk84 (\6\:VSS \7\:VSS) resistor r=0.6518 c=0
Rk85 (\7\:VSS \8\:VSS) resistor r=0.2055 c=0
Rk87 (\9\:VSS VSS) resistor r=0.6718 c=0
Rk86 (\8\:VSS \9\:VSS) resistor r=0.4463 c=0
Rk93 (\3\:VSS \17\:VSS) resistor r=0.2915 c=0
Rk94 (\4\:VSS \19\:VSS) resistor r=0.2384 c=0
Rk95 (\6\:VSS \21\:VSS) resistor r=0.2604 c=0
Rk96 (\7\:VSS \23\:VSS) resistor r=0.2993 c=0
Rk97 (\9\:VSS \25\:VSS) resistor r=0.296 c=0
Rk24 (\21\:qbint \22\:qbint) resistor r=2.266 c=0
Rk25 (\22\:qbint \23\:qbint) resistor r=0.183 c=0
Rk26 (\23\:qbint \24\:qbint) resistor r=0.2231 c=0
Rk27 (\24\:qbint \25\:qbint) resistor r=0.1016 c=0
Rk28 (\23\:qbint \27\:qbint) resistor r=0.1387 c=0
Rk29 (\24\:qbint \29\:qbint) resistor r=0.1868 c=0
Rk7 (\8\:n30 \9\:n30) resistor r=0.06101 c=0
Rk8 (\9\:n30 \10\:n30) resistor r=0.6427 c=0
Rk9 (\9\:n30 \12\:n30) resistor r=0.3688 c=0
Rk30 (\10\:CKb \11\:CKb) resistor r=0.5558 c=0
Rk31 (\11\:CKb \12\:CKb) resistor r=0.8925 c=0
Rk32 (\11\:CKb \14\:CKb) resistor r=0.1782 c=0
Rk10 (\5\:mout \6\:mout) resistor r=0.2587 c=0
Rk11 (\6\:mout \8\:mout) resistor r=0.1613 c=0
Rk12 (\6\:mout \10\:mout) resistor r=0.2265 c=0
Rk16 (\10\:Ckbb \12\:Ckbb) resistor r=0.3391 c=0
Rk17 (\12\:Ckbb \13\:Ckbb) resistor r=0.506 c=0
Rk18 (\13\:Ckbb \14\:Ckbb) resistor r=0.4525 c=0
Rk19 (\14\:Ckbb \15\:Ckbb) resistor r=0.7052 c=0
Rk20 (\15\:Ckbb \16\:Ckbb) resistor r=0.5982 c=0
Rk21 (\13\:Ckbb \17\:Ckbb) resistor r=0.4144 c=0
Rk22 (\14\:Ckbb \18\:Ckbb) resistor r=0.08119 c=0
Rk23 (\15\:Ckbb \19\:Ckbb) resistor r=0.2304 c=0
Rk13 (\5\:n20 \6\:n20) resistor r=0.1815 c=0
Rk14 (\6\:n20 \7\:n20) resistor r=0.4381 c=0
Rk15 (\6\:n20 \9\:n20) resistor r=0.3158 c=0
Rk35 (\2\:Dbp \3\:Dbp) resistor r=0.6187 c=0
Rk36 (\3\:Dbp \5\:Dbp) resistor r=0.1001 c=0
Rk37 (\3\:Dbp \6\:Dbp) resistor r=1.7858 c=0
Rk38 (\6\:Dbp \8\:Dbp) resistor r=0.4313 c=0
Rk39 (\5\:Dbp \9\:Dbp) resistor r=0.1794 c=0
Rk40 (\6\:Dbp \11\:Dbp) resistor r=0.1628 c=0
Rk45 (\5\:qint \7\:qint) resistor r=2.3912 c=0
Rk46 (\7\:qint \9\:qint) resistor r=0.5296 c=0
Rk48 (\2\:Db \3\:Db) resistor r=0.6497 c=0
Rk49 (\3\:Db \4\:Db) resistor r=0.6435 c=0
Rk50 (\4\:Db \6\:Db) resistor r=0.07972 c=0
Rk51 (\3\:Db \8\:Db) resistor r=0.2506 c=0
Rk52 (\4\:Db \10\:Db) resistor r=0.4293 c=0
Rk41 (\7\:SEb \8\:SEb) resistor r=0.1937 c=0
Rk42 (\10\:SEb \11\:SEb) resistor r=0.7898 c=0
Rk43 (\11\:SEb \12\:SEb) resistor r=0.08634 c=0
Rk44 (\11\:SEb \13\:SEb) resistor r=0.2134 c=0
Rk57 (\6\:Eb \8\:Eb) resistor r=0.4652 c=0
Rk58 (\8\:Eb \9\:Eb) resistor r=0.6821 c=0
Rl60 (\1\:D \2\:D) resistor r=39.1533 c=0
Rl61 (\2\:D \3\:D) resistor r=87.2302 c=0
Rl39 (\1\:CK \2\:CK) resistor r=67.3077 c=0
Rl40 (\2\:CK \3\:CK) resistor r=70.3297 c=0
Rl47 (\1\:SE \2\:SE) resistor r=132.669 c=0
Rl50 (\2\:SE \5\:SE) resistor r=97.872 c=0
Rl51 (\3\:SE \6\:SE) resistor r=47.3105 c=0
Rl49 (\3\:SE \4\:SE) resistor r=143.03 c=0
Rl48 (\2\:SE \3\:SE) resistor r=241.222 c=0
Rl63 (\6\:E \7\:E) resistor r=97.2527 c=0
Rl62 (\5\:E \6\:E) resistor r=40.3846 c=0
Rl59 (\3\:E \4\:E) resistor r=24.2328 c=0
Rl55 (\1\:E \2\:E) resistor r=33.8727 c=0
Rl43 (\2\:SI \4\:SI) resistor r=37.3411 c=0
Rl41 (\1\:SI \2\:SI) resistor r=110.786 c=0
Rl42 (\2\:SI \3\:SI) resistor r=8.3025 c=0
Rl38 (\20\:qbint \18\:qbint) resistor r=92.3077 c=0
Rl37 (\19\:qbint \18\:qbint) resistor r=146.131 c=0
Rl7 (qbint \8\:qbint) resistor r=9.5287 c=0
Rl18 (\15\:qbint \14\:qbint) resistor r=34.3295 c=0
Rl20 (\15\:qbint \17\:qbint) resistor r=124.714 c=0
Rl19 (\15\:qbint \16\:qbint) resistor r=11.4953 c=0
Rl33 (\4\:CKb \5\:CKb) resistor r=520.72 c=0
Rl34 (\5\:CKb \6\:CKb) resistor r=210.777 c=0
Rl35 (\2\:CKb \7\:CKb) resistor r=24.7951 c=0
Rl30 (CKb \2\:CKb) resistor r=35.3482 c=0
Rl32 (\3\:CKb \4\:CKb) resistor r=149.543 c=0
Rl36 (\3\:CKb \8\:CKb) resistor r=49.6815 c=0
Rl31 (\2\:CKb \3\:CKb) resistor r=248.466 c=0
Rl25 (mout \2\:mout) resistor r=95.0334 c=0
Rl27 (\2\:mout \4\:mout) resistor r=62.3411 c=0
Rl26 (\2\:mout \3\:mout) resistor r=6.9867 c=0
Rl29 (\7\:Ckbb \8\:Ckbb) resistor r=30.0021 c=0
Rl28 (\5\:Ckbb \6\:Ckbb) resistor r=35.7713 c=0
Rl22 (\3\:Ckbb \4\:Ckbb) resistor r=24.2328 c=0
Rl21 (Ckbb \2\:Ckbb) resistor r=64.6174 c=0
Rl23 (n20 \2\:n20) resistor r=24.2328 c=0
Rl24 (\2\:n20 \3\:n20) resistor r=114.617 c=0
Rl52 (qint \2\:qint) resistor r=120.387 c=0
Rl54 (\2\:qint \4\:qint) resistor r=28.0797 c=0
Rl53 (\2\:qint \3\:qint) resistor r=54.6257 c=0
Rl45 (\3\:SEb \4\:SEb) resistor r=27.6559 c=0
Rl46 (\4\:SEb \5\:SEb) resistor r=107.617 c=0
Rl44 (SEb \2\:SEb) resistor r=39.4 c=0
Rl56 (Eb \2\:Eb) resistor r=67.4757 c=0
Rl57 (\2\:Eb \3\:Eb) resistor r=139.972 c=0
Rl58 (\2\:Eb \4\:Eb) resistor r=1.2666 c=0
Rz19 (VDD \1\:VDD) resistor r=6.25 c=0
Rz16 (\2\:VDD \1\:VDD) resistor r=15 c=0
Rz17 (\5\:VDD \1\:VDD) resistor r=6.25 c=0
Rz18 (\8\:VDD \1\:VDD) resistor r=6.25 c=0
Rz21 (\17\:VSS \16\:VSS) resistor r=75 c=0
Rz22 (\19\:VSS \18\:VSS) resistor r=75 c=0
Rz23 (\21\:VSS \20\:VSS) resistor r=75 c=0
Rz24 (\23\:VSS \22\:VSS) resistor r=75 c=0
Rz25 (\25\:VSS \24\:VSS) resistor r=75 c=0
Rz7 (\29\:qbint \28\:qbint) resistor r=75 c=0
Rz3 (\12\:n30 \11\:n30) resistor r=75 c=0
Rz8 (\9\:CKb \10\:CKb) resistor r=75 c=0
Rz4 (\7\:mout \8\:mout) resistor r=75 c=0
Rz6 (\11\:Ckbb \12\:Ckbb) resistor r=75 c=0
Rz5 (\8\:n20 \9\:n20) resistor r=75 c=0
Rz9 (Dbp \2\:Dbp) resistor r=75 c=0
Rz10 (\7\:Dbp \8\:Dbp) resistor r=75 c=0
Rz12 (\6\:qint \7\:qint) resistor r=75 c=0
Rz13 (Db \2\:Db) resistor r=75 c=0
Rz14 (\9\:Db \10\:Db) resistor r=75 c=0
Rz11 (\6\:SEb \7\:SEb) resistor r=75 c=0
Rz15 (\5\:Eb \6\:Eb) resistor r=75 c=0
Ry18 (\17\:VDD \16\:VDD) resistor r=62 c=0
Ry19 (\19\:VDD \18\:VDD) resistor r=62 c=0
Ry20 (\21\:VDD \20\:VDD) resistor r=62 c=0
Ry21 (\23\:VDD \22\:VDD) resistor r=62 c=0
Ry22 (\25\:VDD \24\:VDD) resistor r=62 c=0
Ry29 (VSS \1\:VSS) resistor r=5.1667 c=0
Ry26 (\2\:VSS \1\:VSS) resistor r=12.4 c=0
Ry27 (\5\:VSS \1\:VSS) resistor r=5.1667 c=0
Ry28 (\8\:VSS \1\:VSS) resistor r=5.1667 c=0
Ry7 (\27\:qbint \26\:qbint) resistor r=31 c=0
Ry3 (\8\:n30 \7\:n30) resistor r=62 c=0
Ry8 (\13\:CKb \14\:CKb) resistor r=62 c=0
Ry4 (\9\:mout \10\:mout) resistor r=62 c=0
Ry6 (\9\:Ckbb \10\:Ckbb) resistor r=62 c=0
Ry5 (\4\:n20 \5\:n20) resistor r=31 c=0
Ry9 (\4\:Dbp \5\:Dbp) resistor r=62 c=0
Ry10 (\4\:Dbp \9\:Dbp) resistor r=62 c=0
Ry11 (\10\:Dbp \11\:Dbp) resistor r=62 c=0
Ry13 (\8\:qint \9\:qint) resistor r=62 c=0
Ry14 (\5\:Db \6\:Db) resistor r=62 c=0
Ry15 (\7\:Db \8\:Db) resistor r=31 c=0
Ry12 (\9\:SEb \10\:SEb) resistor r=62 c=0
Ry16 (\7\:Eb \8\:Eb) resistor r=62 c=0
Rx19 (\2\:D \4\:D) resistor r=45 c=0
Rx12 (\2\:CK \4\:CK) resistor r=45 c=0
Rx18 (\2\:SE \7\:SE) resistor r=45 c=0
Rx20 (\1\:E \8\:E) resistor r=45 c=0
Rx21 (\4\:E \9\:E) resistor r=45 c=0
Rx22 (\6\:E \10\:E) resistor r=45 c=0
Rx13 (\3\:SI \5\:SI) resistor r=45 c=0
Rx8 (\21\:qbint \19\:qbint) resistor r=45 c=0
Rx9 (\22\:qbint \16\:qbint) resistor r=45 c=0
Rx10 (\25\:qbint \8\:qbint) resistor r=45 c=0
Rx1 (\10\:n30 n30) resistor r=45 c=0
Rx11 (\2\:CKb \12\:CKb) resistor r=45 c=0
Rx2 (\3\:mout \5\:mout) resistor r=45 c=0
Rx4 (\2\:Ckbb \16\:Ckbb) resistor r=45 c=0
Rx5 (\8\:Ckbb \17\:Ckbb) resistor r=45 c=0
Rx6 (\6\:Ckbb \18\:Ckbb) resistor r=45 c=0
Rx7 (\4\:Ckbb \19\:Ckbb) resistor r=45 c=0
Rx3 (\2\:n20 \7\:n20) resistor r=45 c=0
Rx17 (\3\:qint \5\:qint) resistor r=45 c=0
Rx14 (\5\:SEb \8\:SEb) resistor r=45 c=0
Rx15 (SEb \12\:SEb) resistor r=45 c=0
Rx16 (\4\:SEb \13\:SEb) resistor r=45 c=0
Rx23 (\4\:Eb \9\:Eb) resistor r=45 c=0
mn56 (\6\:qint \20\:qbint \22\:VSS VSS) g45n1svt w=(2.6e-07) l=4.5e-08 \
        nf=1 as=4.345e-14 ad=3.64e-14 ps=9e-07 pd=8e-07 nrd=1.16667 \
        nrs=1.16667 sa=2.70288e-07 sb=1.4e-07 sd=160n sca=17.5885 \
        scb=0.0172826 scc=0.00162584 m=(1)
mn12 (net518 \1\:SI \20\:VSS VSS) g45n1svt w=(2.6e-07) l=4.5e-08 nf=1 \
        as=5.888e-14 ad=3.77e-14 ps=1.11e-06 pd=8.1e-07 nrd=1.16667 \
        nrs=1.16667 sa=3.35192e-07 sb=5.65e-07 sd=160n sca=13.5771 \
        scb=0.0135427 scc=0.000870653 m=(1)
mn13 (Dbp \4\:SE net518 VSS) g45n1svt w=(2.6e-07) l=4.5e-08 nf=1 \
        as=3.77e-14 ad=4.94e-14 ps=8.1e-07 pd=9e-07 nrd=1.16667 \
        nrs=1.16667 sa=5.25192e-07 sb=3.75e-07 sd=160n sca=13.5771 \
        scb=0.0135427 scc=0.000870653 m=(1)
mn11 (\9\:Db \3\:SEb Dbp VSS) g45n1svt w=(2.6e-07) l=4.5e-08 nf=1 \
        as=4.94e-14 ad=3.64e-14 ps=9e-07 pd=8e-07 nrd=1.16667 nrs=1.16667 \
        sa=7.60192e-07 sb=1.4e-07 sd=160n sca=13.5771 scb=0.0135427 \
        scc=0.000870653 m=(1)
mn1 (net494 \4\:qint \18\:VSS VSS) g45n1svt w=(2.6e-07) l=4.5e-08 nf=1 \
        as=7.852e-14 ad=6.24e-14 ps=1.27e-06 pd=1e-06 nrd=1.16667 \
        nrs=1.16667 sa=4.05192e-07 sb=1.00173e-06 sd=160n sca=10.79 \
        scb=0.0100512 scc=0.000418069 m=(1)
mn2 (Db \3\:Eb net494 VSS) g45n1svt w=(2.6e-07) l=4.5e-08 nf=1 \
        as=6.24e-14 ad=4.16e-14 ps=1e-06 pd=8.4e-07 nrd=1.16667 \
        nrs=1.16667 sa=6.90192e-07 sb=7.16731e-07 sd=160n sca=10.79 \
        scb=0.0100512 scc=0.000418069 m=(1)
mn4 (Db \3\:E net526 VSS) g45n1svt w=(2.6e-07) l=4.5e-08 nf=1 as=1.56e-14 \
        ad=4.16e-14 ps=6.4e-07 pd=8.4e-07 nrd=1.16667 nrs=1.16667 \
        sa=8.95192e-07 sb=5.11731e-07 sd=160n sca=10.79 scb=0.0100512 \
        scc=0.000418069 m=(1)
mn3 (net526 \3\:D \16\:VSS VSS) g45n1svt w=(2.6e-07) l=4.5e-08 nf=1 \
        as=7.457e-14 ad=1.56e-14 ps=1.39e-06 pd=6.4e-07 nrd=1.16667 \
        nrs=1.16667 sa=1.00019e-06 sb=4.06731e-07 sd=160n sca=10.79 \
        scb=0.0100512 scc=0.000418069 m=(1)
mn55_1__rcx (Q qbint VSS VSS) g45n1svt w=(2.6e-07) l=4.5e-08 nf=1 \
        as=4.152e-14 ad=4.16e-14 ps=8.5e-07 pd=8.4e-07 nrd=1.16667 \
        nrs=1.16667 sa=1.4e-07 sb=1.72817e-06 sd=160n sca=17.5885 \
        scb=0.0172826 scc=0.00162584 m=(4)
mn50 (net509 \17\:qbint VSS VSS) g45n1svt w=(2.05e-07) l=4.5e-08 nf=1 \
        as=4.51e-14 ad=4.92e-14 ps=8.5e-07 pd=8.9e-07 nrd=1.16667 \
        nrs=1.16667 sa=1.47e-06 sb=1.945e-06 sd=160n sca=13.8179 \
        scb=0.0141903 scc=0.000851218 m=(1)
mn51 (\11\:n30 \6\:CKb net509 VSS) g45n1svt w=(2.05e-07) l=4.5e-08 nf=1 \
        as=4.92e-14 ad=5.842e-14 ps=8.9e-07 pd=9.8e-07 nrd=1.16667 \
        nrs=1.16667 sa=1.755e-06 sb=1.66e-06 sd=160n sca=13.8179 \
        scb=0.0141903 scc=0.000851218 m=(1)
mn40 (\11\:n30 \3\:Ckbb \7\:mout VSS) g45n1svt w=(2.05e-07) l=4.5e-08 \
        nf=1 as=5.74e-14 ad=5.842e-14 ps=9.7e-07 pd=9.8e-07 nrd=1.16667 \
        nrs=1.16667 sa=2e-06 sb=1.33e-06 sd=160n sca=13.8179 scb=0.0141903 \
        scc=0.000851218 m=(1)
mn30 (\7\:mout \3\:n20 \24\:VSS VSS) g45n1svt w=(2.05e-07) l=4.5e-08 \
        nf=1 as=5.432e-14 ad=5.74e-14 ps=9.4e-07 pd=9.7e-07 nrd=1.16667 \
        nrs=1.16667 sa=2e-06 sb=1.005e-06 sd=160n sca=13.8179 \
        scb=0.0141903 scc=0.000851218 m=(1)
mn35 (net501 \4\:mout \24\:VSS VSS) g45n1svt w=(2.05e-07) l=4.5e-08 nf=1 \
        as=5.432e-14 ad=1.23e-14 ps=9.4e-07 pd=5.3e-07 nrd=1.16667 \
        nrs=1.16667 sa=2e-06 sb=6.95e-07 sd=160n sca=13.8179 scb=0.0141903 \
        scc=0.000851218 m=(1)
mn36 (\8\:n20 \5\:Ckbb net501 VSS) g45n1svt w=(2.05e-07) l=4.5e-08 nf=1 \
        as=1.23e-14 ad=4.715e-14 ps=5.3e-07 pd=8.7e-07 nrd=1.16667 \
        nrs=1.16667 sa=2e-06 sb=5.9e-07 sd=160n sca=13.8179 scb=0.0141903 \
        scc=0.000851218 m=(1)
mn25 (\8\:n20 \8\:CKb \7\:Dbp VSS) g45n1svt w=(2.05e-07) l=4.5e-08 nf=1 \
        as=6.458e-14 ad=4.715e-14 ps=1.04e-06 pd=8.7e-07 nrd=1.16667 \
        nrs=1.16667 sa=2e-06 sb=3.15e-07 sd=160n sca=13.8179 scb=0.0141903 \
        scc=0.000851218 m=(1)
mn45_1__rcx (\28\:qbint n30 VSS VSS) g45n1svt w=(2.05e-07) l=4.5e-08 \
        nf=1 as=4.58e-14 ad=3.28e-14 ps=8.85e-07 pd=7.3e-07 nrd=1.16667 \
        nrs=1.16667 sa=1e-06 sb=2e-06 sd=160n sca=13.8179 scb=0.0141903 \
        scc=0.000851218 m=(2)
mn21 (\11\:Ckbb CKb \22\:VSS VSS) g45n1svt w=(1.45e-07) l=4.5e-08 nf=1 \
        as=4.345e-14 ad=2.03e-14 ps=9e-07 pd=5.7e-07 nrd=1.16667 \
        nrs=1.16667 sa=1.4e-07 sb=3.75e-07 sd=160n sca=22.3376 \
        scb=0.0224607 scc=0.00248252 m=(1)
mn20 (\9\:CKb \3\:CK \20\:VSS VSS) g45n1svt w=(1.45e-07) l=4.5e-08 nf=1 \
        as=5.888e-14 ad=2.175e-14 ps=1.11e-06 pd=5.9e-07 nrd=1.16667 \
        nrs=1.16667 sa=1.5e-07 sb=9.05e-07 sd=160n sca=17.28 scb=0.0183577 \
        scc=0.00144167 m=(1)
mn10 (\6\:SEb \5\:SE \18\:VSS VSS) g45n1svt w=(1.45e-07) l=4.5e-08 nf=1 \
        as=7.852e-14 ad=2.03e-14 ps=1.27e-06 pd=5.7e-07 nrd=1.16667 \
        nrs=1.16667 sa=1.4e-07 sb=1.57017e-06 sd=160n sca=13.253 \
        scb=0.0137915 scc=0.000695334 m=(1)
mn0 (\5\:Eb \5\:E \16\:VSS VSS) g45n1svt w=(1.45e-07) l=4.5e-08 nf=1 \
        as=7.457e-14 ad=2.465e-14 ps=1.39e-06 pd=6.3e-07 nrd=1.16667 \
        nrs=1.16667 sa=1.57466e-06 sb=1.7e-07 sd=160n sca=11.7118 \
        scb=0.0116498 scc=0.000458536 m=(1)
mp50 (net426 \14\:qbint VDD VDD) g45p1svt w=(3.1e-07) l=4.5e-08 nf=1 \
        as=7.84e-14 ad=3.565e-14 ps=1.23e-06 pd=8.5e-07 nrd=1.16667 \
        nrs=1.16667 sa=1.47e-06 sb=1.82e-06 sd=160n sca=13.1273 \
        scb=0.0119313 scc=0.000538101 m=(1)
mp51 (\7\:n30 Ckbb net426 VDD) g45p1svt w=(3.1e-07) l=4.5e-08 nf=1 \
        as=3.565e-14 ad=7.905e-14 ps=8.5e-07 pd=1.13e-06 nrd=1.16667 \
        nrs=1.16667 sa=1.63e-06 sb=1.66e-06 sd=160n sca=13.1273 \
        scb=0.0119313 scc=0.000538101 m=(1)
mp40 (\7\:n30 \5\:CKb \9\:mout VDD) g45p1svt w=(3.1e-07) l=4.5e-08 nf=1 \
        as=1.3485e-13 ad=7.905e-14 ps=1.49e-06 pd=1.13e-06 nrd=1.16667 \
        nrs=1.16667 sa=1.93e-06 sb=1.36e-06 sd=160n sca=13.1273 \
        scb=0.0119313 scc=0.000538101 m=(1)
mp30 (\9\:mout n20 \24\:VDD VDD) g45p1svt w=(3.1e-07) l=4.5e-08 nf=1 \
        as=8.215e-14 ad=1.3485e-13 ps=1.15e-06 pd=1.49e-06 nrd=1.16667 \
        nrs=1.16667 sa=2e-06 sb=8.8e-07 sd=160n sca=13.1273 scb=0.0119313 \
        scc=0.000538101 m=(1)
mp35 (net417 mout \24\:VDD VDD) g45p1svt w=(3.1e-07) l=4.5e-08 nf=1 \
        as=8.215e-14 ad=4.96e-14 ps=1.15e-06 pd=9.4e-07 nrd=1.16667 \
        nrs=1.16667 sa=2e-06 sb=5.7e-07 sd=160n sca=13.1273 scb=0.0119313 \
        scc=0.000538101 m=(1)
mp36 (\4\:n20 \4\:CKb net417 VDD) g45p1svt w=(3.1e-07) l=4.5e-08 nf=1 \
        as=4.96e-14 ad=5.58e-14 ps=9.4e-07 pd=9.8e-07 nrd=1.16667 \
        nrs=1.16667 sa=2e-06 sb=3.65e-07 sd=160n sca=13.1273 scb=0.0119313 \
        scc=0.000538101 m=(1)
mp25 (\4\:n20 \7\:Ckbb \10\:Dbp VDD) g45p1svt w=(3.1e-07) l=4.5e-08 nf=1 \
        as=4.34e-14 ad=5.58e-14 ps=9e-07 pd=9.8e-07 nrd=1.16667 \
        nrs=1.16667 sa=2e-06 sb=1.4e-07 sd=160n sca=13.1273 scb=0.0119313 \
        scc=0.000538101 m=(1)
mp45 (\26\:qbint n30 VDD VDD) g45p1svt w=(3.1e-07) l=4.5e-08 nf=1 \
        as=7.42e-14 ad=4.96e-14 ps=1.205e-06 pd=9.4e-07 nrd=1.16667 \
        nrs=1.16667 sa=1e-06 sb=2e-06 sd=160n sca=13.1273 scb=0.0119313 \
        scc=0.000538101 m=(2)
mp21 (\9\:Ckbb \7\:CKb \22\:VDD VDD) g45p1svt w=(2.15e-07) l=4.5e-08 \
        nf=1 as=9.28e-14 ad=4.3e-14 ps=1.37e-06 pd=8.3e-07 nrd=1.16667 \
        nrs=1.16667 sa=2e-07 sb=6.8e-07 sd=160n sca=45.7906 scb=0.0283307 \
        scc=0.00588417 m=(1)
mp20 (\13\:CKb \1\:CK \20\:VDD VDD) g45p1svt w=(2.15e-07) l=4.5e-08 nf=1 \
        as=1.0105e-13 ad=3.01e-14 ps=1.62e-06 pd=7.1e-07 nrd=1.16667 \
        nrs=1.16667 sa=1.4e-07 sb=8.3e-07 sd=160n sca=14.5646 \
        scb=0.0142004 scc=0.000753562 m=(1)
mp10 (\9\:SEb \1\:SE \18\:VDD VDD) g45p1svt w=(2.15e-07) l=4.5e-08 nf=1 \
        as=5.995e-14 ad=3.01e-14 ps=1.16e-06 pd=7.1e-07 nrd=1.16667 \
        nrs=1.16667 sa=1.4e-07 sb=1.12814e-06 sd=160n sca=11.6359 \
        scb=0.0100097 scc=0.00025962 m=(1)
mp0 (\7\:Eb \7\:E \16\:VDD VDD) g45p1svt w=(2.15e-07) l=4.5e-08 nf=1 \
        as=1.062e-13 ad=3.01e-14 ps=1.54e-06 pd=7.1e-07 nrd=1.16667 \
        nrs=1.16667 sa=1.22233e-06 sb=1.4e-07 sd=160n sca=29.3406 \
        scb=0.0316245 scc=0.00259206 m=(1)
ends SEDFFHQX4
// End of subcircuit definition.
