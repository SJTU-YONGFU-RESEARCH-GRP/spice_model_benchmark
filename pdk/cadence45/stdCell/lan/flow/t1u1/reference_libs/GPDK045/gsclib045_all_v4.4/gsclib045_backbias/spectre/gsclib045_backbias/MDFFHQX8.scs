// gsclib045_backbias/MDFFHQX8/schematic

simulator lang=spectre

subckt MDFFHQX8 CK D0 D1 Q S0 NW VSS VDD
mn13 (n12 D1 VSS VSS) g45n1svt w=(260n) l=45n nf=1 m=(1)
mn14 (D0b S0 n12 VSS) g45n1svt w=(260n) l=45n nf=1 m=(1)
mn12 (D0b S0b n10 VSS) g45n1svt w=(260n) l=45n nf=1 m=(1)
mn11 (n10 D0 VSS VSS) g45n1svt w=(260n) l=45n nf=1 m=(1)
mn55 (Q qbint VSS VSS) g45n1svt w=(2.065u) l=45n nf=1 m=(1)
mn50 (n35 qbint VSS VSS) g45n1svt w=(205n) l=45n nf=1 m=(1)
mn51 (n30 CKb n35 VSS) g45n1svt w=(205n) l=45n nf=1 m=(1)
mn10 (S0b S0 VSS VSS) g45n1svt w=(145n) l=45n nf=1 m=(1)
mn40 (mout CKbb n30 VSS) g45n1svt w=(205n) l=45n nf=1 m=(1)
mn35 (n25 mout VSS VSS) g45n1svt w=(205n) l=45n nf=1 m=(1)
mn36 (n20 CKbb n25 VSS) g45n1svt w=(205n) l=45n nf=1 m=(1)
mn21 (CKbb CKb VSS VSS) g45n1svt w=(145n) l=45n nf=1 m=(1)
mn45 (qbint n30 VSS VSS) g45n1svt w=(780n) l=45n nf=1 m=(1)
mn25 (D0b CKb n20 VSS) g45n1svt w=(205n) l=45n nf=1 m=(1)
mn30 (mout n20 VSS VSS) g45n1svt w=(205n) l=45n nf=1 m=(1)
mn20 (CKb CK VSS VSS) g45n1svt w=(145n) l=45n nf=1 m=(1)
mp14 (D0b S0b n13 NW) g45p1svt w=(390n) l=45n nf=1 m=(1)
mp13 (n13 D1 VDD NW) g45p1svt w=(390n) l=45n nf=1 m=(1)
mp12 (D0b S0 n11 NW) g45p1svt w=(390n) l=45n nf=1 m=(1)
mp11 (n11 D0 VDD NW) g45p1svt w=(390n) l=45n nf=1 m=(1)
mp51 (n30 CKbb n36 NW) g45p1svt w=(310n) l=45n nf=1 m=(1)
mp50 (n36 qbint VDD NW) g45p1svt w=(310n) l=45n nf=1 m=(1)
mp55 (Q qbint VDD NW) g45p1svt w=(3.115u) l=45n nf=1 m=(1)
mp35 (n26 mout VDD NW) g45p1svt w=(310n) l=45n nf=1 m=(1)
mp36 (n20 CKb n26 NW) g45p1svt w=(310n) l=45n nf=1 m=(1)
mp25 (n20 CKbb D0b NW) g45p1svt w=(310n) l=45n nf=1 m=(1)
mp21 (CKbb CKb VDD NW) g45p1svt w=(215n) l=45n nf=1 m=(1)
mp30 (mout n20 VDD NW) g45p1svt w=(310n) l=45n nf=1 m=(1)
mp40 (n30 CKb mout NW) g45p1svt w=(310n) l=45n nf=1 m=(1)
mp10 (S0b S0 VDD NW) g45p1svt w=(215n) l=45n nf=1 m=(1)
mp45 (qbint n30 VDD NW) g45p1svt w=(1.17u) l=45n nf=1 m=(1)
mp20 (CKb CK VDD NW) g45p1svt w=(215n) l=45n nf=1 m=(1)
ends MDFFHQX8
