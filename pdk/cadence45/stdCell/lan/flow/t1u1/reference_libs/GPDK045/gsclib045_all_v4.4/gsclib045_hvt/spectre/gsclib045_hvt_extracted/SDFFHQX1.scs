// Generated for: spectre (May  1 09:15:23 2013 )
// Library name: gsclib045_hvt
// Cell name: SDFFHQX1
// View name: extracted

simulator lang=spectre

subckt SDFFHQX1 CK D Q SE SI VDD VSS
mp55 (\1\:Q \4\:qbint \17\:VDD VDD) g45p1hvt w=(3.9e-07) l=4.5e-08 nf=1 \
        as=5.19e-14 ad=5.46e-14 ps=1.1e-06 pd=1.06e-06 nrd=1.16667 \
        nrs=1.16667 sa=1.4e-07 sb=2.98462e-07 sd=160n sca=19.586 \
        scb=0.0215989 scc=0.000684683 m=(1)
mp11 (net342 \1\:D \7\:VDD VDD) g45p1hvt w=(3.9e-07) l=4.5e-08 nf=1 \
        as=6.535e-14 ad=3.12e-14 ps=1.16e-06 pd=9.4e-07 nrd=1.16667 \
        nrs=1.16667 sa=2.69551e-07 sb=9.43462e-07 sd=160n sca=12.3656 \
        scb=0.0108222 scc=0.000412413 m=(1)
mp12 (\7\:Db \2\:SE net342 VDD) g45p1hvt w=(3.9e-07) l=4.5e-08 nf=1 \
        as=3.12e-14 ad=7.02e-14 ps=9.4e-07 pd=1.14e-06 nrd=1.16667 \
        nrs=1.16667 sa=3.94551e-07 sb=8.18462e-07 sd=160n sca=12.3656 \
        scb=0.0108222 scc=0.000412413 m=(1)
mp14 (\7\:Db SEb net350 VDD) g45p1hvt w=(3.9e-07) l=4.5e-08 nf=1 \
        as=8.19e-14 ad=7.02e-14 ps=1.2e-06 pd=1.14e-06 nrd=1.16667 \
        nrs=1.16667 sa=6.19551e-07 sb=5.93462e-07 sd=160n sca=12.4887 \
        scb=0.0108489 scc=0.000412416 m=(1)
mp13 (net350 \3\:SI \5\:VDD VDD) g45p1hvt w=(3.9e-07) l=4.5e-08 nf=1 \
        as=9.223e-14 ad=8.19e-14 ps=1.41e-06 pd=1.2e-06 nrd=1.16667 \
        nrs=1.16667 sa=8.74551e-07 sb=3.38462e-07 sd=160n sca=13.4085 \
        scb=0.011387 scc=0.000412933 m=(1)
C1 (D VSS) capacitor c=4.3507e-17
C2 (Q VSS) capacitor c=1.52712e-17
C3 (VDD VSS) capacitor c=2.89827e-16
C4 (CK VSS) capacitor c=1.09244e-16
C5 (SE VSS) capacitor c=4.40103e-17
C6 (SI VSS) capacitor c=6.07727e-17
C7 (qbint VSS) capacitor c=1.79908e-17
C8 (CKb VSS) capacitor c=2.17351e-17
C9 (n30 VSS) capacitor c=3.43217e-17
C10 (net391 VSS) capacitor c=5.82309e-18
C11 (mout VSS) capacitor c=5.64258e-17
C12 (CKbb VSS) capacitor c=3.44304e-17
C13 (n20 VSS) capacitor c=3.73077e-17
C14 (net378 VSS) capacitor c=9.11373e-19
C15 (Db VSS) capacitor c=9.0433e-17
C16 (net399 VSS) capacitor c=8.55872e-18
C17 (SEb VSS) capacitor c=3.83858e-17
C18 (net334 VSS) capacitor c=6.50403e-18
C19 (net319 VSS) capacitor c=5.33809e-18
C20 (net342 VSS) capacitor c=2.75167e-18
C21 (net350 VSS) capacitor c=6.08103e-18
C22 (\7\:SE VSS) capacitor c=4.05118e-17
C23 (\3\:SI VSS) capacitor c=4.86977e-17
C24 (\2\:SE VSS) capacitor c=6.66823e-17
C25 (\1\:D VSS) capacitor c=9.03799e-17
C26 (\5\:CKb VSS) capacitor c=4.65943e-17
C27 (\7\:CKbb VSS) capacitor c=3.9191e-17
C28 (\8\:CKb VSS) capacitor c=4.26069e-17
C29 (\5\:qbint VSS) capacitor c=4.7028e-17
C30 (\3\:n30 VSS) capacitor c=4.04187e-17
C31 (\3\:CK VSS) capacitor c=4.81678e-17
C32 (\4\:qbint VSS) capacitor c=6.42521e-17
C33 (\5\:SE VSS) capacitor c=2.54409e-17
C34 (\1\:SI VSS) capacitor c=7.53961e-17
C35 (\3\:SE VSS) capacitor c=7.0182e-17
C36 (\3\:SEb VSS) capacitor c=6.05378e-17
C37 (\4\:D VSS) capacitor c=3.88157e-17
C38 (\10\:CKb VSS) capacitor c=3.34568e-17
C39 (\11\:CKb VSS) capacitor c=2.51137e-17
C40 (\5\:CKbb VSS) capacitor c=5.91905e-17
C41 (\4\:mout VSS) capacitor c=6.61451e-17
C42 (\3\:n20 VSS) capacitor c=3.92417e-17
C43 (\3\:CKbb VSS) capacitor c=3.10207e-17
C44 (\3\:CKb VSS) capacitor c=6.78524e-17
C45 (\8\:qbint VSS) capacitor c=3.72698e-17
C46 (\1\:CK VSS) capacitor c=5.02182e-17
C47 (\3\:qbint VSS) capacitor c=3.01153e-17
C48 (\6\:SE VSS) capacitor c=3.05036e-17
C49 (\2\:SI VSS) capacitor c=4.74764e-17
C50 (\4\:SE VSS) capacitor c=4.42107e-17
C51 (\2\:SEb VSS) capacitor c=5.49748e-17
C52 (\1\:SE VSS) capacitor c=5.21226e-17
C53 (\3\:D VSS) capacitor c=2.67226e-17
C54 (\8\:CKbb VSS) capacitor c=4.13885e-17
C55 (\9\:CKb VSS) capacitor c=2.79099e-17
C56 (\6\:CKbb VSS) capacitor c=4.03023e-17
C57 (\3\:mout VSS) capacitor c=2.54298e-17
C58 (\2\:n20 VSS) capacitor c=4.334e-17
C59 (\4\:CKb VSS) capacitor c=1.61597e-17
C60 (\4\:CKbb VSS) capacitor c=4.17501e-17
C61 (\2\:CKbb VSS) capacitor c=4.14319e-17
C62 (\7\:qbint VSS) capacitor c=2.4774e-17
C63 (\2\:n30 VSS) capacitor c=4.25727e-17
C64 (\2\:CK VSS) capacitor c=4.60188e-17
C65 (\6\:SEb VSS) capacitor c=1.03387e-16
C66 (\5\:VDD VSS) capacitor c=3.14574e-17
C67 (\7\:Db VSS) capacitor c=6.77514e-17
C68 (\7\:VDD VSS) capacitor c=5.22805e-17
C69 (\9\:CKbb VSS) capacitor c=1.02209e-16
C70 (\5\:Db VSS) capacitor c=1.0499e-16
C71 (\4\:n20 VSS) capacitor c=3.43118e-17
C72 (\10\:VDD VSS) capacitor c=3.474e-17
C73 (\9\:mout VSS) capacitor c=7.42701e-17
C74 (\8\:n30 VSS) capacitor c=5.21829e-17
C75 (\14\:VDD VSS) capacitor c=4.18852e-17
C76 (\14\:qbint VSS) capacitor c=7.12629e-17
C77 (\18\:CKb VSS) capacitor c=2.53667e-17
C78 (\17\:VDD VSS) capacitor c=2.56049e-17
C79 (\1\:Q VSS) capacitor c=5.46859e-17
C80 (\1\:VDD VSS) capacitor c=8.09952e-17
C81 (\4\:SEb VSS) capacitor c=5.50045e-17
C82 (\15\:CKbb VSS) capacitor c=4.24774e-17
C83 (\9\:Db VSS) capacitor c=6.88754e-17
C84 (\8\:n20 VSS) capacitor c=8.33314e-17
C85 (\7\:mout VSS) capacitor c=5.47566e-17
C86 (\4\:n30 VSS) capacitor c=7.27477e-17
C87 (\11\:qbint VSS) capacitor c=8.14101e-17
C88 (\15\:CKb VSS) capacitor c=9.31232e-17
C89 (\3\:Q VSS) capacitor c=5.61288e-17
C90 (\2\:qbint VSS) capacitor c=2.18605e-17
C91 (\6\:qbint VSS) capacitor c=2.38217e-17
C92 (\2\:CKb VSS) capacitor c=4.43845e-17
C93 (\2\:mout VSS) capacitor c=2.93226e-17
C94 (\6\:CKb VSS) capacitor c=5.8753e-17
C95 (\7\:CKb VSS) capacitor c=6.89886e-17
C96 (\2\:D VSS) capacitor c=2.85326e-17
C97 (\9\:qbint VSS) capacitor c=7.10184e-17
C98 (\10\:qbint VSS) capacitor c=6.63644e-17
C99 (\13\:qbint VSS) capacitor c=1.05921e-16
C100 (\6\:n30 VSS) capacitor c=1.03561e-16
C101 (\7\:n30 VSS) capacitor c=7.07379e-17
C102 (\5\:mout VSS) capacitor c=6.45752e-17
C103 (\6\:mout VSS) capacitor c=5.97447e-17
C104 (\12\:CKb VSS) capacitor c=5.74216e-17
C105 (\13\:CKb VSS) capacitor c=1.49149e-16
C106 (\14\:CKb VSS) capacitor c=1.66308e-16
C107 (\17\:CKb VSS) capacitor c=8.14976e-17
C108 (\6\:n20 VSS) capacitor c=7.96164e-17
C109 (\7\:n20 VSS) capacitor c=8.51778e-17
C110 (\11\:CKbb VSS) capacitor c=1.16902e-16
C111 (\12\:CKbb VSS) capacitor c=7.68595e-17
C112 (\13\:CKbb VSS) capacitor c=1.01213e-16
C113 (\14\:CKbb VSS) capacitor c=1.33197e-16
C114 (\17\:CKbb VSS) capacitor c=6.1439e-17
C115 (\18\:CKbb VSS) capacitor c=5.30683e-17
C116 (\5\:D VSS) capacitor c=6.15795e-17
C117 (\3\:Db VSS) capacitor c=1.29956e-16
C118 (\4\:SI VSS) capacitor c=7.60448e-17
C119 (\8\:SE VSS) capacitor c=7.43302e-17
C120 (\9\:SE VSS) capacitor c=7.40405e-17
C121 (\10\:SE VSS) capacitor c=2.61063e-17
C122 (\8\:SEb VSS) capacitor c=9.68955e-17
C123 (\3\:VDD VSS) capacitor c=2.03154e-17
C124 (\9\:VDD VSS) capacitor c=4.8161e-17
C125 (\13\:VDD VSS) capacitor c=1.24761e-17
C126 (\16\:VDD VSS) capacitor c=2.07533e-17
Rk29 (\5\:D D) resistor r=0.08856 c=0
Rk2 (\4\:Q Q) resistor r=0.02908 c=0
Rk1 (\2\:Q \4\:Q) resistor r=0.4952 c=0
Rk41 (\2\:VSS \3\:VSS) resistor r=0.1954 c=0
Rk42 (\3\:VSS \4\:VSS) resistor r=0.4568 c=0
Rk43 (\3\:VSS \6\:VSS) resistor r=0.2907 c=0
Rk44 (\4\:VSS \7\:VSS) resistor r=0.6041 c=0
Rk45 (\7\:VSS \8\:VSS) resistor r=0.5991 c=0
Rk47 (\9\:VSS VSS) resistor r=0.1375 c=0
Rk46 (\8\:VSS \9\:VSS) resistor r=0.4139 c=0
Rk48 (\4\:VSS \11\:VSS) resistor r=0.2657 c=0
Rk49 (\7\:VSS \13\:VSS) resistor r=0.1225 c=0
Rk50 (\8\:VSS \15\:VSS) resistor r=0.3173 c=0
Rk51 (\9\:VSS \17\:VSS) resistor r=0.2933 c=0
Rk52 (\2\:VDD \3\:VDD) resistor r=0.223 c=0
Rk53 (\3\:VDD \4\:VDD) resistor r=0.4292 c=0
Rk54 (\3\:VDD \6\:VDD) resistor r=0.2039 c=0
Rk55 (\4\:VDD \8\:VDD) resistor r=0.2986 c=0
Rk56 (\4\:VDD \9\:VDD) resistor r=0.6041 c=0
Rk57 (\9\:VDD \11\:VDD) resistor r=0.1859 c=0
Rk58 (\9\:VDD \12\:VDD) resistor r=0.5991 c=0
Rk59 (\12\:VDD \13\:VDD) resistor r=0.02989 c=0
Rk60 (\13\:VDD \15\:VDD) resistor r=0.236 c=0
Rk63 (\16\:VDD VDD) resistor r=0.1375 c=0
Rk61 (\13\:VDD \16\:VDD) resistor r=0.3832 c=0
Rk62 (\16\:VDD \18\:VDD) resistor r=0.1817 c=0
Rk37 (\9\:SE SE) resistor r=0.3377 c=0
Rk36 (\8\:SE \9\:SE) resistor r=0.3554 c=0
Rk38 (SE \10\:SE) resistor r=0.02105 c=0
Rk35 (\4\:SI SI) resistor r=0.03273 c=0
Rk4 (\9\:qbint \10\:qbint) resistor r=0.3153 c=0
Rk5 (\10\:qbint \12\:qbint) resistor r=0.06062 c=0
Rk6 (\12\:qbint \13\:qbint) resistor r=0.6904 c=0
Rk7 (\10\:qbint \15\:qbint) resistor r=0.3182 c=0
Rk14 (\12\:CKb \13\:CKb) resistor r=0.2788 c=0
Rk15 (\13\:CKb \14\:CKb) resistor r=0.9711 c=0
Rk16 (\14\:CKb \16\:CKb) resistor r=0.4234 c=0
Rk17 (\13\:CKb \17\:CKb) resistor r=0.5459 c=0
Rk18 (\14\:CKb \19\:CKb) resistor r=0.1224 c=0
Rk8 (\5\:n30 \6\:n30) resistor r=0.4975 c=0
Rk9 (\6\:n30 \7\:n30) resistor r=0.3813 c=0
Rk10 (\6\:n30 \9\:n30) resistor r=0.1685 c=0
Rk11 (\5\:mout \6\:mout) resistor r=0.3192 c=0
Rk12 (\6\:mout \8\:mout) resistor r=0.145 c=0
Rk13 (\6\:mout \10\:mout) resistor r=0.3096 c=0
Rk22 (\10\:CKbb \11\:CKbb) resistor r=0.6368 c=0
Rk23 (\11\:CKbb \12\:CKbb) resistor r=0.3322 c=0
Rk24 (\12\:CKbb \13\:CKbb) resistor r=0.3239 c=0
Rk25 (\13\:CKbb \14\:CKbb) resistor r=0.5248 c=0
Rk26 (\12\:CKbb \16\:CKbb) resistor r=0.2753 c=0
Rk27 (\13\:CKbb \17\:CKbb) resistor r=0.235 c=0
Rk28 (\14\:CKbb \18\:CKbb) resistor r=0.2608 c=0
Rk19 (\5\:n20 \6\:n20) resistor r=0.08271 c=0
Rk20 (\6\:n20 \7\:n20) resistor r=0.4677 c=0
Rk21 (\6\:n20 \9\:n20) resistor r=0.3854 c=0
Rk30 (\2\:Db \3\:Db) resistor r=0.6465 c=0
Rk31 (\3\:Db \4\:Db) resistor r=0.417 c=0
Rk32 (\4\:Db \6\:Db) resistor r=0.04616 c=0
Rk33 (\3\:Db \8\:Db) resistor r=0.2642 c=0
Rk34 (\4\:Db \10\:Db) resistor r=0.3646 c=0
Rk39 (\5\:SEb \7\:SEb) resistor r=0.5139 c=0
Rk40 (\7\:SEb \8\:SEb) resistor r=0.6394 c=0
Rl29 (\1\:D \2\:D) resistor r=123.88 c=0
Rl31 (\2\:D \4\:D) resistor r=54.6488 c=0
Rl30 (\2\:D \3\:D) resistor r=6.9867 c=0
Rl5 (\2\:CK \3\:CK) resistor r=96.3431 c=0
Rl4 (\1\:CK \2\:CK) resistor r=109.615 c=0
Rl39 (\6\:SE \7\:SE) resistor r=126.099 c=0
Rl38 (\5\:SE \6\:SE) resistor r=40.3846 c=0
Rl35 (\3\:SE \4\:SE) resistor r=48.6653 c=0
Rl32 (\1\:SE \2\:SE) resistor r=55.6561 c=0
Rl37 (\2\:SI \3\:SI) resistor r=64.5604 c=0
Rl36 (\1\:SI \2\:SI) resistor r=100 c=0
Rl3 (\2\:qbint \4\:qbint) resistor r=120.868 c=0
Rl2 (\2\:qbint \3\:qbint) resistor r=34.3295 c=0
Rl1 (qbint \2\:qbint) resistor r=1.2713 c=0
Rl8 (\5\:qbint \6\:qbint) resistor r=42.0218 c=0
Rl10 (\6\:qbint \8\:qbint) resistor r=84.3295 c=0
Rl9 (\6\:qbint \7\:qbint) resistor r=2.7666 c=0
Rl26 (\8\:CKb \9\:CKb) resistor r=24.2328 c=0
Rl13 (CKb \2\:CKb) resistor r=38.143 c=0
Rl14 (\2\:CKb \3\:CKb) resistor r=174.543 c=0
Rl15 (\2\:CKb \4\:CKb) resistor r=36.87 c=0
Rl23 (\5\:CKb \6\:CKb) resistor r=139.618 c=0
Rl27 (\6\:CKb \10\:CKb) resistor r=89.6181 c=0
Rl25 (\7\:CKb \8\:CKb) resistor r=134.159 c=0
Rl28 (\7\:CKb \11\:CKb) resistor r=32.3738 c=0
Rl24 (\6\:CKb \7\:CKb) resistor r=214.3 c=0
Rl7 (\2\:n30 \3\:n30) resistor r=31.8681 c=0
Rl6 (n30 \2\:n30) resistor r=78.8462 c=0
Rl18 (mout \2\:mout) resistor r=48.8796 c=0
Rl20 (\2\:mout \4\:mout) resistor r=75.8027 c=0
Rl19 (\2\:mout \3\:mout) resistor r=3.7301 c=0
Rl22 (\7\:CKbb \8\:CKbb) resistor r=30.0021 c=0
Rl21 (\5\:CKbb \6\:CKbb) resistor r=24.2328 c=0
Rl12 (\3\:CKbb \4\:CKbb) resistor r=24.2328 c=0
Rl11 (CKbb \2\:CKbb) resistor r=30.0021 c=0
Rl16 (n20 \2\:n20) resistor r=29.5379 c=0
Rl17 (\2\:n20 \3\:n20) resistor r=79.5379 c=0
Rl33 (SEb \2\:SEb) resistor r=24.2328 c=0
Rl34 (\2\:SEb \3\:SEb) resistor r=135.771 c=0
Rz1 (\3\:Q \4\:Q) resistor r=75 c=0
Rz11 (\5\:VSS \6\:VSS) resistor r=75 c=0
Rz12 (\10\:VSS \11\:VSS) resistor r=75 c=0
Rz13 (\12\:VSS \13\:VSS) resistor r=75 c=0
Rz14 (\14\:VSS \15\:VSS) resistor r=75 c=0
Rz15 (\16\:VSS \17\:VSS) resistor r=75 c=0
Rz16 (\1\:VDD \2\:VDD) resistor r=75 c=0
Rz17 (\1\:VDD \4\:VDD) resistor r=6.25 c=0
Rz18 (\1\:VDD \12\:VDD) resistor r=6.25 c=0
Rz2 (\11\:qbint \12\:qbint) resistor r=75 c=0
Rz5 (\15\:CKb \16\:CKb) resistor r=75 c=0
Rz3 (\4\:n30 \5\:n30) resistor r=75 c=0
Rz4 (\7\:mout \8\:mout) resistor r=75 c=0
Rz7 (\15\:CKbb \16\:CKbb) resistor r=75 c=0
Rz6 (\8\:n20 \9\:n20) resistor r=75 c=0
Rz8 (Db \2\:Db) resistor r=75 c=0
Rz9 (\9\:Db \10\:Db) resistor r=75 c=0
Rz10 (\4\:SEb \5\:SEb) resistor r=75 c=0
Ry1 (\1\:Q \2\:Q) resistor r=20.6667 c=0
Ry11 (\1\:VSS \2\:VSS) resistor r=62 c=0
Ry12 (\1\:VSS \4\:VSS) resistor r=5.1667 c=0
Ry13 (\1\:VSS \8\:VSS) resistor r=5.1667 c=0
Ry14 (\5\:VDD \6\:VDD) resistor r=62 c=0
Ry15 (\7\:VDD \8\:VDD) resistor r=31 c=0
Ry16 (\10\:VDD \11\:VDD) resistor r=62 c=0
Ry17 (\14\:VDD \15\:VDD) resistor r=62 c=0
Ry18 (\17\:VDD \18\:VDD) resistor r=62 c=0
Ry2 (\14\:qbint \15\:qbint) resistor r=62 c=0
Ry5 (\18\:CKb \19\:CKb) resistor r=62 c=0
Ry3 (\8\:n30 \9\:n30) resistor r=62 c=0
Ry4 (\9\:mout \10\:mout) resistor r=62 c=0
Ry7 (\9\:CKbb \10\:CKbb) resistor r=62 c=0
Ry6 (\4\:n20 \5\:n20) resistor r=31 c=0
Ry8 (\5\:Db \6\:Db) resistor r=62 c=0
Ry9 (\7\:Db \8\:Db) resistor r=20.6667 c=0
Ry10 (\6\:SEb \7\:SEb) resistor r=62 c=0
Rx13 (\3\:D \5\:D) resistor r=45 c=0
Rx1 (\2\:CK CK) resistor r=45 c=0
Rx15 (\1\:SE \8\:SE) resistor r=45 c=0
Rx16 (\4\:SE \9\:SE) resistor r=45 c=0
Rx17 (\6\:SE \10\:SE) resistor r=45 c=0
Rx14 (\2\:SI \4\:SI) resistor r=45 c=0
Rx2 (\7\:qbint \9\:qbint) resistor r=45 c=0
Rx3 (qbint \13\:qbint) resistor r=45 c=0
Rx6 (\4\:CKb \12\:CKb) resistor r=45 c=0
Rx7 (\9\:CKb \17\:CKb) resistor r=45 c=0
Rx4 (\2\:n30 \7\:n30) resistor r=45 c=0
Rx5 (\3\:mout \5\:mout) resistor r=45 c=0
Rx9 (\8\:CKbb \11\:CKbb) resistor r=45 c=0
Rx10 (\4\:CKbb \14\:CKbb) resistor r=45 c=0
Rx11 (\6\:CKbb \17\:CKbb) resistor r=45 c=0
Rx12 (\2\:CKbb \18\:CKbb) resistor r=45 c=0
Rx8 (\2\:n20 \7\:n20) resistor r=45 c=0
Rx18 (\2\:SEb \8\:SEb) resistor r=45 c=0
mn55 (\3\:Q \3\:qbint \16\:VSS VSS) g45n1hvt w=(2.6e-07) l=4.5e-08 nf=1 \
        as=4.655e-14 ad=3.64e-14 ps=9.4e-07 pd=8e-07 nrd=1.16667 \
        nrs=1.16667 sa=1.4e-07 sb=3.18462e-07 sd=160n sca=17.5885 \
        scb=0.0172826 scc=0.00162584 m=(1)
mn11 (net399 \4\:D \10\:VSS VSS) g45n1hvt w=(2.6e-07) l=4.5e-08 nf=1 \
        as=3.905e-14 ad=7.93e-14 ps=9e-07 pd=1.13e-06 nrd=1.16667 \
        nrs=1.16667 sa=2.53365e-07 sb=9.99808e-07 sd=160n sca=9.89531 \
        scb=0.00874901 scc=0.000299334 m=(1)
mn12 (Db \3\:SEb net399 VSS) g45n1hvt w=(2.6e-07) l=4.5e-08 nf=1 \
        as=7.93e-14 ad=4.16e-14 ps=1.13e-06 pd=8.4e-07 nrd=1.16667 \
        nrs=1.16667 sa=6.03365e-07 sb=6.49808e-07 sd=160n sca=9.89531 \
        scb=0.00874901 scc=0.000299334 m=(1)
mn14 (Db \3\:SE net411 VSS) g45n1hvt w=(2.6e-07) l=4.5e-08 nf=1 \
        as=1.56e-14 ad=4.16e-14 ps=6.4e-07 pd=8.4e-07 nrd=1.16667 \
        nrs=1.16667 sa=8.08365e-07 sb=4.44808e-07 sd=160n sca=9.89531 \
        scb=0.00874901 scc=0.000299334 m=(1)
mn13 (net411 \1\:SI \5\:VSS VSS) g45n1hvt w=(2.6e-07) l=4.5e-08 nf=1 \
        as=5.718e-14 ad=1.56e-14 ps=1.15e-06 pd=6.4e-07 nrd=1.16667 \
        nrs=1.16667 sa=9.13365e-07 sb=3.39808e-07 sd=160n sca=9.89531 \
        scb=0.00874901 scc=0.000299334 m=(1)
mn20 (\15\:CKb \1\:CK \16\:VSS VSS) g45n1hvt w=(1.45e-07) l=4.5e-08 nf=1 \
        as=4.655e-14 ad=2.972e-14 ps=9.4e-07 pd=7e-07 nrd=1.16667 \
        nrs=1.16667 sa=3.95e-07 sb=2.05e-07 sd=160n sca=23.279 \
        scb=0.0230742 scc=0.00267719 m=(1)
mn21 (\15\:CKbb \10\:CKb \10\:VSS VSS) g45n1hvt w=(1.45e-07) l=4.5e-08 \
        nf=1 as=3.905e-14 ad=2.03e-14 ps=9e-07 pd=5.7e-07 nrd=1.16667 \
        nrs=1.16667 sa=1.4e-07 sb=1.09879e-06 sd=160n sca=7.79977 \
        scb=0.00524357 scc=6.87485e-05 m=(1)
mn10 (\4\:SEb \5\:SE \5\:VSS VSS) g45n1hvt w=(1.45e-07) l=4.5e-08 nf=1 \
        as=5.718e-14 ad=2.465e-14 ps=1.15e-06 pd=6.3e-07 nrd=1.16667 \
        nrs=1.16667 sa=1.18638e-06 sb=1.7e-07 sd=160n sca=11.7118 \
        scb=0.0116498 scc=0.000458536 m=(1)
mn45 (\11\:qbint n30 \14\:VSS VSS) g45n1hvt w=(2.05e-07) l=4.5e-08 nf=1 \
        as=3.382e-14 ad=2.87e-14 ps=7.4e-07 pd=6.9e-07 nrd=1.16667 \
        nrs=1.16667 sa=1.4e-07 sb=2e-06 sd=160n sca=11.814 scb=0.0116374 \
        scc=0.000520744 m=(1)
mn50 (net391 \8\:qbint \14\:VSS VSS) g45n1hvt w=(2.05e-07) l=4.5e-08 \
        nf=1 as=3.383e-14 ad=4.408e-14 ps=7.4e-07 pd=8.4e-07 nrd=1.16667 \
        nrs=1.16667 sa=3.5e-07 sb=1.945e-06 sd=160n sca=11.814 \
        scb=0.0116374 scc=0.000520744 m=(1)
mn51 (\4\:n30 \3\:CKb net391 VSS) g45n1hvt w=(2.05e-07) l=4.5e-08 nf=1 \
        as=4.408e-14 ad=5.535e-14 ps=8.4e-07 pd=9.5e-07 nrd=1.16667 \
        nrs=1.16667 sa=6.1e-07 sb=1.685e-06 sd=160n sca=11.814 \
        scb=0.0116374 scc=0.000520744 m=(1)
mn40 (\7\:mout \3\:CKbb \4\:n30 VSS) g45n1hvt w=(2.05e-07) l=4.5e-08 nf=1 \
        as=5.535e-14 ad=7.585e-14 ps=9.5e-07 pd=1.15e-06 nrd=1.16667 \
        nrs=1.16667 sa=9.25e-07 sb=1.37e-06 sd=160n sca=11.814 \
        scb=0.0116374 scc=0.000520744 m=(1)
mn30 (\7\:mout \3\:n20 \12\:VSS VSS) g45n1hvt w=(2.05e-07) l=4.5e-08 \
        nf=1 as=7.03e-14 ad=7.585e-14 ps=1.27e-06 pd=1.15e-06 nrd=1.16667 \
        nrs=1.16667 sa=1.34e-06 sb=9.55e-07 sd=160n sca=11.814 \
        scb=0.0116374 scc=0.000520744 m=(1)
mn35 (net378 \4\:mout \12\:VSS VSS) g45n1hvt w=(2.05e-07) l=4.5e-08 nf=1 \
        as=7.03e-14 ad=1.23e-14 ps=1.27e-06 pd=5.3e-07 nrd=1.16667 \
        nrs=1.16667 sa=1.605e-06 sb=6.9e-07 sd=160n sca=11.814 \
        scb=0.0116374 scc=0.000520744 m=(1)
mn36 (\8\:n20 \5\:CKbb net378 VSS) g45n1hvt w=(2.05e-07) l=4.5e-08 nf=1 \
        as=1.23e-14 ad=4.613e-14 ps=5.3e-07 pd=8.6e-07 nrd=1.16667 \
        nrs=1.16667 sa=1.71e-06 sb=5.85e-07 sd=160n sca=11.814 \
        scb=0.0116374 scc=0.000520744 m=(1)
mn25 (\8\:n20 \11\:CKb \9\:Db VSS) g45n1hvt w=(2.05e-07) l=4.5e-08 nf=1 \
        as=6.458e-14 ad=4.613e-14 ps=1.04e-06 pd=8.6e-07 nrd=1.16667 \
        nrs=1.16667 sa=1.98e-06 sb=3.15e-07 sd=160n sca=11.814 \
        scb=0.0116374 scc=0.000520744 m=(1)
mp20 (\18\:CKb \3\:CK \17\:VDD VDD) g45p1hvt w=(2.15e-07) l=4.5e-08 nf=1 \
        as=5.19e-14 ad=5.483e-14 ps=1.1e-06 pd=9.4e-07 nrd=1.16667 \
        nrs=1.16667 sa=3.45e-07 sb=2.55e-07 sd=160n sca=12.8361 \
        scb=0.0101573 scc=0.000104788 m=(1)
mp21 (\9\:CKbb \5\:CKb \7\:VDD VDD) g45p1hvt w=(2.15e-07) l=4.5e-08 nf=1 \
        as=6.535e-14 ad=3.01e-14 ps=1.16e-06 pd=7.1e-07 nrd=1.16667 \
        nrs=1.16667 sa=1.4e-07 sb=1.34e-06 sd=160n sca=14.2498 \
        scb=0.0138057 scc=0.00069487 m=(1)
mp10 (\6\:SEb \7\:SE \5\:VDD VDD) g45p1hvt w=(2.15e-07) l=4.5e-08 nf=1 \
        as=9.223e-14 ad=3.01e-14 ps=1.41e-06 pd=7.1e-07 nrd=1.16667 \
        nrs=1.16667 sa=1.34e-06 sb=1.4e-07 sd=160n sca=21.6088 \
        scb=0.0245661 scc=0.00103605 m=(1)
mp45 (\14\:qbint \3\:n30 \14\:VDD VDD) g45p1hvt w=(3.1e-07) l=4.5e-08 \
        nf=1 as=8.56e-14 ad=4.315e-14 ps=1.35e-06 pd=1e-06 nrd=1.16667 \
        nrs=1.16667 sa=1.39194e-07 sb=2e-06 sd=160n sca=26.7199 \
        scb=0.0211429 scc=0.00304348 m=(1)
mp50 (net334 \5\:qbint \14\:VDD VDD) g45p1hvt w=(3.1e-07) l=4.5e-08 nf=1 \
        as=8.56e-14 ad=5.27e-14 ps=1.35e-06 pd=9.6e-07 nrd=1.16667 \
        nrs=1.16667 sa=4.04194e-07 sb=1.915e-06 sd=160n sca=26.7199 \
        scb=0.0211429 scc=0.00304348 m=(1)
mp51 (\8\:n30 CKbb net334 VDD) g45p1hvt w=(3.1e-07) l=4.5e-08 nf=1 \
        as=5.27e-14 ad=9.145e-14 ps=9.6e-07 pd=1.21e-06 nrd=1.16667 \
        nrs=1.16667 sa=6.19194e-07 sb=1.7e-06 sd=160n sca=26.7199 \
        scb=0.0211429 scc=0.00304348 m=(1)
mp40 (\8\:n30 CKb \9\:mout VDD) g45p1hvt w=(3.1e-07) l=4.5e-08 nf=1 \
        as=1.209e-13 ad=9.145e-14 ps=1.4e-06 pd=1.21e-06 nrd=1.16667 \
        nrs=1.16667 sa=9.59194e-07 sb=1.36e-06 sd=160n sca=26.7199 \
        scb=0.0211429 scc=0.00304348 m=(1)
mp30 (\9\:mout n20 \10\:VDD VDD) g45p1hvt w=(3.1e-07) l=4.5e-08 nf=1 \
        as=9.46e-14 ad=1.209e-13 ps=1.5e-06 pd=1.4e-06 nrd=1.16667 \
        nrs=1.16667 sa=1.39419e-06 sb=9.25e-07 sd=160n sca=26.7199 \
        scb=0.0211429 scc=0.00304348 m=(1)
mp35 (net319 mout \10\:VDD VDD) g45p1hvt w=(3.1e-07) l=4.5e-08 nf=1 \
        as=9.46e-14 ad=4.805e-14 ps=1.5e-06 pd=9.3e-07 nrd=1.16667 \
        nrs=1.16667 sa=1.65919e-06 sb=6.6e-07 sd=160n sca=26.7199 \
        scb=0.0211429 scc=0.00304348 m=(1)
mp36 (\4\:n20 \8\:CKb net319 VDD) g45p1hvt w=(3.1e-07) l=4.5e-08 nf=1 \
        as=4.805e-14 ad=5.58e-14 ps=9.3e-07 pd=9.8e-07 nrd=1.16667 \
        nrs=1.16667 sa=1.85919e-06 sb=4.6e-07 sd=160n sca=26.7199 \
        scb=0.0211429 scc=0.00304348 m=(1)
mp25 (\5\:Db \7\:CKbb \4\:n20 VDD) g45p1hvt w=(3.1e-07) l=4.5e-08 nf=1 \
        as=5.58e-14 ad=7.285e-14 ps=9.8e-07 pd=1.09e-06 nrd=1.16667 \
        nrs=1.16667 sa=2e-06 sb=2.35e-07 sd=160n sca=26.7199 scb=0.0211429 \
        scc=0.00304348 m=(1)
ends SDFFHQX1
// End of subcircuit definition.
