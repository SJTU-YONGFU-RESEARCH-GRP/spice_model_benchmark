// gsclib045_backbias/HOLDX1/schematic

simulator lang=spectre

subckt HOLDX1 Y VDD VSS NW
mn1 (Y n0 n1 VSS) g45n1svt w=(145n) l=45n nf=1 m=(1)
mn0 (n0 Y VSS VSS) g45n1svt w=(260n) l=45n nf=1 m=(1)
mn2 (n1 n0 n2 VSS) g45n1svt w=(145n) l=45n nf=1 m=(1)
mn3 (n2 n0 VSS VSS) g45n1svt w=(145n) l=45n nf=1 m=(1)
mp2 (p1 n0 p2 NW) g45p1svt w=(215n) l=45n nf=1 m=(1)
mp1 (Y n0 p1 NW) g45p1svt w=(215n) l=45n nf=1 m=(1)
mp3 (p2 n0 VDD NW) g45p1svt w=(215n) l=45n nf=1 m=(1)
mp0 (n0 Y VDD NW) g45p1svt w=(390n) l=45n nf=1 m=(1)
ends HOLDX1
