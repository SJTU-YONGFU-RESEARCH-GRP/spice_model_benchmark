// Generated for: spectre (May  1 09:14:35 2013 )
// Library name: gsclib045_hvt
// Cell name: DFFRX2
// View name: extracted

simulator lang=spectre

subckt DFFRX2 CK D Q QN RN VDD VSS
mp21 (\18\:CKbb CKb \25\:VDD VDD) g45p1hvt w=(2.15e-07) l=4.5e-08 nf=1 \
        as=6.265e-14 ad=3.01e-14 ps=1.75e-06 pd=7.1e-07 nrd=1.16667 \
        nrs=1.16667 sa=1.4e-07 sb=6.95e-07 sd=160n sca=31.5849 \
        scb=0.0355206 scc=0.00288112 m=(1)
mp25 (n22 \3\:D \25\:VDD VDD) g45p1hvt w=(2.15e-07) l=4.5e-08 nf=1 \
        as=6.265e-14 ad=1.29e-14 ps=1.75e-06 pd=5.5e-07 nrd=1.16667 \
        nrs=1.16667 sa=3.35e-07 sb=5e-07 sd=160n sca=24.3526 scb=0.023887 \
        scc=0.00211511 m=(1)
mp26 (\4\:n20 CKbb n22 VDD) g45p1hvt w=(2.15e-07) l=4.5e-08 nf=1 \
        as=1.29e-14 ad=4.515e-14 ps=5.5e-07 pd=8.5e-07 nrd=1.16667 \
        nrs=1.16667 sa=4.4e-07 sb=3.95e-07 sd=160n sca=23.0263 \
        scb=0.0218192 scc=0.0020924 m=(1)
mp37 (\4\:n20 \4\:CKb \3\:n26 VDD) g45p1hvt w=(2.15e-07) l=4.5e-08 nf=1 \
        as=3.01e-14 ad=4.515e-14 ps=7.1e-07 pd=8.5e-07 nrd=1.16667 \
        nrs=1.16667 sa=6.95e-07 sb=1.4e-07 sd=160n sca=21.5982 \
        scb=0.0204624 scc=0.00208846 m=(1)
mp36 (n26 mout \23\:VDD VDD) g45p1hvt w=(2.15e-07) l=4.5e-08 nf=1 \
        as=4.715e-14 ad=3.44e-14 ps=1.46e-06 pd=7.5e-07 nrd=1.16667 \
        nrs=1.16667 sa=1e-07 sb=1.35047e-06 sd=160n sca=12.9303 \
        scb=0.0120133 scc=0.000461649 m=(1)
mp35 (n26 \5\:RN \21\:VDD VDD) g45p1hvt w=(2.15e-07) l=4.5e-08 nf=1 \
        as=8.87e-14 ad=3.44e-14 ps=1.56e-06 pd=7.5e-07 nrd=1.16667 \
        nrs=1.16667 sa=3.05e-07 sb=1.14547e-06 sd=160n sca=12.9303 \
        scb=0.0120133 scc=0.000461649 m=(1)
mp30 (\5\:mout n20 \21\:VDD VDD) g45p1hvt w=(2.15e-07) l=4.5e-08 nf=1 \
        as=8.87e-14 ad=6.88e-14 ps=1.56e-06 pd=1.2e-06 nrd=1.16667 \
        nrs=1.16667 sa=5.7e-07 sb=8.80465e-07 sd=160n sca=12.9303 \
        scb=0.0120133 scc=0.000461649 m=(1)
mp40 (\8\:n30 \8\:CKb \5\:mout VDD) g45p1hvt w=(2.15e-07) l=4.5e-08 nf=1 \
        as=6.88e-14 ad=3.44e-14 ps=1.2e-06 pd=7.5e-07 nrd=1.16667 \
        nrs=1.16667 sa=7.12791e-07 sb=8.45e-07 sd=160n sca=17.4145 \
        scb=0.0172865 scc=0.00131682 m=(1)
mp51 (\8\:n30 \7\:CKbb n41 VDD) g45p1hvt w=(2.15e-07) l=4.5e-08 nf=1 \
        as=1.29e-14 ad=3.44e-14 ps=5.5e-07 pd=7.5e-07 nrd=1.16667 \
        nrs=1.16667 sa=9.17791e-07 sb=6.4e-07 sd=160n sca=17.4145 \
        scb=0.0172865 scc=0.00131682 m=(1)
mp50 (n41 \4\:qbint \19\:VDD VDD) g45p1hvt w=(2.15e-07) l=4.5e-08 nf=1 \
        as=8.078e-14 ad=1.29e-14 ps=1.75e-06 pd=5.5e-07 nrd=1.16667 \
        nrs=1.16667 sa=1.02279e-06 sb=5.35e-07 sd=160n sca=17.4145 \
        scb=0.0172865 scc=0.00131682 m=(1)
mp20 (\12\:CKb \1\:CK \1\:VDD VDD) g45p1hvt w=(2.15e-07) l=4.5e-08 nf=1 \
        as=6.05e-14 ad=3.01e-14 ps=1.18e-06 pd=7.1e-07 nrd=1.16667 \
        nrs=1.16667 sa=1.4e-07 sb=1.01058e-06 sd=160n sca=12.1244 \
        scb=0.0107968 scc=0.000332109 m=(1)
mp56 (\7\:qint \12\:qbint \1\:VDD VDD) g45p1hvt w=(2.15e-07) l=4.5e-08 \
        nf=1 as=5.19e-14 ad=3.01e-14 ps=1.1e-06 pd=7.1e-07 nrd=1.16667 \
        nrs=1.16667 sa=9.78023e-07 sb=1.4e-07 sd=160n sca=48.6469 \
        scb=0.0430734 scc=0.00580912 m=(1)
C1 (CK VSS) capacitor c=7.27633e-17
C2 (RN VSS) capacitor c=4.064e-17
C3 (Q VSS) capacitor c=6.3874e-17
C4 (VDD VSS) capacitor c=2.93527e-16
C5 (D VSS) capacitor c=7.16748e-17
C6 (QN VSS) capacitor c=3.40047e-17
C7 (CKb VSS) capacitor c=4.89891e-17
C8 (CKbb VSS) capacitor c=5.81459e-17
C9 (n21 VSS) capacitor c=1.44146e-19
C10 (n20 VSS) capacitor c=5.4758e-17
C11 (n27 VSS) capacitor c=1.04253e-18
C12 (mout VSS) capacitor c=3.55295e-17
C13 (n30 VSS) capacitor c=4.94147e-17
C14 (qbint VSS) capacitor c=2.66285e-17
C15 (qint VSS) capacitor c=1.8184e-16
C16 (n26 VSS) capacitor c=7.92715e-17
C17 (n41 VSS) capacitor c=9.81012e-19
C18 (\12\:qbint VSS) capacitor c=4.81902e-17
C19 (\5\:qbint VSS) capacitor c=5.17415e-16
C20 (\1\:CK VSS) capacitor c=4.11234e-17
C21 (\1\:RN VSS) capacitor c=7.9408e-17
C22 (\4\:qbint VSS) capacitor c=6.44392e-17
C23 (\7\:CKbb VSS) capacitor c=6.13839e-17
C24 (\8\:CKb VSS) capacitor c=5.61247e-17
C25 (\5\:RN VSS) capacitor c=4.58904e-17
C26 (\4\:CKb VSS) capacitor c=4.19082e-17
C27 (\3\:D VSS) capacitor c=6.16209e-17
C28 (\13\:qbint VSS) capacitor c=3.30012e-17
C29 (\3\:CK VSS) capacitor c=4.58573e-17
C30 (\3\:n30 VSS) capacitor c=4.97015e-17
C31 (\2\:RN VSS) capacitor c=1.42943e-16
C32 (\3\:qbint VSS) capacitor c=5.48864e-17
C33 (\7\:CKb VSS) capacitor c=7.74229e-17
C34 (\5\:CKbb VSS) capacitor c=3.77204e-17
C35 (\3\:n20 VSS) capacitor c=4.03323e-17
C36 (\3\:RN VSS) capacitor c=1.01727e-16
C37 (\4\:mout VSS) capacitor c=7.62805e-17
C38 (\3\:CKbb VSS) capacitor c=7.39895e-17
C39 (\6\:CKb VSS) capacitor c=6.47092e-17
C40 (\1\:D VSS) capacitor c=6.99964e-17
C41 (\3\:CKb VSS) capacitor c=4.31092e-17
C42 (\14\:qbint VSS) capacitor c=2.19898e-17
C43 (\2\:CK VSS) capacitor c=3.60048e-17
C44 (\2\:n30 VSS) capacitor c=4.09643e-17
C45 (\8\:CKbb VSS) capacitor c=4.94731e-17
C46 (\9\:CKb VSS) capacitor c=2.47866e-17
C47 (\6\:CKbb VSS) capacitor c=4.48211e-17
C48 (\2\:n20 VSS) capacitor c=4.22521e-17
C49 (\4\:RN VSS) capacitor c=4.32345e-17
C50 (\3\:mout VSS) capacitor c=5.45684e-17
C51 (\4\:CKbb VSS) capacitor c=3.03556e-17
C52 (\5\:CKb VSS) capacitor c=2.02127e-17
C53 (\2\:CKbb VSS) capacitor c=4.84213e-17
C54 (\2\:D VSS) capacitor c=6.99067e-17
C55 (\2\:CKb VSS) capacitor c=1.95448e-17
C56 (\7\:qint VSS) capacitor c=1.97639e-17
C57 (\1\:VDD VSS) capacitor c=2.23966e-16
C58 (\1\:QN VSS) capacitor c=8.30422e-17
C59 (\3\:Q VSS) capacitor c=4.99756e-17
C60 (\12\:CKb VSS) capacitor c=1.26904e-16
C61 (\17\:VDD VSS) capacitor c=1.0997e-17
C62 (\23\:qbint VSS) capacitor c=2.68483e-17
C63 (\19\:VDD VSS) capacitor c=1.1169e-17
C64 (\8\:n30 VSS) capacitor c=6.36878e-17
C65 (\5\:mout VSS) capacitor c=2.60621e-17
C66 (\21\:VDD VSS) capacitor c=2.04498e-17
C67 (\23\:VDD VSS) capacitor c=1.50253e-17
C68 (\3\:n26 VSS) capacitor c=6.67824e-17
C69 (\4\:n20 VSS) capacitor c=7.98769e-17
C70 (\25\:VDD VSS) capacitor c=1.47406e-17
C71 (\18\:CKbb VSS) capacitor c=4.09409e-17
C72 (\4\:VDD VSS) capacitor c=2.25636e-17
C73 (\11\:qint VSS) capacitor c=2.16293e-17
C74 (\3\:QN VSS) capacitor c=5.35135e-17
C75 (\1\:Q VSS) capacitor c=8.38493e-17
C76 (\10\:CKb VSS) capacitor c=1.28476e-16
C77 (\18\:qbint VSS) capacitor c=1.35312e-16
C78 (\6\:n30 VSS) capacitor c=7.73847e-17
C79 (\9\:mout VSS) capacitor c=9.51675e-17
C80 (\7\:n20 VSS) capacitor c=3.53061e-17
C81 (\14\:CKbb VSS) capacitor c=1.79723e-17
C82 (\2\:qbint VSS) capacitor c=3.43949e-17
C83 (\4\:D VSS) capacitor c=4.32252e-17
C84 (\6\:RN VSS) capacitor c=9.01754e-17
C85 (\6\:n20 VSS) capacitor c=7.21603e-17
C86 (\9\:n20 VSS) capacitor c=1.13625e-16
C87 (\7\:mout VSS) capacitor c=9.59256e-17
C88 (\8\:mout VSS) capacitor c=1.09521e-16
C89 (\9\:CKbb VSS) capacitor c=1.83218e-17
C90 (\10\:CKbb VSS) capacitor c=2.00054e-16
C91 (\11\:CKbb VSS) capacitor c=1.79837e-16
C92 (\12\:CKbb VSS) capacitor c=9.4783e-17
C93 (\13\:CKbb VSS) capacitor c=3.63386e-17
C94 (\16\:CKbb VSS) capacitor c=6.68921e-17
C95 (\17\:CKbb VSS) capacitor c=2.78994e-17
C96 (\4\:n30 VSS) capacitor c=6.33006e-17
C97 (\5\:n30 VSS) capacitor c=1.05525e-16
C98 (\14\:CKb VSS) capacitor c=1.55902e-16
C99 (\15\:CKb VSS) capacitor c=1.42326e-16
C100 (\16\:CKb VSS) capacitor c=5.74096e-17
C101 (\4\:CK VSS) capacitor c=3.1183e-17
C102 (\15\:qbint VSS) capacitor c=6.10281e-17
C103 (\20\:qbint VSS) capacitor c=8.09542e-17
C104 (\21\:qbint VSS) capacitor c=5.01252e-17
C105 (\9\:qint VSS) capacitor c=1.85303e-17
C106 (\10\:qint VSS) capacitor c=2.93262e-17
C107 (\7\:VDD VSS) capacitor c=1.55655e-17
C108 (\8\:VDD VSS) capacitor c=3.1798e-17
C109 (\9\:VDD VSS) capacitor c=2.4363e-17
C110 (\11\:VDD VSS) capacitor c=1.31804e-17
C111 (\12\:VDD VSS) capacitor c=1.68346e-17
Rk43 (\1\:VSS \7\:VSS) resistor r=0.4036 c=0
Rk44 (\7\:VSS \8\:VSS) resistor r=0.4664 c=0
Rk45 (\8\:VSS \9\:VSS) resistor r=0.1378 c=0
Rk46 (\9\:VSS \10\:VSS) resistor r=0.3311 c=0
Rk48 (\11\:VSS VSS) resistor r=0.12 c=0
Rk47 (\10\:VSS \11\:VSS) resistor r=0.09999 c=0
Rk51 (\7\:VSS \17\:VSS) resistor r=0.3332 c=0
Rk52 (\8\:VSS \19\:VSS) resistor r=0.2329 c=0
Rk53 (\10\:VSS \21\:VSS) resistor r=0.3758 c=0
Rk54 (\11\:VSS \23\:VSS) resistor r=0.3487 c=0
Rk25 (\4\:CK CK) resistor r=0.05603 c=0
Rk3 (RN \6\:RN) resistor r=0.04104 c=0
Rk26 (\2\:Q Q) resistor r=0.3252 c=0
Rk27 (Q \4\:Q) resistor r=0.04214 c=0
Rk58 (\1\:VDD \7\:VDD) resistor r=0.1728 c=0
Rk59 (\7\:VDD \8\:VDD) resistor r=0.2129 c=0
Rk60 (\8\:VDD \9\:VDD) resistor r=0.4714 c=0
Rk61 (\9\:VDD \10\:VDD) resistor r=0.1479 c=0
Rk62 (\10\:VDD \11\:VDD) resistor r=0.08669 c=0
Rk64 (\12\:VDD VDD) resistor r=0.1351 c=0
Rk63 (\11\:VDD \12\:VDD) resistor r=0.3274 c=0
Rk67 (\7\:VDD \18\:VDD) resistor r=0.0744 c=0
Rk68 (\8\:VDD \20\:VDD) resistor r=0.0744 c=0
Rk69 (\9\:VDD \22\:VDD) resistor r=0.1282 c=0
Rk70 (\11\:VDD \24\:VDD) resistor r=0.04335 c=0
Rk71 (\12\:VDD \26\:VDD) resistor r=0.0744 c=0
Rk1 (\4\:D D) resistor r=0.1374 c=0
Rk28 (QN \2\:QN) resistor r=0.01693 c=0
Rk29 (\2\:QN \4\:QN) resistor r=0.3926 c=0
Rk21 (\11\:CKb \13\:CKb) resistor r=0.5029 c=0
Rk22 (\13\:CKb \14\:CKb) resistor r=0.7008 c=0
Rk23 (\14\:CKb \15\:CKb) resistor r=0.8998 c=0
Rk24 (\15\:CKb \16\:CKb) resistor r=0.3943 c=0
Rk10 (\9\:CKbb \10\:CKbb) resistor r=0.02034 c=0
Rk11 (\10\:CKbb \11\:CKbb) resistor r=1.2437 c=0
Rk12 (\10\:CKbb \12\:CKbb) resistor r=0.5668 c=0
Rk13 (\12\:CKbb \13\:CKbb) resistor r=0.3042 c=0
Rk14 (\13\:CKbb \15\:CKbb) resistor r=0.1244 c=0
Rk15 (\11\:CKbb \16\:CKbb) resistor r=0.2021 c=0
Rk16 (\12\:CKbb \17\:CKbb) resistor r=0.09051 c=0
Rk17 (\13\:CKbb \19\:CKbb) resistor r=0.2497 c=0
Rk4 (\5\:n20 \6\:n20) resistor r=0.3868 c=0
Rk5 (\6\:n20 \8\:n20) resistor r=0.1173 c=0
Rk6 (\6\:n20 \9\:n20) resistor r=0.4879 c=0
Rk7 (\6\:mout \7\:mout) resistor r=0.08144 c=0
Rk8 (\7\:mout \8\:mout) resistor r=0.5445 c=0
Rk9 (\7\:mout \10\:mout) resistor r=0.3932 c=0
Rk18 (\4\:n30 \5\:n30) resistor r=0.3267 c=0
Rk19 (\5\:n30 \7\:n30) resistor r=0.3229 c=0
Rk20 (\5\:n30 \9\:n30) resistor r=0.4154 c=0
Rk30 (\15\:qbint \5\:qbint) resistor r=0.4368 c=0
Rk32 (\5\:qbint \19\:qbint) resistor r=0.7558 c=0
Rk33 (\19\:qbint \20\:qbint) resistor r=0.5071 c=0
Rk34 (\20\:qbint \21\:qbint) resistor r=0.1814 c=0
Rk36 (\20\:qbint \24\:qbint) resistor r=0.1113 c=0
Rk37 (\8\:qint \9\:qint) resistor r=0.1587 c=0
Rk38 (\9\:qint \10\:qint) resistor r=0.1659 c=0
Rk39 (\9\:qint \12\:qint) resistor r=0.1184 c=0
Rk2 (\2\:n26 \4\:n26) resistor r=0.259 c=0
Rl27 (\1\:CK \2\:CK) resistor r=37.6365 c=0
Rl28 (\2\:CK \3\:CK) resistor r=97.2519 c=0
Rl21 (\1\:RN \2\:RN) resistor r=140.385 c=0
Rl22 (\2\:RN \3\:RN) resistor r=591.873 c=0
Rl24 (\4\:RN \5\:RN) resistor r=56.9251 c=0
Rl23 (\3\:RN \4\:RN) resistor r=91.5405 c=0
Rl5 (\2\:D \3\:D) resistor r=24.2328 c=0
Rl4 (\1\:D \2\:D) resistor r=162.26 c=0
Rl15 (\7\:CKb \8\:CKb) resistor r=184.181 c=0
Rl7 (\4\:CKb \6\:CKb) resistor r=140.385 c=0
Rl2 (CKb \3\:CKb) resistor r=151.923 c=0
Rl16 (\8\:CKb \9\:CKb) resistor r=24.2328 c=0
Rl6 (\4\:CKb \5\:CKb) resistor r=35.7713 c=0
Rl1 (CKb \2\:CKb) resistor r=35.7713 c=0
Rl17 (\7\:CKbb \8\:CKbb) resistor r=31.0185 c=0
Rl14 (\5\:CKbb \6\:CKbb) resistor r=71.8456 c=0
Rl8 (\3\:CKbb \4\:CKbb) resistor r=51.1559 c=0
Rl3 (CKbb \2\:CKbb) resistor r=37.6944 c=0
Rl12 (n20 \2\:n20) resistor r=124.233 c=0
Rl13 (\2\:n20 \3\:n20) resistor r=24.2328 c=0
Rl9 (mout \2\:mout) resistor r=37.3411 c=0
Rl11 (\2\:mout \4\:mout) resistor r=129.649 c=0
Rl10 (\2\:mout \3\:mout) resistor r=0.6051 c=0
Rl25 (n30 \2\:n30) resistor r=103.562 c=0
Rl26 (\2\:n30 \3\:n30) resistor r=26.1559 c=0
Rl39 (\13\:qbint \12\:qbint) resistor r=100 c=0
Rl40 (\14\:qbint \13\:qbint) resistor r=29.5379 c=0
Rl20 (\2\:qbint \4\:qbint) resistor r=45.868 c=0
Rl19 (\2\:qbint \3\:qbint) resistor r=97.7911 c=0
Rl18 (\2\:qbint qbint) resistor r=4.3192 c=0
Rz13 (\17\:VSS \16\:VSS) resistor r=75 c=0
Rz14 (\19\:VSS \18\:VSS) resistor r=75 c=0
Rz15 (\21\:VSS \20\:VSS) resistor r=75 c=0
Rz16 (\23\:VSS \22\:VSS) resistor r=75 c=0
Rz6 (\2\:Q \1\:Q) resistor r=75 c=0
Rz17 (\1\:VDD \4\:VDD) resistor r=7.5 c=0
Rz18 (\10\:VDD \4\:VDD) resistor r=6.25 c=0
Rz7 (\4\:QN \3\:QN) resistor r=75 c=0
Rz5 (\10\:CKb \11\:CKb) resistor r=75 c=0
Rz3 (\14\:CKbb \15\:CKbb) resistor r=75 c=0
Rz1 (\7\:n20 \8\:n20) resistor r=75 c=0
Rz2 (\9\:mout \10\:mout) resistor r=75 c=0
Rz4 (\6\:n30 \7\:n30) resistor r=75 c=0
Rz8 (\19\:qbint \18\:qbint) resistor r=75 c=0
Rz9 (\12\:qint \11\:qint) resistor r=75 c=0
Ry12 (\1\:VSS \4\:VSS) resistor r=6.2 c=0
Ry13 (\9\:VSS \4\:VSS) resistor r=5.1667 c=0
Ry8 (\4\:Q \3\:Q) resistor r=20.6667 c=0
Ry17 (\18\:VDD \17\:VDD) resistor r=62 c=0
Ry18 (\20\:VDD \19\:VDD) resistor r=62 c=0
Ry19 (\22\:VDD \21\:VDD) resistor r=62 c=0
Ry20 (\24\:VDD \23\:VDD) resistor r=62 c=0
Ry21 (\26\:VDD \25\:VDD) resistor r=62 c=0
Ry9 (\2\:QN \1\:QN) resistor r=20.6667 c=0
Ry7 (\12\:CKb \13\:CKb) resistor r=62 c=0
Ry5 (\18\:CKbb \19\:CKbb) resistor r=62 c=0
Ry3 (\4\:n20 \5\:n20) resistor r=62 c=0
Ry4 (\5\:mout \6\:mout) resistor r=62 c=0
Ry6 (\8\:n30 \9\:n30) resistor r=62 c=0
Ry10 (\24\:qbint \23\:qbint) resistor r=62 c=0
Ry11 (\8\:qint \7\:qint) resistor r=62 c=0
Ry1 (n26 \2\:n26) resistor r=62 c=0
Ry2 (\3\:n26 \4\:n26) resistor r=62 c=0
Rx13 (\2\:CK \4\:CK) resistor r=45 c=0
Rx2 (\4\:RN \6\:RN) resistor r=45 c=0
Rx1 (\2\:D \4\:D) resistor r=45 c=0
Rx10 (\9\:CKb \14\:CKb) resistor r=45 c=0
Rx11 (\5\:CKb \15\:CKb) resistor r=45 c=0
Rx12 (\2\:CKb \16\:CKb) resistor r=45 c=0
Rx5 (\4\:CKbb \9\:CKbb) resistor r=45 c=0
Rx6 (\6\:CKbb \11\:CKbb) resistor r=45 c=0
Rx7 (\8\:CKbb \16\:CKbb) resistor r=45 c=0
Rx8 (\2\:CKbb \17\:CKbb) resistor r=45 c=0
Rx3 (\2\:n20 \9\:n20) resistor r=45 c=0
Rx4 (\3\:mout \8\:mout) resistor r=45 c=0
Rx9 (\2\:n30 \4\:n30) resistor r=45 c=0
Rx14 (\15\:qbint \14\:qbint) resistor r=45 c=0
Rx16 (\21\:qbint qbint) resistor r=45 c=0
Rx18 (\10\:qint qint) resistor r=45 c=0
mn21 (\14\:CKbb \3\:CKb \22\:VSS VSS) g45n1hvt w=(1.45e-07) l=4.5e-08 \
        nf=1 as=2.465e-14 ad=2.03e-14 ps=6.3e-07 pd=5.7e-07 nrd=1.16667 \
        nrs=1.16667 sa=1.4e-07 sb=1.7e-07 sd=160n sca=13.6097 scb=0.014254 \
        scc=0.000755054 m=(1)
mn25 (n21 \1\:D \20\:VSS VSS) g45n1hvt w=(1.45e-07) l=4.5e-08 nf=1 \
        as=2.03e-14 ad=1.088e-14 ps=5.7e-07 pd=4.4e-07 nrd=1.16667 \
        nrs=1.16667 sa=1.4e-07 sb=2e-06 sd=160n sca=16.2011 scb=0.0172667 \
        scc=0.0012292 m=(1)
mn26 (\7\:n20 \6\:CKb n21 VSS) g45n1hvt w=(1.45e-07) l=4.5e-08 nf=1 \
        as=1.088e-14 ad=3.118e-14 ps=4.4e-07 pd=7.2e-07 nrd=1.16667 \
        nrs=1.16667 sa=2.6e-07 sb=1.975e-06 sd=160n sca=16.2011 \
        scb=0.0172667 scc=0.0012292 m=(1)
mn37 (\7\:n20 \3\:CKbb n25 VSS) g45n1hvt w=(1.45e-07) l=4.5e-08 nf=1 \
        as=8.7e-15 ad=3.118e-14 ps=4.1e-07 pd=7.2e-07 nrd=1.16667 \
        nrs=1.16667 sa=5.2e-07 sb=1.715e-06 sd=160n sca=16.2011 \
        scb=0.0172667 scc=0.0012292 m=(1)
mn36 (n25 \4\:mout n27 VSS) g45n1hvt w=(1.45e-07) l=4.5e-08 nf=1 \
        as=2.03e-14 ad=8.7e-15 ps=5.7e-07 pd=4.1e-07 nrd=1.16667 \
        nrs=1.16667 sa=6.25e-07 sb=1.61e-06 sd=160n sca=16.2011 \
        scb=0.0172667 scc=0.0012292 m=(1)
mn35 (n27 \3\:RN \18\:VSS VSS) g45n1hvt w=(1.45e-07) l=4.5e-08 nf=1 \
        as=5.4e-14 ad=2.03e-14 ps=1.09e-06 pd=5.7e-07 nrd=1.16667 \
        nrs=1.16667 sa=8.1e-07 sb=1.425e-06 sd=160n sca=16.2011 \
        scb=0.0172667 scc=0.0012292 m=(1)
mn30 (\9\:mout \3\:n20 \18\:VSS VSS) g45n1hvt w=(1.45e-07) l=4.5e-08 \
        nf=1 as=5.4e-14 ad=2.32e-14 ps=1.09e-06 pd=6.1e-07 nrd=1.16667 \
        nrs=1.16667 sa=1.095e-06 sb=1.14e-06 sd=160n sca=16.2011 \
        scb=0.0172667 scc=0.0012292 m=(1)
mn40 (\6\:n30 \5\:CKbb \9\:mout VSS) g45n1hvt w=(1.45e-07) l=4.5e-08 nf=1 \
        as=2.32e-14 ad=3.553e-14 ps=6.1e-07 pd=7.8e-07 nrd=1.16667 \
        nrs=1.16667 sa=1.3e-06 sb=9.35e-07 sd=160n sca=16.2011 \
        scb=0.0172667 scc=0.0012292 m=(1)
mn51 (\6\:n30 \7\:CKb n40 VSS) g45n1hvt w=(1.45e-07) l=4.5e-08 nf=1 \
        as=1.958e-14 ad=3.553e-14 ps=5.6e-07 pd=7.8e-07 nrd=1.16667 \
        nrs=1.16667 sa=1.59e-06 sb=6.45e-07 sd=160n sca=16.2011 \
        scb=0.0172667 scc=0.0012292 m=(1)
mn50 (n40 \3\:qbint \16\:VSS VSS) g45n1hvt w=(1.45e-07) l=4.5e-08 nf=1 \
        as=3.138e-14 ad=1.958e-14 ps=7.6e-07 pd=5.6e-07 nrd=1.16667 \
        nrs=1.16667 sa=1.77e-06 sb=4.65e-07 sd=160n sca=16.2011 \
        scb=0.0172667 scc=0.0012292 m=(1)
mn20 (\10\:CKb \3\:CK \1\:VSS VSS) g45n1hvt w=(1.45e-07) l=4.5e-08 nf=1 \
        as=4.05e-14 ad=2.465e-14 ps=9.2e-07 pd=6.3e-07 nrd=1.16667 \
        nrs=1.16667 sa=1.7e-07 sb=1.21e-06 sd=160n sca=22.3376 \
        scb=0.0224607 scc=0.00248252 m=(1)
mn56 (\11\:qint \13\:qbint \1\:VSS VSS) g45n1hvt w=(1.45e-07) l=4.5e-08 \
        nf=1 as=6.675e-14 ad=2.03e-14 ps=1.59e-06 pd=5.7e-07 nrd=1.16667 \
        nrs=1.16667 sa=1.24e-06 sb=1.4e-07 sd=160n sca=22.3376 \
        scb=0.0224607 scc=0.00248252 m=(1)
mn45 (n35 \2\:RN \16\:VSS VSS) g45n1hvt w=(2.05e-07) l=4.5e-08 nf=1 \
        as=3.138e-14 ad=1.23e-14 ps=7.6e-07 pd=5.3e-07 nrd=1.16667 \
        nrs=1.16667 sa=1.43683e-06 sb=2.45e-07 sd=160n sca=14.2182 \
        scb=0.0146528 scc=0.000922757 m=(1)
mn46 (\18\:qbint \3\:n30 n35 VSS) g45n1hvt w=(2.05e-07) l=4.5e-08 nf=1 \
        as=1.23e-14 ad=2.87e-14 ps=5.3e-07 pd=6.9e-07 nrd=1.16667 \
        nrs=1.16667 sa=1.47463e-06 sb=1.4e-07 sd=160n sca=14.2182 \
        scb=0.0146528 scc=0.000922757 m=(1)
mn57 (\3\:QN qint \1\:VSS VSS) g45n1hvt w=(2.6e-07) l=4.5e-08 nf=1 \
        as=6.877e-14 ad=4.16e-14 ps=1.59e-06 pd=8.4e-07 nrd=1.16667 \
        nrs=1.16667 sa=6.90673e-07 sb=4.46058e-07 sd=160n sca=16.9678 \
        scb=0.0167861 scc=0.00150639 m=(2)
mn55 (\1\:Q \5\:qbint \1\:VSS VSS) g45n1hvt w=(2.6e-07) l=4.5e-08 nf=1 \
        as=5.565e-14 ad=4.16e-14 ps=1.255e-06 pd=8.4e-07 nrd=1.16667 \
        nrs=1.16667 sa=2.75673e-07 sb=8.61058e-07 sd=160n sca=16.9678 \
        scb=0.0167861 scc=0.00150639 m=(2)
mp45 (\23\:qbint \1\:RN \19\:VDD VDD) g45p1hvt w=(3.1e-07) l=4.5e-08 \
        nf=1 as=8.078e-14 ad=4.96e-14 ps=1.75e-06 pd=9.4e-07 nrd=1.16667 \
        nrs=1.16667 sa=9.00242e-07 sb=3.15e-07 sd=160n sca=17.9343 \
        scb=0.0166254 scc=0.0014837 m=(1)
mp46 (\23\:qbint n30 \17\:VDD VDD) g45p1hvt w=(3.1e-07) l=4.5e-08 nf=1 \
        as=6.2e-14 ad=4.96e-14 ps=1.65e-06 pd=9.4e-07 nrd=1.16667 \
        nrs=1.16667 sa=1.10524e-06 sb=1.1e-07 sd=160n sca=17.9343 \
        scb=0.0166254 scc=0.0014837 m=(1)
mp55_1__rcx (\3\:Q \5\:qbint \1\:VDD VDD) g45p1hvt w=(3.9e-07) l=4.5e-08 \
        nf=1 as=6.242e-14 ad=6.24e-14 ps=1.145e-06 pd=1.1e-06 nrd=1.16667 \
        nrs=1.16667 sa=2.57115e-07 sb=8.55064e-07 sd=160n sca=25.6993 \
        scb=0.0190507 scc=0.00277827 m=(2)
mp57_1__rcx (\1\:QN qint \1\:VDD VDD) g45p1hvt w=(3.9e-07) l=4.5e-08 \
        nf=1 as=5.812e-14 ad=6.24e-14 ps=1.105e-06 pd=1.1e-06 nrd=1.16667 \
        nrs=1.16667 sa=6.72115e-07 sb=4.40064e-07 sd=160n sca=26.8 \
        scb=0.0196695 scc=0.0027789 m=(2)
ends DFFRX2
// End of subcircuit definition.
