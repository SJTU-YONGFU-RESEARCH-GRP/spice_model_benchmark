// Generated for: spectre (May  1 09:13:58 2013 )
// Library name: gsclib045_lvt
// Cell name: DFFSRHQX8
// View name: extracted

simulator lang=spectre

subckt DFFSRHQX8 CK D Q RN SN VDD VSS
mp55_1__rcx (Q qbint \22\:VDD VDD) g45p1lvt w=(4.45e-07) l=4.5e-08 nf=1 \
        as=7.073e-14 ad=6.993e-14 ps=1.21e-06 pd=1.20429e-06 nrd=1.16667 \
        nrs=1.16667 sa=1.4e-07 sb=1.87978e-06 sd=160n sca=40.5428 \
        scb=0.0363846 scc=0.00414682 m=(7)
C1 (RN VSS) capacitor c=6.52512e-17
C2 (Q VSS) capacitor c=4.88028e-16
C3 (VDD VSS) capacitor c=4.59841e-16
C4 (CK VSS) capacitor c=9.66958e-17
C5 (D VSS) capacitor c=4.53719e-17
C6 (qbint VSS) capacitor c=3.84041e-16
C7 (n35 VSS) capacitor c=2.1147e-16
C8 (RNb VSS) capacitor c=1.36851e-16
C9 (n42 VSS) capacitor c=6.90802e-17
C10 (n40 VSS) capacitor c=8.87269e-17
C11 (CKb VSS) capacitor c=3.48521e-17
C12 (mout VSS) capacitor c=3.94466e-17
C13 (CKbb VSS) capacitor c=3.55075e-17
C14 (n25 VSS) capacitor c=8.34776e-17
C15 (n20 VSS) capacitor c=2.83239e-17
C16 (n30 VSS) capacitor c=1.97998e-18
C17 (n21 VSS) capacitor c=1.42395e-18
C18 (n41 VSS) capacitor c=1.0503e-16
C19 (n43 VSS) capacitor c=2.07482e-18
C20 (n26 VSS) capacitor c=2.74119e-18
C21 (n31 VSS) capacitor c=4.53202e-18
C22 (n22 VSS) capacitor c=1.71154e-18
C23 (\3\:CK VSS) capacitor c=2.78538e-17
C24 (\11\:CKb VSS) capacitor c=5.48524e-17
C25 (\4\:D VSS) capacitor c=7.35709e-17
C26 (\5\:CKbb VSS) capacitor c=3.82639e-17
C27 (\5\:CKb VSS) capacitor c=4.73427e-17
C28 (\4\:SN VSS) capacitor c=6.14196e-17
C29 (\3\:n20 VSS) capacitor c=6.36134e-17
C30 (\4\:CKb VSS) capacitor c=4.16374e-17
C31 (\3\:RNb VSS) capacitor c=7.24483e-17
C32 (\23\:qbint VSS) capacitor c=1.31372e-16
C33 (\1\:SN VSS) capacitor c=4.58467e-17
C34 (\3\:RN VSS) capacitor c=2.54671e-17
C35 (\1\:CK VSS) capacitor c=3.35983e-17
C36 (\10\:CKb VSS) capacitor c=4.74686e-17
C37 (\3\:D VSS) capacitor c=4.47448e-17
C38 (\7\:CKb VSS) capacitor c=4.70864e-17
C39 (\7\:CKbb VSS) capacitor c=7.11245e-17
C40 (\4\:mout VSS) capacitor c=4.16306e-17
C41 (\6\:SN VSS) capacitor c=5.34404e-17
C42 (\4\:n20 VSS) capacitor c=4.09095e-17
C43 (\5\:RNb VSS) capacitor c=4.74295e-17
C44 (\3\:CKbb VSS) capacitor c=3.94011e-17
C45 (\3\:CKb VSS) capacitor c=5.45581e-17
C46 (\4\:RNb VSS) capacitor c=5.72674e-17
C47 (\22\:qbint VSS) capacitor c=7.46428e-17
C48 (\3\:SN VSS) capacitor c=4.05696e-17
C49 (\1\:RN VSS) capacitor c=2.89591e-17
C50 (\2\:CK VSS) capacitor c=3.147e-17
C51 (\9\:CKb VSS) capacitor c=1.97241e-17
C52 (\1\:D VSS) capacitor c=2.3781e-17
C53 (\6\:CKbb VSS) capacitor c=6.6077e-17
C54 (\8\:CKb VSS) capacitor c=5.0284e-17
C55 (\6\:CKb VSS) capacitor c=4.93733e-17
C56 (\3\:mout VSS) capacitor c=3.38855e-17
C57 (\5\:SN VSS) capacitor c=2.16991e-17
C58 (\4\:CKbb VSS) capacitor c=4.29784e-17
C59 (\2\:CKbb VSS) capacitor c=3.26809e-17
C60 (\2\:RNb VSS) capacitor c=9.98769e-17
C61 (\2\:SN VSS) capacitor c=3.39848e-17
C62 (\2\:RN VSS) capacitor c=2.4903e-17
C63 (\24\:qbint VSS) capacitor c=5.15684e-17
C64 (\1\:VDD VSS) capacitor c=1.87466e-17
C65 (\12\:CKb VSS) capacitor c=8.25476e-17
C66 (\16\:CKbb VSS) capacitor c=1.95782e-17
C67 (\6\:VDD VSS) capacitor c=4.34607e-17
C68 (\5\:n20 VSS) capacitor c=4.13105e-17
C69 (\9\:VDD VSS) capacitor c=5.08456e-17
C70 (\12\:mout VSS) capacitor c=3.68201e-17
C71 (\13\:VDD VSS) capacitor c=4.05883e-17
C72 (\7\:mout VSS) capacitor c=1.7114e-16
C73 (\14\:n35 VSS) capacitor c=6.90249e-17
C74 (\16\:VDD VSS) capacitor c=4.44594e-17
C75 (\3\:n41 VSS) capacitor c=1.11497e-16
C76 (\20\:VDD VSS) capacitor c=6.43303e-17
C77 (\7\:RNb VSS) capacitor c=1.79148e-16
C78 (\26\:qbint VSS) capacitor c=3.36672e-16
C79 (\3\:VDD VSS) capacitor c=9.01601e-17
C80 (\14\:CKb VSS) capacitor c=8.26815e-17
C81 (\13\:CKbb VSS) capacitor c=6.40915e-17
C82 (\9\:n20 VSS) capacitor c=7.4376e-17
C83 (\14\:mout VSS) capacitor c=1.13044e-16
C84 (\3\:n25 VSS) capacitor c=8.02452e-17
C85 (\10\:mout VSS) capacitor c=1.79551e-17
C86 (\10\:n35 VSS) capacitor c=3.74663e-17
C87 (\3\:n42 VSS) capacitor c=7.39457e-17
C88 (\3\:n40 VSS) capacitor c=1.15802e-16
C89 (\9\:RNb VSS) capacitor c=8.41867e-17
C90 (\2\:CKb VSS) capacitor c=4.74683e-17
C91 (\2\:n20 VSS) capacitor c=2.7336e-17
C92 (\2\:mout VSS) capacitor c=4.06626e-17
C93 (\2\:D VSS) capacitor c=4.73527e-17
C94 (\25\:qbint VSS) capacitor c=6.44113e-17
C95 (\37\:qbint VSS) capacitor c=2.84518e-17
C96 (\4\:RN VSS) capacitor c=5.07469e-17
C97 (\6\:RNb VSS) capacitor c=1.4977e-16
C98 (\12\:n35 VSS) capacitor c=3.04232e-16
C99 (\13\:n35 VSS) capacitor c=2.61644e-16
C100 (\7\:SN VSS) capacitor c=2.89028e-16
C101 (\8\:SN VSS) capacitor c=2.87444e-16
C102 (\5\:mout VSS) capacitor c=4.12501e-17
C103 (\6\:mout VSS) capacitor c=1.35993e-16
C104 (\9\:mout VSS) capacitor c=7.23739e-17
C105 (\7\:n20 VSS) capacitor c=1.23841e-16
C106 (\8\:n20 VSS) capacitor c=1.42017e-16
C107 (\5\:D VSS) capacitor c=7.29431e-17
C108 (\8\:CKbb VSS) capacitor c=2.35771e-17
C109 (\9\:CKbb VSS) capacitor c=2.42061e-16
C110 (\10\:CKbb VSS) capacitor c=3.97635e-16
C111 (\11\:CKbb VSS) capacitor c=7.97432e-17
C112 (\12\:CKbb VSS) capacitor c=5.56382e-17
C113 (\15\:CKbb VSS) capacitor c=8.05643e-17
C114 (\16\:CKb VSS) capacitor c=5.7568e-17
C115 (\17\:CKb VSS) capacitor c=7.51173e-17
C116 (\18\:CKb VSS) capacitor c=1.79885e-16
C117 (\19\:CKb VSS) capacitor c=1.87905e-16
C118 (\20\:CKb VSS) capacitor c=5.86857e-17
C119 (\21\:CKb VSS) capacitor c=4.31305e-17
C120 (\5\:VDD VSS) capacitor c=2.7023e-17
C121 (\8\:VDD VSS) capacitor c=1.67384e-17
C122 (\12\:VDD VSS) capacitor c=6.29143e-17
C123 (\15\:VDD VSS) capacitor c=4.84582e-17
C124 (\19\:VDD VSS) capacitor c=7.46812e-17
C125 (\22\:VDD VSS) capacitor c=5.30082e-16
Rk32 (\7\:SN SN) resistor r=2.3401 c=0
Rk33 (SN \8\:SN) resistor r=0.003008 c=0
Rk60 (\2\:VSS \4\:VSS) resistor r=0.1197 c=0
Rk61 (\4\:VSS \5\:VSS) resistor r=0.2999 c=0
Rk62 (\5\:VSS \6\:VSS) resistor r=0.4505 c=0
Rk63 (\6\:VSS \7\:VSS) resistor r=0.06755 c=0
Rk64 (\7\:VSS \8\:VSS) resistor r=1.1364 c=0
Rk65 (\8\:VSS \9\:VSS) resistor r=0.325 c=0
Rk72 (\10\:VSS VSS) resistor r=0.1074 c=0
Rk66 (\9\:VSS \10\:VSS) resistor r=0.498 c=0
Rk73 (\5\:VSS \17\:VSS) resistor r=0.04334 c=0
Rk74 (\7\:VSS \19\:VSS) resistor r=0.2622 c=0
Rk75 (\9\:VSS \21\:VSS) resistor r=0.04334 c=0
Rk23 (\4\:RN RN) resistor r=0.04813 c=0
Rk81 (\2\:VDD \4\:VDD) resistor r=0.2856 c=0
Rk82 (\4\:VDD \5\:VDD) resistor r=0.3159 c=0
Rk83 (\5\:VDD \7\:VDD) resistor r=0.3371 c=0
Rk84 (\5\:VDD \8\:VDD) resistor r=0.4011 c=0
Rk85 (\8\:VDD \10\:VDD) resistor r=0.2641 c=0
Rk86 (\8\:VDD \11\:VDD) resistor r=0.03493 c=0
Rk87 (\11\:VDD \12\:VDD) resistor r=0.4263 c=0
Rk88 (\12\:VDD \14\:VDD) resistor r=0.1769 c=0
Rk89 (\12\:VDD \15\:VDD) resistor r=0.7222 c=0
Rk90 (\15\:VDD \17\:VDD) resistor r=0.2406 c=0
Rk91 (\15\:VDD \18\:VDD) resistor r=0.055 c=0
Rk92 (\18\:VDD \19\:VDD) resistor r=0.4063 c=0
Rk93 (\19\:VDD \21\:VDD) resistor r=0.2042 c=0
Rk105 (\22\:VDD VDD) resistor r=0.1074 c=0
Rk94 (\19\:VDD \22\:VDD) resistor r=0.4186 c=0
Rk59 (\4\:CK CK) resistor r=0.003008 c=0
Rk44 (D \5\:D) resistor r=0.02261 c=0
Rk13 (\25\:qbint \26\:qbint) resistor r=0.4906 c=0
Rk20 (\26\:qbint \37\:qbint) resistor r=0.1668 c=0
Rk29 (\11\:n35 \12\:n35) resistor r=0.1574 c=0
Rk30 (\12\:n35 \13\:n35) resistor r=2.2277 c=0
Rk31 (\12\:n35 \15\:n35) resistor r=0.2901 c=0
Rk24 (\6\:RNb \8\:RNb) resistor r=1.1055 c=0
Rk25 (\8\:RNb \10\:RNb) resistor r=0.4272 c=0
Rk26 (\2\:n42 \4\:n42) resistor r=0.3163 c=0
Rk28 (\2\:n40 \4\:n40) resistor r=0.6196 c=0
Rk52 (\13\:CKb \15\:CKb) resistor r=0.5762 c=0
Rk53 (\15\:CKb \16\:CKb) resistor r=0.305 c=0
Rk54 (\16\:CKb \17\:CKb) resistor r=0.365 c=0
Rk55 (\17\:CKb \18\:CKb) resistor r=0.4677 c=0
Rk56 (\18\:CKb \19\:CKb) resistor r=1.2105 c=0
Rk57 (\17\:CKb \20\:CKb) resistor r=0.2198 c=0
Rk58 (\18\:CKb \21\:CKb) resistor r=0.1461 c=0
Rk35 (\5\:mout \6\:mout) resistor r=0.1769 c=0
Rk36 (\6\:mout \8\:mout) resistor r=0.8735 c=0
Rk37 (\8\:mout \9\:mout) resistor r=0.2968 c=0
Rk38 (\9\:mout \11\:mout) resistor r=0.0679 c=0
Rk39 (\6\:mout \13\:mout) resistor r=0.08708 c=0
Rk40 (\9\:mout \15\:mout) resistor r=0.6207 c=0
Rk45 (\8\:CKbb \9\:CKbb) resistor r=0.06454 c=0
Rk46 (\9\:CKbb \10\:CKbb) resistor r=2.2062 c=0
Rk47 (\10\:CKbb \11\:CKbb) resistor r=0.5001 c=0
Rk48 (\9\:CKbb \12\:CKbb) resistor r=0.2822 c=0
Rk49 (\12\:CKbb \14\:CKbb) resistor r=0.3338 c=0
Rk50 (\10\:CKbb \15\:CKbb) resistor r=0.3737 c=0
Rk51 (\12\:CKbb \17\:CKbb) resistor r=0.0753 c=0
Rk34 (\2\:n25 \4\:n25) resistor r=0.4098 c=0
Rk41 (\6\:n20 \7\:n20) resistor r=0.1056 c=0
Rk42 (\7\:n20 \8\:n20) resistor r=0.7797 c=0
Rk43 (\7\:n20 \10\:n20) resistor r=0.3573 c=0
Rk27 (\2\:n41 \4\:n41) resistor r=0.4131 c=0
Rl48 (\4\:SN \6\:SN) resistor r=178.846 c=0
Rl47 (\4\:SN \5\:SN) resistor r=105.282 c=0
Rl31 (\1\:SN \2\:SN) resistor r=40.3846 c=0
Rl32 (\2\:SN \3\:SN) resistor r=101.099 c=0
Rl30 (\2\:RN \3\:RN) resistor r=58.1076 c=0
Rl29 (\1\:RN \2\:RN) resistor r=70.3867 c=0
Rl62 (\2\:CK \3\:CK) resistor r=34.0659 c=0
Rl61 (\1\:CK \2\:CK) resistor r=165.385 c=0
Rl58 (\2\:D \4\:D) resistor r=116.187 c=0
Rl57 (\2\:D \3\:D) resistor r=52.7257 c=0
Rl56 (\1\:D \2\:D) resistor r=1.2334 c=0
Rl33 (\22\:qbint \23\:qbint) resistor r=180.335 c=0
Rl34 (\24\:qbint \23\:qbint) resistor r=389.455 c=0
Rl43 (RNb \5\:RNb) resistor r=128.846 c=0
Rl42 (\3\:RNb \4\:RNb) resistor r=165.385 c=0
Rl40 (RNb \2\:RNb) resistor r=771.131 c=0
Rl41 (\2\:RNb \3\:RNb) resistor r=63.2566 c=0
Rl60 (\10\:CKb \11\:CKb) resistor r=166.873 c=0
Rl59 (\9\:CKb \10\:CKb) resistor r=36.2715 c=0
Rl55 (\7\:CKb \8\:CKb) resistor r=29.5379 c=0
Rl52 (\5\:CKb \6\:CKb) resistor r=74.2328 c=0
Rl39 (\2\:CKb \4\:CKb) resistor r=30.4507 c=0
Rl38 (\2\:CKb \3\:CKb) resistor r=114.928 c=0
Rl37 (CKb \2\:CKb) resistor r=140.774 c=0
Rl49 (mout \2\:mout) resistor r=47.3105 c=0
Rl51 (\2\:mout \4\:mout) resistor r=128.08 c=0
Rl50 (\2\:mout \3\:mout) resistor r=71.5271 c=0
Rl53 (\5\:CKbb \6\:CKbb) resistor r=24.7951 c=0
Rl54 (\6\:CKbb \7\:CKbb) resistor r=193.774 c=0
Rl36 (\3\:CKbb \4\:CKbb) resistor r=29.5379 c=0
Rl35 (CKbb \2\:CKbb) resistor r=29.4849 c=0
Rl45 (\2\:n20 \3\:n20) resistor r=55.7471 c=0
Rl46 (\2\:n20 \4\:n20) resistor r=82.3738 c=0
Rl44 (n20 \2\:n20) resistor r=48.0022 c=0
Rz20 (\2\:VSS \1\:VSS) resistor r=75 c=0
Rz21 (\17\:VSS \16\:VSS) resistor r=75 c=0
Rz22 (\19\:VSS \18\:VSS) resistor r=75 c=0
Rz23 (\21\:VSS \20\:VSS) resistor r=75 c=0
Rz29 (\4\:VDD \3\:VDD) resistor r=25 c=0
Rz30 (\11\:VDD \3\:VDD) resistor r=6.25 c=0
Rz31 (\18\:VDD \3\:VDD) resistor r=6.25 c=0
Rz32 (\22\:VDD \3\:VDD) resistor r=6.25 c=0
Rz12 (\11\:n35 \10\:n35) resistor r=75 c=0
Rz7 (\9\:RNb \10\:RNb) resistor r=75 c=0
Rz8 (n42 \2\:n42) resistor r=75 c=0
Rz9 (\3\:n42 \4\:n42) resistor r=75 c=0
Rz10 (n40 \2\:n40) resistor r=75 c=0
Rz11 (\3\:n40 \4\:n40) resistor r=75 c=0
Rz19 (\14\:CKb \15\:CKb) resistor r=75 c=0
Rz15 (\10\:mout \11\:mout) resistor r=75 c=0
Rz16 (\14\:mout \15\:mout) resistor r=75 c=0
Rz18 (\13\:CKbb \14\:CKbb) resistor r=75 c=0
Rz13 (n25 \2\:n25) resistor r=75 c=0
Rz14 (\3\:n25 \4\:n25) resistor r=75 c=0
Rz17 (\9\:n20 \10\:n20) resistor r=75 c=0
Ry16 (\4\:VSS \3\:VSS) resistor r=20.6667 c=0
Ry17 (\6\:VSS \3\:VSS) resistor r=5.1667 c=0
Ry18 (\8\:VSS \3\:VSS) resistor r=5.1667 c=0
Ry19 (\10\:VSS \3\:VSS) resistor r=5.1667 c=0
Ry20 (\2\:VDD \1\:VDD) resistor r=62 c=0
Ry21 (\7\:VDD \6\:VDD) resistor r=62 c=0
Ry22 (\10\:VDD \9\:VDD) resistor r=62 c=0
Ry23 (\14\:VDD \13\:VDD) resistor r=62 c=0
Ry24 (\17\:VDD \16\:VDD) resistor r=62 c=0
Ry25 (\21\:VDD \20\:VDD) resistor r=62 c=0
Ry10 (\15\:n35 \14\:n35) resistor r=62 c=0
Ry7 (\7\:RNb \8\:RNb) resistor r=62 c=0
Ry15 (\12\:CKb \13\:CKb) resistor r=62 c=0
Ry11 (\7\:mout \8\:mout) resistor r=62 c=0
Ry12 (\12\:mout \13\:mout) resistor r=62 c=0
Ry14 (\16\:CKbb \17\:CKbb) resistor r=62 c=0
Ry13 (\5\:n20 \6\:n20) resistor r=62 c=0
Ry8 (n41 \2\:n41) resistor r=62 c=0
Ry9 (\3\:n41 \4\:n41) resistor r=62 c=0
Rx6 (\5\:SN \7\:SN) resistor r=45 c=0
Rx7 (\2\:SN \8\:SN) resistor r=45 c=0
Rx3 (\2\:RN \4\:RN) resistor r=45 c=0
Rx18 (\2\:CK \4\:CK) resistor r=45 c=0
Rx10 (\1\:D \5\:D) resistor r=45 c=0
Rx1 (\25\:qbint \24\:qbint) resistor r=45 c=0
Rx2 (\37\:qbint qbint) resistor r=45 c=0
Rx5 (\13\:n35 n35) resistor r=45 c=0
Rx4 (\2\:RNb \6\:RNb) resistor r=45 c=0
Rx14 (\9\:CKb \16\:CKb) resistor r=45 c=0
Rx15 (CKb \19\:CKb) resistor r=45 c=0
Rx16 (\8\:CKb \20\:CKb) resistor r=45 c=0
Rx17 (\6\:CKb \21\:CKb) resistor r=45 c=0
Rx8 (\3\:mout \5\:mout) resistor r=45 c=0
Rx11 (\6\:CKbb \8\:CKbb) resistor r=45 c=0
Rx12 (\2\:CKbb \11\:CKbb) resistor r=45 c=0
Rx13 (\4\:CKbb \15\:CKbb) resistor r=45 c=0
Rx9 (n20 \8\:n20) resistor r=45 c=0
mn55_1__rcx (Q qbint \10\:VSS VSS) g45n1lvt w=(2.95e-07) l=4.5e-08 nf=1 \
        as=4.69e-14 ad=4.636e-14 ps=9.1e-07 pd=9.0429e-07 nrd=1.16667 \
        nrs=1.16667 sa=1.4e-07 sb=1.92051e-06 sd=160n sca=16.4223 \
        scb=0.0158966 scc=0.0014413 m=(7)
mn45_1__rcx (\26\:qbint n35 \10\:VSS VSS) g45n1lvt w=(2.6e-07) l=4.5e-08 \
        nf=1 as=4.623e-14 ad=4.81e-14 ps=8.9e-07 pd=8.9e-07 nrd=1.16667 \
        nrs=1.16667 sa=1.575e-06 sb=6.65e-07 sd=160n sca=17.5885 \
        scb=0.0172826 scc=0.00162584 m=(3)
mn22 (\9\:RNb \1\:RN \20\:VSS VSS) g45n1lvt w=(1.45e-07) l=4.5e-08 nf=1 \
        as=8.755e-14 ad=2.03e-14 ps=1.57e-06 pd=5.7e-07 nrd=1.16667 \
        nrs=1.16667 sa=1.4e-07 sb=9.3e-07 sd=160n sca=11.9911 \
        scb=0.0120555 scc=0.000498628 m=(1)
mn21 (\13\:CKbb \10\:CKb \16\:VSS VSS) g45n1lvt w=(1.45e-07) l=4.5e-08 \
        nf=1 as=7.795e-14 ad=2.03e-14 ps=1.5e-06 pd=5.7e-07 nrd=1.16667 \
        nrs=1.16667 sa=1.40345e-06 sb=1.4e-07 sd=160n sca=16.2011 \
        scb=0.0172667 scc=0.0012292 m=(1)
mn20 (\14\:CKb \1\:CK \1\:VSS VSS) g45n1lvt w=(1.45e-07) l=4.5e-08 nf=1 \
        as=4.065e-14 ad=2.03e-14 ps=1.34e-06 pd=5.7e-07 nrd=1.16667 \
        nrs=1.16667 sa=1.4e-07 sb=1e-07 sd=160n sca=13.6097 scb=0.014254 \
        scc=0.000755054 m=(1)
mn50 (n42 \3\:SN \20\:VSS VSS) g45n1lvt w=(2.05e-07) l=4.5e-08 nf=1 \
        as=8.755e-14 ad=3.28e-14 ps=1.57e-06 pd=7.3e-07 nrd=1.16667 \
        nrs=1.16667 sa=3.99878e-07 sb=5.75e-07 sd=160n sca=10.7727 \
        scb=0.0101457 scc=0.000373012 m=(1)
mn52 (\3\:n40 \22\:qbint n42 VSS) g45n1lvt w=(2.05e-07) l=4.5e-08 nf=1 \
        as=3.28e-14 ad=3.28e-14 ps=7.3e-07 pd=7.3e-07 nrd=1.16667 \
        nrs=1.16667 sa=6.04878e-07 sb=3.7e-07 sd=160n sca=10.7727 \
        scb=0.0101457 scc=0.000373012 m=(1)
mn51 (\3\:n40 \4\:RNb \3\:n42 VSS) g45n1lvt w=(2.05e-07) l=4.5e-08 nf=1 \
        as=3.382e-14 ad=3.28e-14 ps=7.4e-07 pd=7.3e-07 nrd=1.16667 \
        nrs=1.16667 sa=8.09878e-07 sb=1.65e-07 sd=160n sca=10.7727 \
        scb=0.0101457 scc=0.000373012 m=(1)
mn53 (\10\:n35 \3\:CKb n40 VSS) g45n1lvt w=(2.05e-07) l=4.5e-08 nf=1 \
        as=4.305e-14 ad=3.28e-14 ps=8.3e-07 pd=7.3e-07 nrd=1.16667 \
        nrs=1.16667 sa=2.1e-07 sb=3.75e-07 sd=160n sca=10.7727 \
        scb=0.0101457 scc=0.000373012 m=(1)
mn40 (\10\:n35 \3\:CKbb \10\:mout VSS) g45n1lvt w=(2.05e-07) l=4.5e-08 \
        nf=1 as=3.485e-14 ad=3.28e-14 ps=7.5e-07 pd=7.3e-07 nrd=1.16667 \
        nrs=1.16667 sa=4.15e-07 sb=1.7e-07 sd=160n sca=10.7727 \
        scb=0.0101457 scc=0.000373012 m=(1)
mn31 (\14\:mout \5\:RNb \3\:n25 VSS) g45n1lvt w=(2.05e-07) l=4.5e-08 nf=1 \
        as=4.305e-14 ad=3.28e-14 ps=8.3e-07 pd=7.3e-07 nrd=1.16667 \
        nrs=1.16667 sa=2.1e-07 sb=1.79963e-06 sd=160n sca=11.2689 \
        scb=0.0108709 scc=0.000440973 m=(1)
mn32 (\14\:mout \4\:n20 n25 VSS) g45n1lvt w=(2.05e-07) l=4.5e-08 nf=1 \
        as=5.33e-14 ad=3.28e-14 ps=9.3e-07 pd=7.3e-07 nrd=1.16667 \
        nrs=1.16667 sa=4.15e-07 sb=1.59463e-06 sd=160n sca=11.2689 \
        scb=0.0108709 scc=0.000440973 m=(1)
mn30 (n25 \6\:SN \18\:VSS VSS) g45n1lvt w=(2.05e-07) l=4.5e-08 nf=1 \
        as=6.867e-14 ad=5.33e-14 ps=1.08e-06 pd=9.3e-07 nrd=1.16667 \
        nrs=1.16667 sa=7.2e-07 sb=1.28963e-06 sd=160n sca=11.2689 \
        scb=0.0108709 scc=0.000440973 m=(1)
mn35 (n30 \4\:mout \18\:VSS VSS) g45n1lvt w=(2.05e-07) l=4.5e-08 nf=1 \
        as=6.867e-14 ad=3.177e-14 ps=1.08e-06 pd=7.2e-07 nrd=1.16667 \
        nrs=1.16667 sa=1.1e-06 sb=9.09634e-07 sd=160n sca=11.2689 \
        scb=0.0108709 scc=0.000440973 m=(1)
mn36 (\9\:n20 \7\:CKbb n30 VSS) g45n1lvt w=(2.05e-07) l=4.5e-08 nf=1 \
        as=3.177e-14 ad=4.51e-14 ps=7.2e-07 pd=8.5e-07 nrd=1.16667 \
        nrs=1.16667 sa=1.3e-06 sb=7.09634e-07 sd=160n sca=11.2689 \
        scb=0.0108709 scc=0.000440973 m=(1)
mn26 (\9\:n20 \7\:CKb n21 VSS) g45n1lvt w=(2.05e-07) l=4.5e-08 nf=1 \
        as=2.357e-14 ad=4.51e-14 ps=6.4e-07 pd=8.5e-07 nrd=1.16667 \
        nrs=1.16667 sa=1.565e-06 sb=4.44634e-07 sd=160n sca=11.2689 \
        scb=0.0108709 scc=0.000440973 m=(1)
mn25 (n21 \3\:D \16\:VSS VSS) g45n1lvt w=(2.05e-07) l=4.5e-08 nf=1 \
        as=7.795e-14 ad=2.357e-14 ps=1.5e-06 pd=6.4e-07 nrd=1.16667 \
        nrs=1.16667 sa=1.725e-06 sb=2.84634e-07 sd=160n sca=11.2689 \
        scb=0.0108709 scc=0.000440973 m=(1)
mp45_1__rcx (\26\:qbint n35 \22\:VDD VDD) g45p1lvt w=(3.9e-07) l=4.5e-08 \
        nf=1 as=6.423e-14 ad=5.62e-14 ps=1.13667e-06 pd=1.08667e-06 \
        nrd=1.16667 nrs=1.16667 sa=1.575e-06 sb=5.22308e-07 sd=160n \
        sca=18.3796 scb=0.0159892 scc=0.00159615 m=(3)
mp22 (\7\:RNb \3\:RN \20\:VDD VDD) g45p1lvt w=(2.15e-07) l=4.5e-08 nf=1 \
        as=1.1155e-13 ad=2.63e-14 ps=2.55e-06 pd=7.1e-07 nrd=1.16667 \
        nrs=1.16667 sa=1.22326e-07 sb=3.27209e-07 sd=160n sca=45.7906 \
        scb=0.0283307 scc=0.00588417 m=(1)
mp21 (\16\:CKbb \11\:CKb \6\:VDD VDD) g45p1lvt w=(2.15e-07) l=4.5e-08 \
        nf=1 as=4.39e-14 ad=3.01e-14 ps=9.4e-07 pd=7.1e-07 nrd=1.16667 \
        nrs=1.16667 sa=1.79558e-06 sb=1.4e-07 sd=160n sca=15.5686 \
        scb=0.0151127 scc=0.000885455 m=(1)
mp20 (\12\:CKb \3\:CK \1\:VDD VDD) g45p1lvt w=(2.15e-07) l=4.5e-08 nf=1 \
        as=3.01e-14 ad=3.44e-14 ps=7.1e-07 pd=7.5e-07 nrd=1.16667 \
        nrs=1.16667 sa=1.6e-07 sb=1.4e-07 sd=160n sca=15.5771 \
        scb=0.0149239 scc=0.000232429 m=(1)
mp50 (\3\:n41 \1\:SN \20\:VDD VDD) g45p1lvt w=(3.1e-07) l=4.5e-08 nf=1 \
        as=1.1155e-13 ad=5.89e-14 ps=2.55e-06 pd=1e-06 nrd=1.16667 \
        nrs=1.16667 sa=1.86774e-07 sb=4.84839e-07 sd=160n sca=16.8851 \
        scb=0.0157945 scc=0.0012748 m=(1)
mp52 (n43 \23\:qbint \3\:n41 VDD) g45p1lvt w=(3.1e-07) l=4.5e-08 nf=1 \
        as=5.89e-14 ad=2.325e-14 ps=1e-06 pd=7.7e-07 nrd=1.16667 \
        nrs=1.16667 sa=4.21774e-07 sb=2.49839e-07 sd=160n sca=16.8851 \
        scb=0.0157945 scc=0.0012748 m=(1)
mp51 (n43 \3\:RNb \16\:VDD VDD) g45p1lvt w=(3.1e-07) l=4.5e-08 nf=1 \
        as=4.985e-14 ad=2.325e-14 ps=1.35e-06 pd=7.7e-07 nrd=1.16667 \
        nrs=1.16667 sa=5.41774e-07 sb=1.29839e-07 sd=160n sca=16.8851 \
        scb=0.0157945 scc=0.0012748 m=(1)
mp53 (\14\:n35 CKbb n41 VDD) g45p1lvt w=(3.1e-07) l=4.5e-08 nf=1 \
        as=4.9e-14 ad=5.115e-14 ps=1.12e-06 pd=9.5e-07 nrd=1.16667 \
        nrs=1.16667 sa=1.58065e-07 sb=4.65e-07 sd=160n sca=33.4558 \
        scb=0.0229674 scc=0.00395167 m=(1)
mp40 (\14\:n35 \4\:CKb \7\:mout VDD) g45p1lvt w=(3.1e-07) l=4.5e-08 nf=1 \
        as=7.905e-14 ad=5.115e-14 ps=1.13e-06 pd=9.5e-07 nrd=1.16667 \
        nrs=1.16667 sa=3.68065e-07 sb=2.55e-07 sd=160n sca=33.4558 \
        scb=0.0229674 scc=0.00395167 m=(1)
mp31 (n26 RNb \13\:VDD VDD) g45p1lvt w=(3.1e-07) l=4.5e-08 nf=1 \
        as=8.39e-14 ad=2.79e-14 ps=1.48e-06 pd=8e-07 nrd=1.16667 \
        nrs=1.16667 sa=1.7e-07 sb=1.17855e-06 sd=160n sca=35.6995 \
        scb=0.0234062 scc=0.00420468 m=(1)
mp32 (\12\:mout \3\:n20 n26 VDD) g45p1lvt w=(3.1e-07) l=4.5e-08 nf=1 \
        as=2.79e-14 ad=8.54e-14 ps=8e-07 pd=1.54e-06 nrd=1.16667 \
        nrs=1.16667 sa=3.05e-07 sb=1.04355e-06 sd=160n sca=35.6995 \
        scb=0.0234062 scc=0.00420468 m=(1)
mp30 (\12\:mout \4\:SN \9\:VDD VDD) g45p1lvt w=(3.1e-07) l=4.5e-08 nf=1 \
        as=1.0385e-13 ad=8.54e-14 ps=1.29e-06 pd=1.54e-06 nrd=1.16667 \
        nrs=1.16667 sa=4.36774e-07 sb=1.27492e-06 sd=160n sca=13.6224 \
        scb=0.0125368 scc=0.000630866 m=(1)
mp35 (n31 mout \9\:VDD VDD) g45p1lvt w=(3.1e-07) l=4.5e-08 nf=1 \
        as=1.0385e-13 ad=4.185e-14 ps=1.29e-06 pd=8.9e-07 nrd=1.16667 \
        nrs=1.16667 sa=8.16774e-07 sb=8.94919e-07 sd=160n sca=13.6224 \
        scb=0.0125368 scc=0.000630866 m=(1)
mp36 (\5\:n20 \5\:CKb n31 VDD) g45p1lvt w=(3.1e-07) l=4.5e-08 nf=1 \
        as=4.185e-14 ad=7.44e-14 ps=8.9e-07 pd=1.1e-06 nrd=1.16667 \
        nrs=1.16667 sa=9.96774e-07 sb=7.14919e-07 sd=160n sca=13.6224 \
        scb=0.0125368 scc=0.000630866 m=(1)
mp26 (\5\:n20 \5\:CKbb n22 VDD) g45p1lvt w=(3.1e-07) l=4.5e-08 nf=1 \
        as=3.565e-14 ad=7.44e-14 ps=8.5e-07 pd=1.1e-06 nrd=1.16667 \
        nrs=1.16667 sa=1.28177e-06 sb=4.29919e-07 sd=160n sca=13.6224 \
        scb=0.0125368 scc=0.000630866 m=(1)
mp25 (n22 \4\:D \6\:VDD VDD) g45p1lvt w=(3.1e-07) l=4.5e-08 nf=1 \
        as=4.39e-14 ad=3.565e-14 ps=9.4e-07 pd=8.5e-07 nrd=1.16667 \
        nrs=1.16667 sa=1.44177e-06 sb=2.69919e-07 sd=160n sca=13.6224 \
        scb=0.0125368 scc=0.000630866 m=(1)
ends DFFSRHQX8
// End of subcircuit definition.
