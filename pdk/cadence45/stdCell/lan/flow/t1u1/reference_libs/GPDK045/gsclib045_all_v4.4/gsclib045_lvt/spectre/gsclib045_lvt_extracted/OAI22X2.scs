// Generated for: spectre (May  1 09:18:14 2013 )
// Library name: gsclib045_lvt
// Cell name: OAI22X2
// View name: extracted

simulator lang=spectre

subckt OAI22X2 A0 A1 B0 B1 VDD VSS Y
mp0_1__rcx (2 \1\:A0 \8\:VDD VDD) g45p1lvt w=(3.9e-07) l=4.5e-08 nf=1 \
        as=5.46e-14 ad=2.34e-14 ps=1.06e-06 pd=9e-07 nrd=1.16667 \
        nrs=1.16667 sa=1.4e-07 sb=1.445e-06 sd=160n sca=19.9512 \
        scb=0.0180582 scc=0.00139447 m=(1)
mp1_1__rcx (\9\:Y \5\:A1 2 VDD) g45p1lvt w=(3.9e-07) l=4.5e-08 nf=1 \
        as=2.34e-14 ad=6.24e-14 ps=9e-07 pd=1.1e-06 nrd=1.16667 \
        nrs=1.16667 sa=2.45e-07 sb=1.34e-06 sd=160n sca=18.8244 \
        scb=0.0164205 scc=0.00138121 m=(1)
mp1 (\9\:Y \1\:A1 3 VDD) g45p1lvt w=(3.9e-07) l=4.5e-08 nf=1 as=2.34e-14 \
        ad=6.24e-14 ps=9e-07 pd=1.1e-06 nrd=1.16667 nrs=1.16667 sa=4.5e-07 \
        sb=1.135e-06 sd=160n sca=17.7255 scb=0.0154354 scc=0.00137898 \
        m=(1)
mp0 (3 \4\:A0 \5\:VDD VDD) g45p1lvt w=(3.9e-07) l=4.5e-08 nf=1 \
        as=6.24e-14 ad=2.34e-14 ps=1.1e-06 pd=9e-07 nrd=1.16667 \
        nrs=1.16667 sa=5.55e-07 sb=1.03e-06 sd=160n sca=17.42 \
        scb=0.0153123 scc=0.00137893 m=(1)
mp2_1__rcx (6 \4\:B0 \5\:VDD VDD) g45p1lvt w=(3.9e-07) l=4.5e-08 nf=1 \
        as=6.24e-14 ad=7.995e-14 ps=1.1e-06 pd=1.19e-06 nrd=1.16667 \
        nrs=1.16667 sa=7.6e-07 sb=8.25e-07 sd=160n sca=17.3286 \
        scb=0.0152882 scc=0.00137893 m=(1)
mp3_1__rcx (\1\:Y \5\:B1 6 VDD) g45p1lvt w=(3.9e-07) l=4.5e-08 nf=1 \
        as=7.995e-14 ad=6.24e-14 ps=1.19e-06 pd=1.1e-06 nrd=1.16667 \
        nrs=1.16667 sa=1.01e-06 sb=5.75e-07 sd=160n sca=18.1728 \
        scb=0.0157393 scc=0.00137928 m=(1)
mp3 (\1\:Y \1\:B1 4 VDD) g45p1lvt w=(3.9e-07) l=4.5e-08 nf=1 as=2.34e-14 \
        ad=6.24e-14 ps=9e-07 pd=1.1e-06 nrd=1.16667 nrs=1.16667 \
        sa=1.215e-06 sb=3.7e-07 sd=160n sca=19.9512 scb=0.0180582 \
        scc=0.00139447 m=(1)
mp2 (4 \7\:B0 \1\:VDD VDD) g45p1lvt w=(3.9e-07) l=4.5e-08 nf=1 \
        as=1.0335e-13 ad=2.34e-14 ps=1.31e-06 pd=9e-07 nrd=1.16667 \
        nrs=1.16667 sa=1.32e-06 sb=2.65e-07 sd=160n sca=22.0353 \
        scb=0.0216797 scc=0.00148017 m=(1)
C1 (B1 VSS) capacitor c=7.20282e-17
C2 (A0 VSS) capacitor c=3.40637e-16
C3 (VDD VSS) capacitor c=8.80224e-17
C4 (B0 VSS) capacitor c=3.56028e-16
C5 (A1 VSS) capacitor c=5.92899e-17
C6 (Y VSS) capacitor c=1.60776e-17
C7 (net102 VSS) capacitor c=1.02053e-16
C8 (3 VSS) capacitor c=2.01268e-18
C9 (6 VSS) capacitor c=6.17026e-18
C10 (\7\:B0 VSS) capacitor c=7.92154e-17
C11 (\1\:B1 VSS) capacitor c=5.68933e-17
C12 (\5\:B1 VSS) capacitor c=3.80654e-17
C13 (\4\:B0 VSS) capacitor c=4.6036e-17
C14 (\4\:A0 VSS) capacitor c=9.13527e-17
C15 (\1\:A1 VSS) capacitor c=7.79791e-17
C16 (\5\:A1 VSS) capacitor c=5.78284e-17
C17 (\1\:A0 VSS) capacitor c=9.19065e-17
C18 (\2\:B1 VSS) capacitor c=3.66886e-17
C19 (\2\:A1 VSS) capacitor c=2.20909e-17
C20 (\1\:VDD VSS) capacitor c=5.3308e-17
C21 (\1\:Y VSS) capacitor c=7.02158e-17
C22 (\5\:VDD VSS) capacitor c=3.7308e-17
C23 (\9\:Y VSS) capacitor c=5.38247e-17
C24 (\8\:VDD VSS) capacitor c=2.76443e-17
C25 (\7\:net102 VSS) capacitor c=7.70496e-17
C26 (\5\:Y VSS) capacitor c=2.1165e-16
C27 (\3\:A1 VSS) capacitor c=1.14293e-16
C28 (\3\:B1 VSS) capacitor c=9.34611e-17
C29 (\7\:A1 VSS) capacitor c=5.47852e-17
C30 (\4\:Y VSS) capacitor c=6.30503e-17
C31 (\7\:B1 VSS) capacitor c=4.50348e-17
C32 (\2\:net102 VSS) capacitor c=1.59511e-16
C33 (\4\:VDD VSS) capacitor c=3.50682e-17
C34 (\7\:VDD VSS) capacitor c=1.45284e-17
Rk13 (B1 \7\:B1) resistor r=0.2077 c=0
Rk25 (\3\:VSS VSS) resistor r=0.09729 c=0
Rk18 (\2\:VDD \4\:VDD) resistor r=0.7822 c=0
Rk19 (\4\:VDD \6\:VDD) resistor r=0.3023 c=0
Rk22 (\7\:VDD VDD) resistor r=0.1299 c=0
Rk20 (\4\:VDD \7\:VDD) resistor r=0.3211 c=0
Rk21 (\7\:VDD \9\:VDD) resistor r=0.2562 c=0
Rk1 (\7\:A1 A1) resistor r=0.2826 c=0
Rk4 (\2\:Y \3\:Y) resistor r=0.1395 c=0
Rk8 (\4\:Y Y) resistor r=0.04356 c=0
Rk6 (\4\:Y \5\:Y) resistor r=0.4825 c=0
Rk5 (\3\:Y \4\:Y) resistor r=0.3433 c=0
Rk9 (Y \10\:Y) resistor r=0.1577 c=0
Rk10 (\10\:Y \11\:Y) resistor r=0.1395 c=0
Rl14 (\2\:B1 \1\:B1) resistor r=21.9779 c=0
Rl17 (\2\:B1 \5\:B1) resistor r=77.1158 c=0
Rl15 (\3\:B1 \2\:B1) resistor r=65.8294 c=0
Rl8 (A0 \4\:A0) resistor r=104.827 c=0
Rl1 (A0 \1\:A0) resistor r=151.489 c=0
Rl20 (B0 \7\:B0) resistor r=95.3297 c=0
Rl13 (B0 \4\:B0) resistor r=52.7257 c=0
Rl3 (\2\:A1 \1\:A1) resistor r=84.7158 c=0
Rl6 (\2\:A1 \5\:A1) resistor r=36.8321 c=0
Rl4 (\3\:A1 \2\:A1) resistor r=3.2713 c=0
Rz6 (\2\:net102 \7\:net102) resistor r=75 c=0
Rz3 (\2\:net102 net102) resistor r=75 c=0
Ry5 (\1\:VDD \2\:VDD) resistor r=20.6667 c=0
Ry6 (\5\:VDD \6\:VDD) resistor r=62 c=0
Ry7 (\8\:VDD \9\:VDD) resistor r=62 c=0
Ry1 (\2\:Y \1\:Y) resistor r=62 c=0
Ry2 (\3\:Y \1\:Y) resistor r=62 c=0
Ry3 (\10\:Y \9\:Y) resistor r=62 c=0
Ry4 (\11\:Y \9\:Y) resistor r=62 c=0
Rx6 (\7\:B1 \2\:B1) resistor r=45 c=0
Rx1 (\7\:A1 \2\:A1) resistor r=45 c=0
mn0_1__rcx (\2\:net102 A0 \3\:VSS VSS) g45n1lvt w=(2.6e-07) l=4.5e-08 \
        nf=1 as=4.55e-14 ad=4.225e-14 ps=8.7e-07 pd=8.45e-07 nrd=1.16667 \
        nrs=1.16667 sa=1.55e-07 sb=1.615e-06 sd=160n sca=9.14564 \
        scb=0.00759168 scc=0.000213449 m=(2)
mn3_1__rcx (\5\:Y \3\:B1 \7\:net102 VSS) g45n1lvt w=(2.6e-07) l=4.5e-08 \
        nf=1 as=4.16e-14 ad=4.16e-14 ps=8.4e-07 pd=8.4e-07 nrd=1.16667 \
        nrs=1.16667 sa=1.22e-06 sb=5.5e-07 sd=160n sca=9.14564 \
        scb=0.00759168 scc=0.000213449 m=(2)
mn1 (net102 \3\:A1 \3\:VSS VSS) g45n1lvt w=(2.6e-07) l=4.5e-08 nf=1 \
        as=4.55e-14 ad=4.16e-14 ps=8.7e-07 pd=8.4e-07 nrd=1.16667 \
        nrs=1.16667 sa=3.75e-07 sb=1.395e-06 sd=160n sca=9.14564 \
        scb=0.00759168 scc=0.000213449 m=(2)
mn2_1__rcx (\5\:Y B0 \2\:net102 VSS) g45n1lvt w=(2.6e-07) l=4.5e-08 nf=1 \
        as=4.03e-14 ad=4.16e-14 ps=8.3e-07 pd=8.4e-07 nrd=1.16667 \
        nrs=1.16667 sa=1.015e-06 sb=7.55e-07 sd=160n sca=9.14564 \
        scb=0.00759168 scc=0.000213449 m=(2)
ends OAI22X2
// End of subcircuit definition.
