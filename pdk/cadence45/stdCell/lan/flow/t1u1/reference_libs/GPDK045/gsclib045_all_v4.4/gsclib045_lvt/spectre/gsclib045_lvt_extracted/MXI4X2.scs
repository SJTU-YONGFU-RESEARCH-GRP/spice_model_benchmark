// Generated for: spectre (May  1 09:16:22 2013 )
// Library name: gsclib045_lvt
// Cell name: MXI4X2
// View name: extracted

simulator lang=spectre

subckt MXI4X2 A B C D S0 S1 VDD VSS Y
mp0 (\19\:S0b \1\:S0 \18\:VDD VDD) g45p1lvt w=(2.15e-07) l=4.5e-08 nf=1 \
        as=3.44e-14 ad=3.01e-14 ps=7.5e-07 pd=7.1e-07 nrd=1.16667 \
        nrs=1.16667 sa=1.4e-07 sb=2e-06 sd=160n sca=15.6555 scb=0.0150784 \
        scc=0.000248672 m=(1)
mp2 (net296 \1\:A \18\:VDD VDD) g45p1lvt w=(2.15e-07) l=4.5e-08 nf=1 \
        as=3.44e-14 ad=1.29e-14 ps=7.5e-07 pd=5.5e-07 nrd=1.16667 \
        nrs=1.16667 sa=3.45e-07 sb=2e-06 sd=160n sca=12.3871 \
        scb=0.00967424 scc=0.000140878 m=(1)
mp3 (\5\:n0 \7\:S0 net296 VDD) g45p1lvt w=(2.15e-07) l=4.5e-08 nf=1 \
        as=1.29e-14 ad=7.525e-14 ps=5.5e-07 pd=1.13e-06 nrd=1.16667 \
        nrs=1.16667 sa=4.5e-07 sb=2e-06 sd=160n sca=11.6786 scb=0.00891131 \
        scc=0.000138523 m=(1)
mp5 (\5\:n0 \3\:S0b net304 VDD) g45p1lvt w=(2.15e-07) l=4.5e-08 nf=1 \
        as=3.117e-14 ad=7.525e-14 ps=7.2e-07 pd=1.13e-06 nrd=1.16667 \
        nrs=1.16667 sa=8.45e-07 sb=1.91826e-06 sd=160n sca=10.718 \
        scb=0.00841932 scc=0.00013813 m=(1)
mp4 (net304 \3\:B \16\:VDD VDD) g45p1lvt w=(2.15e-07) l=4.5e-08 nf=1 \
        as=1.227e-13 ad=3.117e-14 ps=1.81e-06 pd=7.2e-07 nrd=1.16667 \
        nrs=1.16667 sa=1.035e-06 sb=1.75477e-06 sd=160n sca=10.718 \
        scb=0.00841932 scc=0.00013813 m=(1)
mp6 (net312 \1\:C \16\:VDD VDD) g45p1lvt w=(2.15e-07) l=4.5e-08 nf=1 \
        as=1.227e-13 ad=6.88e-14 ps=1.81e-06 pd=1.07e-06 nrd=1.16667 \
        nrs=1.16667 sa=1.5e-06 sb=1.35465e-06 sd=160n sca=10.718 \
        scb=0.00841932 scc=0.00013813 m=(1)
mp7 (\4\:n1 \8\:S0 net312 VDD) g45p1lvt w=(2.15e-07) l=4.5e-08 nf=1 \
        as=6.88e-14 ad=9.783e-14 ps=1.07e-06 pd=1.34e-06 nrd=1.16667 \
        nrs=1.16667 sa=1.865e-06 sb=1.04058e-06 sd=160n sca=10.718 \
        scb=0.00841932 scc=0.00013813 m=(1)
mp9 (\4\:n1 \10\:S0b net320 VDD) g45p1lvt w=(2.15e-07) l=4.5e-08 nf=1 \
        as=5.16e-14 ad=9.782e-14 ps=9.1e-07 pd=1.34e-06 nrd=1.16667 \
        nrs=1.16667 sa=2e-06 sb=6.10349e-07 sd=160n sca=10.718 \
        scb=0.00841932 scc=0.00013813 m=(1)
mp8 (net320 \1\:D \14\:VDD VDD) g45p1lvt w=(2.15e-07) l=4.5e-08 nf=1 \
        as=7.845e-14 ad=5.16e-14 ps=1.92e-06 pd=9.1e-07 nrd=1.16667 \
        nrs=1.16667 sa=2e-06 sb=3.65116e-07 sd=160n sca=10.718 \
        scb=0.00841932 scc=0.00013813 m=(1)
mp10 (net280 n0 \14\:VDD VDD) g45p1lvt w=(2.15e-07) l=4.5e-08 nf=1 \
        as=7.845e-14 ad=4.73e-14 ps=1.92e-06 pd=8.7e-07 nrd=1.16667 \
        nrs=1.16667 sa=4.25349e-07 sb=1.96291e-06 sd=160n sca=23.7894 \
        scb=0.0219499 scc=0.00260958 m=(1)
mp11 (\13\:n2 \3\:S1 net280 VDD) g45p1lvt w=(2.15e-07) l=4.5e-08 nf=1 \
        as=4.73e-14 ad=5.268e-14 ps=8.7e-07 pd=9.2e-07 nrd=1.16667 \
        nrs=1.16667 sa=6.53372e-07 sb=1.76488e-06 sd=160n sca=23.7894 \
        scb=0.0219499 scc=0.00260958 m=(1)
mp13 (\13\:n2 \3\:S1b net284 VDD) g45p1lvt w=(2.15e-07) l=4.5e-08 nf=1 \
        as=5.16e-14 ad=5.267e-14 ps=9.1e-07 pd=9.2e-07 nrd=1.16667 \
        nrs=1.16667 sa=9.02907e-07 sb=1.47488e-06 sd=160n sca=23.7894 \
        scb=0.0219499 scc=0.00260958 m=(1)
mp12 (net284 n1 \3\:VDD VDD) g45p1lvt w=(2.15e-07) l=4.5e-08 nf=1 \
        as=1.6305e-13 ad=5.16e-14 ps=2.71e-06 pd=9.1e-07 nrd=1.16667 \
        nrs=1.16667 sa=1.14814e-06 sb=1.18988e-06 sd=160n sca=23.7894 \
        scb=0.0219499 scc=0.00260958 m=(1)
mp1 (\5\:S1b \6\:S1 \3\:VDD VDD) g45p1lvt w=(2.15e-07) l=4.5e-08 nf=1 \
        as=1.1585e-13 ad=3.01e-14 ps=2.1e-06 pd=7.1e-07 nrd=1.16667 \
        nrs=1.16667 sa=1.64314e-06 sb=1.4e-07 sd=160n sca=48.554 \
        scb=0.0361963 scc=0.00572043 m=(1)
C1 (C VSS) capacitor c=1.1684e-16
C2 (S1 VSS) capacitor c=1.98851e-16
C3 (D VSS) capacitor c=1.14881e-16
C4 (VDD VSS) capacitor c=4.07843e-16
C5 (B VSS) capacitor c=1.32307e-16
C6 (S0 VSS) capacitor c=3.66188e-17
C7 (A VSS) capacitor c=2.41983e-17
C8 (Y VSS) capacitor c=4.6693e-17
C9 (S0b VSS) capacitor c=5.71673e-17
C10 (net349 VSS) capacitor c=9.72303e-19
C11 (n0 VSS) capacitor c=3.087e-17
C12 (net369 VSS) capacitor c=1.35355e-21
C13 (n1 VSS) capacitor c=4.17738e-17
C14 (net377 VSS) capacitor c=1.27379e-17
C15 (net329 VSS) capacitor c=4.37195e-19
C16 (n2 VSS) capacitor c=1.20375e-16
C17 (S1b VSS) capacitor c=4.69876e-17
C18 (net345 VSS) capacitor c=5.09667e-18
C19 (net304 VSS) capacitor c=3.44319e-18
C20 (net312 VSS) capacitor c=3.17899e-18
C21 (net320 VSS) capacitor c=4.09697e-18
C22 (net280 VSS) capacitor c=7.14473e-18
C23 (net284 VSS) capacitor c=8.54713e-18
C24 (\6\:S1 VSS) capacitor c=1.7851e-17
C25 (\3\:S1b VSS) capacitor c=3.98738e-17
C26 (\3\:S1 VSS) capacitor c=2.74018e-17
C27 (\1\:D VSS) capacitor c=4.33872e-17
C28 (\10\:S0b VSS) capacitor c=3.46878e-17
C29 (\8\:S0 VSS) capacitor c=2.73402e-17
C30 (\1\:C VSS) capacitor c=2.56316e-17
C31 (\3\:B VSS) capacitor c=3.48789e-17
C32 (\3\:S0b VSS) capacitor c=3.90959e-17
C33 (\7\:S0 VSS) capacitor c=6.75674e-17
C34 (\1\:A VSS) capacitor c=5.68242e-17
C35 (\1\:S0 VSS) capacitor c=5.02379e-17
C36 (\4\:S1 VSS) capacitor c=2.24267e-17
C37 (\3\:n1 VSS) capacitor c=1.93707e-17
C38 (\1\:S1 VSS) capacitor c=5.40379e-17
C39 (\3\:n0 VSS) capacitor c=4.737e-17
C40 (\3\:D VSS) capacitor c=3.72758e-17
C41 (\10\:S0 VSS) capacitor c=3.19568e-17
C42 (\6\:S0b VSS) capacitor c=1.55299e-17
C43 (\3\:C VSS) capacitor c=7.43396e-17
C44 (\1\:B VSS) capacitor c=6.10987e-17
C45 (\4\:S0 VSS) capacitor c=3.67543e-17
C46 (\3\:A VSS) capacitor c=7.96952e-17
C47 (\3\:S0 VSS) capacitor c=3.02297e-17
C48 (\5\:S1 VSS) capacitor c=2.26821e-17
C49 (\7\:n2 VSS) capacitor c=3.08395e-17
C50 (\2\:n1 VSS) capacitor c=3.98153e-17
C51 (\4\:S1b VSS) capacitor c=3.11565e-17
C52 (\2\:S1 VSS) capacitor c=4.74594e-17
C53 (\2\:S1b VSS) capacitor c=4.44306e-17
C54 (\2\:n0 VSS) capacitor c=3.34026e-17
C55 (\2\:D VSS) capacitor c=3.62069e-17
C56 (\11\:S0b VSS) capacitor c=1.84065e-17
C57 (\11\:S0 VSS) capacitor c=4.29901e-17
C58 (\8\:S0b VSS) capacitor c=4.67802e-17
C59 (\9\:S0b VSS) capacitor c=3.86235e-17
C60 (\9\:S0 VSS) capacitor c=4.0258e-17
C61 (\5\:S0b VSS) capacitor c=3.122e-17
C62 (\7\:S0b VSS) capacitor c=2.16702e-17
C63 (\2\:C VSS) capacitor c=4.39709e-17
C64 (\2\:B VSS) capacitor c=5.42478e-17
C65 (\5\:S0 VSS) capacitor c=6.43642e-17
C66 (\4\:S0b VSS) capacitor c=4.42548e-17
C67 (\6\:S0 VSS) capacitor c=6.491e-17
C68 (\2\:S0b VSS) capacitor c=2.34134e-17
C69 (\2\:A VSS) capacitor c=7.57464e-17
C70 (\2\:S0 VSS) capacitor c=4.26927e-17
C71 (\5\:S1b VSS) capacitor c=4.74432e-17
C72 (\1\:Y VSS) capacitor c=2.87427e-17
C73 (\13\:n2 VSS) capacitor c=1.73422e-16
C74 (\14\:VDD VSS) capacitor c=2.61587e-17
C75 (\4\:n1 VSS) capacitor c=1.35131e-16
C76 (\16\:VDD VSS) capacitor c=2.69191e-17
C77 (\5\:n0 VSS) capacitor c=3.15564e-16
C78 (\18\:VDD VSS) capacitor c=3.55379e-17
C79 (\19\:S0b VSS) capacitor c=6.5957e-17
C80 (\1\:VDD VSS) capacitor c=7.68927e-17
C81 (\7\:S1b VSS) capacitor c=2.1969e-16
C82 (\3\:Y VSS) capacitor c=5.09386e-17
C83 (\10\:n2 VSS) capacitor c=1.37739e-16
C84 (\7\:n1 VSS) capacitor c=2.92738e-17
C85 (\7\:n0 VSS) capacitor c=1.09461e-16
C86 (\15\:S0b VSS) capacitor c=1.07933e-16
C87 (\12\:S0 VSS) capacitor c=8.24141e-17
C88 (\13\:S0 VSS) capacitor c=6.2019e-17
C89 (\4\:A VSS) capacitor c=8.20004e-17
C90 (\12\:S0b VSS) capacitor c=6.86086e-17
C91 (\13\:S0b VSS) capacitor c=9.70066e-17
C92 (\14\:S0b VSS) capacitor c=7.24439e-17
C93 (\17\:S0b VSS) capacitor c=9.27513e-17
C94 (\18\:S0b VSS) capacitor c=2.70389e-17
C95 (\21\:S0b VSS) capacitor c=4.83273e-17
C96 (\22\:S0b VSS) capacitor c=4.08772e-17
C97 (\14\:S0 VSS) capacitor c=1.54711e-17
C98 (\15\:S0 VSS) capacitor c=1.09258e-16
C99 (\16\:S0 VSS) capacitor c=5.98645e-17
C100 (\17\:S0 VSS) capacitor c=8.63368e-17
C101 (\23\:S0b VSS) capacitor c=7.36766e-17
C102 (\24\:S0b VSS) capacitor c=4.8479e-17
C103 (\4\:n0 VSS) capacitor c=2.52564e-16
C104 (\6\:n1 VSS) capacitor c=2.03791e-16
C105 (\9\:n1 VSS) capacitor c=1.64378e-16
C106 (\9\:n2 VSS) capacitor c=1.1931e-16
C107 (\12\:n2 VSS) capacitor c=1.68367e-16
C108 (\7\:S1 VSS) capacitor c=3.02297e-17
C109 (\8\:S1 VSS) capacitor c=2.52952e-16
C110 (\9\:S1b VSS) capacitor c=2.86088e-16
C111 (\10\:S1b VSS) capacitor c=6.02595e-17
C112 (\3\:VDD VSS) capacitor c=8.45914e-17
C113 (\6\:VDD VSS) capacitor c=5.83377e-17
C114 (\7\:VDD VSS) capacitor c=4.89725e-17
C115 (\9\:VDD VSS) capacitor c=1.50181e-17
Rk11 (\4\:C C) resistor r=0.004024 c=0
Rk27 (\7\:S1 S1) resistor r=0.02903 c=0
Rk28 (S1 \8\:S1) resistor r=1.8942 c=0
Rk17 (\4\:D D) resistor r=0.003004 c=0
Rk32 (\2\:VDD \3\:VDD) resistor r=0.04244 c=0
Rk34 (\3\:VDD \5\:VDD) resistor r=0.4212 c=0
Rk35 (\5\:VDD \6\:VDD) resistor r=0.3024 c=0
Rk36 (\6\:VDD \7\:VDD) resistor r=0.8088 c=0
Rk37 (\7\:VDD \8\:VDD) resistor r=0.0901 c=0
Rk39 (\9\:VDD VDD) resistor r=0.1776 c=0
Rk38 (\8\:VDD \9\:VDD) resistor r=0.3735 c=0
Rk42 (\6\:VDD \15\:VDD) resistor r=0.04332 c=0
Rk43 (\7\:VDD \17\:VDD) resistor r=0.07405 c=0
Rk44 (\9\:VDD \19\:VDD) resistor r=0.2547 c=0
Rk4 (\4\:B B) resistor r=0.004054 c=0
Rk2 (\13\:S0 S0) resistor r=0.08435 c=0
Rk1 (\12\:S0 \13\:S0) resistor r=0.2795 c=0
Rk13 (\14\:S0 \15\:S0) resistor r=0.04804 c=0
Rk14 (\15\:S0 \16\:S0) resistor r=0.3039 c=0
Rk15 (\15\:S0 \17\:S0) resistor r=0.6578 c=0
Rk3 (A \4\:A) resistor r=0.03639 c=0
Rk25 (\2\:Y Y) resistor r=0.06314 c=0
Rk26 (Y \4\:Y) resistor r=0.1488 c=0
Rk45 (\2\:VSS \3\:VSS) resistor r=0.04244 c=0
Rk47 (\3\:VSS \5\:VSS) resistor r=0.2682 c=0
Rk48 (\5\:VSS \6\:VSS) resistor r=0.3033 c=0
Rk49 (\6\:VSS \7\:VSS) resistor r=0.7721 c=0
Rk50 (\7\:VSS \8\:VSS) resistor r=0.1277 c=0
Rk52 (\9\:VSS VSS) resistor r=0.1626 c=0
Rk51 (\8\:VSS \9\:VSS) resistor r=0.3886 c=0
Rk55 (\6\:VSS \15\:VSS) resistor r=0.1276 c=0
Rk56 (\7\:VSS \17\:VSS) resistor r=0.07405 c=0
Rk57 (\9\:VSS \19\:VSS) resistor r=0.1384 c=0
Rk5 (\12\:S0b \13\:S0b) resistor r=0.5985 c=0
Rk6 (\13\:S0b \14\:S0b) resistor r=0.2057 c=0
Rk7 (\14\:S0b \16\:S0b) resistor r=0.5189 c=0
Rk8 (\13\:S0b \17\:S0b) resistor r=0.4804 c=0
Rk9 (\14\:S0b \18\:S0b) resistor r=0.05533 c=0
Rk10 (\16\:S0b \20\:S0b) resistor r=0.5874 c=0
Rk12 (\21\:S0b \22\:S0b) resistor r=0.2283 c=0
Rk16 (\23\:S0b \24\:S0b) resistor r=0.1685 c=0
Rk18 (\4\:n0 \6\:n0) resistor r=2.2175 c=0
Rk19 (\6\:n0 \8\:n0) resistor r=0.5216 c=0
Rk20 (\5\:n1 \6\:n1) resistor r=0.742 c=0
Rk21 (\6\:n1 \8\:n1) resistor r=0.2571 c=0
Rk22 (\6\:n1 \9\:n1) resistor r=1.2301 c=0
Rk23 (\9\:n2 \11\:n2) resistor r=0.8101 c=0
Rk24 (\12\:n2 \14\:n2) resistor r=1.0663 c=0
Rk29 (\6\:S1b \8\:S1b) resistor r=0.3648 c=0
Rk30 (\8\:S1b \9\:S1b) resistor r=1.7769 c=0
Rk31 (\9\:S1b \10\:S1b) resistor r=0.3459 c=0
Rl12 (\1\:C \2\:C) resistor r=30.7692 c=0
Rl13 (\2\:C \3\:C) resistor r=176.099 c=0
Rl38 (\5\:S1 \6\:S1) resistor r=24.7951 c=0
Rl37 (\4\:S1 \5\:S1) resistor r=37.8119 c=0
Rl26 (\2\:S1 \3\:S1) resistor r=27.9704 c=0
Rl25 (\1\:S1 \2\:S1) resistor r=101.282 c=0
Rl20 (\1\:D \2\:D) resistor r=100.692 c=0
Rl21 (\2\:D \3\:D) resistor r=104.538 c=0
Rl11 (\2\:B \3\:B) resistor r=26.3736 c=0
Rl10 (\1\:B \2\:B) resistor r=180.769 c=0
Rl18 (\10\:S0 \11\:S0) resistor r=93.4636 c=0
Rl16 (\8\:S0 \9\:S0) resistor r=71.8456 c=0
Rl7 (\4\:S0 \5\:S0) resistor r=83.8482 c=0
Rl9 (\6\:S0 \7\:S0) resistor r=118.464 c=0
Rl8 (\5\:S0 \6\:S0) resistor r=150.528 c=0
Rl1 (\1\:S0 \2\:S0) resistor r=155.769 c=0
Rl2 (\2\:S0 \3\:S0) resistor r=39.1379 c=0
Rl3 (\1\:A \2\:A) resistor r=45.3867 c=0
Rl4 (\2\:A \3\:A) resistor r=156.925 c=0
Rl19 (\10\:S0b \11\:S0b) resistor r=24.2328 c=0
Rl17 (\8\:S0b \9\:S0b) resistor r=122.246 c=0
Rl14 (\5\:S0b \6\:S0b) resistor r=33.8482 c=0
Rl15 (\6\:S0b \7\:S0b) resistor r=43.4636 c=0
Rl6 (\3\:S0b \4\:S0b) resistor r=56.9251 c=0
Rl5 (S0b \2\:S0b) resistor r=66.5405 c=0
Rl22 (n0 \2\:n0) resistor r=29.5379 c=0
Rl23 (\2\:n0 \3\:n0) resistor r=104.538 c=0
Rl28 (n1 \2\:n1) resistor r=106.925 c=0
Rl29 (\2\:n1 \3\:n1) resistor r=78.4003 c=0
Rl35 (\7\:n2 n2) resistor r=46.5267 c=0
Rl27 (\3\:S1b \4\:S1b) resistor r=42.9995 c=0
Rl24 (S1b \2\:S1b) resistor r=28.0211 c=0
Rz7 (\2\:VDD \1\:VDD) resistor r=25 c=0
Rz8 (\5\:VDD \1\:VDD) resistor r=6.25 c=0
Rz9 (\8\:VDD \1\:VDD) resistor r=6.25 c=0
Rz5 (\4\:Y \3\:Y) resistor r=75 c=0
Rz12 (\15\:VSS \14\:VSS) resistor r=37.5 c=0
Rz13 (\17\:VSS \16\:VSS) resistor r=75 c=0
Rz14 (\19\:VSS \18\:VSS) resistor r=37.5 c=0
Rz1 (\15\:S0b \16\:S0b) resistor r=75 c=0
Rz2 (\7\:n0 \8\:n0) resistor r=75 c=0
Rz3 (\7\:n1 \8\:n1) resistor r=75 c=0
Rz4 (\11\:n2 \10\:n2) resistor r=75 c=0
Rz6 (\7\:S1b \8\:S1b) resistor r=75 c=0
Ry9 (\15\:VDD \14\:VDD) resistor r=62 c=0
Ry10 (\17\:VDD \16\:VDD) resistor r=62 c=0
Ry11 (\19\:VDD \18\:VDD) resistor r=62 c=0
Ry5 (\2\:Y \1\:Y) resistor r=62 c=0
Ry12 (\2\:VSS \1\:VSS) resistor r=20.6667 c=0
Ry13 (\5\:VSS \1\:VSS) resistor r=5.1667 c=0
Ry14 (\8\:VSS \1\:VSS) resistor r=5.1667 c=0
Ry1 (\19\:S0b \20\:S0b) resistor r=62 c=0
Ry2 (\5\:n0 \6\:n0) resistor r=62 c=0
Ry3 (\4\:n1 \5\:n1) resistor r=62 c=0
Ry4 (\14\:n2 \13\:n2) resistor r=62 c=0
Ry6 (\5\:S1b \6\:S1b) resistor r=62 c=0
Rx8 (\2\:C \4\:C) resistor r=45 c=0
Rx21 (\5\:S1 \7\:S1) resistor r=45 c=0
Rx22 (\2\:S1 \8\:S1) resistor r=45 c=0
Rx16 (\2\:D \4\:D) resistor r=45 c=0
Rx4 (\2\:B \4\:B) resistor r=45 c=0
Rx1 (\6\:S0 \12\:S0) resistor r=45 c=0
Rx2 (\2\:S0 \13\:S0) resistor r=45 c=0
Rx11 (\9\:S0 \14\:S0) resistor r=45 c=0
Rx12 (\11\:S0 \16\:S0) resistor r=45 c=0
Rx13 (\5\:S0 \17\:S0) resistor r=45 c=0
Rx3 (\2\:A \4\:A) resistor r=45 c=0
Rx5 (\7\:S0b \12\:S0b) resistor r=45 c=0
Rx6 (\4\:S0b \17\:S0b) resistor r=45 c=0
Rx7 (\2\:S0b \18\:S0b) resistor r=45 c=0
Rx9 (\9\:S0b \21\:S0b) resistor r=45 c=0
Rx10 (\5\:S0b \22\:S0b) resistor r=45 c=0
Rx14 (\11\:S0b \23\:S0b) resistor r=45 c=0
Rx15 (\8\:S0b \24\:S0b) resistor r=45 c=0
Rx17 (\2\:n0 \4\:n0) resistor r=45 c=0
Rx18 (\2\:n1 \9\:n1) resistor r=45 c=0
Rx19 (\9\:n2 \7\:n2) resistor r=45 c=0
Rx20 (\12\:n2 n2) resistor r=45 c=0
Rx23 (\4\:S1b \9\:S1b) resistor r=45 c=0
Rx24 (\2\:S1b \10\:S1b) resistor r=45 c=0
mn0 (\15\:S0b \3\:S0 \18\:VSS VSS) g45n1lvt w=(1.45e-07) l=4.5e-08 nf=1 \
        as=7.18e-14 ad=2.03e-14 ps=1.43e-06 pd=5.7e-07 nrd=1.16667 \
        nrs=1.16667 sa=1.4e-07 sb=1.6069e-06 sd=160n sca=13.253 \
        scb=0.0137915 scc=0.000695334 m=(1)
mn2 (net349 \3\:A \18\:VSS VSS) g45n1lvt w=(1.45e-07) l=4.5e-08 nf=1 \
        as=7.18e-14 ad=8.7e-15 ps=1.43e-06 pd=4.1e-07 nrd=1.16667 \
        nrs=1.16667 sa=3.56379e-07 sb=2e-06 sd=160n sca=11.4452 \
        scb=0.0112553 scc=0.00042156 m=(1)
mn3 (\7\:n0 S0b net349 VSS) g45n1lvt w=(1.45e-07) l=4.5e-08 nf=1 \
        as=8.7e-15 ad=6.307e-14 ps=4.1e-07 pd=1.16e-06 nrd=1.16667 \
        nrs=1.16667 sa=4.61379e-07 sb=2e-06 sd=160n sca=11.4452 \
        scb=0.0112553 scc=0.00042156 m=(1)
mn5 (\7\:n0 \4\:S0 net361 VSS) g45n1lvt w=(1.45e-07) l=4.5e-08 nf=1 \
        as=1.957e-14 ad=6.307e-14 ps=5.6e-07 pd=1.16e-06 nrd=1.16667 \
        nrs=1.16667 sa=9.41379e-07 sb=2e-06 sd=160n sca=11.4452 \
        scb=0.0112553 scc=0.00042156 m=(1)
mn4 (net361 \1\:B \16\:VSS VSS) g45n1lvt w=(1.45e-07) l=4.5e-08 nf=1 \
        as=8.045e-14 ad=1.957e-14 ps=1.51e-06 pd=5.6e-07 nrd=1.16667 \
        nrs=1.16667 sa=1.12138e-06 sb=2e-06 sd=160n sca=11.4452 \
        scb=0.0112553 scc=0.00042156 m=(1)
mn6 (net369 \3\:C \16\:VSS VSS) g45n1lvt w=(1.45e-07) l=4.5e-08 nf=1 \
        as=8.045e-14 ad=1.957e-14 ps=1.51e-06 pd=5.6e-07 nrd=1.16667 \
        nrs=1.16667 sa=1.45638e-06 sb=2e-06 sd=160n sca=11.4452 \
        scb=0.0112553 scc=0.00042156 m=(1)
mn7 (\7\:n1 \6\:S0b net369 VSS) g45n1lvt w=(1.45e-07) l=4.5e-08 nf=1 \
        as=1.957e-14 ad=8.337e-14 ps=5.6e-07 pd=1.44e-06 nrd=1.16667 \
        nrs=1.16667 sa=1.63638e-06 sb=2e-06 sd=160n sca=11.4452 \
        scb=0.0112553 scc=0.00042156 m=(1)
mn9 (\7\:n1 \10\:S0 net377 VSS) g45n1lvt w=(1.45e-07) l=4.5e-08 nf=1 \
        as=5.22e-14 ad=8.337e-14 ps=1.01e-06 pd=1.44e-06 nrd=1.16667 \
        nrs=1.16667 sa=2e-06 sb=2e-06 sd=160n sca=11.4452 scb=0.0112553 \
        scc=0.00042156 m=(1)
mn8 (net377 \3\:D \14\:VSS VSS) g45n1lvt w=(1.45e-07) l=4.5e-08 nf=1 \
        as=7.03e-14 ad=5.22e-14 ps=1.37e-06 pd=1.01e-06 nrd=1.16667 \
        nrs=1.16667 sa=2e-06 sb=2e-06 sd=160n sca=11.4452 scb=0.0112553 \
        scc=0.00042156 m=(1)
mn10 (net329 \3\:n0 \14\:VSS VSS) g45n1lvt w=(1.45e-07) l=4.5e-08 nf=1 \
        as=7.03e-14 ad=2.03e-14 ps=1.37e-06 pd=5.7e-07 nrd=1.16667 \
        nrs=1.16667 sa=2e-06 sb=1.94052e-06 sd=160n sca=11.4452 \
        scb=0.0112553 scc=0.00042156 m=(1)
mn11 (\10\:n2 S1b net329 VSS) g45n1lvt w=(1.45e-07) l=4.5e-08 nf=1 \
        as=2.03e-14 ad=2.32e-14 ps=5.7e-07 pd=6.1e-07 nrd=1.16667 \
        nrs=1.16667 sa=2e-06 sb=1.78862e-06 sd=160n sca=11.4452 \
        scb=0.0112553 scc=0.00042156 m=(1)
mn13 (\10\:n2 \1\:S1 net345 VSS) g45n1lvt w=(1.45e-07) l=4.5e-08 nf=1 \
        as=4.35e-14 ad=2.32e-14 ps=8.9e-07 pd=6.1e-07 nrd=1.16667 \
        nrs=1.16667 sa=2e-06 sb=1.58362e-06 sd=160n sca=11.4452 \
        scb=0.0112553 scc=0.00042156 m=(1)
mn12 (net345 \3\:n1 \3\:VSS VSS) g45n1lvt w=(1.45e-07) l=4.5e-08 nf=1 \
        as=1.0648e-13 ad=4.35e-14 ps=1.83e-06 pd=8.9e-07 nrd=1.16667 \
        nrs=1.16667 sa=2e-06 sb=1.23862e-06 sd=160n sca=11.4452 \
        scb=0.0112553 scc=0.00042156 m=(1)
mn1 (\7\:S1b \4\:S1 \3\:VSS VSS) g45n1lvt w=(1.45e-07) l=4.5e-08 nf=1 \
        as=1.1975e-13 ad=2.03e-14 ps=1.83e-06 pd=5.7e-07 nrd=1.16667 \
        nrs=1.16667 sa=9.57069e-07 sb=1.4e-07 sd=160n sca=23.279 \
        scb=0.0230742 scc=0.00267719 m=(1)
mn14 (\3\:Y n2 \3\:VSS VSS) g45n1lvt w=(2.6e-07) l=4.5e-08 nf=1 \
        as=1.1311e-13 ad=4.16e-14 ps=1.83e-06 pd=8.4e-07 nrd=1.16667 \
        nrs=1.16667 sa=1.15962e-06 sb=6.21058e-07 sd=160n sca=17.5885 \
        scb=0.0172826 scc=0.00162584 m=(2)
mp14_1__rcx (\1\:Y n2 \3\:VDD VDD) g45p1lvt w=(3.9e-07) l=4.5e-08 nf=1 \
        as=1.3945e-13 ad=6.24e-14 ps=2.405e-06 pd=1.1e-06 nrd=1.16667 \
        nrs=1.16667 sa=9.64808e-07 sb=5.39551e-07 sd=160n sca=29.0159 \
        scb=0.0199093 scc=0.0031585 m=(2)
ends MXI4X2
// End of subcircuit definition.
