// gsclib045/FSWX1/schematic

simulator lang=spectre

subckt FSWX1 PSO PSO_out VSS VDD ExtVSS
PM1 (PSO_out n0 VDD VDD) g45p1svt w=(1.8u) l=45n nf=4 m=(1)
mp0 (n0 PSO VDD VDD) g45p1svt w=(900n) l=45n nf=2 m=(1)
NM0 (ExtVSS n0 PSO_out ExtVSS) g45n1svt w=(1.2u) l=45n nf=4 m=(1)
mn0 (ExtVSS PSO n0 ExtVSS) g45n1svt w=(600n) l=45n nf=2 m=(1)
NM1 (ExtVSS n0 VSS ExtVSS) g45n1hvt w=(1.2u) l=45n nf=4 m=(20)
ends FSWX1
