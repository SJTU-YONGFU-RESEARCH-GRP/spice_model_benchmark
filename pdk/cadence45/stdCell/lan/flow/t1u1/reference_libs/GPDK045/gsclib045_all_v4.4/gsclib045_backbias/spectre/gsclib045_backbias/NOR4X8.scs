// gsclib045_backbias/NOR4X8/schematic

simulator lang=spectre

subckt NOR4X8 A B C D Y NW VSS VDD
mn2 (Y C VSS VSS) g45n1svt w=(2.065u) l=45n nf=1 m=(1)
mn3 (Y D VSS VSS) g45n1svt w=(2.065u) l=45n nf=1 m=(1)
mn0 (Y A VSS VSS) g45n1svt w=(2.065u) l=45n nf=1 m=(1)
mn1 (Y B VSS VSS) g45n1svt w=(2.065u) l=45n nf=1 m=(1)
mp1 (n1 B n0 NW) g45p1svt w=(3.115u) l=45n nf=1 m=(1)
mp3 (Y D n2 NW) g45p1svt w=(3.115u) l=45n nf=1 m=(1)
mp2 (n2 C n1 NW) g45p1svt w=(3.115u) l=45n nf=1 m=(1)
mp0 (n0 A VDD NW) g45p1svt w=(3.115u) l=45n nf=1 m=(1)
ends NOR4X8
