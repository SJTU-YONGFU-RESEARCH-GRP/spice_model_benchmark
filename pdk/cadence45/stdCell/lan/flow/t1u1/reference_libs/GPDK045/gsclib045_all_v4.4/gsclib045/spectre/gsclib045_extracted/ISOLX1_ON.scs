// Generated for: spectre (May  1 08:11:38 2013 )
// Library name: gsclib045
// Cell name: ISOLX1_ON
// View name: extracted

simulator lang=spectre

subckt ISOLX1_ON A ISO VDD VSS Y
PM1 (\8\:ison \1\:ISO \6\:VDD VDD) g45p1svt w=(2.15e-07) l=4.5e-08 nf=1 \
        as=3.01e-14 ad=3.01e-14 ps=7.1e-07 pd=7.1e-07 nrd=1.16667 \
        nrs=1.16667 sa=1.4e-07 sb=1.4e-07 sd=160n sca=20.0013 \
        scb=0.0219001 scc=0.000764007 m=(1)
mp0 (\5\:n0 \4\:A \8\:VDD VDD) g45p1svt w=(2.15e-07) l=4.5e-08 nf=1 \
        as=3.01e-14 ad=3.44e-14 ps=7.1e-07 pd=7.5e-07 nrd=1.16667 \
        nrs=1.16667 sa=1.4e-07 sb=5.8e-07 sd=160n sca=11.8775 \
        scb=0.00838325 scc=9.33327e-05 m=(1)
mp1 (\5\:n0 ison \1\:VDD VDD) g45p1svt w=(2.15e-07) l=4.5e-08 nf=1 \
        as=6.535e-14 ad=3.44e-14 ps=1.16e-06 pd=7.5e-07 nrd=1.16667 \
        nrs=1.16667 sa=3.45e-07 sb=3.75e-07 sd=160n sca=12.762 \
        scb=0.00989291 scc=0.000101967 m=(1)
C1 (ISO VSS) capacitor c=6.94172e-18
C2 (VDD VSS) capacitor c=1.42521e-16
C3 (Y VSS) capacitor c=1.61556e-17
C4 (A VSS) capacitor c=5.89358e-17
C5 (ison VSS) capacitor c=5.66214e-17
C6 (n0 VSS) capacitor c=4.26845e-17
C7 (\4\:A VSS) capacitor c=3.83064e-17
C8 (\1\:ISO VSS) capacitor c=4.98512e-17
C9 (\4\:n0 VSS) capacitor c=5.01277e-17
C10 (\3\:ison VSS) capacitor c=6.4514e-17
C11 (\1\:A VSS) capacitor c=8.25419e-17
C12 (\4\:ISO VSS) capacitor c=3.12739e-17
C13 (\3\:n0 VSS) capacitor c=1.74087e-17
C14 (\2\:ison VSS) capacitor c=8.14731e-17
C15 (\3\:A VSS) capacitor c=1.56733e-17
C16 (\3\:ISO VSS) capacitor c=1.66344e-17
C17 (\4\:Y VSS) capacitor c=4.90571e-17
C18 (\1\:VDD VSS) capacitor c=7.83604e-17
C19 (\5\:n0 VSS) capacitor c=7.01533e-17
C20 (\8\:VDD VSS) capacitor c=4.51628e-17
C21 (\8\:ison VSS) capacitor c=6.70094e-17
C22 (\6\:VDD VSS) capacitor c=3.71655e-17
C23 (\2\:Y VSS) capacitor c=4.76283e-17
C24 (\8\:n0 VSS) capacitor c=8.88873e-17
C25 (\6\:ison VSS) capacitor c=4.58399e-17
C26 (\2\:ISO VSS) capacitor c=3.63839e-17
C27 (VDD VSS) capacitor c=8.59454e-18
C28 (\2\:A VSS) capacitor c=4.81889e-17
C29 (\2\:n0 VSS) capacitor c=2.96948e-17
C30 (\5\:ISO VSS) capacitor c=1.96393e-17
C31 (\8\:ISO VSS) capacitor c=4.19397e-17
C32 (\7\:A VSS) capacitor c=4.23057e-17
C33 (\4\:ison VSS) capacitor c=7.38452e-17
C34 (\5\:ison VSS) capacitor c=1.02108e-16
C35 (\7\:n0 VSS) capacitor c=1.37066e-16
C36 (\1\:Y VSS) capacitor c=6.19447e-17
C37 (\5\:VDD VSS) capacitor c=1.51244e-17
Rk25 (VSS VSS) resistor r=0.02258 c=0
Rk24 (\2\:VSS VSS) resistor r=0.3837 c=0
Rk27 (VSS \6\:VSS) resistor r=0.4729 c=0
Rk1 (ISO \5\:ISO) resistor r=0.00366 c=0
Rk2 (\6\:ISO ISO) resistor r=0.007154 c=0
Rk3 (\5\:ISO \6\:ISO) resistor r=0.007724 c=0
Rk5 (\6\:ISO \8\:ISO) resistor r=0.01066 c=0
Rk4 (\7\:ISO \8\:ISO) resistor r=0.006988 c=0
Rk19 (VDD VDD) resistor r=0.06272 c=0
Rk18 (\2\:VDD VDD) resistor r=0.4009 c=0
Rk21 (VDD \5\:VDD) resistor r=0.04998 c=0
Rk22 (\5\:VDD \7\:VDD) resistor r=0.4448 c=0
Rk23 (\5\:VDD \9\:VDD) resistor r=0.216 c=0
Rk15 (Y \1\:Y) resistor r=0.01258 c=0
Rk16 (\1\:Y \3\:Y) resistor r=0.3662 c=0
Rk17 (\1\:Y \5\:Y) resistor r=0.3074 c=0
Rk9 (A \7\:A) resistor r=0.02396 c=0
Rk8 (\6\:A \7\:A) resistor r=0.009587 c=0
Rk10 (\4\:ison \5\:ison) resistor r=0.3644 c=0
Rk11 (\5\:ison \7\:ison) resistor r=0.3336 c=0
Rk12 (\5\:ison \9\:ison) resistor r=0.4237 c=0
Rk13 (\6\:n0 \7\:n0) resistor r=0.4915 c=0
Rk14 (\7\:n0 \9\:n0) resistor r=0.6672 c=0
Rl1 (\1\:ISO \2\:ISO) resistor r=207.409 c=0
Rl3 (\2\:ISO \4\:ISO) resistor r=94.9085 c=0
Rl2 (\2\:ISO \3\:ISO) resistor r=5.1123 c=0
Rl6 (\2\:A \4\:A) resistor r=94.4277 c=0
Rl4 (\1\:A \2\:A) resistor r=204.756 c=0
Rl5 (\2\:A \3\:A) resistor r=1.2666 c=0
Rl7 (ison \2\:ison) resistor r=170.329 c=0
Rl8 (\2\:ison \3\:ison) resistor r=114.56 c=0
Rl9 (n0 \2\:n0) resistor r=45.1626 c=0
Rl11 (\2\:n0 \4\:n0) resistor r=158.537 c=0
Rl10 (\2\:n0 \3\:n0) resistor r=1.2666 c=0
Rz5 (\1\:VSS \2\:VSS) resistor r=37.5 c=0
Rz6 (\5\:VSS \6\:VSS) resistor r=75 c=0
Rz3 (\2\:Y \3\:Y) resistor r=37.5 c=0
Rz1 (\6\:ison \7\:ison) resistor r=75 c=0
Rz2 (\8\:n0 \9\:n0) resistor r=75 c=0
Ry4 (\1\:VDD \2\:VDD) resistor r=20.6667 c=0
Ry5 (\6\:VDD \7\:VDD) resistor r=62 c=0
Ry6 (\8\:VDD \9\:VDD) resistor r=62 c=0
Ry3 (\4\:Y \5\:Y) resistor r=20.6667 c=0
Ry1 (\8\:ison \9\:ison) resistor r=62 c=0
Ry2 (\5\:n0 \6\:n0) resistor r=62 c=0
Rx1 (\3\:ISO \7\:ISO) resistor r=45 c=0
Rx2 (\3\:A \6\:A) resistor r=45 c=0
Rx3 (\2\:ison \4\:ison) resistor r=45 c=0
Rx4 (\3\:n0 \7\:n0) resistor r=45 c=0
mn1 (\8\:n0 \1\:A net127 VSS) g45n1svt w=(1.45e-07) l=4.5e-08 nf=1 \
        as=8.7e-15 ad=2.03e-14 ps=4.1e-07 pd=5.7e-07 nrd=1.16667 \
        nrs=1.16667 sa=1.4e-07 sb=4.8e-07 sd=160n sca=7.688 scb=0.00504888 \
        scc=6.29443e-05 m=(1)
NM1 (\5\:VSS \4\:ISO \6\:ison VSS) g45n1svt w=(1.45e-07) l=4.5e-08 nf=1 \
        as=2.03e-14 ad=2.03e-14 ps=5.7e-07 pd=5.7e-07 nrd=1.16667 \
        nrs=1.16667 sa=1.4e-07 sb=1.4e-07 sd=160n sca=6.67224 \
        scb=0.00331168 scc=2.36561e-05 m=(1)
mn0 (net127 \3\:ison \1\:VSS VSS) g45n1svt w=(1.45e-07) l=4.5e-08 nf=1 \
        as=4.365e-14 ad=8.7e-15 ps=9e-07 pd=4.1e-07 nrd=1.16667 \
        nrs=1.16667 sa=2.45e-07 sb=3.75e-07 sd=160n sca=7.688 \
        scb=0.00504888 scc=6.29443e-05 m=(1)
mn2 (\2\:Y \4\:n0 \1\:VSS VSS) g45n1svt w=(2.6e-07) l=4.5e-08 nf=1 \
        as=4.365e-14 ad=3.64e-14 ps=9e-07 pd=8e-07 nrd=1.16667 nrs=1.16667 \
        sa=3.29615e-07 sb=1.4e-07 sd=160n sca=7.96722 scb=0.00567143 \
        scc=0.000107411 m=(1)
mp2 (\4\:Y n0 \1\:VDD VDD) g45p1svt w=(3.9e-07) l=4.5e-08 nf=1 \
        as=5.46e-14 ad=6.535e-14 ps=1.06e-06 pd=1.16e-06 nrd=1.16667 \
        nrs=1.16667 sa=3.82564e-07 sb=1.4e-07 sd=160n sca=20.4693 \
        scb=0.0229089 scc=0.000811692 m=(1)
ends ISOLX1_ON
// End of subcircuit definition.
