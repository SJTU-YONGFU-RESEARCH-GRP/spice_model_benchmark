// Generated for: spectre (May  1 09:12:50 2013 )
// Library name: gsclib045_hvt
// Cell name: AOI222XL
// View name: extracted

simulator lang=spectre

subckt AOI222XL A0 A1 B0 B1 C0 C1 VDD VSS Y
mp0 (\3\:net134 \3\:A0 \7\:VDD VDD) g45p1hvt w=(2.15e-07) l=4.5e-08 nf=1 \
        as=5.44e-14 ad=3.977e-14 ps=1.75e-06 pd=8e-07 nrd=1.16667 \
        nrs=1.16667 sa=1e-07 sb=3.3e-07 sd=160n sca=43.6839 scb=0.0409846 \
        scc=0.00506402 m=(1)
mp1 (\3\:net134 \1\:A1 \5\:VDD VDD) g45p1hvt w=(2.15e-07) l=4.5e-08 nf=1 \
        as=5.44e-14 ad=3.977e-14 ps=1.75e-06 pd=8e-07 nrd=1.16667 \
        nrs=1.16667 sa=3.3e-07 sb=1e-07 sd=160n sca=35.9206 scb=0.0284699 \
        scc=0.00428553 m=(1)
mp3 (\6\:net122 \1\:B1 net134 VDD) g45p1hvt w=(2.15e-07) l=4.5e-08 nf=1 \
        as=3.44e-14 ad=3.01e-14 ps=7.5e-07 pd=7.1e-07 nrd=1.16667 \
        nrs=1.16667 sa=1.4e-07 sb=8.35e-07 sd=160n sca=12.7104 \
        scb=0.0116911 scc=0.00042519 m=(1)
mp2 (net122 \1\:B0 net134 VDD) g45p1hvt w=(2.15e-07) l=4.5e-08 nf=1 \
        as=3.44e-14 ad=4.515e-14 ps=7.5e-07 pd=8.5e-07 nrd=1.16667 \
        nrs=1.16667 sa=3.45e-07 sb=6.3e-07 sd=160n sca=13.1974 \
        scb=0.0118569 scc=0.000425239 m=(1)
mp4 (\1\:Y \1\:C0 net122 VDD) g45p1hvt w=(2.15e-07) l=4.5e-08 nf=1 \
        as=4.515e-14 ad=4.085e-14 ps=8.5e-07 pd=8.1e-07 nrd=1.16667 \
        nrs=1.16667 sa=6e-07 sb=3.75e-07 sd=160n sca=14.7565 scb=0.0134564 \
        scc=0.00043091 m=(1)
mp5 (\1\:Y \1\:C1 \4\:net122 VDD) g45p1hvt w=(2.15e-07) l=4.5e-08 nf=1 \
        as=3.01e-14 ad=4.085e-14 ps=7.1e-07 pd=8.1e-07 nrd=1.16667 \
        nrs=1.16667 sa=8.35e-07 sb=1.4e-07 sd=160n sca=20.3151 \
        scb=0.022841 scc=0.000796775 m=(1)
C1 (C1 VSS) capacitor c=6.92568e-17
C2 (B1 VSS) capacitor c=6.47526e-17
C3 (C0 VSS) capacitor c=8.88402e-17
C4 (A1 VSS) capacitor c=6.00824e-17
C5 (VDD VSS) capacitor c=1.52734e-16
C6 (B0 VSS) capacitor c=3.50694e-17
C7 (A0 VSS) capacitor c=3.96531e-17
C8 (Y VSS) capacitor c=9.19029e-17
C9 (net147 VSS) capacitor c=5.70603e-18
C10 (net155 VSS) capacitor c=3.97139e-18
C11 (net134 VSS) capacitor c=1.0982e-16
C12 (net122 VSS) capacitor c=1.90284e-17
C13 (\1\:C1 VSS) capacitor c=3.2969e-17
C14 (\1\:C0 VSS) capacitor c=6.05328e-17
C15 (\1\:B0 VSS) capacitor c=4.4556e-17
C16 (\1\:B1 VSS) capacitor c=5.32307e-17
C17 (\1\:A1 VSS) capacitor c=4.7029e-17
C18 (\3\:A0 VSS) capacitor c=3.34518e-17
C19 (\3\:C1 VSS) capacitor c=6.13721e-17
C20 (\3\:C0 VSS) capacitor c=3.80588e-17
C21 (\3\:B0 VSS) capacitor c=5.23791e-17
C22 (\3\:B1 VSS) capacitor c=3.415e-17
C23 (\3\:A1 VSS) capacitor c=2.94979e-17
C24 (\1\:A0 VSS) capacitor c=4.11024e-17
C25 (\2\:C1 VSS) capacitor c=4.99567e-17
C26 (\2\:C0 VSS) capacitor c=6.42399e-17
C27 (\2\:B0 VSS) capacitor c=5.32894e-17
C28 (\2\:B1 VSS) capacitor c=4.36694e-17
C29 (\2\:A1 VSS) capacitor c=3.94947e-17
C30 (\2\:A0 VSS) capacitor c=4.17712e-17
C31 (\4\:net122 VSS) capacitor c=5.98756e-17
C32 (\1\:Y VSS) capacitor c=9.62416e-17
C33 (\6\:net122 VSS) capacitor c=6.05483e-17
C34 (\5\:VDD VSS) capacitor c=7.11971e-18
C35 (\3\:net134 VSS) capacitor c=5.04603e-17
C36 (\7\:VDD VSS) capacitor c=3.27059e-18
C37 (\3\:Y VSS) capacitor c=8.3737e-17
C38 (\5\:Y VSS) capacitor c=7.28602e-17
C39 (\4\:A0 VSS) capacitor c=3.71337e-17
C40 (\4\:A1 VSS) capacitor c=3.60708e-17
C41 (\4\:B1 VSS) capacitor c=3.91303e-17
C42 (\4\:B0 VSS) capacitor c=8.7929e-17
C43 (\4\:C0 VSS) capacitor c=4.40468e-17
C44 (\4\:C1 VSS) capacitor c=5.99864e-17
C45 (\3\:net122 VSS) capacitor c=4.81816e-17
C46 (\3\:VDD VSS) capacitor c=6.68923e-17
C47 (\4\:VDD VSS) capacitor c=7.42043e-18
Rk7 (C1 \4\:C1) resistor r=0.112 c=0
Rk3 (\4\:B1 B1) resistor r=0.07088 c=0
Rk6 (C0 \4\:C0) resistor r=0.09829 c=0
Rk2 (\4\:A1 A1) resistor r=0.1778 c=0
Rk20 (\4\:VDD VDD) resistor r=0.03715 c=0
Rk19 (\3\:VDD \4\:VDD) resistor r=0.2126 c=0
Rk21 (\3\:VDD \6\:VDD) resistor r=0.07346 c=0
Rk22 (\4\:VDD \8\:VDD) resistor r=0.07346 c=0
Rk5 (B0 \4\:B0) resistor r=0.06743 c=0
Rk1 (\4\:A0 A0) resistor r=0.191 c=0
Rk11 (\2\:Y Y) resistor r=0.6536 c=0
Rk12 (Y \4\:Y) resistor r=0.2087 c=0
Rk13 (\4\:Y \6\:Y) resistor r=0.5987 c=0
Rk14 (\2\:VSS \4\:VSS) resistor r=0.222 c=0
Rk16 (\5\:VSS VSS) resistor r=0.05469 c=0
Rk15 (\4\:VSS \5\:VSS) resistor r=0.3958 c=0
Rk17 (\5\:VSS \7\:VSS) resistor r=0.1798 c=0
Rk4 (\2\:net134 \4\:net134) resistor r=0.4783 c=0
Rk8 (\2\:net122 \3\:net122) resistor r=0.04758 c=0
Rk9 (\3\:net122 \5\:net122) resistor r=0.3715 c=0
Rk10 (\3\:net122 \7\:net122) resistor r=0.3269 c=0
Rl11 (\1\:C1 \2\:C1) resistor r=71.1538 c=0
Rl12 (\2\:C1 \3\:C1) resistor r=170.604 c=0
Rl5 (\1\:B1 \2\:B1) resistor r=156.461 c=0
Rl6 (\2\:B1 \3\:B1) resistor r=83.3841 c=0
Rl9 (\1\:C0 \2\:C0) resistor r=210.307 c=0
Rl10 (\2\:C0 \3\:C0) resistor r=29.5379 c=0
Rl3 (\1\:A1 \2\:A1) resistor r=152.615 c=0
Rl4 (\2\:A1 \3\:A1) resistor r=29.5379 c=0
Rl7 (\1\:B0 \2\:B0) resistor r=97.872 c=0
Rl8 (\2\:B0 \3\:B0) resistor r=134.603 c=0
Rl2 (\2\:A0 \3\:A0) resistor r=95.6044 c=0
Rl1 (\1\:A0 \2\:A0) resistor r=88.4615 c=0
Rz1 (\3\:Y \4\:Y) resistor r=75 c=0
Rz2 (\5\:Y \6\:Y) resistor r=75 c=0
Rz3 (\1\:VSS \2\:VSS) resistor r=75 c=0
Rz4 (\6\:VSS \7\:VSS) resistor r=75 c=0
Ry8 (\5\:VDD \6\:VDD) resistor r=62 c=0
Ry9 (\7\:VDD \8\:VDD) resistor r=62 c=0
Ry6 (\1\:Y \2\:Y) resistor r=62 c=0
Ry1 (net134 \2\:net134) resistor r=62 c=0
Ry2 (\3\:net134 \4\:net134) resistor r=62 c=0
Ry3 (net122 \2\:net122) resistor r=62 c=0
Ry4 (\4\:net122 \5\:net122) resistor r=62 c=0
Ry5 (\6\:net122 \7\:net122) resistor r=62 c=0
Rx6 (\2\:C1 \4\:C1) resistor r=45 c=0
Rx3 (\2\:B1 \4\:B1) resistor r=45 c=0
Rx5 (\2\:C0 \4\:C0) resistor r=45 c=0
Rx2 (\2\:A1 \4\:A1) resistor r=45 c=0
Rx4 (\2\:B0 \4\:B0) resistor r=45 c=0
Rx1 (\2\:A0 \4\:A0) resistor r=45 c=0
mn0 (net139 \1\:A0 \6\:VSS VSS) g45n1hvt w=(1.45e-07) l=4.5e-08 nf=1 \
        as=2.03e-14 ad=1.595e-14 ps=5.7e-07 pd=5.1e-07 nrd=1.16667 \
        nrs=1.16667 sa=1.4e-07 sb=1.47e-06 sd=160n sca=6.75077 \
        scb=0.00344229 scc=2.58723e-05 m=(1)
mn1 (\5\:Y \3\:A1 net139 VSS) g45n1hvt w=(1.45e-07) l=4.5e-08 nf=1 \
        as=1.595e-14 ad=7.395e-14 ps=5.1e-07 pd=1.31e-06 nrd=1.16667 \
        nrs=1.16667 sa=2.95e-07 sb=1.315e-06 sd=160n sca=6.75077 \
        scb=0.00344229 scc=2.58723e-05 m=(1)
mn3 (\5\:Y \3\:B1 net147 VSS) g45n1hvt w=(1.45e-07) l=4.5e-08 nf=1 \
        as=2.175e-14 ad=7.395e-14 ps=5.9e-07 pd=1.31e-06 nrd=1.16667 \
        nrs=1.16667 sa=8.5e-07 sb=7.6e-07 sd=160n sca=6.75077 \
        scb=0.00344229 scc=2.58723e-05 m=(1)
mn2 (net147 \3\:B0 \1\:VSS VSS) g45n1hvt w=(1.45e-07) l=4.5e-08 nf=1 \
        as=5.11e-14 ad=2.175e-14 ps=1.05e-06 pd=5.9e-07 nrd=1.16667 \
        nrs=1.16667 sa=1.045e-06 sb=5.65e-07 sd=160n sca=6.75077 \
        scb=0.00344229 scc=2.58723e-05 m=(1)
mn4 (net155 \3\:C0 \1\:VSS VSS) g45n1hvt w=(1.45e-07) l=4.5e-08 nf=1 \
        as=5.11e-14 ad=1.668e-14 ps=1.05e-06 pd=5.2e-07 nrd=1.16667 \
        nrs=1.16667 sa=1.31e-06 sb=3e-07 sd=160n sca=6.75077 \
        scb=0.00344229 scc=2.58723e-05 m=(1)
mn5 (\3\:Y \3\:C1 net155 VSS) g45n1hvt w=(1.45e-07) l=4.5e-08 nf=1 \
        as=1.668e-14 ad=2.03e-14 ps=5.2e-07 pd=5.7e-07 nrd=1.16667 \
        nrs=1.16667 sa=1.47e-06 sb=1.4e-07 sd=160n sca=6.75077 \
        scb=0.00344229 scc=2.58723e-05 m=(1)
ends AOI222XL
// End of subcircuit definition.
