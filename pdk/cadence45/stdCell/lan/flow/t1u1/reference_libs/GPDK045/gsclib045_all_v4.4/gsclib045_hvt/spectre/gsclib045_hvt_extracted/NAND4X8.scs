// Generated for: spectre (May  1 09:17:54 2013 )
// Library name: gsclib045_hvt
// Cell name: NAND4X8
// View name: extracted

simulator lang=spectre

subckt NAND4X8 A B C D VDD VSS Y
mp1_1__rcx (\16\:Y B \13\:VDD VDD) g45p1hvt w=(4.45e-07) l=4.5e-08 nf=1 \
        as=7.12e-14 ad=7.12e-14 ps=1.21e-06 pd=1.21e-06 nrd=1.16667 \
        nrs=1.16667 sa=1.575e-06 sb=2e-06 sd=160n sca=18.517 scb=0.0155152 \
        scc=0.00162155 m=(7)
mp0_1__rcx (\16\:Y A VDD VDD) g45p1hvt w=(4.45e-07) l=4.5e-08 nf=1 \
        as=6.993e-14 ad=7.12e-14 ps=1.20429e-06 pd=1.21e-06 nrd=1.16667 \
        nrs=1.16667 sa=1.4e-07 sb=2e-06 sd=160n sca=30.632 scb=0.0328204 \
        scc=0.00272371 m=(7)
mp2_1__rcx (\9\:Y \1\:C \13\:VDD VDD) g45p1hvt w=(4.45e-07) l=4.5e-08 \
        nf=1 as=7.12e-14 ad=7.12e-14 ps=1.21e-06 pd=1.21e-06 nrd=1.16667 \
        nrs=1.16667 sa=2e-06 sb=2e-06 sd=160n sca=18.517 scb=0.0155152 \
        scc=0.00162155 m=(7)
mp3 (\9\:Y D \1\:VDD VDD) g45p1hvt w=(4.45e-07) l=4.5e-08 nf=1 \
        as=6.993e-14 ad=7.12e-14 ps=1.20429e-06 pd=1.21e-06 nrd=1.16667 \
        nrs=1.16667 sa=2e-06 sb=1.37e-06 sd=160n sca=18.517 scb=0.0155152 \
        scc=0.00162155 m=(7)
C1 (B VSS) capacitor c=4.72166e-16
C2 (D VSS) capacitor c=4.58531e-16
C3 (A VSS) capacitor c=4.36084e-16
C4 (Y VSS) capacitor c=1.49493e-17
C5 (VDD VSS) capacitor c=4.13018e-16
C6 (C VSS) capacitor c=2.10884e-17
C7 (n2 VSS) capacitor c=4.40725e-16
C8 (n1 VSS) capacitor c=4.97624e-16
C9 (n0 VSS) capacitor c=4.30981e-16
C10 (\1\:C VSS) capacitor c=4.47893e-16
C11 (\1\:VDD VSS) capacitor c=2.0629e-16
C12 (\3\:VDD VSS) capacitor c=5.21265e-17
C13 (\1\:Y VSS) capacitor c=2.20217e-16
C14 (\9\:Y VSS) capacitor c=6.08467e-16
C15 (\16\:Y VSS) capacitor c=6.11765e-16
C16 (\13\:VDD VSS) capacitor c=3.88141e-16
Rk92 (\3\:VSS VSS) resistor r=1.1301 c=0
Rk91 (\2\:VSS \3\:VSS) resistor r=0.9022 c=0
Rk34 (\1\:Y Y) resistor r=0.04342 c=0
Rk35 (Y \9\:Y) resistor r=0.227 c=0
Rk42 (\9\:Y \16\:Y) resistor r=0.3333 c=0
Rk82 (\13\:VDD VDD) resistor r=0.2051 c=0
Rk67 (\1\:VDD \13\:VDD) resistor r=0.2051 c=0
Rk15 (\1\:C C) resistor r=0.04316 c=0
Rz28 (VDD \3\:VDD) resistor r=6.25 c=0
Rz26 (\1\:VDD \3\:VDD) resistor r=12.5 c=0
Rz27 (\13\:VDD \3\:VDD) resistor r=6.25 c=0
Ry32 (VSS \1\:VSS) resistor r=5.1667 c=0
Ry30 (\2\:VSS \1\:VSS) resistor r=10.3333 c=0
Ry31 (\3\:VSS \1\:VSS) resistor r=5.1667 c=0
mn2_1__rcx (n0 \1\:C n1 VSS) g45n1hvt w=(2.95e-07) l=4.5e-08 nf=1 \
        as=4.72e-14 ad=4.72e-14 ps=9.1e-07 pd=9.1e-07 nrd=1.16667 \
        nrs=1.16667 sa=2e-06 sb=2e-06 sd=160n sca=16.4223 scb=0.0158966 \
        scc=0.0014413 m=(7)
mn1 (n1 B n2 VSS) g45n1hvt w=(2.95e-07) l=4.5e-08 nf=1 as=4.72e-14 \
        ad=4.72e-14 ps=9.1e-07 pd=9.1e-07 nrd=1.16667 nrs=1.16667 \
        sa=1.575e-06 sb=2e-06 sd=160n sca=16.4223 scb=0.0158966 \
        scc=0.0014413 m=(7)
mn3_1__rcx (\1\:Y D n0 VSS) g45n1hvt w=(2.95e-07) l=4.5e-08 nf=1 \
        as=4.72e-14 ad=4.636e-14 ps=9.1e-07 pd=9.0429e-07 nrd=1.16667 \
        nrs=1.16667 sa=2e-06 sb=1.37e-06 sd=160n sca=16.4223 scb=0.0158966 \
        scc=0.0014413 m=(7)
mn0_1__rcx (n2 A VSS VSS) g45n1hvt w=(2.95e-07) l=4.5e-08 nf=1 \
        as=4.636e-14 ad=4.72e-14 ps=9.0429e-07 pd=9.1e-07 nrd=1.16667 \
        nrs=1.16667 sa=1.4e-07 sb=2e-06 sd=160n sca=16.4223 scb=0.0158966 \
        scc=0.0014413 m=(7)
ends NAND4X8
// End of subcircuit definition.
