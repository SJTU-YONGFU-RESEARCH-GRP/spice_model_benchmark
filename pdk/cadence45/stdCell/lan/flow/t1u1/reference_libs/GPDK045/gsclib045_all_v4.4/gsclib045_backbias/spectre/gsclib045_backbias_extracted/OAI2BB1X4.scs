// Generated for: spectre (May  1 11:31:35 2013 )
// Library name: gsclib045_backbias
// Cell name: OAI2BB1X4
// View name: extracted

simulator lang=spectre

subckt OAI2BB1X4 A0N A1N B0 NW VDD VSS Y
mp0 (\19\:n0 \1\:A0N \3\:VDD NW) g45p1svt w=(3.9e-07) l=4.5e-08 nf=1 \
        as=8.58e-14 ad=1.053e-13 ps=1.22e-06 pd=1.32e-06 nrd=1.16667 \
        nrs=1.16667 sa=1.85e-06 sb=4.55e-07 sd=160n sca=13.3748 \
        scb=0.0113115 scc=0.000384334 m=(1)
mp1 (\19\:n0 \1\:A1N \1\:VDD NW) g45p1svt w=(3.9e-07) l=4.5e-08 nf=1 \
        as=5.46e-14 ad=1.053e-13 ps=1.06e-06 pd=1.32e-06 nrd=1.16667 \
        nrs=1.16667 sa=2e-06 sb=1.4e-07 sd=160n sca=18.4901 scb=0.0196141 \
        scc=0.000605547 m=(1)
mp2_1__rcx (\1\:Y \2\:B0 \3\:VDD NW) g45p1svt w=(3.9e-07) l=4.5e-08 nf=1 \
        as=6.63e-14 ad=6.337e-14 ps=1.12e-06 pd=1.105e-06 nrd=1.16667 \
        nrs=1.16667 sa=1.4e-07 sb=2e-06 sd=160n sca=20.9187 scb=0.0234591 \
        scc=0.000905231 m=(4)
mp3_1__rcx (\1\:Y n0 \3\:VDD NW) g45p1svt w=(3.9e-07) l=4.5e-08 nf=1 \
        as=6.24e-14 ad=6.337e-14 ps=1.1e-06 pd=1.105e-06 nrd=1.16667 \
        nrs=1.16667 sa=3.45e-07 sb=1.96e-06 sd=160n sca=14.8572 \
        scb=0.0133107 scc=0.000397776 m=(4)
C1 (A0N VSS) capacitor c=4.31991e-17
C2 (NW VSS) capacitor c=3.81307e-16
C3 (B0 VSS) capacitor c=1.82022e-17
C4 (Y VSS) capacitor c=7.54033e-17
C5 (VDD VSS) capacitor c=2.44415e-17
C6 (A1N VSS) capacitor c=5.10331e-17
C7 (8 VSS) capacitor c=1.85166e-18
C8 (n0 VSS) capacitor c=5.11132e-16
C9 (9 VSS) capacitor c=3.55348e-18
C10 (10 VSS) capacitor c=3.80467e-18
C11 (\1\:A1N VSS) capacitor c=3.43042e-17
C12 (\1\:A0N VSS) capacitor c=3.87665e-17
C13 (\3\:A1N VSS) capacitor c=5.71162e-17
C14 (\3\:A0N VSS) capacitor c=4.35298e-17
C15 (\13\:B0 VSS) capacitor c=2.87719e-17
C16 (\12\:n0 VSS) capacitor c=2.66136e-17
C17 (\11\:n0 VSS) capacitor c=4.47534e-17
C18 (\8\:B0 VSS) capacitor c=3.18358e-17
C19 (\7\:B0 VSS) capacitor c=3.46035e-17
C20 (\6\:n0 VSS) capacitor c=2.90265e-17
C21 (\5\:n0 VSS) capacitor c=4.44726e-17
C22 (\1\:B0 VSS) capacitor c=5.18209e-17
C23 (\4\:A1N VSS) capacitor c=1.19692e-17
C24 (\2\:A0N VSS) capacitor c=3.60275e-17
C25 (\2\:B0 VSS) capacitor c=5.92509e-16
C26 (\1\:VDD VSS) capacitor c=8.53286e-17
C27 (\19\:n0 VSS) capacitor c=4.45084e-17
C28 (\1\:Y VSS) capacitor c=3.4182e-16
C29 (\14\:n0 VSS) capacitor c=3.67321e-17
C30 (\14\:Y VSS) capacitor c=8.40413e-17
C31 (\12\:Y VSS) capacitor c=1.53153e-16
C32 (\2\:A1N VSS) capacitor c=1.71403e-17
C33 (\4\:A0N VSS) capacitor c=6.4527e-17
C34 (\16\:n0 VSS) capacitor c=1.20351e-16
C35 (\5\:A1N VSS) capacitor c=3.46384e-17
C36 (\3\:VDD VSS) capacitor c=4.36732e-16
Rk32 (\2\:VSS \3\:VSS) resistor r=0.3457 c=0
Rk33 (\3\:VSS \4\:VSS) resistor r=0.3056 c=0
Rk34 (\4\:VSS \5\:VSS) resistor r=0.1477 c=0
Rk36 (\6\:VSS VSS) resistor r=0.06471 c=0
Rk35 (\5\:VSS \6\:VSS) resistor r=0.3379 c=0
Rk37 (\3\:VSS \8\:VSS) resistor r=0.2861 c=0
Rk38 (\5\:VSS \10\:VSS) resistor r=0.2815 c=0
Rk39 (\6\:VSS \12\:VSS) resistor r=0.2815 c=0
Rk14 (\4\:A0N A0N) resistor r=0.1012 c=0
Rk13 (\2\:B0 B0) resistor r=0.02733 c=0
Rk4 (\1\:Y Y) resistor r=0.2349 c=0
Rk8 (Y \13\:Y) resistor r=0.5999 c=0
Rk9 (\13\:Y \15\:Y) resistor r=0.5051 c=0
Rk26 (\3\:VDD VDD) resistor r=0.02963 c=0
Rk21 (\2\:VDD \3\:VDD) resistor r=0.5178 c=0
Rk20 (\5\:A1N A1N) resistor r=0.1642 c=0
Rk16 (\16\:n0 n0) resistor r=0.6413 c=0
Rk15 (\15\:n0 \16\:n0) resistor r=0.364 c=0
Rk18 (\16\:n0 \20\:n0) resistor r=0.1273 c=0
Rl22 (\1\:A0N \2\:A0N) resistor r=64.1533 c=0
Rl23 (\2\:A0N \3\:A0N) resistor r=60.3072 c=0
Rl21 (\2\:B0 \13\:B0) resistor r=41.1873 c=0
Rl12 (\2\:B0 \8\:B0) resistor r=28.6412 c=0
Rl11 (\2\:B0 \7\:B0) resistor r=71.1317 c=0
Rl1 (\2\:B0 \1\:B0) resistor r=28.6412 c=0
Rl24 (\1\:A1N \2\:A1N) resistor r=73.7402 c=0
Rl25 (\2\:A1N \3\:A1N) resistor r=104.154 c=0
Rl26 (\2\:A1N \4\:A1N) resistor r=12.1383 c=0
Rl17 (n0 \12\:n0) resistor r=86.22 c=0
Rl16 (n0 \11\:n0) resistor r=119.208 c=0
Rl7 (n0 \6\:n0) resistor r=28.0797 c=0
Rl6 (n0 \5\:n0) resistor r=28.0797 c=0
Rz4 (\7\:VSS \8\:VSS) resistor r=75 c=0
Rz5 (\9\:VSS \10\:VSS) resistor r=75 c=0
Rz6 (\11\:VSS \12\:VSS) resistor r=75 c=0
Rz1 (\13\:Y \12\:Y) resistor r=75 c=0
Rz2 (\15\:Y \14\:Y) resistor r=75 c=0
Rz3 (\15\:n0 \14\:n0) resistor r=75 c=0
Ry12 (\1\:VSS \2\:VSS) resistor r=62 c=0
Ry13 (\1\:VSS \4\:VSS) resistor r=5.1667 c=0
Ry6 (\2\:VDD \1\:VDD) resistor r=62 c=0
Ry5 (\20\:n0 \19\:n0) resistor r=20.6667 c=0
Rx4 (\2\:A0N \4\:A0N) resistor r=45 c=0
Rx7 (\4\:A1N \5\:A1N) resistor r=45 c=0
mn2_1__rcx (8 \1\:B0 \11\:VSS VSS) g45n1svt w=(2.6e-07) l=4.5e-08 nf=1 \
        as=3.64e-14 ad=1.56e-14 ps=8e-07 pd=6.4e-07 nrd=1.16667 \
        nrs=1.16667 sa=1.4e-07 sb=1.905e-06 sd=160n sca=17.5885 \
        scb=0.0172826 scc=0.00162584 m=(1)
mn3_1__rcx (\12\:Y \5\:n0 8 VSS) g45n1svt w=(2.6e-07) l=4.5e-08 nf=1 \
        as=1.56e-14 ad=4.16e-14 ps=6.4e-07 pd=8.4e-07 nrd=1.16667 \
        nrs=1.16667 sa=2.45e-07 sb=1.8e-06 sd=160n sca=17.5885 \
        scb=0.0172826 scc=0.00162584 m=(1)
mn3_2__rcx (\12\:Y \6\:n0 9 VSS) g45n1svt w=(2.6e-07) l=4.5e-08 nf=1 \
        as=2.99e-14 ad=4.16e-14 ps=7.5e-07 pd=8.4e-07 nrd=1.16667 \
        nrs=1.16667 sa=4.5e-07 sb=1.595e-06 sd=160n sca=17.5885 \
        scb=0.0172826 scc=0.00162584 m=(1)
mn2_2__rcx (9 \7\:B0 \9\:VSS VSS) g45n1svt w=(2.6e-07) l=4.5e-08 nf=1 \
        as=4.16e-14 ad=2.99e-14 ps=8.4e-07 pd=7.5e-07 nrd=1.16667 \
        nrs=1.16667 sa=6.1e-07 sb=1.435e-06 sd=160n sca=17.5885 \
        scb=0.0172826 scc=0.00162584 m=(1)
mn2_3__rcx (10 \8\:B0 \9\:VSS VSS) g45n1svt w=(2.6e-07) l=4.5e-08 nf=1 \
        as=4.16e-14 ad=2.99e-14 ps=8.4e-07 pd=7.5e-07 nrd=1.16667 \
        nrs=1.16667 sa=8.15e-07 sb=1.23e-06 sd=160n sca=17.5885 \
        scb=0.0172826 scc=0.00162584 m=(1)
mn3_3__rcx (\14\:Y \11\:n0 10 VSS) g45n1svt w=(2.6e-07) l=4.5e-08 nf=1 \
        as=2.99e-14 ad=4.16e-14 ps=7.5e-07 pd=8.4e-07 nrd=1.16667 \
        nrs=1.16667 sa=9.75e-07 sb=1.07e-06 sd=160n sca=17.5885 \
        scb=0.0172826 scc=0.00162584 m=(1)
mn3 (\14\:Y \12\:n0 11 VSS) g45n1svt w=(2.6e-07) l=4.5e-08 nf=1 \
        as=6.76e-14 ad=4.16e-14 ps=1.04e-06 pd=8.4e-07 nrd=1.16667 \
        nrs=1.16667 sa=1.18e-06 sb=8.65e-07 sd=160n sca=17.5885 \
        scb=0.0172826 scc=0.00162584 m=(1)
mn2 (11 \13\:B0 \7\:VSS VSS) g45n1svt w=(2.6e-07) l=4.5e-08 nf=1 \
        as=5.72e-14 ad=6.76e-14 ps=9.6e-07 pd=1.04e-06 nrd=1.16667 \
        nrs=1.16667 sa=1.485e-06 sb=5.6e-07 sd=160n sca=17.5885 \
        scb=0.0172826 scc=0.00162584 m=(1)
mn0 (n1 \3\:A0N \7\:VSS VSS) g45n1svt w=(2.6e-07) l=4.5e-08 nf=1 \
        as=5.72e-14 ad=2.86e-14 ps=9.6e-07 pd=7.4e-07 nrd=1.16667 \
        nrs=1.16667 sa=1.75e-06 sb=2.95e-07 sd=160n sca=17.5885 \
        scb=0.0172826 scc=0.00162584 m=(1)
mn1 (\14\:n0 \3\:A1N n1 VSS) g45n1svt w=(2.6e-07) l=4.5e-08 nf=1 \
        as=2.86e-14 ad=3.64e-14 ps=7.4e-07 pd=8e-07 nrd=1.16667 \
        nrs=1.16667 sa=1.905e-06 sb=1.4e-07 sd=160n sca=17.5885 \
        scb=0.0172826 scc=0.00162584 m=(1)
ends OAI2BB1X4
// End of subcircuit definition.
