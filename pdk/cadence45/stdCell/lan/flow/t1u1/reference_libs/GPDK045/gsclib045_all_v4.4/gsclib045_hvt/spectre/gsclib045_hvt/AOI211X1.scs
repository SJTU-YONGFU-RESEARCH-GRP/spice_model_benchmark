// gsclib045_hvt/AOI211X1/schematic

simulator lang=spectre

subckt AOI211X1 A0 A1 B0 C0 Y VDD VSS
mp3 (Y C0 net82 VDD) g45p1hvt w=(390n) l=45n nf=1 m=(1)
mp2 (net82 B0 net91 VDD) g45p1hvt w=(390n) l=45n nf=1 m=(1)
mp1 (net91 A1 VDD VDD) g45p1hvt w=(390n) l=45n nf=1 m=(1)
mp0 (net91 A0 VDD VDD) g45p1hvt w=(390n) l=45n nf=1 m=(1)
mn2 (Y B0 VSS VSS) g45n1hvt w=(260n) l=45n nf=1 m=(1)
mn3 (Y C0 VSS VSS) g45n1hvt w=(260n) l=45n nf=1 m=(1)
mn1 (Y A1 net95 VSS) g45n1hvt w=(260n) l=45n nf=1 m=(1)
mn0 (net95 A0 VSS VSS) g45n1hvt w=(260n) l=45n nf=1 m=(1)
ends AOI211X1
