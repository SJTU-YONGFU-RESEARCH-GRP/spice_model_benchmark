// Generated for: spectre (May  1 11:28:17 2013 )
// Library name: gsclib045_backbias
// Cell name: CLKBUFX3
// View name: extracted

simulator lang=spectre

subckt CLKBUFX3 A NW VDD VSS Y
mp0 (\11\:net44 \1\:A \1\:VDD NW) g45p1svt w=(3.9e-07) l=4.5e-08 nf=1 \
        as=6.24e-14 ad=5.655e-14 ps=1.1e-06 pd=1.07e-06 nrd=1.16667 \
        nrs=1.16667 sa=7.55e-07 sb=1.45e-07 sd=160n sca=22.6205 \
        scb=0.0258254 scc=0.00117627 m=(1)
mp1 (\1\:Y net44 \1\:VDD NW) g45p1svt w=(3.9e-07) l=4.5e-08 nf=1 \
        as=6.24e-14 ad=5.98e-14 ps=1.1e-06 pd=1.08667e-06 nrd=1.16667 \
        nrs=1.16667 sa=1.4e-07 sb=7.6e-07 sd=160n sca=17.5421 \
        scb=0.0176137 scc=0.000504265 m=(3)
C1 (NW VSS) capacitor c=1.80389e-16
C2 (VDD VSS) capacitor c=4.15461e-17
C3 (A VSS) capacitor c=8.4858e-17
C4 (Y VSS) capacitor c=1.80029e-17
C5 (net44 VSS) capacitor c=1.05747e-16
C6 (\1\:A VSS) capacitor c=4.69352e-17
C7 (\3\:A VSS) capacitor c=3.63993e-17
C8 (\2\:A VSS) capacitor c=4.47672e-17
C9 (\3\:net44 VSS) capacitor c=1.10277e-16
C10 (\11\:net44 VSS) capacitor c=8.18577e-17
C11 (\1\:VDD VSS) capacitor c=2.15631e-16
C12 (\1\:Y VSS) capacitor c=1.17805e-16
C13 (\13\:net44 VSS) capacitor c=5.53229e-17
C14 (\4\:Y VSS) capacitor c=1.14265e-16
C15 (\4\:A VSS) capacitor c=3.69802e-17
C16 (\15\:net44 VSS) capacitor c=5.40717e-17
Rk17 (\1\:VSS VSS) resistor r=0.1548 c=0
Rk13 (\1\:VDD VDD) resistor r=0.1749 c=0
Rk9 (\4\:A A) resistor r=0.04486 c=0
Rk2 (\1\:Y Y) resistor r=0.003365 c=0
Rk3 (Y \4\:Y) resistor r=0.2851 c=0
Rk10 (\12\:net44 \14\:net44) resistor r=0.5066 c=0
Rk11 (\14\:net44 \15\:net44) resistor r=0.3154 c=0
Rl10 (\1\:A \2\:A) resistor r=89.6174 c=0
Rl11 (\2\:A \3\:A) resistor r=47.3281 c=0
Rl2 (net44 \3\:net44) resistor r=34.2287 c=0
Rz3 (\14\:net44 \13\:net44) resistor r=75 c=0
Ry3 (\12\:net44 \11\:net44) resistor r=20.6667 c=0
Rx1 (\2\:A \4\:A) resistor r=45 c=0
Rx2 (\15\:net44 \3\:net44) resistor r=45 c=0
mn0 (\13\:net44 \3\:A \1\:VSS VSS) g45n1svt w=(2.6e-07) l=4.5e-08 nf=1 \
        as=4.81e-14 ad=3.64e-14 ps=8.9e-07 pd=8e-07 nrd=1.16667 \
        nrs=1.16667 sa=7.8e-07 sb=1.4e-07 sd=160n sca=12.1772 \
        scb=0.0118935 scc=0.000630577 m=(1)
mn1 (\4\:Y \3\:net44 \1\:VSS VSS) g45n1svt w=(2.6e-07) l=4.5e-08 nf=1 \
        as=4.377e-14 ad=3.987e-14 ps=8.5667e-07 pd=8.2667e-07 nrd=1.16667 \
        nrs=1.16667 sa=1.4e-07 sb=7.8e-07 sd=160n sca=12.1772 \
        scb=0.0118935 scc=0.000630577 m=(3)
ends CLKBUFX3
// End of subcircuit definition.
