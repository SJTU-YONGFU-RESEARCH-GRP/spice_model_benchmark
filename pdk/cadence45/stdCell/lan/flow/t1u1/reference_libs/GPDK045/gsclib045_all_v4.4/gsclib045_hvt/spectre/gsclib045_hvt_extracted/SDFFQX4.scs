// Generated for: spectre (May  1 09:15:35 2013 )
// Library name: gsclib045_hvt
// Cell name: SDFFQX4
// View name: extracted

simulator lang=spectre

subckt SDFFQX4 CK D Q SE SI VDD VSS
mp20 (\17\:CKb \4\:CK \7\:VDD VDD) g45p1hvt w=(2.15e-07) l=4.5e-08 nf=1 \
        as=6.535e-14 ad=3.01e-14 ps=1.16e-06 pd=7.1e-07 nrd=1.16667 \
        nrs=1.16667 sa=1.4e-07 sb=1.39721e-06 sd=160n sca=59.4536 \
        scb=0.0473468 scc=0.00729053 m=(1)
mp50 (n8 \17\:qbint \7\:VDD VDD) g45p1hvt w=(2.15e-07) l=4.5e-08 nf=1 \
        as=5.895e-14 ad=2.687e-14 ps=1.08e-06 pd=6.8e-07 nrd=1.16667 \
        nrs=1.16667 sa=1.53012e-06 sb=1.705e-06 sd=160n sca=13.4114 \
        scb=0.012694 scc=0.000544005 m=(1)
mp51 (\12\:n30 \2\:CKbb n8 VDD) g45p1hvt w=(2.15e-07) l=4.5e-08 nf=1 \
        as=2.687e-14 ad=4.3e-14 ps=6.8e-07 pd=8.3e-07 nrd=1.16667 \
        nrs=1.16667 sa=1.70012e-06 sb=1.535e-06 sd=160n sca=13.4114 \
        scb=0.012694 scc=0.000544005 m=(1)
mp40 (\12\:n30 CKb \8\:mout VDD) g45p1hvt w=(2.15e-07) l=4.5e-08 nf=1 \
        as=6.88e-14 ad=4.3e-14 ps=1.07e-06 pd=8.3e-07 nrd=1.16667 \
        nrs=1.16667 sa=1.91442e-06 sb=1.29e-06 sd=160n sca=13.4114 \
        scb=0.012694 scc=0.000544005 m=(1)
mp30 (\8\:mout \3\:n20 \13\:VDD VDD) g45p1hvt w=(2.15e-07) l=4.5e-08 \
        nf=1 as=9.205e-14 ad=6.88e-14 ps=1.6e-06 pd=1.07e-06 nrd=1.16667 \
        nrs=1.16667 sa=2e-06 sb=9.25e-07 sd=160n sca=13.4114 scb=0.012694 \
        scc=0.000544005 m=(1)
mp35 (n6 \4\:mout \13\:VDD VDD) g45p1hvt w=(2.15e-07) l=4.5e-08 nf=1 \
        as=9.205e-14 ad=2.473e-14 ps=1.6e-06 pd=6.6e-07 nrd=1.16667 \
        nrs=1.16667 sa=2e-06 sb=6.5e-07 sd=160n sca=13.4114 scb=0.012694 \
        scc=0.000544005 m=(1)
mp36 (\6\:n20 \4\:CKb n6 VDD) g45p1hvt w=(2.15e-07) l=4.5e-08 nf=1 \
        as=2.472e-14 ad=3.44e-14 ps=6.6e-07 pd=7.5e-07 nrd=1.16667 \
        nrs=1.16667 sa=2e-06 sb=4.9e-07 sd=160n sca=13.4114 scb=0.012694 \
        scc=0.000544005 m=(1)
mp25 (\6\:n20 \8\:CKbb \5\:Db VDD) g45p1hvt w=(2.15e-07) l=4.5e-08 nf=1 \
        as=6.127e-14 ad=3.44e-14 ps=1e-06 pd=7.5e-07 nrd=1.16667 \
        nrs=1.16667 sa=2e-06 sb=2.85e-07 sd=160n sca=13.4114 scb=0.012694 \
        scc=0.000544005 m=(1)
mp21 (\9\:CKbb \6\:CKb \11\:VDD VDD) g45p1hvt w=(2.15e-07) l=4.5e-08 \
        nf=1 as=3.44e-14 ad=3.01e-14 ps=7.5e-07 pd=7.1e-07 nrd=1.16667 \
        nrs=1.16667 sa=1.4e-07 sb=1.12e-06 sd=160n sca=10.6366 \
        scb=0.00827102 scc=0.000128406 m=(1)
mp11 (n2 \1\:D \11\:VDD VDD) g45p1hvt w=(2.15e-07) l=4.5e-08 nf=1 \
        as=3.44e-14 ad=2.15e-14 ps=7.5e-07 pd=6.3e-07 nrd=1.16667 \
        nrs=1.16667 sa=3.45e-07 sb=9.15e-07 sd=160n sca=10.6366 \
        scb=0.00827102 scc=0.000128406 m=(1)
mp12 (\9\:Db \2\:SE n2 VDD) g45p1hvt w=(2.15e-07) l=4.5e-08 nf=1 \
        as=2.15e-14 ad=3.87e-14 ps=6.3e-07 pd=7.9e-07 nrd=1.16667 \
        nrs=1.16667 sa=4.9e-07 sb=7.7e-07 sd=160n sca=10.6461 \
        scb=0.00827274 scc=0.000128406 m=(1)
mp14 (\9\:Db SEb n4 VDD) g45p1hvt w=(2.15e-07) l=4.5e-08 nf=1 \
        as=3.332e-14 ad=3.87e-14 ps=7.4e-07 pd=7.9e-07 nrd=1.16667 \
        nrs=1.16667 sa=7.15e-07 sb=5.45e-07 sd=160n sca=11.2732 \
        scb=0.00852207 scc=0.000128512 m=(1)
mp13 (n4 \3\:SI \9\:VDD VDD) g45p1hvt w=(2.15e-07) l=4.5e-08 nf=1 \
        as=3.44e-14 ad=3.332e-14 ps=7.5e-07 pd=7.4e-07 nrd=1.16667 \
        nrs=1.16667 sa=9.15e-07 sb=3.45e-07 sd=160n sca=12.5323 \
        scb=0.0098256 scc=0.000132754 m=(1)
mp10 (\9\:SEb \7\:SE \9\:VDD VDD) g45p1hvt w=(2.15e-07) l=4.5e-08 nf=1 \
        as=3.44e-14 ad=3.01e-14 ps=7.5e-07 pd=7.1e-07 nrd=1.16667 \
        nrs=1.16667 sa=1.12e-06 sb=1.4e-07 sd=160n sca=16.3619 \
        scb=0.0163088 scc=0.000299525 m=(1)
C1 (D VSS) capacitor c=7.22142e-17
C2 (Q VSS) capacitor c=2.95087e-16
C3 (VDD VSS) capacitor c=3.35906e-16
C4 (CK VSS) capacitor c=5.45052e-17
C5 (SE VSS) capacitor c=6.40837e-17
C6 (SI VSS) capacitor c=4.18643e-17
C7 (CKb VSS) capacitor c=5.63332e-17
C8 (qbint VSS) capacitor c=2.67116e-16
C9 (n30 VSS) capacitor c=1.96267e-16
C10 (n7 VSS) capacitor c=6.57007e-19
C11 (mout VSS) capacitor c=3.86828e-17
C12 (CKbb VSS) capacitor c=4.51463e-17
C13 (n20 VSS) capacitor c=5.40511e-17
C14 (n5 VSS) capacitor c=1.91161e-18
C15 (Db VSS) capacitor c=9.93103e-17
C16 (n1 VSS) capacitor c=5.99035e-18
C17 (SEb VSS) capacitor c=3.35707e-17
C18 (n8 VSS) capacitor c=2.04398e-18
C19 (n6 VSS) capacitor c=2.92314e-18
C20 (n2 VSS) capacitor c=1.93991e-19
C21 (n4 VSS) capacitor c=3.42778e-18
C22 (\7\:SE VSS) capacitor c=5.11035e-17
C23 (\3\:SI VSS) capacitor c=5.25808e-17
C24 (\2\:SE VSS) capacitor c=4.80126e-17
C25 (\1\:D VSS) capacitor c=6.1397e-17
C26 (\6\:CKb VSS) capacitor c=5.08584e-17
C27 (\8\:CKbb VSS) capacitor c=2.62962e-17
C28 (\4\:CKb VSS) capacitor c=5.35072e-17
C29 (\4\:mout VSS) capacitor c=6.84535e-17
C30 (\3\:n20 VSS) capacitor c=3.20737e-17
C31 (\2\:CKbb VSS) capacitor c=4.00846e-17
C32 (\17\:qbint VSS) capacitor c=5.0243e-17
C33 (\4\:CK VSS) capacitor c=3.25153e-17
C34 (\5\:SE VSS) capacitor c=2.73127e-17
C35 (\1\:SI VSS) capacitor c=6.59098e-17
C36 (\3\:SE VSS) capacitor c=6.87159e-17
C37 (\3\:SEb VSS) capacitor c=7.09519e-17
C38 (\3\:D VSS) capacitor c=3.72345e-17
C39 (\10\:CKb VSS) capacitor c=3.13326e-17
C40 (\9\:CKb VSS) capacitor c=1.43821e-17
C41 (\7\:CKbb VSS) capacitor c=4.91803e-17
C42 (\3\:CKbb VSS) capacitor c=4.54233e-17
C43 (\2\:CKb VSS) capacitor c=5.24805e-17
C44 (\14\:qbint VSS) capacitor c=3.55301e-17
C45 (\3\:CK VSS) capacitor c=2.99639e-17
C46 (\6\:SE VSS) capacitor c=5.45831e-17
C47 (\2\:SI VSS) capacitor c=7.56769e-17
C48 (\4\:SE VSS) capacitor c=5.00463e-17
C49 (\1\:SE VSS) capacitor c=5.19143e-17
C50 (\2\:D VSS) capacitor c=5.29429e-17
C51 (\8\:CKb VSS) capacitor c=4.66155e-17
C52 (\5\:CKbb VSS) capacitor c=1.94378e-17
C53 (\5\:CKb VSS) capacitor c=4.46656e-17
C54 (\3\:mout VSS) capacitor c=5.64634e-17
C55 (\2\:n20 VSS) capacitor c=4.64643e-17
C56 (\4\:CKbb VSS) capacitor c=3.6587e-17
C57 (\3\:CKb VSS) capacitor c=2.26386e-17
C58 (\16\:qbint VSS) capacitor c=4.81255e-17
C59 (\1\:CK VSS) capacitor c=1.90257e-17
C60 (\9\:SEb VSS) capacitor c=7.71233e-18
C61 (\9\:VDD VSS) capacitor c=3.37211e-17
C62 (\9\:Db VSS) capacitor c=7.13289e-17
C63 (\11\:VDD VSS) capacitor c=4.16472e-17
C64 (\9\:CKbb VSS) capacitor c=6.91516e-17
C65 (\5\:Db VSS) capacitor c=7.40895e-17
C66 (\6\:n20 VSS) capacitor c=9.47997e-17
C67 (\13\:VDD VSS) capacitor c=1.34334e-17
C68 (\8\:mout VSS) capacitor c=6.24632e-17
C69 (\12\:n30 VSS) capacitor c=2.7253e-17
C70 (\24\:qbint VSS) capacitor c=7.0822e-17
C71 (\17\:CKb VSS) capacitor c=4.01869e-17
C72 (\1\:VDD VSS) capacitor c=6.65845e-17
C73 (\5\:SEb VSS) capacitor c=6.97504e-17
C74 (\15\:CKbb VSS) capacitor c=8.81979e-17
C75 (\7\:Db VSS) capacitor c=1.00188e-16
C76 (\4\:n20 VSS) capacitor c=8.81582e-17
C77 (\5\:mout VSS) capacitor c=2.93154e-17
C78 (\8\:n30 VSS) capacitor c=8.24464e-17
C79 (\22\:qbint VSS) capacitor c=3.38858e-17
C80 (\14\:CKb VSS) capacitor c=1.75548e-16
C81 (\2\:CK VSS) capacitor c=1.28072e-17
C82 (\6\:CKbb VSS) capacitor c=3.30305e-17
C83 (\7\:CKb VSS) capacitor c=6.10014e-17
C84 (\2\:SEb VSS) capacitor c=6.6704e-17
C85 (\5\:CK VSS) capacitor c=6.28384e-17
C86 (\18\:qbint VSS) capacitor c=5.42841e-17
C87 (\19\:qbint VSS) capacitor c=2.06832e-17
C88 (\20\:qbint VSS) capacitor c=2.67239e-17
C89 (\21\:qbint VSS) capacitor c=3.43538e-17
C90 (\10\:n30 VSS) capacitor c=8.29554e-17
C91 (\11\:n30 VSS) capacitor c=5.847e-17
C92 (\7\:mout VSS) capacitor c=4.13851e-17
C93 (\10\:mout VSS) capacitor c=4.71296e-17
C94 (\8\:n20 VSS) capacitor c=7.15946e-17
C95 (\11\:CKb VSS) capacitor c=9.35291e-17
C96 (\12\:CKb VSS) capacitor c=1.25552e-16
C97 (\13\:CKb VSS) capacitor c=2.29721e-16
C98 (\16\:CKb VSS) capacitor c=7.41308e-17
C99 (\11\:CKbb VSS) capacitor c=1.82488e-16
C100 (\12\:CKbb VSS) capacitor c=1.05641e-16
C101 (\14\:CKbb VSS) capacitor c=4.22202e-17
C102 (\17\:CKbb VSS) capacitor c=1.26991e-16
C103 (\4\:D VSS) capacitor c=4.43982e-17
C104 (\3\:Db VSS) capacitor c=1.56078e-16
C105 (\4\:Db VSS) capacitor c=1.1231e-16
C106 (\8\:SE VSS) capacitor c=4.90699e-17
C107 (\9\:SE VSS) capacitor c=7.30497e-17
C108 (\4\:SI VSS) capacitor c=8.58576e-17
C109 (\7\:SEb VSS) capacitor c=8.32088e-17
C110 (\8\:SEb VSS) capacitor c=6.8817e-17
C111 (\3\:VDD VSS) capacitor c=1.25517e-17
C112 (\4\:VDD VSS) capacitor c=2.71728e-17
C113 (\6\:VDD VSS) capacitor c=3.9381e-17
C114 (\7\:VDD VSS) capacitor c=2.93601e-16
Rk31 (\4\:D D) resistor r=0.08242 c=0
Rk60 (\2\:VDD \3\:VDD) resistor r=0.08004 c=0
Rk61 (\3\:VDD \4\:VDD) resistor r=0.3732 c=0
Rk62 (\4\:VDD \5\:VDD) resistor r=0.2982 c=0
Rk63 (\5\:VDD \6\:VDD) resistor r=0.4602 c=0
Rk75 (\7\:VDD VDD) resistor r=0.1174 c=0
Rk64 (\6\:VDD \7\:VDD) resistor r=0.5428 c=0
Rk66 (\3\:VDD \10\:VDD) resistor r=0.246 c=0
Rk67 (\4\:VDD \12\:VDD) resistor r=0.2529 c=0
Rk68 (\6\:VDD \14\:VDD) resistor r=0.0433 c=0
Rk1 (CK \5\:CK) resistor r=0.0703 c=0
Rk38 (\9\:SE SE) resistor r=0.2325 c=0
Rk37 (\8\:SE \9\:SE) resistor r=0.3512 c=0
Rk40 (SI \4\:SI) resistor r=0.0119 c=0
Rk44 (\2\:VSS \3\:VSS) resistor r=0.04243 c=0
Rk45 (\3\:VSS \4\:VSS) resistor r=0.3958 c=0
Rk46 (\4\:VSS \5\:VSS) resistor r=0.3132 c=0
Rk47 (\5\:VSS \6\:VSS) resistor r=0.4035 c=0
Rk56 (\7\:VSS VSS) resistor r=0.1024 c=0
Rk48 (\6\:VSS \7\:VSS) resistor r=0.5387 c=0
Rk50 (\3\:VSS \10\:VSS) resistor r=0.2951 c=0
Rk51 (\4\:VSS \12\:VSS) resistor r=0.286 c=0
Rk52 (\6\:VSS \14\:VSS) resistor r=0.07381 c=0
Rk20 (\11\:CKb \12\:CKb) resistor r=0.5815 c=0
Rk21 (\12\:CKb \13\:CKb) resistor r=0.6021 c=0
Rk22 (\13\:CKb \15\:CKb) resistor r=1.5784 c=0
Rk23 (\12\:CKb \16\:CKb) resistor r=0.3493 c=0
Rk24 (\15\:CKb \18\:CKb) resistor r=0.2855 c=0
Rk7 (\18\:qbint \19\:qbint) resistor r=0.2925 c=0
Rk8 (\19\:qbint \20\:qbint) resistor r=0.0683 c=0
Rk9 (\20\:qbint \21\:qbint) resistor r=0.1858 c=0
Rk10 (\19\:qbint \23\:qbint) resistor r=0.188 c=0
Rk11 (\20\:qbint \25\:qbint) resistor r=0.2839 c=0
Rk12 (\9\:n30 \10\:n30) resistor r=0.516 c=0
Rk13 (\10\:n30 \11\:n30) resistor r=0.2866 c=0
Rk14 (\10\:n30 \13\:n30) resistor r=0.2095 c=0
Rk15 (\6\:mout \7\:mout) resistor r=0.09754 c=0
Rk16 (\7\:mout \9\:mout) resistor r=0.2708 c=0
Rk17 (\7\:mout \10\:mout) resistor r=0.1967 c=0
Rk25 (\10\:CKbb \11\:CKbb) resistor r=0.6188 c=0
Rk26 (\11\:CKbb \12\:CKbb) resistor r=0.2783 c=0
Rk27 (\11\:CKbb \13\:CKbb) resistor r=0.9614 c=0
Rk28 (\13\:CKbb \14\:CKbb) resistor r=0.1478 c=0
Rk29 (\12\:CKbb \16\:CKbb) resistor r=0.5819 c=0
Rk30 (\13\:CKbb \17\:CKbb) resistor r=0.04616 c=0
Rk18 (\5\:n20 \7\:n20) resistor r=0.416 c=0
Rk19 (\7\:n20 \8\:n20) resistor r=0.4113 c=0
Rk32 (\2\:Db \3\:Db) resistor r=0.6544 c=0
Rk33 (\3\:Db \4\:Db) resistor r=0.36 c=0
Rk34 (\4\:Db \6\:Db) resistor r=0.3483 c=0
Rk35 (\3\:Db \8\:Db) resistor r=0.6392 c=0
Rk36 (\4\:Db \10\:Db) resistor r=0.5483 c=0
Rk41 (\6\:SEb \7\:SEb) resistor r=0.6289 c=0
Rk42 (\7\:SEb \8\:SEb) resistor r=0.4055 c=0
Rk43 (\7\:SEb \10\:SEb) resistor r=0.02784 c=0
Rl42 (\1\:D \2\:D) resistor r=116.076 c=0
Rl43 (\2\:D \3\:D) resistor r=89.1533 c=0
Rl3 (\2\:CK \4\:CK) resistor r=40.0987 c=0
Rl2 (\2\:CK \3\:CK) resistor r=43.9449 c=0
Rl1 (\1\:CK \2\:CK) resistor r=1.2713 c=0
Rl52 (\6\:SE \7\:SE) resistor r=170.33 c=0
Rl51 (\5\:SE \6\:SE) resistor r=36.5385 c=0
Rl48 (\3\:SE \4\:SE) resistor r=35.3072 c=0
Rl44 (\1\:SE \2\:SE) resistor r=66.565 c=0
Rl50 (\2\:SI \3\:SI) resistor r=111.516 c=0
Rl49 (\1\:SI \2\:SI) resistor r=92.1028 c=0
Rl26 (CKb \2\:CKb) resistor r=153.412 c=0
Rl40 (\8\:CKb \9\:CKb) resistor r=26.1559 c=0
Rl34 (\4\:CKb \5\:CKb) resistor r=48.7687 c=0
Rl27 (\2\:CKb \3\:CKb) resistor r=26.1559 c=0
Rl38 (\6\:CKb \7\:CKb) resistor r=156.926 c=0
Rl41 (\7\:CKb \10\:CKb) resistor r=70.3874 c=0
Rl39 (\7\:CKb \8\:CKb) resistor r=241.784 c=0
Rl24 (\15\:qbint \17\:qbint) resistor r=104.785 c=0
Rl22 (\15\:qbint \14\:qbint) resistor r=47.0924 c=0
Rl23 (\15\:qbint \16\:qbint) resistor r=2.9709 c=0
Rl33 (\2\:mout \4\:mout) resistor r=114.4 c=0
Rl31 (mout \2\:mout) resistor r=37.477 c=0
Rl32 (\2\:mout \3\:mout) resistor r=2.7461 c=0
Rl28 (\3\:CKbb \4\:CKbb) resistor r=66.0764 c=0
Rl25 (CKbb \2\:CKbb) resistor r=57.6695 c=0
Rl37 (\6\:CKbb \8\:CKbb) resistor r=39.7465 c=0
Rl36 (\6\:CKbb \7\:CKbb) resistor r=156.166 c=0
Rl35 (\5\:CKbb \6\:CKbb) resistor r=27.7015 c=0
Rl30 (\2\:n20 \3\:n20) resistor r=63.8117 c=0
Rl29 (n20 \2\:n20) resistor r=94.3522 c=0
Rl45 (SEb \2\:SEb) resistor r=40.1031 c=0
Rl46 (\2\:SEb \3\:SEb) resistor r=193.515 c=0
Rl47 (\2\:SEb \4\:SEb) resistor r=3.3229 c=0
Rz19 (\2\:VDD \1\:VDD) resistor r=25 c=0
Rz20 (\5\:VDD \1\:VDD) resistor r=6.25 c=0
Rz21 (\7\:VDD \1\:VDD) resistor r=6.25 c=0
Rz12 (\10\:VSS \9\:VSS) resistor r=75 c=0
Rz13 (\12\:VSS \11\:VSS) resistor r=75 c=0
Rz14 (\14\:VSS \13\:VSS) resistor r=75 c=0
Rz7 (\14\:CKb \15\:CKb) resistor r=75 c=0
Rz3 (\23\:qbint \22\:qbint) resistor r=75 c=0
Rz4 (\9\:n30 \8\:n30) resistor r=75 c=0
Rz5 (\5\:mout \6\:mout) resistor r=75 c=0
Rz8 (\15\:CKbb \16\:CKbb) resistor r=75 c=0
Rz6 (\4\:n20 \5\:n20) resistor r=75 c=0
Rz9 (Db \2\:Db) resistor r=75 c=0
Rz10 (\7\:Db \8\:Db) resistor r=75 c=0
Rz11 (\5\:SEb \6\:SEb) resistor r=75 c=0
Ry15 (\10\:VDD \9\:VDD) resistor r=62 c=0
Ry16 (\12\:VDD \11\:VDD) resistor r=62 c=0
Ry17 (\14\:VDD \13\:VDD) resistor r=62 c=0
Ry12 (\2\:VSS \1\:VSS) resistor r=20.6667 c=0
Ry13 (\5\:VSS \1\:VSS) resistor r=5.1667 c=0
Ry14 (\7\:VSS \1\:VSS) resistor r=5.1667 c=0
Ry7 (\17\:CKb \18\:CKb) resistor r=62 c=0
Ry3 (\25\:qbint \24\:qbint) resistor r=31 c=0
Ry4 (\13\:n30 \12\:n30) resistor r=62 c=0
Ry5 (\8\:mout \9\:mout) resistor r=62 c=0
Ry8 (\9\:CKbb \10\:CKbb) resistor r=62 c=0
Ry6 (\6\:n20 \7\:n20) resistor r=62 c=0
Ry9 (\5\:Db \6\:Db) resistor r=62 c=0
Ry10 (\9\:Db \10\:Db) resistor r=62 c=0
Ry11 (\9\:SEb \10\:SEb) resistor r=62 c=0
Rx13 (\2\:D \4\:D) resistor r=45 c=0
Rx1 (\1\:CK \5\:CK) resistor r=45 c=0
Rx16 (\6\:SE SE) resistor r=45 c=0
Rx14 (\1\:SE \8\:SE) resistor r=45 c=0
Rx15 (\4\:SE \9\:SE) resistor r=45 c=0
Rx17 (\2\:SI \4\:SI) resistor r=45 c=0
Rx7 (\8\:CKb \11\:CKb) resistor r=45 c=0
Rx8 (\3\:CKb \13\:CKb) resistor r=45 c=0
Rx9 (\5\:CKb \16\:CKb) resistor r=45 c=0
Rx2 (\18\:qbint \16\:qbint) resistor r=45 c=0
Rx3 (\21\:qbint qbint) resistor r=45 c=0
Rx4 (\11\:n30 n30) resistor r=45 c=0
Rx5 (\3\:mout \10\:mout) resistor r=45 c=0
Rx10 (\5\:CKbb \12\:CKbb) resistor r=45 c=0
Rx11 (CKbb \14\:CKbb) resistor r=45 c=0
Rx12 (\4\:CKbb \17\:CKbb) resistor r=45 c=0
Rx6 (\2\:n20 \8\:n20) resistor r=45 c=0
Rx18 (\4\:SEb \8\:SEb) resistor r=45 c=0
mn20 (\14\:CKb \3\:CK \7\:VSS VSS) g45n1hvt w=(1.45e-07) l=4.5e-08 nf=1 \
        as=6.345e-14 ad=2.03e-14 ps=1.68e-06 pd=5.7e-07 nrd=1.16667 \
        nrs=1.16667 sa=1.4e-07 sb=2e-06 sd=160n sca=23.279 scb=0.0230742 \
        scc=0.00267719 m=(1)
mn50 (n7 \14\:qbint \7\:VSS VSS) g45n1hvt w=(1.45e-07) l=4.5e-08 nf=1 \
        as=5.49e-14 ad=4.495e-14 ps=1.6e-06 pd=9.1e-07 nrd=1.16667 \
        nrs=1.16667 sa=1.72e-06 sb=1.72e-06 sd=160n sca=23.279 \
        scb=0.0230742 scc=0.00267719 m=(1)
mn51 (\8\:n30 \2\:CKb n7 VSS) g45n1hvt w=(1.45e-07) l=4.5e-08 nf=1 \
        as=4.495e-14 ad=2.32e-14 ps=9.1e-07 pd=6.1e-07 nrd=1.16667 \
        nrs=1.16667 sa=2e-06 sb=1.365e-06 sd=160n sca=23.279 scb=0.0230742 \
        scc=0.00267719 m=(1)
mn40 (\5\:mout \3\:CKbb \8\:n30 VSS) g45n1hvt w=(1.45e-07) l=4.5e-08 nf=1 \
        as=2.32e-14 ad=3.697e-14 ps=6.1e-07 pd=8e-07 nrd=1.16667 \
        nrs=1.16667 sa=2e-06 sb=1.16e-06 sd=160n sca=23.279 scb=0.0230742 \
        scc=0.00267719 m=(1)
mn30 (\5\:mout n20 \13\:VSS VSS) g45n1hvt w=(1.45e-07) l=4.5e-08 nf=1 \
        as=5.43e-14 ad=3.697e-14 ps=1.64e-06 pd=8e-07 nrd=1.16667 \
        nrs=1.16667 sa=2e-06 sb=8.6e-07 sd=160n sca=23.279 scb=0.0230742 \
        scc=0.00267719 m=(1)
mn36 (n5 mout \13\:VSS VSS) g45n1hvt w=(1.45e-07) l=4.5e-08 nf=1 \
        as=5.43e-14 ad=1.885e-14 ps=1.64e-06 pd=5.5e-07 nrd=1.16667 \
        nrs=1.16667 sa=2e-06 sb=6.65e-07 sd=160n sca=23.279 scb=0.0230742 \
        scc=0.00267719 m=(1)
mn35 (\4\:n20 \7\:CKbb n5 VSS) g45n1hvt w=(1.45e-07) l=4.5e-08 nf=1 \
        as=1.885e-14 ad=4.422e-14 ps=5.5e-07 pd=9e-07 nrd=1.16667 \
        nrs=1.16667 sa=2e-06 sb=4.9e-07 sd=160n sca=23.279 scb=0.0230742 \
        scc=0.00267719 m=(1)
mn25 (\7\:Db \9\:CKb \4\:n20 VSS) g45n1hvt w=(1.45e-07) l=4.5e-08 nf=1 \
        as=4.422e-14 ad=2.03e-14 ps=9e-07 pd=5.7e-07 nrd=1.16667 \
        nrs=1.16667 sa=2e-06 sb=1.4e-07 sd=160n sca=23.279 scb=0.0230742 \
        scc=0.00267719 m=(1)
mn21 (\15\:CKbb \10\:CKb \11\:VSS VSS) g45n1hvt w=(1.45e-07) l=4.5e-08 \
        nf=1 as=2.32e-14 ad=6.452e-14 ps=6.1e-07 pd=1.18e-06 nrd=1.16667 \
        nrs=1.16667 sa=4.45e-07 sb=1.175e-06 sd=160n sca=11.7118 \
        scb=0.0116498 scc=0.000458536 m=(1)
mn11 (n1 \3\:D \11\:VSS VSS) g45n1hvt w=(1.45e-07) l=4.5e-08 nf=1 \
        as=2.32e-14 ad=3.77e-14 ps=6.1e-07 pd=8.1e-07 nrd=1.16667 \
        nrs=1.16667 sa=6.5e-07 sb=9.7e-07 sd=160n sca=11.7118 \
        scb=0.0116498 scc=0.000458536 m=(1)
mn12 (Db \3\:SEb n1 VSS) g45n1hvt w=(1.45e-07) l=4.5e-08 nf=1 as=3.77e-14 \
        ad=2.32e-14 ps=8.1e-07 pd=6.1e-07 nrd=1.16667 nrs=1.16667 \
        sa=9.55e-07 sb=6.65e-07 sd=160n sca=11.7118 scb=0.0116498 \
        scc=0.000458536 m=(1)
mn14 (Db \3\:SE n3 VSS) g45n1hvt w=(1.45e-07) l=4.5e-08 nf=1 as=8.7e-15 \
        ad=2.32e-14 ps=4.1e-07 pd=6.1e-07 nrd=1.16667 nrs=1.16667 \
        sa=1.16e-06 sb=4.6e-07 sd=160n sca=11.7118 scb=0.0116498 \
        scc=0.000458536 m=(1)
mn13 (n3 \1\:SI \9\:VSS VSS) g45n1hvt w=(1.45e-07) l=4.5e-08 nf=1 \
        as=2.465e-14 ad=8.7e-15 ps=6.3e-07 pd=4.1e-07 nrd=1.16667 \
        nrs=1.16667 sa=1.265e-06 sb=3.55e-07 sd=160n sca=11.7118 \
        scb=0.0116498 scc=0.000458536 m=(1)
mn10 (\5\:SEb \5\:SE \9\:VSS VSS) g45n1hvt w=(1.45e-07) l=4.5e-08 nf=1 \
        as=2.465e-14 ad=2.03e-14 ps=6.3e-07 pd=5.7e-07 nrd=1.16667 \
        nrs=1.16667 sa=1.48e-06 sb=1.4e-07 sd=160n sca=11.7118 \
        scb=0.0116498 scc=0.000458536 m=(1)
mn55_1__rcx (Q qbint \7\:VSS VSS) g45n1hvt w=(2.6e-07) l=4.5e-08 nf=1 \
        as=8.688e-14 ad=4.16e-14 ps=1.62e-06 pd=8.4e-07 nrd=1.16667 \
        nrs=1.16667 sa=2.53365e-07 sb=1.5826e-06 sd=160n sca=17.5885 \
        scb=0.0172826 scc=0.00162584 m=(4)
mn45_1__rcx (\22\:qbint n30 \7\:VSS VSS) g45n1hvt w=(2.05e-07) l=4.5e-08 \
        nf=1 as=7.387e-14 ad=3.383e-14 ps=1.6e-06 pd=7.4e-07 nrd=1.16667 \
        nrs=1.16667 sa=1.23451e-06 sb=1.50537e-06 sd=160n sca=19.867 \
        scb=0.0198061 scc=0.00201945 m=(2)
mp55_1__rcx (Q qbint \7\:VDD VDD) g45p1hvt w=(3.9e-07) l=4.5e-08 nf=1 \
        as=6.506e-14 ad=6.24e-14 ps=1.13e-06 pd=1.1e-06 nrd=1.16667 \
        nrs=1.16667 sa=2.69551e-07 sb=1.53878e-06 sd=160n sca=33.5925 \
        scb=0.0236177 scc=0.00338536 m=(4)
mp45 (\24\:qbint n30 \7\:VDD VDD) g45p1hvt w=(3.1e-07) l=4.5e-08 nf=1 \
        as=6.452e-14 ad=4.96e-14 ps=1.12e-06 pd=9.4e-07 nrd=1.16667 \
        nrs=1.16667 sa=1.09234e-06 sb=1.48056e-06 sd=160n sca=17.3904 \
        scb=0.0162056 scc=0.00137566 m=(2)
ends SDFFQX4
// End of subcircuit definition.
