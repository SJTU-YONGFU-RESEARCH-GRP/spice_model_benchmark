// Generated for: spectre (May  1 09:14:12 2013 )
// Library name: gsclib045_lvt
// Cell name: DFFTRXL
// View name: extracted

simulator lang=spectre

subckt DFFTRXL CK D Q QN RN VDD VSS
mp57 (\1\:QN \4\:qint \19\:VDD VDD) g45p1lvt w=(2.15e-07) l=4.5e-08 nf=1 \
        as=5.515e-14 ad=3.762e-14 ps=1.45e-06 pd=7.8e-07 nrd=1.16667 \
        nrs=1.16667 sa=1.75e-07 sb=3.35e-07 sd=160n sca=48.9651 \
        scb=0.0318882 scc=0.00591085 m=(1)
mp56 (\5\:qint \7\:qbint \19\:VDD VDD) g45p1lvt w=(2.15e-07) l=4.5e-08 \
        nf=1 as=5.515e-14 ad=3.01e-14 ps=1.45e-06 pd=7.1e-07 nrd=1.16667 \
        nrs=1.16667 sa=3.7e-07 sb=1.4e-07 sd=160n sca=46.9517 scb=0.029008 \
        scc=0.00588492 m=(1)
mp55 (\3\:Q \5\:qbint \17\:VDD VDD) g45p1lvt w=(2.15e-07) l=4.5e-08 nf=1 \
        as=5.89e-14 ad=3.117e-14 ps=1.6e-06 pd=7.2e-07 nrd=1.16667 \
        nrs=1.16667 sa=1.45e-07 sb=3.35e-07 sd=160n sca=13.9534 \
        scb=0.0134231 scc=0.000640578 m=(1)
mp20 (\13\:CKb \3\:CK \17\:VDD VDD) g45p1lvt w=(2.15e-07) l=4.5e-08 nf=1 \
        as=5.89e-14 ad=3.01e-14 ps=1.6e-06 pd=7.1e-07 nrd=1.16667 \
        nrs=1.16667 sa=3.4e-07 sb=1.4e-07 sd=160n sca=13.9534 \
        scb=0.0134231 scc=0.000640578 m=(1)
mp45 (\16\:qbint \3\:n30 \15\:VDD VDD) g45p1lvt w=(2.15e-07) l=4.5e-08 \
        nf=1 as=8.63e-14 ad=3.01e-14 ps=1.52e-06 pd=7.1e-07 nrd=1.16667 \
        nrs=1.16667 sa=1.4e-07 sb=1.755e-06 sd=160n sca=12.1244 \
        scb=0.0107968 scc=0.000332109 m=(1)
mp50 (n36 \8\:qbint \15\:VDD VDD) g45p1lvt w=(2.15e-07) l=4.5e-08 nf=1 \
        as=8.63e-14 ad=3.118e-14 ps=1.52e-06 pd=7.2e-07 nrd=1.16667 \
        nrs=1.16667 sa=4.05e-07 sb=1.49e-06 sd=160n sca=12.1244 \
        scb=0.0107968 scc=0.000332109 m=(1)
mp51 (\8\:n30 \2\:CKbb n36 VDD) g45p1lvt w=(2.15e-07) l=4.5e-08 nf=1 \
        as=3.118e-14 ad=3.44e-14 ps=7.2e-07 pd=7.5e-07 nrd=1.16667 \
        nrs=1.16667 sa=5.95e-07 sb=1.3e-06 sd=160n sca=12.1244 \
        scb=0.0107968 scc=0.000332109 m=(1)
mp40 (\8\:n30 \2\:CKb \6\:mout VDD) g45p1lvt w=(2.15e-07) l=4.5e-08 nf=1 \
        as=7.203e-14 ad=3.44e-14 ps=1.1e-06 pd=7.5e-07 nrd=1.16667 \
        nrs=1.16667 sa=8e-07 sb=1.095e-06 sd=160n sca=12.1244 \
        scb=0.0107968 scc=0.000332109 m=(1)
mp30 (\6\:mout \3\:n20 \13\:VDD VDD) g45p1lvt w=(2.15e-07) l=4.5e-08 \
        nf=1 as=8.63e-14 ad=7.203e-14 ps=1.52e-06 pd=1.1e-06 nrd=1.16667 \
        nrs=1.16667 sa=1.18e-06 sb=7.15e-07 sd=160n sca=12.1244 \
        scb=0.0107968 scc=0.000332109 m=(1)
mp35 (n26 mout \13\:VDD VDD) g45p1lvt w=(2.15e-07) l=4.5e-08 nf=1 \
        as=8.63e-14 ad=1.29e-14 ps=1.52e-06 pd=5.5e-07 nrd=1.16667 \
        nrs=1.16667 sa=1.445e-06 sb=4.5e-07 sd=160n sca=12.1244 \
        scb=0.0107968 scc=0.000332109 m=(1)
mp36 (\9\:n20 \7\:CKb n26 VDD) g45p1lvt w=(2.15e-07) l=4.5e-08 nf=1 \
        as=1.29e-14 ad=3.44e-14 ps=5.5e-07 pd=7.5e-07 nrd=1.16667 \
        nrs=1.16667 sa=1.55e-06 sb=3.45e-07 sd=160n sca=12.1244 \
        scb=0.0107968 scc=0.000332109 m=(1)
mp25 (\9\:n20 \7\:CKbb \8\:Db VDD) g45p1lvt w=(2.15e-07) l=4.5e-08 nf=1 \
        as=3.01e-14 ad=3.44e-14 ps=7.1e-07 pd=7.5e-07 nrd=1.16667 \
        nrs=1.16667 sa=1.755e-06 sb=1.4e-07 sd=160n sca=12.1244 \
        scb=0.0107968 scc=0.000332109 m=(1)
mp21 (\9\:CKbb \8\:CKb \11\:VDD VDD) g45p1lvt w=(2.15e-07) l=4.5e-08 \
        nf=1 as=5.838e-14 ad=3.01e-14 ps=1.48e-06 pd=7.1e-07 nrd=1.16667 \
        nrs=1.16667 sa=1.4e-07 sb=5.15e-07 sd=160n sca=46.8621 \
        scb=0.0289219 scc=0.00588474 m=(1)
mp0 (\3\:Db \4\:RN \11\:VDD VDD) g45p1lvt w=(2.15e-07) l=4.5e-08 nf=1 \
        as=5.838e-14 ad=3.44e-14 ps=1.48e-06 pd=7.5e-07 nrd=1.16667 \
        nrs=1.16667 sa=3.5e-07 sb=3.05e-07 sd=160n sca=48.9651 \
        scb=0.0318882 scc=0.00591085 m=(1)
mp1 (\3\:Db \1\:D \1\:VDD VDD) g45p1lvt w=(2.15e-07) l=4.5e-08 nf=1 \
        as=4.44e-14 ad=3.44e-14 ps=1.35e-06 pd=7.5e-07 nrd=1.16667 \
        nrs=1.16667 sa=5.55e-07 sb=1e-07 sd=160n sca=57.0065 scb=0.0445545 \
        scc=0.00681945 m=(1)
C1 (D VSS) capacitor c=5.53782e-17
C2 (QN VSS) capacitor c=2.29681e-17
C3 (RN VSS) capacitor c=6.45708e-17
C4 (Q VSS) capacitor c=5.11104e-17
C5 (VDD VSS) capacitor c=2.80173e-16
C6 (CK VSS) capacitor c=5.43771e-17
C7 (qint VSS) capacitor c=1.99284e-17
C8 (qbint VSS) capacitor c=1.8263e-17
C9 (CKb VSS) capacitor c=8.19209e-17
C10 (n30 VSS) capacitor c=3.84709e-17
C11 (n35 VSS) capacitor c=5.08221e-18
C12 (mout VSS) capacitor c=8.47423e-17
C13 (CKbb VSS) capacitor c=5.1998e-17
C14 (n20 VSS) capacitor c=4.78685e-17
C15 (Db VSS) capacitor c=6.18428e-17
C16 (n0 VSS) capacitor c=7.73859e-19
C17 (n36 VSS) capacitor c=1.63392e-18
C18 (\1\:D VSS) capacitor c=2.99561e-17
C19 (\4\:RN VSS) capacitor c=4.25943e-17
C20 (\8\:CKb VSS) capacitor c=4.33039e-17
C21 (\7\:CKbb VSS) capacitor c=4.14188e-17
C22 (\7\:CKb VSS) capacitor c=7.78361e-17
C23 (\3\:n20 VSS) capacitor c=3.55012e-17
C24 (\2\:CKb VSS) capacitor c=4.44446e-17
C25 (\2\:CKbb VSS) capacitor c=4.32976e-17
C26 (\8\:qbint VSS) capacitor c=5.4143e-17
C27 (\3\:n30 VSS) capacitor c=3.12859e-17
C28 (\3\:CK VSS) capacitor c=3.11117e-17
C29 (\5\:qbint VSS) capacitor c=3.87673e-17
C30 (\7\:qbint VSS) capacitor c=3.58748e-17
C31 (\4\:qint VSS) capacitor c=3.81262e-17
C32 (\3\:D VSS) capacitor c=2.99285e-17
C33 (\1\:RN VSS) capacitor c=4.11022e-17
C34 (\4\:CKb VSS) capacitor c=2.65518e-17
C35 (\9\:CKb VSS) capacitor c=2.96691e-17
C36 (\5\:CKbb VSS) capacitor c=9.19415e-17
C37 (\3\:mout VSS) capacitor c=5.5672e-17
C38 (\3\:CKbb VSS) capacitor c=3.66645e-17
C39 (\11\:qbint VSS) capacitor c=2.88151e-17
C40 (\1\:CK VSS) capacitor c=4.11448e-17
C41 (\4\:qbint VSS) capacitor c=2.62604e-17
C42 (\3\:qint VSS) capacitor c=3.10033e-17
C43 (\2\:D VSS) capacitor c=2.89161e-17
C44 (\3\:RN VSS) capacitor c=4.14978e-17
C45 (\8\:CKbb VSS) capacitor c=4.84314e-17
C46 (\10\:CKb VSS) capacitor c=3.18292e-17
C47 (\6\:CKbb VSS) capacitor c=3.06885e-17
C48 (\2\:mout VSS) capacitor c=6.72024e-17
C49 (\4\:n20 VSS) capacitor c=5.52088e-17
C50 (\4\:CKbb VSS) capacitor c=3.5878e-17
C51 (\3\:CKb VSS) capacitor c=2.19988e-17
C52 (\10\:qbint VSS) capacitor c=2.5963e-17
C53 (\2\:n30 VSS) capacitor c=3.92941e-17
C54 (\2\:CK VSS) capacitor c=3.13585e-17
C55 (\1\:VDD VSS) capacitor c=1.30911e-17
C56 (\3\:Db VSS) capacitor c=9.06594e-17
C57 (\11\:VDD VSS) capacitor c=2.13178e-17
C58 (\9\:CKbb VSS) capacitor c=5.96949e-17
C59 (\8\:Db VSS) capacitor c=2.24651e-17
C60 (\9\:n20 VSS) capacitor c=3.57644e-17
C61 (\13\:VDD VSS) capacitor c=2.39587e-17
C62 (\6\:mout VSS) capacitor c=3.6927e-17
C63 (\8\:n30 VSS) capacitor c=3.96585e-17
C64 (\15\:VDD VSS) capacitor c=2.48041e-17
C65 (\16\:qbint VSS) capacitor c=4.55158e-17
C66 (\13\:CKb VSS) capacitor c=1.45715e-16
C67 (\17\:VDD VSS) capacitor c=1.28233e-17
C68 (\3\:Q VSS) capacitor c=4.97251e-17
C69 (\5\:qint VSS) capacitor c=3.26496e-17
C70 (\19\:VDD VSS) capacitor c=1.18029e-17
C71 (\1\:QN VSS) capacitor c=1.5866e-17
C72 (\4\:VDD VSS) capacitor c=5.07556e-17
C73 (\11\:CKbb VSS) capacitor c=7.18765e-17
C74 (\6\:Db VSS) capacitor c=7.47025e-17
C75 (\7\:n20 VSS) capacitor c=5.08648e-17
C76 (\8\:mout VSS) capacitor c=3.69588e-17
C77 (\4\:n30 VSS) capacitor c=7.62256e-17
C78 (\14\:qbint VSS) capacitor c=8.55675e-17
C79 (\11\:CKb VSS) capacitor c=7.51951e-17
C80 (\1\:Q VSS) capacitor c=5.20201e-17
C81 (\9\:qint VSS) capacitor c=3.12612e-17
C82 (\3\:QN VSS) capacitor c=3.52256e-17
C83 (\2\:qint VSS) capacitor c=1.25668e-17
C84 (\2\:qbint VSS) capacitor c=3.84479e-17
C85 (\3\:qbint VSS) capacitor c=3.72934e-17
C86 (\9\:qbint VSS) capacitor c=2.9314e-17
C87 (\5\:CKb VSS) capacitor c=4.1852e-17
C88 (\6\:CKb VSS) capacitor c=7.22505e-17
C89 (\7\:qint VSS) capacitor c=3.28649e-17
C90 (\8\:qint VSS) capacitor c=2.85862e-17
C91 (\4\:CK VSS) capacitor c=8.07667e-17
C92 (\12\:qbint VSS) capacitor c=6.18426e-17
C93 (\13\:qbint VSS) capacitor c=4.36404e-17
C94 (\18\:qbint VSS) capacitor c=1.12769e-16
C95 (\6\:n30 VSS) capacitor c=8.39204e-17
C96 (\7\:n30 VSS) capacitor c=5.19029e-17
C97 (\4\:mout VSS) capacitor c=3.856e-17
C98 (\5\:mout VSS) capacitor c=5.4457e-17
C99 (\15\:CKb VSS) capacitor c=1.56639e-16
C100 (\16\:CKb VSS) capacitor c=7.74459e-17
C101 (\5\:n20 VSS) capacitor c=4.59979e-17
C102 (\6\:n20 VSS) capacitor c=5.10753e-17
C103 (\13\:CKbb VSS) capacitor c=6.67456e-17
C104 (\14\:CKbb VSS) capacitor c=9.17856e-17
C105 (\15\:CKbb VSS) capacitor c=9.50477e-17
C106 (\16\:CKbb VSS) capacitor c=6.77652e-17
C107 (\17\:CKbb VSS) capacitor c=6.27164e-17
C108 (\5\:RN VSS) capacitor c=5.79494e-17
C109 (\4\:D VSS) capacitor c=7.65171e-17
C110 (\5\:Db VSS) capacitor c=7.44926e-17
C111 (\3\:VDD VSS) capacitor c=1.82742e-17
C112 (\6\:VDD VSS) capacitor c=4.12718e-17
C113 (\7\:VDD VSS) capacitor c=4.04552e-17
C114 (\9\:VDD VSS) capacitor c=7.59777e-18
C115 (\10\:VDD VSS) capacitor c=9.77877e-18
Rk32 (\4\:D D) resistor r=0.1747 c=0
Rk2 (\4\:QN QN) resistor r=0.0927 c=0
Rk1 (\2\:QN \4\:QN) resistor r=0.2238 c=0
Rk31 (RN \5\:RN) resistor r=0.187 c=0
Rk6 (\2\:Q Q) resistor r=0.16 c=0
Rk7 (Q \4\:Q) resistor r=0.152 c=0
Rk37 (\2\:VDD \3\:VDD) resistor r=0.3948 c=0
Rk38 (\3\:VDD \5\:VDD) resistor r=0.2951 c=0
Rk39 (\5\:VDD \6\:VDD) resistor r=0.2676 c=0
Rk40 (\6\:VDD \7\:VDD) resistor r=0.5201 c=0
Rk41 (\7\:VDD \8\:VDD) resistor r=0.3627 c=0
Rk42 (\8\:VDD \9\:VDD) resistor r=0.04985 c=0
Rk44 (\10\:VDD VDD) resistor r=0.2323 c=0
Rk43 (\9\:VDD \10\:VDD) resistor r=0.2674 c=0
Rk45 (\3\:VDD \12\:VDD) resistor r=0.222 c=0
Rk46 (\6\:VDD \14\:VDD) resistor r=0.1017 c=0
Rk47 (\7\:VDD \16\:VDD) resistor r=0.1017 c=0
Rk48 (\9\:VDD \18\:VDD) resistor r=0.07311 c=0
Rk49 (\10\:VDD \20\:VDD) resistor r=0.222 c=0
Rk50 (\2\:VSS \4\:VSS) resistor r=0.3847 c=0
Rk51 (\4\:VSS \5\:VSS) resistor r=0.2616 c=0
Rk52 (\5\:VSS \6\:VSS) resistor r=0.4966 c=0
Rk53 (\6\:VSS \7\:VSS) resistor r=0.3902 c=0
Rk54 (\7\:VSS \8\:VSS) resistor r=0.04485 c=0
Rk56 (\9\:VSS VSS) resistor r=0.2323 c=0
Rk55 (\8\:VSS \9\:VSS) resistor r=0.2724 c=0
Rk57 (\5\:VSS \11\:VSS) resistor r=0.04318 c=0
Rk58 (\6\:VSS \13\:VSS) resistor r=0.3694 c=0
Rk59 (\8\:VSS \15\:VSS) resistor r=0.07311 c=0
Rk60 (\9\:VSS \17\:VSS) resistor r=0.07311 c=0
Rk8 (\4\:CK CK) resistor r=0.2418 c=0
Rk3 (\6\:qint \7\:qint) resistor r=0.1173 c=0
Rk4 (\7\:qint \8\:qint) resistor r=0.1188 c=0
Rk5 (\7\:qint \10\:qint) resistor r=0.1053 c=0
Rk9 (\12\:qbint \13\:qbint) resistor r=0.2452 c=0
Rk10 (\13\:qbint \15\:qbint) resistor r=0.2569 c=0
Rk11 (\13\:qbint \17\:qbint) resistor r=0.287 c=0
Rk12 (\15\:qbint \18\:qbint) resistor r=0.8078 c=0
Rk19 (\12\:CKb \14\:CKb) resistor r=0.476 c=0
Rk20 (\14\:CKb \15\:CKb) resistor r=0.952 c=0
Rk21 (\15\:CKb \16\:CKb) resistor r=0.5262 c=0
Rk13 (\5\:n30 \6\:n30) resistor r=0.4647 c=0
Rk14 (\6\:n30 \7\:n30) resistor r=0.2175 c=0
Rk15 (\6\:n30 \9\:n30) resistor r=0.2739 c=0
Rk16 (\4\:mout \5\:mout) resistor r=0.1639 c=0
Rk17 (\5\:mout \7\:mout) resistor r=0.2791 c=0
Rk18 (\5\:mout \9\:mout) resistor r=0.08273 c=0
Rk25 (\10\:CKbb \12\:CKbb) resistor r=0.2997 c=0
Rk26 (\12\:CKbb \13\:CKbb) resistor r=0.3913 c=0
Rk27 (\13\:CKbb \14\:CKbb) resistor r=0.1843 c=0
Rk28 (\14\:CKbb \15\:CKbb) resistor r=0.682 c=0
Rk29 (\13\:CKbb \16\:CKbb) resistor r=0.3477 c=0
Rk30 (\15\:CKbb \17\:CKbb) resistor r=0.2586 c=0
Rk22 (\5\:n20 \6\:n20) resistor r=0.2083 c=0
Rk23 (\6\:n20 \8\:n20) resistor r=0.237 c=0
Rk24 (\6\:n20 \10\:n20) resistor r=0.176 c=0
Rk33 (\2\:Db \4\:Db) resistor r=0.4546 c=0
Rk34 (\4\:Db \5\:Db) resistor r=0.4775 c=0
Rk35 (\5\:Db \7\:Db) resistor r=0.3903 c=0
Rk36 (\5\:Db \9\:Db) resistor r=0.08888 c=0
Rl37 (\1\:D \2\:D) resistor r=33.7834 c=0
Rl38 (\2\:D \3\:D) resistor r=24.7951 c=0
Rl36 (\2\:RN \4\:RN) resistor r=43.2462 c=0
Rl34 (\1\:RN \2\:RN) resistor r=47.0924 c=0
Rl35 (\2\:RN \3\:RN) resistor r=2.9709 c=0
Rl11 (\2\:CK \3\:CK) resistor r=26.3736 c=0
Rl10 (\1\:CK \2\:CK) resistor r=100 c=0
Rl3 (\2\:qint \4\:qint) resistor r=49.7141 c=0
Rl2 (\2\:qint \3\:qint) resistor r=34.3295 c=0
Rl1 (qint \2\:qint) resistor r=0.5213 c=0
Rl7 (\2\:qbint \5\:qbint) resistor r=104.301 c=0
Rl4 (qbint \2\:qbint) resistor r=38.9161 c=0
Rl8 (\2\:qbint \6\:qbint) resistor r=3.9233 c=0
Rl9 (\3\:qbint \7\:qbint) resistor r=60.772 c=0
Rl6 (\3\:qbint \4\:qbint) resistor r=28.0797 c=0
Rl5 (\2\:qbint \3\:qbint) resistor r=146.04 c=0
Rl14 (\8\:qbint \9\:qbint) resistor r=111.253 c=0
Rl16 (\9\:qbint \11\:qbint) resistor r=47.791 c=0
Rl15 (\9\:qbint \10\:qbint) resistor r=2.7666 c=0
Rl18 (CKb \2\:CKb) resistor r=199.566 c=0
Rl33 (\7\:CKb \10\:CKb) resistor r=24.2328 c=0
Rl19 (\2\:CKb \3\:CKb) resistor r=24.2328 c=0
Rl31 (\5\:CKb \8\:CKb) resistor r=51.3446 c=0
Rl28 (\4\:CKb \5\:CKb) resistor r=47.0285 c=0
Rl30 (\6\:CKb \7\:CKb) resistor r=172.62 c=0
Rl32 (\6\:CKb \9\:CKb) resistor r=30.4507 c=0
Rl29 (\5\:CKb \6\:CKb) resistor r=201.946 c=0
Rl13 (\2\:n30 \3\:n30) resistor r=29.9451 c=0
Rl12 (n30 \2\:n30) resistor r=113.462 c=0
Rl24 (mout \2\:mout) resistor r=111.139 c=0
Rl25 (\2\:mout \3\:mout) resistor r=24.2328 c=0
Rl27 (\7\:CKbb \8\:CKbb) resistor r=64.6174 c=0
Rl26 (\5\:CKbb \6\:CKbb) resistor r=46.8456 c=0
Rl20 (\3\:CKbb \4\:CKbb) resistor r=37.2302 c=0
Rl17 (CKbb \2\:CKbb) resistor r=64.5404 c=0
Rl22 (\2\:n20 \3\:n20) resistor r=67.6161 c=0
Rl21 (n20 \2\:n20) resistor r=85.2786 c=0
Rl23 (\2\:n20 \4\:n20) resistor r=4.3511 c=0
Rz1 (\3\:QN \4\:QN) resistor r=75 c=0
Rz3 (\1\:Q \2\:Q) resistor r=75 c=0
Rz12 (\4\:VDD \5\:VDD) resistor r=6.8182 c=0
Rz13 (\4\:VDD \8\:VDD) resistor r=6.25 c=0
Rz14 (\1\:VSS \2\:VSS) resistor r=75 c=0
Rz15 (\10\:VSS \11\:VSS) resistor r=75 c=0
Rz16 (\12\:VSS \13\:VSS) resistor r=75 c=0
Rz17 (\14\:VSS \15\:VSS) resistor r=75 c=0
Rz18 (\16\:VSS \17\:VSS) resistor r=75 c=0
Rz2 (\9\:qint \10\:qint) resistor r=75 c=0
Rz4 (\14\:qbint \15\:qbint) resistor r=75 c=0
Rz7 (\11\:CKb \12\:CKb) resistor r=75 c=0
Rz5 (\4\:n30 \5\:n30) resistor r=75 c=0
Rz6 (\8\:mout \9\:mout) resistor r=75 c=0
Rz9 (\11\:CKbb \12\:CKbb) resistor r=75 c=0
Rz8 (\7\:n20 \8\:n20) resistor r=75 c=0
Rz10 (Db \2\:Db) resistor r=75 c=0
Rz11 (\6\:Db \7\:Db) resistor r=75 c=0
Ry1 (\1\:QN \2\:QN) resistor r=62 c=0
Ry3 (\3\:Q \4\:Q) resistor r=62 c=0
Ry12 (\1\:VDD \2\:VDD) resistor r=62 c=0
Ry13 (\11\:VDD \12\:VDD) resistor r=62 c=0
Ry14 (\13\:VDD \14\:VDD) resistor r=62 c=0
Ry15 (\15\:VDD \16\:VDD) resistor r=62 c=0
Ry16 (\17\:VDD \18\:VDD) resistor r=62 c=0
Ry17 (\19\:VDD \20\:VDD) resistor r=62 c=0
Ry18 (\3\:VSS \4\:VSS) resistor r=5.6364 c=0
Ry19 (\3\:VSS \7\:VSS) resistor r=5.1667 c=0
Ry2 (\5\:qint \6\:qint) resistor r=62 c=0
Ry4 (\16\:qbint \17\:qbint) resistor r=62 c=0
Ry7 (\13\:CKb \14\:CKb) resistor r=62 c=0
Ry5 (\8\:n30 \9\:n30) resistor r=62 c=0
Ry6 (\6\:mout \7\:mout) resistor r=62 c=0
Ry9 (\9\:CKbb \10\:CKbb) resistor r=62 c=0
Ry8 (\9\:n20 \10\:n20) resistor r=62 c=0
Ry10 (\3\:Db \4\:Db) resistor r=62 c=0
Ry11 (\8\:Db \9\:Db) resistor r=62 c=0
Rx15 (\2\:D \4\:D) resistor r=45 c=0
Rx14 (\3\:RN \5\:RN) resistor r=45 c=0
Rx2 (\2\:CK \4\:CK) resistor r=45 c=0
Rx1 (qint \8\:qint) resistor r=45 c=0
Rx3 (\10\:qbint \12\:qbint) resistor r=45 c=0
Rx4 (\6\:qbint \18\:qbint) resistor r=45 c=0
Rx7 (\3\:CKb \15\:CKb) resistor r=45 c=0
Rx8 (\10\:CKb \16\:CKb) resistor r=45 c=0
Rx5 (\2\:n30 \7\:n30) resistor r=45 c=0
Rx6 (\2\:mout \4\:mout) resistor r=45 c=0
Rx10 (\6\:CKbb \14\:CKbb) resistor r=45 c=0
Rx11 (\4\:CKbb \15\:CKbb) resistor r=45 c=0
Rx12 (\8\:CKbb \16\:CKbb) resistor r=45 c=0
Rx13 (CKbb \17\:CKbb) resistor r=45 c=0
Rx9 (\4\:n20 \5\:n20) resistor r=45 c=0
mn57 (\3\:QN \3\:qint \16\:VSS VSS) g45n1lvt w=(1.45e-07) l=4.5e-08 nf=1 \
        as=5.19e-14 ad=2.537e-14 ps=1.6e-06 pd=6.4e-07 nrd=1.16667 \
        nrs=1.16667 sa=1.75e-07 sb=3.35e-07 sd=160n sca=23.279 \
        scb=0.0230742 scc=0.00267719 m=(1)
mn56 (\9\:qint \4\:qbint \16\:VSS VSS) g45n1lvt w=(1.45e-07) l=4.5e-08 \
        nf=1 as=5.19e-14 ad=2.03e-14 ps=1.6e-06 pd=5.7e-07 nrd=1.16667 \
        nrs=1.16667 sa=3.7e-07 sb=1.4e-07 sd=160n sca=23.279 scb=0.0230742 \
        scc=0.00267719 m=(1)
mn55 (\1\:Q qbint \14\:VSS VSS) g45n1lvt w=(1.45e-07) l=4.5e-08 nf=1 \
        as=6.132e-14 ad=2.03e-14 ps=1.73e-06 pd=5.7e-07 nrd=1.16667 \
        nrs=1.16667 sa=1.4e-07 sb=4.2e-07 sd=160n sca=23.279 scb=0.0230742 \
        scc=0.00267719 m=(1)
mn20 (\11\:CKb \1\:CK \14\:VSS VSS) g45n1lvt w=(1.45e-07) l=4.5e-08 nf=1 \
        as=6.132e-14 ad=2.32e-14 ps=1.73e-06 pd=6.1e-07 nrd=1.16667 \
        nrs=1.16667 sa=4e-07 sb=1.6e-07 sd=160n sca=23.279 scb=0.0230742 \
        scc=0.00267719 m=(1)
mn45 (\14\:qbint n30 \12\:VSS VSS) g45n1lvt w=(1.45e-07) l=4.5e-08 nf=1 \
        as=2.392e-14 ad=2.03e-14 ps=6.2e-07 pd=5.7e-07 nrd=1.16667 \
        nrs=1.16667 sa=1.4e-07 sb=1.825e-06 sd=160n sca=22.3376 \
        scb=0.0224607 scc=0.00248252 m=(1)
mn50 (n35 \11\:qbint \12\:VSS VSS) g45n1lvt w=(1.45e-07) l=4.5e-08 nf=1 \
        as=2.392e-14 ad=3.19e-14 ps=6.2e-07 pd=7.3e-07 nrd=1.16667 \
        nrs=1.16667 sa=3.5e-07 sb=1.615e-06 sd=160n sca=22.3376 \
        scb=0.0224607 scc=0.00248252 m=(1)
mn51 (\4\:n30 CKb n35 VSS) g45n1lvt w=(1.45e-07) l=4.5e-08 nf=1 \
        as=3.19e-14 ad=2.755e-14 ps=7.3e-07 pd=6.7e-07 nrd=1.16667 \
        nrs=1.16667 sa=6.15e-07 sb=1.35e-06 sd=160n sca=22.3376 \
        scb=0.0224607 scc=0.00248252 m=(1)
mn40 (\4\:n30 \3\:CKbb \8\:mout VSS) g45n1lvt w=(1.45e-07) l=4.5e-08 nf=1 \
        as=4.06e-14 ad=2.755e-14 ps=8.5e-07 pd=6.7e-07 nrd=1.16667 \
        nrs=1.16667 sa=8.5e-07 sb=1.115e-06 sd=160n sca=22.3376 \
        scb=0.0224607 scc=0.00248252 m=(1)
mn30 (\8\:mout n20 \10\:VSS VSS) g45n1lvt w=(1.45e-07) l=4.5e-08 nf=1 \
        as=5.165e-14 ad=4.06e-14 ps=1.59e-06 pd=8.5e-07 nrd=1.16667 \
        nrs=1.16667 sa=1.175e-06 sb=7.9e-07 sd=160n sca=22.3376 \
        scb=0.0224607 scc=0.00248252 m=(1)
mn35 (n25 \3\:mout \10\:VSS VSS) g45n1lvt w=(1.45e-07) l=4.5e-08 nf=1 \
        as=5.165e-14 ad=8.7e-15 ps=1.59e-06 pd=4.1e-07 nrd=1.16667 \
        nrs=1.16667 sa=1.37e-06 sb=5.95e-07 sd=160n sca=22.3376 \
        scb=0.0224607 scc=0.00248252 m=(1)
mn36 (\7\:n20 \5\:CKbb n25 VSS) g45n1lvt w=(1.45e-07) l=4.5e-08 nf=1 \
        as=8.7e-15 ad=2.32e-14 ps=4.1e-07 pd=6.1e-07 nrd=1.16667 \
        nrs=1.16667 sa=1.475e-06 sb=4.9e-07 sd=160n sca=22.3376 \
        scb=0.0224607 scc=0.00248252 m=(1)
mn25 (\7\:n20 \9\:CKb \6\:Db VSS) g45n1lvt w=(1.45e-07) l=4.5e-08 nf=1 \
        as=4.132e-14 ad=2.32e-14 ps=8.6e-07 pd=6.1e-07 nrd=1.16667 \
        nrs=1.16667 sa=1.68e-06 sb=2.85e-07 sd=160n sca=22.3376 \
        scb=0.0224607 scc=0.00248252 m=(1)
mn21 (\11\:CKbb \4\:CKb \1\:VSS VSS) g45n1lvt w=(1.45e-07) l=4.5e-08 \
        nf=1 as=5.19e-14 ad=2.03e-14 ps=1.6e-06 pd=5.7e-07 nrd=1.16667 \
        nrs=1.16667 sa=1.4e-07 sb=5.5e-07 sd=160n sca=23.279 scb=0.0230742 \
        scc=0.00267719 m=(1)
mn0 (n0 \1\:RN \1\:VSS VSS) g45n1lvt w=(1.45e-07) l=4.5e-08 nf=1 \
        as=5.19e-14 ad=1.232e-14 ps=1.6e-06 pd=4.6e-07 nrd=1.16667 \
        nrs=1.16667 sa=3.35e-07 sb=3.55e-07 sd=160n sca=23.279 \
        scb=0.0230742 scc=0.00267719 m=(1)
mn1 (Db \3\:D n0 VSS) g45n1lvt w=(1.45e-07) l=4.5e-08 nf=1 as=1.233e-14 \
        ad=3.263e-14 ps=4.6e-07 pd=7.4e-07 nrd=1.16667 nrs=1.16667 \
        sa=4.65e-07 sb=2.25e-07 sd=160n sca=23.279 scb=0.0230742 \
        scc=0.00267719 m=(1)
ends DFFTRXL
// End of subcircuit definition.
