// Generated for: spectre (May  1 09:14:01 2013 )
// Library name: gsclib045_lvt
// Cell name: DFFSRX4
// View name: extracted

simulator lang=spectre

subckt DFFSRX4 CK D Q QN RN SN VDD VSS
mp20 (\19\:CKb \1\:CK \37\:VDD VDD) g45p1lvt w=(2.15e-07) l=4.5e-08 nf=1 \
        as=6.128e-14 ad=3.01e-14 ps=1e-06 pd=7.1e-07 nrd=1.16667 \
        nrs=1.16667 sa=1.4e-07 sb=1.0386e-06 sd=160n sca=15.9848 \
        scb=0.0156658 scc=0.000281378 m=(1)
mp25 (n22 \1\:D \37\:VDD VDD) g45p1lvt w=(2.15e-07) l=4.5e-08 nf=1 \
        as=6.128e-14 ad=6.988e-14 ps=1e-06 pd=1.08e-06 nrd=1.16667 \
        nrs=1.16667 sa=4.7e-07 sb=7.08605e-07 sd=160n sca=11.7846 \
        scb=0.00917683 scc=0.000161 m=(1)
mp26 (\5\:n20 \3\:CKbb n22 VDD) g45p1lvt w=(2.15e-07) l=4.5e-08 nf=1 \
        as=6.988e-14 ad=3.76e-14 ps=1.08e-06 pd=9.1e-07 nrd=1.16667 \
        nrs=1.16667 sa=8.4e-07 sb=3.38605e-07 sd=160n sca=10.9013 \
        scb=0.00874909 scc=0.000160703 m=(1)
mp36 (\5\:n20 \3\:CKb n31 VDD) g45p1lvt w=(2.15e-07) l=4.5e-08 nf=1 \
        as=1.29e-14 ad=3.76e-14 ps=5.5e-07 pd=9.1e-07 nrd=1.16667 \
        nrs=1.16667 sa=6.93372e-07 sb=3.41977e-07 sd=160n sca=13.6743 \
        scb=0.0130525 scc=0.000590384 m=(1)
mp35 (n31 mout \33\:VDD VDD) g45p1lvt w=(2.15e-07) l=4.5e-08 nf=1 \
        as=9.855e-14 ad=1.29e-14 ps=1.91e-06 pd=5.5e-07 nrd=1.16667 \
        nrs=1.16667 sa=7.98372e-07 sb=2.36977e-07 sd=160n sca=13.6743 \
        scb=0.0130525 scc=0.000590384 m=(1)
mp21 (\11\:CKbb \5\:CKb \33\:VDD VDD) g45p1lvt w=(2.15e-07) l=4.5e-08 \
        nf=1 as=9.855e-14 ad=3.01e-14 ps=1.91e-06 pd=7.1e-07 nrd=1.16667 \
        nrs=1.16667 sa=2.04651e-07 sb=1.4e-07 sd=160n sca=45.7906 \
        scb=0.0283307 scc=0.00588417 m=(1)
mp31 (net402 \3\:RNb \30\:VDD VDD) g45p1lvt w=(2.15e-07) l=4.5e-08 nf=1 \
        as=8.015e-14 ad=1.29e-14 ps=2.64e-06 pd=5.5e-07 nrd=1.16667 \
        nrs=1.16667 sa=1.97674e-07 sb=1.15895e-06 sd=160n sca=45.7906 \
        scb=0.0283307 scc=0.00588417 m=(1)
mp32 (\8\:mout \2\:n20 net402 VDD) g45p1lvt w=(2.15e-07) l=4.5e-08 nf=1 \
        as=1.29e-14 ad=9.353e-14 ps=5.5e-07 pd=1.3e-06 nrd=1.16667 \
        nrs=1.16667 sa=3.02674e-07 sb=1.05395e-06 sd=160n sca=45.7906 \
        scb=0.0283307 scc=0.00588417 m=(1)
mp30 (\8\:mout \5\:SN \27\:VDD VDD) g45p1lvt w=(2.15e-07) l=4.5e-08 nf=1 \
        as=9.823e-14 ad=9.353e-14 ps=1.6e-06 pd=1.3e-06 nrd=1.16667 \
        nrs=1.16667 sa=7.82674e-07 sb=5.73953e-07 sd=160n sca=45.7906 \
        scb=0.0283307 scc=0.00588417 m=(1)
mp22 (\11\:RNb \1\:RN \27\:VDD VDD) g45p1lvt w=(2.15e-07) l=4.5e-08 nf=1 \
        as=9.823e-14 ad=5.03e-14 ps=1.6e-06 pd=1.11e-06 nrd=1.16667 \
        nrs=1.16667 sa=1.12267e-06 sb=2.33953e-07 sd=160n sca=45.7906 \
        scb=0.0283307 scc=0.00588417 m=(1)
mp40 (\12\:n35 \9\:CKb \6\:mout VDD) g45p1lvt w=(2.15e-07) l=4.5e-08 nf=1 \
        as=4.01e-14 ad=3.56e-14 ps=9.4e-07 pd=8.1e-07 nrd=1.16667 \
        nrs=1.16667 sa=1.86512e-07 sb=3.10814e-07 sd=160n sca=15.6338 \
        scb=0.015455 scc=0.000959319 m=(1)
mp53 (\12\:n35 \7\:CKbb n41 VDD) g45p1lvt w=(2.15e-07) l=4.5e-08 nf=1 \
        as=3.01e-14 ad=3.56e-14 ps=7.1e-07 pd=8.1e-07 nrd=1.16667 \
        nrs=1.16667 sa=3.41279e-07 sb=1.4e-07 sd=160n sca=18.4975 \
        scb=0.0182651 scc=0.0015388 m=(1)
mp51 (n43 \4\:RNb \23\:VDD VDD) g45p1lvt w=(2.15e-07) l=4.5e-08 nf=1 \
        as=3.01e-14 ad=1.29e-14 ps=7.1e-07 pd=5.5e-07 nrd=1.16667 \
        nrs=1.16667 sa=1.4e-07 sb=2e-06 sd=160n sca=12.1244 scb=0.0107968 \
        scc=0.000332109 m=(1)
mp52 (\3\:n41 qbint n43 VDD) g45p1lvt w=(2.15e-07) l=4.5e-08 nf=1 \
        as=1.29e-14 ad=3.44e-14 ps=5.5e-07 pd=7.5e-07 nrd=1.16667 \
        nrs=1.16667 sa=2.45e-07 sb=2e-06 sd=160n sca=12.1244 scb=0.0107968 \
        scc=0.000332109 m=(1)
mp50 (\3\:n41 \1\:SN \1\:VDD VDD) g45p1lvt w=(2.15e-07) l=4.5e-08 nf=1 \
        as=5.25e-14 ad=3.44e-14 ps=1.02e-06 pd=7.5e-07 nrd=1.16667 \
        nrs=1.16667 sa=4.5e-07 sb=2e-06 sd=160n sca=12.1244 scb=0.0107968 \
        scc=0.000332109 m=(1)
C1 (RN VSS) capacitor c=8.2202e-17
C2 (Q VSS) capacitor c=2.22404e-17
C3 (CK VSS) capacitor c=8.03567e-17
C4 (SN VSS) capacitor c=8.09066e-17
C5 (QN VSS) capacitor c=1.61781e-17
C6 (D VSS) capacitor c=6.27755e-17
C7 (VDD VSS) capacitor c=4.79888e-16
C8 (CKb VSS) capacitor c=5.15279e-17
C9 (n21 VSS) capacitor c=1.49997e-18
C10 (n20 VSS) capacitor c=6.0871e-17
C11 (CKbb VSS) capacitor c=3.23105e-17
C12 (mout VSS) capacitor c=9.39412e-17
C13 (RNb VSS) capacitor c=2.94334e-17
C14 (net426 VSS) capacitor c=1.0975e-16
C15 (n35 VSS) capacitor c=2.01917e-16
C16 (n40 VSS) capacitor c=8.29811e-17
C17 (n42 VSS) capacitor c=7.57924e-17
C18 (qbint VSS) capacitor c=8.64333e-17
C19 (qint VSS) capacitor c=2.86495e-16
C20 (n22 VSS) capacitor c=5.52275e-18
C21 (n31 VSS) capacitor c=8.39255e-19
C22 (net402 VSS) capacitor c=9.59976e-19
C23 (n41 VSS) capacitor c=8.45559e-17
C24 (\20\:qbint VSS) capacitor c=5.07619e-17
C25 (\4\:qbint VSS) capacitor c=2.43354e-16
C26 (\1\:SN VSS) capacitor c=7.66706e-17
C27 (\4\:RNb VSS) capacitor c=7.88541e-17
C28 (\7\:CKbb VSS) capacitor c=5.63779e-17
C29 (\9\:CKb VSS) capacitor c=1.14654e-16
C30 (\1\:RN VSS) capacitor c=3.72408e-17
C31 (\5\:SN VSS) capacitor c=4.04327e-17
C32 (\2\:n20 VSS) capacitor c=1.13249e-16
C33 (\3\:RNb VSS) capacitor c=8.02669e-17
C34 (\5\:CKb VSS) capacitor c=3.16021e-17
C35 (\3\:CKb VSS) capacitor c=6.91488e-17
C36 (\3\:CKbb VSS) capacitor c=5.74856e-17
C37 (\1\:D VSS) capacitor c=2.97874e-17
C38 (\1\:CK VSS) capacitor c=4.05005e-17
C39 (\18\:qbint VSS) capacitor c=2.99247e-17
C40 (\2\:SN VSS) capacitor c=1.91778e-16
C41 (\3\:qbint VSS) capacitor c=3.95546e-17
C42 (\6\:RNb VSS) capacitor c=4.24387e-17
C43 (\8\:CKb VSS) capacitor c=6.929e-17
C44 (\5\:CKbb VSS) capacitor c=5.08948e-17
C45 (\3\:RN VSS) capacitor c=3.55493e-17
C46 (\3\:SN VSS) capacitor c=1.13771e-16
C47 (\2\:RNb VSS) capacitor c=4.85334e-17
C48 (\7\:CKb VSS) capacitor c=3.69764e-17
C49 (\2\:mout VSS) capacitor c=5.83715e-17
C50 (\3\:D VSS) capacitor c=6.89631e-17
C51 (\3\:CK VSS) capacitor c=3.00155e-17
C52 (\19\:qbint VSS) capacitor c=4.63126e-17
C53 (\10\:qbint VSS) capacitor c=1.42874e-17
C54 (\2\:qbint VSS) capacitor c=7.30678e-17
C55 (\5\:RNb VSS) capacitor c=6.17322e-17
C56 (\8\:CKbb VSS) capacitor c=2.51472e-17
C57 (\6\:CKbb VSS) capacitor c=3.80732e-17
C58 (\2\:RN VSS) capacitor c=2.54386e-17
C59 (\4\:SN VSS) capacitor c=2.99889e-17
C60 (\10\:CKb VSS) capacitor c=5.55871e-17
C61 (\3\:n20 VSS) capacitor c=3.85914e-17
C62 (\6\:CKb VSS) capacitor c=2.65772e-17
C63 (\3\:mout VSS) capacitor c=3.53534e-17
C64 (\4\:CKb VSS) capacitor c=5.48913e-17
C65 (\4\:CKbb VSS) capacitor c=3.52646e-17
C66 (\2\:CKb VSS) capacitor c=3.58937e-17
C67 (\2\:D VSS) capacitor c=4.70118e-17
C68 (\2\:CK VSS) capacitor c=3.82364e-17
C69 (\15\:qint VSS) capacitor c=4.16632e-17
C70 (\1\:VDD VSS) capacitor c=4.08073e-16
C71 (\25\:qbint VSS) capacitor c=5.99662e-17
C72 (\3\:n41 VSS) capacitor c=1.01493e-16
C73 (\23\:VDD VSS) capacitor c=2.92783e-17
C74 (\12\:n35 VSS) capacitor c=3.97261e-17
C75 (\6\:mout VSS) capacitor c=1.95906e-16
C76 (\11\:RNb VSS) capacitor c=9.69772e-17
C77 (\27\:VDD VSS) capacitor c=5.4687e-17
C78 (\8\:mout VSS) capacitor c=2.51168e-16
C79 (\30\:VDD VSS) capacitor c=2.11228e-17
C80 (\11\:CKbb VSS) capacitor c=2.82665e-16
C81 (\33\:VDD VSS) capacitor c=1.83422e-17
C82 (\5\:n20 VSS) capacitor c=1.34234e-16
C83 (\37\:VDD VSS) capacitor c=3.16431e-17
C84 (\19\:CKb VSS) capacitor c=8.57715e-17
C85 (\3\:VDD VSS) capacitor c=1.043e-16
C86 (\18\:qint VSS) capacitor c=2.94485e-17
C87 (\1\:QN VSS) capacitor c=1.10064e-16
C88 (\1\:Q VSS) capacitor c=1.16641e-16
C89 (\28\:qbint VSS) capacitor c=2.03327e-17
C90 (\3\:n42 VSS) capacitor c=8.8856e-17
C91 (\3\:n40 VSS) capacitor c=8.2003e-17
C92 (\10\:n35 VSS) capacitor c=5.89624e-17
C93 (\4\:mout VSS) capacitor c=9.74341e-17
C94 (\8\:RNb VSS) capacitor c=2.27255e-16
C95 (\12\:mout VSS) capacitor c=7.7667e-17
C96 (\3\:net426 VSS) capacitor c=1.014e-16
C97 (\16\:CKbb VSS) capacitor c=2.86135e-17
C98 (\7\:n20 VSS) capacitor c=1.29039e-16
C99 (\15\:CKb VSS) capacitor c=9.16223e-17
C100 (\2\:CKbb VSS) capacitor c=4.15344e-17
C101 (\4\:CK VSS) capacitor c=3.77748e-17
C102 (\4\:D VSS) capacitor c=4.27699e-17
C103 (\4\:n20 VSS) capacitor c=1.04804e-16
C104 (\11\:CKb VSS) capacitor c=1.61686e-16
C105 (\13\:CKb VSS) capacitor c=1.28383e-16
C106 (\14\:CKb VSS) capacitor c=9.98886e-17
C107 (\17\:CKb VSS) capacitor c=2.27241e-16
C108 (\18\:CKb VSS) capacitor c=3.66597e-17
C109 (\6\:SN VSS) capacitor c=5.25542e-17
C110 (\4\:RN VSS) capacitor c=6.25291e-17
C111 (\10\:mout VSS) capacitor c=1.68386e-16
C112 (\11\:mout VSS) capacitor c=8.37063e-17
C113 (\9\:CKbb VSS) capacitor c=2.33209e-17
C114 (\10\:CKbb VSS) capacitor c=2.5928e-16
C115 (\13\:CKbb VSS) capacitor c=5.75067e-17
C116 (\14\:CKbb VSS) capacitor c=6.86068e-17
C117 (\15\:CKbb VSS) capacitor c=9.36425e-17
C118 (\7\:RNb VSS) capacitor c=2.06705e-16
C119 (\10\:RNb VSS) capacitor c=9.91064e-17
C120 (\8\:n35 VSS) capacitor c=1.31934e-16
C121 (\9\:n35 VSS) capacitor c=1.68597e-16
C122 (\5\:Q VSS) capacitor c=1.488e-16
C123 (\6\:QN VSS) capacitor c=1.50304e-16
C124 (\21\:qbint VSS) capacitor c=2.23151e-17
C125 (\22\:qbint VSS) capacitor c=2.85278e-17
C126 (\23\:qbint VSS) capacitor c=2.13952e-16
C127 (\24\:qbint VSS) capacitor c=2.65146e-16
C128 (\27\:qbint VSS) capacitor c=2.63152e-17
C129 (\30\:qbint VSS) capacitor c=5.41392e-17
C130 (\17\:qint VSS) capacitor c=4.06316e-17
C131 (\20\:qint VSS) capacitor c=2.9967e-17
C132 (\22\:VDD VSS) capacitor c=2.66004e-17
C133 (\26\:VDD VSS) capacitor c=4.82627e-17
C134 (\29\:VDD VSS) capacitor c=4.26444e-17
C135 (\32\:VDD VSS) capacitor c=9.49924e-18
C136 (\36\:VDD VSS) capacitor c=1.58315e-17
Rk14 (\4\:RN RN) resistor r=0.04442 c=0
Rk36 (\1\:Q Q) resistor r=0.1313 c=0
Rk37 (Q \5\:Q) resistor r=0.1733 c=0
Rk63 (\1\:VSS \11\:VSS) resistor r=0.8452 c=0
Rk64 (\11\:VSS \12\:VSS) resistor r=0.1829 c=0
Rk65 (\12\:VSS \13\:VSS) resistor r=0.8717 c=0
Rk66 (\13\:VSS \14\:VSS) resistor r=0.1469 c=0
Rk68 (\15\:VSS VSS) resistor r=0.1852 c=0
Rk67 (\14\:VSS \15\:VSS) resistor r=0.3661 c=0
Rk74 (\12\:VSS \27\:VSS) resistor r=0.2079 c=0
Rk75 (\13\:VSS \29\:VSS) resistor r=0.04333 c=0
Rk76 (\15\:VSS \31\:VSS) resistor r=0.07416 c=0
Rk1 (CK \4\:CK) resistor r=0.09921 c=0
Rk13 (\6\:SN SN) resistor r=0.04669 c=0
Rk42 (\1\:QN QN) resistor r=0.09357 c=0
Rk43 (QN \6\:QN) resistor r=0.1507 c=0
Rk2 (\4\:D D) resistor r=0.06128 c=0
Rk90 (\1\:VDD \22\:VDD) resistor r=0.258 c=0
Rk91 (\22\:VDD \24\:VDD) resistor r=0.292 c=0
Rk92 (\22\:VDD \25\:VDD) resistor r=0.6094 c=0
Rk93 (\25\:VDD \26\:VDD) resistor r=0.2206 c=0
Rk94 (\26\:VDD \28\:VDD) resistor r=0.2265 c=0
Rk95 (\26\:VDD \29\:VDD) resistor r=0.6368 c=0
Rk96 (\29\:VDD \31\:VDD) resistor r=0.1029 c=0
Rk97 (\29\:VDD \32\:VDD) resistor r=0.2154 c=0
Rk98 (\32\:VDD \34\:VDD) resistor r=0.1029 c=0
Rk99 (\32\:VDD \35\:VDD) resistor r=0.1303 c=0
Rk102 (\36\:VDD VDD) resistor r=0.1752 c=0
Rk100 (\35\:VDD \36\:VDD) resistor r=0.3761 c=0
Rk101 (\36\:VDD \38\:VDD) resistor r=0.2663 c=0
Rk6 (\11\:CKb \12\:CKb) resistor r=1.4544 c=0
Rk7 (\12\:CKb \13\:CKb) resistor r=0.2229 c=0
Rk8 (\13\:CKb \14\:CKb) resistor r=0.8743 c=0
Rk9 (\14\:CKb \16\:CKb) resistor r=0.3204 c=0
Rk10 (\12\:CKb \17\:CKb) resistor r=0.06307 c=0
Rk11 (\14\:CKb \18\:CKb) resistor r=0.1315 c=0
Rk12 (\16\:CKb \20\:CKb) resistor r=0.6841 c=0
Rk3 (\4\:n20 \6\:n20) resistor r=0.7409 c=0
Rk4 (\6\:n20 \8\:n20) resistor r=0.6536 c=0
Rk20 (\9\:CKbb \10\:CKbb) resistor r=0.1616 c=0
Rk21 (\10\:CKbb \12\:CKbb) resistor r=1.9562 c=0
Rk22 (\12\:CKbb \13\:CKbb) resistor r=0.2799 c=0
Rk23 (\13\:CKbb \14\:CKbb) resistor r=0.375 c=0
Rk24 (\10\:CKbb \15\:CKbb) resistor r=0.4481 c=0
Rk25 (\13\:CKbb \17\:CKbb) resistor r=0.05032 c=0
Rk15 (\5\:mout \7\:mout) resistor r=0.5131 c=0
Rk16 (\7\:mout \9\:mout) resistor r=1.0096 c=0
Rk17 (\9\:mout \10\:mout) resistor r=0.917 c=0
Rk18 (\10\:mout \11\:mout) resistor r=0.5804 c=0
Rk19 (\10\:mout \13\:mout) resistor r=0.4076 c=0
Rk26 (\7\:RNb \9\:RNb) resistor r=1.3156 c=0
Rk27 (\9\:RNb \10\:RNb) resistor r=0.7596 c=0
Rk28 (\9\:RNb \12\:RNb) resistor r=0.5181 c=0
Rk5 (\2\:net426 \4\:net426) resistor r=0.6291 c=0
Rk32 (\8\:n35 \9\:n35) resistor r=0.9616 c=0
Rk33 (\9\:n35 \11\:n35) resistor r=0.2486 c=0
Rk34 (\9\:n35 \13\:n35) resistor r=0.1557 c=0
Rk29 (\2\:n40 \4\:n40) resistor r=0.3153 c=0
Rk30 (\2\:n42 \4\:n42) resistor r=0.5274 c=0
Rk46 (\21\:qbint \22\:qbint) resistor r=0.2298 c=0
Rk47 (\22\:qbint \23\:qbint) resistor r=0.1293 c=0
Rk48 (\23\:qbint \24\:qbint) resistor r=2.1178 c=0
Rk49 (\22\:qbint \26\:qbint) resistor r=0.2528 c=0
Rk50 (\23\:qbint \27\:qbint) resistor r=0.07864 c=0
Rk51 (\27\:qbint \29\:qbint) resistor r=0.07494 c=0
Rk52 (\27\:qbint \30\:qbint) resistor r=0.3191 c=0
Rk53 (\16\:qint \17\:qint) resistor r=0.187 c=0
Rk54 (\17\:qint \19\:qint) resistor r=0.3247 c=0
Rk55 (\17\:qint \20\:qint) resistor r=0.1944 c=0
Rk31 (\2\:n41 \4\:n41) resistor r=0.6339 c=0
Rl18 (\1\:RN \2\:RN) resistor r=78.079 c=0
Rl19 (\2\:RN \3\:RN) resistor r=26.1559 c=0
Rl1 (\1\:CK \2\:CK) resistor r=156.925 c=0
Rl2 (\2\:CK \3\:CK) resistor r=37.6944 c=0
Rl28 (\1\:SN \2\:SN) resistor r=234.181 c=0
Rl29 (\2\:SN \3\:SN) resistor r=978.412 c=0
Rl31 (\4\:SN \5\:SN) resistor r=80.2198 c=0
Rl30 (\3\:SN \4\:SN) resistor r=28.8462 c=0
Rl3 (\1\:D \2\:D) resistor r=96.1538 c=0
Rl4 (\2\:D \3\:D) resistor r=103.297 c=0
Rl21 (\8\:CKb \9\:CKb) resistor r=183.747 c=0
Rl22 (\9\:CKb \10\:CKb) resistor r=495.667 c=0
Rl12 (\5\:CKb \6\:CKb) resistor r=31.9251 c=0
Rl13 (\6\:CKb \7\:CKb) resistor r=72.3097 c=0
Rl6 (\3\:CKb \4\:CKb) resistor r=66.5405 c=0
Rl5 (CKb \2\:CKb) resistor r=29.5379 c=0
Rl16 (n20 \2\:n20) resistor r=205.335 c=0
Rl17 (\2\:n20 \3\:n20) resistor r=224.513 c=0
Rl23 (\7\:CKbb \8\:CKbb) resistor r=47.3097 c=0
Rl20 (\5\:CKbb \6\:CKbb) resistor r=44.9225 c=0
Rl8 (\2\:CKbb \3\:CKbb) resistor r=198.385 c=0
Rl7 (CKbb \2\:CKbb) resistor r=23.7402 c=0
Rl9 (\2\:CKbb \4\:CKbb) resistor r=8.9468 c=0
Rl10 (mout \2\:mout) resistor r=192.308 c=0
Rl11 (\2\:mout \3\:mout) resistor r=34.5219 c=0
Rl15 (\2\:RNb \3\:RNb) resistor r=132.692 c=0
Rl24 (\4\:RNb \5\:RNb) resistor r=171.131 c=0
Rl25 (\5\:RNb \6\:RNb) resistor r=80.5643 c=0
Rl14 (RNb \2\:RNb) resistor r=93.7438 c=0
Rl65 (\19\:qbint \20\:qbint) resistor r=81.9251 c=0
Rl64 (\19\:qbint \18\:qbint) resistor r=54.3856 c=0
Rl43 (\4\:qbint \10\:qbint) resistor r=7.1351 c=0
Rl26 (\2\:qbint qbint) resistor r=165.18 c=0
Rl27 (\2\:qbint \3\:qbint) resistor r=42.2849 c=0
Rz26 (\27\:VSS \26\:VSS) resistor r=75 c=0
Rz27 (\29\:VSS \28\:VSS) resistor r=75 c=0
Rz28 (\31\:VSS \30\:VSS) resistor r=75 c=0
Rz30 (\1\:VDD \3\:VDD) resistor r=4.4118 c=0
Rz31 (\25\:VDD \3\:VDD) resistor r=6.25 c=0
Rz32 (\35\:VDD \3\:VDD) resistor r=6.25 c=0
Rz4 (\15\:CKb \16\:CKb) resistor r=75 c=0
Rz1 (\7\:n20 \8\:n20) resistor r=75 c=0
Rz7 (\16\:CKbb \17\:CKbb) resistor r=75 c=0
Rz5 (\4\:mout \5\:mout) resistor r=75 c=0
Rz6 (\12\:mout \13\:mout) resistor r=75 c=0
Rz8 (\8\:RNb \9\:RNb) resistor r=75 c=0
Rz2 (net426 \2\:net426) resistor r=75 c=0
Rz3 (\3\:net426 \4\:net426) resistor r=75 c=0
Rz13 (\11\:n35 \10\:n35) resistor r=75 c=0
Rz9 (n40 \2\:n40) resistor r=75 c=0
Rz10 (\3\:n40 \4\:n40) resistor r=75 c=0
Rz11 (n42 \2\:n42) resistor r=75 c=0
Rz12 (\3\:n42 \4\:n42) resistor r=75 c=0
Rz18 (\29\:qbint \28\:qbint) resistor r=75 c=0
Rz19 (\19\:qint \18\:qint) resistor r=75 c=0
Ry17 (\1\:VSS \3\:VSS) resistor r=3.6471 c=0
Ry18 (\11\:VSS \3\:VSS) resistor r=5.1667 c=0
Ry19 (\14\:VSS \3\:VSS) resistor r=5.1667 c=0
Ry27 (\24\:VDD \23\:VDD) resistor r=62 c=0
Ry28 (\28\:VDD \27\:VDD) resistor r=62 c=0
Ry29 (\31\:VDD \30\:VDD) resistor r=62 c=0
Ry30 (\34\:VDD \33\:VDD) resistor r=62 c=0
Ry31 (\38\:VDD \37\:VDD) resistor r=62 c=0
Ry2 (\19\:CKb \20\:CKb) resistor r=62 c=0
Ry1 (\5\:n20 \6\:n20) resistor r=62 c=0
Ry5 (\11\:CKbb \12\:CKbb) resistor r=62 c=0
Ry3 (\6\:mout \7\:mout) resistor r=62 c=0
Ry4 (\8\:mout \9\:mout) resistor r=62 c=0
Ry6 (\11\:RNb \12\:RNb) resistor r=62 c=0
Ry9 (\13\:n35 \12\:n35) resistor r=62 c=0
Ry14 (\26\:qbint \25\:qbint) resistor r=31 c=0
Ry15 (\16\:qint \15\:qint) resistor r=20.6667 c=0
Ry7 (n41 \2\:n41) resistor r=62 c=0
Ry8 (\3\:n41 \4\:n41) resistor r=62 c=0
Rx9 (\2\:RN \4\:RN) resistor r=45 c=0
Rx1 (\2\:CK \4\:CK) resistor r=45 c=0
Rx8 (\4\:SN \6\:SN) resistor r=45 c=0
Rx2 (\2\:D \4\:D) resistor r=45 c=0
Rx4 (\10\:CKb \11\:CKb) resistor r=45 c=0
Rx5 (\4\:CKb \13\:CKb) resistor r=45 c=0
Rx6 (\6\:CKb \17\:CKb) resistor r=45 c=0
Rx7 (\2\:CKb \18\:CKb) resistor r=45 c=0
Rx3 (\3\:n20 \4\:n20) resistor r=45 c=0
Rx11 (\8\:CKbb \9\:CKbb) resistor r=45 c=0
Rx12 (\4\:CKbb \14\:CKbb) resistor r=45 c=0
Rx13 (\6\:CKbb \15\:CKbb) resistor r=45 c=0
Rx10 (\3\:mout \11\:mout) resistor r=45 c=0
Rx14 (\5\:RNb \7\:RNb) resistor r=45 c=0
Rx15 (RNb \10\:RNb) resistor r=45 c=0
Rx16 (\8\:n35 n35) resistor r=45 c=0
Rx17 (\21\:qbint \10\:qbint) resistor r=45 c=0
Rx18 (\24\:qbint \19\:qbint) resistor r=45 c=0
Rx19 (\30\:qbint \2\:qbint) resistor r=45 c=0
Rx20 (\20\:qint qint) resistor r=45 c=0
mn20 (\15\:CKb \3\:CK \30\:VSS VSS) g45n1lvt w=(1.45e-07) l=4.5e-08 nf=1 \
        as=7.15e-14 ad=2.03e-14 ps=1.39e-06 pd=5.7e-07 nrd=1.16667 \
        nrs=1.16667 sa=1.4e-07 sb=1.43e-06 sd=160n sca=11.9911 \
        scb=0.0120555 scc=0.000498628 m=(1)
mn25 (n21 \3\:D \30\:VSS VSS) g45n1lvt w=(1.45e-07) l=4.5e-08 nf=1 \
        as=7.15e-14 ad=8.7e-15 ps=1.39e-06 pd=4.1e-07 nrd=1.16667 \
        nrs=1.16667 sa=4.05e-07 sb=1.165e-06 sd=160n sca=11.9911 \
        scb=0.0120555 scc=0.000498628 m=(1)
mn26 (\7\:n20 CKb n21 VSS) g45n1lvt w=(1.45e-07) l=4.5e-08 nf=1 \
        as=8.7e-15 ad=5.51e-14 ps=4.1e-07 pd=1.05e-06 nrd=1.16667 \
        nrs=1.16667 sa=5.1e-07 sb=1.06e-06 sd=160n sca=11.9911 \
        scb=0.0120555 scc=0.000498628 m=(1)
mn36 (\7\:n20 CKbb n30 VSS) g45n1lvt w=(1.45e-07) l=4.5e-08 nf=1 \
        as=2.61e-14 ad=5.51e-14 ps=6.5e-07 pd=1.05e-06 nrd=1.16667 \
        nrs=1.16667 sa=9.35e-07 sb=6.35e-07 sd=160n sca=11.9911 \
        scb=0.0120555 scc=0.000498628 m=(1)
mn35 (n30 \2\:mout \28\:VSS VSS) g45n1lvt w=(1.45e-07) l=4.5e-08 nf=1 \
        as=7.222e-14 ad=2.61e-14 ps=1.4e-06 pd=6.5e-07 nrd=1.16667 \
        nrs=1.16667 sa=1.16e-06 sb=4.1e-07 sd=160n sca=11.9911 \
        scb=0.0120555 scc=0.000498628 m=(1)
mn21 (\16\:CKbb \7\:CKb \28\:VSS VSS) g45n1lvt w=(1.45e-07) l=4.5e-08 \
        nf=1 as=7.222e-14 ad=2.03e-14 ps=1.4e-06 pd=5.7e-07 nrd=1.16667 \
        nrs=1.16667 sa=1.43e-06 sb=1.4e-07 sd=160n sca=11.9911 \
        scb=0.0120555 scc=0.000498628 m=(1)
mn31 (\12\:mout \2\:RNb \3\:net426 VSS) g45n1lvt w=(1.45e-07) l=4.5e-08 \
        nf=1 as=2.755e-14 ad=4.278e-14 ps=6.7e-07 pd=8.8e-07 nrd=1.16667 \
        nrs=1.16667 sa=1.9e-07 sb=1.065e-06 sd=160n sca=11.9911 \
        scb=0.0120555 scc=0.000498628 m=(1)
mn32 (\12\:mout n20 net426 VSS) g45n1lvt w=(1.45e-07) l=4.5e-08 nf=1 \
        as=3.988e-14 ad=4.278e-14 ps=8.4e-07 pd=8.8e-07 nrd=1.16667 \
        nrs=1.16667 sa=5.3e-07 sb=7.25e-07 sd=160n sca=11.9911 \
        scb=0.0120555 scc=0.000498628 m=(1)
mn30 (net426 \3\:SN \26\:VSS VSS) g45n1lvt w=(1.45e-07) l=4.5e-08 nf=1 \
        as=4.75e-14 ad=3.988e-14 ps=9.9e-07 pd=8.4e-07 nrd=1.16667 \
        nrs=1.16667 sa=8.5e-07 sb=4.05e-07 sd=160n sca=11.9911 \
        scb=0.0120555 scc=0.000498628 m=(1)
mn22 (\8\:RNb \3\:RN \26\:VSS VSS) g45n1lvt w=(1.45e-07) l=4.5e-08 nf=1 \
        as=4.75e-14 ad=2.03e-14 ps=9.9e-07 pd=5.7e-07 nrd=1.16667 \
        nrs=1.16667 sa=1.115e-06 sb=1.4e-07 sd=160n sca=11.9911 \
        scb=0.0120555 scc=0.000498628 m=(1)
mn40 (\10\:n35 \5\:CKbb \4\:mout VSS) g45n1lvt w=(1.45e-07) l=4.5e-08 \
        nf=1 as=2.03e-14 ad=2.32e-14 ps=5.7e-07 pd=6.1e-07 nrd=1.16667 \
        nrs=1.16667 sa=1.4e-07 sb=4.9e-07 sd=160n sca=18.4982 \
        scb=0.0194884 scc=0.00168796 m=(1)
mn53 (\10\:n35 \8\:CKb \3\:n40 VSS) g45n1lvt w=(1.45e-07) l=4.5e-08 nf=1 \
        as=4.133e-14 ad=2.32e-14 ps=8.6e-07 pd=6.1e-07 nrd=1.16667 \
        nrs=1.16667 sa=3.45e-07 sb=2.85e-07 sd=160n sca=18.4982 \
        scb=0.0194884 scc=0.00168796 m=(1)
mn51 (n40 \6\:RNb \3\:n42 VSS) g45n1lvt w=(1.45e-07) l=4.5e-08 nf=1 \
        as=2.103e-14 ad=2.538e-14 ps=5.8e-07 pd=6.4e-07 nrd=1.16667 \
        nrs=1.16667 sa=1.45e-07 sb=2e-06 sd=160n sca=8.85152 \
        scb=0.00706865 scc=0.000138481 m=(1)
mn52 (n40 \3\:qbint n42 VSS) g45n1lvt w=(1.45e-07) l=4.5e-08 nf=1 \
        as=2.32e-14 ad=2.538e-14 ps=6.1e-07 pd=6.4e-07 nrd=1.16667 \
        nrs=1.16667 sa=3.65e-07 sb=2e-06 sd=160n sca=8.85152 \
        scb=0.00706865 scc=0.000138481 m=(1)
mn50 (n42 \2\:SN \1\:VSS VSS) g45n1lvt w=(1.45e-07) l=4.5e-08 nf=1 \
        as=2.92e-14 ad=2.32e-14 ps=7.3e-07 pd=6.1e-07 nrd=1.16667 \
        nrs=1.16667 sa=5.7e-07 sb=2e-06 sd=160n sca=8.85152 scb=0.00706865 \
        scc=0.000138481 m=(1)
mn45_1__rcx (\28\:qbint n35 \1\:VSS VSS) g45n1lvt w=(2.05e-07) l=4.5e-08 \
        nf=1 as=5.169e-14 ad=3.28e-14 ps=9.6e-07 pd=7.3e-07 nrd=1.16667 \
        nrs=1.16667 sa=5.77439e-07 sb=2e-06 sd=160n sca=10.1075 \
        scb=0.00913344 scc=0.000289639 m=(2)
mn56 (\18\:qint \18\:qbint \1\:VSS VSS) g45n1lvt w=(2.6e-07) l=4.5e-08 \
        nf=1 as=5.46e-14 ad=3.64e-14 ps=9.4e-07 pd=8e-07 nrd=1.16667 \
        nrs=1.16667 sa=2e-06 sb=1.4e-07 sd=160n sca=9.32128 scb=0.00786794 \
        scc=0.000232361 m=(1)
mn57_1__rcx (\1\:QN qint \1\:VSS VSS) g45n1lvt w=(2.6e-07) l=4.5e-08 \
        nf=1 as=7.455e-14 ad=5.395e-14 ps=1.255e-06 pd=9.35e-07 \
        nrd=1.16667 nrs=1.16667 sa=1.71038e-06 sb=1.165e-06 sd=160n \
        sca=9.32128 scb=0.00786794 scc=0.000232361 m=(4)
mn55_1__rcx (\1\:Q \4\:qbint \1\:VSS VSS) g45n1lvt w=(2.6e-07) l=4.5e-08 \
        nf=1 as=7.944e-14 ad=4.16e-14 ps=1.3175e-06 pd=8.4e-07 nrd=1.16667 \
        nrs=1.16667 sa=9.37692e-07 sb=2e-06 sd=160n sca=9.32128 \
        scb=0.00786794 scc=0.000232361 m=(4)
mp45 (\25\:qbint n35 \1\:VDD VDD) g45p1lvt w=(3.1e-07) l=4.5e-08 nf=1 \
        as=6.9e-14 ad=4.96e-14 ps=1.15e-06 pd=9.4e-07 nrd=1.16667 \
        nrs=1.16667 sa=5.12661e-07 sb=2e-06 sd=160n sca=15.9771 \
        scb=0.0149994 scc=0.00109313 m=(2)
mp56 (\15\:qint \20\:qbint \1\:VDD VDD) g45p1lvt w=(3.9e-07) l=4.5e-08 \
        nf=1 as=6.24e-14 ad=5.46e-14 ps=1.1e-06 pd=1.06e-06 nrd=1.16667 \
        nrs=1.16667 sa=1.98256e-06 sb=1.4e-07 sd=160n sca=29.2317 \
        scb=0.0232252 scc=0.00281645 m=(1)
mp57 (\6\:QN qint \1\:VDD VDD) g45p1lvt w=(3.9e-07) l=4.5e-08 nf=1 \
        as=7.41e-14 ad=6.728e-14 ps=1.16e-06 pd=1.125e-06 nrd=1.16667 \
        nrs=1.16667 sa=1.69103e-06 sb=1.015e-06 sd=160n sca=25.6993 \
        scb=0.0190507 scc=0.00277827 m=(4)
mp55_1__rcx (\5\:Q \4\:qbint \1\:VDD VDD) g45p1lvt w=(3.9e-07) l=4.5e-08 \
        nf=1 as=7.89e-14 ad=6.923e-14 ps=1.2e-06 pd=1.135e-06 nrd=1.16667 \
        nrs=1.16667 sa=8.25449e-07 sb=1.955e-06 sd=160n sca=25.6993 \
        scb=0.0190507 scc=0.00277827 m=(4)
ends DFFSRX4
// End of subcircuit definition.
