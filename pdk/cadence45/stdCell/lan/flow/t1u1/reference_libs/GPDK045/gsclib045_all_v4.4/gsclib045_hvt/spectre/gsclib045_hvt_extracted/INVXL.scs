// Generated for: spectre (May  1 09:16:41 2013 )
// Library name: gsclib045_hvt
// Cell name: INVXL
// View name: extracted

simulator lang=spectre

subckt INVXL A VDD VSS Y
mp0 (\3\:Y \1\:A \1\:VDD VDD) g45p1hvt w=(2.15e-07) l=4.5e-08 nf=1 \
        as=4.962e-14 ad=2.87e-14 ps=1.44e-06 pd=7.5e-07 nrd=1.16667 \
        nrs=1.16667 sa=1e-07 sb=1.33488e-07 sd=160n sca=40.8937 \
        scb=0.0499242 scc=0.00347111 m=(1)
C1 (VDD VSS) capacitor c=4.64864e-17
C2 (A VSS) capacitor c=1.56261e-17
C3 (Y VSS) capacitor c=4.25547e-17
C4 (\1\:A VSS) capacitor c=3.25884e-17
C5 (\3\:A VSS) capacitor c=2.17731e-17
C6 (\2\:A VSS) capacitor c=3.41794e-17
C7 (\3\:Y VSS) capacitor c=1.83815e-17
C8 (\1\:VDD VSS) capacitor c=6.8192e-18
C9 (\1\:Y VSS) capacitor c=2.3558e-17
C10 (\4\:A VSS) capacitor c=3.66346e-17
Rk4 (\2\:VDD VDD) resistor r=0.07089 c=0
Rk1 (A \4\:A) resistor r=0.01335 c=0
Rk7 (VSS \4\:VSS) resistor r=0.08469 c=0
Rk2 (Y \2\:Y) resistor r=0.1764 c=0
Rk3 (Y \4\:Y) resistor r=0.2302 c=0
Rl1 (\1\:A \2\:A) resistor r=117.519 c=0
Rl2 (\2\:A \3\:A) resistor r=67.5189 c=0
Rz3 (\3\:VSS \4\:VSS) resistor r=75 c=0
Rz1 (\1\:Y \2\:Y) resistor r=75 c=0
Ry2 (\1\:VDD \2\:VDD) resistor r=62 c=0
Ry1 (\3\:Y \4\:Y) resistor r=62 c=0
Rx1 (\2\:A \4\:A) resistor r=45 c=0
mn0 (\1\:Y \3\:A \3\:VSS VSS) g45n1hvt w=(1.45e-07) l=4.5e-08 nf=1 \
        as=3.86e-14 ad=2.32e-14 ps=1.23e-06 pd=6.1e-07 nrd=1.16667 \
        nrs=1.16667 sa=1e-07 sb=1.6e-07 sd=160n sca=10.4914 scb=0.00978575 \
        scc=0.000300434 m=(1)
ends INVXL
// End of subcircuit definition.
