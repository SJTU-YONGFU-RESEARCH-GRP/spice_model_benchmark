// Generated for: spectre (May  1 11:28:12 2013 )
// Library name: gsclib045_backbias
// Cell name: CLKAND2X6
// View name: extracted

simulator lang=spectre

subckt CLKAND2X6 A B NW VDD VSS Y
mp0_1__rcx (\20\:net61 A VDD NW) g45p1svt w=(1.95e-07) l=4.5e-08 nf=1 \
        as=5.407e-14 ad=3.12e-14 ps=1.4e-06 pd=7.1e-07 nrd=1.16667 \
        nrs=1.16667 sa=1e-07 sb=2e-06 sd=160n sca=59.1807 scb=0.0520305 \
        scc=0.00794391 m=(4)
mp1_1__rcx (\20\:net61 B VDD NW) g45p1svt w=(1.95e-07) l=4.5e-08 nf=1 \
        as=5.215e-14 ad=3.12e-14 ps=1.41e-06 pd=7.1e-07 nrd=1.16667 \
        nrs=1.16667 sa=3.05e-07 sb=2e-06 sd=160n sca=44.2595 scb=0.0339396 \
        scc=0.00538195 m=(4)
C1 (Y VSS) capacitor c=1.17275e-17
C2 (B VSS) capacitor c=4.01514e-16
C3 (NW VSS) capacitor c=3.57303e-16
C4 (VDD VSS) capacitor c=5.43744e-16
C5 (A VSS) capacitor c=5.61429e-16
C6 (net61 VSS) capacitor c=3.97502e-16
C7 (9 VSS) capacitor c=1.73025e-18
C8 (10 VSS) capacitor c=5.1205e-18
C9 (11 VSS) capacitor c=1.71135e-18
C10 (\12\:A VSS) capacitor c=6.62363e-17
C11 (\11\:B VSS) capacitor c=4.47814e-17
C12 (\12\:B VSS) capacitor c=2.50951e-17
C13 (\8\:A VSS) capacitor c=3.0283e-17
C14 (\7\:A VSS) capacitor c=4.77649e-17
C15 (\1\:B VSS) capacitor c=5.60844e-17
C16 (\4\:B VSS) capacitor c=3.50653e-17
C17 (\1\:A VSS) capacitor c=3.31594e-17
C18 (\1\:Y VSS) capacitor c=2.93422e-16
C19 (\20\:net61 VSS) capacitor c=2.04205e-16
C20 (\28\:net61 VSS) capacitor c=1.21163e-16
C21 (\30\:net61 VSS) capacitor c=8.22868e-17
C22 (\19\:net61 VSS) capacitor c=7.97432e-17
C23 (\4\:Y VSS) capacitor c=2.14622e-16
Rk15 (\1\:Y Y) resistor r=0.003371 c=0
Rk16 (Y \4\:Y) resistor r=0.1832 c=0
Rk38 (\2\:VSS \3\:VSS) resistor r=0.08001 c=0
Rk41 (\3\:VSS \6\:VSS) resistor r=0.1703 c=0
Rk42 (\6\:VSS \7\:VSS) resistor r=0.1853 c=0
Rk44 (\8\:VSS VSS) resistor r=0.02963 c=0
Rk43 (\7\:VSS \8\:VSS) resistor r=0.3355 c=0
Rk48 (\7\:VSS \16\:VSS) resistor r=0.1987 c=0
Rk49 (\8\:VSS \18\:VSS) resistor r=0.2033 c=0
Rk7 (net61 \19\:net61) resistor r=0.199 c=0
Rk8 (\19\:net61 \20\:net61) resistor r=0.3493 c=0
Rk12 (\19\:net61 \29\:net61) resistor r=0.4711 c=0
Rk13 (\29\:net61 \31\:net61) resistor r=0.534 c=0
Rl16 (B \11\:B) resistor r=28.0797 c=0
Rl17 (B \12\:B) resistor r=27.2353 c=0
Rl3 (B \1\:B) resistor r=100.478 c=0
Rl5 (B \4\:B) resistor r=90.0661 c=0
Rl20 (A \12\:A) resistor r=43.4636 c=0
Rl11 (A \8\:A) resistor r=58.8489 c=0
Rl10 (A \7\:A) resistor r=28.6412 c=0
Rl1 (A \1\:A) resistor r=36.3335 c=0
Rz9 (\16\:VSS \15\:VSS) resistor r=75 c=0
Rz10 (\18\:VSS \17\:VSS) resistor r=75 c=0
Rz1 (\29\:net61 \28\:net61) resistor r=75 c=0
Rz2 (\31\:net61 \30\:net61) resistor r=75 c=0
Ry17 (\2\:VSS \1\:VSS) resistor r=31 c=0
Ry18 (\6\:VSS \1\:VSS) resistor r=5.1667 c=0
mn0_1__rcx (8 \1\:A \17\:VSS VSS) g45n1svt w=(2.6e-07) l=4.5e-08 nf=1 \
        as=3.64e-14 ad=3.64e-14 ps=8e-07 pd=8e-07 nrd=1.16667 nrs=1.16667 \
        sa=1.4e-07 sb=2e-06 sd=160n sca=9.14564 scb=0.00759168 \
        scc=0.000213449 m=(1)
mn1_1__rcx (\30\:net61 \4\:B 8 VSS) g45n1svt w=(2.6e-07) l=4.5e-08 nf=1 \
        as=3.64e-14 ad=4.16e-14 ps=8e-07 pd=8.4e-07 nrd=1.16667 \
        nrs=1.16667 sa=3.25e-07 sb=2e-06 sd=160n sca=9.14564 \
        scb=0.00759168 scc=0.000213449 m=(1)
mn1_2__rcx (\30\:net61 \1\:B 9 VSS) g45n1svt w=(2.6e-07) l=4.5e-08 nf=1 \
        as=1.56e-14 ad=4.16e-14 ps=6.4e-07 pd=8.4e-07 nrd=1.16667 \
        nrs=1.16667 sa=5.3e-07 sb=2e-06 sd=160n sca=9.14564 scb=0.00759168 \
        scc=0.000213449 m=(1)
mn0_2__rcx (9 \7\:A \15\:VSS VSS) g45n1svt w=(2.6e-07) l=4.5e-08 nf=1 \
        as=4.16e-14 ad=1.56e-14 ps=8.4e-07 pd=6.4e-07 nrd=1.16667 \
        nrs=1.16667 sa=6.35e-07 sb=1.925e-06 sd=160n sca=9.14564 \
        scb=0.00759168 scc=0.000213449 m=(1)
mn0_3__rcx (10 \8\:A \15\:VSS VSS) g45n1svt w=(2.6e-07) l=4.5e-08 nf=1 \
        as=4.16e-14 ad=3.9e-14 ps=8.4e-07 pd=8.2e-07 nrd=1.16667 \
        nrs=1.16667 sa=8.4e-07 sb=1.72e-06 sd=160n sca=9.14564 \
        scb=0.00759168 scc=0.000213449 m=(1)
mn1_3__rcx (\28\:net61 \12\:B 10 VSS) g45n1svt w=(2.6e-07) l=4.5e-08 nf=1 \
        as=3.9e-14 ad=4.16e-14 ps=8.2e-07 pd=8.4e-07 nrd=1.16667 \
        nrs=1.16667 sa=1.035e-06 sb=1.525e-06 sd=160n sca=9.14564 \
        scb=0.00759168 scc=0.000213449 m=(1)
mn1 (\28\:net61 \11\:B 11 VSS) g45n1svt w=(2.6e-07) l=4.5e-08 nf=1 \
        as=1.56e-14 ad=4.16e-14 ps=6.4e-07 pd=8.4e-07 nrd=1.16667 \
        nrs=1.16667 sa=1.24e-06 sb=1.32e-06 sd=160n sca=9.14564 \
        scb=0.00759168 scc=0.000213449 m=(1)
mn0 (11 \12\:A \3\:VSS VSS) g45n1svt w=(2.6e-07) l=4.5e-08 nf=1 \
        as=5.96e-14 ad=1.56e-14 ps=1.04e-06 pd=6.4e-07 nrd=1.16667 \
        nrs=1.16667 sa=1.345e-06 sb=1.215e-06 sd=160n sca=9.14564 \
        scb=0.00759168 scc=0.000213449 m=(1)
mn2_1__rcx (\4\:Y net61 \3\:VSS VSS) g45n1svt w=(3.1e-07) l=4.5e-08 nf=1 \
        as=5.16e-14 ad=4.836e-14 ps=9.6e-07 pd=9.32e-07 nrd=1.16667 \
        nrs=1.16667 sa=1.35806e-06 sb=9.6e-07 sd=160n sca=10.4852 \
        scb=0.00950193 scc=0.000416321 m=(5)
mp2_1__rcx (\1\:Y net61 VDD NW) g45p1svt w=(4.7e-07) l=4.5e-08 nf=1 \
        as=7.407e-14 ad=7.332e-14 ps=1.302e-06 pd=1.252e-06 nrd=1.16667 \
        nrs=1.16667 sa=7.83457e-07 sb=9.6e-07 sd=160n sca=26.9787 \
        scb=0.0178954 scc=0.0027966 m=(5)
ends CLKAND2X6
// End of subcircuit definition.
