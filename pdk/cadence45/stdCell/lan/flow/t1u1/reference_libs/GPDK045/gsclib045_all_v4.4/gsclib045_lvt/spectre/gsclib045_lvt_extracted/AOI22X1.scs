// Generated for: spectre (May  1 09:11:59 2013 )
// Library name: gsclib045_lvt
// Cell name: AOI22X1
// View name: extracted

simulator lang=spectre

subckt AOI22X1 A0 A1 B0 B1 VDD VSS Y
mp0 (\5\:net89 \1\:A0 \4\:VDD VDD) g45p1lvt w=(3.9e-07) l=4.5e-08 nf=1 \
        as=7.26e-14 ad=5.46e-14 ps=1.44e-06 pd=1.06e-06 nrd=1.16667 \
        nrs=1.16667 sa=1.4e-07 sb=7.65e-07 sd=160n sca=25.383 \
        scb=0.0290112 scc=0.00169816 m=(1)
mp1 (\3\:net89 \1\:A1 \4\:VDD VDD) g45p1lvt w=(3.9e-07) l=4.5e-08 nf=1 \
        as=7.26e-14 ad=6.435e-14 ps=1.44e-06 pd=1.11e-06 nrd=1.16667 \
        nrs=1.16667 sa=3.45e-07 sb=5.6e-07 sd=160n sca=15.7692 \
        scb=0.0144715 scc=0.000333573 m=(1)
mp3 (\1\:Y \1\:B1 \3\:net89 VDD) g45p1lvt w=(3.9e-07) l=4.5e-08 nf=1 \
        as=6.435e-14 ad=6.435e-14 ps=1.11e-06 pd=1.11e-06 nrd=1.16667 \
        nrs=1.16667 sa=5.55e-07 sb=3.5e-07 sd=160n sca=14.4126 \
        scb=0.011746 scc=0.00029444 m=(1)
mp2 (\1\:Y \1\:B0 net89 VDD) g45p1lvt w=(3.9e-07) l=4.5e-08 nf=1 \
        as=5.46e-14 ad=6.435e-14 ps=1.06e-06 pd=1.11e-06 nrd=1.16667 \
        nrs=1.16667 sa=7.65e-07 sb=1.4e-07 sd=160n sca=16.4371 \
        scb=0.0157949 scc=0.000369535 m=(1)
C1 (Y VSS) capacitor c=7.85579e-17
C2 (B1 VSS) capacitor c=2.4454e-17
C3 (VDD VSS) capacitor c=9.30093e-17
C4 (B0 VSS) capacitor c=3.48214e-17
C5 (A0 VSS) capacitor c=6.84418e-17
C6 (net102 VSS) capacitor c=2.43791e-18
C7 (net89 VSS) capacitor c=5.34431e-17
C8 (\1\:B0 VSS) capacitor c=5.46304e-17
C9 (\1\:B1 VSS) capacitor c=5.70413e-17
C10 (\1\:A1 VSS) capacitor c=8.26747e-17
C11 (\1\:A0 VSS) capacitor c=6.8793e-17
C12 (\3\:B0 VSS) capacitor c=4.189e-17
C13 (\3\:B1 VSS) capacitor c=5.40722e-17
C14 (\3\:A1 VSS) capacitor c=4.00494e-17
C15 (\4\:A0 VSS) capacitor c=4.32286e-17
C16 (\2\:B0 VSS) capacitor c=5.1167e-17
C17 (\2\:B1 VSS) capacitor c=5.52593e-17
C18 (\2\:A1 VSS) capacitor c=6.21341e-17
C19 (\3\:A0 VSS) capacitor c=1.69153e-17
C20 (\1\:Y VSS) capacitor c=8.61894e-17
C21 (\3\:net89 VSS) capacitor c=9.51955e-17
C22 (\4\:VDD VSS) capacitor c=4.59442e-17
C23 (\5\:net89 VSS) capacitor c=4.30316e-17
C24 (\3\:Y VSS) capacitor c=1.06063e-16
C25 (\2\:A0 VSS) capacitor c=3.87455e-17
C26 (\4\:A1 VSS) capacitor c=4.08679e-17
C27 (\5\:A1 VSS) capacitor c=4.4388e-17
C28 (\4\:B1 VSS) capacitor c=7.16434e-17
C29 (\4\:B0 VSS) capacitor c=3.53817e-17
C30 (\3\:VDD VSS) capacitor c=4.5621e-17
Rk6 (\2\:Y Y) resistor r=0.2428 c=0
Rk7 (Y \4\:Y) resistor r=0.5393 c=0
Rk5 (B1 \4\:B1) resistor r=0.03079 c=0
Rk2 (A1 \4\:A1) resistor r=0.004076 c=0
Rk4 (\4\:A1 \5\:A1) resistor r=0.06597 c=0
Rk3 (\5\:A1 \6\:A1) resistor r=0.004196 c=0
Rk12 (\4\:VSS VSS) resistor r=0.2507 c=0
Rk11 (\2\:VSS \4\:VSS) resistor r=0.3583 c=0
Rk13 (VSS \6\:VSS) resistor r=0.2284 c=0
Rk15 (\3\:VDD VDD) resistor r=0.1014 c=0
Rk16 (\3\:VDD \5\:VDD) resistor r=0.1285 c=0
Rk10 (\4\:B0 B0) resistor r=0.03383 c=0
Rk1 (A0 \5\:A0) resistor r=0.00426 c=0
Rk8 (\2\:net89 \4\:net89) resistor r=0.4624 c=0
Rk9 (\4\:net89 \6\:net89) resistor r=0.4119 c=0
Rl6 (\1\:B1 \2\:B1) resistor r=98.0568 c=0
Rl7 (\2\:B1 \3\:B1) resistor r=94.2107 c=0
Rl4 (\1\:A1 \2\:A1) resistor r=171.131 c=0
Rl5 (\2\:A1 \3\:A1) resistor r=24.7951 c=0
Rl8 (\1\:B0 \2\:B0) resistor r=144.231 c=0
Rl9 (\2\:B0 \3\:B0) resistor r=54.9451 c=0
Rl1 (\1\:A0 \2\:A0) resistor r=152.726 c=0
Rl3 (\2\:A0 \4\:A0) resistor r=60.4181 c=0
Rl2 (\2\:A0 \3\:A0) resistor r=5.013 c=0
Rz1 (\3\:Y \4\:Y) resistor r=37.5 c=0
Rz2 (\1\:VSS \2\:VSS) resistor r=37.5 c=0
Rz3 (\5\:VSS \6\:VSS) resistor r=37.5 c=0
Ry1 (\1\:Y \2\:Y) resistor r=31 c=0
Ry6 (\4\:VDD \5\:VDD) resistor r=62 c=0
Ry2 (net89 \2\:net89) resistor r=20.6667 c=0
Ry3 (\3\:net89 \4\:net89) resistor r=31 c=0
Ry4 (\5\:net89 \6\:net89) resistor r=31 c=0
Rx3 (\2\:B1 \4\:B1) resistor r=45 c=0
Rx2 (\2\:A1 \6\:A1) resistor r=45 c=0
Rx4 (\2\:B0 \4\:B0) resistor r=45 c=0
Rx1 (\3\:A0 \5\:A0) resistor r=45 c=0
mn0 (net102 \4\:A0 \5\:VSS VSS) g45n1lvt w=(2.6e-07) l=4.5e-08 nf=1 \
        as=3.64e-14 ad=2.99e-14 ps=8e-07 pd=7.5e-07 nrd=1.16667 \
        nrs=1.16667 sa=1.4e-07 sb=7.1e-07 sd=160n sca=7.84363 \
        scb=0.00546499 scc=9.84911e-05 m=(1)
mn1 (\3\:Y \3\:A1 net102 VSS) g45n1lvt w=(2.6e-07) l=4.5e-08 nf=1 \
        as=2.99e-14 ad=5.46e-14 ps=7.5e-07 pd=9.4e-07 nrd=1.16667 \
        nrs=1.16667 sa=3e-07 sb=5.5e-07 sd=160n sca=7.84363 scb=0.00546499 \
        scc=9.84911e-05 m=(1)
mn3 (\3\:Y \3\:B1 net98 VSS) g45n1lvt w=(2.6e-07) l=4.5e-08 nf=1 \
        as=2.86e-14 ad=5.46e-14 ps=7.4e-07 pd=9.4e-07 nrd=1.16667 \
        nrs=1.16667 sa=5.55e-07 sb=2.95e-07 sd=160n sca=7.84363 \
        scb=0.00546499 scc=9.84911e-05 m=(1)
mn2 (net98 \3\:B0 \1\:VSS VSS) g45n1lvt w=(2.6e-07) l=4.5e-08 nf=1 \
        as=3.64e-14 ad=2.86e-14 ps=8e-07 pd=7.4e-07 nrd=1.16667 \
        nrs=1.16667 sa=7.1e-07 sb=1.4e-07 sd=160n sca=7.84363 \
        scb=0.00546499 scc=9.84911e-05 m=(1)
ends AOI22X1
// End of subcircuit definition.
