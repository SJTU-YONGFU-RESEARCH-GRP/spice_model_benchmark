// Generated for: spectre (May  1 08:11:31 2013 )
// Library name: gsclib045
// Cell name: HSWX1
// View name: extracted

simulator lang=spectre

subckt HSWX1 ExtVDD PSO PSO_out VDD VSS
PM0_1__rcx (VDD n0 ExtVDD ExtVDD) g45p1hvt w=(4.5e-07) l=4.5e-08 nf=1 \
        as=7.1e-14 ad=7.2e-14 ps=1.21556e-06 pd=1.22e-06 nrd=1.16667 \
        nrs=1.16667 sa=1.4e-07 sb=2e-06 sd=160n sca=18.5135 scb=0.0195852 \
        scc=0.00148685 m=(36)
PM0_31__rcx (VDD n0 ExtVDD ExtVDD) g45p1hvt w=(4.5e-07) l=4.5e-08 nf=1 \
        as=7.2e-14 ad=7.2e-14 ps=1.22e-06 pd=1.22e-06 nrd=1.16667 \
        nrs=1.16667 sa=1.575e-06 sb=2e-06 sd=160n sca=3.55421 \
        scb=0.000138381 scc=9.64541e-09 m=(8)
PM0_45__rcx (VDD n0 ExtVDD ExtVDD) g45p1hvt w=(4.5e-07) l=4.5e-08 nf=1 \
        as=7.1e-14 ad=7.2e-14 ps=1.21556e-06 pd=1.22e-06 nrd=1.16667 \
        nrs=1.16667 sa=2e-06 sb=1.78e-06 sd=160n sca=8.16604 \
        scb=0.00609017 scc=0.000206552 m=(36)
PM6 (\3\:PSO_out pson \82\:ExtVDD ExtVDD) g45p1svt w=(3.9e-07) l=4.5e-08 \
        nf=1 as=5.46e-14 ad=6.24e-14 ps=1.06e-06 pd=1.1e-06 nrd=1.16667 \
        nrs=1.16667 sa=3.45e-07 sb=1.4e-07 sd=160n sca=26.2769 \
        scb=0.0231127 scc=0.00250765 m=(1)
PM2 (\13\:pson \1\:PSO \82\:ExtVDD ExtVDD) g45p1svt w=(3.9e-07) \
        l=4.5e-08 nf=1 as=6.24e-14 ad=5.46e-14 ps=1.1e-06 pd=1.06e-06 \
        nrd=1.16667 nrs=1.16667 sa=1.4e-07 sb=3.45e-07 sd=160n sca=40.4286 \
        scb=0.040773 scc=0.00487953 m=(1)
C1 (ExtVDD VSS) capacitor c=3.16417e-15
C2 (PSO_out VSS) capacitor c=2.69049e-17
C3 (VDD VSS) capacitor c=2.54052e-16
C4 (PSO VSS) capacitor c=4.43544e-17
C5 (pson VSS) capacitor c=4.86252e-17
C6 (n0 VSS) capacitor c=1.87789e-15
C7 (\1\:PSO VSS) capacitor c=4.73795e-17
C8 (\6\:pson VSS) capacitor c=1.22471e-16
C9 (\4\:pson VSS) capacitor c=5.13374e-17
C10 (\3\:PSO VSS) capacitor c=3.65072e-17
C11 (\23\:n0 VSS) capacitor c=5.91673e-17
C12 (\2\:PSO VSS) capacitor c=3.72469e-17
C13 (\3\:pson VSS) capacitor c=2.90094e-17
C14 (\3\:PSO_out VSS) capacitor c=8.997e-17
C15 (\82\:ExtVDD VSS) capacitor c=1.10574e-16
C16 (\104\:n0 VSS) capacitor c=9.6629e-17
C17 (\13\:pson VSS) capacitor c=6.906e-17
C18 (\1\:PSO_out VSS) capacitor c=7.19566e-17
C19 (\106\:n0 VSS) capacitor c=6.82924e-17
C20 (\16\:pson VSS) capacitor c=6.9254e-17
C21 (\11\:pson VSS) capacitor c=1.42133e-17
C22 (\2\:pson VSS) capacitor c=4.29433e-17
C23 (\5\:pson VSS) capacitor c=3.08215e-17
C24 (VDD VSS) capacitor c=4.29137e-15
C25 (ExtVDD VSS) capacitor c=5.05972e-16
C26 (ExtVDD VSS) capacitor c=2.7536e-15
C27 (\15\:pson VSS) capacitor c=4.01925e-17
C28 (\7\:PSO VSS) capacitor c=3.07054e-17
C29 (\102\:n0 VSS) capacitor c=6.3146e-17
C30 (\103\:n0 VSS) capacitor c=3.16477e-17
C31 (\19\:ExtVDD VSS) capacitor c=1.72779e-16
Rk21 (ExtVDD ExtVDD) resistor r=0.1152 c=0
Rk27 (ExtVDD \19\:ExtVDD) resistor r=0.1454 c=0
Rk65 (ExtVDD \83\:ExtVDD) resistor r=0.5907 c=0
Rk8 (PSO_out \2\:PSO_out) resistor r=0.07766 c=0
Rk9 (\2\:PSO_out \4\:PSO_out) resistor r=0.5379 c=0
Rk140 (VSS VSS) resistor r=1.1339 c=0
Rk138 (\2\:VSS VSS) resistor r=1.2041 c=0
Rk145 (\11\:VSS VSS) resistor r=1.2041 c=0
Rk147 (VSS \13\:VSS) resistor r=1.2044 c=0
Rk149 (\14\:VSS VSS) resistor r=0.125 c=0
Rk148 (\13\:VSS \14\:VSS) resistor r=0.02991 c=0
Rk150 (\14\:VSS \16\:VSS) resistor r=0.2739 c=0
Rk99 (VDD VDD) resistor r=0.6116 c=0
Rk3 (\4\:PSO PSO) resistor r=0.003496 c=0
Rk4 (\5\:PSO PSO) resistor r=0.003496 c=0
Rk5 (\4\:PSO \5\:PSO) resistor r=0.01452 c=0
Rk7 (\5\:PSO \7\:PSO) resistor r=0.01694 c=0
Rk6 (\6\:PSO \7\:PSO) resistor r=0.00333 c=0
Rk1 (\14\:pson \15\:pson) resistor r=0.2801 c=0
Rk2 (\14\:pson \17\:pson) resistor r=0.5333 c=0
Rk10 (\102\:n0 \103\:n0) resistor r=0.3546 c=0
Rk11 (\103\:n0 \105\:n0) resistor r=0.3196 c=0
Rk12 (\103\:n0 \107\:n0) resistor r=0.21 c=0
Rl1 (\1\:PSO \2\:PSO) resistor r=62.6365 c=0
Rl2 (\2\:PSO \3\:PSO) resistor r=58.7903 c=0
Rl5 (\4\:pson pson) resistor r=153.846 c=0
Rl12 (\11\:pson \6\:pson) resistor r=39.7092 c=0
Rl3 (\2\:pson pson) resistor r=93.5977 c=0
Rl4 (\2\:pson \3\:pson) resistor r=63.5319 c=0
Rl7 (\5\:pson \6\:pson) resistor r=57.3013 c=0
Rl14 (\5\:pson \11\:pson) resistor r=15.1758 c=0
Rl6 (\5\:pson \2\:pson) resistor r=132.706 c=0
Rl37 (n0 \23\:n0) resistor r=247.291 c=0
Rz2 (\1\:PSO_out \2\:PSO_out) resistor r=37.5 c=0
Rz10 (\16\:VSS \15\:VSS) resistor r=37.5 c=0
Rz1 (\17\:pson \16\:pson) resistor r=37.5 c=0
Rz3 (\107\:n0 \106\:n0) resistor r=37.5 c=0
Ry30 (\83\:ExtVDD \82\:ExtVDD) resistor r=20.6667 c=0
Ry2 (\3\:PSO_out \4\:PSO_out) resistor r=20.6667 c=0
Ry93 (VSS \1\:VSS) resistor r=5.1667 c=0
Ry95 (VSS \10\:VSS) resistor r=5.1667 c=0
Ry92 (VSS \1\:VSS) resistor r=5.1667 c=0
Ry91 (\2\:VSS \1\:VSS) resistor r=5.1667 c=0
Ry94 (\11\:VSS \10\:VSS) resistor r=5.1667 c=0
Ry96 (\13\:VSS \10\:VSS) resistor r=5.1667 c=0
Ry1 (\14\:pson \13\:pson) resistor r=20.6667 c=0
Ry3 (\105\:n0 \104\:n0) resistor r=20.6667 c=0
Rx2 (\2\:PSO \6\:PSO) resistor r=45 c=0
Rx1 (\15\:pson \3\:pson) resistor r=45 c=0
Rx3 (\102\:n0 \23\:n0) resistor r=15 c=0
NM2 (\15\:VSS \3\:PSO \16\:pson VSS) g45n1svt w=(2.6e-07) l=4.5e-08 nf=1 \
        as=4.16e-14 ad=3.64e-14 ps=8.4e-07 pd=8e-07 nrd=1.16667 \
        nrs=1.16667 sa=1.4e-07 sb=3.45e-07 sd=160n sca=9.22468 \
        scb=0.0071987 scc=0.000180033 m=(1)
NM4 (\1\:PSO_out \4\:pson \15\:VSS VSS) g45n1svt w=(2.6e-07) l=4.5e-08 \
        nf=1 as=3.64e-14 ad=4.16e-14 ps=8e-07 pd=8.4e-07 nrd=1.16667 \
        nrs=1.16667 sa=3.45e-07 sb=1.4e-07 sd=160n sca=10.1772 \
        scb=0.00801794 scc=0.000181716 m=(1)
NM0 (VSS \6\:pson \106\:n0 VSS) g45n1svt w=(3e-07) l=4.5e-08 nf=1 \
        as=4.8e-14 ad=4.2e-14 ps=9.2e-07 pd=8.8e-07 nrd=1.16667 \
        nrs=1.16667 sa=3.45e-07 sb=1.4e-07 sd=160n sca=12.6172 \
        scb=0.0114252 scc=0.000508261 m=(2)
PM1_1__rcx (\104\:n0 \6\:pson \19\:ExtVDD ExtVDD) g45p1svt w=(4.5e-07) \
        l=4.5e-08 nf=1 as=6.3e-14 ad=7.2e-14 ps=1.18e-06 pd=1.22e-06 \
        nrd=1.16667 nrs=1.16667 sa=3.45e-07 sb=1.4e-07 sd=160n sca=22.5241 \
        scb=0.0206307 scc=0.00192213 m=(2)
ends HSWX1
// End of subcircuit definition.
