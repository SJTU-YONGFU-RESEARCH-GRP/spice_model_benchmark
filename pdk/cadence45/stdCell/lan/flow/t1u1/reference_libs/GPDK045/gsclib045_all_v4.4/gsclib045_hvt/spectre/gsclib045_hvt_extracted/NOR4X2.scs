// Generated for: spectre (May  1 09:18:28 2013 )
// Library name: gsclib045_hvt
// Cell name: NOR4X2
// View name: extracted

simulator lang=spectre

subckt NOR4X2 A B C D VDD VSS Y
mp0_1__rcx (3 \1\:A \6\:VDD VDD) g45p1hvt w=(3.9e-07) l=4.5e-08 nf=1 \
        as=5.46e-14 ad=2.34e-14 ps=1.06e-06 pd=9e-07 nrd=1.16667 \
        nrs=1.16667 sa=1.4e-07 sb=1.42e-06 sd=160n sca=18.6506 \
        scb=0.0190998 scc=0.000768188 m=(1)
mp1_1__rcx (3 \1\:B 2 VDD) g45p1hvt w=(3.9e-07) l=4.5e-08 nf=1 \
        as=6.825e-14 ad=2.34e-14 ps=1.13e-06 pd=9e-07 nrd=1.16667 \
        nrs=1.16667 sa=2.45e-07 sb=1.315e-06 sd=160n sca=16.4248 \
        scb=0.0152088 scc=0.000666128 m=(1)
mp2_1__rcx (8 \1\:C 2 VDD) g45p1hvt w=(3.9e-07) l=4.5e-08 nf=1 \
        as=6.825e-14 ad=9.75e-14 ps=1.13e-06 pd=1.28e-06 nrd=1.16667 \
        nrs=1.16667 sa=4.65e-07 sb=1.095e-06 sd=160n sca=14.4756 \
        scb=0.0126313 scc=0.000647839 m=(1)
mp3_1__rcx (\9\:Y \4\:D 8 VDD) g45p1hvt w=(3.9e-07) l=4.5e-08 nf=1 \
        as=9.75e-14 ad=6.24e-14 ps=1.28e-06 pd=1.1e-06 nrd=1.16667 \
        nrs=1.16667 sa=7.6e-07 sb=8e-07 sd=160n sca=13.5671 scb=0.012183 \
        scc=0.000647513 m=(1)
mp3 (\9\:Y \1\:D 5 VDD) g45p1hvt w=(3.9e-07) l=4.5e-08 nf=1 as=4.485e-14 \
        ad=6.24e-14 ps=1.01e-06 pd=1.1e-06 nrd=1.16667 nrs=1.16667 \
        sa=9.65e-07 sb=5.95e-07 sd=160n sca=13.8806 scb=0.0122706 \
        scc=0.000647529 m=(1)
mp2 (6 \4\:C 5 VDD) g45p1hvt w=(3.9e-07) l=4.5e-08 nf=1 as=4.485e-14 \
        ad=4.485e-14 ps=1.01e-06 pd=1.01e-06 nrd=1.16667 nrs=1.16667 \
        sa=1.125e-06 sb=4.35e-07 sd=160n sca=14.5014 scb=0.0126527 \
        scc=0.000647871 m=(1)
mp1 (6 \6\:B 4 VDD) g45p1hvt w=(3.9e-07) l=4.5e-08 nf=1 as=2.34e-14 \
        ad=4.485e-14 ps=9e-07 pd=1.01e-06 nrd=1.16667 nrs=1.16667 \
        sa=1.285e-06 sb=2.75e-07 sd=160n sca=15.7201 scb=0.0141032 \
        scc=0.000654378 m=(1)
mp0 (4 \6\:A \1\:VDD VDD) g45p1hvt w=(3.9e-07) l=4.5e-08 nf=1 \
        as=9.33e-14 ad=2.34e-14 ps=1.57e-06 pd=9e-07 nrd=1.16667 \
        nrs=1.16667 sa=1.39e-06 sb=1.7e-07 sd=160n sca=17.2962 \
        scb=0.0167016 scc=0.000693147 m=(1)
C1 (C VSS) capacitor c=4.47206e-17
C2 (D VSS) capacitor c=7.9145e-17
C3 (A VSS) capacitor c=5.52587e-16
C4 (Y VSS) capacitor c=1.29743e-16
C5 (VDD VSS) capacitor c=1.30748e-16
C6 (3 VSS) capacitor c=2.71439e-18
C7 (2 VSS) capacitor c=6.11733e-18
C8 (8 VSS) capacitor c=1.14642e-17
C9 (5 VSS) capacitor c=6.26401e-18
C10 (6 VSS) capacitor c=5.8704e-18
C11 (4 VSS) capacitor c=3.24579e-18
C12 (\6\:A VSS) capacitor c=6.85606e-17
C13 (\6\:B VSS) capacitor c=8.08271e-17
C14 (\4\:C VSS) capacitor c=8.3525e-17
C15 (\1\:D VSS) capacitor c=5.6089e-17
C16 (\4\:D VSS) capacitor c=2.48911e-17
C17 (\1\:C VSS) capacitor c=4.17998e-17
C18 (\1\:B VSS) capacitor c=7.38468e-17
C19 (\1\:A VSS) capacitor c=6.27747e-17
C20 (\3\:D VSS) capacitor c=9.01316e-17
C21 (\2\:C VSS) capacitor c=3.8171e-16
C22 (\2\:B VSS) capacitor c=5.16878e-16
C23 (\1\:VDD VSS) capacitor c=4.25189e-17
C24 (\9\:Y VSS) capacitor c=9.79666e-17
C25 (\6\:VDD VSS) capacitor c=3.33774e-17
C26 (\1\:Y VSS) capacitor c=3.23037e-16
C27 (\2\:D VSS) capacitor c=2.22867e-17
C28 (\8\:D VSS) capacitor c=6.4611e-17
C29 (\4\:VDD VSS) capacitor c=3.52764e-17
C30 (\5\:VDD VSS) capacitor c=1.48365e-17
Rk18 (\1\:VSS VSS) resistor r=0.0151 c=0
Rk20 (\1\:VSS \10\:VSS) resistor r=0.2456 c=0
Rk6 (C \2\:C) resistor r=0.1193 c=0
Rk3 (D \8\:D) resistor r=0.0177 c=0
Rk13 (\1\:Y Y) resistor r=0.6934 c=0
Rk14 (Y \10\:Y) resistor r=0.6432 c=0
Rk24 (\2\:VDD \4\:VDD) resistor r=0.4119 c=0
Rk26 (\5\:VDD VDD) resistor r=0.07227 c=0
Rk25 (\4\:VDD \5\:VDD) resistor r=0.3784 c=0
Rk27 (\5\:VDD \7\:VDD) resistor r=0.224 c=0
Rk5 (\2\:B B) resistor r=0.005639 c=0
Rl12 (\2\:C \4\:C) resistor r=114.153 c=0
Rl5 (\2\:C \1\:C) resistor r=56.461 c=0
Rl7 (\2\:D \1\:D) resistor r=100.426 c=0
Rl9 (\2\:D \4\:D) resistor r=35.772 c=0
Rl8 (\2\:D \3\:D) resistor r=87.6951 c=0
Rl17 (A \6\:A) resistor r=59.8103 c=0
Rl1 (A \1\:A) resistor r=49.05 c=0
Rl15 (\2\:B \6\:B) resistor r=29.5379 c=0
Rl3 (\2\:B \1\:B) resistor r=44.9225 c=0
Rz7 (\10\:VSS \9\:VSS) resistor r=75 c=0
Ry1 (\10\:Y \9\:Y) resistor r=62 c=0
Ry3 (\1\:VDD \2\:VDD) resistor r=62 c=0
Ry4 (\6\:VDD \7\:VDD) resistor r=62 c=0
Rx1 (\8\:D \3\:D) resistor r=45 c=0
mn3 (\1\:Y \3\:D \9\:VSS VSS) g45n1hvt w=(2.6e-07) l=4.5e-08 nf=1 \
        as=4.16e-14 ad=4.745e-14 ps=8.4e-07 pd=8.85e-07 nrd=1.16667 \
        nrs=1.16667 sa=8e-07 sb=1.02e-06 sd=160n sca=9.14564 \
        scb=0.00759168 scc=0.000213449 m=(2)
mn0_1__rcx (\1\:Y A \1\:VSS VSS) g45n1hvt w=(2.6e-07) l=4.5e-08 nf=1 \
        as=3.835e-14 ad=4.55e-14 ps=8.15e-07 pd=8.7e-07 nrd=1.16667 \
        nrs=1.16667 sa=1.4e-07 sb=1.68e-06 sd=160n sca=9.14564 \
        scb=0.00759168 scc=0.000213449 m=(2)
mn1 (\1\:Y \2\:B \1\:VSS VSS) g45n1hvt w=(2.6e-07) l=4.5e-08 nf=1 \
        as=4.355e-14 ad=4.55e-14 ps=8.55e-07 pd=8.7e-07 nrd=1.16667 \
        nrs=1.16667 sa=3.6e-07 sb=1.46e-06 sd=160n sca=9.14564 \
        scb=0.00759168 scc=0.000213449 m=(2)
mn2_1__rcx (\1\:Y \2\:C \1\:VSS VSS) g45n1hvt w=(2.6e-07) l=4.5e-08 nf=1 \
        as=4.355e-14 ad=4.745e-14 ps=8.55e-07 pd=8.85e-07 nrd=1.16667 \
        nrs=1.16667 sa=5.8e-07 sb=1.24e-06 sd=160n sca=9.14564 \
        scb=0.00759168 scc=0.000213449 m=(2)
ends NOR4X2
// End of subcircuit definition.
