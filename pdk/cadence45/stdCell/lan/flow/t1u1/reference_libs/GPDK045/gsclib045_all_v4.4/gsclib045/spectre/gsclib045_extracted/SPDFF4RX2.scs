// Generated for: spectre (May  1 08:13:17 2013 )
// Library name: gsclib045
// Cell name: SPDFF4RX2
// View name: extracted

simulator lang=spectre

subckt SPDFF4RX2 CK D1 D2 D3 D4 Q1 Q1N Q2 Q2N Q3 Q3N Q4 Q4N RN SE SI1 SI2 \
        SI3 SI4 VDD VSS
PM40_1__rcx (\5\:Q4 \6\:qbint_4 \6\:VDD VDD) g45p1svt w=(3.9e-07) \
        l=4.5e-08 nf=1 as=9.642e-14 ad=1.312e-13 ps=1.74e-06 pd=1.935e-06 \
        nrd=1.16667 nrs=1.16667 sa=1.43019e-06 sb=1.2e-07 sd=160n \
        sca=30.5009 scb=0.0202006 scc=0.00336097 m=(2)
PM37 (\3\:Q3N qint_3 \30\:VDD VDD) g45p1svt w=(3.9e-07) l=4.5e-08 nf=1 \
        as=8.951e-14 ad=6.24e-14 ps=1.885e-06 pd=1.1e-06 nrd=1.16667 \
        nrs=1.16667 sa=2.5e-07 sb=3.25e-07 sd=160n sca=30.5009 \
        scb=0.0202006 scc=0.00336097 m=(2)
PM19 (\3\:Q2N qint_2 \83\:VDD VDD) g45p1svt w=(3.9e-07) l=4.5e-08 nf=1 \
        as=8.951e-14 ad=6.24e-14 ps=1.885e-06 pd=1.1e-06 nrd=1.16667 \
        nrs=1.16667 sa=1.2e-07 sb=4.55e-07 sd=160n sca=30.5009 \
        scb=0.0202006 scc=0.00336097 m=(2)
PM38 (\3\:Q4N qint_4 \1\:VDD VDD) g45p1svt w=(3.9e-07) l=4.5e-08 nf=1 \
        as=8.951e-14 ad=6.24e-14 ps=1.885e-06 pd=1.1e-06 nrd=1.16667 \
        nrs=1.16667 sa=2.5e-07 sb=3.25e-07 sd=160n sca=31.932 \
        scb=0.0211673 scc=0.00336255 m=(2)
PM17 (\6\:Q2 qbint_2 \77\:VDD VDD) g45p1svt w=(3.9e-07) l=4.5e-08 nf=1 \
        as=9.642e-14 ad=1.312e-13 ps=1.74e-06 pd=1.935e-06 nrd=1.16667 \
        nrs=1.16667 sa=1.43019e-06 sb=1.2e-07 sd=160n sca=30.5009 \
        scb=0.0202006 scc=0.00336097 m=(2)
PM35 (\5\:Q3 \6\:qbint_3 \36\:VDD VDD) g45p1svt w=(3.9e-07) l=4.5e-08 \
        nf=1 as=9.642e-14 ad=1.312e-13 ps=1.74e-06 pd=1.935e-06 \
        nrd=1.16667 nrs=1.16667 sa=1.43019e-06 sb=1.2e-07 sd=160n \
        sca=30.5009 scb=0.0202006 scc=0.00336097 m=(2)
mp57_1__rcx (\3\:Q1N qint \112\:VDD VDD) g45p1svt w=(3.9e-07) l=4.5e-08 \
        nf=1 as=8.951e-14 ad=6.24e-14 ps=1.885e-06 pd=1.1e-06 nrd=1.16667 \
        nrs=1.16667 sa=1.2e-07 sb=4.55e-07 sd=160n sca=34.6642 \
        scb=0.0254864 scc=0.00342609 m=(2)
mp55_1__rcx (\6\:Q1 qbint \106\:VDD VDD) g45p1svt w=(3.9e-07) l=4.5e-08 \
        nf=1 as=9.642e-14 ad=1.312e-13 ps=1.74e-06 pd=1.935e-06 \
        nrd=1.16667 nrs=1.16667 sa=1.43019e-06 sb=1.2e-07 sd=160n \
        sca=30.5009 scb=0.0202006 scc=0.00336097 m=(2)
C1 (SI3 VSS) capacitor c=4.23394e-17
C2 (Q4N VSS) capacitor c=2.46337e-17
C3 (Q4 VSS) capacitor c=2.91977e-17
C4 (VDD VSS) capacitor c=1.71285e-15
C5 (Q1N VSS) capacitor c=2.43539e-17
C6 (D4 VSS) capacitor c=2.08566e-17
C7 (SI4 VSS) capacitor c=4.25128e-17
C8 (RN VSS) capacitor c=3.51886e-17
C9 (SE VSS) capacitor c=2.72945e-17
C10 (CK VSS) capacitor c=4.62339e-17
C11 (D1 VSS) capacitor c=2.02624e-17
C12 (SI1 VSS) capacitor c=4.24162e-17
C13 (Q2N VSS) capacitor c=2.47809e-17
C14 (D2 VSS) capacitor c=2.02624e-17
C15 (SI2 VSS) capacitor c=4.21302e-17
C16 (Q3N VSS) capacitor c=2.51677e-17
C17 (D3 VSS) capacitor c=2.08566e-17
C18 (Ckbb VSS) capacitor c=2.22894e-17
C19 (CKb VSS) capacitor c=3.43291e-17
C20 (Db VSS) capacitor c=5.0385e-17
C21 (qint VSS) capacitor c=1.21909e-16
C22 (n8 VSS) capacitor c=1.76436e-18
C23 (n6 VSS) capacitor c=6.72223e-17
C24 (SEb VSS) capacitor c=4.28106e-17
C25 (qbint VSS) capacitor c=1.26536e-16
C26 (n30 VSS) capacitor c=4.09537e-17
C27 (mout VSS) capacitor c=5.22995e-17
C28 (n20 VSS) capacitor c=2.55521e-17
C29 (n2 VSS) capacitor c=3.96884e-18
C30 (n4 VSS) capacitor c=1.50247e-18
C31 (n9 VSS) capacitor c=1.21856e-18
C32 (n11 VSS) capacitor c=3.08731e-18
C33 (n5 VSS) capacitor c=2.3104e-19
C34 (n1 VSS) capacitor c=2.88673e-18
C35 (Db_2 VSS) capacitor c=5.05828e-17
C36 (qint_2 VSS) capacitor c=1.60974e-16
C37 (n8_2 VSS) capacitor c=1.76436e-18
C38 (n6_2 VSS) capacitor c=6.72223e-17
C39 (SEb_2 VSS) capacitor c=4.29388e-17
C40 (qbint_2 VSS) capacitor c=1.53134e-16
C41 (n30_2 VSS) capacitor c=4.09537e-17
C42 (mout_2 VSS) capacitor c=5.22998e-17
C43 (n20_2 VSS) capacitor c=2.55522e-17
C44 (n2_2 VSS) capacitor c=3.96884e-18
C45 (n4_2 VSS) capacitor c=1.50187e-18
C46 (n9_2 VSS) capacitor c=1.21856e-18
C47 (n11_2 VSS) capacitor c=3.08731e-18
C48 (n5_2 VSS) capacitor c=2.3104e-19
C49 (n1_2 VSS) capacitor c=2.88673e-18
C50 (Db_3 VSS) capacitor c=1.02875e-16
C51 (qint_3 VSS) capacitor c=1.61765e-16
C52 (n8_3 VSS) capacitor c=1.76436e-18
C53 (n6_3 VSS) capacitor c=7.48955e-17
C54 (SEb_3 VSS) capacitor c=5.68111e-17
C55 (qbint_3 VSS) capacitor c=4.73513e-17
C56 (n30_3 VSS) capacitor c=4.9461e-17
C57 (mout_3 VSS) capacitor c=5.25786e-17
C58 (n20_3 VSS) capacitor c=4.67209e-17
C59 (n2_3 VSS) capacitor c=3.95036e-18
C60 (n4_3 VSS) capacitor c=1.50247e-18
C61 (n9_3 VSS) capacitor c=1.18302e-18
C62 (n11_3 VSS) capacitor c=3.08731e-18
C63 (n5_3 VSS) capacitor c=2.3104e-19
C64 (n1_3 VSS) capacitor c=2.88673e-18
C65 (Db_4 VSS) capacitor c=1.02845e-16
C66 (qint_4 VSS) capacitor c=1.21976e-16
C67 (n8_4 VSS) capacitor c=1.76436e-18
C68 (n6_4 VSS) capacitor c=7.48955e-17
C69 (SEb_4 VSS) capacitor c=5.68047e-17
C70 (qbint_4 VSS) capacitor c=4.7356e-17
C71 (n30_4 VSS) capacitor c=4.93483e-17
C72 (mout_4 VSS) capacitor c=5.25776e-17
C73 (n20_4 VSS) capacitor c=4.67199e-17
C74 (n2_4 VSS) capacitor c=3.95036e-18
C75 (n4_4 VSS) capacitor c=1.50247e-18
C76 (n9_4 VSS) capacitor c=1.18302e-18
C77 (n11_4 VSS) capacitor c=3.08731e-18
C78 (n5_4 VSS) capacitor c=2.3104e-19
C79 (n1_4 VSS) capacitor c=2.88673e-18
C80 (\4\:qbint_4 VSS) capacitor c=3.52654e-17
C81 (\27\:RN VSS) capacitor c=3.27082e-17
C82 (\30\:Ckbb VSS) capacitor c=7.6512e-17
C83 (\29\:CKb VSS) capacitor c=2.87123e-17
C84 (\23\:RN VSS) capacitor c=6.5104e-17
C85 (\27\:CKb VSS) capacitor c=3.75016e-17
C86 (\26\:Ckbb VSS) capacitor c=9.09037e-17
C87 (\1\:D4 VSS) capacitor c=4.76409e-17
C88 (\27\:SE VSS) capacitor c=4.13386e-17
C89 (\3\:SEb_4 VSS) capacitor c=4.27899e-17
C90 (\3\:SI4 VSS) capacitor c=8.45991e-17
C91 (\22\:SE VSS) capacitor c=4.42305e-17
C92 (\4\:qbint_3 VSS) capacitor c=4.05902e-17
C93 (\20\:RN VSS) capacitor c=3.27082e-17
C94 (\19\:Ckbb VSS) capacitor c=7.49434e-17
C95 (\22\:CKb VSS) capacitor c=2.87207e-17
C96 (\16\:RN VSS) capacitor c=6.5104e-17
C97 (\20\:CKb VSS) capacitor c=3.75016e-17
C98 (\15\:Ckbb VSS) capacitor c=9.09064e-17
C99 (\1\:D3 VSS) capacitor c=4.76426e-17
C100 (\20\:SE VSS) capacitor c=4.13386e-17
C101 (\3\:SEb_3 VSS) capacitor c=4.27899e-17
C102 (\3\:SI3 VSS) capacitor c=8.36857e-17
C103 (\15\:SE VSS) capacitor c=4.64072e-17
C104 (\1\:CK VSS) capacitor c=3.97193e-17
C105 (\18\:CKb VSS) capacitor c=3.4982e-17
C106 (\12\:SE VSS) capacitor c=4.42339e-17
C107 (\3\:SI2 VSS) capacitor c=8.22752e-17
C108 (\8\:SE VSS) capacitor c=4.09456e-17
C109 (\1\:D2 VSS) capacitor c=4.65692e-17
C110 (\13\:Ckbb VSS) capacitor c=9.02268e-17
C111 (\13\:CKb VSS) capacitor c=3.66746e-17
C112 (\13\:RN VSS) capacitor c=6.54428e-17
C113 (\4\:n20_2 VSS) capacitor c=4.61479e-17
C114 (\10\:CKb VSS) capacitor c=2.85049e-17
C115 (\10\:Ckbb VSS) capacitor c=7.66501e-17
C116 (\11\:qbint_2 VSS) capacitor c=4.83225e-17
C117 (\10\:RN VSS) capacitor c=3.28447e-17
C118 (\3\:n30_2 VSS) capacitor c=4.80863e-17
C119 (\10\:qbint_2 VSS) capacitor c=4.00918e-17
C120 (\5\:SE VSS) capacitor c=4.44051e-17
C121 (\3\:SI1 VSS) capacitor c=8.44173e-17
C122 (\1\:SE VSS) capacitor c=4.08287e-17
C123 (\1\:D1 VSS) capacitor c=4.65676e-17
C124 (\6\:Ckbb VSS) capacitor c=9.02246e-17
C125 (\6\:CKb VSS) capacitor c=3.66746e-17
C126 (\6\:RN VSS) capacitor c=6.54428e-17
C127 (\4\:n20 VSS) capacitor c=4.61476e-17
C128 (\3\:CKb VSS) capacitor c=2.85034e-17
C129 (\3\:Ckbb VSS) capacitor c=7.66772e-17
C130 (\11\:qbint VSS) capacitor c=4.8328e-17
C131 (\3\:RN VSS) capacitor c=3.28447e-17
C132 (\3\:n30 VSS) capacitor c=4.79747e-17
C133 (\10\:qbint VSS) capacitor c=3.51339e-17
C134 (\9\:qbint_4 VSS) capacitor c=3.04938e-17
C135 (\3\:n30_4 VSS) capacitor c=4.16089e-17
C136 (\25\:RN VSS) capacitor c=5.15561e-17
C137 (\3\:qbint_4 VSS) capacitor c=4.03738e-17
C138 (\31\:CKb VSS) capacitor c=3.40678e-17
C139 (\31\:Ckbb VSS) capacitor c=6.02164e-17
C140 (\4\:n20_4 VSS) capacitor c=4.02612e-17
C141 (\24\:RN VSS) capacitor c=8.26802e-17
C142 (\3\:mout_4 VSS) capacitor c=4.93331e-17
C143 (\28\:Ckbb VSS) capacitor c=5.79078e-17
C144 (\26\:CKb VSS) capacitor c=5.7991e-17
C145 (\3\:D4 VSS) capacitor c=4.06457e-17
C146 (\25\:SE VSS) capacitor c=4.33001e-17
C147 (\1\:SI4 VSS) capacitor c=5.63485e-17
C148 (\24\:SE VSS) capacitor c=3.95202e-17
C149 (\9\:qbint_3 VSS) capacitor c=3.5842e-17
C150 (\3\:n30_3 VSS) capacitor c=4.16089e-17
C151 (\18\:RN VSS) capacitor c=5.15561e-17
C152 (\3\:qbint_3 VSS) capacitor c=4.03738e-17
C153 (\24\:CKb VSS) capacitor c=3.408e-17
C154 (\20\:Ckbb VSS) capacitor c=6.02148e-17
C155 (\4\:n20_3 VSS) capacitor c=4.02749e-17
C156 (\17\:RN VSS) capacitor c=8.26843e-17
C157 (\3\:mout_3 VSS) capacitor c=4.93331e-17
C158 (\17\:Ckbb VSS) capacitor c=5.79086e-17
C159 (\19\:CKb VSS) capacitor c=5.7991e-17
C160 (\3\:D3 VSS) capacitor c=4.06457e-17
C161 (\18\:SE VSS) capacitor c=4.345e-17
C162 (\1\:SI3 VSS) capacitor c=5.68693e-17
C163 (\17\:SE VSS) capacitor c=4.07218e-17
C164 (\3\:CK VSS) capacitor c=4.14933e-17
C165 (\17\:CKb VSS) capacitor c=3.06741e-17
C166 (\14\:SE VSS) capacitor c=4.05823e-17
C167 (\1\:SI2 VSS) capacitor c=5.49139e-17
C168 (\10\:SE VSS) capacitor c=4.345e-17
C169 (\3\:SEb_2 VSS) capacitor c=5.71893e-17
C170 (\3\:D2 VSS) capacitor c=4.06724e-17
C171 (\14\:CKb VSS) capacitor c=5.81134e-17
C172 (\11\:Ckbb VSS) capacitor c=5.79328e-17
C173 (\3\:mout_2 VSS) capacitor c=4.93391e-17
C174 (\12\:RN VSS) capacitor c=8.2561e-17
C175 (\3\:n20_2 VSS) capacitor c=3.98228e-17
C176 (\9\:Ckbb VSS) capacitor c=6.03062e-17
C177 (\8\:CKb VSS) capacitor c=3.43169e-17
C178 (\13\:qbint_2 VSS) capacitor c=4.03738e-17
C179 (\8\:RN VSS) capacitor c=5.13394e-17
C180 (\5\:qbint_2 VSS) capacitor c=3.58385e-17
C181 (\7\:SE VSS) capacitor c=3.95567e-17
C182 (\1\:SI1 VSS) capacitor c=5.63485e-17
C183 (\3\:SE VSS) capacitor c=4.33001e-17
C184 (\3\:SEb VSS) capacitor c=5.71894e-17
C185 (\3\:D1 VSS) capacitor c=4.06724e-17
C186 (\7\:CKb VSS) capacitor c=5.81133e-17
C187 (\4\:Ckbb VSS) capacitor c=5.79321e-17
C188 (\3\:mout VSS) capacitor c=4.93391e-17
C189 (\5\:RN VSS) capacitor c=8.25573e-17
C190 (\3\:n20 VSS) capacitor c=3.9835e-17
C191 (\2\:Ckbb VSS) capacitor c=6.03045e-17
C192 (\13\:qbint VSS) capacitor c=4.03738e-17
C193 (\1\:RN VSS) capacitor c=5.13394e-17
C194 (\5\:qbint VSS) capacitor c=3.04921e-17
C195 (\4\:qint_4 VSS) capacitor c=2.31475e-17
C196 (\8\:qbint_4 VSS) capacitor c=1.78944e-17
C197 (\2\:n30_4 VSS) capacitor c=4.09824e-17
C198 (\28\:RN VSS) capacitor c=2.88185e-17
C199 (\26\:RN VSS) capacitor c=1.36843e-16
C200 (\2\:qbint_4 VSS) capacitor c=4.34306e-17
C201 (\32\:CKb VSS) capacitor c=5.05396e-17
C202 (\32\:Ckbb VSS) capacitor c=2.22619e-17
C203 (\30\:CKb VSS) capacitor c=3.9247e-17
C204 (\3\:n20_4 VSS) capacitor c=2.51715e-17
C205 (\22\:RN VSS) capacitor c=2.95042e-17
C206 (\2\:mout_4 VSS) capacitor c=4.88215e-17
C207 (\29\:Ckbb VSS) capacitor c=2.17719e-17
C208 (\28\:CKb VSS) capacitor c=4.0862e-17
C209 (\27\:Ckbb VSS) capacitor c=4.46796e-17
C210 (\2\:D4 VSS) capacitor c=3.65522e-17
C211 (\28\:SE VSS) capacitor c=5.0578e-17
C212 (\2\:SEb_4 VSS) capacitor c=7.66708e-17
C213 (\26\:SE VSS) capacitor c=5.01787e-17
C214 (\2\:SI4 VSS) capacitor c=4.89219e-17
C215 (\23\:SE VSS) capacitor c=2.61959e-17
C216 (\4\:qint_3 VSS) capacitor c=2.39935e-17
C217 (\8\:qbint_3 VSS) capacitor c=1.90326e-17
C218 (\2\:n30_3 VSS) capacitor c=4.09857e-17
C219 (\21\:RN VSS) capacitor c=2.89267e-17
C220 (\19\:RN VSS) capacitor c=1.36844e-16
C221 (\2\:qbint_3 VSS) capacitor c=4.34303e-17
C222 (\25\:CKb VSS) capacitor c=5.04876e-17
C223 (\21\:Ckbb VSS) capacitor c=2.22406e-17
C224 (\23\:CKb VSS) capacitor c=3.92471e-17
C225 (\3\:n20_3 VSS) capacitor c=2.51716e-17
C226 (\15\:RN VSS) capacitor c=2.95394e-17
C227 (\2\:mout_3 VSS) capacitor c=4.88215e-17
C228 (\18\:Ckbb VSS) capacitor c=2.1772e-17
C229 (\21\:CKb VSS) capacitor c=4.08646e-17
C230 (\16\:Ckbb VSS) capacitor c=4.46127e-17
C231 (\2\:D3 VSS) capacitor c=3.65523e-17
C232 (\21\:SE VSS) capacitor c=5.0586e-17
C233 (\2\:SEb_3 VSS) capacitor c=7.66847e-17
C234 (\19\:SE VSS) capacitor c=5.02064e-17
C235 (\2\:SI3 VSS) capacitor c=4.89202e-17
C236 (\16\:SE VSS) capacitor c=2.58441e-17
C237 (\2\:CK VSS) capacitor c=3.26581e-17
C238 (\15\:CKb VSS) capacitor c=2.08504e-17
C239 (\13\:SE VSS) capacitor c=2.66574e-17
C240 (\2\:SI2 VSS) capacitor c=4.89409e-17
C241 (\11\:SE VSS) capacitor c=5.02647e-17
C242 (\2\:SEb_2 VSS) capacitor c=7.59001e-17
C243 (\9\:SE VSS) capacitor c=5.05765e-17
C244 (\2\:D2 VSS) capacitor c=3.65354e-17
C245 (\14\:Ckbb VSS) capacitor c=4.45378e-17
C246 (\12\:CKb VSS) capacitor c=4.08439e-17
C247 (\12\:Ckbb VSS) capacitor c=2.1772e-17
C248 (\2\:mout_2 VSS) capacitor c=4.88183e-17
C249 (\14\:RN VSS) capacitor c=2.96596e-17
C250 (\11\:CKb VSS) capacitor c=3.97498e-17
C251 (\8\:Ckbb VSS) capacitor c=2.22358e-17
C252 (\9\:CKb VSS) capacitor c=5.04931e-17
C253 (\12\:qbint_2 VSS) capacitor c=4.34462e-17
C254 (\9\:RN VSS) capacitor c=1.36915e-16
C255 (\11\:RN VSS) capacitor c=2.89059e-17
C256 (\2\:n30_2 VSS) capacitor c=4.10088e-17
C257 (\6\:qint_2 VSS) capacitor c=2.39803e-17
C258 (\6\:SE VSS) capacitor c=2.58717e-17
C259 (\2\:SI1 VSS) capacitor c=4.89465e-17
C260 (\4\:SE VSS) capacitor c=5.02533e-17
C261 (\2\:SEb VSS) capacitor c=7.58933e-17
C262 (\2\:SE VSS) capacitor c=5.05765e-17
C263 (\2\:D1 VSS) capacitor c=3.65353e-17
C264 (\7\:Ckbb VSS) capacitor c=4.46047e-17
C265 (\5\:CKb VSS) capacitor c=4.08467e-17
C266 (\5\:Ckbb VSS) capacitor c=2.17719e-17
C267 (\2\:mout VSS) capacitor c=4.88244e-17
C268 (\7\:RN VSS) capacitor c=2.96267e-17
C269 (\4\:CKb VSS) capacitor c=3.97497e-17
C270 (\2\:CKb VSS) capacitor c=5.05451e-17
C271 (\12\:qbint VSS) capacitor c=4.34465e-17
C272 (\2\:RN VSS) capacitor c=1.36914e-16
C273 (\4\:RN VSS) capacitor c=2.88001e-17
C274 (\2\:n30 VSS) capacitor c=4.10083e-17
C275 (\6\:qint VSS) capacitor c=2.3136e-17
C276 (\1\:VDD VSS) capacitor c=1.30703e-17
C277 (\3\:Q4N VSS) capacitor c=4.46779e-17
C278 (\8\:qint_4 VSS) capacitor c=1.89607e-17
C279 (\5\:Q4 VSS) capacitor c=3.28147e-19
C280 (\16\:qbint_4 VSS) capacitor c=1.25763e-16
C281 (\20\:VDD VSS) capacitor c=2.85313e-17
C282 (\4\:n30_4 VSS) capacitor c=8.63003e-17
C283 (\4\:mout_4 VSS) capacitor c=5.63424e-17
C284 (\22\:VDD VSS) capacitor c=1.96838e-17
C285 (\24\:VDD VSS) capacitor c=2.17753e-17
C286 (\3\:n6_4 VSS) capacitor c=6.7455e-17
C287 (\7\:n20_4 VSS) capacitor c=6.88936e-17
C288 (\4\:Db_4 VSS) capacitor c=9.02488e-17
C289 (\26\:VDD VSS) capacitor c=1.92995e-17
C290 (\6\:Db_4 VSS) capacitor c=5.06203e-17
C291 (\28\:VDD VSS) capacitor c=2.47713e-17
C292 (\5\:SEb_4 VSS) capacitor c=1.02007e-16
C293 (\3\:Q3N VSS) capacitor c=7.35044e-17
C294 (\8\:qint_3 VSS) capacitor c=2.71655e-17
C295 (\5\:Q3 VSS) capacitor c=8.88957e-17
C296 (\16\:qbint_3 VSS) capacitor c=1.25763e-16
C297 (\44\:VDD VSS) capacitor c=2.83631e-17
C298 (\4\:n30_3 VSS) capacitor c=8.60994e-17
C299 (\4\:mout_3 VSS) capacitor c=5.63424e-17
C300 (\47\:VDD VSS) capacitor c=1.9504e-17
C301 (\50\:VDD VSS) capacitor c=2.15956e-17
C302 (\3\:n6_3 VSS) capacitor c=6.7455e-17
C303 (\7\:n20_3 VSS) capacitor c=6.88936e-17
C304 (\4\:Db_3 VSS) capacitor c=9.02488e-17
C305 (\53\:VDD VSS) capacitor c=1.92511e-17
C306 (\6\:Db_3 VSS) capacitor c=5.06203e-17
C307 (\56\:VDD VSS) capacitor c=2.46284e-17
C308 (\5\:SEb_3 VSS) capacitor c=1.08481e-16
C309 (\56\:CKb VSS) capacitor c=3.58392e-17
C310 (\59\:VDD VSS) capacitor c=1.73919e-17
C311 (\24\:Ckbb VSS) capacitor c=1.1931e-16
C312 (\6\:SEb_2 VSS) capacitor c=1.08863e-16
C313 (\62\:VDD VSS) capacitor c=2.42678e-17
C314 (\65\:VDD VSS) capacitor c=1.92823e-17
C315 (\4\:Db_2 VSS) capacitor c=8.97079e-17
C316 (\5\:n20_2 VSS) capacitor c=6.90653e-17
C317 (\68\:VDD VSS) capacitor c=2.15214e-17
C318 (\3\:n6_2 VSS) capacitor c=7.56767e-17
C319 (\71\:VDD VSS) capacitor c=1.9496e-17
C320 (\8\:mout_2 VSS) capacitor c=5.62645e-17
C321 (\4\:n30_2 VSS) capacitor c=8.61595e-17
C322 (\75\:VDD VSS) capacitor c=2.83724e-17
C323 (\15\:qbint_2 VSS) capacitor c=1.25297e-16
C324 (\6\:Q2 VSS) capacitor c=7.05477e-18
C325 (\8\:qint_2 VSS) capacitor c=2.83464e-17
C326 (\3\:Q2N VSS) capacitor c=7.34461e-17
C327 (\6\:SEb VSS) capacitor c=1.02296e-16
C328 (\91\:VDD VSS) capacitor c=2.4773e-17
C329 (\94\:VDD VSS) capacitor c=1.92692e-17
C330 (\4\:Db VSS) capacitor c=8.97079e-17
C331 (\5\:n20 VSS) capacitor c=6.90653e-17
C332 (\98\:VDD VSS) capacitor c=2.17377e-17
C333 (\3\:n6 VSS) capacitor c=7.56767e-17
C334 (\101\:VDD VSS) capacitor c=1.96646e-17
C335 (\8\:mout VSS) capacitor c=5.62646e-17
C336 (\4\:n30 VSS) capacitor c=8.63852e-17
C337 (\104\:VDD VSS) capacitor c=2.8541e-17
C338 (\15\:qbint VSS) capacitor c=1.25297e-16
C339 (\6\:Q1 VSS) capacitor c=3.28147e-19
C340 (\8\:qint VSS) capacitor c=1.9054e-17
C341 (\3\:Q1N VSS) capacitor c=3.89275e-17
C342 (\4\:VDD VSS) capacitor c=1.88502e-16
C343 (\1\:Q4N VSS) capacitor c=1.74296e-17
C344 (\11\:qint_4 VSS) capacitor c=1.8038e-17
C345 (\19\:qbint_4 VSS) capacitor c=4.65344e-17
C346 (\6\:n30_4 VSS) capacitor c=1.41436e-16
C347 (\8\:mout_4 VSS) capacitor c=3.01247e-17
C348 (\9\:n20_4 VSS) capacitor c=4.66623e-17
C349 (\8\:Db_4 VSS) capacitor c=7.35275e-17
C350 (\7\:SEb_4 VSS) capacitor c=7.24426e-17
C351 (\1\:Q3N VSS) capacitor c=3.03794e-17
C352 (\11\:qint_3 VSS) capacitor c=2.80436e-17
C353 (\1\:Q3 VSS) capacitor c=4.12726e-17
C354 (\19\:qbint_3 VSS) capacitor c=4.65877e-17
C355 (\6\:n30_3 VSS) capacitor c=1.41295e-16
C356 (\8\:mout_3 VSS) capacitor c=3.01247e-17
C357 (\9\:n20_3 VSS) capacitor c=4.66623e-17
C358 (\8\:Db_3 VSS) capacitor c=7.35275e-17
C359 (\7\:SEb_3 VSS) capacitor c=7.88926e-17
C360 (\51\:CKb VSS) capacitor c=5.74251e-17
C361 (\22\:Ckbb VSS) capacitor c=5.40522e-16
C362 (\4\:SEb_2 VSS) capacitor c=7.97915e-17
C363 (\6\:Db_2 VSS) capacitor c=1.03112e-16
C364 (\8\:Db_2 VSS) capacitor c=7.37703e-17
C365 (\9\:n20_2 VSS) capacitor c=4.66805e-17
C366 (\6\:mout_2 VSS) capacitor c=3.01511e-17
C367 (\6\:n30_2 VSS) capacitor c=1.4276e-16
C368 (\19\:qbint_2 VSS) capacitor c=4.65078e-17
C369 (\2\:Q2 VSS) capacitor c=7.5105e-19
C370 (\12\:qint_2 VSS) capacitor c=2.80436e-17
C371 (\1\:Q2N VSS) capacitor c=3.03794e-17
C372 (\4\:SEb VSS) capacitor c=7.22932e-17
C373 (\6\:Db VSS) capacitor c=1.03081e-16
C374 (\8\:Db VSS) capacitor c=7.37703e-17
C375 (\9\:n20 VSS) capacitor c=4.66805e-17
C376 (\6\:mout VSS) capacitor c=3.01511e-17
C377 (\6\:n30 VSS) capacitor c=1.42901e-16
C378 (\19\:qbint VSS) capacitor c=4.64545e-17
C379 (\12\:qint VSS) capacitor c=1.80147e-17
C380 (\1\:Q1N VSS) capacitor c=1.37388e-17
C381 (\4\:qbint VSS) capacitor c=3.16698e-17
C382 (\2\:n20 VSS) capacitor c=2.37037e-17
C383 (\10\:qint VSS) capacitor c=1.72476e-17
C384 (\11\:qint VSS) capacitor c=3.84969e-17
C385 (\1\:Q1 VSS) capacitor c=2.65998e-17
C386 (\4\:Q1 VSS) capacitor c=2.91314e-17
C387 (\5\:Q1 VSS) capacitor c=2.38969e-17
C388 (\4\:qbint_2 VSS) capacitor c=3.56483e-17
C389 (\14\:qbint VSS) capacitor c=9.64018e-17
C390 (\17\:qbint VSS) capacitor c=5.0444e-17
C391 (\18\:qbint VSS) capacitor c=1.75694e-17
C392 (\8\:n30 VSS) capacitor c=1.33004e-16
C393 (\4\:mout VSS) capacitor c=7.89724e-17
C394 (\5\:mout VSS) capacitor c=7.35246e-17
C395 (\2\:n20_2 VSS) capacitor c=2.37037e-17
C396 (\7\:n20 VSS) capacitor c=9.99108e-17
C397 (\8\:n20 VSS) capacitor c=1.03531e-16
C398 (\4\:D1 VSS) capacitor c=5.25379e-17
C399 (\3\:Db VSS) capacitor c=1.04576e-16
C400 (\4\:SI1 VSS) capacitor c=3.0521e-17
C401 (\8\:SEb VSS) capacitor c=9.29991e-17
C402 (\16\:CKb VSS) capacitor c=1.35609e-17
C403 (\10\:qint_2 VSS) capacitor c=1.922e-17
C404 (\11\:qint_2 VSS) capacitor c=4.28927e-17
C405 (\1\:Q2 VSS) capacitor c=4.05213e-17
C406 (\4\:Q2 VSS) capacitor c=2.85345e-17
C407 (\5\:Q2 VSS) capacitor c=5.32105e-17
C408 (\14\:qbint_2 VSS) capacitor c=9.63127e-17
C409 (\17\:qbint_2 VSS) capacitor c=4.91734e-17
C410 (\18\:qbint_2 VSS) capacitor c=2.16759e-17
C411 (\8\:n30_2 VSS) capacitor c=1.33004e-16
C412 (\4\:mout_2 VSS) capacitor c=7.89724e-17
C413 (\5\:mout_2 VSS) capacitor c=7.35246e-17
C414 (\7\:n20_2 VSS) capacitor c=9.99108e-17
C415 (\8\:n20_2 VSS) capacitor c=1.03531e-16
C416 (\2\:n20_3 VSS) capacitor c=2.31147e-17
C417 (\4\:D2 VSS) capacitor c=5.25379e-17
C418 (\3\:Db_2 VSS) capacitor c=1.04576e-16
C419 (\4\:SI2 VSS) capacitor c=3.0521e-17
C420 (\8\:SEb_2 VSS) capacitor c=9.28781e-17
C421 (\5\:CK VSS) capacitor c=4.93533e-17
C422 (\5\:qbint_3 VSS) capacitor c=3.56676e-17
C423 (\6\:qbint_3 VSS) capacitor c=1.34631e-16
C424 (\5\:SI3 VSS) capacitor c=3.03986e-17
C425 (\4\:SEb_3 VSS) capacitor c=9.26969e-17
C426 (\4\:D3 VSS) capacitor c=5.2548e-17
C427 (\3\:Db_3 VSS) capacitor c=1.05368e-16
C428 (\5\:n20_3 VSS) capacitor c=1.03499e-16
C429 (\6\:n20_3 VSS) capacitor c=1.00499e-16
C430 (\6\:mout_3 VSS) capacitor c=7.36208e-17
C431 (\7\:mout_3 VSS) capacitor c=7.90899e-17
C432 (\2\:n20_4 VSS) capacitor c=2.31147e-17
C433 (\8\:n30_3 VSS) capacitor c=1.33317e-16
C434 (\14\:qbint_3 VSS) capacitor c=2.17137e-17
C435 (\15\:qbint_3 VSS) capacitor c=4.92062e-17
C436 (\18\:qbint_3 VSS) capacitor c=9.64388e-17
C437 (\10\:qint_3 VSS) capacitor c=1.91978e-17
C438 (\13\:qint_3 VSS) capacitor c=4.30302e-17
C439 (\5\:qbint_4 VSS) capacitor c=3.20753e-17
C440 (\6\:qbint_4 VSS) capacitor c=1.08627e-16
C441 (\5\:SI4 VSS) capacitor c=3.03986e-17
C442 (\4\:SEb_4 VSS) capacitor c=9.27585e-17
C443 (\4\:D4 VSS) capacitor c=5.2548e-17
C444 (\3\:Db_4 VSS) capacitor c=1.05368e-16
C445 (\5\:n20_4 VSS) capacitor c=1.03499e-16
C446 (\6\:n20_4 VSS) capacitor c=1.00499e-16
C447 (\6\:mout_4 VSS) capacitor c=7.36208e-17
C448 (\7\:mout_4 VSS) capacitor c=7.90899e-17
C449 (\8\:n30_4 VSS) capacitor c=1.33317e-16
C450 (\33\:CKb VSS) capacitor c=1.12828e-16
C451 (\34\:CKb VSS) capacitor c=4.03878e-16
C452 (\35\:CKb VSS) capacitor c=6.25693e-16
C453 (\36\:CKb VSS) capacitor c=5.83853e-16
C454 (\37\:CKb VSS) capacitor c=1.57601e-16
C455 (\38\:CKb VSS) capacitor c=4.00415e-16
C456 (\39\:CKb VSS) capacitor c=4.84592e-16
C457 (\40\:CKb VSS) capacitor c=3.858e-16
C458 (\41\:CKb VSS) capacitor c=1.57016e-16
C459 (\42\:CKb VSS) capacitor c=5.85113e-16
C460 (\43\:CKb VSS) capacitor c=6.25866e-16
C461 (\44\:CKb VSS) capacitor c=4.03634e-16
C462 (\45\:CKb VSS) capacitor c=1.12971e-16
C463 (\46\:CKb VSS) capacitor c=7.21452e-17
C464 (\47\:CKb VSS) capacitor c=8.45848e-17
C465 (\48\:CKb VSS) capacitor c=7.21452e-17
C466 (\49\:CKb VSS) capacitor c=3.65849e-17
C467 (\50\:CKb VSS) capacitor c=1.07666e-16
C468 (\53\:CKb VSS) capacitor c=7.30478e-17
C469 (\54\:CKb VSS) capacitor c=8.45852e-17
C470 (\55\:CKb VSS) capacitor c=7.30478e-17
C471 (\29\:RN VSS) capacitor c=2.1292e-16
C472 (\30\:RN VSS) capacitor c=6.20596e-16
C473 (\31\:RN VSS) capacitor c=6.08367e-16
C474 (\32\:RN VSS) capacitor c=4.14826e-16
C475 (\33\:RN VSS) capacitor c=5.92252e-16
C476 (\34\:RN VSS) capacitor c=4.5373e-16
C477 (\35\:RN VSS) capacitor c=6.08389e-16
C478 (\36\:RN VSS) capacitor c=6.19492e-16
C479 (\37\:RN VSS) capacitor c=2.1379e-16
C480 (\29\:SE VSS) capacitor c=5.5593e-17
C481 (\30\:SE VSS) capacitor c=8.74528e-16
C482 (\31\:SE VSS) capacitor c=6.60286e-16
C483 (\32\:SE VSS) capacitor c=6.81994e-16
C484 (\33\:SE VSS) capacitor c=2.0853e-16
C485 (\34\:SE VSS) capacitor c=2.23786e-16
C486 (\35\:SE VSS) capacitor c=6.82773e-16
C487 (\36\:SE VSS) capacitor c=6.6017e-16
C488 (\37\:SE VSS) capacitor c=8.75832e-16
C489 (\38\:SE VSS) capacitor c=5.55228e-17
C490 (\39\:SE VSS) capacitor c=8.57953e-17
C491 (\40\:SE VSS) capacitor c=5.31388e-17
C492 (\41\:SE VSS) capacitor c=5.57394e-17
C493 (\42\:SE VSS) capacitor c=8.57356e-17
C494 (\43\:SE VSS) capacitor c=5.79672e-17
C495 (\44\:SE VSS) capacitor c=5.33847e-17
C496 (\45\:SE VSS) capacitor c=5.55135e-17
C497 (\46\:SE VSS) capacitor c=8.56547e-17
C498 (\33\:Ckbb VSS) capacitor c=3.50957e-16
C499 (\34\:Ckbb VSS) capacitor c=1.59439e-16
C500 (\35\:Ckbb VSS) capacitor c=5.93422e-16
C501 (\36\:Ckbb VSS) capacitor c=6.29546e-16
C502 (\37\:Ckbb VSS) capacitor c=1.59439e-16
C503 (\38\:Ckbb VSS) capacitor c=3.24656e-16
C504 (\40\:Ckbb VSS) capacitor c=2.36577e-16
C505 (\41\:Ckbb VSS) capacitor c=1.59375e-16
C506 (\42\:Ckbb VSS) capacitor c=6.2929e-16
C507 (\43\:Ckbb VSS) capacitor c=5.93664e-16
C508 (\44\:Ckbb VSS) capacitor c=1.59375e-16
C509 (\45\:Ckbb VSS) capacitor c=3.51034e-16
C510 (\14\:qbint_4 VSS) capacitor c=1.76311e-17
C511 (\15\:qbint_4 VSS) capacitor c=5.04529e-17
C512 (\18\:qbint_4 VSS) capacitor c=9.65285e-17
C513 (\3\:Q4 VSS) capacitor c=2.66e-17
C514 (\7\:Q4 VSS) capacitor c=2.39265e-17
C515 (\10\:qint_4 VSS) capacitor c=1.72235e-17
C516 (\13\:qint_4 VSS) capacitor c=3.94229e-17
C517 (\6\:VDD VSS) capacitor c=3.49754e-17
C518 (\8\:VDD VSS) capacitor c=1.92023e-17
C519 (\10\:VDD VSS) capacitor c=7.80979e-18
C520 (\11\:VDD VSS) capacitor c=2.06665e-17
C521 (\12\:VDD VSS) capacitor c=3.04443e-17
C522 (\30\:VDD VSS) capacitor c=7.06594e-17
C523 (\36\:VDD VSS) capacitor c=6.94328e-17
C524 (\43\:VDD VSS) capacitor c=1.59843e-17
C525 (\46\:VDD VSS) capacitor c=2.00394e-17
C526 (\49\:VDD VSS) capacitor c=2.04835e-17
C527 (\55\:VDD VSS) capacitor c=3.31347e-17
C528 (\58\:VDD VSS) capacitor c=3.78513e-17
C529 (\64\:VDD VSS) capacitor c=3.04016e-17
C530 (\67\:VDD VSS) capacitor c=2.04828e-17
C531 (\70\:VDD VSS) capacitor c=7.72015e-18
C532 (\74\:VDD VSS) capacitor c=1.93037e-17
C533 (\77\:VDD VSS) capacitor c=7.35828e-17
C534 (\83\:VDD VSS) capacitor c=5.38699e-17
C535 (\90\:VDD VSS) capacitor c=2.63437e-17
C536 (\93\:VDD VSS) capacitor c=2.73187e-17
C537 (\97\:VDD VSS) capacitor c=4.19588e-18
C538 (\100\:VDD VSS) capacitor c=2.01794e-17
C539 (\103\:VDD VSS) capacitor c=2.58333e-17
C540 (\106\:VDD VSS) capacitor c=2.81562e-17
C541 (\112\:VDD VSS) capacitor c=1.72894e-17
Rk70 (SI3 \4\:SI3) resistor r=0.007747 c=0
Rk72 (\4\:SI3 \5\:SI3) resistor r=0.03285 c=0
Rk71 (\5\:SI3 \6\:SI3) resistor r=0.007747 c=0
Rk195 (Q4N \2\:Q4N) resistor r=0.02804 c=0
Rk196 (Q4N \4\:Q4N) resistor r=0.1532 c=0
Rk276 (\1\:VSS \5\:VSS) resistor r=0.06477 c=0
Rk277 (\5\:VSS \6\:VSS) resistor r=0.1637 c=0
Rk279 (\6\:VSS \8\:VSS) resistor r=0.3147 c=0
Rk280 (\8\:VSS \9\:VSS) resistor r=0.3082 c=0
Rk281 (\9\:VSS \10\:VSS) resistor r=0.2042 c=0
Rk282 (\10\:VSS \11\:VSS) resistor r=0.5581 c=0
Rk283 (\11\:VSS \12\:VSS) resistor r=0.4515 c=0
Rk287 (\8\:VSS \20\:VSS) resistor r=0.04398 c=0
Rk288 (\10\:VSS \22\:VSS) resistor r=0.04398 c=0
Rk289 (\11\:VSS \24\:VSS) resistor r=0.04398 c=0
Rk290 (\12\:VSS \25\:VSS) resistor r=0.3539 c=0
Rk292 (\25\:VSS \27\:VSS) resistor r=0.2284 c=0
Rk294 (\27\:VSS \29\:VSS) resistor r=0.2195 c=0
Rk295 (\29\:VSS \30\:VSS) resistor r=0.0952 c=0
Rk296 (\30\:VSS \31\:VSS) resistor r=0.5124 c=0
Rk297 (\31\:VSS \32\:VSS) resistor r=0.5581 c=0
Rk298 (\32\:VSS \33\:VSS) resistor r=0.04449 c=0
Rk299 (\33\:VSS \34\:VSS) resistor r=0.3665 c=0
Rk300 (\34\:VSS \35\:VSS) resistor r=0.4477 c=0
Rk301 (\35\:VSS \36\:VSS) resistor r=0.3981 c=0
Rk302 (\36\:VSS \37\:VSS) resistor r=0.4515 c=0
Rk303 (\37\:VSS \38\:VSS) resistor r=0.5581 c=0
Rk304 (\38\:VSS \39\:VSS) resistor r=0.2042 c=0
Rk305 (\39\:VSS \40\:VSS) resistor r=0.3082 c=0
Rk306 (\40\:VSS \41\:VSS) resistor r=0.3147 c=0
Rk311 (\43\:VSS VSS) resistor r=0.1 c=0
Rk308 (\41\:VSS \43\:VSS) resistor r=0.2284 c=0
Rk312 (VSS \46\:VSS) resistor r=0.2907 c=0
Rk313 (\46\:VSS \47\:VSS) resistor r=0.411 c=0
Rk314 (\47\:VSS \48\:VSS) resistor r=0.3589 c=0
Rk315 (\48\:VSS \49\:VSS) resistor r=0.1992 c=0
Rk316 (\49\:VSS \50\:VSS) resistor r=0.5124 c=0
Rk317 (\50\:VSS \51\:VSS) resistor r=0.3147 c=0
Rk319 (\51\:VSS \53\:VSS) resistor r=0.2689 c=0
Rk321 (\12\:VSS \57\:VSS) resistor r=0.07227 c=0
Rk326 (\30\:VSS \67\:VSS) resistor r=0.04398 c=0
Rk327 (\31\:VSS \69\:VSS) resistor r=0.04398 c=0
Rk328 (\32\:VSS \71\:VSS) resistor r=0.04398 c=0
Rk329 (\34\:VSS \73\:VSS) resistor r=0.04398 c=0
Rk330 (\35\:VSS \75\:VSS) resistor r=0.04205 c=0
Rk331 (\36\:VSS \77\:VSS) resistor r=0.07227 c=0
Rk332 (\37\:VSS \79\:VSS) resistor r=0.04398 c=0
Rk333 (\38\:VSS \81\:VSS) resistor r=0.04398 c=0
Rk334 (\40\:VSS \83\:VSS) resistor r=0.04398 c=0
Rk339 (\46\:VSS \93\:VSS) resistor r=0.04398 c=0
Rk340 (\47\:VSS \95\:VSS) resistor r=0.04398 c=0
Rk341 (\49\:VSS \97\:VSS) resistor r=0.04398 c=0
Rk342 (\50\:VSS \99\:VSS) resistor r=0.04398 c=0
Rk187 (\2\:Q4 \3\:Q4) resistor r=0.001736 c=0
Rk188 (\4\:Q4 Q4) resistor r=0.002952 c=0
Rk189 (\3\:Q4 \4\:Q4) resistor r=0.09521 c=0
Rk191 (\4\:Q4 \7\:Q4) resistor r=0.06086 c=0
Rk190 (\6\:Q4 \7\:Q4) resistor r=0.002894 c=0
Rk198 (\1\:VDD \5\:VDD) resistor r=0.05524 c=0
Rk199 (\5\:VDD \6\:VDD) resistor r=0.1637 c=0
Rk201 (\6\:VDD \8\:VDD) resistor r=0.2893 c=0
Rk202 (\8\:VDD \9\:VDD) resistor r=0.3082 c=0
Rk203 (\9\:VDD \10\:VDD) resistor r=0.1535 c=0
Rk204 (\10\:VDD \11\:VDD) resistor r=0.1752 c=0
Rk205 (\11\:VDD \12\:VDD) resistor r=0.444 c=0
Rk206 (\12\:VDD \13\:VDD) resistor r=0.4388 c=0
Rk210 (\8\:VDD \21\:VDD) resistor r=0.04398 c=0
Rk211 (\10\:VDD \23\:VDD) resistor r=0.04398 c=0
Rk212 (\11\:VDD \25\:VDD) resistor r=0.04398 c=0
Rk213 (\12\:VDD \27\:VDD) resistor r=0.04398 c=0
Rk214 (\13\:VDD \29\:VDD) resistor r=0.07227 c=0
Rk215 (\13\:VDD \30\:VDD) resistor r=0.3539 c=0
Rk219 (\30\:VDD \36\:VDD) resistor r=0.2189 c=0
Rk223 (\36\:VDD \42\:VDD) resistor r=0.1941 c=0
Rk224 (\42\:VDD \43\:VDD) resistor r=0.0952 c=0
Rk225 (\43\:VDD \45\:VDD) resistor r=0.04398 c=0
Rk226 (\43\:VDD \46\:VDD) resistor r=0.4617 c=0
Rk227 (\46\:VDD \48\:VDD) resistor r=0.04398 c=0
Rk228 (\46\:VDD \49\:VDD) resistor r=0.1752 c=0
Rk229 (\49\:VDD \51\:VDD) resistor r=0.04398 c=0
Rk230 (\49\:VDD \52\:VDD) resistor r=0.4793 c=0
Rk231 (\52\:VDD \54\:VDD) resistor r=0.07227 c=0
Rk232 (\52\:VDD \55\:VDD) resistor r=0.3665 c=0
Rk233 (\55\:VDD \57\:VDD) resistor r=0.04398 c=0
Rk234 (\55\:VDD \58\:VDD) resistor r=0.4465 c=0
Rk235 (\58\:VDD \60\:VDD) resistor r=0.04398 c=0
Rk236 (\58\:VDD \61\:VDD) resistor r=0.3995 c=0
Rk237 (\61\:VDD \63\:VDD) resistor r=0.07227 c=0
Rk238 (\61\:VDD \64\:VDD) resistor r=0.4388 c=0
Rk239 (\64\:VDD \66\:VDD) resistor r=0.04398 c=0
Rk240 (\64\:VDD \67\:VDD) resistor r=0.444 c=0
Rk241 (\67\:VDD \69\:VDD) resistor r=0.04398 c=0
Rk242 (\67\:VDD \70\:VDD) resistor r=0.1752 c=0
Rk243 (\70\:VDD \72\:VDD) resistor r=0.04398 c=0
Rk244 (\70\:VDD \73\:VDD) resistor r=0.1535 c=0
Rk245 (\73\:VDD \74\:VDD) resistor r=0.3082 c=0
Rk246 (\74\:VDD \76\:VDD) resistor r=0.04398 c=0
Rk247 (\74\:VDD \77\:VDD) resistor r=0.2893 c=0
Rk256 (\83\:VDD VDD) resistor r=0.1 c=0
Rk251 (\77\:VDD \83\:VDD) resistor r=0.2189 c=0
Rk257 (VDD \90\:VDD) resistor r=0.2907 c=0
Rk258 (\90\:VDD \92\:VDD) resistor r=0.04398 c=0
Rk259 (\90\:VDD \93\:VDD) resistor r=0.3983 c=0
Rk260 (\93\:VDD \95\:VDD) resistor r=0.04398 c=0
Rk261 (\93\:VDD \96\:VDD) resistor r=0.3716 c=0
Rk262 (\96\:VDD \97\:VDD) resistor r=0.07238 c=0
Rk263 (\97\:VDD \99\:VDD) resistor r=0.04398 c=0
Rk264 (\97\:VDD \100\:VDD) resistor r=0.1752 c=0
Rk265 (\100\:VDD \102\:VDD) resistor r=0.04398 c=0
Rk266 (\100\:VDD \103\:VDD) resistor r=0.4617 c=0
Rk267 (\103\:VDD \105\:VDD) resistor r=0.04398 c=0
Rk268 (\103\:VDD \106\:VDD) resistor r=0.2893 c=0
Rk272 (\106\:VDD \112\:VDD) resistor r=0.2593 c=0
Rk1 (Q1N \2\:Q1N) resistor r=0.02804 c=0
Rk2 (Q1N \4\:Q1N) resistor r=0.1532 c=0
Rk108 (\4\:D4 D4) resistor r=0.01754 c=0
Rk6 (\1\:Q1 \3\:Q1) resistor r=0.001736 c=0
Rk7 (Q1 \4\:Q1) resistor r=0.002836 c=0
Rk8 (\1\:Q1 \4\:Q1) resistor r=0.09521 c=0
Rk10 (\4\:Q1 \5\:Q1) resistor r=0.06086 c=0
Rk9 (\5\:Q1 \7\:Q1) resistor r=0.002894 c=0
Rk103 (SI4 \4\:SI4) resistor r=0.007747 c=0
Rk105 (\4\:SI4 \5\:SI4) resistor r=0.03285 c=0
Rk104 (\5\:SI4 \6\:SI4) resistor r=0.007747 c=0
Rk144 (\29\:RN \30\:RN) resistor r=1.305 c=0
Rk145 (\30\:RN \31\:RN) resistor r=4.4962 c=0
Rk146 (\31\:RN \32\:RN) resistor r=1.305 c=0
Rk152 (\33\:RN RN) resistor r=0.01712 c=0
Rk147 (\32\:RN \33\:RN) resistor r=2.5227 c=0
Rk148 (\33\:RN \34\:RN) resistor r=2.8704 c=0
Rk149 (\34\:RN \35\:RN) resistor r=1.305 c=0
Rk150 (\35\:RN \36\:RN) resistor r=4.4962 c=0
Rk151 (\36\:RN \37\:RN) resistor r=1.305 c=0
Rk153 (\29\:SE \30\:SE) resistor r=0.2654 c=0
Rk154 (\30\:SE \31\:SE) resistor r=0.6014 c=0
Rk155 (\31\:SE \32\:SE) resistor r=4.7059 c=0
Rk156 (\32\:SE \33\:SE) resistor r=0.3895 c=0
Rk157 (\33\:SE \34\:SE) resistor r=1.2639 c=0
Rk158 (\34\:SE \35\:SE) resistor r=0.3895 c=0
Rk159 (\35\:SE \36\:SE) resistor r=4.7059 c=0
Rk160 (\36\:SE \37\:SE) resistor r=0.7054 c=0
Rk161 (\37\:SE \38\:SE) resistor r=0.2654 c=0
Rk162 (\31\:SE \39\:SE) resistor r=0.235 c=0
Rk163 (\32\:SE \40\:SE) resistor r=0.207 c=0
Rk164 (\40\:SE \41\:SE) resistor r=0.2654 c=0
Rk165 (\33\:SE \42\:SE) resistor r=0.235 c=0
Rk167 (\43\:SE SE) resistor r=0.03329 c=0
Rk166 (\34\:SE \43\:SE) resistor r=0.235 c=0
Rk168 (\35\:SE \44\:SE) resistor r=0.207 c=0
Rk169 (\44\:SE \45\:SE) resistor r=0.2654 c=0
Rk170 (\36\:SE \46\:SE) resistor r=0.235 c=0
Rk69 (CK \5\:CK) resistor r=0.01184 c=0
Rk68 (\4\:CK \5\:CK) resistor r=0.004264 c=0
Rk24 (\4\:D1 D1) resistor r=0.01775 c=0
Rk29 (\4\:SI1 \5\:SI1) resistor r=0.007747 c=0
Rk30 (SI1 \6\:SI1) resistor r=0.007747 c=0
Rk31 (\4\:SI1 \6\:SI1) resistor r=0.03326 c=0
Rk34 (Q2N \2\:Q2N) resistor r=0.02804 c=0
Rk35 (Q2N \4\:Q2N) resistor r=0.1532 c=0
Rk39 (\1\:Q2 \3\:Q2) resistor r=0.001736 c=0
Rk40 (Q2 \4\:Q2) resistor r=0.002836 c=0
Rk41 (\1\:Q2 \4\:Q2) resistor r=0.09521 c=0
Rk43 (\4\:Q2 \5\:Q2) resistor r=0.06086 c=0
Rk42 (\5\:Q2 \7\:Q2) resistor r=0.002894 c=0
Rk57 (\4\:D2 D2) resistor r=0.01775 c=0
Rk62 (\4\:SI2 \5\:SI2) resistor r=0.007747 c=0
Rk63 (SI2 \6\:SI2) resistor r=0.007747 c=0
Rk64 (\4\:SI2 \6\:SI2) resistor r=0.03326 c=0
Rk101 (Q3N \2\:Q3N) resistor r=0.02804 c=0
Rk102 (Q3N \4\:Q3N) resistor r=0.1532 c=0
Rk93 (\2\:Q3 \3\:Q3) resistor r=0.001736 c=0
Rk94 (\4\:Q3 Q3) resistor r=0.002952 c=0
Rk95 (\3\:Q3 \4\:Q3) resistor r=0.09521 c=0
Rk97 (\4\:Q3 \7\:Q3) resistor r=0.06086 c=0
Rk96 (\6\:Q3 \7\:Q3) resistor r=0.002894 c=0
Rk75 (\4\:D3 D3) resistor r=0.01754 c=0
Rk67 (\23\:Ckbb \25\:Ckbb) resistor r=0.3085 c=0
Rk171 (\33\:Ckbb \34\:Ckbb) resistor r=0.8055 c=0
Rk172 (\34\:Ckbb \35\:Ckbb) resistor r=0.4859 c=0
Rk173 (\35\:Ckbb \36\:Ckbb) resistor r=4.115 c=0
Rk174 (\36\:Ckbb \37\:Ckbb) resistor r=0.8055 c=0
Rk175 (\37\:Ckbb \38\:Ckbb) resistor r=0.4859 c=0
Rk176 (\38\:Ckbb \39\:Ckbb) resistor r=2.1228 c=0
Rk177 (\39\:Ckbb \40\:Ckbb) resistor r=1.4891 c=0
Rk178 (\40\:Ckbb \41\:Ckbb) resistor r=0.4859 c=0
Rk179 (\41\:Ckbb \42\:Ckbb) resistor r=0.8055 c=0
Rk180 (\42\:Ckbb \43\:Ckbb) resistor r=4.115 c=0
Rk181 (\43\:Ckbb \44\:Ckbb) resistor r=0.4859 c=0
Rk182 (\44\:Ckbb \45\:Ckbb) resistor r=0.8055 c=0
Rk122 (\33\:CKb \34\:CKb) resistor r=0.6749 c=0
Rk123 (\34\:CKb \35\:CKb) resistor r=0.9926 c=0
Rk124 (\35\:CKb \36\:CKb) resistor r=3.8956 c=0
Rk125 (\36\:CKb \37\:CKb) resistor r=0.3026 c=0
Rk126 (\37\:CKb \38\:CKb) resistor r=0.9926 c=0
Rk127 (\38\:CKb \39\:CKb) resistor r=2.0118 c=0
Rk128 (\39\:CKb \40\:CKb) resistor r=1.8832 c=0
Rk129 (\40\:CKb \41\:CKb) resistor r=0.9926 c=0
Rk130 (\41\:CKb \42\:CKb) resistor r=0.3026 c=0
Rk131 (\42\:CKb \43\:CKb) resistor r=3.8956 c=0
Rk132 (\43\:CKb \44\:CKb) resistor r=0.9926 c=0
Rk133 (\44\:CKb \45\:CKb) resistor r=0.731 c=0
Rk134 (\34\:CKb \46\:CKb) resistor r=0.2799 c=0
Rk135 (\36\:CKb \47\:CKb) resistor r=0.3709 c=0
Rk136 (\37\:CKb \48\:CKb) resistor r=0.2799 c=0
Rk137 (\39\:CKb \49\:CKb) resistor r=0.1116 c=0
Rk138 (\49\:CKb \50\:CKb) resistor r=0.2136 c=0
Rk139 (\50\:CKb \52\:CKb) resistor r=0.2747 c=0
Rk140 (\41\:CKb \53\:CKb) resistor r=0.2799 c=0
Rk141 (\42\:CKb \54\:CKb) resistor r=0.3709 c=0
Rk142 (\44\:CKb \55\:CKb) resistor r=0.2799 c=0
Rk143 (\49\:CKb \57\:CKb) resistor r=0.1988 c=0
Rk25 (\2\:Db \3\:Db) resistor r=0.2053 c=0
Rk26 (\3\:Db \5\:Db) resistor r=0.2977 c=0
Rk27 (\3\:Db \7\:Db) resistor r=0.5506 c=0
Rk28 (\5\:Db \9\:Db) resistor r=0.4364 c=0
Rk3 (\9\:qint \10\:qint) resistor r=0.1064 c=0
Rk4 (\10\:qint \11\:qint) resistor r=0.1402 c=0
Rk5 (\10\:qint \13\:qint) resistor r=0.1185 c=0
Rk20 (\2\:n6 \4\:n6) resistor r=0.2219 c=0
Rk32 (\5\:SEb \7\:SEb) resistor r=0.4089 c=0
Rk33 (\7\:SEb \8\:SEb) resistor r=0.5393 c=0
Rk11 (\14\:qbint \16\:qbint) resistor r=0.5571 c=0
Rk12 (\16\:qbint \17\:qbint) resistor r=0.3364 c=0
Rk13 (\17\:qbint \18\:qbint) resistor r=0.1562 c=0
Rk14 (\17\:qbint \20\:qbint) resistor r=0.203 c=0
Rk15 (\5\:n30 \7\:n30) resistor r=0.3667 c=0
Rk16 (\7\:n30 \8\:n30) resistor r=0.5747 c=0
Rk17 (\4\:mout \5\:mout) resistor r=0.4487 c=0
Rk18 (\5\:mout \7\:mout) resistor r=0.119 c=0
Rk19 (\5\:mout \9\:mout) resistor r=0.2114 c=0
Rk21 (\6\:n20 \7\:n20) resistor r=0.2651 c=0
Rk22 (\7\:n20 \8\:n20) resistor r=0.5712 c=0
Rk23 (\7\:n20 \10\:n20) resistor r=0.1916 c=0
Rk58 (\2\:Db_2 \3\:Db_2) resistor r=0.2053 c=0
Rk59 (\3\:Db_2 \5\:Db_2) resistor r=0.2977 c=0
Rk60 (\3\:Db_2 \7\:Db_2) resistor r=0.5506 c=0
Rk61 (\5\:Db_2 \9\:Db_2) resistor r=0.4364 c=0
Rk36 (\9\:qint_2 \10\:qint_2) resistor r=0.1064 c=0
Rk37 (\10\:qint_2 \11\:qint_2) resistor r=0.1402 c=0
Rk38 (\10\:qint_2 \13\:qint_2) resistor r=0.1185 c=0
Rk53 (\2\:n6_2 \4\:n6_2) resistor r=0.2219 c=0
Rk65 (\5\:SEb_2 \7\:SEb_2) resistor r=0.4116 c=0
Rk66 (\7\:SEb_2 \8\:SEb_2) resistor r=0.5393 c=0
Rk44 (\14\:qbint_2 \16\:qbint_2) resistor r=0.5571 c=0
Rk45 (\16\:qbint_2 \17\:qbint_2) resistor r=0.3364 c=0
Rk46 (\17\:qbint_2 \18\:qbint_2) resistor r=0.1562 c=0
Rk47 (\17\:qbint_2 \20\:qbint_2) resistor r=0.203 c=0
Rk48 (\5\:n30_2 \7\:n30_2) resistor r=0.3667 c=0
Rk49 (\7\:n30_2 \8\:n30_2) resistor r=0.5747 c=0
Rk50 (\4\:mout_2 \5\:mout_2) resistor r=0.4487 c=0
Rk51 (\5\:mout_2 \7\:mout_2) resistor r=0.119 c=0
Rk52 (\5\:mout_2 \9\:mout_2) resistor r=0.2114 c=0
Rk54 (\6\:n20_2 \7\:n20_2) resistor r=0.2651 c=0
Rk55 (\7\:n20_2 \8\:n20_2) resistor r=0.5712 c=0
Rk56 (\7\:n20_2 \10\:n20_2) resistor r=0.1916 c=0
Rk76 (\2\:Db_3 \3\:Db_3) resistor r=0.5972 c=0
Rk77 (\3\:Db_3 \5\:Db_3) resistor r=0.2977 c=0
Rk78 (\3\:Db_3 \7\:Db_3) resistor r=0.2053 c=0
Rk79 (\5\:Db_3 \9\:Db_3) resistor r=0.4364 c=0
Rk98 (\9\:qint_3 \10\:qint_3) resistor r=0.1064 c=0
Rk99 (\10\:qint_3 \12\:qint_3) resistor r=0.1185 c=0
Rk100 (\10\:qint_3 \13\:qint_3) resistor r=0.1402 c=0
Rk80 (\2\:n6_3 \4\:n6_3) resistor r=0.2219 c=0
Rk73 (\4\:SEb_3 \6\:SEb_3) resistor r=0.5407 c=0
Rk74 (\6\:SEb_3 \8\:SEb_3) resistor r=0.4091 c=0
Rk89 (\14\:qbint_3 \15\:qbint_3) resistor r=0.1562 c=0
Rk90 (\15\:qbint_3 \17\:qbint_3) resistor r=0.3364 c=0
Rk91 (\17\:qbint_3 \18\:qbint_3) resistor r=0.5567 c=0
Rk92 (\15\:qbint_3 \20\:qbint_3) resistor r=0.1988 c=0
Rk87 (\5\:n30_3 \7\:n30_3) resistor r=0.3674 c=0
Rk88 (\7\:n30_3 \8\:n30_3) resistor r=0.5778 c=0
Rk84 (\5\:mout_3 \6\:mout_3) resistor r=0.2412 c=0
Rk85 (\6\:mout_3 \7\:mout_3) resistor r=0.4487 c=0
Rk86 (\6\:mout_3 \9\:mout_3) resistor r=0.119 c=0
Rk81 (\5\:n20_3 \6\:n20_3) resistor r=0.5712 c=0
Rk82 (\6\:n20_3 \8\:n20_3) resistor r=0.2627 c=0
Rk83 (\6\:n20_3 \10\:n20_3) resistor r=0.1916 c=0
Rk109 (\2\:Db_4 \3\:Db_4) resistor r=0.5972 c=0
Rk110 (\3\:Db_4 \5\:Db_4) resistor r=0.2977 c=0
Rk111 (\3\:Db_4 \7\:Db_4) resistor r=0.2053 c=0
Rk112 (\5\:Db_4 \9\:Db_4) resistor r=0.4364 c=0
Rk192 (\9\:qint_4 \10\:qint_4) resistor r=0.1064 c=0
Rk193 (\10\:qint_4 \12\:qint_4) resistor r=0.1185 c=0
Rk194 (\10\:qint_4 \13\:qint_4) resistor r=0.1402 c=0
Rk113 (\2\:n6_4 \4\:n6_4) resistor r=0.2219 c=0
Rk106 (\4\:SEb_4 \6\:SEb_4) resistor r=0.5407 c=0
Rk107 (\6\:SEb_4 \8\:SEb_4) resistor r=0.4091 c=0
Rk183 (\14\:qbint_4 \15\:qbint_4) resistor r=0.1562 c=0
Rk184 (\15\:qbint_4 \17\:qbint_4) resistor r=0.3364 c=0
Rk185 (\17\:qbint_4 \18\:qbint_4) resistor r=0.5567 c=0
Rk186 (\15\:qbint_4 \20\:qbint_4) resistor r=0.1988 c=0
Rk120 (\5\:n30_4 \7\:n30_4) resistor r=0.3674 c=0
Rk121 (\7\:n30_4 \8\:n30_4) resistor r=0.5778 c=0
Rk117 (\5\:mout_4 \6\:mout_4) resistor r=0.2412 c=0
Rk118 (\6\:mout_4 \7\:mout_4) resistor r=0.4487 c=0
Rk119 (\6\:mout_4 \9\:mout_4) resistor r=0.119 c=0
Rk114 (\5\:n20_4 \6\:n20_4) resistor r=0.5712 c=0
Rk115 (\6\:n20_4 \8\:n20_4) resistor r=0.2627 c=0
Rk116 (\6\:n20_4 \10\:n20_4) resistor r=0.1916 c=0
Rl103 (\2\:SI3 \3\:SI3) resistor r=89.1533 c=0
Rl102 (\1\:SI3 \2\:SI3) resistor r=41.0764 c=0
Rl155 (\1\:D4 \2\:D4) resistor r=91.5405 c=0
Rl156 (\2\:D4 \3\:D4) resistor r=35.7713 c=0
Rl150 (\2\:SI4 \3\:SI4) resistor r=89.1533 c=0
Rl149 (\1\:SI4 \2\:SI4) resistor r=41.0764 c=0
Rl164 (\23\:RN \24\:RN) resistor r=147.643 c=0
Rl117 (\16\:RN \17\:RN) resistor r=147.643 c=0
Rl77 (\12\:RN \13\:RN) resistor r=147.643 c=0
Rl30 (\5\:RN \6\:RN) resistor r=147.643 c=0
Rl176 (\27\:RN \28\:RN) resistor r=29.5379 c=0
Rl175 (\26\:RN \27\:RN) resistor r=37.6944 c=0
Rl174 (\25\:RN \26\:RN) resistor r=47.3097 c=0
Rl163 (\22\:RN \23\:RN) resistor r=52.6149 c=0
Rl129 (\20\:RN \21\:RN) resistor r=29.5379 c=0
Rl128 (\19\:RN \20\:RN) resistor r=37.6944 c=0
Rl127 (\18\:RN \19\:RN) resistor r=47.3097 c=0
Rl116 (\15\:RN \16\:RN) resistor r=52.6149 c=0
Rl78 (\13\:RN \14\:RN) resistor r=52.6149 c=0
Rl66 (\9\:RN \10\:RN) resistor r=37.6944 c=0
Rl65 (\8\:RN \9\:RN) resistor r=47.3097 c=0
Rl67 (\10\:RN \11\:RN) resistor r=29.5379 c=0
Rl31 (\6\:RN \7\:RN) resistor r=52.6149 c=0
Rl19 (\2\:RN \3\:RN) resistor r=37.6944 c=0
Rl18 (\1\:RN \2\:RN) resistor r=47.3097 c=0
Rl20 (\3\:RN \4\:RN) resistor r=29.5379 c=0
Rl154 (\27\:SE \28\:SE) resistor r=52.6149 c=0
Rl151 (\25\:SE \26\:SE) resistor r=33.3841 c=0
Rl147 (\22\:SE \23\:SE) resistor r=54.5379 c=0
Rl148 (\23\:SE \24\:SE) resistor r=41.0764 c=0
Rl107 (\20\:SE \21\:SE) resistor r=52.6149 c=0
Rl104 (\18\:SE \19\:SE) resistor r=33.3841 c=0
Rl100 (\15\:SE \16\:SE) resistor r=54.5379 c=0
Rl101 (\16\:SE \17\:SE) resistor r=41.0764 c=0
Rl93 (\12\:SE \13\:SE) resistor r=54.5379 c=0
Rl94 (\13\:SE \14\:SE) resistor r=41.0764 c=0
Rl90 (\10\:SE \11\:SE) resistor r=33.3841 c=0
Rl87 (\8\:SE \9\:SE) resistor r=52.6149 c=0
Rl46 (\5\:SE \6\:SE) resistor r=54.5379 c=0
Rl47 (\6\:SE \7\:SE) resistor r=41.0764 c=0
Rl43 (\3\:SE \4\:SE) resistor r=33.3841 c=0
Rl40 (\1\:SE \2\:SE) resistor r=52.6149 c=0
Rl98 (\1\:CK \2\:CK) resistor r=24.2328 c=0
Rl99 (\2\:CK \3\:CK) resistor r=58.8482 c=0
Rl38 (\1\:D1 \2\:D1) resistor r=91.5405 c=0
Rl39 (\2\:D1 \3\:D1) resistor r=35.7713 c=0
Rl45 (\2\:SI1 \3\:SI1) resistor r=89.1533 c=0
Rl44 (\1\:SI1 \2\:SI1) resistor r=41.0764 c=0
Rl85 (\1\:D2 \2\:D2) resistor r=91.5405 c=0
Rl86 (\2\:D2 \3\:D2) resistor r=35.7713 c=0
Rl92 (\2\:SI2 \3\:SI2) resistor r=89.1533 c=0
Rl91 (\1\:SI2 \2\:SI2) resistor r=41.0764 c=0
Rl108 (\1\:D3 \2\:D3) resistor r=91.5405 c=0
Rl109 (\2\:D3 \3\:D3) resistor r=35.7713 c=0
Rl169 (\30\:Ckbb \31\:Ckbb) resistor r=183.747 c=0
Rl122 (\19\:Ckbb \20\:Ckbb) resistor r=183.747 c=0
Rl72 (\9\:Ckbb \10\:Ckbb) resistor r=183.747 c=0
Rl25 (\2\:Ckbb \3\:Ckbb) resistor r=183.747 c=0
Rl170 (\31\:Ckbb \32\:Ckbb) resistor r=62.6944 c=0
Rl160 (\28\:Ckbb \29\:Ckbb) resistor r=62.6944 c=0
Rl157 (\26\:Ckbb \27\:Ckbb) resistor r=230.67 c=0
Rl123 (\20\:Ckbb \21\:Ckbb) resistor r=62.6944 c=0
Rl113 (\17\:Ckbb \18\:Ckbb) resistor r=62.6944 c=0
Rl110 (\15\:Ckbb \16\:Ckbb) resistor r=230.67 c=0
Rl84 (\13\:Ckbb \14\:Ckbb) resistor r=230.67 c=0
Rl81 (\11\:Ckbb \12\:Ckbb) resistor r=62.6944 c=0
Rl71 (\8\:Ckbb \9\:Ckbb) resistor r=62.6944 c=0
Rl37 (\6\:Ckbb \7\:Ckbb) resistor r=230.67 c=0
Rl34 (\4\:Ckbb \5\:Ckbb) resistor r=62.6944 c=0
Rl24 (Ckbb \2\:Ckbb) resistor r=62.6944 c=0
Rl158 (\26\:CKb \27\:CKb) resistor r=109.983 c=0
Rl111 (\19\:CKb \20\:CKb) resistor r=109.983 c=0
Rl83 (\13\:CKb \14\:CKb) resistor r=109.983 c=0
Rl36 (\6\:CKb \7\:CKb) resistor r=109.983 c=0
Rl171 (\31\:CKb \32\:CKb) resistor r=31.9251 c=0
Rl168 (\29\:CKb \30\:CKb) resistor r=24.2328 c=0
Rl159 (\27\:CKb \28\:CKb) resistor r=32.9066 c=0
Rl124 (\24\:CKb \25\:CKb) resistor r=31.9251 c=0
Rl121 (\22\:CKb \23\:CKb) resistor r=24.2328 c=0
Rl112 (\20\:CKb \21\:CKb) resistor r=32.9066 c=0
Rl82 (\12\:CKb \13\:CKb) resistor r=33.8727 c=0
Rl73 (\10\:CKb \11\:CKb) resistor r=24.2328 c=0
Rl70 (\8\:CKb \9\:CKb) resistor r=31.9251 c=0
Rl35 (\5\:CKb \6\:CKb) resistor r=33.8727 c=0
Rl26 (\3\:CKb \4\:CKb) resistor r=24.2328 c=0
Rl23 (CKb \2\:CKb) resistor r=31.9251 c=0
Rl97 (\16\:CKb \18\:CKb) resistor r=64.2642 c=0
Rl96 (\16\:CKb \17\:CKb) resistor r=37.3411 c=0
Rl95 (\15\:CKb \16\:CKb) resistor r=1.2334 c=0
Rl5 (qint \6\:qint) resistor r=6.6351 c=0
Rl41 (SEb \2\:SEb) resistor r=26.9231 c=0
Rl42 (\2\:SEb \3\:SEb) resistor r=148.376 c=0
Rl21 (\12\:qbint \11\:qbint) resistor r=62.2302 c=0
Rl22 (\12\:qbint \13\:qbint) resistor r=39.1533 c=0
Rl12 (qbint \7\:qbint) resistor r=5.8198 c=0
Rl9 (\4\:qbint qbint) resistor r=145.471 c=0
Rl15 (\4\:qbint \10\:qbint) resistor r=37.6951 c=0
Rl10 (\4\:qbint \5\:qbint) resistor r=51.1566 c=0
Rl17 (\2\:n30 \3\:n30) resistor r=44.9638 c=0
Rl16 (n30 \2\:n30) resistor r=49.9532 c=0
Rl32 (mout \2\:mout) resistor r=72.3097 c=0
Rl33 (\2\:mout \3\:mout) resistor r=26.1559 c=0
Rl29 (\2\:n20 \4\:n20) resistor r=36.2526 c=0
Rl28 (\2\:n20 \3\:n20) resistor r=82.4064 c=0
Rl27 (n20 \2\:n20) resistor r=2.7713 c=0
Rl52 (qint_2 \6\:qint_2) resistor r=6.6351 c=0
Rl88 (SEb_2 \2\:SEb_2) resistor r=26.9231 c=0
Rl89 (\2\:SEb_2 \3\:SEb_2) resistor r=148.376 c=0
Rl68 (\12\:qbint_2 \11\:qbint_2) resistor r=62.2302 c=0
Rl69 (\12\:qbint_2 \13\:qbint_2) resistor r=39.1533 c=0
Rl59 (qbint_2 \7\:qbint_2) resistor r=5.8198 c=0
Rl56 (\4\:qbint_2 qbint_2) resistor r=145.471 c=0
Rl62 (\4\:qbint_2 \10\:qbint_2) resistor r=37.6951 c=0
Rl57 (\4\:qbint_2 \5\:qbint_2) resistor r=51.1566 c=0
Rl64 (\2\:n30_2 \3\:n30_2) resistor r=44.9638 c=0
Rl63 (n30_2 \2\:n30_2) resistor r=49.9532 c=0
Rl79 (mout_2 \2\:mout_2) resistor r=72.3097 c=0
Rl80 (\2\:mout_2 \3\:mout_2) resistor r=26.1559 c=0
Rl76 (\2\:n20_2 \4\:n20_2) resistor r=36.2526 c=0
Rl75 (\2\:n20_2 \3\:n20_2) resistor r=82.4064 c=0
Rl74 (n20_2 \2\:n20_2) resistor r=2.7713 c=0
Rl143 (qint_3 \4\:qint_3) resistor r=6.6351 c=0
Rl106 (\2\:SEb_3 \3\:SEb_3) resistor r=26.3736 c=0
Rl105 (SEb_3 \2\:SEb_3) resistor r=147.512 c=0
Rl125 (\2\:qbint_3 qbint_3) resistor r=62.2302 c=0
Rl126 (\2\:qbint_3 \3\:qbint_3) resistor r=39.1533 c=0
Rl132 (\5\:qbint_3 \4\:qbint_3) resistor r=37.6951 c=0
Rl136 (\5\:qbint_3 \9\:qbint_3) resistor r=51.1566 c=0
Rl135 (\6\:qbint_3 \8\:qbint_3) resistor r=5.8198 c=0
Rl133 (\6\:qbint_3 \5\:qbint_3) resistor r=145.471 c=0
Rl130 (n30_3 \2\:n30_3) resistor r=44.1006 c=0
Rl131 (\2\:n30_3 \3\:n30_3) resistor r=49.8142 c=0
Rl114 (mout_3 \2\:mout_3) resistor r=72.3097 c=0
Rl115 (\2\:mout_3 \3\:mout_3) resistor r=26.1559 c=0
Rl118 (n20_3 \2\:n20_3) resistor r=36.2526 c=0
Rl120 (\2\:n20_3 \4\:n20_3) resistor r=82.4064 c=0
Rl119 (\2\:n20_3 \3\:n20_3) resistor r=2.7666 c=0
Rl190 (qint_4 \4\:qint_4) resistor r=6.6351 c=0
Rl153 (\2\:SEb_4 \3\:SEb_4) resistor r=26.3736 c=0
Rl152 (SEb_4 \2\:SEb_4) resistor r=147.512 c=0
Rl172 (\2\:qbint_4 qbint_4) resistor r=62.2302 c=0
Rl173 (\2\:qbint_4 \3\:qbint_4) resistor r=39.1533 c=0
Rl179 (\5\:qbint_4 \4\:qbint_4) resistor r=37.6951 c=0
Rl183 (\5\:qbint_4 \9\:qbint_4) resistor r=51.1566 c=0
Rl182 (\6\:qbint_4 \8\:qbint_4) resistor r=5.8198 c=0
Rl180 (\6\:qbint_4 \5\:qbint_4) resistor r=145.471 c=0
Rl177 (n30_4 \2\:n30_4) resistor r=44.1006 c=0
Rl178 (\2\:n30_4 \3\:n30_4) resistor r=49.8142 c=0
Rl161 (mout_4 \2\:mout_4) resistor r=72.3097 c=0
Rl162 (\2\:mout_4 \3\:mout_4) resistor r=26.1559 c=0
Rl165 (n20_4 \2\:n20_4) resistor r=36.2526 c=0
Rl167 (\2\:n20_4 \4\:n20_4) resistor r=82.4064 c=0
Rl166 (\2\:n20_4 \3\:n20_4) resistor r=2.7666 c=0
Rz43 (\2\:Q4N \1\:Q4N) resistor r=75 c=0
Rz58 (\20\:VSS \19\:VSS) resistor r=75 c=0
Rz59 (\22\:VSS \21\:VSS) resistor r=75 c=0
Rz60 (\24\:VSS \23\:VSS) resistor r=75 c=0
Rz62 (\57\:VSS \56\:VSS) resistor r=75 c=0
Rz67 (\67\:VSS \66\:VSS) resistor r=75 c=0
Rz68 (\69\:VSS \68\:VSS) resistor r=75 c=0
Rz69 (\71\:VSS \70\:VSS) resistor r=75 c=0
Rz70 (\73\:VSS \72\:VSS) resistor r=75 c=0
Rz71 (\75\:VSS \74\:VSS) resistor r=75 c=0
Rz72 (\77\:VSS \76\:VSS) resistor r=75 c=0
Rz73 (\79\:VSS \78\:VSS) resistor r=75 c=0
Rz74 (\81\:VSS \80\:VSS) resistor r=75 c=0
Rz75 (\83\:VSS \82\:VSS) resistor r=75 c=0
Rz80 (\93\:VSS \92\:VSS) resistor r=75 c=0
Rz81 (\95\:VSS \94\:VSS) resistor r=75 c=0
Rz82 (\97\:VSS \96\:VSS) resistor r=75 c=0
Rz83 (\99\:VSS \98\:VSS) resistor r=75 c=0
Rz41 (\2\:Q4 \1\:Q4) resistor r=75 c=0
Rz44 (\5\:VDD \4\:VDD) resistor r=9.375 c=0
Rz45 (\9\:VDD \4\:VDD) resistor r=6.25 c=0
Rz46 (\13\:VDD \4\:VDD) resistor r=6.25 c=0
Rz47 (\42\:VDD \4\:VDD) resistor r=6.25 c=0
Rz48 (\52\:VDD \4\:VDD) resistor r=6.25 c=0
Rz49 (\61\:VDD \4\:VDD) resistor r=6.25 c=0
Rz50 (\73\:VDD \4\:VDD) resistor r=6.25 c=0
Rz51 (\83\:VDD \4\:VDD) resistor r=6.25 c=0
Rz52 (\96\:VDD \4\:VDD) resistor r=6.25 c=0
Rz53 (\106\:VDD \4\:VDD) resistor r=6.25 c=0
Rz1 (\2\:Q1N \1\:Q1N) resistor r=75 c=0
Rz3 (\3\:Q1 \2\:Q1) resistor r=75 c=0
Rz11 (\2\:Q2N \1\:Q2N) resistor r=75 c=0
Rz13 (\3\:Q2 \2\:Q2) resistor r=75 c=0
Rz31 (\2\:Q3N \1\:Q3N) resistor r=75 c=0
Rz29 (\2\:Q3 \1\:Q3) resistor r=75 c=0
Rz21 (\22\:Ckbb \23\:Ckbb) resistor r=75 c=0
Rz39 (\22\:Ckbb \39\:Ckbb) resistor r=37.5 c=0
Rz38 (\51\:CKb \52\:CKb) resistor r=75 c=0
Rz8 (\6\:Db \7\:Db) resistor r=75 c=0
Rz9 (\8\:Db \9\:Db) resistor r=75 c=0
Rz2 (\13\:qint \12\:qint) resistor r=75 c=0
Rz10 (\4\:SEb \5\:SEb) resistor r=75 c=0
Rz4 (\20\:qbint \19\:qbint) resistor r=75 c=0
Rz5 (\6\:n30 \7\:n30) resistor r=75 c=0
Rz6 (\6\:mout \7\:mout) resistor r=75 c=0
Rz7 (\9\:n20 \10\:n20) resistor r=75 c=0
Rz18 (\6\:Db_2 \7\:Db_2) resistor r=75 c=0
Rz19 (\8\:Db_2 \9\:Db_2) resistor r=75 c=0
Rz12 (\13\:qint_2 \12\:qint_2) resistor r=75 c=0
Rz20 (\4\:SEb_2 \5\:SEb_2) resistor r=75 c=0
Rz14 (\20\:qbint_2 \19\:qbint_2) resistor r=75 c=0
Rz15 (\6\:n30_2 \7\:n30_2) resistor r=75 c=0
Rz16 (\6\:mout_2 \7\:mout_2) resistor r=75 c=0
Rz17 (\9\:n20_2 \10\:n20_2) resistor r=75 c=0
Rz23 (Db_3 \2\:Db_3) resistor r=75 c=0
Rz24 (\8\:Db_3 \9\:Db_3) resistor r=75 c=0
Rz30 (\12\:qint_3 \11\:qint_3) resistor r=75 c=0
Rz22 (\7\:SEb_3 \8\:SEb_3) resistor r=75 c=0
Rz28 (\20\:qbint_3 \19\:qbint_3) resistor r=75 c=0
Rz27 (\6\:n30_3 \7\:n30_3) resistor r=75 c=0
Rz26 (\8\:mout_3 \9\:mout_3) resistor r=75 c=0
Rz25 (\9\:n20_3 \10\:n20_3) resistor r=75 c=0
Rz33 (Db_4 \2\:Db_4) resistor r=75 c=0
Rz34 (\8\:Db_4 \9\:Db_4) resistor r=75 c=0
Rz42 (\12\:qint_4 \11\:qint_4) resistor r=75 c=0
Rz32 (\7\:SEb_4 \8\:SEb_4) resistor r=75 c=0
Rz40 (\20\:qbint_4 \19\:qbint_4) resistor r=75 c=0
Rz37 (\6\:n30_4 \7\:n30_4) resistor r=75 c=0
Rz36 (\8\:mout_4 \9\:mout_4) resistor r=75 c=0
Rz35 (\9\:n20_4 \10\:n20_4) resistor r=75 c=0
Ry50 (\4\:Q4N \3\:Q4N) resistor r=31 c=0
Ry88 (\5\:VSS \4\:VSS) resistor r=7.75 c=0
Ry89 (\9\:VSS \4\:VSS) resistor r=5.1667 c=0
Ry90 (\12\:VSS \4\:VSS) resistor r=5.1667 c=0
Ry91 (\29\:VSS \4\:VSS) resistor r=5.1667 c=0
Ry92 (\33\:VSS \4\:VSS) resistor r=5.1667 c=0
Ry93 (\36\:VSS \4\:VSS) resistor r=5.1667 c=0
Ry94 (\39\:VSS \4\:VSS) resistor r=5.1667 c=0
Ry95 (\43\:VSS \4\:VSS) resistor r=5.1667 c=0
Ry96 (\48\:VSS \4\:VSS) resistor r=5.1667 c=0
Ry97 (\51\:VSS \4\:VSS) resistor r=5.1667 c=0
Ry48 (\6\:Q4 \5\:Q4) resistor r=31 c=0
Ry55 (\21\:VDD \20\:VDD) resistor r=62 c=0
Ry56 (\23\:VDD \22\:VDD) resistor r=62 c=0
Ry57 (\25\:VDD \24\:VDD) resistor r=62 c=0
Ry58 (\27\:VDD \26\:VDD) resistor r=62 c=0
Ry59 (\29\:VDD \28\:VDD) resistor r=62 c=0
Ry64 (\45\:VDD \44\:VDD) resistor r=62 c=0
Ry65 (\48\:VDD \47\:VDD) resistor r=62 c=0
Ry66 (\51\:VDD \50\:VDD) resistor r=62 c=0
Ry67 (\54\:VDD \53\:VDD) resistor r=62 c=0
Ry68 (\57\:VDD \56\:VDD) resistor r=62 c=0
Ry69 (\60\:VDD \59\:VDD) resistor r=62 c=0
Ry70 (\63\:VDD \62\:VDD) resistor r=62 c=0
Ry71 (\66\:VDD \65\:VDD) resistor r=62 c=0
Ry72 (\69\:VDD \68\:VDD) resistor r=62 c=0
Ry73 (\72\:VDD \71\:VDD) resistor r=62 c=0
Ry74 (\76\:VDD \75\:VDD) resistor r=62 c=0
Ry79 (\92\:VDD \91\:VDD) resistor r=62 c=0
Ry80 (\95\:VDD \94\:VDD) resistor r=62 c=0
Ry81 (\99\:VDD \98\:VDD) resistor r=62 c=0
Ry82 (\102\:VDD \101\:VDD) resistor r=62 c=0
Ry83 (\105\:VDD \104\:VDD) resistor r=62 c=0
Ry1 (\4\:Q1N \3\:Q1N) resistor r=31 c=0
Ry3 (\7\:Q1 \6\:Q1) resistor r=31 c=0
Ry13 (\4\:Q2N \3\:Q2N) resistor r=31 c=0
Ry15 (\7\:Q2 \6\:Q2) resistor r=31 c=0
Ry37 (\4\:Q3N \3\:Q3N) resistor r=31 c=0
Ry35 (\6\:Q3 \5\:Q3) resistor r=31 c=0
Ry25 (\24\:Ckbb \25\:Ckbb) resistor r=62 c=0
Ry46 (\56\:CKb \57\:CKb) resistor r=62 c=0
Ry10 (Db \2\:Db) resistor r=62 c=0
Ry11 (\4\:Db \5\:Db) resistor r=62 c=0
Ry2 (\9\:qint \8\:qint) resistor r=62 c=0
Ry7 (n6 \2\:n6) resistor r=62 c=0
Ry8 (\3\:n6 \4\:n6) resistor r=62 c=0
Ry12 (\6\:SEb \7\:SEb) resistor r=62 c=0
Ry4 (\16\:qbint \15\:qbint) resistor r=62 c=0
Ry5 (\4\:n30 \5\:n30) resistor r=62 c=0
Ry6 (\8\:mout \9\:mout) resistor r=62 c=0
Ry9 (\5\:n20 \6\:n20) resistor r=62 c=0
Ry22 (Db_2 \2\:Db_2) resistor r=62 c=0
Ry23 (\4\:Db_2 \5\:Db_2) resistor r=62 c=0
Ry14 (\9\:qint_2 \8\:qint_2) resistor r=62 c=0
Ry19 (n6_2 \2\:n6_2) resistor r=62 c=0
Ry20 (\3\:n6_2 \4\:n6_2) resistor r=62 c=0
Ry24 (\6\:SEb_2 \7\:SEb_2) resistor r=62 c=0
Ry16 (\16\:qbint_2 \15\:qbint_2) resistor r=62 c=0
Ry17 (\4\:n30_2 \5\:n30_2) resistor r=62 c=0
Ry18 (\8\:mout_2 \9\:mout_2) resistor r=62 c=0
Ry21 (\5\:n20_2 \6\:n20_2) resistor r=62 c=0
Ry27 (\4\:Db_3 \5\:Db_3) resistor r=62 c=0
Ry28 (\6\:Db_3 \7\:Db_3) resistor r=62 c=0
Ry36 (\9\:qint_3 \8\:qint_3) resistor r=62 c=0
Ry29 (n6_3 \2\:n6_3) resistor r=62 c=0
Ry30 (\3\:n6_3 \4\:n6_3) resistor r=62 c=0
Ry26 (\5\:SEb_3 \6\:SEb_3) resistor r=62 c=0
Ry34 (\17\:qbint_3 \16\:qbint_3) resistor r=62 c=0
Ry33 (\4\:n30_3 \5\:n30_3) resistor r=62 c=0
Ry32 (\4\:mout_3 \5\:mout_3) resistor r=62 c=0
Ry31 (\7\:n20_3 \8\:n20_3) resistor r=62 c=0
Ry39 (\4\:Db_4 \5\:Db_4) resistor r=62 c=0
Ry40 (\6\:Db_4 \7\:Db_4) resistor r=62 c=0
Ry49 (\9\:qint_4 \8\:qint_4) resistor r=62 c=0
Ry41 (n6_4 \2\:n6_4) resistor r=62 c=0
Ry42 (\3\:n6_4 \4\:n6_4) resistor r=62 c=0
Ry38 (\5\:SEb_4 \6\:SEb_4) resistor r=62 c=0
Ry47 (\17\:qbint_4 \16\:qbint_4) resistor r=62 c=0
Ry45 (\4\:n30_4 \5\:n30_4) resistor r=62 c=0
Ry44 (\4\:mout_4 \5\:mout_4) resistor r=62 c=0
Ry43 (\7\:n20_4 \8\:n20_4) resistor r=62 c=0
Rx20 (\2\:SI3 \6\:SI3) resistor r=45 c=0
Rx31 (\2\:D4 \4\:D4) resistor r=45 c=0
Rx29 (\2\:SI4 \6\:SI4) resistor r=45 c=0
Rx48 (\28\:RN \29\:RN) resistor r=45 c=0
Rx49 (\22\:RN \30\:RN) resistor r=45 c=0
Rx50 (\21\:RN \31\:RN) resistor r=45 c=0
Rx51 (\15\:RN \32\:RN) resistor r=45 c=0
Rx52 (\14\:RN \34\:RN) resistor r=45 c=0
Rx53 (\11\:RN \35\:RN) resistor r=45 c=0
Rx54 (\7\:RN \36\:RN) resistor r=45 c=0
Rx55 (\4\:RN \37\:RN) resistor r=45 c=0
Rx56 (\28\:SE \29\:SE) resistor r=45 c=0
Rx57 (\26\:SE \30\:SE) resistor r=45 c=0
Rx58 (\4\:SE \37\:SE) resistor r=45 c=0
Rx59 (\2\:SE \38\:SE) resistor r=45 c=0
Rx60 (\23\:SE \39\:SE) resistor r=45 c=0
Rx61 (\19\:SE \40\:SE) resistor r=45 c=0
Rx62 (\21\:SE \41\:SE) resistor r=45 c=0
Rx63 (\16\:SE \42\:SE) resistor r=45 c=0
Rx64 (\13\:SE \43\:SE) resistor r=45 c=0
Rx65 (\11\:SE \44\:SE) resistor r=45 c=0
Rx66 (\9\:SE \45\:SE) resistor r=45 c=0
Rx67 (\6\:SE \46\:SE) resistor r=45 c=0
Rx19 (\2\:CK \4\:CK) resistor r=45 c=0
Rx7 (\2\:D1 \4\:D1) resistor r=45 c=0
Rx8 (\2\:SI1 \5\:SI1) resistor r=45 c=0
Rx16 (\2\:D2 \4\:D2) resistor r=45 c=0
Rx17 (\2\:SI2 \5\:SI2) resistor r=45 c=0
Rx22 (\2\:D3 \4\:D3) resistor r=45 c=0
Rx68 (\32\:Ckbb \33\:Ckbb) resistor r=45 c=0
Rx69 (\29\:Ckbb \34\:Ckbb) resistor r=45 c=0
Rx70 (\27\:Ckbb \35\:Ckbb) resistor r=45 c=0
Rx71 (\21\:Ckbb \36\:Ckbb) resistor r=45 c=0
Rx72 (\18\:Ckbb \37\:Ckbb) resistor r=45 c=0
Rx73 (\16\:Ckbb \38\:Ckbb) resistor r=45 c=0
Rx74 (\14\:Ckbb \40\:Ckbb) resistor r=45 c=0
Rx75 (\12\:Ckbb \41\:Ckbb) resistor r=45 c=0
Rx76 (\8\:Ckbb \42\:Ckbb) resistor r=45 c=0
Rx77 (\7\:Ckbb \43\:Ckbb) resistor r=45 c=0
Rx78 (\5\:Ckbb \44\:Ckbb) resistor r=45 c=0
Rx79 (Ckbb \45\:Ckbb) resistor r=45 c=0
Rx35 (\32\:CKb \33\:CKb) resistor r=45 c=0
Rx36 (\28\:CKb \35\:CKb) resistor r=45 c=0
Rx37 (\21\:CKb \38\:CKb) resistor r=45 c=0
Rx38 (\12\:CKb \40\:CKb) resistor r=45 c=0
Rx39 (\5\:CKb \43\:CKb) resistor r=45 c=0
Rx40 (\2\:CKb \45\:CKb) resistor r=45 c=0
Rx41 (\30\:CKb \46\:CKb) resistor r=45 c=0
Rx42 (\25\:CKb \47\:CKb) resistor r=45 c=0
Rx43 (\23\:CKb \48\:CKb) resistor r=45 c=0
Rx44 (\15\:CKb \50\:CKb) resistor r=45 c=0
Rx45 (\11\:CKb \53\:CKb) resistor r=45 c=0
Rx46 (\9\:CKb \54\:CKb) resistor r=45 c=0
Rx47 (\4\:CKb \55\:CKb) resistor r=45 c=0
Rx1 (\11\:qint \6\:qint) resistor r=45 c=0
Rx9 (\2\:SEb \8\:SEb) resistor r=45 c=0
Rx2 (\14\:qbint \12\:qbint) resistor r=45 c=0
Rx3 (\18\:qbint \7\:qbint) resistor r=45 c=0
Rx4 (\2\:n30 \8\:n30) resistor r=45 c=0
Rx5 (\2\:mout \4\:mout) resistor r=45 c=0
Rx6 (n20 \8\:n20) resistor r=45 c=0
Rx10 (\11\:qint_2 \6\:qint_2) resistor r=45 c=0
Rx18 (\2\:SEb_2 \8\:SEb_2) resistor r=45 c=0
Rx11 (\14\:qbint_2 \12\:qbint_2) resistor r=45 c=0
Rx12 (\18\:qbint_2 \7\:qbint_2) resistor r=45 c=0
Rx13 (\2\:n30_2 \8\:n30_2) resistor r=45 c=0
Rx14 (\2\:mout_2 \4\:mout_2) resistor r=45 c=0
Rx15 (n20_2 \8\:n20_2) resistor r=45 c=0
Rx28 (\13\:qint_3 \4\:qint_3) resistor r=45 c=0
Rx21 (\2\:SEb_3 \4\:SEb_3) resistor r=45 c=0
Rx26 (\14\:qbint_3 \8\:qbint_3) resistor r=45 c=0
Rx27 (\18\:qbint_3 \2\:qbint_3) resistor r=45 c=0
Rx25 (\2\:n30_3 \8\:n30_3) resistor r=45 c=0
Rx24 (\2\:mout_3 \7\:mout_3) resistor r=45 c=0
Rx23 (\3\:n20_3 \5\:n20_3) resistor r=45 c=0
Rx82 (\13\:qint_4 \4\:qint_4) resistor r=45 c=0
Rx30 (\2\:SEb_4 \4\:SEb_4) resistor r=45 c=0
Rx80 (\14\:qbint_4 \8\:qbint_4) resistor r=45 c=0
Rx81 (\18\:qbint_4 \2\:qbint_4) resistor r=45 c=0
Rx34 (\2\:n30_4 \8\:n30_4) resistor r=45 c=0
Rx33 (\2\:mout_4 \7\:mout_4) resistor r=45 c=0
Rx32 (\3\:n20_4 \5\:n20_4) resistor r=45 c=0
NM35 (\1\:Q3 \6\:qbint_3 \27\:VSS VSS) g45n1svt w=(2.6e-07) l=4.5e-08 \
        nf=1 as=5.735e-14 ad=6.045e-14 ps=1.22e-06 pd=1.24e-06 nrd=1.16667 \
        nrs=1.16667 sa=3.95e-07 sb=1.2e-07 sd=160n sca=17.5885 \
        scb=0.0172826 scc=0.00162584 m=(2)
mn55_1__rcx (\2\:Q1 qbint \51\:VSS VSS) g45n1svt w=(2.6e-07) l=4.5e-08 \
        nf=1 as=5.735e-14 ad=6.045e-14 ps=1.22e-06 pd=1.24e-06 nrd=1.16667 \
        nrs=1.16667 sa=3.95e-07 sb=1.2e-07 sd=160n sca=17.5885 \
        scb=0.0172826 scc=0.00162584 m=(2)
NM37 (\1\:Q3N qint_3 \25\:VSS VSS) g45n1svt w=(2.6e-07) l=4.5e-08 nf=1 \
        as=6.372e-14 ad=4.16e-14 ps=1.55e-06 pd=8.4e-07 nrd=1.16667 \
        nrs=1.16667 sa=4.56058e-07 sb=1.2e-07 sd=160n sca=17.5885 \
        scb=0.0172826 scc=0.00162584 m=(2)
mn57 (\1\:Q1N qint \53\:VSS VSS) g45n1svt w=(2.6e-07) l=4.5e-08 nf=1 \
        as=6.372e-14 ad=4.16e-14 ps=1.55e-06 pd=8.4e-07 nrd=1.16667 \
        nrs=1.16667 sa=4.56058e-07 sb=1.2e-07 sd=160n sca=17.5885 \
        scb=0.0172826 scc=0.00162584 m=(2)
NM38 (\1\:Q4N qint_4 \1\:VSS VSS) g45n1svt w=(2.6e-07) l=4.5e-08 nf=1 \
        as=6.373e-14 ad=4.16e-14 ps=1.55e-06 pd=8.4e-07 nrd=1.16667 \
        nrs=1.16667 sa=4.56058e-07 sb=1.2e-07 sd=160n sca=17.5885 \
        scb=0.0172826 scc=0.00162584 m=(2)
NM40 (\1\:Q4 \6\:qbint_4 \6\:VSS VSS) g45n1svt w=(2.6e-07) l=4.5e-08 \
        nf=1 as=5.735e-14 ad=6.045e-14 ps=1.22e-06 pd=1.24e-06 nrd=1.16667 \
        nrs=1.16667 sa=3.95e-07 sb=1.2e-07 sd=160n sca=17.5885 \
        scb=0.0172826 scc=0.00162584 m=(2)
NM17 (\2\:Q2 qbint_2 \41\:VSS VSS) g45n1svt w=(2.6e-07) l=4.5e-08 nf=1 \
        as=5.735e-14 ad=6.045e-14 ps=1.22e-06 pd=1.24e-06 nrd=1.16667 \
        nrs=1.16667 sa=3.95e-07 sb=1.2e-07 sd=160n sca=17.5885 \
        scb=0.0172826 scc=0.00162584 m=(2)
NM19_1__rcx (\1\:Q2N qint_2 \43\:VSS VSS) g45n1svt w=(2.6e-07) l=4.5e-08 \
        nf=1 as=6.372e-14 ad=4.16e-14 ps=1.55e-06 pd=8.4e-07 nrd=1.16667 \
        nrs=1.16667 sa=4.56058e-07 sb=1.2e-07 sd=160n sca=17.5885 \
        scb=0.0172826 scc=0.00162584 m=(2)
mn21 (\22\:Ckbb \17\:CKb \74\:VSS VSS) g45n1svt w=(1.45e-07) l=4.5e-08 \
        nf=1 as=9.708e-14 ad=6.752e-14 ps=1.51e-06 pd=1.56e-06 nrd=1.16667 \
        nrs=1.16667 sa=2.3e-07 sb=3.6e-07 sd=160n sca=19.8813 \
        scb=0.0206549 scc=0.00197265 m=(1)
mn20 (\51\:CKb \3\:CK \74\:VSS VSS) g45n1svt w=(1.45e-07) l=4.5e-08 nf=1 \
        as=2.03e-14 ad=6.752e-14 ps=5.7e-07 pd=1.56e-06 nrd=1.16667 \
        nrs=1.16667 sa=4.5e-07 sb=1.4e-07 sd=160n sca=19.8813 \
        scb=0.0206549 scc=0.00197265 m=(1)
NM39 (\11\:qint_4 \9\:qbint_4 \1\:VSS VSS) g45n1svt w=(1.45e-07) \
        l=4.5e-08 nf=1 as=6.735e-14 ad=2.03e-14 ps=1.6e-06 pd=5.7e-07 \
        nrd=1.16667 nrs=1.16667 sa=1.4e-07 sb=5.4e-07 sd=160n sca=23.279 \
        scb=0.0230742 scc=0.00267719 m=(1)
NM42 (n11_4 \3\:qbint_4 \19\:VSS VSS) g45n1svt w=(1.45e-07) l=4.5e-08 \
        nf=1 as=8.05e-14 ad=1.957e-14 ps=1.49e-06 pd=5.6e-07 nrd=1.16667 \
        nrs=1.16667 sa=1.645e-06 sb=5.75e-07 sd=160n sca=15.7071 \
        scb=0.0167369 scc=0.00113434 m=(1)
NM41 (\6\:n30_4 \31\:CKb n11_4 VSS) g45n1svt w=(1.45e-07) l=4.5e-08 nf=1 \
        as=2.9e-14 ad=1.957e-14 ps=6.9e-07 pd=5.6e-07 nrd=1.16667 \
        nrs=1.16667 sa=7.55e-07 sb=1.465e-06 sd=160n sca=15.7071 \
        scb=0.0167369 scc=0.00113434 m=(1)
NM45 (\8\:mout_4 \31\:Ckbb \6\:n30_4 VSS) g45n1svt w=(1.45e-07) l=4.5e-08 \
        nf=1 as=2.9e-14 ad=3.335e-14 ps=6.9e-07 pd=7.5e-07 nrd=1.16667 \
        nrs=1.16667 sa=1.22e-06 sb=1e-06 sd=160n sca=15.7071 scb=0.0167369 \
        scc=0.00113434 m=(1)
NM49 (\8\:mout_4 \4\:n20_4 \21\:VSS VSS) g45n1svt w=(1.45e-07) l=4.5e-08 \
        nf=1 as=3.335e-14 ad=8.475e-14 ps=7.5e-07 pd=1.59e-06 nrd=1.16667 \
        nrs=1.16667 sa=1.275e-06 sb=9.45e-07 sd=160n sca=15.7071 \
        scb=0.0167369 scc=0.00113434 m=(1)
NM47 (n7_4 \24\:RN \21\:VSS VSS) g45n1svt w=(1.45e-07) l=4.5e-08 nf=1 \
        as=8.7e-15 ad=8.475e-14 ps=4.1e-07 pd=1.59e-06 nrd=1.16667 \
        nrs=1.16667 sa=1.59e-06 sb=6.3e-07 sd=160n sca=15.7071 \
        scb=0.0167369 scc=0.00113434 m=(1)
NM46 (n5_4 \3\:mout_4 n7_4 VSS) g45n1svt w=(1.45e-07) l=4.5e-08 nf=1 \
        as=1.957e-14 ad=8.7e-15 ps=5.6e-07 pd=4.1e-07 nrd=1.16667 \
        nrs=1.16667 sa=1.695e-06 sb=5.25e-07 sd=160n sca=15.7071 \
        scb=0.0167369 scc=0.00113434 m=(1)
NM48 (\9\:n20_4 \28\:Ckbb n5_4 VSS) g45n1svt w=(1.45e-07) l=4.5e-08 nf=1 \
        as=2.32e-14 ad=1.957e-14 ps=6.1e-07 pd=5.6e-07 nrd=1.16667 \
        nrs=1.16667 sa=1.875e-06 sb=3.45e-07 sd=160n sca=15.7071 \
        scb=0.0167369 scc=0.00113434 m=(1)
NM50 (\8\:Db_4 \26\:CKb \9\:n20_4 VSS) g45n1svt w=(1.45e-07) l=4.5e-08 \
        nf=1 as=2.03e-14 ad=2.32e-14 ps=5.7e-07 pd=6.1e-07 nrd=1.16667 \
        nrs=1.16667 sa=2e-06 sb=1.4e-07 sd=160n sca=15.7071 scb=0.0167369 \
        scc=0.00113434 m=(1)
NM54 (n1_4 \3\:D4 \23\:VSS VSS) g45n1svt w=(1.45e-07) l=4.5e-08 nf=1 \
        as=5.027e-14 ad=2.03e-14 ps=1.33e-06 pd=5.7e-07 nrd=1.16667 \
        nrs=1.16667 sa=8.86379e-07 sb=1.25e-07 sd=160n sca=12.9138 \
        scb=0.0133404 scc=0.000640143 m=(1)
NM53 (Db_4 SEb_4 n1_4 VSS) g45n1svt w=(1.45e-07) l=4.5e-08 nf=1 \
        as=3.77e-14 ad=2.03e-14 ps=8.1e-07 pd=5.7e-07 nrd=1.16667 \
        nrs=1.16667 sa=3.1e-07 sb=7.01379e-07 sd=160n sca=12.9138 \
        scb=0.0133404 scc=0.000640143 m=(1)
NM52 (Db_4 \25\:SE n3_4 VSS) g45n1svt w=(1.45e-07) l=4.5e-08 nf=1 \
        as=3.77e-14 ad=8.7e-15 ps=8.1e-07 pd=4.1e-07 nrd=1.16667 \
        nrs=1.16667 sa=6.15e-07 sb=3.96379e-07 sd=160n sca=12.9138 \
        scb=0.0133404 scc=0.000640143 m=(1)
NM51 (n3_4 \1\:SI4 \56\:VSS VSS) g45n1svt w=(1.45e-07) l=4.5e-08 nf=1 \
        as=8.7e-15 ad=7.87e-14 ps=4.1e-07 pd=1.6e-06 nrd=1.16667 \
        nrs=1.16667 sa=7.2e-07 sb=2.91379e-07 sd=160n sca=12.9138 \
        scb=0.0133404 scc=0.000640143 m=(1)
NM55 (\7\:SEb_4 \24\:SE \56\:VSS VSS) g45n1svt w=(1.45e-07) l=4.5e-08 \
        nf=1 as=7.87e-14 ad=3.262e-14 ps=1.6e-06 pd=7.4e-07 nrd=1.16667 \
        nrs=1.16667 sa=2.25e-07 sb=4.41897e-07 sd=160n sca=23.279 \
        scb=0.0230742 scc=0.00267719 m=(1)
NM36 (\11\:qint_3 \9\:qbint_3 \25\:VSS VSS) g45n1svt w=(1.45e-07) \
        l=4.5e-08 nf=1 as=6.735e-14 ad=2.03e-14 ps=1.6e-06 pd=5.7e-07 \
        nrd=1.16667 nrs=1.16667 sa=1.4e-07 sb=5.4e-07 sd=160n sca=23.279 \
        scb=0.0230742 scc=0.00267719 m=(1)
NM33 (n11_3 \3\:qbint_3 \66\:VSS VSS) g45n1svt w=(1.45e-07) l=4.5e-08 \
        nf=1 as=8.05e-14 ad=1.957e-14 ps=1.49e-06 pd=5.6e-07 nrd=1.16667 \
        nrs=1.16667 sa=1.645e-06 sb=5.75e-07 sd=160n sca=15.7071 \
        scb=0.0167369 scc=0.00113434 m=(1)
NM34 (\6\:n30_3 \24\:CKb n11_3 VSS) g45n1svt w=(1.45e-07) l=4.5e-08 nf=1 \
        as=2.9e-14 ad=1.957e-14 ps=6.9e-07 pd=5.6e-07 nrd=1.16667 \
        nrs=1.16667 sa=7.55e-07 sb=1.465e-06 sd=160n sca=15.7071 \
        scb=0.0167369 scc=0.00113434 m=(1)
NM30 (\8\:mout_3 \20\:Ckbb \6\:n30_3 VSS) g45n1svt w=(1.45e-07) l=4.5e-08 \
        nf=1 as=2.9e-14 ad=3.335e-14 ps=6.9e-07 pd=7.5e-07 nrd=1.16667 \
        nrs=1.16667 sa=1.22e-06 sb=1e-06 sd=160n sca=15.7071 scb=0.0167369 \
        scc=0.00113434 m=(1)
NM26 (\8\:mout_3 \4\:n20_3 \68\:VSS VSS) g45n1svt w=(1.45e-07) l=4.5e-08 \
        nf=1 as=3.335e-14 ad=8.475e-14 ps=7.5e-07 pd=1.59e-06 nrd=1.16667 \
        nrs=1.16667 sa=1.275e-06 sb=9.45e-07 sd=160n sca=15.7071 \
        scb=0.0167369 scc=0.00113434 m=(1)
NM28 (n7_3 \17\:RN \68\:VSS VSS) g45n1svt w=(1.45e-07) l=4.5e-08 nf=1 \
        as=8.7e-15 ad=8.475e-14 ps=4.1e-07 pd=1.59e-06 nrd=1.16667 \
        nrs=1.16667 sa=1.59e-06 sb=6.3e-07 sd=160n sca=15.7071 \
        scb=0.0167369 scc=0.00113434 m=(1)
NM29 (n5_3 \3\:mout_3 n7_3 VSS) g45n1svt w=(1.45e-07) l=4.5e-08 nf=1 \
        as=1.957e-14 ad=8.7e-15 ps=5.6e-07 pd=4.1e-07 nrd=1.16667 \
        nrs=1.16667 sa=1.695e-06 sb=5.25e-07 sd=160n sca=15.7071 \
        scb=0.0167369 scc=0.00113434 m=(1)
NM27 (\9\:n20_3 \17\:Ckbb n5_3 VSS) g45n1svt w=(1.45e-07) l=4.5e-08 nf=1 \
        as=2.32e-14 ad=1.957e-14 ps=6.1e-07 pd=5.6e-07 nrd=1.16667 \
        nrs=1.16667 sa=1.875e-06 sb=3.45e-07 sd=160n sca=15.7071 \
        scb=0.0167369 scc=0.00113434 m=(1)
NM25 (\8\:Db_3 \19\:CKb \9\:n20_3 VSS) g45n1svt w=(1.45e-07) l=4.5e-08 \
        nf=1 as=2.03e-14 ad=2.32e-14 ps=5.7e-07 pd=6.1e-07 nrd=1.16667 \
        nrs=1.16667 sa=2e-06 sb=1.4e-07 sd=160n sca=15.7071 scb=0.0167369 \
        scc=0.00113434 m=(1)
NM21 (n1_3 \3\:D3 \70\:VSS VSS) g45n1svt w=(1.45e-07) l=4.5e-08 nf=1 \
        as=5.027e-14 ad=2.03e-14 ps=1.33e-06 pd=5.7e-07 nrd=1.16667 \
        nrs=1.16667 sa=8.86379e-07 sb=1.25e-07 sd=160n sca=12.9138 \
        scb=0.0133404 scc=0.000640143 m=(1)
NM22 (Db_3 SEb_3 n1_3 VSS) g45n1svt w=(1.45e-07) l=4.5e-08 nf=1 \
        as=3.77e-14 ad=2.03e-14 ps=8.1e-07 pd=5.7e-07 nrd=1.16667 \
        nrs=1.16667 sa=3.1e-07 sb=7.01379e-07 sd=160n sca=12.9138 \
        scb=0.0133404 scc=0.000640143 m=(1)
NM23 (Db_3 \18\:SE n3_3 VSS) g45n1svt w=(1.45e-07) l=4.5e-08 nf=1 \
        as=3.77e-14 ad=8.7e-15 ps=8.1e-07 pd=4.1e-07 nrd=1.16667 \
        nrs=1.16667 sa=6.15e-07 sb=3.96379e-07 sd=160n sca=12.9138 \
        scb=0.0133404 scc=0.000640143 m=(1)
NM24 (n3_3 \1\:SI3 \72\:VSS VSS) g45n1svt w=(1.45e-07) l=4.5e-08 nf=1 \
        as=8.7e-15 ad=7.87e-14 ps=4.1e-07 pd=1.6e-06 nrd=1.16667 \
        nrs=1.16667 sa=7.2e-07 sb=2.91379e-07 sd=160n sca=12.9138 \
        scb=0.0133404 scc=0.000640143 m=(1)
NM20 (\7\:SEb_3 \17\:SE \72\:VSS VSS) g45n1svt w=(1.45e-07) l=4.5e-08 \
        nf=1 as=7.87e-14 ad=3.262e-14 ps=1.6e-06 pd=7.4e-07 nrd=1.16667 \
        nrs=1.16667 sa=2.25e-07 sb=4.41897e-07 sd=160n sca=23.279 \
        scb=0.0230742 scc=0.00267719 m=(1)
NM18 (\12\:qint_2 \5\:qbint_2 \43\:VSS VSS) g45n1svt w=(1.45e-07) \
        l=4.5e-08 nf=1 as=6.735e-14 ad=2.03e-14 ps=1.6e-06 pd=5.7e-07 \
        nrd=1.16667 nrs=1.16667 sa=1.4e-07 sb=5.4e-07 sd=160n sca=23.279 \
        scb=0.0230742 scc=0.00267719 m=(1)
NM15 (n11_2 \13\:qbint_2 \82\:VSS VSS) g45n1svt w=(1.45e-07) l=4.5e-08 \
        nf=1 as=8.05e-14 ad=1.957e-14 ps=1.49e-06 pd=5.6e-07 nrd=1.16667 \
        nrs=1.16667 sa=1.645e-06 sb=5.75e-07 sd=160n sca=15.7071 \
        scb=0.0167369 scc=0.00113434 m=(1)
NM16 (\6\:n30_2 \8\:CKb n11_2 VSS) g45n1svt w=(1.45e-07) l=4.5e-08 nf=1 \
        as=2.9e-14 ad=1.957e-14 ps=6.9e-07 pd=5.6e-07 nrd=1.16667 \
        nrs=1.16667 sa=7.55e-07 sb=1.465e-06 sd=160n sca=15.7071 \
        scb=0.0167369 scc=0.00113434 m=(1)
NM12 (\6\:mout_2 \9\:Ckbb \6\:n30_2 VSS) g45n1svt w=(1.45e-07) l=4.5e-08 \
        nf=1 as=2.9e-14 ad=3.335e-14 ps=6.9e-07 pd=7.5e-07 nrd=1.16667 \
        nrs=1.16667 sa=1.22e-06 sb=1e-06 sd=160n sca=15.7071 scb=0.0167369 \
        scc=0.00113434 m=(1)
NM8 (\6\:mout_2 \3\:n20_2 \80\:VSS VSS) g45n1svt w=(1.45e-07) l=4.5e-08 \
        nf=1 as=3.335e-14 ad=8.475e-14 ps=7.5e-07 pd=1.59e-06 nrd=1.16667 \
        nrs=1.16667 sa=1.275e-06 sb=9.45e-07 sd=160n sca=15.7071 \
        scb=0.0167369 scc=0.00113434 m=(1)
NM10 (n7_2 \12\:RN \80\:VSS VSS) g45n1svt w=(1.45e-07) l=4.5e-08 nf=1 \
        as=8.7e-15 ad=8.475e-14 ps=4.1e-07 pd=1.59e-06 nrd=1.16667 \
        nrs=1.16667 sa=1.59e-06 sb=6.3e-07 sd=160n sca=15.7071 \
        scb=0.0167369 scc=0.00113434 m=(1)
NM11 (n5_2 \3\:mout_2 n7_2 VSS) g45n1svt w=(1.45e-07) l=4.5e-08 nf=1 \
        as=1.957e-14 ad=8.7e-15 ps=5.6e-07 pd=4.1e-07 nrd=1.16667 \
        nrs=1.16667 sa=1.695e-06 sb=5.25e-07 sd=160n sca=15.7071 \
        scb=0.0167369 scc=0.00113434 m=(1)
NM9 (\9\:n20_2 \11\:Ckbb n5_2 VSS) g45n1svt w=(1.45e-07) l=4.5e-08 nf=1 \
        as=2.32e-14 ad=1.957e-14 ps=6.1e-07 pd=5.6e-07 nrd=1.16667 \
        nrs=1.16667 sa=1.875e-06 sb=3.45e-07 sd=160n sca=15.7071 \
        scb=0.0167369 scc=0.00113434 m=(1)
NM7 (\8\:Db_2 \14\:CKb \9\:n20_2 VSS) g45n1svt w=(1.45e-07) l=4.5e-08 \
        nf=1 as=2.03e-14 ad=2.32e-14 ps=5.7e-07 pd=6.1e-07 nrd=1.16667 \
        nrs=1.16667 sa=2e-06 sb=1.4e-07 sd=160n sca=15.7071 scb=0.0167369 \
        scc=0.00113434 m=(1)
NM1 (n1_2 \3\:D2 \78\:VSS VSS) g45n1svt w=(1.45e-07) l=4.5e-08 nf=1 \
        as=5.027e-14 ad=2.03e-14 ps=1.33e-06 pd=5.7e-07 nrd=1.16667 \
        nrs=1.16667 sa=8.86379e-07 sb=1.25e-07 sd=160n sca=12.9138 \
        scb=0.0133404 scc=0.000640143 m=(1)
NM2 (\6\:Db_2 \3\:SEb_2 n1_2 VSS) g45n1svt w=(1.45e-07) l=4.5e-08 nf=1 \
        as=3.77e-14 ad=2.03e-14 ps=8.1e-07 pd=5.7e-07 nrd=1.16667 \
        nrs=1.16667 sa=3.1e-07 sb=7.01379e-07 sd=160n sca=12.9138 \
        scb=0.0133404 scc=0.000640143 m=(1)
NM3 (\6\:Db_2 \10\:SE n3_2 VSS) g45n1svt w=(1.45e-07) l=4.5e-08 nf=1 \
        as=3.77e-14 ad=8.7e-15 ps=8.1e-07 pd=4.1e-07 nrd=1.16667 \
        nrs=1.16667 sa=6.15e-07 sb=3.96379e-07 sd=160n sca=12.9138 \
        scb=0.0133404 scc=0.000640143 m=(1)
NM4 (n3_2 \1\:SI2 \76\:VSS VSS) g45n1svt w=(1.45e-07) l=4.5e-08 nf=1 \
        as=8.7e-15 ad=7.87e-14 ps=4.1e-07 pd=1.6e-06 nrd=1.16667 \
        nrs=1.16667 sa=7.2e-07 sb=2.91379e-07 sd=160n sca=12.9138 \
        scb=0.0133404 scc=0.000640143 m=(1)
NM0 (\4\:SEb_2 \14\:SE \76\:VSS VSS) g45n1svt w=(1.45e-07) l=4.5e-08 \
        nf=1 as=7.87e-14 ad=3.262e-14 ps=1.6e-06 pd=7.4e-07 nrd=1.16667 \
        nrs=1.16667 sa=2.25e-07 sb=4.41897e-07 sd=160n sca=23.279 \
        scb=0.0230742 scc=0.00267719 m=(1)
mn56 (\12\:qint \5\:qbint \53\:VSS VSS) g45n1svt w=(1.45e-07) l=4.5e-08 \
        nf=1 as=6.735e-14 ad=2.03e-14 ps=1.6e-06 pd=5.7e-07 nrd=1.16667 \
        nrs=1.16667 sa=1.4e-07 sb=5.4e-07 sd=160n sca=23.279 scb=0.0230742 \
        scc=0.00267719 m=(1)
mn50 (n11 \13\:qbint \98\:VSS VSS) g45n1svt w=(1.45e-07) l=4.5e-08 nf=1 \
        as=8.05e-14 ad=1.957e-14 ps=1.49e-06 pd=5.6e-07 nrd=1.16667 \
        nrs=1.16667 sa=1.645e-06 sb=5.75e-07 sd=160n sca=15.7071 \
        scb=0.0167369 scc=0.00113434 m=(1)
mn51 (\6\:n30 CKb n11 VSS) g45n1svt w=(1.45e-07) l=4.5e-08 nf=1 \
        as=2.9e-14 ad=1.957e-14 ps=6.9e-07 pd=5.6e-07 nrd=1.16667 \
        nrs=1.16667 sa=7.55e-07 sb=1.465e-06 sd=160n sca=15.7071 \
        scb=0.0167369 scc=0.00113434 m=(1)
mn40 (\6\:mout \2\:Ckbb \6\:n30 VSS) g45n1svt w=(1.45e-07) l=4.5e-08 nf=1 \
        as=2.9e-14 ad=3.335e-14 ps=6.9e-07 pd=7.5e-07 nrd=1.16667 \
        nrs=1.16667 sa=1.22e-06 sb=1e-06 sd=160n sca=15.7071 scb=0.0167369 \
        scc=0.00113434 m=(1)
mn30 (\6\:mout \3\:n20 \96\:VSS VSS) g45n1svt w=(1.45e-07) l=4.5e-08 \
        nf=1 as=3.335e-14 ad=8.475e-14 ps=7.5e-07 pd=1.59e-06 nrd=1.16667 \
        nrs=1.16667 sa=1.275e-06 sb=9.45e-07 sd=160n sca=15.7071 \
        scb=0.0167369 scc=0.00113434 m=(1)
mn35 (n7 \5\:RN \96\:VSS VSS) g45n1svt w=(1.45e-07) l=4.5e-08 nf=1 \
        as=8.7e-15 ad=8.475e-14 ps=4.1e-07 pd=1.59e-06 nrd=1.16667 \
        nrs=1.16667 sa=1.59e-06 sb=6.3e-07 sd=160n sca=15.7071 \
        scb=0.0167369 scc=0.00113434 m=(1)
mn36 (n5 \3\:mout n7 VSS) g45n1svt w=(1.45e-07) l=4.5e-08 nf=1 \
        as=1.957e-14 ad=8.7e-15 ps=5.6e-07 pd=4.1e-07 nrd=1.16667 \
        nrs=1.16667 sa=1.695e-06 sb=5.25e-07 sd=160n sca=15.7071 \
        scb=0.0167369 scc=0.00113434 m=(1)
mn37 (\9\:n20 \4\:Ckbb n5 VSS) g45n1svt w=(1.45e-07) l=4.5e-08 nf=1 \
        as=2.32e-14 ad=1.957e-14 ps=6.1e-07 pd=5.6e-07 nrd=1.16667 \
        nrs=1.16667 sa=1.875e-06 sb=3.45e-07 sd=160n sca=15.7071 \
        scb=0.0167369 scc=0.00113434 m=(1)
mn25 (\8\:Db \7\:CKb \9\:n20 VSS) g45n1svt w=(1.45e-07) l=4.5e-08 nf=1 \
        as=2.03e-14 ad=2.32e-14 ps=5.7e-07 pd=6.1e-07 nrd=1.16667 \
        nrs=1.16667 sa=2e-06 sb=1.4e-07 sd=160n sca=15.7071 scb=0.0167369 \
        scc=0.00113434 m=(1)
mn11 (n1 \3\:D1 \94\:VSS VSS) g45n1svt w=(1.45e-07) l=4.5e-08 nf=1 \
        as=5.027e-14 ad=2.03e-14 ps=1.33e-06 pd=5.7e-07 nrd=1.16667 \
        nrs=1.16667 sa=8.86379e-07 sb=1.25e-07 sd=160n sca=12.9138 \
        scb=0.0133404 scc=0.000640143 m=(1)
mn12 (\6\:Db \3\:SEb n1 VSS) g45n1svt w=(1.45e-07) l=4.5e-08 nf=1 \
        as=3.77e-14 ad=2.03e-14 ps=8.1e-07 pd=5.7e-07 nrd=1.16667 \
        nrs=1.16667 sa=3.1e-07 sb=7.01379e-07 sd=160n sca=12.9138 \
        scb=0.0133404 scc=0.000640143 m=(1)
mn14 (\6\:Db \3\:SE n3 VSS) g45n1svt w=(1.45e-07) l=4.5e-08 nf=1 \
        as=3.77e-14 ad=8.7e-15 ps=8.1e-07 pd=4.1e-07 nrd=1.16667 \
        nrs=1.16667 sa=6.15e-07 sb=3.96379e-07 sd=160n sca=12.9138 \
        scb=0.0133404 scc=0.000640143 m=(1)
mn13 (n3 \1\:SI1 \92\:VSS VSS) g45n1svt w=(1.45e-07) l=4.5e-08 nf=1 \
        as=8.7e-15 ad=7.87e-14 ps=4.1e-07 pd=1.6e-06 nrd=1.16667 \
        nrs=1.16667 sa=7.2e-07 sb=2.91379e-07 sd=160n sca=12.9138 \
        scb=0.0133404 scc=0.000640143 m=(1)
mn10 (\4\:SEb \7\:SE \92\:VSS VSS) g45n1svt w=(1.45e-07) l=4.5e-08 nf=1 \
        as=7.87e-14 ad=3.262e-14 ps=1.6e-06 pd=7.4e-07 nrd=1.16667 \
        nrs=1.16667 sa=2.25e-07 sb=4.41897e-07 sd=160n sca=23.279 \
        scb=0.0230742 scc=0.00267719 m=(1)
NM44 (\19\:qbint_4 \3\:n30_4 n9_4 VSS) g45n1svt w=(2.05e-07) l=4.5e-08 \
        nf=1 as=3.382e-14 ad=2.05e-14 ps=7.4e-07 pd=6.1e-07 nrd=1.16667 \
        nrs=1.16667 sa=1.65e-07 sb=1.50683e-06 sd=160n sca=13.8179 \
        scb=0.0141903 scc=0.000851218 m=(1)
NM43 (n9_4 \25\:RN \19\:VSS VSS) g45n1svt w=(2.05e-07) l=4.5e-08 nf=1 \
        as=2.05e-14 ad=8.05e-14 ps=6.1e-07 pd=1.49e-06 nrd=1.16667 \
        nrs=1.16667 sa=3.1e-07 sb=1.40073e-06 sd=160n sca=13.8179 \
        scb=0.0141903 scc=0.000851218 m=(1)
NM31 (\19\:qbint_3 \3\:n30_3 n9_3 VSS) g45n1svt w=(2.05e-07) l=4.5e-08 \
        nf=1 as=3.382e-14 ad=2.05e-14 ps=7.4e-07 pd=6.1e-07 nrd=1.16667 \
        nrs=1.16667 sa=1.65e-07 sb=1.50683e-06 sd=160n sca=13.8179 \
        scb=0.0141903 scc=0.000851218 m=(1)
NM32 (n9_3 \18\:RN \66\:VSS VSS) g45n1svt w=(2.05e-07) l=4.5e-08 nf=1 \
        as=2.05e-14 ad=8.05e-14 ps=6.1e-07 pd=1.49e-06 nrd=1.16667 \
        nrs=1.16667 sa=3.1e-07 sb=1.40073e-06 sd=160n sca=13.8179 \
        scb=0.0141903 scc=0.000851218 m=(1)
NM13 (\19\:qbint_2 n30_2 n9_2 VSS) g45n1svt w=(2.05e-07) l=4.5e-08 nf=1 \
        as=3.382e-14 ad=2.05e-14 ps=7.4e-07 pd=6.1e-07 nrd=1.16667 \
        nrs=1.16667 sa=1.65e-07 sb=1.50683e-06 sd=160n sca=13.8179 \
        scb=0.0141903 scc=0.000851218 m=(1)
NM14 (n9_2 \8\:RN \82\:VSS VSS) g45n1svt w=(2.05e-07) l=4.5e-08 nf=1 \
        as=2.05e-14 ad=8.05e-14 ps=6.1e-07 pd=1.49e-06 nrd=1.16667 \
        nrs=1.16667 sa=3.1e-07 sb=1.40073e-06 sd=160n sca=13.8179 \
        scb=0.0141903 scc=0.000851218 m=(1)
mn46 (\19\:qbint n30 n9 VSS) g45n1svt w=(2.05e-07) l=4.5e-08 nf=1 \
        as=3.382e-14 ad=2.05e-14 ps=7.4e-07 pd=6.1e-07 nrd=1.16667 \
        nrs=1.16667 sa=1.65e-07 sb=1.50683e-06 sd=160n sca=13.8179 \
        scb=0.0141903 scc=0.000851218 m=(1)
mn45 (n9 \1\:RN \98\:VSS VSS) g45n1svt w=(2.05e-07) l=4.5e-08 nf=1 \
        as=2.05e-14 ad=8.05e-14 ps=6.1e-07 pd=1.49e-06 nrd=1.16667 \
        nrs=1.16667 sa=3.1e-07 sb=1.40073e-06 sd=160n sca=13.8179 \
        scb=0.0141903 scc=0.000851218 m=(1)
mp21 (\24\:Ckbb \18\:CKb \59\:VDD VDD) g45p1svt w=(2.15e-07) l=4.5e-08 \
        nf=1 as=3.01e-14 ad=8.732e-14 ps=7.1e-07 pd=1.85e-06 nrd=1.16667 \
        nrs=1.16667 sa=1.4e-07 sb=3.6e-07 sd=160n sca=31.508 scb=0.0252524 \
        scc=0.00399199 m=(1)
mp20 (\56\:CKb \1\:CK \59\:VDD VDD) g45p1svt w=(2.15e-07) l=4.5e-08 nf=1 \
        as=3.01e-14 ad=8.732e-14 ps=7.1e-07 pd=1.85e-06 nrd=1.16667 \
        nrs=1.16667 sa=3.6e-07 sb=1.4e-07 sd=160n sca=31.508 scb=0.0252524 \
        scc=0.00399199 m=(1)
PM42 (n8_4 qbint_4 \20\:VDD VDD) g45p1svt w=(2.15e-07) l=4.5e-08 nf=1 \
        as=1.1192e-13 ad=3.01e-14 ps=1.9e-06 pd=7.1e-07 nrd=1.16667 \
        nrs=1.16667 sa=1.22e-06 sb=1.235e-06 sd=160n sca=29.9075 \
        scb=0.0247057 scc=0.00372713 m=(1)
PM41 (\4\:n30_4 \30\:Ckbb n8_4 VDD) g45p1svt w=(2.15e-07) l=4.5e-08 nf=1 \
        as=3.01e-14 ad=5.375e-14 ps=7.1e-07 pd=9.3e-07 nrd=1.16667 \
        nrs=1.16667 sa=1.035e-06 sb=1.42e-06 sd=160n sca=29.9075 \
        scb=0.0247057 scc=0.00372713 m=(1)
PM45 (\4\:n30_4 \29\:CKb \4\:mout_4 VDD) g45p1svt w=(2.15e-07) l=4.5e-08 \
        nf=1 as=3.762e-14 ad=5.375e-14 ps=7.8e-07 pd=9.3e-07 nrd=1.16667 \
        nrs=1.16667 sa=7.4e-07 sb=1.715e-06 sd=160n sca=29.9075 \
        scb=0.0247057 scc=0.00372713 m=(1)
PM49 (\4\:mout_4 n20_4 \22\:VDD VDD) g45p1svt w=(2.15e-07) l=4.5e-08 \
        nf=1 as=3.762e-14 ad=8.415e-14 ps=7.8e-07 pd=1.83e-06 nrd=1.16667 \
        nrs=1.16667 sa=1.935e-06 sb=5.2e-07 sd=160n sca=29.9075 \
        scb=0.0247057 scc=0.00372713 m=(1)
PM48 (n6_4 \23\:RN \22\:VDD VDD) g45p1svt w=(2.15e-07) l=4.5e-08 nf=1 \
        as=3.44e-14 ad=8.415e-14 ps=7.5e-07 pd=1.83e-06 nrd=1.16667 \
        nrs=1.16667 sa=2e-06 sb=3.05e-07 sd=160n sca=29.9075 scb=0.0247057 \
        scc=0.00372713 m=(1)
PM46 (n6_4 mout_4 \24\:VDD VDD) g45p1svt w=(2.15e-07) l=4.5e-08 nf=1 \
        as=3.44e-14 ad=6.29e-14 ps=7.5e-07 pd=1.83e-06 nrd=1.16667 \
        nrs=1.16667 sa=2e-06 sb=1e-07 sd=160n sca=29.9075 scb=0.0247057 \
        scc=0.00372713 m=(1)
PM47 (\7\:n20_4 \27\:CKb \3\:n6_4 VDD) g45p1svt w=(2.15e-07) l=4.5e-08 \
        nf=1 as=3.44e-14 ad=3.01e-14 ps=7.5e-07 pd=7.1e-07 nrd=1.16667 \
        nrs=1.16667 sa=1.4e-07 sb=3.31047e-07 sd=160n sca=45.7906 \
        scb=0.0283307 scc=0.00588417 m=(1)
PM50 (\7\:n20_4 \26\:Ckbb \4\:Db_4 VDD) g45p1svt w=(2.15e-07) l=4.5e-08 \
        nf=1 as=2.71e-14 ad=3.44e-14 ps=7.1e-07 pd=7.5e-07 nrd=1.16667 \
        nrs=1.16667 sa=1.26047e-07 sb=3.45e-07 sd=160n sca=45.7906 \
        scb=0.0283307 scc=0.00588417 m=(1)
PM54 (n2_4 \1\:D4 \26\:VDD VDD) g45p1svt w=(2.15e-07) l=4.5e-08 nf=1 \
        as=7.07e-14 ad=3.87e-14 ps=1.71e-06 pd=7.9e-07 nrd=1.16667 \
        nrs=1.16667 sa=1e-06 sb=1.10465e-07 sd=160n sca=21.1782 \
        scb=0.0203295 scc=0.00208843 m=(1)
PM53 (\6\:Db_4 \27\:SE n2_4 VDD) g45p1svt w=(2.15e-07) l=4.5e-08 nf=1 \
        as=3.44e-14 ad=3.87e-14 ps=7.5e-07 pd=7.9e-07 nrd=1.16667 \
        nrs=1.16667 sa=3.35465e-07 sb=7.75e-07 sd=160n sca=21.1782 \
        scb=0.0203295 scc=0.00208843 m=(1)
PM51 (\6\:Db_4 \3\:SEb_4 n4_4 VDD) g45p1svt w=(2.15e-07) l=4.5e-08 nf=1 \
        as=3.44e-14 ad=2.58e-14 ps=7.5e-07 pd=6.7e-07 nrd=1.16667 \
        nrs=1.16667 sa=5.40465e-07 sb=5.7e-07 sd=160n sca=21.1782 \
        scb=0.0203295 scc=0.00208843 m=(1)
PM52 (n4_4 \3\:SI4 \28\:VDD VDD) g45p1svt w=(2.15e-07) l=4.5e-08 nf=1 \
        as=2.58e-14 ad=1.001e-13 ps=6.7e-07 pd=1.75e-06 nrd=1.16667 \
        nrs=1.16667 sa=7.05465e-07 sb=4.05e-07 sd=160n sca=21.1782 \
        scb=0.0203295 scc=0.00208843 m=(1)
PM55 (\5\:SEb_4 \22\:SE \28\:VDD VDD) g45p1svt w=(2.15e-07) l=4.5e-08 \
        nf=1 as=3.01e-14 ad=1.001e-13 ps=7.1e-07 pd=1.75e-06 nrd=1.16667 \
        nrs=1.16667 sa=9.70465e-07 sb=1.4e-07 sd=160n sca=21.1782 \
        scb=0.0203295 scc=0.00208843 m=(1)
PM33 (n8_3 qbint_3 \44\:VDD VDD) g45p1svt w=(2.15e-07) l=4.5e-08 nf=1 \
        as=1.1192e-13 ad=3.01e-14 ps=1.9e-06 pd=7.1e-07 nrd=1.16667 \
        nrs=1.16667 sa=1.22e-06 sb=1.235e-06 sd=160n sca=29.9075 \
        scb=0.0247057 scc=0.00372713 m=(1)
PM34 (\4\:n30_3 \19\:Ckbb n8_3 VDD) g45p1svt w=(2.15e-07) l=4.5e-08 nf=1 \
        as=3.01e-14 ad=5.375e-14 ps=7.1e-07 pd=9.3e-07 nrd=1.16667 \
        nrs=1.16667 sa=1.035e-06 sb=1.42e-06 sd=160n sca=29.9075 \
        scb=0.0247057 scc=0.00372713 m=(1)
PM30 (\4\:n30_3 \22\:CKb \4\:mout_3 VDD) g45p1svt w=(2.15e-07) l=4.5e-08 \
        nf=1 as=3.762e-14 ad=5.375e-14 ps=7.8e-07 pd=9.3e-07 nrd=1.16667 \
        nrs=1.16667 sa=7.4e-07 sb=1.715e-06 sd=160n sca=29.9075 \
        scb=0.0247057 scc=0.00372713 m=(1)
PM26 (\4\:mout_3 n20_3 \47\:VDD VDD) g45p1svt w=(2.15e-07) l=4.5e-08 \
        nf=1 as=3.762e-14 ad=8.415e-14 ps=7.8e-07 pd=1.83e-06 nrd=1.16667 \
        nrs=1.16667 sa=1.935e-06 sb=5.2e-07 sd=160n sca=29.9075 \
        scb=0.0247057 scc=0.00372713 m=(1)
PM27 (n6_3 \16\:RN \47\:VDD VDD) g45p1svt w=(2.15e-07) l=4.5e-08 nf=1 \
        as=3.44e-14 ad=8.415e-14 ps=7.5e-07 pd=1.83e-06 nrd=1.16667 \
        nrs=1.16667 sa=2e-06 sb=3.05e-07 sd=160n sca=29.9075 scb=0.0247057 \
        scc=0.00372713 m=(1)
PM29 (n6_3 mout_3 \50\:VDD VDD) g45p1svt w=(2.15e-07) l=4.5e-08 nf=1 \
        as=3.44e-14 ad=6.29e-14 ps=7.5e-07 pd=1.83e-06 nrd=1.16667 \
        nrs=1.16667 sa=2e-06 sb=1e-07 sd=160n sca=29.9075 scb=0.0247057 \
        scc=0.00372713 m=(1)
PM28 (\7\:n20_3 \20\:CKb \3\:n6_3 VDD) g45p1svt w=(2.15e-07) l=4.5e-08 \
        nf=1 as=3.44e-14 ad=3.01e-14 ps=7.5e-07 pd=7.1e-07 nrd=1.16667 \
        nrs=1.16667 sa=1.4e-07 sb=3.31047e-07 sd=160n sca=45.7906 \
        scb=0.0283307 scc=0.00588417 m=(1)
PM25 (\7\:n20_3 \15\:Ckbb \4\:Db_3 VDD) g45p1svt w=(2.15e-07) l=4.5e-08 \
        nf=1 as=2.71e-14 ad=3.44e-14 ps=7.1e-07 pd=7.5e-07 nrd=1.16667 \
        nrs=1.16667 sa=1.26047e-07 sb=3.45e-07 sd=160n sca=45.7906 \
        scb=0.0283307 scc=0.00588417 m=(1)
PM21 (n2_3 \1\:D3 \53\:VDD VDD) g45p1svt w=(2.15e-07) l=4.5e-08 nf=1 \
        as=7.07e-14 ad=3.87e-14 ps=1.71e-06 pd=7.9e-07 nrd=1.16667 \
        nrs=1.16667 sa=1e-06 sb=1.10465e-07 sd=160n sca=21.1782 \
        scb=0.0203295 scc=0.00208843 m=(1)
PM22 (\6\:Db_3 \20\:SE n2_3 VDD) g45p1svt w=(2.15e-07) l=4.5e-08 nf=1 \
        as=3.44e-14 ad=3.87e-14 ps=7.5e-07 pd=7.9e-07 nrd=1.16667 \
        nrs=1.16667 sa=3.35465e-07 sb=7.75e-07 sd=160n sca=21.1782 \
        scb=0.0203295 scc=0.00208843 m=(1)
PM24 (\6\:Db_3 \3\:SEb_3 n4_3 VDD) g45p1svt w=(2.15e-07) l=4.5e-08 nf=1 \
        as=3.44e-14 ad=2.58e-14 ps=7.5e-07 pd=6.7e-07 nrd=1.16667 \
        nrs=1.16667 sa=5.40465e-07 sb=5.7e-07 sd=160n sca=21.1782 \
        scb=0.0203295 scc=0.00208843 m=(1)
PM23 (n4_3 \3\:SI3 \56\:VDD VDD) g45p1svt w=(2.15e-07) l=4.5e-08 nf=1 \
        as=2.58e-14 ad=1.001e-13 ps=6.7e-07 pd=1.75e-06 nrd=1.16667 \
        nrs=1.16667 sa=7.05465e-07 sb=4.05e-07 sd=160n sca=21.1782 \
        scb=0.0203295 scc=0.00208843 m=(1)
PM20 (\5\:SEb_3 \15\:SE \56\:VDD VDD) g45p1svt w=(2.15e-07) l=4.5e-08 \
        nf=1 as=3.01e-14 ad=1.001e-13 ps=7.1e-07 pd=1.75e-06 nrd=1.16667 \
        nrs=1.16667 sa=9.70465e-07 sb=1.4e-07 sd=160n sca=21.1782 \
        scb=0.0203295 scc=0.00208843 m=(1)
PM15 (n8_2 \11\:qbint_2 \75\:VDD VDD) g45p1svt w=(2.15e-07) l=4.5e-08 \
        nf=1 as=1.1192e-13 ad=3.01e-14 ps=1.9e-06 pd=7.1e-07 nrd=1.16667 \
        nrs=1.16667 sa=1.22e-06 sb=1.235e-06 sd=160n sca=29.9075 \
        scb=0.0247057 scc=0.00372713 m=(1)
PM16 (\4\:n30_2 \10\:Ckbb n8_2 VDD) g45p1svt w=(2.15e-07) l=4.5e-08 nf=1 \
        as=3.01e-14 ad=5.375e-14 ps=7.1e-07 pd=9.3e-07 nrd=1.16667 \
        nrs=1.16667 sa=1.035e-06 sb=1.42e-06 sd=160n sca=29.9075 \
        scb=0.0247057 scc=0.00372713 m=(1)
PM12 (\4\:n30_2 \10\:CKb \8\:mout_2 VDD) g45p1svt w=(2.15e-07) l=4.5e-08 \
        nf=1 as=3.762e-14 ad=5.375e-14 ps=7.8e-07 pd=9.3e-07 nrd=1.16667 \
        nrs=1.16667 sa=7.4e-07 sb=1.715e-06 sd=160n sca=29.9075 \
        scb=0.0247057 scc=0.00372713 m=(1)
PM8 (\8\:mout_2 \4\:n20_2 \71\:VDD VDD) g45p1svt w=(2.15e-07) l=4.5e-08 \
        nf=1 as=3.762e-14 ad=8.415e-14 ps=7.8e-07 pd=1.83e-06 nrd=1.16667 \
        nrs=1.16667 sa=1.935e-06 sb=5.2e-07 sd=160n sca=29.9075 \
        scb=0.0247057 scc=0.00372713 m=(1)
PM9 (\3\:n6_2 \13\:RN \71\:VDD VDD) g45p1svt w=(2.15e-07) l=4.5e-08 nf=1 \
        as=3.44e-14 ad=8.415e-14 ps=7.5e-07 pd=1.83e-06 nrd=1.16667 \
        nrs=1.16667 sa=2e-06 sb=3.05e-07 sd=160n sca=29.9075 scb=0.0247057 \
        scc=0.00372713 m=(1)
PM11 (\3\:n6_2 mout_2 \68\:VDD VDD) g45p1svt w=(2.15e-07) l=4.5e-08 nf=1 \
        as=3.44e-14 ad=6.29e-14 ps=7.5e-07 pd=1.83e-06 nrd=1.16667 \
        nrs=1.16667 sa=2e-06 sb=1e-07 sd=160n sca=29.9075 scb=0.0247057 \
        scc=0.00372713 m=(1)
PM10 (\5\:n20_2 \13\:CKb n6_2 VDD) g45p1svt w=(2.15e-07) l=4.5e-08 nf=1 \
        as=3.44e-14 ad=3.01e-14 ps=7.5e-07 pd=7.1e-07 nrd=1.16667 \
        nrs=1.16667 sa=1.4e-07 sb=3.31047e-07 sd=160n sca=45.7906 \
        scb=0.0283307 scc=0.00588417 m=(1)
PM7 (\5\:n20_2 \13\:Ckbb \4\:Db_2 VDD) g45p1svt w=(2.15e-07) l=4.5e-08 \
        nf=1 as=2.71e-14 ad=3.44e-14 ps=7.1e-07 pd=7.5e-07 nrd=1.16667 \
        nrs=1.16667 sa=1.26047e-07 sb=3.45e-07 sd=160n sca=45.7906 \
        scb=0.0283307 scc=0.00588417 m=(1)
PM1 (n2_2 \1\:D2 \65\:VDD VDD) g45p1svt w=(2.15e-07) l=4.5e-08 nf=1 \
        as=7.07e-14 ad=3.87e-14 ps=1.71e-06 pd=7.9e-07 nrd=1.16667 \
        nrs=1.16667 sa=1e-06 sb=1.10465e-07 sd=160n sca=21.1782 \
        scb=0.0203295 scc=0.00208843 m=(1)
PM2 (Db_2 \8\:SE n2_2 VDD) g45p1svt w=(2.15e-07) l=4.5e-08 nf=1 \
        as=3.44e-14 ad=3.87e-14 ps=7.5e-07 pd=7.9e-07 nrd=1.16667 \
        nrs=1.16667 sa=3.35465e-07 sb=7.75e-07 sd=160n sca=21.1782 \
        scb=0.0203295 scc=0.00208843 m=(1)
PM4 (Db_2 SEb_2 n4_2 VDD) g45p1svt w=(2.15e-07) l=4.5e-08 nf=1 \
        as=3.44e-14 ad=2.58e-14 ps=7.5e-07 pd=6.7e-07 nrd=1.16667 \
        nrs=1.16667 sa=5.40465e-07 sb=5.7e-07 sd=160n sca=21.1782 \
        scb=0.0203295 scc=0.00208843 m=(1)
PM3 (n4_2 \3\:SI2 \62\:VDD VDD) g45p1svt w=(2.15e-07) l=4.5e-08 nf=1 \
        as=2.58e-14 ad=1.001e-13 ps=6.7e-07 pd=1.75e-06 nrd=1.16667 \
        nrs=1.16667 sa=7.05465e-07 sb=4.05e-07 sd=160n sca=21.1782 \
        scb=0.0203295 scc=0.00208843 m=(1)
PM0 (\6\:SEb_2 \12\:SE \62\:VDD VDD) g45p1svt w=(2.15e-07) l=4.5e-08 \
        nf=1 as=3.01e-14 ad=1.001e-13 ps=7.1e-07 pd=1.75e-06 nrd=1.16667 \
        nrs=1.16667 sa=9.70465e-07 sb=1.4e-07 sd=160n sca=21.1782 \
        scb=0.0203295 scc=0.00208843 m=(1)
mp50 (n8 \11\:qbint \104\:VDD VDD) g45p1svt w=(2.15e-07) l=4.5e-08 nf=1 \
        as=1.1192e-13 ad=3.01e-14 ps=1.9e-06 pd=7.1e-07 nrd=1.16667 \
        nrs=1.16667 sa=1.22e-06 sb=1.235e-06 sd=160n sca=29.9075 \
        scb=0.0247057 scc=0.00372713 m=(1)
mp51 (\4\:n30 \3\:Ckbb n8 VDD) g45p1svt w=(2.15e-07) l=4.5e-08 nf=1 \
        as=3.01e-14 ad=5.375e-14 ps=7.1e-07 pd=9.3e-07 nrd=1.16667 \
        nrs=1.16667 sa=1.035e-06 sb=1.42e-06 sd=160n sca=29.9075 \
        scb=0.0247057 scc=0.00372713 m=(1)
mp40 (\4\:n30 \3\:CKb \8\:mout VDD) g45p1svt w=(2.15e-07) l=4.5e-08 nf=1 \
        as=3.762e-14 ad=5.375e-14 ps=7.8e-07 pd=9.3e-07 nrd=1.16667 \
        nrs=1.16667 sa=7.4e-07 sb=1.715e-06 sd=160n sca=29.9075 \
        scb=0.0247057 scc=0.00372713 m=(1)
mp30 (\8\:mout \4\:n20 \101\:VDD VDD) g45p1svt w=(2.15e-07) l=4.5e-08 \
        nf=1 as=3.762e-14 ad=8.415e-14 ps=7.8e-07 pd=1.83e-06 nrd=1.16667 \
        nrs=1.16667 sa=1.935e-06 sb=5.2e-07 sd=160n sca=29.9075 \
        scb=0.0247057 scc=0.00372713 m=(1)
mp35 (\3\:n6 \6\:RN \101\:VDD VDD) g45p1svt w=(2.15e-07) l=4.5e-08 nf=1 \
        as=3.44e-14 ad=8.415e-14 ps=7.5e-07 pd=1.83e-06 nrd=1.16667 \
        nrs=1.16667 sa=2e-06 sb=3.05e-07 sd=160n sca=29.9075 scb=0.0247057 \
        scc=0.00372713 m=(1)
mp36 (\3\:n6 mout \98\:VDD VDD) g45p1svt w=(2.15e-07) l=4.5e-08 nf=1 \
        as=3.44e-14 ad=6.29e-14 ps=7.5e-07 pd=1.83e-06 nrd=1.16667 \
        nrs=1.16667 sa=2e-06 sb=1e-07 sd=160n sca=29.9075 scb=0.0247057 \
        scc=0.00372713 m=(1)
mp37 (\5\:n20 \6\:CKb n6 VDD) g45p1svt w=(2.15e-07) l=4.5e-08 nf=1 \
        as=3.44e-14 ad=3.01e-14 ps=7.5e-07 pd=7.1e-07 nrd=1.16667 \
        nrs=1.16667 sa=1.4e-07 sb=3.31047e-07 sd=160n sca=45.7906 \
        scb=0.0283307 scc=0.00588417 m=(1)
mp25 (\5\:n20 \6\:Ckbb \4\:Db VDD) g45p1svt w=(2.15e-07) l=4.5e-08 nf=1 \
        as=2.71e-14 ad=3.44e-14 ps=7.1e-07 pd=7.5e-07 nrd=1.16667 \
        nrs=1.16667 sa=1.26047e-07 sb=3.45e-07 sd=160n sca=45.7906 \
        scb=0.0283307 scc=0.00588417 m=(1)
mp11 (n2 \1\:D1 \94\:VDD VDD) g45p1svt w=(2.15e-07) l=4.5e-08 nf=1 \
        as=7.07e-14 ad=3.87e-14 ps=1.71e-06 pd=7.9e-07 nrd=1.16667 \
        nrs=1.16667 sa=1e-06 sb=1.10465e-07 sd=160n sca=21.1782 \
        scb=0.0203295 scc=0.00208843 m=(1)
mp12 (Db \1\:SE n2 VDD) g45p1svt w=(2.15e-07) l=4.5e-08 nf=1 as=3.44e-14 \
        ad=3.87e-14 ps=7.5e-07 pd=7.9e-07 nrd=1.16667 nrs=1.16667 \
        sa=3.35465e-07 sb=7.75e-07 sd=160n sca=21.1782 scb=0.0203295 \
        scc=0.00208843 m=(1)
mp14 (Db SEb n4 VDD) g45p1svt w=(2.15e-07) l=4.5e-08 nf=1 as=3.44e-14 \
        ad=2.58e-14 ps=7.5e-07 pd=6.7e-07 nrd=1.16667 nrs=1.16667 \
        sa=5.40465e-07 sb=5.7e-07 sd=160n sca=21.1782 scb=0.0203295 \
        scc=0.00208843 m=(1)
mp13 (n4 \3\:SI1 \91\:VDD VDD) g45p1svt w=(2.15e-07) l=4.5e-08 nf=1 \
        as=2.58e-14 ad=1.001e-13 ps=6.7e-07 pd=1.75e-06 nrd=1.16667 \
        nrs=1.16667 sa=7.05465e-07 sb=4.05e-07 sd=160n sca=21.1782 \
        scb=0.0203295 scc=0.00208843 m=(1)
mp10 (\6\:SEb \5\:SE \91\:VDD VDD) g45p1svt w=(2.15e-07) l=4.5e-08 nf=1 \
        as=3.01e-14 ad=1.001e-13 ps=7.1e-07 pd=1.75e-06 nrd=1.16667 \
        nrs=1.16667 sa=9.70465e-07 sb=1.4e-07 sd=160n sca=21.1782 \
        scb=0.0203295 scc=0.00208843 m=(1)
mp56 (\8\:qint \10\:qbint \112\:VDD VDD) g45p1svt w=(2.15e-07) l=4.5e-08 \
        nf=1 as=1.0092e-13 ad=3.01e-14 ps=1.97e-06 pd=7.1e-07 nrd=1.16667 \
        nrs=1.16667 sa=5.4e-07 sb=1.4e-07 sd=160n sca=46.1789 \
        scb=0.0284493 scc=0.00588419 m=(1)
PM18 (\8\:qint_2 \10\:qbint_2 \83\:VDD VDD) g45p1svt w=(2.15e-07) \
        l=4.5e-08 nf=1 as=1.0092e-13 ad=3.01e-14 ps=1.97e-06 pd=7.1e-07 \
        nrd=1.16667 nrs=1.16667 sa=5.4e-07 sb=1.4e-07 sd=160n sca=45.7906 \
        scb=0.0283307 scc=0.00588417 m=(1)
PM36 (\8\:qint_3 \4\:qbint_3 \30\:VDD VDD) g45p1svt w=(2.15e-07) \
        l=4.5e-08 nf=1 as=1.0092e-13 ad=3.01e-14 ps=1.97e-06 pd=7.1e-07 \
        nrd=1.16667 nrs=1.16667 sa=1.4e-07 sb=5.4e-07 sd=160n sca=45.7906 \
        scb=0.0283307 scc=0.00588417 m=(1)
PM39 (\8\:qint_4 \4\:qbint_4 \1\:VDD VDD) g45p1svt w=(2.15e-07) \
        l=4.5e-08 nf=1 as=1.0092e-13 ad=3.01e-14 ps=1.97e-06 pd=7.1e-07 \
        nrd=1.16667 nrs=1.16667 sa=1.4e-07 sb=5.4e-07 sd=160n sca=46.1789 \
        scb=0.0284493 scc=0.00588419 m=(1)
PM43 (\16\:qbint_4 n30_4 \6\:VDD VDD) g45p1svt w=(3.1e-07) l=4.5e-08 \
        nf=1 as=4.96e-14 ad=1.4765e-13 ps=9.4e-07 pd=2.19e-06 nrd=1.16667 \
        nrs=1.16667 sa=7.65e-07 sb=1.28081e-06 sd=160n sca=35.6995 \
        scb=0.0234062 scc=0.00420468 m=(1)
PM44 (\16\:qbint_4 \27\:RN \20\:VDD VDD) g45p1svt w=(3.1e-07) l=4.5e-08 \
        nf=1 as=4.96e-14 ad=1.1192e-13 ps=9.4e-07 pd=1.9e-06 nrd=1.16667 \
        nrs=1.16667 sa=9.7e-07 sb=1.07581e-06 sd=160n sca=35.6995 \
        scb=0.0234062 scc=0.00420468 m=(1)
PM32 (\16\:qbint_3 n30_3 \36\:VDD VDD) g45p1svt w=(3.1e-07) l=4.5e-08 \
        nf=1 as=4.96e-14 ad=1.4765e-13 ps=9.4e-07 pd=2.19e-06 nrd=1.16667 \
        nrs=1.16667 sa=7.65e-07 sb=1.28081e-06 sd=160n sca=35.6995 \
        scb=0.0234062 scc=0.00420468 m=(1)
PM31 (\16\:qbint_3 \20\:RN \44\:VDD VDD) g45p1svt w=(3.1e-07) l=4.5e-08 \
        nf=1 as=4.96e-14 ad=1.1192e-13 ps=9.4e-07 pd=1.9e-06 nrd=1.16667 \
        nrs=1.16667 sa=9.7e-07 sb=1.07581e-06 sd=160n sca=35.6995 \
        scb=0.0234062 scc=0.00420468 m=(1)
PM14 (\15\:qbint_2 \3\:n30_2 \77\:VDD VDD) g45p1svt w=(3.1e-07) \
        l=4.5e-08 nf=1 as=4.96e-14 ad=1.4765e-13 ps=9.4e-07 pd=2.19e-06 \
        nrd=1.16667 nrs=1.16667 sa=7.65e-07 sb=1.28081e-06 sd=160n \
        sca=35.6995 scb=0.0234062 scc=0.00420468 m=(1)
PM13 (\15\:qbint_2 \10\:RN \75\:VDD VDD) g45p1svt w=(3.1e-07) l=4.5e-08 \
        nf=1 as=4.96e-14 ad=1.1192e-13 ps=9.4e-07 pd=1.9e-06 nrd=1.16667 \
        nrs=1.16667 sa=9.7e-07 sb=1.07581e-06 sd=160n sca=35.6995 \
        scb=0.0234062 scc=0.00420468 m=(1)
mp46 (\15\:qbint \3\:n30 \106\:VDD VDD) g45p1svt w=(3.1e-07) l=4.5e-08 \
        nf=1 as=4.96e-14 ad=1.4765e-13 ps=9.4e-07 pd=2.19e-06 nrd=1.16667 \
        nrs=1.16667 sa=7.65e-07 sb=1.28081e-06 sd=160n sca=35.6995 \
        scb=0.0234062 scc=0.00420468 m=(1)
mp45 (\15\:qbint \3\:RN \104\:VDD VDD) g45p1svt w=(3.1e-07) l=4.5e-08 \
        nf=1 as=4.96e-14 ad=1.1192e-13 ps=9.4e-07 pd=1.9e-06 nrd=1.16667 \
        nrs=1.16667 sa=9.7e-07 sb=1.07581e-06 sd=160n sca=35.6995 \
        scb=0.0234062 scc=0.00420468 m=(1)
ends SPDFF4RX2
// End of subcircuit definition.
