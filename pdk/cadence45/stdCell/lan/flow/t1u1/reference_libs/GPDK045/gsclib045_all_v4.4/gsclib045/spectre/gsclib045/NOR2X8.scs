// gsclib045/NOR2X8/schematic

simulator lang=spectre

subckt NOR2X8 A B Y VSS VDD
mn1 (Y B VSS VSS) g45n1svt w=(2.065u) l=45n nf=1 m=(1)
mn0 (Y A VSS VSS) g45n1svt w=(2.065u) l=45n nf=1 m=(1)
mp1 (Y B net41 VDD) g45p1svt w=(3.115u) l=45n nf=1 m=(1)
mp0 (net41 A VDD VDD) g45p1svt w=(3.115u) l=45n nf=1 m=(1)
ends NOR2X8
