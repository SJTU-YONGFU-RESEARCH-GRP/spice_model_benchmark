// Generated for: spectre (May  1 09:16:06 2013 )
// Library name: gsclib045_hvt
// Cell name: SDFFTRXL
// View name: extracted

simulator lang=spectre

subckt SDFFTRXL CK D Q QN RN SE SI VDD VSS
mp57 (\1\:QN \4\:net436 \22\:VDD VDD) g45p1hvt w=(2.15e-07) l=4.5e-08 \
        nf=1 as=3.44e-14 ad=3.548e-14 ps=7.5e-07 pd=7.6e-07 nrd=1.16667 \
        nrs=1.16667 sa=1.65e-07 sb=3.45e-07 sd=160n sca=49.5197 \
        scb=0.0328493 scc=0.0059298 m=(1)
mp56 (\5\:net436 \6\:qbint \22\:VDD VDD) g45p1hvt w=(2.15e-07) l=4.5e-08 \
        nf=1 as=3.44e-14 ad=3.01e-14 ps=7.5e-07 pd=7.1e-07 nrd=1.16667 \
        nrs=1.16667 sa=3.7e-07 sb=1.4e-07 sd=160n sca=47.0806 \
        scb=0.0291408 scc=0.00588526 m=(1)
mp55 (\3\:Q qbint \20\:VDD VDD) g45p1hvt w=(2.15e-07) l=4.5e-08 nf=1 \
        as=4.408e-14 ad=4.837e-14 ps=8.4e-07 pd=8.8e-07 nrd=1.16667 \
        nrs=1.16667 sa=2.25e-07 sb=4.35e-07 sd=160n sca=12.1244 \
        scb=0.0107968 scc=0.000332109 m=(1)
mp20 (\15\:CKb \1\:CK \20\:VDD VDD) g45p1hvt w=(2.15e-07) l=4.5e-08 nf=1 \
        as=4.407e-14 ad=3.977e-14 ps=8.4e-07 pd=8e-07 nrd=1.16667 \
        nrs=1.16667 sa=4.75e-07 sb=1.85e-07 sd=160n sca=12.1244 \
        scb=0.0107968 scc=0.000332109 m=(1)
mp45 (\15\:qbint n30 \18\:VDD VDD) g45p1hvt w=(2.15e-07) l=4.5e-08 nf=1 \
        as=7.61e-14 ad=3.01e-14 ps=1.35e-06 pd=7.1e-07 nrd=1.16667 \
        nrs=1.16667 sa=1.4e-07 sb=1.825e-06 sd=160n sca=27.1298 \
        scb=0.023603 scc=0.0032399 m=(1)
mp50 (net395 \7\:qbint \18\:VDD VDD) g45p1hvt w=(2.15e-07) l=4.5e-08 \
        nf=1 as=7.61e-14 ad=5.483e-14 ps=1.35e-06 pd=9.4e-07 nrd=1.16667 \
        nrs=1.16667 sa=4.05e-07 sb=1.56e-06 sd=160n sca=27.1298 \
        scb=0.023603 scc=0.0032399 m=(1)
mp51 (\7\:n30 \3\:CKbb net395 VDD) g45p1hvt w=(2.15e-07) l=4.5e-08 nf=1 \
        as=5.482e-14 ad=3.44e-14 ps=9.4e-07 pd=7.5e-07 nrd=1.16667 \
        nrs=1.16667 sa=7.05e-07 sb=1.26e-06 sd=160n sca=27.1298 \
        scb=0.023603 scc=0.0032399 m=(1)
mp40 (\7\:n30 \3\:CKb \8\:mout VDD) g45p1hvt w=(2.15e-07) l=4.5e-08 nf=1 \
        as=3.87e-14 ad=3.44e-14 ps=7.9e-07 pd=7.5e-07 nrd=1.16667 \
        nrs=1.16667 sa=9.1e-07 sb=1.055e-06 sd=160n sca=27.1298 \
        scb=0.023603 scc=0.0032399 m=(1)
mp30 (\8\:mout \3\:n20 \16\:VDD VDD) g45p1hvt w=(2.15e-07) l=4.5e-08 \
        nf=1 as=1.037e-13 ad=3.87e-14 ps=1.81e-06 pd=7.9e-07 nrd=1.16667 \
        nrs=1.16667 sa=1.135e-06 sb=8.3e-07 sd=160n sca=27.1298 \
        scb=0.023603 scc=0.0032399 m=(1)
mp35 (net375 mout \16\:VDD VDD) g45p1hvt w=(2.15e-07) l=4.5e-08 nf=1 \
        as=1.037e-13 ad=1.29e-14 ps=1.81e-06 pd=5.5e-07 nrd=1.16667 \
        nrs=1.16667 sa=1.4e-06 sb=5.65e-07 sd=160n sca=27.1298 \
        scb=0.023603 scc=0.0032399 m=(1)
mp36 (\4\:n20 \8\:CKb net375 VDD) g45p1hvt w=(2.15e-07) l=4.5e-08 nf=1 \
        as=1.29e-14 ad=3.87e-14 ps=5.5e-07 pd=7.9e-07 nrd=1.16667 \
        nrs=1.16667 sa=1.505e-06 sb=4.6e-07 sd=160n sca=27.1298 \
        scb=0.023603 scc=0.0032399 m=(1)
mp25 (\4\:n20 \6\:CKbb \4\:Dbp VDD) g45p1hvt w=(2.15e-07) l=4.5e-08 nf=1 \
        as=5.052e-14 ad=3.87e-14 ps=9e-07 pd=7.9e-07 nrd=1.16667 \
        nrs=1.16667 sa=1.73e-06 sb=2.35e-07 sd=160n sca=27.1298 \
        scb=0.023603 scc=0.0032399 m=(1)
mp21 (\8\:CKbb \9\:CKb \14\:VDD VDD) g45p1hvt w=(2.15e-07) l=4.5e-08 \
        nf=1 as=3.44e-14 ad=3.01e-14 ps=7.5e-07 pd=7.1e-07 nrd=1.16667 \
        nrs=1.16667 sa=1.4e-07 sb=7.7e-07 sd=160n sca=11.0038 \
        scb=0.00893072 scc=0.000173706 m=(1)
mp12 (net411 \4\:SI \14\:VDD VDD) g45p1hvt w=(2.15e-07) l=4.5e-08 nf=1 \
        as=3.44e-14 ad=3.762e-14 ps=7.5e-07 pd=7.8e-07 nrd=1.16667 \
        nrs=1.16667 sa=3.45e-07 sb=5.65e-07 sd=160n sca=11.0038 \
        scb=0.00893072 scc=0.000173706 m=(1)
mp13 (\6\:Dbp SEb net411 VDD) g45p1hvt w=(2.15e-07) l=4.5e-08 nf=1 \
        as=3.762e-14 ad=3.44e-14 ps=7.8e-07 pd=7.5e-07 nrd=1.16667 \
        nrs=1.16667 sa=5.65e-07 sb=3.45e-07 sd=160n sca=11.0038 \
        scb=0.00893072 scc=0.000173706 m=(1)
mp11 (\6\:Dbp \7\:SE \5\:Db VDD) g45p1hvt w=(2.15e-07) l=4.5e-08 nf=1 \
        as=3.01e-14 ad=3.44e-14 ps=7.1e-07 pd=7.5e-07 nrd=1.16667 \
        nrs=1.16667 sa=7.7e-07 sb=1.4e-07 sd=160n sca=11.0038 \
        scb=0.00893072 scc=0.000173706 m=(1)
mp10 (\5\:SEb \6\:SE \12\:VDD VDD) g45p1hvt w=(2.15e-07) l=4.5e-08 nf=1 \
        as=9.44e-14 ad=3.01e-14 ps=1.56e-06 pd=7.1e-07 nrd=1.16667 \
        nrs=1.16667 sa=1.4e-07 sb=7.1e-07 sd=160n sca=21.9815 \
        scb=0.0208641 scc=0.00225088 m=(1)
mp0 (\3\:Db \1\:RN \12\:VDD VDD) g45p1hvt w=(2.15e-07) l=4.5e-08 nf=1 \
        as=9.44e-14 ad=4.3e-14 ps=1.56e-06 pd=8.3e-07 nrd=1.16667 \
        nrs=1.16667 sa=4.65e-07 sb=3.85e-07 sd=160n sca=22.1877 \
        scb=0.0209143 scc=0.00225089 m=(1)
mp1 (\3\:Db \4\:D \1\:VDD VDD) g45p1hvt w=(2.15e-07) l=4.5e-08 nf=1 \
        as=3.01e-14 ad=4.3e-14 ps=7.1e-07 pd=8.3e-07 nrd=1.16667 \
        nrs=1.16667 sa=7.1e-07 sb=1.4e-07 sd=160n sca=23.1737 \
        scb=0.0215726 scc=0.00225171 m=(1)
C1 (D VSS) capacitor c=8.98133e-17
C2 (SI VSS) capacitor c=2.65242e-17
C3 (RN VSS) capacitor c=2.88003e-17
C4 (VDD VSS) capacitor c=3.32087e-16
C5 (CK VSS) capacitor c=7.29533e-17
C6 (Q VSS) capacitor c=4.71238e-17
C7 (QN VSS) capacitor c=2.20786e-17
C8 (SE VSS) capacitor c=2.6291e-17
C9 (net436 VSS) capacitor c=2.08137e-17
C10 (qbint VSS) capacitor c=4.27413e-17
C11 (CKb VSS) capacitor c=4.60968e-17
C12 (n30 VSS) capacitor c=5.02332e-17
C13 (net460 VSS) capacitor c=4.17447e-18
C14 (mout VSS) capacitor c=7.63246e-17
C15 (CKbb VSS) capacitor c=2.25269e-17
C16 (n20 VSS) capacitor c=3.98549e-17
C17 (Dbp VSS) capacitor c=1.04148e-16
C18 (Db VSS) capacitor c=1.26017e-16
C19 (SEb VSS) capacitor c=4.14851e-17
C20 (net395 VSS) capacitor c=4.07614e-18
C21 (net375 VSS) capacitor c=4.79291e-20
C22 (\4\:D VSS) capacitor c=3.37545e-17
C23 (\1\:RN VSS) capacitor c=4.39077e-17
C24 (\6\:SE VSS) capacitor c=2.7824e-17
C25 (\7\:SE VSS) capacitor c=3.81274e-17
C26 (\4\:SI VSS) capacitor c=4.59873e-17
C27 (\9\:CKb VSS) capacitor c=5.0594e-17
C28 (\6\:CKbb VSS) capacitor c=4.65109e-17
C29 (\8\:CKb VSS) capacitor c=5.85682e-17
C30 (\3\:n20 VSS) capacitor c=3.71361e-17
C31 (\3\:CKb VSS) capacitor c=5.34695e-17
C32 (\3\:CKbb VSS) capacitor c=4.53365e-17
C33 (\7\:qbint VSS) capacitor c=4.26357e-17
C34 (\1\:CK VSS) capacitor c=3.0729e-17
C35 (\6\:qbint VSS) capacitor c=2.79789e-17
C36 (\4\:net436 VSS) capacitor c=3.15371e-17
C37 (\3\:D VSS) capacitor c=3.05906e-17
C38 (\3\:RN VSS) capacitor c=3.26255e-17
C39 (\1\:SE VSS) capacitor c=3.04012e-17
C40 (\3\:SEb VSS) capacitor c=3.66068e-17
C41 (\5\:SE VSS) capacitor c=6.27555e-17
C42 (\1\:SI VSS) capacitor c=5.2279e-17
C43 (\5\:CKb VSS) capacitor c=3.34714e-17
C44 (\10\:CKb VSS) capacitor c=3.01798e-17
C45 (\4\:CKbb VSS) capacitor c=8.09507e-17
C46 (\3\:mout VSS) capacitor c=5.29132e-17
C47 (\10\:qbint VSS) capacitor c=3.86338e-17
C48 (\2\:n30 VSS) capacitor c=4.03489e-17
C49 (\3\:CK VSS) capacitor c=3.77994e-17
C50 (\5\:qbint VSS) capacitor c=2.11506e-17
C51 (\4\:qbint VSS) capacitor c=2.70819e-17
C52 (\3\:net436 VSS) capacitor c=3.05473e-17
C53 (\1\:D VSS) capacitor c=1.75664e-17
C54 (\2\:RN VSS) capacitor c=4.32635e-17
C55 (\2\:SE VSS) capacitor c=3.198e-17
C56 (\4\:SEb VSS) capacitor c=4.77305e-17
C57 (\2\:SEb VSS) capacitor c=4.20809e-17
C58 (\3\:SI VSS) capacitor c=2.63864e-17
C59 (\7\:CKbb VSS) capacitor c=4.25044e-17
C60 (\11\:CKb VSS) capacitor c=3.20239e-17
C61 (\5\:CKbb VSS) capacitor c=2.98417e-17
C62 (\2\:mout VSS) capacitor c=5.30355e-17
C63 (\2\:n20 VSS) capacitor c=4.30475e-17
C64 (\4\:CKb VSS) capacitor c=2.11792e-17
C65 (\2\:CKbb VSS) capacitor c=4.5628e-17
C66 (\2\:CKb VSS) capacitor c=3.03549e-17
C67 (\9\:qbint VSS) capacitor c=5.1764e-17
C68 (\3\:n30 VSS) capacitor c=2.29256e-17
C69 (\2\:CK VSS) capacitor c=3.63549e-17
C70 (\2\:qbint VSS) capacitor c=4.79849e-17
C71 (\1\:VDD VSS) capacitor c=3.6969e-17
C72 (\3\:Db VSS) capacitor c=2.03636e-16
C73 (\12\:VDD VSS) capacitor c=2.21364e-17
C74 (\5\:SEb VSS) capacitor c=1.00942e-16
C75 (\5\:Db VSS) capacitor c=1.32219e-16
C76 (\6\:Dbp VSS) capacitor c=4.54631e-17
C77 (\14\:VDD VSS) capacitor c=3.8682e-17
C78 (\8\:CKbb VSS) capacitor c=8.48824e-17
C79 (\4\:Dbp VSS) capacitor c=1.04835e-16
C80 (\4\:n20 VSS) capacitor c=3.19627e-17
C81 (\16\:VDD VSS) capacitor c=8.41131e-18
C82 (\8\:mout VSS) capacitor c=4.0655e-17
C83 (\7\:n30 VSS) capacitor c=7.06971e-17
C84 (\18\:VDD VSS) capacitor c=3.11569e-17
C85 (\15\:qbint VSS) capacitor c=4.41722e-17
C86 (\15\:CKb VSS) capacitor c=1.04715e-16
C87 (\20\:VDD VSS) capacitor c=2.61497e-17
C88 (\3\:Q VSS) capacitor c=4.91226e-17
C89 (\5\:net436 VSS) capacitor c=3.45705e-17
C90 (\22\:VDD VSS) capacitor c=3.66927e-17
C91 (\1\:QN VSS) capacitor c=1.97875e-17
C92 (\3\:VDD VSS) capacitor c=7.17098e-17
C93 (\7\:SEb VSS) capacitor c=1.623e-16
C94 (\7\:Db VSS) capacitor c=1.32873e-16
C95 (\14\:CKbb VSS) capacitor c=4.14233e-17
C96 (\8\:Dbp VSS) capacitor c=6.90223e-17
C97 (\8\:n20 VSS) capacitor c=5.97262e-17
C98 (\6\:mout VSS) capacitor c=3.73598e-17
C99 (\5\:n30 VSS) capacitor c=9.13568e-17
C100 (\13\:qbint VSS) capacitor c=9.98903e-17
C101 (\19\:CKb VSS) capacitor c=6.40154e-17
C102 (\1\:Q VSS) capacitor c=7.2366e-17
C103 (\9\:net436 VSS) capacitor c=2.82431e-17
C104 (\3\:QN VSS) capacitor c=3.41876e-17
C105 (\2\:net436 VSS) capacitor c=1.2445e-17
C106 (\3\:qbint VSS) capacitor c=3.82894e-17
C107 (\6\:CKb VSS) capacitor c=6.51832e-17
C108 (\7\:CKb VSS) capacitor c=7.1774e-17
C109 (\2\:SI VSS) capacitor c=3.53319e-17
C110 (\3\:SE VSS) capacitor c=2.50255e-17
C111 (\4\:SE VSS) capacitor c=8.65174e-17
C112 (\7\:net436 VSS) capacitor c=2.95113e-17
C113 (\8\:net436 VSS) capacitor c=2.97844e-17
C114 (\2\:D VSS) capacitor c=2.50996e-17
C115 (\4\:CK VSS) capacitor c=3.04272e-17
C116 (\11\:qbint VSS) capacitor c=3.36171e-17
C117 (\12\:qbint VSS) capacitor c=2.93581e-17
C118 (\17\:qbint VSS) capacitor c=9.02144e-17
C119 (\4\:n30 VSS) capacitor c=7.91282e-17
C120 (\4\:mout VSS) capacitor c=5.38389e-17
C121 (\5\:mout VSS) capacitor c=5.14224e-17
C122 (\12\:CKb VSS) capacitor c=1.64056e-17
C123 (\13\:CKb VSS) capacitor c=6.19298e-17
C124 (\14\:CKb VSS) capacitor c=8.9717e-17
C125 (\17\:CKb VSS) capacitor c=6.14e-17
C126 (\18\:CKb VSS) capacitor c=4.92648e-17
C127 (\6\:n20 VSS) capacitor c=6.13693e-17
C128 (\7\:n20 VSS) capacitor c=5.07428e-17
C129 (\10\:CKbb VSS) capacitor c=1.3287e-16
C130 (\11\:CKbb VSS) capacitor c=6.2803e-17
C131 (\12\:CKbb VSS) capacitor c=9.07828e-17
C132 (\13\:CKbb VSS) capacitor c=1.13122e-16
C133 (\16\:CKbb VSS) capacitor c=2.56444e-17
C134 (\5\:SI VSS) capacitor c=7.53984e-17
C135 (\3\:Dbp VSS) capacitor c=1.19506e-16
C136 (\9\:SEb VSS) capacitor c=1.61695e-16
C137 (\10\:SEb VSS) capacitor c=5.96621e-17
C138 (\8\:SE VSS) capacitor c=1.05467e-16
C139 (\4\:RN VSS) capacitor c=5.74762e-17
C140 (\5\:D VSS) capacitor c=3.8344e-17
C141 (\5\:VDD VSS) capacitor c=2.30049e-17
C142 (\6\:VDD VSS) capacitor c=3.35625e-17
C143 (\8\:VDD VSS) capacitor c=3.18872e-17
C144 (\9\:VDD VSS) capacitor c=3.1542e-17
C145 (\11\:VDD VSS) capacitor c=1.07716e-17
Rk43 (D \5\:D) resistor r=0.1291 c=0
Rk33 (\5\:SI SI) resistor r=0.03534 c=0
Rk42 (RN \4\:RN) resistor r=0.1263 c=0
Rk47 (\2\:VDD \4\:VDD) resistor r=0.52 c=0
Rk48 (\4\:VDD \5\:VDD) resistor r=0.1301 c=0
Rk49 (\5\:VDD \6\:VDD) resistor r=0.606 c=0
Rk50 (\6\:VDD \7\:VDD) resistor r=0.2654 c=0
Rk51 (\7\:VDD \8\:VDD) resistor r=0.2679 c=0
Rk52 (\8\:VDD \9\:VDD) resistor r=0.5133 c=0
Rk53 (\9\:VDD \10\:VDD) resistor r=0.4211 c=0
Rk55 (\11\:VDD VDD) resistor r=0.2025 c=0
Rk54 (\10\:VDD \11\:VDD) resistor r=0.3484 c=0
Rk56 (\5\:VDD \13\:VDD) resistor r=0.1795 c=0
Rk57 (\6\:VDD \15\:VDD) resistor r=0.2624 c=0
Rk58 (\8\:VDD \17\:VDD) resistor r=0.07334 c=0
Rk59 (\9\:VDD \19\:VDD) resistor r=0.2214 c=0
Rk60 (\10\:VDD \21\:VDD) resistor r=0.3351 c=0
Rk61 (\11\:VDD \23\:VDD) resistor r=0.4151 c=0
Rk8 (CK \4\:CK) resistor r=0.08095 c=0
Rk6 (\2\:Q Q) resistor r=0.2325 c=0
Rk7 (Q \4\:Q) resistor r=0.1766 c=0
Rk2 (\4\:QN QN) resistor r=0.08313 c=0
Rk1 (\2\:QN \4\:QN) resistor r=0.2241 c=0
Rk62 (\2\:VSS \3\:VSS) resistor r=0.0875 c=0
Rk63 (\3\:VSS \4\:VSS) resistor r=0.6336 c=0
Rk64 (\4\:VSS \5\:VSS) resistor r=0.2804 c=0
Rk65 (\5\:VSS \6\:VSS) resistor r=0.2519 c=0
Rk66 (\6\:VSS \7\:VSS) resistor r=0.5114 c=0
Rk67 (\7\:VSS \8\:VSS) resistor r=0.4349 c=0
Rk68 (\3\:VSS \10\:VSS) resistor r=0.293 c=0
Rk69 (\4\:VSS \12\:VSS) resistor r=0.2204 c=0
Rk70 (\6\:VSS \14\:VSS) resistor r=0.04326 c=0
Rk71 (\7\:VSS \16\:VSS) resistor r=0.04326 c=0
Rk73 (\17\:VSS VSS) resistor r=0.2176 c=0
Rk72 (\8\:VSS \17\:VSS) resistor r=0.3337 c=0
Rk74 (\8\:VSS \19\:VSS) resistor r=0.1194 c=0
Rk75 (\17\:VSS \21\:VSS) resistor r=0.07334 c=0
Rk41 (SE \8\:SE) resistor r=0.04113 c=0
Rk3 (\6\:net436 \7\:net436) resistor r=0.1174 c=0
Rk4 (\7\:net436 \8\:net436) resistor r=0.119 c=0
Rk5 (\7\:net436 \10\:net436) resistor r=0.1055 c=0
Rk9 (\11\:qbint \12\:qbint) resistor r=0.1776 c=0
Rk10 (\12\:qbint \14\:qbint) resistor r=0.1202 c=0
Rk11 (\12\:qbint \16\:qbint) resistor r=0.2251 c=0
Rk12 (\14\:qbint \17\:qbint) resistor r=0.7298 c=0
Rk18 (\12\:CKb \13\:CKb) resistor r=0.05038 c=0
Rk19 (\13\:CKb \14\:CKb) resistor r=0.2996 c=0
Rk20 (\14\:CKb \16\:CKb) resistor r=0.5266 c=0
Rk21 (\13\:CKb \17\:CKb) resistor r=0.515 c=0
Rk22 (\14\:CKb \18\:CKb) resistor r=0.3162 c=0
Rk23 (\16\:CKb \20\:CKb) resistor r=0.4107 c=0
Rk13 (\4\:n30 \6\:n30) resistor r=0.4506 c=0
Rk14 (\6\:n30 \8\:n30) resistor r=0.4269 c=0
Rk15 (\4\:mout \5\:mout) resistor r=0.2403 c=0
Rk16 (\5\:mout \7\:mout) resistor r=0.1339 c=0
Rk17 (\5\:mout \9\:mout) resistor r=0.2297 c=0
Rk27 (\9\:CKbb \10\:CKbb) resistor r=0.5477 c=0
Rk28 (\10\:CKbb \11\:CKbb) resistor r=0.4234 c=0
Rk29 (\11\:CKbb \12\:CKbb) resistor r=0.2125 c=0
Rk30 (\12\:CKbb \13\:CKbb) resistor r=0.7399 c=0
Rk31 (\11\:CKbb \15\:CKbb) resistor r=0.2495 c=0
Rk32 (\12\:CKbb \16\:CKbb) resistor r=0.04286 c=0
Rk24 (\5\:n20 \6\:n20) resistor r=0.1244 c=0
Rk25 (\6\:n20 \7\:n20) resistor r=0.257 c=0
Rk26 (\6\:n20 \9\:n20) resistor r=0.1998 c=0
Rk34 (\2\:Dbp \3\:Dbp) resistor r=0.6709 c=0
Rk35 (\3\:Dbp \5\:Dbp) resistor r=0.4263 c=0
Rk36 (\3\:Dbp \7\:Dbp) resistor r=0.2392 c=0
Rk37 (\5\:Dbp \9\:Dbp) resistor r=0.395 c=0
Rk44 (\2\:Db \4\:Db) resistor r=1.1956 c=0
Rk45 (\4\:Db \6\:Db) resistor r=0.7797 c=0
Rk46 (\6\:Db \8\:Db) resistor r=0.7843 c=0
Rk38 (\6\:SEb \8\:SEb) resistor r=0.5275 c=0
Rk39 (\8\:SEb \9\:SEb) resistor r=0.8721 c=0
Rk40 (\9\:SEb \10\:SEb) resistor r=0.3236 c=0
Rl47 (\2\:D \4\:D) resistor r=78.5603 c=0
Rl46 (\2\:D \3\:D) resistor r=84.3295 c=0
Rl45 (\1\:D \2\:D) resistor r=15.4894 c=0
Rl34 (\2\:SI \4\:SI) resistor r=102.726 c=0
Rl32 (\1\:SI \2\:SI) resistor r=154.496 c=0
Rl33 (\2\:SI \3\:SI) resistor r=3.1183 c=0
Rl43 (\1\:RN \2\:RN) resistor r=95.3867 c=0
Rl44 (\2\:RN \3\:RN) resistor r=47.3097 c=0
Rl9 (\1\:CK \2\:CK) resistor r=68.4636 c=0
Rl10 (\2\:CK \3\:CK) resistor r=93.4636 c=0
Rl37 (\1\:SE \2\:SE) resistor r=69.0258 c=0
Rl41 (\3\:SE \6\:SE) resistor r=63.143 c=0
Rl38 (\2\:SE \3\:SE) resistor r=17.6971 c=0
Rl42 (\4\:SE \7\:SE) resistor r=124.681 c=0
Rl40 (\4\:SE \5\:SE) resistor r=180.313 c=0
Rl39 (\3\:SE \4\:SE) resistor r=208.082 c=0
Rl3 (\2\:net436 \4\:net436) resistor r=49.7141 c=0
Rl2 (\2\:net436 \3\:net436) resistor r=34.3295 c=0
Rl1 (net436 \2\:net436) resistor r=2.0213 c=0
Rl4 (qbint \2\:qbint) resistor r=131.502 c=0
Rl7 (\2\:qbint \5\:qbint) resistor r=24.7951 c=0
Rl8 (\3\:qbint \6\:qbint) resistor r=58.8489 c=0
Rl6 (\3\:qbint \4\:qbint) resistor r=30.0028 c=0
Rl5 (\2\:qbint \3\:qbint) resistor r=177.761 c=0
Rl13 (\7\:qbint \8\:qbint) resistor r=108.895 c=0
Rl15 (\8\:qbint \10\:qbint) resistor r=34.3295 c=0
Rl14 (\8\:qbint \9\:qbint) resistor r=0.5166 c=0
Rl31 (\8\:CKb \11\:CKb) resistor r=24.2328 c=0
Rl19 (\3\:CKb \4\:CKb) resistor r=58.8482 c=0
Rl16 (CKb \2\:CKb) resistor r=39.6174 c=0
Rl29 (\6\:CKb \9\:CKb) resistor r=160.998 c=0
Rl26 (\5\:CKb \6\:CKb) resistor r=99.845 c=0
Rl28 (\7\:CKb \8\:CKb) resistor r=139.928 c=0
Rl30 (\7\:CKb \10\:CKb) resistor r=45.8353 c=0
Rl27 (\6\:CKb \7\:CKb) resistor r=193.595 c=0
Rl11 (n30 \2\:n30) resistor r=142.308 c=0
Rl12 (\2\:n30 \3\:n30) resistor r=29.5379 c=0
Rl22 (mout \2\:mout) resistor r=87.2302 c=0
Rl23 (\2\:mout \3\:mout) resistor r=29.5379 c=0
Rl25 (\6\:CKbb \7\:CKbb) resistor r=24.2328 c=0
Rl24 (\4\:CKbb \5\:CKbb) resistor r=71.8456 c=0
Rl18 (\2\:CKbb \3\:CKbb) resistor r=104.695 c=0
Rl17 (CKbb \2\:CKbb) resistor r=27.9704 c=0
Rl21 (\2\:n20 \3\:n20) resistor r=38.085 c=0
Rl20 (n20 \2\:n20) resistor r=89.6174 c=0
Rl36 (\3\:SEb \4\:SEb) resistor r=68.4636 c=0
Rl35 (SEb \2\:SEb) resistor r=73.7687 c=0
Rz15 (\3\:VDD \4\:VDD) resistor r=9.375 c=0
Rz16 (\3\:VDD \7\:VDD) resistor r=6.25 c=0
Rz17 (\3\:VDD \10\:VDD) resistor r=6.25 c=0
Rz3 (\1\:Q \2\:Q) resistor r=75 c=0
Rz1 (\3\:QN \4\:QN) resistor r=75 c=0
Rz18 (\9\:VSS \10\:VSS) resistor r=75 c=0
Rz19 (\11\:VSS \12\:VSS) resistor r=75 c=0
Rz20 (\13\:VSS \14\:VSS) resistor r=75 c=0
Rz21 (\15\:VSS \16\:VSS) resistor r=75 c=0
Rz22 (\18\:VSS \19\:VSS) resistor r=75 c=0
Rz23 (\20\:VSS \21\:VSS) resistor r=75 c=0
Rz2 (\9\:net436 \10\:net436) resistor r=75 c=0
Rz4 (\13\:qbint \14\:qbint) resistor r=75 c=0
Rz7 (\19\:CKb \20\:CKb) resistor r=75 c=0
Rz5 (\5\:n30 \6\:n30) resistor r=75 c=0
Rz6 (\6\:mout \7\:mout) resistor r=75 c=0
Rz9 (\14\:CKbb \15\:CKbb) resistor r=75 c=0
Rz8 (\8\:n20 \9\:n20) resistor r=75 c=0
Rz10 (Dbp \2\:Dbp) resistor r=75 c=0
Rz11 (\8\:Dbp \9\:Dbp) resistor r=75 c=0
Rz13 (Db \2\:Db) resistor r=75 c=0
Rz14 (\7\:Db \8\:Db) resistor r=75 c=0
Rz12 (\7\:SEb \8\:SEb) resistor r=75 c=0
Ry15 (\1\:VDD \2\:VDD) resistor r=62 c=0
Ry16 (\12\:VDD \13\:VDD) resistor r=62 c=0
Ry17 (\14\:VDD \15\:VDD) resistor r=62 c=0
Ry18 (\16\:VDD \17\:VDD) resistor r=62 c=0
Ry19 (\18\:VDD \19\:VDD) resistor r=62 c=0
Ry20 (\20\:VDD \21\:VDD) resistor r=62 c=0
Ry21 (\22\:VDD \23\:VDD) resistor r=62 c=0
Ry3 (\3\:Q \4\:Q) resistor r=62 c=0
Ry1 (\1\:QN \2\:QN) resistor r=62 c=0
Ry22 (\1\:VSS \2\:VSS) resistor r=7.75 c=0
Ry23 (\1\:VSS \5\:VSS) resistor r=5.1667 c=0
Ry24 (\1\:VSS \8\:VSS) resistor r=5.1667 c=0
Ry2 (\5\:net436 \6\:net436) resistor r=62 c=0
Ry4 (\15\:qbint \16\:qbint) resistor r=62 c=0
Ry7 (\15\:CKb \16\:CKb) resistor r=62 c=0
Ry5 (\7\:n30 \8\:n30) resistor r=62 c=0
Ry6 (\8\:mout \9\:mout) resistor r=62 c=0
Ry9 (\8\:CKbb \9\:CKbb) resistor r=62 c=0
Ry8 (\4\:n20 \5\:n20) resistor r=62 c=0
Ry10 (\4\:Dbp \5\:Dbp) resistor r=62 c=0
Ry11 (\6\:Dbp \7\:Dbp) resistor r=62 c=0
Ry13 (\3\:Db \4\:Db) resistor r=62 c=0
Ry14 (\5\:Db \6\:Db) resistor r=62 c=0
Ry12 (\5\:SEb \6\:SEb) resistor r=62 c=0
Rx19 (\1\:D \5\:D) resistor r=45 c=0
Rx14 (\3\:SI \5\:SI) resistor r=45 c=0
Rx18 (\2\:RN \4\:RN) resistor r=45 c=0
Rx2 (\2\:CK \4\:CK) resistor r=45 c=0
Rx17 (\2\:SE \8\:SE) resistor r=45 c=0
Rx1 (net436 \8\:net436) resistor r=45 c=0
Rx3 (\9\:qbint \11\:qbint) resistor r=45 c=0
Rx4 (\2\:qbint \17\:qbint) resistor r=45 c=0
Rx7 (\4\:CKb \12\:CKb) resistor r=45 c=0
Rx8 (\11\:CKb \17\:CKb) resistor r=45 c=0
Rx9 (\2\:CKb \18\:CKb) resistor r=45 c=0
Rx5 (\3\:n30 \4\:n30) resistor r=45 c=0
Rx6 (\2\:mout \4\:mout) resistor r=45 c=0
Rx11 (\7\:CKbb \10\:CKbb) resistor r=45 c=0
Rx12 (\2\:CKbb \13\:CKbb) resistor r=45 c=0
Rx13 (\5\:CKbb \16\:CKbb) resistor r=45 c=0
Rx10 (\2\:n20 \7\:n20) resistor r=45 c=0
Rx15 (\4\:SEb \9\:SEb) resistor r=45 c=0
Rx16 (\2\:SEb \10\:SEb) resistor r=45 c=0
mn57 (\3\:QN \3\:net436 \20\:VSS VSS) g45n1hvt w=(1.45e-07) l=4.5e-08 \
        nf=1 as=5.335e-14 ad=2.393e-14 ps=1.62e-06 pd=6.2e-07 nrd=1.16667 \
        nrs=1.16667 sa=1.65e-07 sb=3.45e-07 sd=160n sca=23.279 \
        scb=0.0230742 scc=0.00267719 m=(1)
mn56 (\9\:net436 \4\:qbint \20\:VSS VSS) g45n1hvt w=(1.45e-07) l=4.5e-08 \
        nf=1 as=5.335e-14 ad=2.03e-14 ps=1.62e-06 pd=5.7e-07 nrd=1.16667 \
        nrs=1.16667 sa=3.7e-07 sb=1.4e-07 sd=160n sca=23.279 scb=0.0230742 \
        scc=0.00267719 m=(1)
mn55 (\1\:Q \5\:qbint \18\:VSS VSS) g45n1hvt w=(1.45e-07) l=4.5e-08 nf=1 \
        as=5.663e-14 ad=2.103e-14 ps=1.58e-06 pd=5.8e-07 nrd=1.16667 \
        nrs=1.16667 sa=1.45e-07 sb=4.7e-07 sd=160n sca=14.7993 \
        scb=0.0157101 scc=0.000964917 m=(1)
mn20 (\19\:CKb \3\:CK \18\:VSS VSS) g45n1hvt w=(1.45e-07) l=4.5e-08 nf=1 \
        as=5.663e-14 ad=3.19e-14 ps=1.58e-06 pd=7.3e-07 nrd=1.16667 \
        nrs=1.16667 sa=3.95e-07 sb=2.2e-07 sd=160n sca=14.7993 \
        scb=0.0157101 scc=0.000964917 m=(1)
mn45 (\13\:qbint \2\:n30 \15\:VSS VSS) g45n1hvt w=(1.45e-07) l=4.5e-08 \
        nf=1 as=4.765e-14 ad=2.465e-14 ps=1.43e-06 pd=6.3e-07 nrd=1.16667 \
        nrs=1.16667 sa=1.7e-07 sb=1.855e-06 sd=160n sca=13.253 \
        scb=0.0137915 scc=0.000695334 m=(1)
mn50 (net460 \10\:qbint \15\:VSS VSS) g45n1hvt w=(1.45e-07) l=4.5e-08 \
        nf=1 as=4.765e-14 ad=2.32e-14 ps=1.43e-06 pd=6.1e-07 nrd=1.16667 \
        nrs=1.16667 sa=3.65e-07 sb=1.66e-06 sd=160n sca=13.253 \
        scb=0.0137915 scc=0.000695334 m=(1)
mn51 (\5\:n30 CKb net460 VSS) g45n1hvt w=(1.45e-07) l=4.5e-08 nf=1 \
        as=2.32e-14 ad=3.48e-14 ps=6.1e-07 pd=7.7e-07 nrd=1.16667 \
        nrs=1.16667 sa=5.7e-07 sb=1.455e-06 sd=160n sca=13.253 \
        scb=0.0137915 scc=0.000695334 m=(1)
mn40 (\5\:n30 CKbb \6\:mout VSS) g45n1hvt w=(1.45e-07) l=4.5e-08 nf=1 \
        as=4.278e-14 ad=3.48e-14 ps=8.8e-07 pd=7.7e-07 nrd=1.16667 \
        nrs=1.16667 sa=8.55e-07 sb=1.17e-06 sd=160n sca=13.253 \
        scb=0.0137915 scc=0.000695334 m=(1)
mn30 (\6\:mout n20 \13\:VSS VSS) g45n1hvt w=(1.45e-07) l=4.5e-08 nf=1 \
        as=5.345e-14 ad=4.278e-14 ps=1.51e-06 pd=8.8e-07 nrd=1.16667 \
        nrs=1.16667 sa=1.195e-06 sb=8.3e-07 sd=160n sca=13.253 \
        scb=0.0137915 scc=0.000695334 m=(1)
mn35 (net452 \3\:mout \13\:VSS VSS) g45n1hvt w=(1.45e-07) l=4.5e-08 nf=1 \
        as=5.345e-14 ad=8.7e-15 ps=1.51e-06 pd=4.1e-07 nrd=1.16667 \
        nrs=1.16667 sa=1.43e-06 sb=5.95e-07 sd=160n sca=13.253 \
        scb=0.0137915 scc=0.000695334 m=(1)
mn36 (\8\:n20 \4\:CKbb net452 VSS) g45n1hvt w=(1.45e-07) l=4.5e-08 nf=1 \
        as=8.7e-15 ad=2.32e-14 ps=4.1e-07 pd=6.1e-07 nrd=1.16667 \
        nrs=1.16667 sa=1.535e-06 sb=4.9e-07 sd=160n sca=13.253 \
        scb=0.0137915 scc=0.000695334 m=(1)
mn25 (\8\:Dbp \10\:CKb \8\:n20 VSS) g45n1hvt w=(1.45e-07) l=4.5e-08 nf=1 \
        as=2.32e-14 ad=4.133e-14 ps=6.1e-07 pd=8.6e-07 nrd=1.16667 \
        nrs=1.16667 sa=1.74e-06 sb=2.85e-07 sd=160n sca=13.253 \
        scb=0.0137915 scc=0.000695334 m=(1)
mn21 (\14\:CKbb \5\:CKb \11\:VSS VSS) g45n1hvt w=(1.45e-07) l=4.5e-08 \
        nf=1 as=2.32e-14 ad=2.03e-14 ps=6.1e-07 pd=5.7e-07 nrd=1.16667 \
        nrs=1.16667 sa=1.4e-07 sb=8.65e-07 sd=160n sca=7.79977 \
        scb=0.00524357 scc=6.87485e-05 m=(1)
mn12 (net484 \1\:SI \11\:VSS VSS) g45n1hvt w=(1.45e-07) l=4.5e-08 nf=1 \
        as=2.32e-14 ad=2.248e-14 ps=6.1e-07 pd=6e-07 nrd=1.16667 \
        nrs=1.16667 sa=3.45e-07 sb=6.6e-07 sd=160n sca=7.79977 \
        scb=0.00524357 scc=6.87485e-05 m=(1)
mn13 (Dbp \5\:SE net484 VSS) g45n1hvt w=(1.45e-07) l=4.5e-08 nf=1 \
        as=2.248e-14 ad=3.045e-14 ps=6e-07 pd=7.1e-07 nrd=1.16667 \
        nrs=1.16667 sa=5.45e-07 sb=4.6e-07 sd=160n sca=7.79977 \
        scb=0.00524357 scc=6.87485e-05 m=(1)
mn11 (\7\:Db \3\:SEb Dbp VSS) g45n1hvt w=(1.45e-07) l=4.5e-08 nf=1 \
        as=3.045e-14 ad=2.973e-14 ps=7.1e-07 pd=7e-07 nrd=1.16667 \
        nrs=1.16667 sa=8e-07 sb=2.05e-07 sd=160n sca=7.79977 \
        scb=0.00524357 scc=6.87485e-05 m=(1)
mn10 (\7\:SEb \1\:SE \9\:VSS VSS) g45n1hvt w=(1.45e-07) l=4.5e-08 nf=1 \
        as=2.392e-14 ad=2.03e-14 ps=6.2e-07 pd=5.7e-07 nrd=1.16667 \
        nrs=1.16667 sa=1.4e-07 sb=5.95e-07 sd=160n sca=10.4914 \
        scb=0.00978575 scc=0.000300434 m=(1)
mn0 (net476 \3\:RN \9\:VSS VSS) g45n1hvt w=(1.45e-07) l=4.5e-08 nf=1 \
        as=2.392e-14 ad=2.9e-14 ps=6.2e-07 pd=6.9e-07 nrd=1.16667 \
        nrs=1.16667 sa=3.5e-07 sb=3.85e-07 sd=160n sca=10.4914 \
        scb=0.00978575 scc=0.000300434 m=(1)
mn1 (Db \3\:D net476 VSS) g45n1hvt w=(1.45e-07) l=4.5e-08 nf=1 as=2.9e-14 \
        ad=2.03e-14 ps=6.9e-07 pd=5.7e-07 nrd=1.16667 nrs=1.16667 \
        sa=5.95e-07 sb=1.4e-07 sd=160n sca=10.4914 scb=0.00978575 \
        scc=0.000300434 m=(1)
ends SDFFTRXL
// End of subcircuit definition.
