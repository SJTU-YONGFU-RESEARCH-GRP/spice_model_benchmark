// Generated for: spectre (May  1 09:20:07 2013 )
// Library name: gsclib045_hvt
// Cell name: TLATNTSCAX6
// View name: extracted

simulator lang=spectre

subckt TLATNTSCAX6 CK E ECK SE VDD VSS
mp1 (\6\:Eb \1\:E net246 VDD) g45p1hvt w=(2.15e-07) l=4.5e-08 nf=1 \
        as=1.29e-14 ad=3.01e-14 ps=5.5e-07 pd=7.1e-07 nrd=1.16667 \
        nrs=1.16667 sa=1.4e-07 sb=5.95e-07 sd=160n sca=16.4413 \
        scb=0.0164604 scc=0.000341327 m=(1)
mp0 (net246 \1\:SE \24\:VDD VDD) g45p1hvt w=(2.15e-07) l=4.5e-08 nf=1 \
        as=3.548e-14 ad=1.29e-14 ps=7.6e-07 pd=5.5e-07 nrd=1.16667 \
        nrs=1.16667 sa=2.45e-07 sb=4.9e-07 sd=160n sca=14.2155 \
        scb=0.0125694 scc=0.000239267 m=(1)
mp2 (\14\:CKb \1\:CK \24\:VDD VDD) g45p1hvt w=(2.15e-07) l=4.5e-08 nf=1 \
        as=3.548e-14 ad=6.02e-14 ps=7.6e-07 pd=9.9e-07 nrd=1.16667 \
        nrs=1.16667 sa=4.55e-07 sb=2.8e-07 sd=160n sca=12.3184 \
        scb=0.0100356 scc=0.000221045 m=(1)
mp5 (\5\:n5 \3\:CKbb \3\:Eb VDD) g45p1hvt w=(2.15e-07) l=4.5e-08 nf=1 \
        as=5.375e-14 ad=3.44e-14 ps=9.3e-07 pd=7.5e-07 nrd=1.16667 \
        nrs=1.16667 sa=2.5e-07 sb=8e-07 sd=160n sca=20.4333 scb=0.0198015 \
        scc=0.00193653 m=(1)
mp16 (\5\:n5 \3\:CKb net234 VDD) g45p1hvt w=(2.15e-07) l=4.5e-08 nf=1 \
        as=3.118e-14 ad=3.44e-14 ps=7.2e-07 pd=7.5e-07 nrd=1.16667 \
        nrs=1.16667 sa=4.55e-07 sb=5.95e-07 sd=160n sca=20.4333 \
        scb=0.0198015 scc=0.00193653 m=(1)
mp15 (net234 \3\:Eint \22\:VDD VDD) g45p1hvt w=(2.15e-07) l=4.5e-08 nf=1 \
        as=9.95e-14 ad=3.118e-14 ps=1.74e-06 pd=7.2e-07 nrd=1.16667 \
        nrs=1.16667 sa=6.45e-07 sb=4.05e-07 sd=160n sca=20.4333 \
        scb=0.0198015 scc=0.00193653 m=(1)
mp3 (\10\:CKbb \5\:CKb \22\:VDD VDD) g45p1hvt w=(2.15e-07) l=4.5e-08 \
        nf=1 as=9.95e-14 ad=3.01e-14 ps=1.74e-06 pd=7.1e-07 nrd=1.16667 \
        nrs=1.16667 sa=9.1e-07 sb=1.4e-07 sd=160n sca=20.4333 \
        scb=0.0198015 scc=0.00193653 m=(1)
C1 (CK VSS) capacitor c=8.60641e-17
C2 (VDD VSS) capacitor c=2.61635e-16
C3 (SE VSS) capacitor c=9.00897e-17
C4 (E VSS) capacitor c=4.9181e-17
C5 (ECK VSS) capacitor c=5.08539e-16
C6 (Eb VSS) capacitor c=6.31001e-17
C7 (CKb VSS) capacitor c=3.21015e-17
C8 (n5 VSS) capacitor c=4.79671e-17
C9 (CKbb VSS) capacitor c=2.61567e-17
C10 (Eint VSS) capacitor c=5.48013e-17
C11 (16 VSS) capacitor c=1.96117e-18
C12 (ECKb VSS) capacitor c=2.8871e-16
C13 (17 VSS) capacitor c=3.55937e-18
C14 (net234 VSS) capacitor c=2.02974e-18
C15 (\3\:n5 VSS) capacitor c=4.3094e-17
C16 (\5\:CKb VSS) capacitor c=6.32299e-17
C17 (\3\:Eint VSS) capacitor c=4.56776e-17
C18 (\3\:CKb VSS) capacitor c=5.10281e-17
C19 (\3\:CKbb VSS) capacitor c=5.78036e-17
C20 (\1\:CK VSS) capacitor c=5.40937e-17
C21 (\1\:SE VSS) capacitor c=9.87549e-17
C22 (\1\:E VSS) capacitor c=9.57937e-17
C23 (\10\:Eint VSS) capacitor c=6.25659e-17
C24 (\4\:CKbb VSS) capacitor c=3.2252e-17
C25 (\9\:CKbb VSS) capacitor c=4.3186e-17
C26 (\5\:Eint VSS) capacitor c=6.83849e-17
C27 (\6\:CKb VSS) capacitor c=3.50173e-17
C28 (\3\:CK VSS) capacitor c=2.82818e-17
C29 (\3\:SE VSS) capacitor c=3.35342e-17
C30 (\4\:E VSS) capacitor c=2.71008e-17
C31 (\7\:ECKb VSS) capacitor c=2.09889e-17
C32 (\6\:Eint VSS) capacitor c=3.97196e-16
C33 (\2\:n5 VSS) capacitor c=3.0947e-17
C34 (\7\:CKb VSS) capacitor c=2.00212e-17
C35 (\4\:Eint VSS) capacitor c=5.42224e-17
C36 (\2\:CKbb VSS) capacitor c=5.55458e-17
C37 (\4\:CKb VSS) capacitor c=3.99752e-17
C38 (\2\:CKb VSS) capacitor c=1.84808e-17
C39 (\2\:CK VSS) capacitor c=4.81552e-17
C40 (\2\:SE VSS) capacitor c=8.41061e-17
C41 (\3\:E VSS) capacitor c=1.23819e-17
C42 (\17\:ECKb VSS) capacitor c=2.01561e-16
C43 (\18\:VDD VSS) capacitor c=4.06799e-17
C44 (\15\:Eint VSS) capacitor c=5.49869e-17
C45 (\10\:CKbb VSS) capacitor c=1.01387e-16
C46 (\22\:VDD VSS) capacitor c=1.69062e-17
C47 (\5\:n5 VSS) capacitor c=1.84221e-16
C48 (\3\:Eb VSS) capacitor c=1.39488e-16
C49 (\14\:CKb VSS) capacitor c=1.04947e-16
C50 (\24\:VDD VSS) capacitor c=4.36361e-17
C51 (\6\:Eb VSS) capacitor c=1.15542e-17
C52 (\1\:VDD VSS) capacitor c=4.64866e-17
C53 (\24\:ECKb VSS) capacitor c=5.6205e-17
C54 (\17\:Eint VSS) capacitor c=3.58819e-17
C55 (\13\:CKbb VSS) capacitor c=1.3828e-16
C56 (\7\:n5 VSS) capacitor c=8.83988e-17
C57 (\12\:CKb VSS) capacitor c=9.6969e-17
C58 (\8\:Eb VSS) capacitor c=9.39944e-17
C59 (\2\:E VSS) capacitor c=5.99792e-17
C60 (\5\:CKbb VSS) capacitor c=1.4672e-16
C61 (\5\:E VSS) capacitor c=4.05993e-17
C62 (\4\:SE VSS) capacitor c=4.76463e-17
C63 (\4\:CK VSS) capacitor c=4.05498e-17
C64 (\5\:Eb VSS) capacitor c=1.92183e-16
C65 (\8\:CKb VSS) capacitor c=6.15133e-17
C66 (\9\:CKb VSS) capacitor c=6.35986e-17
C67 (\10\:CKb VSS) capacitor c=5.83192e-17
C68 (\11\:CKb VSS) capacitor c=8.81219e-17
C69 (\4\:n5 VSS) capacitor c=1.58019e-16
C70 (\12\:CKbb VSS) capacitor c=1.06793e-16
C71 (\15\:CKbb VSS) capacitor c=1.22716e-16
C72 (\11\:Eint VSS) capacitor c=6.62632e-17
C73 (\12\:Eint VSS) capacitor c=5.76364e-17
C74 (\13\:Eint VSS) capacitor c=4.10956e-17
C75 (\20\:ECKb VSS) capacitor c=9.59584e-17
C76 (\3\:VDD VSS) capacitor c=3.81151e-16
C77 (\9\:VDD VSS) capacitor c=2.79178e-17
C78 (\11\:VDD VSS) capacitor c=1.97398e-17
Rk3 (CK \4\:CK) resistor r=0.09307 c=0
Rk38 (\2\:VDD \3\:VDD) resistor r=0.1979 c=0
Rk44 (\3\:VDD \9\:VDD) resistor r=0.4184 c=0
Rk45 (\9\:VDD \10\:VDD) resistor r=0.4161 c=0
Rk47 (\11\:VDD VDD) resistor r=0.2278 c=0
Rk46 (\10\:VDD \11\:VDD) resistor r=0.3233 c=0
Rk51 (\3\:VDD \19\:VDD) resistor r=0.2577 c=0
Rk53 (\9\:VDD \23\:VDD) resistor r=0.1026 c=0
Rk54 (\11\:VDD \25\:VDD) resistor r=0.2815 c=0
Rk2 (SE \4\:SE) resistor r=0.09307 c=0
Rk1 (\5\:E E) resistor r=0.1669 c=0
Rk55 (\2\:VSS \3\:VSS) resistor r=0.1979 c=0
Rk58 (\3\:VSS \6\:VSS) resistor r=0.04244 c=0
Rk59 (\6\:VSS \7\:VSS) resistor r=0.3073 c=0
Rk60 (\7\:VSS \8\:VSS) resistor r=0.4617 c=0
Rk61 (\8\:VSS \9\:VSS) resistor r=0.4302 c=0
Rk63 (\10\:VSS VSS) resistor r=0.2283 c=0
Rk62 (\9\:VSS \10\:VSS) resistor r=0.3233 c=0
Rk64 (VSS \12\:VSS) resistor r=0.1795 c=0
Rk68 (\7\:VSS \20\:VSS) resistor r=0.04331 c=0
Rk69 (\8\:VSS \22\:VSS) resistor r=0.04331 c=0
Rk70 (\10\:VSS \24\:VSS) resistor r=0.1763 c=0
Rk4 (\2\:Eb \4\:Eb) resistor r=0.4314 c=0
Rk5 (\4\:Eb \5\:Eb) resistor r=0.9404 c=0
Rk6 (\5\:Eb \7\:Eb) resistor r=0.1045 c=0
Rk7 (\5\:Eb \9\:Eb) resistor r=0.5786 c=0
Rk8 (\8\:CKb \9\:CKb) resistor r=0.4073 c=0
Rk9 (\9\:CKb \10\:CKb) resistor r=0.2077 c=0
Rk10 (\9\:CKb \11\:CKb) resistor r=0.4009 c=0
Rk11 (\10\:CKb \13\:CKb) resistor r=0.3503 c=0
Rk12 (\13\:CKb \15\:CKb) resistor r=0.57 c=0
Rk13 (\4\:n5 \6\:n5) resistor r=1.1289 c=0
Rk14 (\6\:n5 \8\:n5) resistor r=0.5004 c=0
Rk15 (\11\:CKbb \12\:CKbb) resistor r=0.5813 c=0
Rk16 (\12\:CKbb \14\:CKbb) resistor r=0.4507 c=0
Rk17 (\14\:CKbb \15\:CKbb) resistor r=0.909 c=0
Rk18 (\11\:Eint \12\:Eint) resistor r=0.3233 c=0
Rk20 (\13\:Eint \6\:Eint) resistor r=0.2284 c=0
Rk19 (\12\:Eint \13\:Eint) resistor r=0.267 c=0
Rk21 (\12\:Eint \16\:Eint) resistor r=0.1427 c=0
Rk22 (\13\:Eint \18\:Eint) resistor r=0.08669 c=0
Rk25 (\17\:ECKb \20\:ECKb) resistor r=0.4184 c=0
Rk28 (\20\:ECKb \25\:ECKb) resistor r=0.393 c=0
Rl6 (\1\:CK \2\:CK) resistor r=219.923 c=0
Rl7 (\2\:CK \3\:CK) resistor r=39.1533 c=0
Rl4 (\1\:SE \2\:SE) resistor r=218.464 c=0
Rl5 (\2\:SE \3\:SE) resistor r=37.6944 c=0
Rl1 (\1\:E \2\:E) resistor r=259.924 c=0
Rl3 (\2\:E \4\:E) resistor r=37.2017 c=0
Rl2 (\2\:E \3\:E) resistor r=9.7447 c=0
Rl15 (\5\:CKb \6\:CKb) resistor r=150 c=0
Rl16 (\6\:CKb \7\:CKb) resistor r=29.5379 c=0
Rl9 (\3\:CKb \4\:CKb) resistor r=24.2328 c=0
Rl8 (CKb \2\:CKb) resistor r=47.3097 c=0
Rl18 (\2\:n5 \3\:n5) resistor r=24.2328 c=0
Rl17 (n5 \2\:n5) resistor r=91.1062 c=0
Rl11 (\2\:CKbb \3\:CKbb) resistor r=189.939 c=0
Rl10 (\2\:CKbb CKbb) resistor r=24.2328 c=0
Rl21 (\5\:CKbb \4\:CKbb) resistor r=54.5712 c=0
Rl25 (\5\:CKbb \9\:CKbb) resistor r=24.7951 c=0
Rl27 (\6\:Eint \10\:Eint) resistor r=83.7903 c=0
Rl19 (\6\:Eint \5\:Eint) resistor r=63.4387 c=0
Rl13 (\2\:Eint \3\:Eint) resistor r=58.0007 c=0
Rl12 (\2\:Eint Eint) resistor r=85.2786 c=0
Rl14 (\2\:Eint \4\:Eint) resistor r=4.3511 c=0
Rl33 (ECKb \7\:ECKb) resistor r=4.8851 c=0
Rz11 (\2\:VDD \1\:VDD) resistor r=75 c=0
Rz12 (\3\:VDD \1\:VDD) resistor r=6.25 c=0
Rz13 (\10\:VDD \1\:VDD) resistor r=6.25 c=0
Rz14 (\12\:VSS \11\:VSS) resistor r=75 c=0
Rz18 (\20\:VSS \19\:VSS) resistor r=75 c=0
Rz19 (\22\:VSS \21\:VSS) resistor r=75 c=0
Rz20 (\24\:VSS \23\:VSS) resistor r=75 c=0
Rz1 (Eb \2\:Eb) resistor r=75 c=0
Rz2 (\8\:Eb \9\:Eb) resistor r=75 c=0
Rz3 (\12\:CKb \13\:CKb) resistor r=75 c=0
Rz4 (\7\:n5 \8\:n5) resistor r=75 c=0
Rz5 (\14\:CKbb \13\:CKbb) resistor r=75 c=0
Rz6 (\18\:Eint \17\:Eint) resistor r=75 c=0
Rz7 (\25\:ECKb \24\:ECKb) resistor r=75 c=0
Ry17 (\19\:VDD \18\:VDD) resistor r=62 c=0
Ry19 (\23\:VDD \22\:VDD) resistor r=62 c=0
Ry20 (\25\:VDD \24\:VDD) resistor r=62 c=0
Ry21 (\2\:VSS \1\:VSS) resistor r=62 c=0
Ry22 (\6\:VSS \1\:VSS) resistor r=5.1667 c=0
Ry23 (\9\:VSS \1\:VSS) resistor r=5.1667 c=0
Ry1 (\3\:Eb \4\:Eb) resistor r=62 c=0
Ry2 (\6\:Eb \7\:Eb) resistor r=62 c=0
Ry3 (\14\:CKb \15\:CKb) resistor r=62 c=0
Ry4 (\5\:n5 \6\:n5) resistor r=62 c=0
Ry5 (\11\:CKbb \10\:CKbb) resistor r=62 c=0
Ry6 (\16\:Eint \15\:Eint) resistor r=62 c=0
Rx3 (\2\:CK \4\:CK) resistor r=45 c=0
Rx2 (\2\:SE \4\:SE) resistor r=45 c=0
Rx1 (\3\:E \5\:E) resistor r=45 c=0
Rx4 (\7\:CKb \8\:CKb) resistor r=45 c=0
Rx5 (\2\:CKb \10\:CKb) resistor r=45 c=0
Rx6 (\4\:CKb \11\:CKb) resistor r=45 c=0
Rx7 (\2\:n5 \4\:n5) resistor r=45 c=0
Rx8 (\12\:CKbb \2\:CKbb) resistor r=45 c=0
Rx9 (\15\:CKbb \5\:CKbb) resistor r=45 c=0
Rx10 (\11\:Eint \4\:Eint) resistor r=45 c=0
Rx13 (\20\:ECKb \7\:ECKb) resistor r=45 c=0
mn1 (\8\:Eb \4\:E \11\:VSS VSS) g45n1hvt w=(1.45e-07) l=4.5e-08 nf=1 \
        as=2.03e-14 ad=2.61e-14 ps=5.7e-07 pd=6.5e-07 nrd=1.16667 \
        nrs=1.16667 sa=1.4e-07 sb=6.85e-07 sd=160n sca=6.59604 \
        scb=0.00318587 scc=2.16275e-05 m=(1)
mn0 (\8\:Eb \3\:SE \23\:VSS VSS) g45n1hvt w=(1.45e-07) l=4.5e-08 nf=1 \
        as=2.393e-14 ad=2.61e-14 ps=6.2e-07 pd=6.5e-07 nrd=1.16667 \
        nrs=1.16667 sa=3.65e-07 sb=4.6e-07 sd=160n sca=6.59604 \
        scb=0.00318587 scc=2.16275e-05 m=(1)
mn2 (\12\:CKb \3\:CK \23\:VSS VSS) g45n1hvt w=(1.45e-07) l=4.5e-08 nf=1 \
        as=2.392e-14 ad=3.625e-14 ps=6.2e-07 pd=7.9e-07 nrd=1.16667 \
        nrs=1.16667 sa=5.75e-07 sb=2.5e-07 sd=160n sca=6.59604 \
        scb=0.00318587 scc=2.16275e-05 m=(1)
mn5 (Eb CKb \7\:n5 VSS) g45n1hvt w=(1.45e-07) l=4.5e-08 nf=1 as=5.8e-14 \
        ad=2.03e-14 ps=1.09e-06 pd=5.7e-07 nrd=1.16667 nrs=1.16667 \
        sa=1.4e-07 sb=9.85e-07 sd=160n sca=14.3814 scb=0.0152134 \
        scc=0.00088947 m=(1)
mn16 (\7\:n5 CKbb net263 VSS) g45n1hvt w=(1.45e-07) l=4.5e-08 nf=1 \
        as=2.32e-14 ad=5.8e-14 ps=6.1e-07 pd=1.09e-06 nrd=1.16667 \
        nrs=1.16667 sa=5.85e-07 sb=5.4e-07 sd=160n sca=14.3814 \
        scb=0.0152134 scc=0.00088947 m=(1)
mn15 (net263 Eint \21\:VSS VSS) g45n1hvt w=(1.45e-07) l=4.5e-08 nf=1 \
        as=4.84e-14 ad=2.32e-14 ps=1.46e-06 pd=6.1e-07 nrd=1.16667 \
        nrs=1.16667 sa=7.9e-07 sb=3.35e-07 sd=160n sca=14.3814 \
        scb=0.0152134 scc=0.00088947 m=(1)
mn3 (\13\:CKbb \6\:CKb \21\:VSS VSS) g45n1hvt w=(1.45e-07) l=4.5e-08 \
        nf=1 as=4.84e-14 ad=2.03e-14 ps=1.46e-06 pd=5.7e-07 nrd=1.16667 \
        nrs=1.16667 sa=9.85e-07 sb=1.4e-07 sd=160n sca=14.3814 \
        scb=0.0152134 scc=0.00088947 m=(1)
mn10 (\17\:Eint n5 \19\:VSS VSS) g45n1hvt w=(2.05e-07) l=4.5e-08 nf=1 \
        as=8.885e-14 ad=2.87e-14 ps=1.58e-06 pd=6.9e-07 nrd=1.16667 \
        nrs=1.16667 sa=1.4e-07 sb=1.54476e-06 sd=160n sca=18.43 \
        scb=0.0187068 scc=0.00173343 m=(1)
mn20_1__rcx (16 \5\:Eint \19\:VSS VSS) g45n1hvt w=(2.6e-07) l=4.5e-08 \
        nf=1 as=8.885e-14 ad=1.56e-14 ps=1.58e-06 pd=6.4e-07 nrd=1.16667 \
        nrs=1.16667 sa=3.19135e-07 sb=1.63e-06 sd=160n sca=12.8392 \
        scb=0.0126987 scc=0.00074151 m=(1)
mn21_1__rcx (\24\:ECKb \9\:CKbb 16 VSS) g45n1hvt w=(2.6e-07) l=4.5e-08 \
        nf=1 as=1.56e-14 ad=4.16e-14 ps=6.4e-07 pd=8.4e-07 nrd=1.16667 \
        nrs=1.16667 sa=4.24135e-07 sb=1.525e-06 sd=160n sca=12.8392 \
        scb=0.0126987 scc=0.00074151 m=(1)
mn21 (\24\:ECKb \4\:CKbb 17 VSS) g45n1hvt w=(2.6e-07) l=4.5e-08 nf=1 \
        as=2.86e-14 ad=4.16e-14 ps=7.4e-07 pd=8.4e-07 nrd=1.16667 \
        nrs=1.16667 sa=6.29135e-07 sb=1.32e-06 sd=160n sca=12.8392 \
        scb=0.0126987 scc=0.00074151 m=(1)
mn20 (17 \10\:Eint \3\:VSS VSS) g45n1hvt w=(2.6e-07) l=4.5e-08 nf=1 \
        as=4.66e-14 ad=2.86e-14 ps=9.4e-07 pd=7.4e-07 nrd=1.16667 \
        nrs=1.16667 sa=7.84135e-07 sb=1.165e-06 sd=160n sca=12.8392 \
        scb=0.0126987 scc=0.00074151 m=(1)
mn22_1__rcx (ECK ECKb \3\:VSS VSS) g45n1hvt w=(3.1e-07) l=4.5e-08 nf=1 \
        as=4.9e-14 ad=4.836e-14 ps=9.4e-07 pd=9.32e-07 nrd=1.16667 \
        nrs=1.16667 sa=8.45726e-07 sb=9.6e-07 sd=160n sca=15.9751 \
        scb=0.0153507 scc=0.00137372 m=(5)
mp10 (\15\:Eint \3\:n5 \3\:VDD VDD) g45p1hvt w=(3.1e-07) l=4.5e-08 nf=1 \
        as=5.76e-14 ad=8.835e-14 ps=1.1e-06 pd=1.19e-06 nrd=1.16667 \
        nrs=1.16667 sa=2.85e-07 sb=1.985e-06 sd=160n sca=17.3904 \
        scb=0.0162056 scc=0.00137566 m=(1)
mp20_1__rcx (\17\:ECKb \6\:Eint \3\:VDD VDD) g45p1hvt w=(3.9e-07) \
        l=4.5e-08 nf=1 as=6.4e-14 ad=6.24e-14 ps=1.18e-06 pd=1.1e-06 \
        nrd=1.16667 nrs=1.16667 sa=4.1e-07 sb=1.78e-06 sd=160n sca=15.8351 \
        scb=0.0142471 scc=0.00110276 m=(2)
mp21 (\17\:ECKb \5\:CKbb \18\:VDD VDD) g45p1hvt w=(3.9e-07) l=4.5e-08 \
        nf=1 as=6.24e-14 ad=6.24e-14 ps=1.1e-06 pd=1.1e-06 nrd=1.16667 \
        nrs=1.16667 sa=6.15e-07 sb=1.575e-06 sd=160n sca=15.8351 \
        scb=0.0142471 scc=0.00110276 m=(2)
mp22_1__rcx (ECK ECKb \3\:VDD VDD) g45p1hvt w=(4.7e-07) l=4.5e-08 nf=1 \
        as=7.424e-14 ad=7.332e-14 ps=1.26e-06 pd=1.252e-06 nrd=1.16667 \
        nrs=1.16667 sa=1.03766e-06 sb=9.6e-07 sd=160n sca=26.9787 \
        scb=0.0178954 scc=0.0027966 m=(5)
ends TLATNTSCAX6
// End of subcircuit definition.
