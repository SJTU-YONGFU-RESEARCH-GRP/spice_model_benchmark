// Generated for: spectre (May  1 09:12:09 2013 )
// Library name: gsclib045_lvt
// Cell name: AOI2BB2X4
// View name: extracted

simulator lang=spectre

subckt AOI2BB2X4 A0N A1N B0 B1 VDD VSS Y
mp1 (\17\:net144 \1\:A1N \17\:VDD VDD) g45p1lvt w=(3.9e-07) l=4.5e-08 \
        nf=1 as=6.24e-14 ad=5.46e-14 ps=1.1e-06 pd=1.06e-06 nrd=1.16667 \
        nrs=1.16667 sa=1.4e-07 sb=3.26538e-07 sd=160n sca=18.6612 \
        scb=0.0194292 scc=0.000712894 m=(1)
mp0 (\18\:net148 \1\:A0N \17\:VDD VDD) g45p1lvt w=(3.9e-07) l=4.5e-08 \
        nf=1 as=6.24e-14 ad=4.74e-14 ps=1.1e-06 pd=1.12e-06 nrd=1.16667 \
        nrs=1.16667 sa=3.45e-07 sb=1.21538e-07 sd=160n sca=14.9537 \
        scb=0.0131754 scc=0.000560012 m=(1)
mp2_1__rcx (net127 \2\:net148 \3\:VDD VDD) g45p1lvt w=(3.9e-07) \
        l=4.5e-08 nf=1 as=6.24e-14 ad=5.775e-14 ps=1.1e-06 pd=1.09e-06 \
        nrd=1.16667 nrs=1.16667 sa=1.12308e-07 sb=2e-06 sd=160n \
        sca=18.3986 scb=0.0159927 scc=0.00159615 m=(4)
mp3_1__rcx (net127 \2\:net144 \3\:VDD VDD) g45p1lvt w=(3.9e-07) \
        l=4.5e-08 nf=1 as=6.24e-14 ad=6.24e-14 ps=1.1e-06 pd=1.1e-06 \
        nrd=1.16667 nrs=1.16667 sa=3.17308e-07 sb=2e-06 sd=160n \
        sca=18.3796 scb=0.0159892 scc=0.00159615 m=(4)
mp4_1__rcx (Y B0 net127 VDD) g45p1lvt w=(3.9e-07) l=4.5e-08 nf=1 \
        as=6.045e-14 ad=6.24e-14 ps=1.09e-06 pd=1.1e-06 nrd=1.16667 \
        nrs=1.16667 sa=1.75231e-06 sb=1.575e-06 sd=160n sca=18.3796 \
        scb=0.0159892 scc=0.00159615 m=(4)
mp5_1__rcx (Y B1 net127 VDD) g45p1lvt w=(3.9e-07) l=4.5e-08 nf=1 \
        as=6.24e-14 ad=6.24e-14 ps=1.1e-06 pd=1.1e-06 nrd=1.16667 \
        nrs=1.16667 sa=1.95731e-06 sb=1.37e-06 sd=160n sca=18.3796 \
        scb=0.0159892 scc=0.00159615 m=(4)
C1 (VDD VSS) capacitor c=1.97722e-16
C2 (A0N VSS) capacitor c=7.39503e-17
C3 (B0 VSS) capacitor c=6.83964e-16
C4 (Y VSS) capacitor c=3.49669e-16
C5 (A1N VSS) capacitor c=9.15244e-17
C6 (B1 VSS) capacitor c=4.00604e-16
C7 (net144 VSS) capacitor c=6.23334e-17
C8 (net148 VSS) capacitor c=7.65965e-17
C9 (12 VSS) capacitor c=1.73025e-18
C10 (13 VSS) capacitor c=1.73025e-18
C11 (14 VSS) capacitor c=4.73764e-18
C12 (15 VSS) capacitor c=5.31477e-18
C13 (17 VSS) capacitor c=2.03972e-18
C14 (18 VSS) capacitor c=1.0071e-17
C15 (net127 VSS) capacitor c=7.30163e-16
C16 (\1\:A0N VSS) capacitor c=4.95136e-17
C17 (\1\:A1N VSS) capacitor c=4.59431e-17
C18 (\13\:B0 VSS) capacitor c=3.46204e-17
C19 (\11\:B1 VSS) capacitor c=4.36049e-17
C20 (\13\:B1 VSS) capacitor c=5.28059e-17
C21 (\9\:B0 VSS) capacitor c=3.8692e-17
C22 (\8\:B0 VSS) capacitor c=2.92518e-17
C23 (\1\:B1 VSS) capacitor c=2.85054e-17
C24 (\5\:B1 VSS) capacitor c=4.09723e-17
C25 (\3\:B0 VSS) capacitor c=3.79237e-17
C26 (\13\:net148 VSS) capacitor c=4.92037e-17
C27 (\11\:net144 VSS) capacitor c=2.48074e-17
C28 (\10\:net144 VSS) capacitor c=4.49716e-17
C29 (\4\:net148 VSS) capacitor c=6.23097e-17
C30 (\8\:net148 VSS) capacitor c=5.81158e-17
C31 (\5\:net144 VSS) capacitor c=4.66247e-17
C32 (\3\:A0N VSS) capacitor c=3.51623e-17
C33 (\3\:A1N VSS) capacitor c=3.11849e-17
C34 (\2\:net144 VSS) capacitor c=6.04821e-16
C35 (\2\:net148 VSS) capacitor c=6.5043e-16
C36 (\2\:A0N VSS) capacitor c=3.43033e-17
C37 (\2\:A1N VSS) capacitor c=3.91387e-17
C38 (\18\:net148 VSS) capacitor c=5.75355e-17
C39 (\17\:VDD VSS) capacitor c=3.42623e-17
C40 (\17\:net144 VSS) capacitor c=8.46235e-17
C41 (\1\:VDD VSS) capacitor c=1.03696e-16
C42 (\1\:Y VSS) capacitor c=8.88579e-17
C43 (\17\:Y VSS) capacitor c=4.735e-17
C44 (\13\:Y VSS) capacitor c=8.89051e-17
C45 (\15\:Y VSS) capacitor c=7.92491e-17
C46 (\20\:net148 VSS) capacitor c=4.73461e-17
C47 (\15\:net144 VSS) capacitor c=1.99631e-16
C48 (\2\:B1 VSS) capacitor c=2.23355e-17
C49 (\4\:A1N VSS) capacitor c=4.15896e-17
C50 (\4\:A0N VSS) capacitor c=5.80516e-17
C51 (\17\:net148 VSS) capacitor c=4.312e-17
C52 (\12\:Y VSS) capacitor c=8.95114e-17
C53 (\3\:VDD VSS) capacitor c=2.68353e-16
C54 (\8\:VDD VSS) capacitor c=1.2811e-17
Rk37 (\2\:VSS \4\:VSS) resistor r=0.5474 c=0
Rk38 (\4\:VSS \5\:VSS) resistor r=0.04494 c=0
Rk39 (\5\:VSS \6\:VSS) resistor r=0.4259 c=0
Rk40 (\6\:VSS \7\:VSS) resistor r=0.3607 c=0
Rk41 (\7\:VSS \8\:VSS) resistor r=0.2706 c=0
Rk42 (\5\:VSS \10\:VSS) resistor r=0.2076 c=0
Rk43 (\6\:VSS \12\:VSS) resistor r=0.1993 c=0
Rk44 (\7\:VSS \14\:VSS) resistor r=0.1993 c=0
Rk46 (\15\:VSS VSS) resistor r=0.1299 c=0
Rk45 (\8\:VSS \15\:VSS) resistor r=0.4217 c=0
Rk47 (\8\:VSS \17\:VSS) resistor r=0.2532 c=0
Rk48 (\15\:VSS \19\:VSS) resistor r=0.2366 c=0
Rk49 (\2\:VDD \3\:VDD) resistor r=0.574 c=0
Rk55 (\8\:VDD VDD) resistor r=0.1675 c=0
Rk54 (\3\:VDD \8\:VDD) resistor r=0.3105 c=0
Rk60 (\8\:VDD \18\:VDD) resistor r=0.2217 c=0
Rk2 (A0N \4\:A0N) resistor r=0.174 c=0
Rk13 (\2\:Y Y) resistor r=0.3821 c=0
Rk19 (Y \12\:Y) resistor r=0.4902 c=0
Rk20 (\12\:Y \14\:Y) resistor r=0.2977 c=0
Rk21 (\14\:Y \16\:Y) resistor r=0.4686 c=0
Rk22 (\12\:Y \18\:Y) resistor r=0.3133 c=0
Rk1 (A1N \4\:A1N) resistor r=0.06001 c=0
Rk4 (\2\:net144 \16\:net144) resistor r=1.2504 c=0
Rk5 (\16\:net144 \18\:net144) resistor r=0.6517 c=0
Rk8 (\2\:net148 \17\:net148) resistor r=0.2067 c=0
Rk9 (\17\:net148 \19\:net148) resistor r=0.2172 c=0
Rk10 (\17\:net148 \21\:net148) resistor r=0.2177 c=0
Rl3 (\1\:A0N \2\:A0N) resistor r=91.0764 c=0
Rl4 (\2\:A0N \3\:A0N) resistor r=56.461 c=0
Rl45 (B0 \13\:B0) resistor r=39.5604 c=0
Rl36 (B0 \9\:B0) resistor r=41.5412 c=0
Rl35 (B0 \8\:B0) resistor r=39.6174 c=0
Rl26 (B0 \3\:B0) resistor r=41.1873 c=0
Rl1 (\1\:A1N \2\:A1N) resistor r=92.3077 c=0
Rl2 (\2\:A1N \3\:A1N) resistor r=57.1429 c=0
Rl41 (B1 \11\:B1) resistor r=103.08 c=0
Rl43 (B1 \13\:B1) resistor r=106.868 c=0
Rl29 (\2\:B1 B1) resistor r=38.2679 c=0
Rl28 (\2\:B1 \1\:B1) resistor r=33.7068 c=0
Rl31 (\2\:B1 \5\:B1) resistor r=90.7134 c=0
Rl20 (\2\:net144 \11\:net144) resistor r=30.0028 c=0
Rl19 (\2\:net144 \10\:net144) resistor r=29.579 c=0
Rl7 (\2\:net144 net144) resistor r=82.6695 c=0
Rl10 (\2\:net144 \5\:net144) resistor r=28.9526 c=0
Rl24 (\2\:net148 \13\:net148) resistor r=102.726 c=0
Rl12 (\2\:net148 \4\:net148) resistor r=124.51 c=0
Rl15 (\2\:net148 \8\:net148) resistor r=94.6154 c=0
Rl5 (\2\:net148 net148) resistor r=165.08 c=0
Rz7 (\1\:VSS \2\:VSS) resistor r=75 c=0
Rz8 (\9\:VSS \10\:VSS) resistor r=75 c=0
Rz9 (\11\:VSS \12\:VSS) resistor r=75 c=0
Rz10 (\13\:VSS \14\:VSS) resistor r=75 c=0
Rz11 (\16\:VSS \17\:VSS) resistor r=75 c=0
Rz12 (\18\:VSS \19\:VSS) resistor r=75 c=0
Rz13 (\2\:VDD \1\:VDD) resistor r=7.5 c=0
Rz14 (\3\:VDD \1\:VDD) resistor r=6.25 c=0
Rz3 (\2\:Y \1\:Y) resistor r=75 c=0
Rz4 (\14\:Y \13\:Y) resistor r=75 c=0
Rz5 (\16\:Y \15\:Y) resistor r=75 c=0
Rz6 (\18\:Y \17\:Y) resistor r=75 c=0
Rz1 (\16\:net144 \15\:net144) resistor r=75 c=0
Rz2 (\21\:net148 \20\:net148) resistor r=75 c=0
Ry16 (\3\:VSS \4\:VSS) resistor r=6.2 c=0
Ry17 (\3\:VSS \8\:VSS) resistor r=5.1667 c=0
Ry22 (\18\:VDD \17\:VDD) resistor r=62 c=0
Ry1 (\18\:net144 \17\:net144) resistor r=62 c=0
Ry2 (\19\:net148 \18\:net148) resistor r=62 c=0
Rx2 (\2\:A0N \4\:A0N) resistor r=45 c=0
Rx1 (\2\:A1N \4\:A1N) resistor r=45 c=0
mn1 (\15\:net144 \3\:A1N \18\:VSS VSS) g45n1lvt w=(2.6e-07) l=4.5e-08 \
        nf=1 as=6.11e-14 ad=3.64e-14 ps=9.9e-07 pd=8e-07 nrd=1.16667 \
        nrs=1.16667 sa=1.4e-07 sb=4.6e-07 sd=160n sca=10.79 scb=0.0100512 \
        scc=0.000418069 m=(1)
mn0 (\20\:net148 \3\:A0N \18\:VSS VSS) g45n1lvt w=(2.6e-07) l=4.5e-08 \
        nf=1 as=6.11e-14 ad=4.68e-14 ps=9.9e-07 pd=8.8e-07 nrd=1.16667 \
        nrs=1.16667 sa=4.2e-07 sb=1.8e-07 sd=160n sca=10.79 scb=0.0100512 \
        scc=0.000418069 m=(1)
mn2_1__rcx (11 net148 \16\:VSS VSS) g45n1lvt w=(2.6e-07) l=4.5e-08 nf=1 \
        as=3.64e-14 ad=1.56e-14 ps=8e-07 pd=6.4e-07 nrd=1.16667 \
        nrs=1.16667 sa=1.4e-07 sb=2e-06 sd=160n sca=9.14564 scb=0.00759168 \
        scc=0.000213449 m=(1)
mn3_1__rcx (\15\:Y \5\:net144 11 VSS) g45n1lvt w=(2.6e-07) l=4.5e-08 nf=1 \
        as=1.56e-14 ad=4.16e-14 ps=6.4e-07 pd=8.4e-07 nrd=1.16667 \
        nrs=1.16667 sa=2.45e-07 sb=2e-06 sd=160n sca=9.14564 \
        scb=0.00759168 scc=0.000213449 m=(1)
mn3_2__rcx (\15\:Y net144 12 VSS) g45n1lvt w=(2.6e-07) l=4.5e-08 nf=1 \
        as=1.56e-14 ad=4.16e-14 ps=6.4e-07 pd=8.4e-07 nrd=1.16667 \
        nrs=1.16667 sa=4.5e-07 sb=2e-06 sd=160n sca=9.14564 scb=0.00759168 \
        scc=0.000213449 m=(1)
mn2_2__rcx (12 \8\:net148 \13\:VSS VSS) g45n1lvt w=(2.6e-07) l=4.5e-08 \
        nf=1 as=4.16e-14 ad=1.56e-14 ps=8.4e-07 pd=6.4e-07 nrd=1.16667 \
        nrs=1.16667 sa=5.55e-07 sb=2e-06 sd=160n sca=9.14564 \
        scb=0.00759168 scc=0.000213449 m=(1)
mn2_3__rcx (13 \4\:net148 \13\:VSS VSS) g45n1lvt w=(2.6e-07) l=4.5e-08 \
        nf=1 as=4.16e-14 ad=1.56e-14 ps=8.4e-07 pd=6.4e-07 nrd=1.16667 \
        nrs=1.16667 sa=7.6e-07 sb=2e-06 sd=160n sca=9.14564 scb=0.00759168 \
        scc=0.000213449 m=(1)
mn3_3__rcx (\13\:Y \10\:net144 13 VSS) g45n1lvt w=(2.6e-07) l=4.5e-08 \
        nf=1 as=1.56e-14 ad=4.16e-14 ps=6.4e-07 pd=8.4e-07 nrd=1.16667 \
        nrs=1.16667 sa=8.65e-07 sb=2e-06 sd=160n sca=9.14564 \
        scb=0.00759168 scc=0.000213449 m=(1)
mn3 (\13\:Y \11\:net144 14 VSS) g45n1lvt w=(2.6e-07) l=4.5e-08 nf=1 \
        as=4.16e-14 ad=4.16e-14 ps=8.4e-07 pd=8.4e-07 nrd=1.16667 \
        nrs=1.16667 sa=1.07e-06 sb=1.93e-06 sd=160n sca=9.14564 \
        scb=0.00759168 scc=0.000213449 m=(1)
mn2 (14 \13\:net148 \11\:VSS VSS) g45n1lvt w=(2.6e-07) l=4.5e-08 nf=1 \
        as=4.16e-14 ad=4.16e-14 ps=8.4e-07 pd=8.4e-07 nrd=1.16667 \
        nrs=1.16667 sa=1.275e-06 sb=1.725e-06 sd=160n sca=9.14564 \
        scb=0.00759168 scc=0.000213449 m=(1)
mn4_1__rcx (\11\:VSS \3\:B0 15 VSS) g45n1lvt w=(2.6e-07) l=4.5e-08 nf=1 \
        as=4.94e-14 ad=4.16e-14 ps=9e-07 pd=8.4e-07 nrd=1.16667 \
        nrs=1.16667 sa=1.48e-06 sb=1.52e-06 sd=160n sca=9.14564 \
        scb=0.00759168 scc=0.000213449 m=(1)
mn5_1__rcx (15 \5\:B1 \17\:Y VSS) g45n1lvt w=(2.6e-07) l=4.5e-08 nf=1 \
        as=4.16e-14 ad=4.94e-14 ps=8.4e-07 pd=9e-07 nrd=1.16667 \
        nrs=1.16667 sa=1.715e-06 sb=1.285e-06 sd=160n sca=9.14564 \
        scb=0.00759168 scc=0.000213449 m=(1)
mn5_2__rcx (16 \1\:B1 \17\:Y VSS) g45n1lvt w=(2.6e-07) l=4.5e-08 nf=1 \
        as=4.16e-14 ad=3.38e-14 ps=8.4e-07 pd=7.8e-07 nrd=1.16667 \
        nrs=1.16667 sa=1.92e-06 sb=1.08e-06 sd=160n sca=9.14564 \
        scb=0.00759168 scc=0.000213449 m=(1)
mn4_2__rcx (\9\:VSS \8\:B0 16 VSS) g45n1lvt w=(2.6e-07) l=4.5e-08 nf=1 \
        as=3.38e-14 ad=4.16e-14 ps=7.8e-07 pd=8.4e-07 nrd=1.16667 \
        nrs=1.16667 sa=2e-06 sb=9.05e-07 sd=160n sca=9.14564 \
        scb=0.00759168 scc=0.000213449 m=(1)
mn4_3__rcx (\9\:VSS \9\:B0 17 VSS) g45n1lvt w=(2.6e-07) l=4.5e-08 nf=1 \
        as=2.08e-14 ad=4.16e-14 ps=6.8e-07 pd=8.4e-07 nrd=1.16667 \
        nrs=1.16667 sa=2e-06 sb=7e-07 sd=160n sca=9.14564 scb=0.00759168 \
        scc=0.000213449 m=(1)
mn5_3__rcx (17 \13\:B1 \1\:Y VSS) g45n1lvt w=(2.6e-07) l=4.5e-08 nf=1 \
        as=6.24e-14 ad=2.08e-14 ps=1e-06 pd=6.8e-07 nrd=1.16667 \
        nrs=1.16667 sa=2e-06 sb=5.75e-07 sd=160n sca=9.14564 \
        scb=0.00759168 scc=0.000213449 m=(1)
mn5 (18 \11\:B1 \1\:Y VSS) g45n1lvt w=(2.6e-07) l=4.5e-08 nf=1 \
        as=6.24e-14 ad=2.73e-14 ps=1e-06 pd=7.3e-07 nrd=1.16667 \
        nrs=1.16667 sa=2e-06 sb=2.9e-07 sd=160n sca=9.14564 scb=0.00759168 \
        scc=0.000213449 m=(1)
mn4 (\1\:VSS \13\:B0 18 VSS) g45n1lvt w=(2.6e-07) l=4.5e-08 nf=1 \
        as=2.73e-14 ad=3.64e-14 ps=7.3e-07 pd=8e-07 nrd=1.16667 \
        nrs=1.16667 sa=2e-06 sb=1.4e-07 sd=160n sca=9.14564 scb=0.00759168 \
        scc=0.000213449 m=(1)
ends AOI2BB2X4
// End of subcircuit definition.
