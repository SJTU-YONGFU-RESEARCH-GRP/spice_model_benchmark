// Generated for: spectre (May  1 08:11:48 2013 )
// Library name: gsclib045
// Cell name: LSHL_ISONH_X1_FROM_OFF
// View name: extracted

simulator lang=spectre

subckt LSHL_ISONH_X1_FROM_OFF A ExtVDD ISOn VSS Y
mp0 (\9\:n0 \1\:A \3\:ExtVDD ExtVDD) g45p1svt w=(2.15e-07) l=4.5e-08 \
        nf=1 as=3.01e-14 ad=3.01e-14 ps=7.1e-07 pd=7.1e-07 nrd=1.16667 \
        nrs=1.16667 sa=1.4e-07 sb=1.4e-07 sd=160n sca=10.57 scb=0.00792753 \
        scc=9.23989e-05 m=(1)
C1 (Y VSS) capacitor c=2.37055e-17
C2 (A VSS) capacitor c=4.24738e-17
C3 (ExtVDD VSS) capacitor c=1.59225e-16
C4 (VDD VSS) capacitor c=8.39217e-17
C5 (ISOn VSS) capacitor c=9.19503e-17
C6 (gatedVSS VSS) capacitor c=2.41757e-16
C7 (n0 VSS) capacitor c=2.7041e-17
C8 (\4\:n0 VSS) capacitor c=5.87521e-17
C9 (\1\:ISOn VSS) capacitor c=4.95814e-17
C10 (\1\:A VSS) capacitor c=5.29085e-17
C11 (\4\:A VSS) capacitor c=3.23123e-17
C12 (\3\:n0 VSS) capacitor c=4.72174e-17
C13 (\2\:ISOn VSS) capacitor c=6.23995e-17
C14 (\3\:A VSS) capacitor c=1.29918e-17
C15 (\6\:Y VSS) capacitor c=4.86246e-17
C16 (\1\:ExtVDD VSS) capacitor c=1.57733e-16
C17 (\2\:Y VSS) capacitor c=1.49561e-16
C18 (\9\:n0 VSS) capacitor c=1.15951e-16
C19 (\3\:ExtVDD VSS) capacitor c=9.21222e-17
C20 (\4\:Y VSS) capacitor c=5.95548e-17
C21 (\7\:gatedVSS VSS) capacitor c=4.53582e-17
C22 (\7\:n0 VSS) capacitor c=8.53466e-17
C23 (ExtVDD VSS) capacitor c=8.49292e-17
C24 (\2\:A VSS) capacitor c=4.36575e-17
C25 (VDD VSS) capacitor c=2.21404e-16
C26 (\3\:ISOn VSS) capacitor c=8.69242e-17
C27 (\5\:n0 VSS) capacitor c=7.14345e-17
C28 (\6\:n0 VSS) capacitor c=1.87959e-16
C29 (\1\:Y VSS) capacitor c=4.3656e-17
Rk14 (Y \1\:Y) resistor r=0.04858 c=0
Rk15 (\1\:Y \3\:Y) resistor r=0.5102 c=0
Rk16 (Y \5\:Y) resistor r=0.3376 c=0
Rk17 (\1\:Y \7\:Y) resistor r=0.2186 c=0
Rk18 (\2\:VSS VSS) resistor r=0.5817 c=0
Rk19 (VSS \3\:VSS) resistor r=0.0631 c=0
Rk21 (\4\:VSS VSS) resistor r=0.3635 c=0
Rk20 (\3\:VSS \4\:VSS) resistor r=0.03376 c=0
Rk22 (\3\:VSS \6\:VSS) resistor r=0.1786 c=0
Rk24 (\8\:VSS VSS) resistor r=0.5817 c=0
Rk26 (\9\:VSS VSS) resistor r=0.3635 c=0
Rk25 (VSS \9\:VSS) resistor r=0.09723 c=0
Rk6 (ExtVDD ExtVDD) resistor r=0.001734 c=0
Rk5 (\4\:ExtVDD ExtVDD) resistor r=0.2699 c=0
Rk4 (\2\:ExtVDD \4\:ExtVDD) resistor r=0.8305 c=0
Rk23 (VDD VDD) resistor r=0.4049 c=0
Rk3 (\6\:ISOn ISOn) resistor r=0.008599 c=0
Rk10 (gatedVSS \8\:gatedVSS) resistor r=0.08655 c=0
Rk11 (\5\:n0 \6\:n0) resistor r=0.3065 c=0
Rk12 (\6\:n0 \8\:n0) resistor r=0.6671 c=0
Rk13 (\6\:n0 \10\:n0) resistor r=0.5355 c=0
Rl1 (\1\:A \2\:A) resistor r=248.037 c=0
Rl3 (\2\:A \4\:A) resistor r=132.409 c=0
Rl2 (\2\:A \3\:A) resistor r=1.2666 c=0
Rl4 (\2\:ISOn \1\:ISOn) resistor r=77.4365 c=0
Rl5 (\3\:ISOn \2\:ISOn) resistor r=130.132 c=0
Rl10 (\2\:n0 \4\:n0) resistor r=147.373 c=0
Rl8 (n0 \2\:n0) resistor r=37.3411 c=0
Rl9 (\2\:n0 \3\:n0) resistor r=1.263 c=0
Rz7 (\4\:Y \5\:Y) resistor r=37.5 c=0
Rz8 (\6\:VSS \5\:VSS) resistor r=75 c=0
Rz3 (gatedVSS \3\:gatedVSS) resistor r=37.5 c=0
Rz5 (\8\:gatedVSS \7\:gatedVSS) resistor r=75 c=0
Rz6 (\7\:n0 \8\:n0) resistor r=75 c=0
Ry4 (\2\:Y \3\:Y) resistor r=20.6667 c=0
Ry5 (\6\:Y \7\:Y) resistor r=20.6667 c=0
Ry6 (\2\:VSS \1\:VSS) resistor r=31 c=0
Ry7 (\4\:VSS \1\:VSS) resistor r=5.1667 c=0
Ry8 (\8\:VSS \7\:VSS) resistor r=31 c=0
Ry9 (\9\:VSS \7\:VSS) resistor r=5.1667 c=0
Ry1 (\1\:ExtVDD \2\:ExtVDD) resistor r=20.6667 c=0
Ry2 (\3\:ExtVDD \4\:ExtVDD) resistor r=62 c=0
Ry3 (\9\:n0 \10\:n0) resistor r=62 c=0
Rx1 (\3\:A A) resistor r=45 c=0
Rx2 (\6\:ISOn \2\:ISOn) resistor r=45 c=0
Rx3 (\3\:n0 \5\:n0) resistor r=45 c=0
mn0 (\7\:gatedVSS \4\:A \7\:n0 VSS) g45n1svt w=(1.45e-07) l=4.5e-08 nf=1 \
        as=2.03e-14 ad=2.03e-14 ps=5.7e-07 pd=5.7e-07 nrd=1.16667 \
        nrs=1.16667 sa=1.4e-07 sb=1.4e-07 sd=160n sca=4.89823 \
        scb=0.00185688 scc=0.000107217 m=(1)
NM0 (\4\:Y n0 \3\:gatedVSS VSS) g45n1svt w=(2.6e-07) l=4.5e-08 nf=1 \
        as=3.64e-14 ad=3.64e-14 ps=8e-07 pd=8e-07 nrd=1.16667 nrs=1.16667 \
        sa=1.4e-07 sb=1.4e-07 sd=160n sca=11.8713 scb=0.0115056 \
        scc=0.000581193 m=(1)
NM3 (gatedVSS \3\:ISOn \5\:VSS VSS) g45n1svt w=(2.6e-07) l=4.5e-08 nf=1 \
        as=3.64e-14 ad=4.16e-14 ps=8e-07 pd=8.4e-07 nrd=1.16667 \
        nrs=1.16667 sa=1.4e-07 sb=3.45e-07 sd=160n sca=11.8713 \
        scb=0.0115056 scc=0.000581193 m=(2)
PM0 (\6\:Y \4\:n0 \1\:ExtVDD ExtVDD) g45p1svt w=(3.9e-07) l=4.5e-08 nf=1 \
        as=5.46e-14 ad=6.24e-14 ps=1.06e-06 pd=1.1e-06 nrd=1.16667 \
        nrs=1.16667 sa=3.45e-07 sb=1.4e-07 sd=160n sca=26.6928 \
        scb=0.0286638 scc=0.00274044 m=(1)
PM4 (\2\:Y \1\:ISOn \1\:ExtVDD ExtVDD) g45p1svt w=(3.9e-07) l=4.5e-08 \
        nf=1 as=6.24e-14 ad=5.46e-14 ps=1.1e-06 pd=1.06e-06 nrd=1.16667 \
        nrs=1.16667 sa=1.4e-07 sb=3.45e-07 sd=160n sca=12.1292 \
        scb=0.0106781 scc=0.000178505 m=(1)
ends LSHL_ISONH_X1_FROM_OFF
// End of subcircuit definition.
