// gsclib045_backbias/TLATNTSCAX20/schematic

simulator lang=spectre

subckt TLATNTSCAX20 CK E ECK SE VSS VDD NW
mn1 (Eb E VSS VSS) g45n1svt w=(145n) l=45n nf=1 m=(1)
mn0 (Eb SE VSS VSS) g45n1svt w=(145n) l=45n nf=1 m=(1)
mn22 (ECK ECKb VSS VSS) g45n1svt w=(5.185u) l=45n nf=1 m=(1)
mn21 (ECKb CKbb net271 VSS) g45n1svt w=(1.3u) l=45n nf=1 m=(1)
mn20 (net271 Eint VSS VSS) g45n1svt w=(1.3u) l=45n nf=1 m=(1)
mn16 (n5 CKbb net263 VSS) g45n1svt w=(145n) l=45n nf=1 m=(1)
mn15 (net263 Eint VSS VSS) g45n1svt w=(145n) l=45n nf=1 m=(1)
mn2 (CKb CK VSS VSS) g45n1svt w=(145n) l=45n nf=1 m=(1)
mn10 (Eint n5 VSS VSS) g45n1svt w=(520n) l=45n nf=1 m=(1)
mn5 (Eb CKb n5 VSS) g45n1svt w=(145n) l=45n nf=1 m=(1)
mn3 (CKbb CKb VSS VSS) g45n1svt w=(145n) l=45n nf=1 m=(1)
mp1 (Eb E net246 NW) g45p1svt w=(215n) l=45n nf=1 m=(1)
mp0 (net246 SE VDD NW) g45p1svt w=(215n) l=45n nf=1 m=(1)
mp22 (ECK ECKb VDD NW) g45p1svt w=(7.815u) l=45n nf=1 m=(1)
mp16 (n5 CKb net234 NW) g45p1svt w=(215n) l=45n nf=1 m=(1)
mp15 (net234 Eint VDD NW) g45p1svt w=(215n) l=45n nf=1 m=(1)
mp2 (CKb CK VDD NW) g45p1svt w=(215n) l=45n nf=1 m=(1)
mp10 (Eint n5 VDD NW) g45p1svt w=(780n) l=45n nf=1 m=(1)
mp3 (CKbb CKb VDD NW) g45p1svt w=(215n) l=45n nf=1 m=(1)
mp5 (n5 CKbb Eb NW) g45p1svt w=(215n) l=45n nf=1 m=(1)
mp21 (ECKb CKbb VDD NW) g45p1svt w=(1.95u) l=45n nf=1 m=(1)
mp20 (ECKb Eint VDD NW) g45p1svt w=(1.95u) l=45n nf=1 m=(1)
ends TLATNTSCAX20
