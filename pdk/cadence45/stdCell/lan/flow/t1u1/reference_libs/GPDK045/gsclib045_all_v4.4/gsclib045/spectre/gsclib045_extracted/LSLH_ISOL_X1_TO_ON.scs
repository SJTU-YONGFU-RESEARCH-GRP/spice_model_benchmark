// Generated for: spectre (May  1 08:11:58 2013 )
// Library name: gsclib045
// Cell name: LSLH_ISOL_X1_TO_ON
// View name: extracted

simulator lang=spectre

subckt LSLH_ISOL_X1_TO_ON A ExtVDD ISO VDD VSS Y
PM2 (\7\:Ab \9\:A \3\:ExtVDD ExtVDD) g45p1svt w=(2.15e-07) l=4.5e-08 \
        nf=1 as=3.01e-14 ad=3.01e-14 ps=7.1e-07 pd=7.1e-07 nrd=1.16667 \
        nrs=1.16667 sa=1.4e-07 sb=1.4e-07 sd=160n sca=24.7929 \
        scb=0.0299675 scc=0.00134688 m=(1)
PM0 (\12\:Ybint \4\:Yint \14\:VDD VDD) g45p1svt w=(2.15e-07) l=4.5e-08 \
        nf=1 as=3.01e-14 ad=3.01e-14 ps=7.1e-07 pd=7.1e-07 nrd=1.16667 \
        nrs=1.16667 sa=1.4e-07 sb=1.4e-07 sd=160n sca=23.0829 \
        scb=0.0252371 scc=0.00197374 m=(1)
PM5 (\16\:ison \1\:ISO \12\:VDD VDD) g45p1svt w=(2.15e-07) l=4.5e-08 \
        nf=1 as=3.01e-14 ad=3.01e-14 ps=7.1e-07 pd=7.1e-07 nrd=1.16667 \
        nrs=1.16667 sa=1.4e-07 sb=1.4e-07 sd=160n sca=9.3087 \
        scb=0.00624818 scc=6.7825e-05 m=(1)
PM1 (\11\:Yint Ybint \10\:VDD VDD) g45p1svt w=(2.15e-07) l=4.5e-08 nf=1 \
        as=3.01e-14 ad=3.01e-14 ps=7.1e-07 pd=7.1e-07 nrd=1.16667 \
        nrs=1.16667 sa=1.4e-07 sb=1.4e-07 sd=160n sca=7.11886 \
        scb=0.00384538 scc=3.76076e-05 m=(1)
PM3 (\19\:Ybint ison \8\:VDD VDD) g45p1svt w=(2.15e-07) l=4.5e-08 nf=1 \
        as=3.01e-14 ad=3.01e-14 ps=7.1e-07 pd=7.1e-07 nrd=1.16667 \
        nrs=1.16667 sa=1.4e-07 sb=1.4e-07 sd=160n sca=9.98341 \
        scb=0.00767826 scc=0.000153511 m=(1)
C1 (VDD VSS) capacitor c=4.26782e-16
C2 (A VSS) capacitor c=2.18126e-17
C3 (ISO VSS) capacitor c=3.2182e-17
C4 (ExtVDD VSS) capacitor c=1.40172e-16
C5 (Yint VSS) capacitor c=3.76744e-17
C6 (Ab VSS) capacitor c=1.5527e-16
C7 (ison VSS) capacitor c=3.91171e-17
C8 (Ybint VSS) capacitor c=2.67629e-17
C9 (GatedVSS VSS) capacitor c=3.54616e-17
C10 (\6\:Ybint VSS) capacitor c=4.25602e-17
C11 (\1\:ISO VSS) capacitor c=2.49529e-17
C12 (\4\:Yint VSS) capacitor c=2.7218e-17
C13 (\9\:A VSS) capacitor c=4.9305e-17
C14 (\3\:Ybint VSS) capacitor c=2.60416e-17
C15 (\1\:A VSS) capacitor c=2.07422e-16
C16 (\4\:ISO VSS) capacitor c=5.78774e-17
C17 (\10\:A VSS) capacitor c=2.4381e-17
C18 (\7\:Ybint VSS) capacitor c=3.76917e-17
C19 (\5\:Ybint VSS) capacitor c=6.86725e-18
C20 (\2\:Ybint VSS) capacitor c=2.59523e-17
C21 (\11\:ison VSS) capacitor c=3.39699e-17
C22 (\6\:ison VSS) capacitor c=1.90128e-17
C23 (\3\:ISO VSS) capacitor c=5.27828e-17
C24 (\3\:Yint VSS) capacitor c=2.4391e-17
C25 (\2\:GatedVSS VSS) capacitor c=2.92681e-17
C26 (\4\:Ab VSS) capacitor c=6.13072e-17
C27 (\6\:A VSS) capacitor c=2.23826e-17
C28 (\3\:Y VSS) capacitor c=1.14808e-16
C29 (\1\:VDD VSS) capacitor c=7.21964e-17
C30 (\19\:Ybint VSS) capacitor c=4.07521e-17
C31 (\8\:VDD VSS) capacitor c=4.40715e-17
C32 (\10\:VDD VSS) capacitor c=3.30106e-17
C33 (\11\:Yint VSS) capacitor c=5.49713e-17
C34 (\16\:ison VSS) capacitor c=3.8728e-17
C35 (\12\:VDD VSS) capacitor c=4.71773e-17
C36 (\12\:Ybint VSS) capacitor c=8.48723e-17
C37 (\14\:VDD VSS) capacitor c=5.20239e-17
C38 (\7\:Ab VSS) capacitor c=8.86668e-17
C39 (\3\:ExtVDD VSS) capacitor c=3.52558e-17
C40 (\1\:Y VSS) capacitor c=5.30917e-17
C41 (\15\:GatedVSS VSS) capacitor c=3.27112e-16
C42 (\3\:GatedVSS VSS) capacitor c=3.63819e-16
C43 (\5\:Yint VSS) capacitor c=1.89096e-16
C44 (\13\:ison VSS) capacitor c=5.14106e-17
C45 (\10\:Ab VSS) capacitor c=6.62352e-17
C46 (\8\:GatedVSS VSS) capacitor c=1.10776e-16
C47 (VDD VSS) capacitor c=4.4522e-17
C48 (\2\:Yint VSS) capacitor c=2.52602e-17
C49 (\4\:A VSS) capacitor c=1.65425e-16
C50 (\5\:A VSS) capacitor c=2.47709e-17
C51 (\2\:ison VSS) capacitor c=1.56311e-16
C52 (\4\:Ybint VSS) capacitor c=1.41313e-17
C53 (\12\:A VSS) capacitor c=4.15794e-17
C54 (\9\:Ab VSS) capacitor c=1.05619e-16
C55 (\8\:Yint VSS) capacitor c=3.8532e-17
C56 (\6\:ISO VSS) capacitor c=8.19772e-18
C57 (\8\:ISO VSS) capacitor c=2.44868e-17
C58 (\12\:ison VSS) capacitor c=5.84121e-17
C59 (\13\:Yint VSS) capacitor c=3.31745e-17
C60 (\15\:ison VSS) capacitor c=4.54304e-17
C61 (\7\:GatedVSS VSS) capacitor c=1.87295e-16
C62 (\14\:GatedVSS VSS) capacitor c=1.03867e-16
C63 (\18\:GatedVSS VSS) capacitor c=8.12454e-17
C64 (\8\:Ybint VSS) capacitor c=4.21669e-17
C65 (\9\:Ybint VSS) capacitor c=1.65644e-16
C66 (\11\:Ybint VSS) capacitor c=6.35309e-17
C67 (\18\:Ybint VSS) capacitor c=3.06331e-17
C68 (\3\:VDD VSS) capacitor c=6.45147e-17
C69 (\4\:VDD VSS) capacitor c=2.48875e-17
C70 (\6\:VDD VSS) capacitor c=2.8347e-17
C71 (\7\:VDD VSS) capacitor c=1.61801e-17
Rk49 (VDD VDD) resistor r=0.3048 c=0
Rk44 (\2\:VDD \3\:VDD) resistor r=0.4462 c=0
Rk45 (\3\:VDD \4\:VDD) resistor r=0.1593 c=0
Rk46 (\4\:VDD \6\:VDD) resistor r=0.2185 c=0
Rk48 (\7\:VDD VDD) resistor r=0.1844 c=0
Rk47 (\6\:VDD \7\:VDD) resistor r=0.03913 c=0
Rk50 (\3\:VDD \9\:VDD) resistor r=0.2979 c=0
Rk51 (\4\:VDD \11\:VDD) resistor r=0.2408 c=0
Rk52 (\7\:VDD \13\:VDD) resistor r=0.2566 c=0
Rk53 (VDD \15\:VDD) resistor r=0.2859 c=0
Rk58 (VSS VSS) resistor r=0.317 c=0
Rk57 (\6\:VSS VSS) resistor r=0.2994 c=0
Rk42 (VSS VSS) resistor r=0.2777 c=0
Rk41 (\4\:VSS VSS) resistor r=0.5895 c=0
Rk40 (\2\:VSS \4\:VSS) resistor r=0.4817 c=0
Rk43 (VSS \5\:VSS) resistor r=0.1157 c=0
Rk59 (VSS \12\:VSS) resistor r=0.07642 c=0
Rk4 (A \12\:A) resistor r=0.01985 c=0
Rk3 (\12\:A \13\:A) resistor r=0.002167 c=0
Rk13 (\5\:ISO ISO) resistor r=0.00414 c=0
Rk14 (ISO \6\:ISO) resistor r=0.00414 c=0
Rk15 (\5\:ISO \6\:ISO) resistor r=0.007372 c=0
Rk17 (\6\:ISO \8\:ISO) resistor r=0.02924 c=0
Rk16 (\7\:ISO \8\:ISO) resistor r=0.00414 c=0
Rk38 (\2\:Y Y) resistor r=0.3888 c=0
Rk39 (Y \4\:Y) resistor r=0.2155 c=0
Rk5 (ExtVDD ExtVDD) resistor r=0.01053 c=0
Rk6 (ExtVDD \2\:ExtVDD) resistor r=0.00653 c=0
Rk7 (\2\:ExtVDD \4\:ExtVDD) resistor r=0.3218 c=0
Rk11 (\5\:Yint \8\:Yint) resistor r=0.2012 c=0
Rk19 (\12\:Yint \13\:Yint) resistor r=0.2046 c=0
Rk8 (\8\:Ab \9\:Ab) resistor r=0.6832 c=0
Rk9 (\9\:Ab \11\:Ab) resistor r=0.4471 c=0
Rk18 (\12\:ison \14\:ison) resistor r=0.382 c=0
Rk20 (\15\:ison \17\:ison) resistor r=0.2456 c=0
Rk31 (\8\:Ybint \9\:Ybint) resistor r=0.2475 c=0
Rk33 (\9\:Ybint \11\:Ybint) resistor r=0.1519 c=0
Rk34 (\11\:Ybint \13\:Ybint) resistor r=0.5779 c=0
Rk37 (\18\:Ybint \20\:Ybint) resistor r=0.2764 c=0
Rk23 (\3\:GatedVSS \7\:GatedVSS) resistor r=0.356 c=0
Rk24 (\7\:GatedVSS \9\:GatedVSS) resistor r=0.7656 c=0
Rk27 (\7\:GatedVSS \14\:GatedVSS) resistor r=0.8118 c=0
Rk29 (\15\:GatedVSS \18\:GatedVSS) resistor r=1.1454 c=0
Rl21 (\4\:A \9\:A) resistor r=239.672 c=0
Rl16 (\4\:A \1\:A) resistor r=494.483 c=0
Rl22 (\5\:A \10\:A) resistor r=59.022 c=0
Rl18 (\5\:A \6\:A) resistor r=46.4864 c=0
Rl17 (\5\:A \4\:A) resistor r=192.732 c=0
Rl2 (\1\:ISO \2\:ISO) resistor r=56.5719 c=0
Rl4 (\2\:ISO \4\:ISO) resistor r=193.396 c=0
Rl3 (\2\:ISO \3\:ISO) resistor r=0.6051 c=0
Rl12 (\2\:Yint \4\:Yint) resistor r=41.7694 c=0
Rl10 (\2\:Yint Yint) resistor r=148.662 c=0
Rl11 (\2\:Yint \3\:Yint) resistor r=34.5546 c=0
Rl7 (Ab \4\:Ab) resistor r=178.013 c=0
Rl23 (\2\:ison ison) resistor r=165.444 c=0
Rl32 (\2\:ison \11\:ison) resistor r=115.398 c=0
Rl27 (\2\:ison \6\:ison) resistor r=4.4574 c=0
Rl36 (\7\:Ybint \6\:Ybint) resistor r=173.707 c=0
Rl13 (\2\:Ybint Ybint) resistor r=58.6635 c=0
Rl35 (\4\:Ybint \6\:Ybint) resistor r=90.3549 c=0
Rl33 (\4\:Ybint \3\:Ybint) resistor r=52.8549 c=0
Rl34 (\4\:Ybint \5\:Ybint) resistor r=1.2666 c=0
Rl1 (\2\:GatedVSS GatedVSS) resistor r=171.167 c=0
Rz15 (\2\:VSS \1\:VSS) resistor r=37.5 c=0
Rz14 (\1\:Y \2\:Y) resistor r=37.5 c=0
Rz2 (\11\:Ab \10\:Ab) resistor r=75 c=0
Rz5 (\14\:ison \13\:ison) resistor r=75 c=0
Rz7 (\9\:GatedVSS \8\:GatedVSS) resistor r=75 c=0
Ry10 (\1\:VDD \2\:VDD) resistor r=20.6667 c=0
Ry11 (\8\:VDD \9\:VDD) resistor r=62 c=0
Ry12 (\10\:VDD \11\:VDD) resistor r=62 c=0
Ry13 (\12\:VDD \13\:VDD) resistor r=62 c=0
Ry14 (\14\:VDD \15\:VDD) resistor r=62 c=0
Ry15 (\6\:VSS \8\:VSS) resistor r=7.75 c=0
Ry8 (\4\:VSS \3\:VSS) resistor r=7.75 c=0
Ry9 (\5\:VSS \3\:VSS) resistor r=5.1667 c=0
Ry16 (\12\:VSS \8\:VSS) resistor r=5.1667 c=0
Ry7 (\3\:Y \4\:Y) resistor r=20.6667 c=0
Ry1 (\3\:ExtVDD \4\:ExtVDD) resistor r=62 c=0
Ry3 (\12\:Yint \11\:Yint) resistor r=62 c=0
Ry2 (\8\:Ab \7\:Ab) resistor r=62 c=0
Ry4 (\17\:ison \16\:ison) resistor r=62 c=0
Ry5 (\13\:Ybint \12\:Ybint) resistor r=62 c=0
Ry6 (\20\:Ybint \19\:Ybint) resistor r=62 c=0
Rx1 (\13\:A \6\:A) resistor r=45 c=0
Rx4 (\3\:ISO \7\:ISO) resistor r=45 c=0
Rx3 (\8\:Yint \3\:Yint) resistor r=45 c=0
Rx6 (\13\:Yint Yint) resistor r=45 c=0
Rx2 (\9\:Ab \4\:Ab) resistor r=45 c=0
Rx5 (\12\:ison \6\:ison) resistor r=45 c=0
Rx7 (\15\:ison \11\:ison) resistor r=45 c=0
Rx10 (\8\:Ybint \5\:Ybint) resistor r=45 c=0
Rx11 (\11\:Ybint \2\:Ybint) resistor r=45 c=0
Rx12 (\18\:Ybint \7\:Ybint) resistor r=45 c=0
Rx8 (\14\:GatedVSS GatedVSS) resistor r=45 c=0
Rx9 (\18\:GatedVSS \2\:GatedVSS) resistor r=45 c=0
NM2 (\8\:GatedVSS \10\:A \10\:Ab VSS) g45n1svt w=(1.45e-07) l=4.5e-08 \
        nf=1 as=2.03e-14 ad=2.03e-14 ps=5.7e-07 pd=5.7e-07 nrd=1.16667 \
        nrs=1.16667 sa=1.4e-07 sb=1.4e-07 sd=160n sca=12.9138 \
        scb=0.0133404 scc=0.000640143 m=(1)
NM4 (\6\:VSS \4\:ISO \13\:ison VSS) g45n1svt w=(1.45e-07) l=4.5e-08 nf=1 \
        as=4.365e-14 ad=2.03e-14 ps=9e-07 pd=5.7e-07 nrd=1.16667 \
        nrs=1.16667 sa=1.4e-07 sb=9.9e-07 sd=160n sca=8.42104 \
        scb=0.00632542 scc=0.000106623 m=(1)
mn0 (\1\:Y \3\:Ybint \1\:VSS VSS) g45n1svt w=(2.6e-07) l=4.5e-08 nf=1 \
        as=3.64e-14 ad=3.64e-14 ps=8e-07 pd=8e-07 nrd=1.16667 nrs=1.16667 \
        sa=1.4e-07 sb=1.4e-07 sd=160n sca=15.3338 scb=0.0153436 \
        scc=0.00119435 m=(1)
NM3_1__rcx (\15\:GatedVSS \2\:ison \6\:VSS VSS) g45n1svt w=(2.6e-07) \
        l=4.5e-08 nf=1 as=4.16e-14 ad=4.081e-14 ps=8.4e-07 pd=8.45e-07 \
        nrd=1.16667 nrs=1.16667 sa=2.71058e-07 sb=7.55e-07 sd=160n \
        sca=9.14564 scb=0.00759168 scc=0.000213449 m=(4)
NM1_1__rcx (\5\:Yint Ab \3\:GatedVSS VSS) g45n1svt w=(2.6e-07) l=4.5e-08 \
        nf=1 as=4.16e-14 ad=3.987e-14 ps=8.4e-07 pd=8.2667e-07 nrd=1.16667 \
        nrs=1.16667 sa=5.5e-07 sb=7.55e-07 sd=160n sca=15.3338 \
        scb=0.0153436 scc=0.00119435 m=(3)
NM0_1__rcx (\9\:Ybint \1\:A \3\:GatedVSS VSS) g45n1svt w=(2.6e-07) \
        l=4.5e-08 nf=1 as=3.987e-14 ad=4.16e-14 ps=8.2667e-07 pd=8.4e-07 \
        nrd=1.16667 nrs=1.16667 sa=7.55e-07 sb=5.5e-07 sd=160n sca=15.3338 \
        scb=0.0153436 scc=0.00119435 m=(3)
mp0 (\3\:Y \6\:Ybint \1\:VDD VDD) g45p1svt w=(3.9e-07) l=4.5e-08 nf=1 \
        as=5.46e-14 ad=5.46e-14 ps=1.06e-06 pd=1.06e-06 nrd=1.16667 \
        nrs=1.16667 sa=1.4e-07 sb=1.4e-07 sd=160n sca=15.9223 \
        scb=0.0171758 scc=0.000582452 m=(1)
ends LSLH_ISOL_X1_TO_ON
// End of subcircuit definition.
