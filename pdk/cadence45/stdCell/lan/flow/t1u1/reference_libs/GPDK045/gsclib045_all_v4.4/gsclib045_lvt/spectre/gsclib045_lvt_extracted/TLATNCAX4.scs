// Generated for: spectre (May  1 09:19:09 2013 )
// Library name: gsclib045_lvt
// Cell name: TLATNCAX4
// View name: extracted

simulator lang=spectre

subckt TLATNCAX4 CK E ECK VDD VSS
mp0 (\9\:CKb \3\:CK \11\:VDD VDD) g45p1lvt w=(2.15e-07) l=4.5e-08 nf=1 \
        as=9.025e-14 ad=3.01e-14 ps=1.44e-06 pd=7.1e-07 nrd=1.16667 \
        nrs=1.16667 sa=1.4e-07 sb=1.36081e-06 sd=160n sca=52.4731 \
        scb=0.0379902 scc=0.00614793 m=(1)
mp1 (\14\:CKbb CKb \11\:VDD VDD) g45p1lvt w=(2.15e-07) l=4.5e-08 nf=1 \
        as=1.1785e-13 ad=3.35e-14 ps=1.9e-06 pd=8.3e-07 nrd=1.16667 \
        nrs=1.16667 sa=1.345e-06 sb=1.55814e-07 sd=160n sca=45.7906 \
        scb=0.0283307 scc=0.00588417 m=(1)
mp15 (net205 Eint \6\:VDD VDD) g45p1lvt w=(2.15e-07) l=4.5e-08 nf=1 \
        as=8.27e-14 ad=1.505e-14 ps=1.32e-06 pd=5.7e-07 nrd=1.16667 \
        nrs=1.16667 sa=5.7e-07 sb=9.35e-07 sd=160n sca=13.1637 \
        scb=0.0123476 scc=0.000501177 m=(1)
mp16 (\5\:n0 \5\:CKb net205 VDD) g45p1lvt w=(2.15e-07) l=4.5e-08 nf=1 \
        as=1.505e-14 ad=4.085e-14 ps=5.7e-07 pd=8.1e-07 nrd=1.16667 \
        nrs=1.16667 sa=6.85e-07 sb=8.2e-07 sd=160n sca=13.1637 \
        scb=0.0123476 scc=0.000501177 m=(1)
mp6 (\5\:n0 \6\:CKbb net217 VDD) g45p1lvt w=(2.15e-07) l=4.5e-08 nf=1 \
        as=2.902e-14 ad=4.085e-14 ps=7e-07 pd=8.1e-07 nrd=1.16667 \
        nrs=1.16667 sa=9.2e-07 sb=5.85e-07 sd=160n sca=13.449 \
        scb=0.0124246 scc=0.00050119 m=(1)
mp5 (net217 \1\:E \1\:VDD VDD) g45p1lvt w=(2.15e-07) l=4.5e-08 nf=1 \
        as=4.73e-14 ad=2.902e-14 ps=8.7e-07 pd=7e-07 nrd=1.16667 \
        nrs=1.16667 sa=1.1e-06 sb=4.05e-07 sd=160n sca=14.1512 \
        scb=0.0128629 scc=0.000501608 m=(1)
mp10 (\8\:Eint \4\:n0 \1\:VDD VDD) g45p1lvt w=(2.15e-07) l=4.5e-08 nf=1 \
        as=4.73e-14 ad=3.01e-14 ps=8.7e-07 pd=7.1e-07 nrd=1.16667 \
        nrs=1.16667 sa=1.365e-06 sb=1.4e-07 sd=160n sca=17.1027 \
        scb=0.0172361 scc=0.000555702 m=(1)
C1 (CK VSS) capacitor c=4.31943e-17
C2 (VDD VSS) capacitor c=2.13886e-16
C3 (E VSS) capacitor c=4.4191e-17
C4 (ECK VSS) capacitor c=1.82914e-17
C5 (CKb VSS) capacitor c=3.16673e-17
C6 (ECKb VSS) capacitor c=2.21612e-16
C7 (CKbb VSS) capacitor c=5.82706e-17
C8 (Eint VSS) capacitor c=6.56915e-17
C9 (n0 VSS) capacitor c=1.97463e-17
C10 (net254 VSS) capacitor c=1.5743e-18
C11 (net205 VSS) capacitor c=1.36479e-18
C12 (net217 VSS) capacitor c=2.42653e-18
C13 (\4\:n0 VSS) capacitor c=3.79639e-17
C14 (\1\:E VSS) capacitor c=4.02729e-17
C15 (\6\:CKbb VSS) capacitor c=4.42604e-17
C16 (\5\:CKb VSS) capacitor c=8.20556e-17
C17 (\7\:Eint VSS) capacitor c=4.05608e-17
C18 (\3\:CK VSS) capacitor c=2.28653e-17
C19 (\3\:n0 VSS) capacitor c=3.07378e-17
C20 (\3\:E VSS) capacitor c=3.94839e-17
C21 (\4\:CKb VSS) capacitor c=8.21631e-17
C22 (\4\:CKbb VSS) capacitor c=5.93026e-17
C23 (\5\:Eint VSS) capacitor c=2.73994e-17
C24 (\4\:Eint VSS) capacitor c=6.75358e-17
C25 (\3\:CKbb VSS) capacitor c=5.87765e-17
C26 (\2\:CKb VSS) capacitor c=4.22489e-17
C27 (\1\:CK VSS) capacitor c=2.67475e-17
C28 (\2\:E VSS) capacitor c=4.24082e-17
C29 (\7\:CKbb VSS) capacitor c=4.771e-17
C30 (\6\:CKb VSS) capacitor c=3.55366e-17
C31 (\5\:CKbb VSS) capacitor c=6.50455e-17
C32 (\6\:Eint VSS) capacitor c=2.70515e-17
C33 (\2\:CKbb VSS) capacitor c=3.89688e-17
C34 (\3\:CKb VSS) capacitor c=2.34635e-17
C35 (\8\:Eint VSS) capacitor c=6.03424e-17
C36 (\1\:VDD VSS) capacitor c=3.14456e-17
C37 (\5\:n0 VSS) capacitor c=6.55236e-17
C38 (\6\:VDD VSS) capacitor c=3.19577e-17
C39 (\14\:ECKb VSS) capacitor c=1.1604e-16
C40 (\9\:VDD VSS) capacitor c=1.3558e-17
C41 (\14\:CKbb VSS) capacitor c=3.39994e-17
C42 (\1\:ECK VSS) capacitor c=1.23211e-16
C43 (\9\:CKb VSS) capacitor c=1.30344e-16
C44 (\3\:VDD VSS) capacitor c=4.4756e-17
C45 (\10\:Eint VSS) capacitor c=1.97762e-16
C46 (\8\:n0 VSS) capacitor c=5.0885e-17
C47 (\18\:ECKb VSS) capacitor c=8.5705e-17
C48 (\12\:CKbb VSS) capacitor c=3.88629e-17
C49 (\6\:ECK VSS) capacitor c=1.01746e-16
C50 (\11\:CKb VSS) capacitor c=3.38572e-17
C51 (\2\:CK VSS) capacitor c=2.79655e-17
C52 (\2\:Eint VSS) capacitor c=3.31489e-17
C53 (\3\:Eint VSS) capacitor c=3.72051e-17
C54 (\2\:n0 VSS) capacitor c=3.04855e-17
C55 (\5\:CK VSS) capacitor c=7.38506e-17
C56 (\16\:ECKb VSS) capacitor c=1.44647e-16
C57 (\17\:ECKb VSS) capacitor c=5.34955e-17
C58 (\7\:CKb VSS) capacitor c=9.89407e-17
C59 (\8\:CKb VSS) capacitor c=2.27857e-16
C60 (\8\:CKbb VSS) capacitor c=5.38743e-17
C61 (\9\:CKbb VSS) capacitor c=4.07149e-17
C62 (\10\:CKbb VSS) capacitor c=3.93805e-17
C63 (\11\:CKbb VSS) capacitor c=3.61221e-17
C64 (\4\:E VSS) capacitor c=6.7291e-17
C65 (\7\:n0 VSS) capacitor c=1.1576e-16
C66 (\10\:n0 VSS) capacitor c=7.7575e-17
C67 (\12\:Eint VSS) capacitor c=9.48057e-17
C68 (\5\:VDD VSS) capacitor c=2.91847e-17
C69 (\8\:VDD VSS) capacitor c=1.46769e-17
C70 (\11\:VDD VSS) capacitor c=1.09169e-16
Rk1 (CK \5\:CK) resistor r=0.08278 c=0
Rk24 (\2\:VSS \4\:VSS) resistor r=0.2519 c=0
Rk25 (\4\:VSS \5\:VSS) resistor r=0.4558 c=0
Rk30 (\6\:VSS VSS) resistor r=0.1925 c=0
Rk26 (\5\:VSS \6\:VSS) resistor r=0.3855 c=0
Rk31 (\5\:VSS \11\:VSS) resistor r=0.3213 c=0
Rk35 (\2\:VDD \4\:VDD) resistor r=0.3703 c=0
Rk36 (\4\:VDD \5\:VDD) resistor r=0.3757 c=0
Rk37 (\5\:VDD \7\:VDD) resistor r=0.155 c=0
Rk38 (\5\:VDD \8\:VDD) resistor r=0.2201 c=0
Rk39 (\8\:VDD \10\:VDD) resistor r=0.07334 c=0
Rk47 (\11\:VDD VDD) resistor r=0.1674 c=0
Rk40 (\8\:VDD \11\:VDD) resistor r=0.2176 c=0
Rk18 (E \4\:E) resistor r=0.05396 c=0
Rk4 (\1\:ECK ECK) resistor r=0.04575 c=0
Rk5 (ECK \6\:ECK) resistor r=0.2023 c=0
Rk10 (\7\:CKb \8\:CKb) resistor r=0.7902 c=0
Rk11 (\8\:CKb \10\:CKb) resistor r=1.162 c=0
Rk12 (\10\:CKb \12\:CKb) resistor r=0.275 c=0
Rk7 (\15\:ECKb \16\:ECKb) resistor r=0.6843 c=0
Rk8 (\16\:ECKb \17\:ECKb) resistor r=0.2716 c=0
Rk9 (\16\:ECKb \19\:ECKb) resistor r=0.5695 c=0
Rk13 (\8\:CKbb \9\:CKbb) resistor r=0.2276 c=0
Rk14 (\9\:CKbb \10\:CKbb) resistor r=0.3206 c=0
Rk15 (\10\:CKbb \11\:CKbb) resistor r=0.1225 c=0
Rk16 (\11\:CKbb \13\:CKbb) resistor r=0.2449 c=0
Rk17 (\11\:CKbb \15\:CKbb) resistor r=0.08284 c=0
Rk22 (\9\:Eint \11\:Eint) resistor r=0.7356 c=0
Rk23 (\11\:Eint \12\:Eint) resistor r=0.8497 c=0
Rk19 (\6\:n0 \7\:n0) resistor r=0.4438 c=0
Rk20 (\7\:n0 \9\:n0) resistor r=0.303 c=0
Rk21 (\7\:n0 \10\:n0) resistor r=0.4419 c=0
Rl2 (\2\:CK \3\:CK) resistor r=63.1801 c=0
Rl1 (\1\:CK \2\:CK) resistor r=40.1031 c=0
Rl3 (\2\:CK \4\:CK) resistor r=3.3229 c=0
Rl30 (\1\:E \2\:E) resistor r=72.3097 c=0
Rl31 (\2\:E \3\:E) resistor r=99.2328 c=0
Rl27 (\4\:CKb \5\:CKb) resistor r=232.258 c=0
Rl16 (CKb \2\:CKb) resistor r=100 c=0
Rl28 (\5\:CKb \6\:CKb) resistor r=24.2328 c=0
Rl17 (CKb \3\:CKb) resistor r=49.2328 c=0
Rl29 (\6\:CKbb \7\:CKbb) resistor r=57.6695 c=0
Rl26 (\4\:CKbb \5\:CKbb) resistor r=92.9995 c=0
Rl18 (CKbb \2\:CKbb) resistor r=66.5405 c=0
Rl19 (\2\:CKbb \3\:CKbb) resistor r=58.8482 c=0
Rl24 (\5\:Eint \6\:Eint) resistor r=26.1559 c=0
Rl20 (Eint \2\:Eint) resistor r=90.3625 c=0
Rl23 (\2\:Eint \5\:Eint) resistor r=153.528 c=0
Rl25 (\3\:Eint \7\:Eint) resistor r=30.4507 c=0
Rl22 (\3\:Eint \4\:Eint) resistor r=144.209 c=0
Rl21 (\2\:Eint \3\:Eint) resistor r=36.9286 c=0
Rl34 (\2\:n0 \4\:n0) resistor r=143.11 c=0
Rl33 (\2\:n0 \3\:n0) resistor r=46.9565 c=0
Rl32 (n0 \2\:n0) resistor r=16.2005 c=0
Rz8 (\2\:VSS \1\:VSS) resistor r=75 c=0
Rz9 (\11\:VSS \10\:VSS) resistor r=75 c=0
Rz13 (\4\:VDD \3\:VDD) resistor r=12.5 c=0
Rz14 (\11\:VDD \3\:VDD) resistor r=6.25 c=0
Rz4 (\11\:CKb \12\:CKb) resistor r=75 c=0
Rz3 (\19\:ECKb \18\:ECKb) resistor r=75 c=0
Rz5 (\12\:CKbb \13\:CKbb) resistor r=75 c=0
Rz7 (\10\:Eint \11\:Eint) resistor r=75 c=0
Rz6 (\8\:n0 \9\:n0) resistor r=75 c=0
Ry8 (\4\:VSS \3\:VSS) resistor r=10.3333 c=0
Ry9 (\6\:VSS \3\:VSS) resistor r=5.1667 c=0
Ry10 (\2\:VDD \1\:VDD) resistor r=62 c=0
Ry11 (\7\:VDD \6\:VDD) resistor r=62 c=0
Ry12 (\10\:VDD \9\:VDD) resistor r=62 c=0
Ry4 (\9\:CKb \10\:CKb) resistor r=62 c=0
Ry3 (\15\:ECKb \14\:ECKb) resistor r=62 c=0
Ry5 (\14\:CKbb \15\:CKbb) resistor r=62 c=0
Ry7 (\8\:Eint \9\:Eint) resistor r=62 c=0
Ry6 (\5\:n0 \6\:n0) resistor r=62 c=0
Rx1 (\4\:CK \5\:CK) resistor r=45 c=0
Rx8 (\2\:E \4\:E) resistor r=45 c=0
Rx3 (\6\:CKb \7\:CKb) resistor r=45 c=0
Rx4 (\3\:CKb \8\:CKb) resistor r=45 c=0
Rx2 (\17\:ECKb ECKb) resistor r=45 c=0
Rx5 (\7\:CKbb \8\:CKbb) resistor r=45 c=0
Rx6 (\5\:CKbb \9\:CKbb) resistor r=45 c=0
Rx7 (\2\:CKbb \10\:CKbb) resistor r=45 c=0
Rx10 (\6\:Eint \12\:Eint) resistor r=45 c=0
Rx9 (n0 \10\:n0) resistor r=45 c=0
mn0 (\11\:CKb \1\:CK \6\:VSS VSS) g45n1lvt w=(1.45e-07) l=4.5e-08 nf=1 \
        as=4.8e-14 ad=2.32e-14 ps=9.6e-07 pd=6.1e-07 nrd=1.16667 \
        nrs=1.16667 sa=1.6e-07 sb=1.355e-06 sd=160n sca=19.8813 \
        scb=0.0206549 scc=0.00197265 m=(1)
mn1 (\12\:CKbb \2\:CKb \6\:VSS VSS) g45n1lvt w=(1.45e-07) l=4.5e-08 nf=1 \
        as=5.162e-14 ad=2.465e-14 ps=1.01e-06 pd=6.3e-07 nrd=1.16667 \
        nrs=1.16667 sa=1.345e-06 sb=1.7e-07 sd=160n sca=19.8813 \
        scb=0.0206549 scc=0.00197265 m=(1)
mn15 (net230 \5\:Eint \10\:VSS VSS) g45n1lvt w=(1.45e-07) l=4.5e-08 nf=1 \
        as=3.47e-14 ad=1.812e-14 ps=8.4e-07 pd=5.4e-07 nrd=1.16667 \
        nrs=1.16667 sa=4.5e-07 sb=1.095e-06 sd=160n sca=11.4452 \
        scb=0.0112553 scc=0.00042156 m=(1)
mn16 (\8\:n0 \4\:CKbb net230 VSS) g45n1lvt w=(1.45e-07) l=4.5e-08 nf=1 \
        as=1.812e-14 ad=2.755e-14 ps=5.4e-07 pd=6.7e-07 nrd=1.16667 \
        nrs=1.16667 sa=6.2e-07 sb=9.25e-07 sd=160n sca=11.4452 \
        scb=0.0112553 scc=0.00042156 m=(1)
mn6 (\8\:n0 \4\:CKb net254 VSS) g45n1lvt w=(1.45e-07) l=4.5e-08 nf=1 \
        as=3.48e-14 ad=2.755e-14 ps=7.7e-07 pd=6.7e-07 nrd=1.16667 \
        nrs=1.16667 sa=8.55e-07 sb=6.9e-07 sd=160n sca=11.4452 \
        scb=0.0112553 scc=0.00042156 m=(1)
mn5 (net254 \3\:E \1\:VSS VSS) g45n1lvt w=(1.45e-07) l=4.5e-08 nf=1 \
        as=4.75e-14 ad=3.48e-14 ps=9.9e-07 pd=7.7e-07 nrd=1.16667 \
        nrs=1.16667 sa=1.14e-06 sb=4.05e-07 sd=160n sca=11.4452 \
        scb=0.0112553 scc=0.00042156 m=(1)
mn10 (\10\:Eint \3\:n0 \1\:VSS VSS) g45n1lvt w=(1.45e-07) l=4.5e-08 nf=1 \
        as=4.75e-14 ad=2.03e-14 ps=9.9e-07 pd=5.7e-07 nrd=1.16667 \
        nrs=1.16667 sa=1.405e-06 sb=1.4e-07 sd=160n sca=11.4452 \
        scb=0.0112553 scc=0.00042156 m=(1)
mn21 (\18\:ECKb \3\:CKbb net238 VSS) g45n1lvt w=(2.6e-07) l=4.5e-08 nf=1 \
        as=1.56e-14 ad=3.64e-14 ps=6.4e-07 pd=8e-07 nrd=1.16667 \
        nrs=1.16667 sa=1.4e-07 sb=8.74231e-07 sd=160n sca=17.5885 \
        scb=0.0172826 scc=0.00162584 m=(1)
mn20 (net238 \4\:Eint \10\:VSS VSS) g45n1lvt w=(2.6e-07) l=4.5e-08 nf=1 \
        as=3.47e-14 ad=1.56e-14 ps=8.4e-07 pd=6.4e-07 nrd=1.16667 \
        nrs=1.16667 sa=2.45e-07 sb=7.69231e-07 sd=160n sca=17.5885 \
        scb=0.0172826 scc=0.00162584 m=(1)
mn22_1__rcx (\6\:ECK ECKb \6\:VSS VSS) g45n1lvt w=(2.6e-07) l=4.5e-08 \
        nf=1 as=4.766e-14 ad=4.16e-14 ps=9.275e-07 pd=8.4e-07 nrd=1.16667 \
        nrs=1.16667 sa=2.98942e-07 sb=9.48462e-07 sd=160n sca=15.3338 \
        scb=0.0153436 scc=0.00119435 m=(4)
mp21 (\14\:ECKb CKbb \9\:VDD VDD) g45p1lvt w=(3.9e-07) l=4.5e-08 nf=1 \
        as=6.41e-14 ad=6.24e-14 ps=1.48e-06 pd=1.1e-06 nrd=1.16667 \
        nrs=1.16667 sa=1.08974e-07 sb=9.41923e-07 sd=160n sca=11.9453 \
        scb=0.010292 scc=0.000333254 m=(1)
mp20 (\14\:ECKb \7\:Eint \6\:VDD VDD) g45p1lvt w=(3.9e-07) l=4.5e-08 \
        nf=1 as=8.27e-14 ad=6.24e-14 ps=1.32e-06 pd=1.1e-06 nrd=1.16667 \
        nrs=1.16667 sa=3.13974e-07 sb=7.36923e-07 sd=160n sca=11.9453 \
        scb=0.010292 scc=0.000333254 m=(1)
mp22_1__rcx (\1\:ECK ECKb \11\:VDD VDD) g45p1lvt w=(3.9e-07) l=4.5e-08 \
        nf=1 as=9.973e-14 ad=6.24e-14 ps=1.525e-06 pd=1.1e-06 nrd=1.16667 \
        nrs=1.16667 sa=2.99551e-07 sb=9.83269e-07 sd=160n sca=32.0868 \
        scb=0.0213516 scc=0.00336326 m=(4)
ends TLATNCAX4
// End of subcircuit definition.
