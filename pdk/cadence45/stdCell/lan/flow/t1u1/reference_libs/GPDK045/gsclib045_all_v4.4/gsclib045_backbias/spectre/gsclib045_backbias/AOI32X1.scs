// gsclib045_backbias/AOI32X1/schematic

simulator lang=spectre

subckt AOI32X1 A0 A1 A2 B0 B1 Y VSS NW VDD
mn3 (net118 B0 VSS VSS) g45n1svt w=(260n) l=45n nf=1 m=(1)
mn2 (Y A2 net126 VSS) g45n1svt w=(260n) l=45n nf=1 m=(1)
mn0 (net122 A0 VSS VSS) g45n1svt w=(260n) l=45n nf=1 m=(1)
mn1 (net126 A1 net122 VSS) g45n1svt w=(260n) l=45n nf=1 m=(1)
mn4 (Y B1 net118 VSS) g45n1svt w=(260n) l=45n nf=1 m=(1)
mp3 (Y B0 net114 NW) g45p1svt w=(390n) l=45n nf=1 m=(1)
mp4 (Y B1 net114 NW) g45p1svt w=(390n) l=45n nf=1 m=(1)
mp2 (net114 A2 VDD NW) g45p1svt w=(390n) l=45n nf=1 m=(1)
mp1 (net114 A1 VDD NW) g45p1svt w=(390n) l=45n nf=1 m=(1)
mp0 (net114 A0 VDD NW) g45p1svt w=(390n) l=45n nf=1 m=(1)
ends AOI32X1
