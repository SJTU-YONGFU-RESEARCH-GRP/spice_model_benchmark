// gsclib045_hvt/NAND2X2/schematic

simulator lang=spectre

subckt NAND2X2 A B Y VDD VSS
mp1 (Y B VDD VDD) g45p1hvt w=(780n) l=45n nf=1 m=(1)
mp0 (Y A VDD VDD) g45p1hvt w=(780n) l=45n nf=1 m=(1)
mn1 (Y B n0 VSS) g45n1hvt w=(520n) l=45n nf=1 m=(1)
mn0 (n0 A VSS VSS) g45n1hvt w=(520n) l=45n nf=1 m=(1)
ends NAND2X2
