// Generated for: spectre (May  1 08:16:30 2013 )
// Library name: gsclib045
// Cell name: NOR4BX2
// View name: extracted

simulator lang=spectre

subckt NOR4BX2 AN B C D VDD VSS Y
mp0 (\12\:n0 \1\:AN \8\:VDD VDD) g45p1svt w=(2.15e-07) l=4.5e-08 nf=1 \
        as=6.128e-14 ad=3.41e-14 ps=1e-06 pd=8.4e-07 nrd=1.16667 \
        nrs=1.16667 sa=2.85e-07 sb=1.58605e-07 sd=160n sca=36.537 \
        scb=0.0294967 scc=0.00430052 m=(1)
C1 (C VSS) capacitor c=4.08597e-17
C2 (Y VSS) capacitor c=1.65728e-16
C3 (VDD VSS) capacitor c=1.6905e-16
C4 (B VSS) capacitor c=5.31962e-17
C5 (AN VSS) capacitor c=3.81284e-17
C6 (D VSS) capacitor c=5.73956e-17
C7 (n0 VSS) capacitor c=7.03165e-17
C8 (n1 VSS) capacitor c=2.18383e-16
C9 (n2 VSS) capacitor c=9.82708e-17
C10 (n3 VSS) capacitor c=1.91683e-16
C11 (\1\:D VSS) capacitor c=8.5314e-17
C12 (\1\:C VSS) capacitor c=1.12004e-16
C13 (\1\:AN VSS) capacitor c=2.3598e-17
C14 (\1\:B VSS) capacitor c=7.66721e-17
C15 (\3\:AN VSS) capacitor c=2.49397e-17
C16 (\3\:D VSS) capacitor c=1.46504e-17
C17 (\3\:B VSS) capacitor c=1.0583e-16
C18 (\3\:n0 VSS) capacitor c=1.21537e-17
C19 (\2\:AN VSS) capacitor c=1.9221e-17
C20 (\10\:Y VSS) capacitor c=1.81052e-16
C21 (\3\:n2 VSS) capacitor c=9.19337e-17
C22 (\6\:VDD VSS) capacitor c=4.34258e-17
C23 (\12\:n0 VSS) capacitor c=1.49795e-17
C24 (\8\:VDD VSS) capacitor c=2.64843e-17
C25 (\1\:VDD VSS) capacitor c=9.93031e-17
C26 (\1\:Y VSS) capacitor c=4.45821e-17
C27 (\3\:Y VSS) capacitor c=7.07905e-17
C28 (\5\:Y VSS) capacitor c=3.83825e-17
C29 (\8\:Y VSS) capacitor c=2.93229e-17
C30 (\10\:n0 VSS) capacitor c=2.28354e-17
C31 (\4\:n0 VSS) capacitor c=8.0428e-17
C32 (\3\:C VSS) capacitor c=8.84287e-17
C33 (\4\:D VSS) capacitor c=7.58433e-17
C34 (\4\:AN VSS) capacitor c=4.96369e-17
C35 (\8\:n0 VSS) capacitor c=2.38369e-17
C36 (\9\:n0 VSS) capacitor c=3.39246e-17
C37 (\7\:B VSS) capacitor c=5.91421e-17
C38 (\7\:C VSS) capacitor c=7.74179e-17
C39 (\7\:Y VSS) capacitor c=3.6029e-17
C40 (\8\:D VSS) capacitor c=3.67188e-17
C41 (\4\:VDD VSS) capacitor c=1.49414e-17
C42 (\5\:VDD VSS) capacitor c=8.82321e-18
Rk21 (\2\:VSS \3\:VSS) resistor r=0.05493 c=0
Rk30 (\14\:VSS VSS) resistor r=0.1123 c=0
Rk29 (\3\:VSS \14\:VSS) resistor r=0.2276 c=0
Rk33 (\14\:VSS \20\:VSS) resistor r=0.362 c=0
Rk9 (C \7\:C) resistor r=0.06779 c=0
Rk10 (\2\:Y \4\:Y) resistor r=0.2725 c=0
Rk11 (\4\:Y \6\:Y) resistor r=0.2954 c=0
Rk14 (\7\:Y Y) resistor r=0.2136 c=0
Rk12 (\6\:Y \7\:Y) resistor r=0.07033 c=0
Rk13 (\7\:Y \9\:Y) resistor r=0.2141 c=0
Rk15 (Y \11\:Y) resistor r=0.9982 c=0
Rk34 (\2\:VDD \3\:VDD) resistor r=0.7016 c=0
Rk35 (\3\:VDD \4\:VDD) resistor r=0.1351 c=0
Rk37 (\5\:VDD VDD) resistor r=0.03965 c=0
Rk36 (\4\:VDD \5\:VDD) resistor r=0.3755 c=0
Rk38 (\4\:VDD \7\:VDD) resistor r=0.2191 c=0
Rk39 (\5\:VDD \9\:VDD) resistor r=0.3985 c=0
Rk7 (\7\:B B) resistor r=0.1211 c=0
Rk1 (\4\:AN AN) resistor r=0.1719 c=0
Rk16 (\8\:D \9\:D) resistor r=0.01775 c=0
Rk17 (\10\:D D) resistor r=0.01788 c=0
Rk18 (\9\:D \10\:D) resistor r=0.04313 c=0
Rk2 (\8\:n0 \9\:n0) resistor r=0.1459 c=0
Rk3 (\9\:n0 \11\:n0) resistor r=0.1384 c=0
Rk4 (\9\:n0 \13\:n0) resistor r=0.09946 c=0
Rk8 (\2\:n2 \4\:n2) resistor r=0.5221 c=0
Rl15 (\3\:C \1\:C) resistor r=62.4901 c=0
Rl10 (\3\:B \1\:B) resistor r=29.4415 c=0
Rl1 (\1\:AN \2\:AN) resistor r=35.7713 c=0
Rl2 (\2\:AN \3\:AN) resistor r=37.6944 c=0
Rl20 (\1\:D \3\:D) resistor r=78.2445 c=0
Rl21 (\4\:D \3\:D) resistor r=4.3511 c=0
Rl4 (\3\:n0 n0) resistor r=59.5407 c=0
Rl5 (\4\:n0 \3\:n0) resistor r=12.1383 c=0
Rz11 (\20\:VSS \19\:VSS) resistor r=75 c=0
Rz2 (\2\:Y \1\:Y) resistor r=75 c=0
Rz3 (\4\:Y \3\:Y) resistor r=75 c=0
Rz4 (\6\:Y \5\:Y) resistor r=75 c=0
Rz5 (\9\:Y \8\:Y) resistor r=75 c=0
Rz12 (\2\:VDD \1\:VDD) resistor r=37.5 c=0
Rz13 (\3\:VDD \1\:VDD) resistor r=6.25 c=0
Rz1 (\11\:n0 \10\:n0) resistor r=75 c=0
Ry11 (\2\:VSS \1\:VSS) resistor r=31 c=0
Ry12 (\3\:VSS \1\:VSS) resistor r=5.1667 c=0
Ry7 (\11\:Y \10\:Y) resistor r=62 c=0
Ry13 (\7\:VDD \6\:VDD) resistor r=62 c=0
Ry14 (\9\:VDD \8\:VDD) resistor r=62 c=0
Ry1 (\13\:n0 \12\:n0) resistor r=62 c=0
Ry5 (\2\:n2 n2) resistor r=62 c=0
Ry6 (\4\:n2 \3\:n2) resistor r=62 c=0
Rx4 (\7\:C \1\:C) resistor r=45 c=0
Rx3 (\7\:B \3\:B) resistor r=45 c=0
Rx1 (\2\:AN \4\:AN) resistor r=45 c=0
Rx5 (\8\:D \3\:D) resistor r=45 c=0
Rx2 (\8\:n0 \3\:n0) resistor r=45 c=0
mn0 (\10\:n0 \3\:AN \19\:VSS VSS) g45n1svt w=(1.45e-07) l=4.5e-08 nf=1 \
        as=2.03e-14 ad=2.973e-14 ps=5.7e-07 pd=7e-07 nrd=1.16667 \
        nrs=1.16667 sa=1.4e-07 sb=2.05e-07 sd=160n sca=23.279 \
        scb=0.0230742 scc=0.00267719 m=(1)
mn1_1__rcx (\8\:Y n0 \3\:VSS VSS) g45n1svt w=(2.6e-07) l=4.5e-08 nf=1 \
        as=4.263e-14 ad=4.16e-14 ps=1.035e-06 pd=8.4e-07 nrd=1.16667 \
        nrs=1.16667 sa=1e-07 sb=1.615e-06 sd=160n sca=8.81533 \
        scb=0.00706435 scc=0.000179997 m=(2)
mn2 (\5\:Y \1\:B \3\:VSS VSS) g45n1svt w=(2.6e-07) l=4.5e-08 nf=1 \
        as=4.68e-14 ad=4.16e-14 ps=8.8e-07 pd=8.4e-07 nrd=1.16667 \
        nrs=1.16667 sa=5.1e-07 sb=1.205e-06 sd=160n sca=8.81533 \
        scb=0.00706435 scc=0.000179997 m=(2)
mn3_1__rcx (\3\:Y \3\:C \3\:VSS VSS) g45n1svt w=(2.6e-07) l=4.5e-08 nf=1 \
        as=4.68e-14 ad=4.16e-14 ps=8.8e-07 pd=8.4e-07 nrd=1.16667 \
        nrs=1.16667 sa=9.6e-07 sb=7.55e-07 sd=160n sca=8.81533 \
        scb=0.00706435 scc=0.000179997 m=(2)
mn4 (\1\:Y \4\:D \3\:VSS VSS) g45n1svt w=(2.6e-07) l=4.5e-08 nf=1 \
        as=3.9e-14 ad=4.16e-14 ps=8.2e-07 pd=8.4e-07 nrd=1.16667 \
        nrs=1.16667 sa=1.37e-06 sb=3.45e-07 sd=160n sca=8.81533 \
        scb=0.00706435 scc=0.000179997 m=(2)
mp2_1__rcx (n2 \3\:B n1 VDD) g45p1svt w=(3.9e-07) l=4.5e-08 nf=1 \
        as=5.85e-14 ad=6.24e-14 ps=1.08e-06 pd=1.1e-06 nrd=1.16667 \
        nrs=1.16667 sa=5.35641e-07 sb=3.45e-07 sd=160n sca=13.5671 \
        scb=0.012183 scc=0.000647513 m=(2)
mp4_1__rcx (\10\:Y \1\:D n3 VDD) g45p1svt w=(3.9e-07) l=4.5e-08 nf=1 \
        as=5.85e-14 ad=6.24e-14 ps=1.08e-06 pd=1.1e-06 nrd=1.16667 \
        nrs=1.16667 sa=5.5e-07 sb=3.45e-07 sd=160n sca=17.0995 \
        scb=0.0163575 scc=0.000685689 m=(2)
mp1_1__rcx (n1 \4\:n0 \6\:VDD VDD) g45p1svt w=(3.9e-07) l=4.5e-08 nf=1 \
        as=6.24e-14 ad=5.57e-14 ps=1.1e-06 pd=1.08e-06 nrd=1.16667 \
        nrs=1.16667 sa=1.25641e-07 sb=7.55e-07 sd=160n sca=13.7988 \
        scb=0.0122414 scc=0.000647521 m=(2)
mp3_1__rcx (n3 \1\:C \3\:n2 VDD) g45p1svt w=(3.9e-07) l=4.5e-08 nf=1 \
        as=6.24e-14 ad=5.85e-14 ps=1.1e-06 pd=1.08e-06 nrd=1.16667 \
        nrs=1.16667 sa=1.4e-07 sb=7.55e-07 sd=160n sca=13.895 \
        scb=0.0122763 scc=0.000647531 m=(2)
ends NOR4BX2
// End of subcircuit definition.
