// gsclib045_hvt/CLKBUFX20/schematic

simulator lang=spectre

subckt CLKBUFX20 A Y VSS VDD
mp1 (Y net44 VDD VDD) g45p1hvt w=(7.815u) l=45n nf=1 m=(1)
mp0 (net44 A VDD VDD) g45p1hvt w=(1.95u) l=45n nf=1 m=(1)
mn1 (Y net44 VSS VSS) g45n1hvt w=(5.185u) l=45n nf=1 m=(1)
mn0 (net44 A VSS VSS) g45n1hvt w=(1.3u) l=45n nf=1 m=(1)
ends CLKBUFX20
