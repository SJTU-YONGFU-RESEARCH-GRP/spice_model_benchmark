// Generated for: spectre (May  1 11:32:05 2013 )
// Library name: gsclib045_backbias
// Cell name: OR4X8
// View name: extracted

simulator lang=spectre

subckt OR4X8 A B C D NW VDD VSS Y
mp0_1__rcx (2 \1\:A \13\:VDD NW) g45p1svt w=(3.9e-07) l=4.5e-08 nf=1 \
        as=5.46e-14 ad=2.34e-14 ps=1.06e-06 pd=9e-07 nrd=1.16667 \
        nrs=1.16667 sa=1.4e-07 sb=1.85596e-06 sd=160n sca=15.9946 \
        scb=0.0153756 scc=0.000392843 m=(1)
mp1_1__rcx (3 \1\:B 2 NW) g45p1svt w=(3.9e-07) l=4.5e-08 nf=1 as=2.34e-14 \
        ad=6.825e-14 ps=9e-07 pd=1.13e-06 nrd=1.16667 nrs=1.16667 \
        sa=2.45e-07 sb=1.82769e-06 sd=160n sca=14.2697 scb=0.0124687 \
        scc=0.000342275 m=(1)
mp2_1__rcx (3 \1\:C 5 NW) g45p1svt w=(3.9e-07) l=4.5e-08 nf=1 as=9.36e-14 \
        ad=6.825e-14 ps=1.26e-06 pd=1.13e-06 nrd=1.16667 nrs=1.16667 \
        sa=4.65e-07 sb=1.76846e-06 sd=160n sca=12.6655 scb=0.010598 \
        scc=0.000333408 m=(1)
mp3_1__rcx (\35\:n0 \5\:D 5 NW) g45p1svt w=(3.9e-07) l=4.5e-08 nf=1 \
        as=9.36e-14 ad=6.24e-14 ps=1.26e-06 pd=1.1e-06 nrd=1.16667 \
        nrs=1.16667 sa=7.5e-07 sb=1.69173e-06 sd=160n sca=11.9453 \
        scb=0.010292 scc=0.000333254 m=(1)
mp3 (\35\:n0 \1\:D 8 NW) g45p1svt w=(3.9e-07) l=4.5e-08 nf=1 as=4.485e-14 \
        ad=6.24e-14 ps=1.01e-06 pd=1.1e-06 nrd=1.16667 nrs=1.16667 \
        sa=9.55e-07 sb=1.63654e-06 sd=160n sca=11.9453 scb=0.010292 \
        scc=0.000333254 m=(1)
mp2 (8 \4\:C 7 NW) g45p1svt w=(3.9e-07) l=4.5e-08 nf=1 as=5.265e-14 \
        ad=4.485e-14 ps=1.05e-06 pd=1.01e-06 nrd=1.16667 nrs=1.16667 \
        sa=1.115e-06 sb=1.56423e-06 sd=160n sca=11.9453 scb=0.010292 \
        scc=0.000333254 m=(1)
mp1 (6 \6\:B 7 NW) g45p1svt w=(3.9e-07) l=4.5e-08 nf=1 as=5.265e-14 \
        ad=3.705e-14 ps=1.05e-06 pd=9.7e-07 nrd=1.16667 nrs=1.16667 \
        sa=1.295e-06 sb=1.38423e-06 sd=160n sca=11.9453 scb=0.010292 \
        scc=0.000333254 m=(1)
mp0 (6 \6\:A \1\:VDD NW) g45p1svt w=(3.9e-07) l=4.5e-08 nf=1 \
        as=1.1957e-13 ad=3.705e-14 ps=1.91e-06 pd=9.7e-07 nrd=1.16667 \
        nrs=1.16667 sa=1.435e-06 sb=1.24423e-06 sd=160n sca=11.9453 \
        scb=0.010292 scc=0.000333254 m=(1)
C1 (NW VSS) capacitor c=4.26671e-16
C2 (Y VSS) capacitor c=1.18449e-17
C3 (B VSS) capacitor c=3.1419e-17
C4 (VDD VSS) capacitor c=2.89746e-17
C5 (C VSS) capacitor c=9.44537e-17
C6 (D VSS) capacitor c=9.06344e-17
C7 (A VSS) capacitor c=6.00282e-16
C8 (n0 VSS) capacitor c=5.71125e-16
C9 (2 VSS) capacitor c=2.7576e-18
C10 (3 VSS) capacitor c=6.37875e-18
C11 (5 VSS) capacitor c=1.06733e-17
C12 (8 VSS) capacitor c=6.15809e-18
C13 (7 VSS) capacitor c=7.60329e-18
C14 (6 VSS) capacitor c=5.85e-18
C15 (\6\:A VSS) capacitor c=6.71464e-17
C16 (\6\:B VSS) capacitor c=6.13515e-17
C17 (\4\:C VSS) capacitor c=8.6396e-17
C18 (\1\:D VSS) capacitor c=5.21353e-17
C19 (\5\:D VSS) capacitor c=3.53078e-17
C20 (\1\:C VSS) capacitor c=4.35133e-17
C21 (\1\:B VSS) capacitor c=7.08209e-17
C22 (\1\:A VSS) capacitor c=6.30287e-17
C23 (\2\:D VSS) capacitor c=5.15847e-17
C24 (\2\:C VSS) capacitor c=2.99176e-16
C25 (\2\:B VSS) capacitor c=5.11597e-16
C26 (\1\:Y VSS) capacitor c=4.64857e-16
C27 (\1\:VDD VSS) capacitor c=5.51021e-16
C28 (\35\:n0 VSS) capacitor c=1.45833e-16
C29 (\13\:VDD VSS) capacitor c=4.01443e-17
C30 (\27\:n0 VSS) capacitor c=2.74943e-16
C31 (\3\:D VSS) capacitor c=7.18986e-17
C32 (\7\:D VSS) capacitor c=3.33432e-17
C33 (\26\:n0 VSS) capacitor c=1.44028e-16
C34 (\4\:Y VSS) capacitor c=2.0828e-16
C35 (\6\:VDD VSS) capacitor c=9.0379e-17
Rk17 (\1\:Y Y) resistor r=0.09033 c=0
Rk18 (Y \4\:Y) resistor r=0.06634 c=0
Rk5 (\2\:B B) resistor r=0.05402 c=0
Rk37 (\1\:VSS VSS) resistor r=0.03465 c=0
Rk42 (\1\:VSS \22\:VSS) resistor r=0.199 c=0
Rk49 (\6\:VDD VDD) resistor r=0.09231 c=0
Rk48 (\1\:VDD \6\:VDD) resistor r=0.7658 c=0
Rk53 (\6\:VDD \14\:VDD) resistor r=0.1936 c=0
Rk2 (C \2\:C) resistor r=0.02269 c=0
Rk1 (\7\:D D) resistor r=0.1118 c=0
Rk10 (n0 \26\:n0) resistor r=0.2011 c=0
Rk11 (\26\:n0 \27\:n0) resistor r=0.2717 c=0
Rk15 (\26\:n0 \36\:n0) resistor r=1.0799 c=0
Rl15 (\2\:B \6\:B) resistor r=24.2328 c=0
Rl3 (\2\:B \1\:B) resistor r=29.5379 c=0
Rl12 (\2\:C \4\:C) resistor r=131.461 c=0
Rl5 (\2\:C \1\:C) resistor r=56.461 c=0
Rl7 (\2\:D \1\:D) resistor r=149.977 c=0
Rl10 (\2\:D \5\:D) resistor r=130.746 c=0
Rl8 (\3\:D \2\:D) resistor r=2.7713 c=0
Rl17 (A \6\:A) resistor r=69.0258 c=0
Rl1 (A \1\:A) resistor r=48.0541 c=0
Rz14 (\22\:VSS \21\:VSS) resistor r=75 c=0
Ry12 (\14\:VDD \13\:VDD) resistor r=62 c=0
Ry1 (\36\:n0 \35\:n0) resistor r=62 c=0
Rx1 (\7\:D \2\:D) resistor r=45 c=0
mn0_1__rcx (\27\:n0 A \1\:VSS VSS) g45n1svt w=(2.6e-07) l=4.5e-08 nf=1 \
        as=4.27e-14 ad=4.55e-14 ps=8.7e-07 pd=8.7e-07 nrd=1.16667 \
        nrs=1.16667 sa=1.4e-07 sb=2e-06 sd=160n sca=9.14564 scb=0.00759168 \
        scc=0.000213449 m=(2)
mn1_1__rcx (\27\:n0 \2\:B \1\:VSS VSS) g45n1svt w=(2.6e-07) l=4.5e-08 \
        nf=1 as=4.485e-14 ad=4.55e-14 ps=8.65e-07 pd=8.7e-07 nrd=1.16667 \
        nrs=1.16667 sa=3.6e-07 sb=2e-06 sd=160n sca=9.14564 scb=0.00759168 \
        scc=0.000213449 m=(2)
mn2 (\27\:n0 \2\:C \1\:VSS VSS) g45n1svt w=(2.6e-07) l=4.5e-08 nf=1 \
        as=4.485e-14 ad=4.615e-14 ps=8.65e-07 pd=8.75e-07 nrd=1.16667 \
        nrs=1.16667 sa=5.8e-07 sb=2e-06 sd=160n sca=9.14564 scb=0.00759168 \
        scc=0.000213449 m=(2)
mn3_1__rcx (\27\:n0 \3\:D \21\:VSS VSS) g45n1svt w=(2.6e-07) l=4.5e-08 \
        nf=1 as=4.16e-14 ad=4.615e-14 ps=8.4e-07 pd=8.75e-07 nrd=1.16667 \
        nrs=1.16667 sa=8e-07 sb=2e-06 sd=160n sca=9.14564 scb=0.00759168 \
        scc=0.000213449 m=(2)
mn4_1__rcx (\4\:Y n0 \1\:VSS VSS) g45n1svt w=(2.95e-07) l=4.5e-08 nf=1 \
        as=4.746e-14 ad=4.636e-14 ps=9.1429e-07 pd=9.0429e-07 nrd=1.16667 \
        nrs=1.16667 sa=1.67322e-06 sb=1.37e-06 sd=160n sca=10.0255 \
        scb=0.00888998 scc=0.000340749 m=(7)
mp4_1__rcx (\1\:Y n0 \1\:VDD NW) g45p1svt w=(4.45e-07) l=4.5e-08 nf=1 \
        as=7.811e-14 ad=6.993e-14 ps=1.31e-06 pd=1.20429e-06 nrd=1.16667 \
        nrs=1.16667 sa=1.12792e-06 sb=1.37e-06 sd=160n sca=27.9404 \
        scb=0.0185207 scc=0.00295096 m=(7)
ends OR4X8
// End of subcircuit definition.
