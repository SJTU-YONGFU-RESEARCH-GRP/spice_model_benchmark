// Generated for: spectre (May  1 09:15:04 2013 )
// Library name: gsclib045_lvt
// Cell name: SDFFSRX1
// View name: extracted

simulator lang=spectre

subckt SDFFSRX1 CK D Q QN RN SE SI SN VDD VSS
mp57 (\1\:QN \4\:net573 \29\:VDD VDD) g45p1lvt w=(3.9e-07) l=4.5e-08 \
        nf=1 as=5.728e-14 ad=5.46e-14 ps=1.15e-06 pd=1.06e-06 nrd=1.16667 \
        nrs=1.16667 sa=1.4e-07 sb=2.48846e-07 sd=160n sca=34.4399 \
        scb=0.0250891 scc=0.0034155 m=(1)
mp55 (\1\:Q qbint \26\:VDD VDD) g45p1lvt w=(3.9e-07) l=4.5e-08 nf=1 \
        as=5.835e-14 ad=5.46e-14 ps=1.16e-06 pd=1.06e-06 nrd=1.16667 \
        nrs=1.16667 sa=1.4e-07 sb=2.51603e-07 sd=160n sca=12.53 \
        scb=0.0110214 scc=0.000443901 m=(1)
C1 (CK VSS) capacitor c=5.62586e-17
C2 (SE VSS) capacitor c=4.0188e-17
C3 (SN VSS) capacitor c=3.22418e-16
C4 (SI VSS) capacitor c=6.81016e-17
C5 (QN VSS) capacitor c=2.27442e-17
C6 (VDD VSS) capacitor c=4.99504e-16
C7 (RN VSS) capacitor c=1.13428e-16
C8 (D VSS) capacitor c=9.34936e-17
C9 (Q VSS) capacitor c=9.09667e-17
C10 (net573 VSS) capacitor c=2.30725e-17
C11 (qbint VSS) capacitor c=5.66428e-17
C12 (RNb VSS) capacitor c=5.37175e-17
C13 (n35 VSS) capacitor c=1.56855e-17
C14 (n8 VSS) capacitor c=9.07161e-17
C15 (n10 VSS) capacitor c=6.83427e-17
C16 (CKb VSS) capacitor c=4.22183e-17
C17 (mout VSS) capacitor c=6.95851e-17
C18 (CKbb VSS) capacitor c=4.38991e-17
C19 (n4 VSS) capacitor c=7.30927e-17
C20 (n20 VSS) capacitor c=5.36921e-17
C21 (Db VSS) capacitor c=6.63967e-17
C22 (n0 VSS) capacitor c=3.58747e-18
C23 (SEb VSS) capacitor c=3.46603e-17
C24 (n11 VSS) capacitor c=1.17908e-16
C25 (n9 VSS) capacitor c=1.57959e-18
C26 (n5 VSS) capacitor c=2.63396e-18
C27 (n7 VSS) capacitor c=9.53981e-19
C28 (n1 VSS) capacitor c=4.42426e-18
C29 (\7\:SE VSS) capacitor c=4.2485e-17
C30 (\3\:SI VSS) capacitor c=4.61022e-17
C31 (\1\:SE VSS) capacitor c=4.01582e-17
C32 (\4\:D VSS) capacitor c=4.73068e-17
C33 (\1\:CK VSS) capacitor c=3.41836e-17
C34 (\8\:CKb VSS) capacitor c=2.69835e-17
C35 (\7\:CKb VSS) capacitor c=6.86005e-17
C36 (\5\:SN VSS) capacitor c=6.2396e-17
C37 (\5\:RNb VSS) capacitor c=6.79361e-17
C38 (\5\:CKb VSS) capacitor c=3.63364e-17
C39 (\5\:CKbb VSS) capacitor c=6.37756e-17
C40 (\2\:RNb VSS) capacitor c=8.99091e-17
C41 (\8\:qbint VSS) capacitor c=9.70006e-17
C42 (\1\:SN VSS) capacitor c=4.18519e-17
C43 (\4\:n35 VSS) capacitor c=4.50283e-17
C44 (\1\:RN VSS) capacitor c=3.52467e-17
C45 (\7\:qbint VSS) capacitor c=3.09009e-17
C46 (\4\:net573 VSS) capacitor c=4.43707e-17
C47 (\5\:SE VSS) capacitor c=2.5707e-17
C48 (\1\:SI VSS) capacitor c=6.39182e-17
C49 (\3\:SE VSS) capacitor c=6.72329e-17
C50 (\3\:SEb VSS) capacitor c=6.66298e-17
C51 (\1\:D VSS) capacitor c=4.39588e-17
C52 (\3\:CK VSS) capacitor c=3.95678e-17
C53 (\11\:CKb VSS) capacitor c=2.49378e-17
C54 (\10\:CKb VSS) capacitor c=5.94161e-17
C55 (\3\:CKbb VSS) capacitor c=1.52417e-16
C56 (\3\:mout VSS) capacitor c=6.96952e-17
C57 (\4\:SN VSS) capacitor c=7.06495e-17
C58 (\3\:n20 VSS) capacitor c=3.88735e-17
C59 (\4\:RNb VSS) capacitor c=5.50532e-17
C60 (\4\:CKbb VSS) capacitor c=1.13689e-16
C61 (\9\:qbint VSS) capacitor c=4.60521e-17
C62 (\3\:SN VSS) capacitor c=6.10201e-17
C63 (\3\:n35 VSS) capacitor c=3.92586e-17
C64 (\3\:RN VSS) capacitor c=6.25955e-17
C65 (\5\:qbint VSS) capacitor c=3.34832e-17
C66 (\4\:qbint VSS) capacitor c=2.19185e-17
C67 (\3\:net573 VSS) capacitor c=3.53746e-17
C68 (\6\:SE VSS) capacitor c=4.50444e-17
C69 (\2\:SI VSS) capacitor c=6.25939e-17
C70 (\4\:SE VSS) capacitor c=4.91872e-17
C71 (\2\:SEb VSS) capacitor c=6.18403e-17
C72 (\2\:SE VSS) capacitor c=3.97849e-17
C73 (\3\:D VSS) capacitor c=2.24213e-17
C74 (\2\:CK VSS) capacitor c=4.69604e-17
C75 (\9\:CKb VSS) capacitor c=5.61622e-17
C76 (\6\:CKbb VSS) capacitor c=5.01993e-17
C77 (\6\:CKb VSS) capacitor c=3.24296e-17
C78 (\2\:mout VSS) capacitor c=5.80138e-17
C79 (\6\:SN VSS) capacitor c=3.2527e-17
C80 (\3\:CKb VSS) capacitor c=3.72733e-17
C81 (\6\:RNb VSS) capacitor c=2.25402e-17
C82 (\4\:CKb VSS) capacitor c=4.26252e-17
C83 (\2\:CKb VSS) capacitor c=3.44547e-17
C84 (\3\:RNb VSS) capacitor c=2.52191e-17
C85 (\10\:qbint VSS) capacitor c=2.66494e-17
C86 (\2\:SN VSS) capacitor c=4.58394e-17
C87 (\2\:RN VSS) capacitor c=4.7259e-17
C88 (\6\:qbint VSS) capacitor c=2.01122e-17
C89 (\4\:SEb VSS) capacitor c=1.40313e-17
C90 (\5\:VDD VSS) capacitor c=2.83518e-17
C91 (\6\:Db VSS) capacitor c=8.42596e-17
C92 (\7\:VDD VSS) capacitor c=3.19444e-17
C93 (\14\:CKb VSS) capacitor c=6.18834e-17
C94 (\10\:VDD VSS) capacitor c=1.44065e-17
C95 (\7\:CKbb VSS) capacitor c=4.34264e-17
C96 (\8\:Db VSS) capacitor c=8.20843e-17
C97 (\9\:n20 VSS) capacitor c=5.1279e-17
C98 (\13\:VDD VSS) capacitor c=1.11069e-17
C99 (\10\:mout VSS) capacitor c=3.75532e-17
C100 (\16\:VDD VSS) capacitor c=1.94575e-17
C101 (\8\:mout VSS) capacitor c=7.45935e-17
C102 (\9\:n35 VSS) capacitor c=4.76028e-17
C103 (\19\:VDD VSS) capacitor c=3.40776e-17
C104 (\3\:n11 VSS) capacitor c=1.18843e-16
C105 (\22\:VDD VSS) capacitor c=1.21258e-17
C106 (\16\:qbint VSS) capacitor c=6.34454e-17
C107 (\10\:RNb VSS) capacitor c=2.60095e-17
C108 (\26\:VDD VSS) capacitor c=3.24491e-17
C109 (\1\:Q VSS) capacitor c=6.5282e-17
C110 (\5\:net573 VSS) capacitor c=3.20403e-17
C111 (\29\:VDD VSS) capacitor c=5.79931e-17
C112 (\1\:QN VSS) capacitor c=4.74368e-17
C113 (\1\:VDD VSS) capacitor c=1.02487e-16
C114 (\8\:SEb VSS) capacitor c=5.17732e-17
C115 (\22\:CKb VSS) capacitor c=6.41049e-17
C116 (\10\:CKbb VSS) capacitor c=5.56683e-17
C117 (\4\:Db VSS) capacitor c=1.63835e-16
C118 (\5\:n20 VSS) capacitor c=2.76045e-17
C119 (\12\:mout VSS) capacitor c=3.01948e-17
C120 (\3\:n4 VSS) capacitor c=7.40068e-17
C121 (\14\:mout VSS) capacitor c=4.23574e-17
C122 (\5\:n35 VSS) capacitor c=4.1861e-17
C123 (\3\:n8 VSS) capacitor c=8.34018e-17
C124 (\3\:n10 VSS) capacitor c=8.40599e-17
C125 (\13\:qbint VSS) capacitor c=6.47677e-17
C126 (\12\:RNb VSS) capacitor c=1.41964e-16
C127 (\3\:Q VSS) capacitor c=2.98462e-17
C128 (\9\:net573 VSS) capacitor c=3.84613e-17
C129 (\3\:QN VSS) capacitor c=3.62602e-17
C130 (\2\:net573 VSS) capacitor c=8.34485e-18
C131 (\2\:qbint VSS) capacitor c=2.16421e-17
C132 (\3\:qbint VSS) capacitor c=3.3136e-17
C133 (\2\:n35 VSS) capacitor c=2.03286e-17
C134 (\2\:n20 VSS) capacitor c=4.65515e-17
C135 (\2\:CKbb VSS) capacitor c=5.7222e-17
C136 (\7\:net573 VSS) capacitor c=2.96014e-17
C137 (\8\:net573 VSS) capacitor c=2.88677e-17
C138 (\2\:D VSS) capacitor c=4.65419e-17
C139 (\11\:qbint VSS) capacitor c=1.19854e-16
C140 (\12\:qbint VSS) capacitor c=1.17134e-16
C141 (\15\:qbint VSS) capacitor c=6.39045e-17
C142 (\7\:n35 VSS) capacitor c=1.63841e-16
C143 (\8\:n35 VSS) capacitor c=1.39359e-16
C144 (\12\:CKb VSS) capacitor c=1.11813e-16
C145 (\13\:CKb VSS) capacitor c=6.76952e-17
C146 (\7\:RNb VSS) capacitor c=1.37388e-16
C147 (\8\:RNb VSS) capacitor c=2.16131e-16
C148 (\9\:RNb VSS) capacitor c=1.3143e-16
C149 (\7\:SN VSS) capacitor c=2.71878e-16
C150 (\4\:mout VSS) capacitor c=4.35504e-17
C151 (\5\:mout VSS) capacitor c=4.53129e-17
C152 (\6\:mout VSS) capacitor c=6.40828e-17
C153 (\7\:mout VSS) capacitor c=5.87654e-17
C154 (\7\:n20 VSS) capacitor c=6.14204e-17
C155 (\8\:n20 VSS) capacitor c=7.58387e-17
C156 (\9\:CKbb VSS) capacitor c=4.997e-17
C157 (\16\:CKb VSS) capacitor c=6.58781e-17
C158 (\17\:CKb VSS) capacitor c=1.40702e-16
C159 (\18\:CKb VSS) capacitor c=1.47472e-16
C160 (\20\:CKb VSS) capacitor c=8.64984e-17
C161 (\21\:CKb VSS) capacitor c=2.07551e-17
C162 (\4\:CK VSS) capacitor c=8.13987e-17
C163 (\5\:D VSS) capacitor c=3.33259e-17
C164 (\3\:Db VSS) capacitor c=2.072e-16
C165 (\4\:SI VSS) capacitor c=7.25936e-17
C166 (\8\:SE VSS) capacitor c=7.15729e-17
C167 (\9\:SE VSS) capacitor c=7.97685e-17
C168 (\10\:SE VSS) capacitor c=3.69921e-17
C169 (\6\:SEb VSS) capacitor c=7.96664e-17
C170 (\7\:SEb VSS) capacitor c=6.65436e-17
C171 (\3\:VDD VSS) capacitor c=2.23958e-17
C172 (\9\:VDD VSS) capacitor c=2.43694e-17
C173 (\12\:VDD VSS) capacitor c=4.40864e-17
C174 (\18\:VDD VSS) capacitor c=3.40321e-17
C175 (\21\:VDD VSS) capacitor c=3.0118e-17
C176 (\25\:VDD VSS) capacitor c=1.40813e-17
C177 (\28\:VDD VSS) capacitor c=1.98425e-17
Rk59 (\2\:VSS \3\:VSS) resistor r=0.1754 c=0
Rk60 (\3\:VSS \4\:VSS) resistor r=0.3758 c=0
Rk61 (\4\:VSS \5\:VSS) resistor r=0.1001 c=0
Rk62 (\5\:VSS \6\:VSS) resistor r=0.2948 c=0
Rk63 (\6\:VSS \7\:VSS) resistor r=0.4752 c=0
Rk64 (\7\:VSS \8\:VSS) resistor r=0.4312 c=0
Rk65 (\8\:VSS \9\:VSS) resistor r=0.8542 c=0
Rk66 (\9\:VSS \10\:VSS) resistor r=0.3475 c=0
Rk67 (\10\:VSS \11\:VSS) resistor r=0.03492 c=0
Rk69 (\12\:VSS VSS) resistor r=0.1977 c=0
Rk68 (\11\:VSS \12\:VSS) resistor r=0.3182 c=0
Rk70 (\3\:VSS \14\:VSS) resistor r=0.2715 c=0
Rk71 (\4\:VSS \16\:VSS) resistor r=0.2199 c=0
Rk72 (\6\:VSS \18\:VSS) resistor r=0.04332 c=0
Rk73 (\7\:VSS \20\:VSS) resistor r=0.3395 c=0
Rk74 (\9\:VSS \22\:VSS) resistor r=0.04332 c=0
Rk75 (\11\:VSS \24\:VSS) resistor r=0.2582 c=0
Rk76 (\12\:VSS \26\:VSS) resistor r=0.371 c=0
Rk46 (\4\:CK CK) resistor r=0.09742 c=0
Rk54 (\8\:SE SE) resistor r=0.1336 c=0
Rk53 (\8\:SE \9\:SE) resistor r=0.4362 c=0
Rk55 (SE \10\:SE) resistor r=0.1164 c=0
Rk25 (\7\:SN SN) resistor r=2.0206 c=0
Rk26 (SN \8\:SN) resistor r=0.00358 c=0
Rk52 (\4\:SI SI) resistor r=0.05785 c=0
Rk2 (\4\:QN QN) resistor r=0.09048 c=0
Rk1 (\2\:QN \4\:QN) resistor r=0.3061 c=0
Rk77 (\2\:VDD \3\:VDD) resistor r=0.213 c=0
Rk78 (\3\:VDD \4\:VDD) resistor r=0.4387 c=0
Rk79 (\3\:VDD \6\:VDD) resistor r=0.2447 c=0
Rk80 (\4\:VDD \8\:VDD) resistor r=0.2864 c=0
Rk81 (\4\:VDD \9\:VDD) resistor r=0.2954 c=0
Rk82 (\9\:VDD \11\:VDD) resistor r=0.04332 c=0
Rk83 (\9\:VDD \12\:VDD) resistor r=0.4401 c=0
Rk84 (\12\:VDD \14\:VDD) resistor r=0.07405 c=0
Rk85 (\12\:VDD \15\:VDD) resistor r=0.4663 c=0
Rk86 (\15\:VDD \17\:VDD) resistor r=0.07149 c=0
Rk87 (\15\:VDD \18\:VDD) resistor r=0.5351 c=0
Rk88 (\18\:VDD \20\:VDD) resistor r=0.1463 c=0
Rk89 (\18\:VDD \21\:VDD) resistor r=0.3207 c=0
Rk90 (\21\:VDD \23\:VDD) resistor r=0.07405 c=0
Rk91 (\21\:VDD \24\:VDD) resistor r=0.3485 c=0
Rk92 (\24\:VDD \25\:VDD) resistor r=0.03492 c=0
Rk93 (\25\:VDD \27\:VDD) resistor r=0.215 c=0
Rk96 (\28\:VDD VDD) resistor r=0.1977 c=0
Rk94 (\25\:VDD \28\:VDD) resistor r=0.3182 c=0
Rk95 (\28\:VDD \30\:VDD) resistor r=0.4362 c=0
Rk8 (\4\:RN RN) resistor r=0.003004 c=0
Rk47 (\5\:D D) resistor r=0.08082 c=0
Rk6 (\2\:Q Q) resistor r=0.3961 c=0
Rk7 (Q \4\:Q) resistor r=0.1585 c=0
Rk3 (\6\:net573 \7\:net573) resistor r=0.1149 c=0
Rk4 (\7\:net573 \8\:net573) resistor r=0.1195 c=0
Rk5 (\7\:net573 \10\:net573) resistor r=0.1089 c=0
Rk9 (\11\:qbint \12\:qbint) resistor r=0.7739 c=0
Rk10 (\12\:qbint \14\:qbint) resistor r=0.1162 c=0
Rk11 (\12\:qbint \15\:qbint) resistor r=0.3429 c=0
Rk12 (\14\:qbint \17\:qbint) resistor r=0.4197 c=0
Rk20 (\7\:RNb \8\:RNb) resistor r=1.0444 c=0
Rk21 (\8\:RNb \9\:RNb) resistor r=0.6935 c=0
Rk22 (\9\:RNb \11\:RNb) resistor r=0.04766 c=0
Rk23 (\9\:RNb \13\:RNb) resistor r=0.7351 c=0
Rk16 (\6\:n35 \7\:n35) resistor r=0.1596 c=0
Rk17 (\7\:n35 \8\:n35) resistor r=1.0844 c=0
Rk18 (\7\:n35 \10\:n35) resistor r=0.1645 c=0
Rk13 (\2\:n8 \4\:n8) resistor r=0.613 c=0
Rk15 (\2\:n10 \4\:n10) resistor r=0.3049 c=0
Rk19 (\12\:CKb \13\:CKb) resistor r=0.6601 c=0
Rk39 (\15\:CKb \16\:CKb) resistor r=0.302 c=0
Rk40 (\16\:CKb \17\:CKb) resistor r=0.4743 c=0
Rk41 (\17\:CKb \18\:CKb) resistor r=0.9474 c=0
Rk42 (\16\:CKb \19\:CKb) resistor r=0.3363 c=0
Rk43 (\19\:CKb \20\:CKb) resistor r=0.03275 c=0
Rk44 (\17\:CKb \21\:CKb) resistor r=0.05544 c=0
Rk45 (\19\:CKb \23\:CKb) resistor r=0.4207 c=0
Rk27 (\4\:mout \5\:mout) resistor r=0.2298 c=0
Rk28 (\5\:mout \6\:mout) resistor r=0.2759 c=0
Rk29 (\6\:mout \7\:mout) resistor r=0.3131 c=0
Rk30 (\7\:mout \9\:mout) resistor r=0.3646 c=0
Rk31 (\5\:mout \11\:mout) resistor r=0.08682 c=0
Rk32 (\6\:mout \13\:mout) resistor r=0.1233 c=0
Rk33 (\7\:mout \15\:mout) resistor r=0.1374 c=0
Rk37 (\8\:CKbb \9\:CKbb) resistor r=0.1548 c=0
Rk38 (\9\:CKbb \11\:CKbb) resistor r=0.2173 c=0
Rk24 (\2\:n4 \4\:n4) resistor r=0.5012 c=0
Rk34 (\6\:n20 \7\:n20) resistor r=0.1221 c=0
Rk35 (\7\:n20 \8\:n20) resistor r=0.3813 c=0
Rk36 (\7\:n20 \10\:n20) resistor r=0.2062 c=0
Rk48 (\2\:Db \3\:Db) resistor r=0.3369 c=0
Rk49 (\3\:Db \5\:Db) resistor r=1.0737 c=0
Rk50 (\3\:Db \7\:Db) resistor r=0.627 c=0
Rk51 (\5\:Db \9\:Db) resistor r=0.409 c=0
Rk56 (\5\:SEb \6\:SEb) resistor r=0.09154 c=0
Rk57 (\6\:SEb \7\:SEb) resistor r=0.4471 c=0
Rk58 (\6\:SEb \9\:SEb) resistor r=0.4716 c=0
Rk14 (\2\:n11 \4\:n11) resistor r=0.4176 c=0
Rl42 (\1\:CK \2\:CK) resistor r=39.1533 c=0
Rl43 (\2\:CK \3\:CK) resistor r=144.923 c=0
Rl54 (\6\:SE \7\:SE) resistor r=170.604 c=0
Rl53 (\5\:SE \6\:SE) resistor r=51.9231 c=0
Rl50 (\3\:SE \4\:SE) resistor r=35.7134 c=0
Rl47 (\1\:SE \2\:SE) resistor r=71.8456 c=0
Rl29 (\4\:SN \5\:SN) resistor r=138.487 c=0
Rl30 (\5\:SN \6\:SN) resistor r=50.6918 c=0
Rl15 (\1\:SN \2\:SN) resistor r=31.461 c=0
Rl16 (\2\:SN \3\:SN) resistor r=104.538 c=0
Rl52 (\2\:SI \3\:SI) resistor r=109.066 c=0
Rl51 (\1\:SI \2\:SI) resistor r=113.462 c=0
Rl10 (\1\:RN \2\:RN) resistor r=54.5379 c=0
Rl11 (\2\:RN \3\:RN) resistor r=204.538 c=0
Rl46 (\2\:D \4\:D) resistor r=106.794 c=0
Rl44 (\1\:D \2\:D) resistor r=178.614 c=0
Rl45 (\2\:D \3\:D) resistor r=5.487 c=0
Rl3 (\2\:net573 \4\:net573) resistor r=47.791 c=0
Rl2 (\2\:net573 \3\:net573) resistor r=36.2526 c=0
Rl1 (net573 \2\:net573) resistor r=5.915 c=0
Rl17 (\8\:qbint \9\:qbint) resistor r=161.538 c=0
Rl18 (\9\:qbint \10\:qbint) resistor r=38.5707 c=0
Rl4 (qbint \2\:qbint) resistor r=124.847 c=0
Rl7 (\2\:qbint \5\:qbint) resistor r=36.3849 c=0
Rl8 (\2\:qbint \6\:qbint) resistor r=6.2575 c=0
Rl9 (\3\:qbint \7\:qbint) resistor r=60.772 c=0
Rl6 (\3\:qbint \4\:qbint) resistor r=28.0797 c=0
Rl5 (\2\:qbint \3\:qbint) resistor r=150.199 c=0
Rl24 (\4\:RNb \5\:RNb) resistor r=136.906 c=0
Rl19 (RNb \2\:RNb) resistor r=264.95 c=0
Rl25 (\5\:RNb \6\:RNb) resistor r=114.898 c=0
Rl20 (\2\:RNb \3\:RNb) resistor r=43.4636 c=0
Rl14 (\2\:n35 \4\:n35) resistor r=100.803 c=0
Rl13 (\2\:n35 \3\:n35) resistor r=50.8027 c=0
Rl12 (n35 \2\:n35) resistor r=1.2334 c=0
Rl39 (\8\:CKb \9\:CKb) resistor r=74.7951 c=0
Rl41 (\9\:CKb \11\:CKb) resistor r=33.4251 c=0
Rl40 (\9\:CKb \10\:CKb) resistor r=180.746 c=0
Rl33 (\6\:CKb \7\:CKb) resistor r=66.8866 c=0
Rl23 (\4\:CKb \5\:CKb) resistor r=53.3592 c=0
Rl22 (\3\:CKb \4\:CKb) resistor r=117.979 c=0
Rl21 (CKb \2\:CKb) resistor r=93.4636 c=0
Rl31 (mout \2\:mout) resistor r=39.6174 c=0
Rl32 (\2\:mout \3\:mout) resistor r=87.6944 c=0
Rl37 (\4\:CKbb \5\:CKbb) resistor r=147.208 c=0
Rl36 (\3\:CKbb \4\:CKbb) resistor r=695.72 c=0
Rl34 (CKbb \2\:CKbb) resistor r=70.8353 c=0
Rl35 (\2\:CKbb \3\:CKbb) resistor r=146.132 c=0
Rl38 (\2\:CKbb \6\:CKbb) resistor r=86.4638 c=0
Rl26 (n20 \2\:n20) resistor r=97.2294 c=0
Rl27 (\2\:n20 \3\:n20) resistor r=37.614 c=0
Rl28 (\2\:n20 \4\:n20) resistor r=4.7568 c=0
Rl48 (SEb \2\:SEb) resistor r=24.2328 c=0
Rl49 (\2\:SEb \3\:SEb) resistor r=193.464 c=0
Rz21 (\13\:VSS \14\:VSS) resistor r=75 c=0
Rz22 (\15\:VSS \16\:VSS) resistor r=75 c=0
Rz23 (\17\:VSS \18\:VSS) resistor r=75 c=0
Rz24 (\19\:VSS \20\:VSS) resistor r=75 c=0
Rz25 (\21\:VSS \22\:VSS) resistor r=75 c=0
Rz26 (\23\:VSS \24\:VSS) resistor r=75 c=0
Rz27 (\25\:VSS \26\:VSS) resistor r=75 c=0
Rz1 (\3\:QN \4\:QN) resistor r=75 c=0
Rz28 (\1\:VDD \2\:VDD) resistor r=75 c=0
Rz29 (\1\:VDD \4\:VDD) resistor r=6.25 c=0
Rz30 (\1\:VDD \15\:VDD) resistor r=6.25 c=0
Rz31 (\1\:VDD \24\:VDD) resistor r=6.25 c=0
Rz3 (\3\:Q \4\:Q) resistor r=75 c=0
Rz2 (\9\:net573 \10\:net573) resistor r=75 c=0
Rz4 (\13\:qbint \14\:qbint) resistor r=75 c=0
Rz10 (\12\:RNb \13\:RNb) resistor r=75 c=0
Rz9 (\5\:n35 \6\:n35) resistor r=75 c=0
Rz5 (n8 \2\:n8) resistor r=75 c=0
Rz6 (\3\:n8 \4\:n8) resistor r=75 c=0
Rz7 (n10 \2\:n10) resistor r=75 c=0
Rz8 (\3\:n10 \4\:n10) resistor r=75 c=0
Rz17 (\22\:CKb \23\:CKb) resistor r=75 c=0
Rz13 (\12\:mout \13\:mout) resistor r=75 c=0
Rz14 (\14\:mout \15\:mout) resistor r=75 c=0
Rz16 (\10\:CKbb \11\:CKbb) resistor r=75 c=0
Rz11 (n4 \2\:n4) resistor r=75 c=0
Rz12 (\3\:n4 \4\:n4) resistor r=75 c=0
Rz15 (\5\:n20 \6\:n20) resistor r=75 c=0
Rz18 (Db \2\:Db) resistor r=75 c=0
Rz19 (\4\:Db \5\:Db) resistor r=75 c=0
Rz20 (\8\:SEb \9\:SEb) resistor r=75 c=0
Ry17 (\1\:VSS \2\:VSS) resistor r=62 c=0
Ry18 (\1\:VSS \5\:VSS) resistor r=5.1667 c=0
Ry19 (\1\:VSS \8\:VSS) resistor r=5.1667 c=0
Ry20 (\1\:VSS \10\:VSS) resistor r=5.1667 c=0
Ry1 (\1\:QN \2\:QN) resistor r=20.6667 c=0
Ry21 (\5\:VDD \6\:VDD) resistor r=62 c=0
Ry22 (\7\:VDD \8\:VDD) resistor r=62 c=0
Ry23 (\10\:VDD \11\:VDD) resistor r=62 c=0
Ry24 (\13\:VDD \14\:VDD) resistor r=62 c=0
Ry25 (\16\:VDD \17\:VDD) resistor r=62 c=0
Ry26 (\19\:VDD \20\:VDD) resistor r=62 c=0
Ry27 (\22\:VDD \23\:VDD) resistor r=62 c=0
Ry28 (\26\:VDD \27\:VDD) resistor r=62 c=0
Ry29 (\29\:VDD \30\:VDD) resistor r=62 c=0
Ry3 (\1\:Q \2\:Q) resistor r=20.6667 c=0
Ry2 (\5\:net573 \6\:net573) resistor r=62 c=0
Ry4 (\16\:qbint \17\:qbint) resistor r=62 c=0
Ry8 (\10\:RNb \11\:RNb) resistor r=62 c=0
Ry7 (\9\:n35 \10\:n35) resistor r=62 c=0
Ry13 (\14\:CKb \15\:CKb) resistor r=62 c=0
Ry9 (\8\:mout \9\:mout) resistor r=62 c=0
Ry10 (\10\:mout \11\:mout) resistor r=62 c=0
Ry12 (\7\:CKbb \8\:CKbb) resistor r=62 c=0
Ry11 (\9\:n20 \10\:n20) resistor r=62 c=0
Ry14 (\6\:Db \7\:Db) resistor r=62 c=0
Ry15 (\8\:Db \9\:Db) resistor r=62 c=0
Ry16 (\4\:SEb \5\:SEb) resistor r=62 c=0
Ry5 (n11 \2\:n11) resistor r=62 c=0
Ry6 (\3\:n11 \4\:n11) resistor r=62 c=0
Rx18 (\2\:CK \4\:CK) resistor r=45 c=0
Rx21 (\4\:SE \8\:SE) resistor r=45 c=0
Rx22 (\2\:SE \9\:SE) resistor r=45 c=0
Rx23 (\6\:SE \10\:SE) resistor r=45 c=0
Rx10 (\6\:SN \7\:SN) resistor r=45 c=0
Rx11 (\2\:SN \8\:SN) resistor r=45 c=0
Rx20 (\2\:SI \4\:SI) resistor r=45 c=0
Rx2 (\2\:RN \4\:RN) resistor r=45 c=0
Rx19 (\3\:D \5\:D) resistor r=45 c=0
Rx1 (net573 \8\:net573) resistor r=45 c=0
Rx3 (\6\:qbint \11\:qbint) resistor r=45 c=0
Rx4 (\10\:qbint \15\:qbint) resistor r=45 c=0
Rx8 (\6\:RNb \7\:RNb) resistor r=45 c=0
Rx9 (\3\:RNb \8\:RNb) resistor r=45 c=0
Rx5 (n35 \8\:n35) resistor r=45 c=0
Rx6 (\4\:CKb \12\:CKb) resistor r=45 c=0
Rx7 (\2\:CKb \13\:CKb) resistor r=45 c=0
Rx15 (\3\:CKb \18\:CKb) resistor r=45 c=0
Rx16 (\9\:CKb \20\:CKb) resistor r=45 c=0
Rx17 (\6\:CKb \21\:CKb) resistor r=45 c=0
Rx12 (\2\:mout \4\:mout) resistor r=45 c=0
Rx14 (\6\:CKbb \9\:CKbb) resistor r=45 c=0
Rx13 (\4\:n20 \8\:n20) resistor r=45 c=0
Rx24 (\2\:SEb \7\:SEb) resistor r=45 c=0
mn57 (\3\:QN \3\:net573 \25\:VSS VSS) g45n1lvt w=(2.6e-07) l=4.5e-08 \
        nf=1 as=3.833e-14 ad=3.64e-14 ps=8.9e-07 pd=8e-07 nrd=1.16667 \
        nrs=1.16667 sa=1.4e-07 sb=2.50577e-07 sd=160n sca=17.5885 \
        scb=0.0172826 scc=0.00162584 m=(1)
mn55 (\3\:Q \5\:qbint \23\:VSS VSS) g45n1lvt w=(2.6e-07) l=4.5e-08 nf=1 \
        as=3.905e-14 ad=3.64e-14 ps=9e-07 pd=8e-07 nrd=1.16667 nrs=1.16667 \
        sa=1.4e-07 sb=3.00769e-07 sd=160n sca=11.5806 scb=0.0111274 \
        scc=0.000535497 m=(1)
mn56 (\9\:net573 \4\:qbint \25\:VSS VSS) g45n1lvt w=(1.45e-07) l=4.5e-08 \
        nf=1 as=3.833e-14 ad=2.03e-14 ps=8.9e-07 pd=5.7e-07 nrd=1.16667 \
        nrs=1.16667 sa=3.7e-07 sb=1.4e-07 sd=160n sca=23.279 scb=0.0230742 \
        scc=0.00267719 m=(1)
mn22 (\12\:RNb \3\:RN \23\:VSS VSS) g45n1lvt w=(1.45e-07) l=4.5e-08 nf=1 \
        as=3.905e-14 ad=3.263e-14 ps=9e-07 pd=7.4e-07 nrd=1.16667 \
        nrs=1.16667 sa=3.75e-07 sb=2.25e-07 sd=160n sca=8.70265 \
        scb=0.00681258 scc=0.000126945 m=(1)
mn45 (\13\:qbint \3\:n35 \21\:VSS VSS) g45n1lvt w=(1.45e-07) l=4.5e-08 \
        nf=1 as=6.97e-14 ad=2.03e-14 ps=1.36e-06 pd=5.7e-07 nrd=1.16667 \
        nrs=1.16667 sa=1.4e-07 sb=1.045e-06 sd=160n sca=11.1906 \
        scb=0.0108717 scc=0.000387468 m=(1)
mn50 (n8 \3\:SN \21\:VSS VSS) g45n1lvt w=(1.45e-07) l=4.5e-08 nf=1 \
        as=6.97e-14 ad=2.32e-14 ps=1.36e-06 pd=6.1e-07 nrd=1.16667 \
        nrs=1.16667 sa=4.05e-07 sb=7.8e-07 sd=160n sca=11.1906 \
        scb=0.0108717 scc=0.000387468 m=(1)
mn52 (\3\:n10 \9\:qbint n8 VSS) g45n1lvt w=(1.45e-07) l=4.5e-08 nf=1 \
        as=2.32e-14 ad=5.438e-14 ps=6.1e-07 pd=1.04e-06 nrd=1.16667 \
        nrs=1.16667 sa=6.1e-07 sb=5.75e-07 sd=160n sca=11.1906 \
        scb=0.0108717 scc=0.000387468 m=(1)
mn51 (\3\:n10 RNb \3\:n8 VSS) g45n1lvt w=(1.45e-07) l=4.5e-08 nf=1 \
        as=2.248e-14 ad=5.438e-14 ps=6e-07 pd=1.04e-06 nrd=1.16667 \
        nrs=1.16667 sa=1.03e-06 sb=1.55e-07 sd=160n sca=11.1906 \
        scb=0.0108717 scc=0.000387468 m=(1)
mn53 (\5\:n35 CKb n10 VSS) g45n1lvt w=(1.45e-07) l=4.5e-08 nf=1 \
        as=2.03e-14 ad=2.32e-14 ps=5.7e-07 pd=6.1e-07 nrd=1.16667 \
        nrs=1.16667 sa=1.4e-07 sb=4.6e-07 sd=160n sca=23.279 scb=0.0230742 \
        scc=0.00267719 m=(1)
mn40 (\5\:n35 \4\:CKbb \14\:mout VSS) g45n1lvt w=(1.45e-07) l=4.5e-08 \
        nf=1 as=3.698e-14 ad=2.32e-14 ps=8e-07 pd=6.1e-07 nrd=1.16667 \
        nrs=1.16667 sa=3.45e-07 sb=2.55e-07 sd=160n sca=23.279 \
        scb=0.0230742 scc=0.00267719 m=(1)
mn31 (\12\:mout \4\:RNb \3\:n4 VSS) g45n1lvt w=(1.45e-07) l=4.5e-08 nf=1 \
        as=2.03e-14 ad=2.682e-14 ps=5.7e-07 pd=6.6e-07 nrd=1.16667 \
        nrs=1.16667 sa=1.4e-07 sb=1.09e-06 sd=160n sca=15.2405 \
        scb=0.016218 scc=0.00104639 m=(1)
mn32 (\12\:mout \3\:n20 n4 VSS) g45n1lvt w=(1.45e-07) l=4.5e-08 nf=1 \
        as=2.32e-14 ad=2.682e-14 ps=6.1e-07 pd=6.6e-07 nrd=1.16667 \
        nrs=1.16667 sa=3.7e-07 sb=8.6e-07 sd=160n sca=15.2405 scb=0.016218 \
        scc=0.00104639 m=(1)
mn30 (n4 \4\:SN \19\:VSS VSS) g45n1lvt w=(1.45e-07) l=4.5e-08 nf=1 \
        as=2.32e-14 ad=2.32e-14 ps=6.1e-07 pd=6.1e-07 nrd=1.16667 \
        nrs=1.16667 sa=5.75e-07 sb=6.55e-07 sd=160n sca=15.2405 \
        scb=0.016218 scc=0.00104639 m=(1)
mn35 (n6 \3\:mout \19\:VSS VSS) g45n1lvt w=(1.45e-07) l=4.5e-08 nf=1 \
        as=2.32e-14 ad=8.7e-15 ps=6.1e-07 pd=4.1e-07 nrd=1.16667 \
        nrs=1.16667 sa=7.8e-07 sb=4.5e-07 sd=160n sca=15.2405 scb=0.016218 \
        scc=0.00104639 m=(1)
mn36 (\5\:n20 \3\:CKbb n6 VSS) g45n1lvt w=(1.45e-07) l=4.5e-08 nf=1 \
        as=8.7e-15 ad=2.32e-14 ps=4.1e-07 pd=6.1e-07 nrd=1.16667 \
        nrs=1.16667 sa=8.85e-07 sb=3.45e-07 sd=160n sca=15.2405 \
        scb=0.016218 scc=0.00104639 m=(1)
mn25 (\4\:Db \10\:CKb \5\:n20 VSS) g45n1lvt w=(1.45e-07) l=4.5e-08 nf=1 \
        as=2.32e-14 ad=2.03e-14 ps=6.1e-07 pd=5.7e-07 nrd=1.16667 \
        nrs=1.16667 sa=1.09e-06 sb=1.4e-07 sd=160n sca=15.2405 \
        scb=0.016218 scc=0.00104639 m=(1)
mn21 (\10\:CKbb \11\:CKb \17\:VSS VSS) g45n1lvt w=(1.45e-07) l=4.5e-08 \
        nf=1 as=7.025e-14 ad=2.03e-14 ps=1.39e-06 pd=5.7e-07 nrd=1.16667 \
        nrs=1.16667 sa=1.4e-07 sb=1.7e-07 sd=160n sca=15.7071 \
        scb=0.0167369 scc=0.00113434 m=(1)
mn20 (\22\:CKb \3\:CK \15\:VSS VSS) g45n1lvt w=(1.45e-07) l=4.5e-08 nf=1 \
        as=5.23e-14 ad=2.03e-14 ps=1.35e-06 pd=5.7e-07 nrd=1.16667 \
        nrs=1.16667 sa=1.4e-07 sb=5.63793e-07 sd=160n sca=16.7245 \
        scb=0.0178071 scc=0.00133148 m=(1)
mn11 (n0 \1\:D \15\:VSS VSS) g45n1lvt w=(1.45e-07) l=4.5e-08 nf=1 \
        as=5.23e-14 ad=2.755e-14 ps=1.35e-06 pd=6.7e-07 nrd=1.16667 \
        nrs=1.16667 sa=3.01034e-07 sb=1.035e-06 sd=160n sca=10.2779 \
        scb=0.00944477 scc=0.000275883 m=(1)
mn12 (Db \3\:SEb n0 VSS) g45n1lvt w=(1.45e-07) l=4.5e-08 nf=1 \
        as=2.755e-14 ad=2.32e-14 ps=6.7e-07 pd=6.1e-07 nrd=1.16667 \
        nrs=1.16667 sa=5.36034e-07 sb=8e-07 sd=160n sca=10.2779 \
        scb=0.00944477 scc=0.000275883 m=(1)
mn14 (Db \3\:SE n2 VSS) g45n1lvt w=(1.45e-07) l=4.5e-08 nf=1 as=8.7e-15 \
        ad=2.32e-14 ps=4.1e-07 pd=6.1e-07 nrd=1.16667 nrs=1.16667 \
        sa=7.41034e-07 sb=5.95e-07 sd=160n sca=10.2779 scb=0.00944477 \
        scc=0.000275883 m=(1)
mn13 (n2 \1\:SI \13\:VSS VSS) g45n1lvt w=(1.45e-07) l=4.5e-08 nf=1 \
        as=3.698e-14 ad=8.7e-15 ps=8e-07 pd=4.1e-07 nrd=1.16667 \
        nrs=1.16667 sa=8.46034e-07 sb=4.9e-07 sd=160n sca=10.2779 \
        scb=0.00944477 scc=0.000275883 m=(1)
mn10 (\8\:SEb \5\:SE \13\:VSS VSS) g45n1lvt w=(1.45e-07) l=4.5e-08 nf=1 \
        as=3.698e-14 ad=2.755e-14 ps=8e-07 pd=6.7e-07 nrd=1.16667 \
        nrs=1.16667 sa=1.14603e-06 sb=1.9e-07 sd=160n sca=10.2779 \
        scb=0.00944477 scc=0.000275883 m=(1)
mp56 (\5\:net573 \7\:qbint \29\:VDD VDD) g45p1lvt w=(2.15e-07) l=4.5e-08 \
        nf=1 as=5.728e-14 ad=3.01e-14 ps=1.15e-06 pd=7.1e-07 nrd=1.16667 \
        nrs=1.16667 sa=3.7e-07 sb=1.4e-07 sd=160n sca=46.9828 \
        scb=0.0290392 scc=0.00588499 m=(1)
mp22 (\10\:RNb \1\:RN \26\:VDD VDD) g45p1lvt w=(2.15e-07) l=4.5e-08 nf=1 \
        as=5.835e-14 ad=3.01e-14 ps=1.16e-06 pd=7.1e-07 nrd=1.16667 \
        nrs=1.16667 sa=3.75e-07 sb=1.4e-07 sd=160n sca=10.1292 \
        scb=0.00731698 scc=7.20009e-05 m=(1)
mp45 (\16\:qbint \4\:n35 \22\:VDD VDD) g45p1lvt w=(2.15e-07) l=4.5e-08 \
        nf=1 as=1.019e-13 ad=3.01e-14 ps=1.78e-06 pd=7.1e-07 nrd=1.16667 \
        nrs=1.16667 sa=1.4e-07 sb=8.4e-07 sd=160n sca=23.7894 \
        scb=0.0219499 scc=0.00260958 m=(1)
mp50 (\3\:n11 \1\:SN \22\:VDD VDD) g45p1lvt w=(2.15e-07) l=4.5e-08 nf=1 \
        as=1.019e-13 ad=3.44e-14 ps=1.78e-06 pd=7.5e-07 nrd=1.16667 \
        nrs=1.16667 sa=4.05e-07 sb=5.75e-07 sd=160n sca=23.7894 \
        scb=0.0219499 scc=0.00260958 m=(1)
mp52 (\3\:n11 \8\:qbint n9 VDD) g45p1lvt w=(2.15e-07) l=4.5e-08 nf=1 \
        as=1.29e-14 ad=3.44e-14 ps=5.5e-07 pd=7.5e-07 nrd=1.16667 \
        nrs=1.16667 sa=6.1e-07 sb=3.7e-07 sd=160n sca=23.7894 \
        scb=0.0219499 scc=0.00260958 m=(1)
mp51 (n9 \2\:RNb \19\:VDD VDD) g45p1lvt w=(2.15e-07) l=4.5e-08 nf=1 \
        as=9.777e-14 ad=1.29e-14 ps=1.64e-06 pd=5.5e-07 nrd=1.16667 \
        nrs=1.16667 sa=7.15e-07 sb=2.65e-07 sd=160n sca=23.7894 \
        scb=0.0219499 scc=0.00260958 m=(1)
mp53 (\9\:n35 \5\:CKbb n11 VDD) g45p1lvt w=(2.15e-07) l=4.5e-08 nf=1 \
        as=6.773e-14 ad=3.762e-14 ps=1.06e-06 pd=7.8e-07 nrd=1.16667 \
        nrs=1.16667 sa=3.15e-07 sb=3.6e-07 sd=160n sca=23.7894 \
        scb=0.0219499 scc=0.00260958 m=(1)
mp40 (\9\:n35 \5\:CKb \8\:mout VDD) g45p1lvt w=(2.15e-07) l=4.5e-08 nf=1 \
        as=3.01e-14 ad=3.762e-14 ps=7.1e-07 pd=7.8e-07 nrd=1.16667 \
        nrs=1.16667 sa=5.35e-07 sb=1.4e-07 sd=160n sca=23.7894 \
        scb=0.0219499 scc=0.00260958 m=(1)
mp31 (n5 \5\:RNb \16\:VDD VDD) g45p1lvt w=(2.15e-07) l=4.5e-08 nf=1 \
        as=6.515e-14 ad=3.762e-14 ps=2.18e-06 pd=7.8e-07 nrd=1.16667 \
        nrs=1.16667 sa=1.59302e-07 sb=9.68605e-07 sd=160n sca=22.8495 \
        scb=0.0214046 scc=0.00242442 m=(1)
mp32 (\10\:mout n20 n5 VDD) g45p1lvt w=(2.15e-07) l=4.5e-08 nf=1 \
        as=3.762e-14 ad=3.44e-14 ps=7.8e-07 pd=7.5e-07 nrd=1.16667 \
        nrs=1.16667 sa=3.79302e-07 sb=7.48605e-07 sd=160n sca=22.8495 \
        scb=0.0214046 scc=0.00242442 m=(1)
mp30 (\10\:mout \5\:SN \13\:VDD VDD) g45p1lvt w=(2.15e-07) l=4.5e-08 \
        nf=1 as=6.675e-14 ad=3.44e-14 ps=1.83e-06 pd=7.5e-07 nrd=1.16667 \
        nrs=1.16667 sa=5.84302e-07 sb=5.43605e-07 sd=160n sca=22.8495 \
        scb=0.0214046 scc=0.00242442 m=(1)
mp35 (n7 mout \13\:VDD VDD) g45p1lvt w=(2.15e-07) l=4.5e-08 nf=1 \
        as=6.675e-14 ad=1.29e-14 ps=1.83e-06 pd=5.5e-07 nrd=1.16667 \
        nrs=1.16667 sa=6.63953e-07 sb=4.5e-07 sd=160n sca=17.4145 \
        scb=0.0172865 scc=0.00131682 m=(1)
mp36 (\9\:n20 \7\:CKb n7 VDD) g45p1lvt w=(2.15e-07) l=4.5e-08 nf=1 \
        as=1.29e-14 ad=3.44e-14 ps=5.5e-07 pd=7.5e-07 nrd=1.16667 \
        nrs=1.16667 sa=7.68953e-07 sb=3.45e-07 sd=160n sca=17.4145 \
        scb=0.0172865 scc=0.00131682 m=(1)
mp25 (\9\:n20 CKbb \8\:Db VDD) g45p1lvt w=(2.15e-07) l=4.5e-08 nf=1 \
        as=3.01e-14 ad=3.44e-14 ps=7.1e-07 pd=7.5e-07 nrd=1.16667 \
        nrs=1.16667 sa=9.73953e-07 sb=1.4e-07 sd=160n sca=17.4145 \
        scb=0.0172865 scc=0.00131682 m=(1)
mp21 (\7\:CKbb \8\:CKb \10\:VDD VDD) g45p1lvt w=(2.15e-07) l=4.5e-08 \
        nf=1 as=5.19e-14 ad=3.01e-14 ps=1.65e-06 pd=7.1e-07 nrd=1.16667 \
        nrs=1.16667 sa=1.4e-07 sb=1e-07 sd=160n sca=21.1782 scb=0.0203295 \
        scc=0.00208843 m=(1)
mp20 (\14\:CKb \1\:CK \7\:VDD VDD) g45p1lvt w=(2.15e-07) l=4.5e-08 nf=1 \
        as=3.44e-14 ad=2.73e-14 ps=7.5e-07 pd=7.1e-07 nrd=1.16667 \
        nrs=1.16667 sa=1.26977e-07 sb=1.32e-06 sd=160n sca=10.4936 \
        scb=0.00800718 scc=0.000111754 m=(1)
mp11 (n1 \4\:D \7\:VDD VDD) g45p1lvt w=(2.15e-07) l=4.5e-08 nf=1 \
        as=3.44e-14 ad=4.623e-14 ps=7.5e-07 pd=8.6e-07 nrd=1.16667 \
        nrs=1.16667 sa=3.31977e-07 sb=1.115e-06 sd=160n sca=10.4936 \
        scb=0.00800718 scc=0.000111754 m=(1)
mp12 (\6\:Db \1\:SE n1 VDD) g45p1lvt w=(2.15e-07) l=4.5e-08 nf=1 \
        as=4.623e-14 ad=3.44e-14 ps=8.6e-07 pd=7.5e-07 nrd=1.16667 \
        nrs=1.16667 sa=5.91977e-07 sb=8.55e-07 sd=160n sca=10.4936 \
        scb=0.00800718 scc=0.000111754 m=(1)
mp14 (\6\:Db SEb n3 VDD) g45p1lvt w=(2.15e-07) l=4.5e-08 nf=1 \
        as=3.548e-14 ad=3.44e-14 ps=7.6e-07 pd=7.5e-07 nrd=1.16667 \
        nrs=1.16667 sa=7.96977e-07 sb=6.5e-07 sd=160n sca=10.7789 \
        scb=0.00808417 scc=0.000111767 m=(1)
mp13 (n3 \3\:SI \5\:VDD VDD) g45p1lvt w=(2.15e-07) l=4.5e-08 nf=1 \
        as=5.483e-14 ad=3.548e-14 ps=9.4e-07 pd=7.6e-07 nrd=1.16667 \
        nrs=1.16667 sa=1.00698e-06 sb=4.4e-07 sd=160n sca=11.6546 \
        scb=0.0086845 scc=0.000112508 m=(1)
mp10 (\4\:SEb \7\:SE \5\:VDD VDD) g45p1lvt w=(2.15e-07) l=4.5e-08 nf=1 \
        as=5.483e-14 ad=3.01e-14 ps=9.4e-07 pd=7.1e-07 nrd=1.16667 \
        nrs=1.16667 sa=1.30698e-06 sb=1.4e-07 sd=160n sca=16.2189 \
        scb=0.016045 scc=0.000282872 m=(1)
ends SDFFSRX1
// End of subcircuit definition.
