// Generated for: spectre (May  1 11:27:35 2013 )
// Library name: gsclib045_backbias
// Cell name: AOI222X1
// View name: extracted

simulator lang=spectre

subckt AOI222X1 A0 A1 B0 B1 C0 C1 NW VDD VSS Y
mp0 (net122 \3\:A0 \4\:VDD NW) g45p1svt w=(3.9e-07) l=4.5e-08 nf=1 \
        as=5.46e-14 ad=6.24e-14 ps=1.06e-06 pd=1.1e-06 nrd=1.16667 \
        nrs=1.16667 sa=1.4e-07 sb=3.45e-07 sd=160n sca=18.9913 \
        scb=0.020688 scc=0.00060344 m=(1)
mp1 (net122 \1\:A1 \1\:VDD NW) g45p1svt w=(3.9e-07) l=4.5e-08 nf=1 \
        as=5.46e-14 ad=6.24e-14 ps=1.06e-06 pd=1.1e-06 nrd=1.16667 \
        nrs=1.16667 sa=3.45e-07 sb=1.4e-07 sd=160n sca=13.7713 \
        scb=0.0118072 scc=0.000241734 m=(1)
mp3 (\5\:net118 \1\:B1 \3\:net122 NW) g45p1svt w=(3.9e-07) l=4.5e-08 nf=1 \
        as=6.24e-14 ad=5.46e-14 ps=1.1e-06 pd=1.06e-06 nrd=1.16667 \
        nrs=1.16667 sa=1.4e-07 sb=7.55e-07 sd=160n sca=11.6444 \
        scb=0.00959467 scc=0.000231862 m=(1)
mp2 (\3\:net118 \1\:B0 \3\:net122 NW) g45p1svt w=(3.9e-07) l=4.5e-08 nf=1 \
        as=6.24e-14 ad=6.24e-14 ps=1.1e-06 pd=1.1e-06 nrd=1.16667 \
        nrs=1.16667 sa=3.45e-07 sb=5.5e-07 sd=160n sca=12.1511 \
        scb=0.00987528 scc=0.000232041 m=(1)
mp4 (\5\:Y \1\:C0 \3\:net118 NW) g45p1svt w=(3.9e-07) l=4.5e-08 nf=1 \
        as=6.24e-14 ad=6.24e-14 ps=1.1e-06 pd=1.1e-06 nrd=1.16667 \
        nrs=1.16667 sa=5.5e-07 sb=3.45e-07 sd=160n sca=13.6523 \
        scb=0.011626 scc=0.000240092 m=(1)
mp5 (\5\:Y \1\:C1 net118 NW) g45p1svt w=(3.9e-07) l=4.5e-08 nf=1 \
        as=5.46e-14 ad=6.24e-14 ps=1.06e-06 pd=1.1e-06 nrd=1.16667 \
        nrs=1.16667 sa=7.55e-07 sb=1.4e-07 sd=160n sca=18.5104 \
        scb=0.0199204 scc=0.000545053 m=(1)
C1 (NW VSS) capacitor c=2.70313e-16
C2 (Y VSS) capacitor c=8.22238e-17
C3 (A1 VSS) capacitor c=4.15491e-17
C4 (VDD VSS) capacitor c=2.43098e-17
C5 (B0 VSS) capacitor c=6.69818e-17
C6 (A0 VSS) capacitor c=3.78683e-17
C7 (net139 VSS) capacitor c=6.24372e-18
C8 (net147 VSS) capacitor c=1.55458e-18
C9 (net155 VSS) capacitor c=1.3325e-18
C10 (net122 VSS) capacitor c=8.10066e-17
C11 (net118 VSS) capacitor c=5.51375e-17
C12 (\1\:C1 VSS) capacitor c=5.14809e-17
C13 (\1\:C0 VSS) capacitor c=5.46425e-17
C14 (\1\:B0 VSS) capacitor c=5.21023e-17
C15 (\1\:B1 VSS) capacitor c=6.51379e-17
C16 (\1\:A1 VSS) capacitor c=6.82768e-17
C17 (\3\:A0 VSS) capacitor c=5.37946e-17
C18 (\3\:C1 VSS) capacitor c=5.96802e-17
C19 (\3\:C0 VSS) capacitor c=7.59479e-17
C20 (\3\:B0 VSS) capacitor c=7.25568e-17
C21 (\4\:B1 VSS) capacitor c=5.20046e-17
C22 (\3\:A1 VSS) capacitor c=4.96193e-17
C23 (\1\:A0 VSS) capacitor c=5.37514e-17
C24 (\2\:C1 VSS) capacitor c=5.49522e-17
C25 (\2\:C0 VSS) capacitor c=5.4583e-17
C26 (\2\:B0 VSS) capacitor c=6.87775e-17
C27 (\3\:B1 VSS) capacitor c=2.39145e-17
C28 (\2\:A1 VSS) capacitor c=5.33438e-17
C29 (\2\:A0 VSS) capacitor c=4.88495e-17
C30 (\5\:Y VSS) capacitor c=6.72231e-17
C31 (\3\:net118 VSS) capacitor c=7.67993e-17
C32 (\3\:net122 VSS) capacitor c=9.72523e-17
C33 (\5\:net118 VSS) capacitor c=6.29055e-17
C34 (\1\:VDD VSS) capacitor c=2.266e-16
C35 (\4\:VDD VSS) capacitor c=3.7453e-17
C36 (\3\:Y VSS) capacitor c=9.98564e-17
C37 (\1\:Y VSS) capacitor c=7.42746e-17
C38 (\2\:B1 VSS) capacitor c=4.9891e-17
C39 (\4\:A0 VSS) capacitor c=3.76665e-17
C40 (\4\:A1 VSS) capacitor c=6.7884e-17
C41 (\5\:B1 VSS) capacitor c=3.2092e-17
C42 (\7\:B1 VSS) capacitor c=7.56554e-17
C43 (\4\:B0 VSS) capacitor c=5.13188e-17
C44 (\4\:C0 VSS) capacitor c=1.23936e-16
C45 (\5\:C1 VSS) capacitor c=3.85663e-17
C46 (\6\:C1 VSS) capacitor c=8.56998e-17
C47 (\3\:VDD VSS) capacitor c=4.09706e-17
Rk11 (\4\:C1 \5\:C1) resistor r=0.002024 c=0
Rk12 (\6\:C1 C1) resistor r=0.002091 c=0
Rk13 (\5\:C1 \6\:C1) resistor r=0.09482 c=0
Rk17 (\4\:Y Y) resistor r=0.4959 c=0
Rk16 (\2\:Y \4\:Y) resistor r=0.4841 c=0
Rk18 (Y \6\:Y) resistor r=0.32 c=0
Rk5 (\5\:B1 \6\:B1) resistor r=0.002024 c=0
Rk6 (B1 \7\:B1) resistor r=0.001956 c=0
Rk7 (\5\:B1 \7\:B1) resistor r=0.09482 c=0
Rk10 (\4\:C0 C0) resistor r=0.01234 c=0
Rk4 (A1 \4\:A1) resistor r=0.1891 c=0
Rk24 (\3\:VDD VDD) resistor r=0.03969 c=0
Rk23 (\2\:VDD \3\:VDD) resistor r=0.3938 c=0
Rk25 (\3\:VDD \5\:VDD) resistor r=0.2793 c=0
Rk9 (\4\:B0 B0) resistor r=0.0767 c=0
Rk3 (\4\:A0 A0) resistor r=0.01803 c=0
Rk19 (\2\:VSS \4\:VSS) resistor r=0.288 c=0
Rk21 (\5\:VSS VSS) resistor r=0.08985 c=0
Rk20 (\4\:VSS \5\:VSS) resistor r=0.3108 c=0
Rk22 (\5\:VSS \7\:VSS) resistor r=0.1871 c=0
Rk8 (\2\:net122 \4\:net122) resistor r=0.5158 c=0
Rk14 (\2\:net118 \4\:net118) resistor r=0.295 c=0
Rk15 (\4\:net118 \6\:net118) resistor r=0.295 c=0
Rl12 (\1\:C1 \2\:C1) resistor r=143.464 c=0
Rl13 (\2\:C1 \3\:C1) resistor r=79.2614 c=0
Rl5 (\1\:B1 \2\:B1) resistor r=152.726 c=0
Rl7 (\2\:B1 \4\:B1) resistor r=64.2642 c=0
Rl6 (\2\:B1 \3\:B1) resistor r=14.8815 c=0
Rl10 (\1\:C0 \2\:C0) resistor r=79.5379 c=0
Rl11 (\2\:C0 \3\:C0) resistor r=121.846 c=0
Rl3 (\1\:A1 \2\:A1) resistor r=171.846 c=0
Rl4 (\2\:A1 \3\:A1) resistor r=29.5379 c=0
Rl8 (\1\:B0 \2\:B0) resistor r=65.782 c=0
Rl9 (\2\:B0 \3\:B0) resistor r=137.637 c=0
Rl2 (\2\:A0 \3\:A0) resistor r=157.487 c=0
Rl1 (\1\:A0 \2\:A0) resistor r=42.2849 c=0
Rz1 (\1\:Y \2\:Y) resistor r=75 c=0
Rz2 (\3\:Y \4\:Y) resistor r=75 c=0
Rz3 (\1\:VSS \2\:VSS) resistor r=75 c=0
Rz4 (\6\:VSS \7\:VSS) resistor r=75 c=0
Ry6 (\5\:Y \6\:Y) resistor r=62 c=0
Ry8 (\1\:VDD \2\:VDD) resistor r=62 c=0
Ry9 (\4\:VDD \5\:VDD) resistor r=20.6667 c=0
Ry1 (net122 \2\:net122) resistor r=31 c=0
Ry2 (\3\:net122 \4\:net122) resistor r=62 c=0
Ry3 (net118 \2\:net118) resistor r=62 c=0
Ry4 (\3\:net118 \4\:net118) resistor r=62 c=0
Ry5 (\5\:net118 \6\:net118) resistor r=62 c=0
Rx6 (\2\:C1 \4\:C1) resistor r=45 c=0
Rx3 (\3\:B1 \6\:B1) resistor r=45 c=0
Rx5 (\2\:C0 \4\:C0) resistor r=45 c=0
Rx2 (\2\:A1 \4\:A1) resistor r=45 c=0
Rx4 (\2\:B0 \4\:B0) resistor r=45 c=0
Rx1 (\2\:A0 \4\:A0) resistor r=45 c=0
mn0 (net139 \1\:A0 \6\:VSS VSS) g45n1svt w=(2.6e-07) l=4.5e-08 nf=1 \
        as=3.64e-14 ad=1.56e-14 ps=8e-07 pd=6.4e-07 nrd=1.16667 \
        nrs=1.16667 sa=1.4e-07 sb=1.165e-06 sd=160n sca=8.09546 \
        scb=0.00588493 scc=0.000117119 m=(1)
mn1 (\1\:Y \3\:A1 net139 VSS) g45n1svt w=(2.6e-07) l=4.5e-08 nf=1 \
        as=1.56e-14 ad=9.36e-14 ps=6.4e-07 pd=1.24e-06 nrd=1.16667 \
        nrs=1.16667 sa=2.45e-07 sb=1.06e-06 sd=160n sca=8.09546 \
        scb=0.00588493 scc=0.000117119 m=(1)
mn3 (\1\:Y \4\:B1 net147 VSS) g45n1svt w=(2.6e-07) l=4.5e-08 nf=1 \
        as=1.82e-14 ad=9.36e-14 ps=6.6e-07 pd=1.24e-06 nrd=1.16667 \
        nrs=1.16667 sa=6.5e-07 sb=6.55e-07 sd=160n sca=8.09546 \
        scb=0.00588493 scc=0.000117119 m=(1)
mn2 (net147 \3\:B0 \1\:VSS VSS) g45n1svt w=(2.6e-07) l=4.5e-08 nf=1 \
        as=6.5e-14 ad=1.82e-14 ps=1.02e-06 pd=6.6e-07 nrd=1.16667 \
        nrs=1.16667 sa=7.65e-07 sb=5.4e-07 sd=160n sca=8.09546 \
        scb=0.00588493 scc=0.000117119 m=(1)
mn4 (net155 \3\:C0 \1\:VSS VSS) g45n1svt w=(2.6e-07) l=4.5e-08 nf=1 \
        as=6.5e-14 ad=1.56e-14 ps=1.02e-06 pd=6.4e-07 nrd=1.16667 \
        nrs=1.16667 sa=1.06e-06 sb=2.45e-07 sd=160n sca=8.09546 \
        scb=0.00588493 scc=0.000117119 m=(1)
mn5 (\3\:Y \3\:C1 net155 VSS) g45n1svt w=(2.6e-07) l=4.5e-08 nf=1 \
        as=1.56e-14 ad=3.64e-14 ps=6.4e-07 pd=8e-07 nrd=1.16667 \
        nrs=1.16667 sa=1.165e-06 sb=1.4e-07 sd=160n sca=8.09546 \
        scb=0.00588493 scc=0.000117119 m=(1)
ends AOI222X1
// End of subcircuit definition.
