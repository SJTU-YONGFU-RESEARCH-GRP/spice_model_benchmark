// gsclib045_lvt/SEDFFX4/schematic

simulator lang=spectre

subckt SEDFFX4 CK D E Q QN SE SI VDD VSS
mp4 (Db Eb net473 VDD) g45p1lvt w=(215n) l=45n nf=1 m=(1)
mp3 (net473 D VDD VDD) g45p1lvt w=(215n) l=45n nf=1 m=(1)
mp13 (Dbp SEb net465 VDD) g45p1lvt w=(215n) l=45n nf=1 m=(1)
mp12 (net465 SI VDD VDD) g45p1lvt w=(215n) l=45n nf=1 m=(1)
mp51 (n30 CKbb net457 VDD) g45p1lvt w=(215n) l=45n nf=1 m=(1)
mp50 (net457 net536 VDD VDD) g45p1lvt w=(215n) l=45n nf=1 m=(1)
mp57 (QN net502 VDD VDD) g45p1lvt w=(1.56u) l=45n nf=1 m=(1)
mp55 (Q net536 VDD VDD) g45p1lvt w=(1.56u) l=45n nf=1 m=(1)
mp35 (net437 mout VDD VDD) g45p1lvt w=(215n) l=45n nf=1 m=(1)
mp36 (n20 CKb net437 VDD) g45p1lvt w=(215n) l=45n nf=1 m=(1)
mp20 (CKb CK VDD VDD) g45p1lvt w=(215n) l=45n nf=1 m=(1)
mp1 (net425 net502 VDD VDD) g45p1lvt w=(215n) l=45n nf=1 m=(1)
mp2 (Db E net425 VDD) g45p1lvt w=(215n) l=45n nf=1 m=(1)
mp45 (net536 n30 VDD VDD) g45p1lvt w=(620n) l=45n nf=1 m=(1)
mp56 (net502 net536 VDD VDD) g45p1lvt w=(390n) l=45n nf=1 m=(1)
mp21 (CKbb CKb VDD VDD) g45p1lvt w=(215n) l=45n nf=1 m=(1)
mp40 (n30 CKb mout VDD) g45p1lvt w=(215n) l=45n nf=1 m=(1)
mp30 (mout n20 VDD VDD) g45p1lvt w=(215n) l=45n nf=1 m=(1)
mp0 (Eb E VDD VDD) g45p1lvt w=(215n) l=45n nf=1 m=(1)
mp25 (n20 CKbb Dbp VDD) g45p1lvt w=(215n) l=45n nf=1 m=(1)
mp11 (Dbp SE Db VDD) g45p1lvt w=(215n) l=45n nf=1 m=(1)
mp10 (SEb SE VDD VDD) g45p1lvt w=(215n) l=45n nf=1 m=(1)
mn4 (Db E net554 VSS) g45n1lvt w=(145n) l=45n nf=1 m=(1)
mn3 (net554 D VSS VSS) g45n1lvt w=(145n) l=45n nf=1 m=(1)
mn13 (Dbp SE net546 VSS) g45n1lvt w=(145n) l=45n nf=1 m=(1)
mn12 (net546 SI VSS VSS) g45n1lvt w=(145n) l=45n nf=1 m=(1)
mn57 (QN net502 VSS VSS) g45n1lvt w=(1.04u) l=45n nf=1 m=(1)
mn55 (Q net536 VSS VSS) g45n1lvt w=(1.04u) l=45n nf=1 m=(1)
mn50 (net534 net536 VSS VSS) g45n1lvt w=(145n) l=45n nf=1 m=(1)
mn51 (n30 CKb net534 VSS) g45n1lvt w=(145n) l=45n nf=1 m=(1)
mn35 (net526 mout VSS VSS) g45n1lvt w=(145n) l=45n nf=1 m=(1)
mn36 (n20 CKbb net526 VSS) g45n1lvt w=(145n) l=45n nf=1 m=(1)
mn20 (CKb CK VSS VSS) g45n1lvt w=(145n) l=45n nf=1 m=(1)
mn1 (net514 net502 VSS VSS) g45n1lvt w=(145n) l=45n nf=1 m=(1)
mn2 (Db Eb net514 VSS) g45n1lvt w=(145n) l=45n nf=1 m=(1)
mn45 (net536 n30 VSS VSS) g45n1lvt w=(410n) l=45n nf=1 m=(1)
mn56 (net502 net536 VSS VSS) g45n1lvt w=(260n) l=45n nf=1 m=(1)
mn21 (CKbb CKb VSS VSS) g45n1lvt w=(145n) l=45n nf=1 m=(1)
mn40 (mout CKbb n30 VSS) g45n1lvt w=(145n) l=45n nf=1 m=(1)
mn10 (SEb SE VSS VSS) g45n1lvt w=(145n) l=45n nf=1 m=(1)
mn30 (mout n20 VSS VSS) g45n1lvt w=(145n) l=45n nf=1 m=(1)
mn0 (Eb E VSS VSS) g45n1lvt w=(145n) l=45n nf=1 m=(1)
mn25 (Dbp CKb n20 VSS) g45n1lvt w=(145n) l=45n nf=1 m=(1)
mn11 (Db SEb Dbp VSS) g45n1lvt w=(145n) l=45n nf=1 m=(1)
ends SEDFFX4
