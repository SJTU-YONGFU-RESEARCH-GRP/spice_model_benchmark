// Generated for: spectre (May  1 09:13:31 2013 )
// Library name: gsclib045_hvt
// Cell name: TBUFX3
// View name: extracted

simulator lang=spectre

subckt TBUFX3 A OE VDD VSS Y
mp4 (\6\:pon \3\:OE \14\:VDD VDD) g45p1hvt w=(3.9e-07) l=4.5e-08 nf=1 \
        as=5.46e-14 ad=6.24e-14 ps=1.06e-06 pd=1.1e-06 nrd=1.16667 \
        nrs=1.16667 sa=1.4e-07 sb=5.04551e-07 sd=160n sca=24.3383 \
        scb=0.0260706 scc=0.00165215 m=(1)
mp3 (\6\:pon \1\:A \12\:VDD VDD) g45p1hvt w=(3.9e-07) l=4.5e-08 nf=1 \
        as=8.305e-14 ad=6.24e-14 ps=1.32e-06 pd=1.1e-06 nrd=1.16667 \
        nrs=1.16667 sa=3.45e-07 sb=2.99551e-07 sd=160n sca=19.1183 \
        scb=0.0171898 scc=0.00129044 m=(1)
mp2 (\9\:non OEb net127 VDD) g45p1hvt w=(3.9e-07) l=4.5e-08 nf=1 \
        as=2.34e-14 ad=5.46e-14 ps=9e-07 pd=1.06e-06 nrd=1.16667 \
        nrs=1.16667 sa=1.4e-07 sb=9.35e-07 sd=160n sca=30.5009 \
        scb=0.0202006 scc=0.00336097 m=(1)
mp1 (net127 \4\:A \3\:VDD VDD) g45p1hvt w=(3.9e-07) l=4.5e-08 nf=1 \
        as=6.825e-14 ad=2.34e-14 ps=1.13e-06 pd=9e-07 nrd=1.16667 \
        nrs=1.16667 sa=2.45e-07 sb=8.3e-07 sd=160n sca=30.5804 \
        scb=0.0202168 scc=0.00336097 m=(1)
mp5_1__rcx (\4\:Y pon \3\:VDD VDD) g45p1hvt w=(3.9e-07) l=4.5e-08 nf=1 \
        as=8.795e-14 ad=5.98e-14 ps=1.32333e-06 pd=1.08667e-06 nrd=1.16667 \
        nrs=1.16667 sa=4.65e-07 sb=6.1e-07 sd=160n sca=31.2654 \
        scb=0.0205378 scc=0.00336116 m=(3)
C1 (OE VSS) capacitor c=6.21399e-17
C2 (Y VSS) capacitor c=2.44631e-17
C3 (VDD VSS) capacitor c=1.13393e-16
C4 (A VSS) capacitor c=2.50623e-17
C5 (pon VSS) capacitor c=1.44979e-16
C6 (OEb VSS) capacitor c=8.94277e-17
C7 (non VSS) capacitor c=1.16202e-16
C8 (net127 VSS) capacitor c=3.8178e-18
C9 (\4\:A VSS) capacitor c=8.82175e-17
C10 (\4\:OE VSS) capacitor c=3.5817e-17
C11 (\1\:A VSS) capacitor c=4.35692e-17
C12 (\3\:OE VSS) capacitor c=4.46822e-17
C13 (\6\:A VSS) capacitor c=2.76e-17
C14 (\4\:OEb VSS) capacitor c=2.88849e-17
C15 (\7\:OE VSS) capacitor c=2.46644e-17
C16 (\3\:A VSS) capacitor c=6.18229e-17
C17 (\1\:OE VSS) capacitor c=4.1049e-17
C18 (\4\:non VSS) capacitor c=2.31324e-17
C19 (\5\:A VSS) capacitor c=4.92731e-17
C20 (\3\:OEb VSS) capacitor c=1.25091e-17
C21 (\6\:OE VSS) capacitor c=1.90335e-17
C22 (\2\:A VSS) capacitor c=4.12156e-17
C23 (\2\:OE VSS) capacitor c=3.67514e-17
C24 (\9\:non VSS) capacitor c=3.24912e-17
C25 (\7\:OEb VSS) capacitor c=9.327e-17
C26 (\12\:VDD VSS) capacitor c=3.50294e-17
C27 (\6\:pon VSS) capacitor c=2.17575e-16
C28 (\14\:VDD VSS) capacitor c=2.80602e-17
C29 (\1\:VDD VSS) capacitor c=2.75601e-17
C30 (\1\:Y VSS) capacitor c=7.64518e-17
C31 (\11\:non VSS) capacitor c=6.24995e-17
C32 (\9\:OEb VSS) capacitor c=3.07581e-17
C33 (\8\:pon VSS) capacitor c=7.92024e-17
C34 (\5\:OE VSS) capacitor c=1.44661e-17
C35 (\2\:OEb VSS) capacitor c=3.39372e-17
C36 (\8\:OE VSS) capacitor c=5.58462e-17
C37 (\5\:OEb VSS) capacitor c=2.00046e-17
C38 (\6\:OEb VSS) capacitor c=5.02989e-17
C39 (\7\:A VSS) capacitor c=1.63369e-16
C40 (\8\:A VSS) capacitor c=1.52476e-16
C41 (\9\:A VSS) capacitor c=5.44811e-17
C42 (\7\:non VSS) capacitor c=7.41149e-17
C43 (\8\:non VSS) capacitor c=5.99983e-17
C44 (\5\:pon VSS) capacitor c=1.96635e-16
C45 (\4\:Y VSS) capacitor c=9.95621e-17
C46 (\3\:VDD VSS) capacitor c=9.17733e-17
C47 (\6\:VDD VSS) capacitor c=1.61499e-17
C48 (\7\:VDD VSS) capacitor c=7.57484e-18
Rk2 (\9\:OE OE) resistor r=0.003271 c=0
Rk1 (\8\:OE \9\:OE) resistor r=0.2153 c=0
Rk15 (\1\:Y Y) resistor r=0.2199 c=0
Rk16 (Y \4\:Y) resistor r=0.04988 c=0
Rk29 (\2\:VDD \3\:VDD) resistor r=0.1327 c=0
Rk31 (\3\:VDD \5\:VDD) resistor r=0.2981 c=0
Rk32 (\5\:VDD \6\:VDD) resistor r=0.3056 c=0
Rk34 (\7\:VDD VDD) resistor r=0.03966 c=0
Rk33 (\6\:VDD \7\:VDD) resistor r=0.2051 c=0
Rk37 (\6\:VDD \13\:VDD) resistor r=0.2154 c=0
Rk38 (\7\:VDD \15\:VDD) resistor r=0.2577 c=0
Rk8 (\8\:A A) resistor r=0.0262 c=0
Rk6 (\7\:A \8\:A) resistor r=1.1854 c=0
Rk7 (\8\:A \9\:A) resistor r=0.2681 c=0
Rk20 (\2\:VSS \3\:VSS) resistor r=0.1126 c=0
Rk22 (\3\:VSS \5\:VSS) resistor r=0.3344 c=0
Rk26 (\10\:VSS VSS) resistor r=0.2377 c=0
Rk25 (\5\:VSS \10\:VSS) resistor r=0.3131 c=0
Rk27 (\5\:VSS \12\:VSS) resistor r=0.07144 c=0
Rk28 (\10\:VSS \14\:VSS) resistor r=0.2466 c=0
Rk12 (\5\:pon \7\:pon) resistor r=1.5174 c=0
Rk13 (\7\:pon \9\:pon) resistor r=0.7166 c=0
Rk3 (\5\:OEb \6\:OEb) resistor r=0.1109 c=0
Rk4 (\6\:OEb \8\:OEb) resistor r=0.4762 c=0
Rk5 (\6\:OEb \10\:OEb) resistor r=0.05947 c=0
Rk9 (\7\:non \8\:non) resistor r=0.4473 c=0
Rk10 (\8\:non \10\:non) resistor r=0.1057 c=0
Rk11 (\8\:non \12\:non) resistor r=0.2549 c=0
Rl2 (\2\:OE \3\:OE) resistor r=87.6374 c=0
Rl1 (\1\:OE \2\:OE) resistor r=30.7692 c=0
Rl5 (\4\:OE \5\:OE) resistor r=99.7141 c=0
Rl7 (\5\:OE \7\:OE) resistor r=34.3295 c=0
Rl6 (\5\:OE \6\:OE) resistor r=4.3144 c=0
Rl11 (\4\:A \5\:A) resistor r=91.0764 c=0
Rl12 (\5\:A \6\:A) resistor r=29.5379 c=0
Rl3 (\1\:A \2\:A) resistor r=26.098 c=0
Rl4 (\2\:A \3\:A) resistor r=83.7903 c=0
Rl8 (OEb \2\:OEb) resistor r=150.308 c=0
Rl10 (\2\:OEb \4\:OEb) resistor r=23.7402 c=0
Rl9 (\2\:OEb \3\:OEb) resistor r=16.1277 c=0
Rl18 (non \4\:non) resistor r=3.203 c=0
Rz10 (\2\:VDD \1\:VDD) resistor r=75 c=0
Rz11 (\5\:VDD \1\:VDD) resistor r=6.25 c=0
Rz8 (\12\:VSS \11\:VSS) resistor r=75 c=0
Rz9 (\14\:VSS \13\:VSS) resistor r=75 c=0
Rz3 (\9\:pon \8\:pon) resistor r=75 c=0
Rz1 (\9\:OEb \10\:OEb) resistor r=75 c=0
Rz2 (\12\:non \11\:non) resistor r=75 c=0
Ry10 (\13\:VDD \12\:VDD) resistor r=62 c=0
Ry11 (\15\:VDD \14\:VDD) resistor r=62 c=0
Ry6 (\2\:VSS \1\:VSS) resistor r=62 c=0
Ry7 (\5\:VSS \1\:VSS) resistor r=5.1667 c=0
Ry3 (\7\:pon \6\:pon) resistor r=20.6667 c=0
Ry1 (\7\:OEb \8\:OEb) resistor r=62 c=0
Ry2 (\10\:non \9\:non) resistor r=62 c=0
Rx1 (\6\:OE \8\:OE) resistor r=45 c=0
Rx2 (\2\:OE \9\:OE) resistor r=45 c=0
Rx4 (\5\:A \7\:A) resistor r=45 c=0
Rx5 (\2\:A \9\:A) resistor r=45 c=0
Rx7 (\5\:pon pon) resistor r=45 c=0
Rx3 (\3\:OEb \5\:OEb) resistor r=45 c=0
Rx6 (\7\:non \4\:non) resistor r=45 c=0
mn4 (\8\:pon \1\:OE net144 VSS) g45n1hvt w=(2.6e-07) l=4.5e-08 nf=1 \
        as=2.34e-14 ad=3.64e-14 ps=7e-07 pd=8e-07 nrd=1.16667 nrs=1.16667 \
        sa=1.4e-07 sb=5.42692e-07 sd=160n sca=12.1772 scb=0.0118935 \
        scc=0.000630577 m=(1)
mn3 (net144 \3\:A \13\:VSS VSS) g45n1hvt w=(2.6e-07) l=4.5e-08 nf=1 \
        as=5.017e-14 ad=2.34e-14 ps=9.9e-07 pd=7e-07 nrd=1.16667 \
        nrs=1.16667 sa=2.75e-07 sb=4.07692e-07 sd=160n sca=12.1772 \
        scb=0.0118935 scc=0.000630577 m=(1)
mn2 (\11\:non \4\:OEb \11\:VSS VSS) g45n1hvt w=(2.6e-07) l=4.5e-08 nf=1 \
        as=6.58e-14 ad=5.72e-14 ps=1.22e-06 pd=9.6e-07 nrd=1.16667 \
        nrs=1.16667 sa=1.7e-07 sb=1.105e-06 sd=160n sca=8.65991 \
        scb=0.00681295 scc=0.000165238 m=(1)
mn1 (\11\:non \6\:A \3\:VSS VSS) g45n1hvt w=(2.6e-07) l=4.5e-08 nf=1 \
        as=6.37e-14 ad=5.72e-14 ps=1.01e-06 pd=9.6e-07 nrd=1.16667 \
        nrs=1.16667 sa=4.35e-07 sb=8.4e-07 sd=160n sca=8.65991 \
        scb=0.00681295 scc=0.000165238 m=(1)
mn5_1__rcx (\1\:Y non \3\:VSS VSS) g45n1hvt w=(2.6e-07) l=4.5e-08 nf=1 \
        as=4.897e-14 ad=3.987e-14 ps=8.9667e-07 pd=8.2667e-07 nrd=1.16667 \
        nrs=1.16667 sa=7.25e-07 sb=5.5e-07 sd=160n sca=8.65991 \
        scb=0.00681295 scc=0.000165238 m=(3)
mn0 (\9\:OEb \7\:OE \13\:VSS VSS) g45n1hvt w=(1.45e-07) l=4.5e-08 nf=1 \
        as=5.017e-14 ad=4.93e-14 ps=9.9e-07 pd=9.7e-07 nrd=1.16667 \
        nrs=1.16667 sa=5.55e-07 sb=3.4e-07 sd=160n sca=15.2405 \
        scb=0.016218 scc=0.00104639 m=(1)
mp0 (\7\:OEb \4\:OE \12\:VDD VDD) g45p1hvt w=(2.15e-07) l=4.5e-08 nf=1 \
        as=8.305e-14 ad=3.01e-14 ps=1.32e-06 pd=7.1e-07 nrd=1.16667 \
        nrs=1.16667 sa=6.1e-07 sb=1.4e-07 sd=160n sca=22.5405 \
        scb=0.0210689 scc=0.00225095 m=(1)
ends TBUFX3
// End of subcircuit definition.
