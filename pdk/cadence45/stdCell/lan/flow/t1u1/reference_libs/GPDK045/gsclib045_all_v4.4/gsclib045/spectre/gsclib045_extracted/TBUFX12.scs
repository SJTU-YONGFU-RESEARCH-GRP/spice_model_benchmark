// Generated for: spectre (May  1 08:09:20 2013 )
// Library name: gsclib045
// Cell name: TBUFX12
// View name: extracted

simulator lang=spectre

subckt TBUFX12 A OE VDD VSS Y
mp0 (\14\:OEb \1\:OE \26\:VDD VDD) g45p1svt w=(3.9e-07) l=4.5e-08 nf=1 \
        as=8.945e-14 ad=6.63e-14 ps=1.36e-06 pd=1.12e-06 nrd=1.16667 \
        nrs=1.16667 sa=1.7e-07 sb=1.50135e-06 sd=160n sca=24.3916 \
        scb=0.0229031 scc=0.00193544 m=(1)
mp5_1__rcx (Y pon \1\:VDD VDD) g45p1svt w=(3.9e-07) l=4.5e-08 nf=1 \
        as=6.403e-14 ad=6.24e-14 ps=1.11583e-06 pd=1.1e-06 nrd=1.16667 \
        nrs=1.16667 sa=8.53333e-07 sb=2e-06 sd=160n sca=13.5671 \
        scb=0.012183 scc=0.000647513 m=(12)
C1 (OE VSS) capacitor c=3.20491e-17
C2 (Y VSS) capacitor c=8.82295e-16
C3 (VDD VSS) capacitor c=3.68835e-16
C4 (A VSS) capacitor c=1.48672e-15
C5 (OEb VSS) capacitor c=6.79285e-17
C6 (pon VSS) capacitor c=4.27619e-16
C7 (14 VSS) capacitor c=1.84769e-18
C8 (15 VSS) capacitor c=5.60508e-20
C9 (16 VSS) capacitor c=1.82655e-18
C10 (non VSS) capacitor c=3.65999e-16
C11 (5 VSS) capacitor c=4.32879e-18
C12 (6 VSS) capacitor c=2.85578e-18
C13 (7 VSS) capacitor c=2.83609e-18
C14 (8 VSS) capacitor c=2.12885e-18
C15 (\23\:A VSS) capacitor c=8.05921e-17
C16 (\8\:OEb VSS) capacitor c=8.89549e-17
C17 (\13\:OEb VSS) capacitor c=6.6494e-17
C18 (\16\:A VSS) capacitor c=6.15335e-17
C19 (\21\:A VSS) capacitor c=5.32364e-17
C20 (\5\:OEb VSS) capacitor c=2.24603e-17
C21 (\10\:A VSS) capacitor c=4.02802e-17
C22 (\1\:OE VSS) capacitor c=5.32749e-17
C23 (\15\:A VSS) capacitor c=3.35594e-17
C24 (\16\:OE VSS) capacitor c=3.14062e-17
C25 (\18\:OE VSS) capacitor c=5.09329e-17
C26 (\7\:A VSS) capacitor c=3.80259e-17
C27 (\8\:A VSS) capacitor c=2.34238e-17
C28 (\4\:OE VSS) capacitor c=3.76037e-17
C29 (\11\:OE VSS) capacitor c=2.28311e-17
C30 (\3\:A VSS) capacitor c=5.39025e-17
C31 (\3\:OE VSS) capacitor c=3.53238e-17
C32 (\13\:non VSS) capacitor c=3.80551e-17
C33 (\6\:OEb VSS) capacitor c=1.71462e-17
C34 (\2\:OEb VSS) capacitor c=4.72265e-16
C35 (\5\:OE VSS) capacitor c=4.15794e-16
C36 (\8\:OE VSS) capacitor c=2.516e-17
C37 (\2\:OE VSS) capacitor c=2.58483e-17
C38 (\1\:VDD VSS) capacitor c=6.01909e-16
C39 (\40\:non VSS) capacitor c=4.5017e-17
C40 (\24\:VDD VSS) capacitor c=4.96067e-17
C41 (\34\:non VSS) capacitor c=1.23511e-16
C42 (\4\:VDD VSS) capacitor c=5.73287e-17
C43 (\25\:non VSS) capacitor c=3.2328e-16
C44 (\24\:pon VSS) capacitor c=7.89243e-17
C45 (\34\:pon VSS) capacitor c=8.21445e-17
C46 (\16\:OEb VSS) capacitor c=4.95678e-17
C47 (\7\:OE VSS) capacitor c=1.03551e-17
C48 (\19\:OE VSS) capacitor c=5.05983e-17
C49 (\20\:OE VSS) capacitor c=3.68865e-17
C50 (\15\:OEb VSS) capacitor c=2.07688e-16
C51 (\18\:OEb VSS) capacitor c=2.31185e-16
C52 (\32\:non VSS) capacitor c=7.3576e-17
C53 (\33\:non VSS) capacitor c=1.45693e-16
C54 (\26\:pon VSS) capacitor c=5.25467e-16
C55 (\36\:pon VSS) capacitor c=2.63591e-16
C56 (\23\:VDD VSS) capacitor c=2.18118e-17
C57 (\26\:VDD VSS) capacitor c=1.83454e-16
Rk1 (\19\:OE OE) resistor r=0.1575 c=0
Rk2 (OE \20\:OE) resistor r=0.06326 c=0
Rk88 (\1\:VSS \16\:VSS) resistor r=0.3934 c=0
Rk89 (\16\:VSS \17\:VSS) resistor r=0.1653 c=0
Rk91 (\18\:VSS VSS) resistor r=0.1827 c=0
Rk90 (\17\:VSS \18\:VSS) resistor r=0.3685 c=0
Rk102 (\16\:VSS \40\:VSS) resistor r=0.2646 c=0
Rk103 (\18\:VSS \42\:VSS) resistor r=0.2547 c=0
Rk61 (\1\:VDD \22\:VDD) resistor r=0.1679 c=0
Rk62 (\22\:VDD \23\:VDD) resistor r=0.223 c=0
Rk63 (\23\:VDD \25\:VDD) resistor r=0.24 c=0
Rk75 (\26\:VDD VDD) resistor r=0.1827 c=0
Rk64 (\23\:VDD \26\:VDD) resistor r=0.3809 c=0
Rk4 (\15\:OEb \17\:OEb) resistor r=0.4064 c=0
Rk5 (\15\:OEb \18\:OEb) resistor r=1.8402 c=0
Rk22 (\25\:pon \26\:pon) resistor r=0.3642 c=0
Rk27 (\26\:pon \35\:pon) resistor r=0.3926 c=0
Rk28 (\26\:pon \36\:pon) resistor r=1.9434 c=0
Rk16 (\25\:non \32\:non) resistor r=0.2383 c=0
Rk17 (\32\:non \33\:non) resistor r=0.4675 c=0
Rk18 (\33\:non \35\:non) resistor r=0.6406 c=0
Rk21 (\33\:non \41\:non) resistor r=0.1133 c=0
Rl20 (\5\:OE \16\:OE) resistor r=84.2969 c=0
Rl22 (\5\:OE \18\:OE) resistor r=89.8352 c=0
Rl5 (\5\:OE \4\:OE) resistor r=97.3098 c=0
Rl1 (\2\:OE \1\:OE) resistor r=73.7687 c=0
Rl2 (\2\:OE \3\:OE) resistor r=29.5379 c=0
Rl11 (\7\:OE \11\:OE) resistor r=34.3295 c=0
Rl7 (\7\:OE \5\:OE) resistor r=56.64 c=0
Rl8 (\7\:OE \8\:OE) resistor r=2.0166 c=0
Rl45 (A \23\:A) resistor r=114.264 c=0
Rl34 (A \16\:A) resistor r=84.5933 c=0
Rl38 (A \21\:A) resistor r=24.2328 c=0
Rl23 (A \10\:A) resistor r=78.3307 c=0
Rl27 (A \15\:A) resistor r=84.3341 c=0
Rl14 (A \7\:A) resistor r=28.0797 c=0
Rl15 (A \8\:A) resistor r=30.2861 c=0
Rl4 (A \3\:A) resistor r=98.7687 c=0
Rl32 (\6\:OEb \5\:OEb) resistor r=29.5379 c=0
Rl40 (\2\:OEb \8\:OEb) resistor r=210.338 c=0
Rl44 (\2\:OEb \13\:OEb) resistor r=94.0258 c=0
Rl28 (\2\:OEb OEb) resistor r=133.437 c=0
Rl31 (\2\:OEb \5\:OEb) resistor r=86.8321 c=0
Rl59 (non \13\:non) resistor r=9.5799 c=0
Rz28 (\40\:VSS \39\:VSS) resistor r=75 c=0
Rz29 (\42\:VSS \41\:VSS) resistor r=75 c=0
Rz14 (\1\:VDD \4\:VDD) resistor r=8.3333 c=0
Rz15 (\22\:VDD \4\:VDD) resistor r=6.25 c=0
Rz16 (\26\:VDD \4\:VDD) resistor r=6.25 c=0
Rz1 (\17\:OEb \16\:OEb) resistor r=75 c=0
Rz6 (\25\:pon \24\:pon) resistor r=75 c=0
Rz7 (\35\:pon \34\:pon) resistor r=75 c=0
Ry27 (\1\:VSS \4\:VSS) resistor r=2.9524 c=0
Ry29 (\17\:VSS \4\:VSS) resistor r=5.1667 c=0
Ry21 (\25\:VDD \24\:VDD) resistor r=62 c=0
Ry1 (\15\:OEb \14\:OEb) resistor r=20.6667 c=0
Ry2 (\35\:non \34\:non) resistor r=62 c=0
Ry3 (\41\:non \40\:non) resistor r=62 c=0
Rx1 (\19\:OE \8\:OE) resistor r=45 c=0
Rx2 (\20\:OE \2\:OE) resistor r=45 c=0
Rx5 (\18\:OEb \6\:OEb) resistor r=45 c=0
Rx14 (\36\:pon pon) resistor r=45 c=0
Rx13 (\32\:non \13\:non) resistor r=45 c=0
mn0 (\16\:OEb \3\:OE \41\:VSS VSS) g45n1svt w=(2.6e-07) l=4.5e-08 nf=1 \
        as=4.94e-14 ad=4.42e-14 ps=9.6e-07 pd=8.6e-07 nrd=1.16667 \
        nrs=1.16667 sa=1.7e-07 sb=1.50837e-06 sd=160n sca=12.8392 \
        scb=0.0126987 scc=0.00074151 m=(1)
mn5_1__rcx (Y non \1\:VSS VSS) g45n1svt w=(2.6e-07) l=4.5e-08 nf=1 \
        as=4.082e-14 ad=4.16e-14 ps=8.3667e-07 pd=8.4e-07 nrd=1.16667 \
        nrs=1.16667 sa=1.35827e-06 sb=2e-06 sd=160n sca=9.14564 \
        scb=0.00759168 scc=0.000213449 m=(12)
mn3_1__rcx (13 \3\:A \41\:VSS VSS) g45n1svt w=(1.95e-07) l=4.5e-08 nf=1 \
        as=4.94e-14 ad=3.12e-14 ps=9.6e-07 pd=7.1e-07 nrd=1.16667 \
        nrs=1.16667 sa=4.35e-07 sb=1.92077e-06 sd=160n sca=10.4876 \
        scb=0.00973116 scc=0.000329538 m=(1)
mn4_1__rcx (\34\:pon \11\:OE 13 VSS) g45n1svt w=(1.95e-07) l=4.5e-08 nf=1 \
        as=3.12e-14 ad=6.728e-14 ps=7.1e-07 pd=1.08e-06 nrd=1.16667 \
        nrs=1.16667 sa=6.4e-07 sb=1.84192e-06 sd=160n sca=10.4876 \
        scb=0.00973116 scc=0.000329538 m=(1)
mn4_2__rcx (\34\:pon \4\:OE 14 VSS) g45n1svt w=(1.95e-07) l=4.5e-08 nf=1 \
        as=2.535e-14 ad=6.728e-14 ps=6.5e-07 pd=1.08e-06 nrd=1.16667 \
        nrs=1.16667 sa=1.03e-06 sb=1.68885e-06 sd=160n sca=10.4876 \
        scb=0.00973116 scc=0.000329538 m=(1)
mn3_2__rcx (14 \8\:A \39\:VSS VSS) g45n1svt w=(1.95e-07) l=4.5e-08 nf=1 \
        as=3.09e-14 ad=2.535e-14 ps=7.1e-07 pd=6.5e-07 nrd=1.16667 \
        nrs=1.16667 sa=1.205e-06 sb=1.61705e-06 sd=160n sca=10.4876 \
        scb=0.00973116 scc=0.000329538 m=(1)
mn1_1__rcx (\25\:non A \1\:VSS VSS) g45n1svt w=(1.95e-07) l=4.5e-08 nf=1 \
        as=3.09e-14 ad=3.26e-14 ps=7.1e-07 pd=7.8e-07 nrd=1.16667 \
        nrs=1.16667 sa=1.95128e-06 sb=1.285e-06 sd=160n sca=10.2695 \
        scb=0.00939499 scc=0.000302823 m=(2)
mn2_1__rcx (\25\:non \2\:OEb \1\:VSS VSS) g45n1svt w=(1.95e-07) \
        l=4.5e-08 nf=1 as=3.12e-14 ad=3.26e-14 ps=7.1e-07 pd=7.8e-07 \
        nrd=1.16667 nrs=1.16667 sa=1.27449e-06 sb=1.96179e-06 sd=160n \
        sca=7.99316 scb=0.0056435 scc=9.07136e-05 m=(2)
mn3_3__rcx (15 \7\:A \39\:VSS VSS) g45n1svt w=(1.9e-07) l=4.5e-08 nf=1 \
        as=3.09e-14 ad=1.14e-14 ps=7.1e-07 pd=5e-07 nrd=1.16667 \
        nrs=1.16667 sa=1.41e-06 sb=1.57605e-06 sd=160n sca=10.353 \
        scb=0.00952974 scc=0.000309813 m=(1)
mn4_3__rcx (\24\:pon \18\:OE 15 VSS) g45n1svt w=(1.9e-07) l=4.5e-08 nf=1 \
        as=1.14e-14 ad=4.37e-14 ps=5e-07 pd=8.4e-07 nrd=1.16667 \
        nrs=1.16667 sa=1.515e-06 sb=1.53461e-06 sd=160n sca=10.353 \
        scb=0.00952974 scc=0.000309813 m=(1)
mn4 (\24\:pon \16\:OE 16 VSS) g45n1svt w=(1.9e-07) l=4.5e-08 nf=1 \
        as=2.945e-14 ad=4.37e-14 ps=6.9e-07 pd=8.4e-07 nrd=1.16667 \
        nrs=1.16667 sa=1.79e-06 sb=1.42605e-06 sd=160n sca=10.353 \
        scb=0.00952974 scc=0.000309813 m=(1)
mn3 (16 \15\:A \1\:VSS VSS) g45n1svt w=(1.9e-07) l=4.5e-08 nf=1 \
        as=3.09e-14 ad=2.945e-14 ps=7.1e-07 pd=6.9e-07 nrd=1.16667 \
        nrs=1.16667 sa=1.99e-06 sb=1.34711e-06 sd=160n sca=10.353 \
        scb=0.00952974 scc=0.000309813 m=(1)
mn1_3__rcx (\25\:non A \1\:VSS VSS) g45n1svt w=(1.9e-07) l=4.5e-08 nf=1 \
        as=3.415e-14 ad=3.04e-14 ps=7.75e-07 pd=7e-07 nrd=1.16667 \
        nrs=1.16667 sa=1.49816e-06 sb=2e-06 sd=160n sca=7.92284 \
        scb=0.00551663 scc=8.5052e-05 m=(2)
mn2_3__rcx (\25\:non \2\:OEb \1\:VSS VSS) g45n1svt w=(1.9e-07) l=4.5e-08 \
        nf=1 as=3.04e-14 ad=3.04e-14 ps=7e-07 pd=7e-07 nrd=1.16667 \
        nrs=1.16667 sa=1.57908e-06 sb=2e-06 sd=160n sca=7.92284 \
        scb=0.00551663 scc=8.5052e-05 m=(2)
mp1_1__rcx (5 \10\:A \26\:VDD VDD) g45p1svt w=(2.95e-07) l=4.5e-08 nf=1 \
        as=7.24e-14 ad=5.015e-14 ps=1.83e-06 pd=9.3e-07 nrd=1.16667 \
        nrs=1.16667 sa=1.96085e-06 sb=1.37424e-06 sd=160n sca=24.985 \
        scb=0.0208309 scc=0.00278311 m=(1)
mp2_1__rcx (\34\:non \5\:OEb 5 VDD) g45p1svt w=(2.95e-07) l=4.5e-08 nf=1 \
        as=5.015e-14 ad=4.72e-14 ps=9.3e-07 pd=9.1e-07 nrd=1.16667 \
        nrs=1.16667 sa=1.97144e-06 sb=1.24305e-06 sd=160n sca=24.985 \
        scb=0.0208309 scc=0.00278311 m=(1)
mp2_2__rcx (\34\:non OEb 6 VDD) g45p1svt w=(2.95e-07) l=4.5e-08 nf=1 \
        as=1.77e-14 ad=4.72e-14 ps=7.1e-07 pd=9.1e-07 nrd=1.16667 \
        nrs=1.16667 sa=1.97492e-06 sb=1.11797e-06 sd=160n sca=24.985 \
        scb=0.0208309 scc=0.00278311 m=(1)
mp1_2__rcx (6 \21\:A \24\:VDD VDD) g45p1svt w=(2.95e-07) l=4.5e-08 nf=1 \
        as=8.135e-14 ad=1.77e-14 ps=1.32e-06 pd=7.1e-07 nrd=1.16667 \
        nrs=1.16667 sa=1.97669e-06 sb=1.0539e-06 sd=160n sca=24.985 \
        scb=0.0208309 scc=0.00278311 m=(1)
mp3_1__rcx (\26\:pon A \26\:VDD VDD) g45p1svt w=(2.95e-07) l=4.5e-08 \
        nf=1 as=8.093e-14 ad=4.74e-14 ps=1.595e-06 pd=9.2e-07 nrd=1.16667 \
        nrs=1.16667 sa=4.35e-07 sb=1.91661e-06 sd=160n sca=24.0377 \
        scb=0.0205536 scc=0.00241838 m=(2)
mp4_1__rcx (\26\:pon \5\:OE \26\:VDD VDD) g45p1svt w=(2.95e-07) \
        l=4.5e-08 nf=1 as=1.2427e-13 ad=4.74e-14 ps=2.18e-06 pd=9.2e-07 \
        nrd=1.16667 nrs=1.16667 sa=6.21695e-07 sb=1.97754e-06 sd=160n \
        sca=25.2842 scb=0.0209131 scc=0.00278313 m=(2)
mp1_3__rcx (7 \16\:A \24\:VDD VDD) g45p1svt w=(2.9e-07) l=4.5e-08 nf=1 \
        as=8.135e-14 ad=1.74e-14 ps=1.32e-06 pd=7e-07 nrd=1.16667 \
        nrs=1.16667 sa=1.94931e-06 sb=9.47759e-07 sd=160n sca=23.09 \
        scb=0.0200797 scc=0.00245753 m=(1)
mp2_3__rcx (\40\:non \13\:OEb 7 VDD) g45p1svt w=(2.9e-07) l=4.5e-08 nf=1 \
        as=1.74e-14 ad=6.4e-14 ps=7e-07 pd=1.42e-06 nrd=1.16667 \
        nrs=1.16667 sa=1.95293e-06 sb=8.86207e-07 sd=160n sca=23.09 \
        scb=0.0200797 scc=0.00245753 m=(1)
mp2 (\40\:non \8\:OEb 8 VDD) g45p1svt w=(2.9e-07) l=4.5e-08 nf=1 \
        as=1.74e-14 ad=6.4e-14 ps=7e-07 pd=1.42e-06 nrd=1.16667 \
        nrs=1.16667 sa=8.4931e-07 sb=2e-06 sd=160n sca=10.9993 \
        scb=0.00888516 scc=0.000178627 m=(1)
mp1 (8 \23\:A \1\:VDD VDD) g45p1svt w=(2.9e-07) l=4.5e-08 nf=1 \
        as=8.975e-14 ad=1.74e-14 ps=1.33e-06 pd=7e-07 nrd=1.16667 \
        nrs=1.16667 sa=9.14483e-07 sb=2e-06 sd=160n sca=10.9993 \
        scb=0.00888516 scc=0.000178627 m=(1)
mp3_2__rcx (\26\:pon A \26\:VDD VDD) g45p1svt w=(2.9e-07) l=4.5e-08 nf=1 \
        as=7.24e-14 ad=5.438e-14 ps=1.83e-06 pd=9.55e-07 nrd=1.16667 \
        nrs=1.16667 sa=1.39138e-06 sb=1.93759e-06 sd=160n sca=25.2314 \
        scb=0.0210442 scc=0.00282901 m=(2)
mp4_3__rcx (\26\:pon \5\:OE \26\:VDD VDD) g45p1svt w=(2.9e-07) l=4.5e-08 \
        nf=1 as=1.124e-13 ad=5.437e-14 ps=1.83e-06 pd=9.55e-07 nrd=1.16667 \
        nrs=1.16667 sa=1.59638e-06 sb=1.81034e-06 sd=160n sca=25.2314 \
        scb=0.0210442 scc=0.00282901 m=(2)
ends TBUFX12
// End of subcircuit definition.
