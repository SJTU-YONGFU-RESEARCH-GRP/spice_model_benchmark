// Generated for: spectre (May  1 09:18:56 2013 )
// Library name: gsclib045_hvt
// Cell name: OAI222X1
// View name: extracted

simulator lang=spectre

subckt OAI222X1 A0 A1 B0 B1 C0 C1 VDD VSS Y
mp0 (n2 \1\:A0 \6\:VDD VDD) g45p1hvt w=(3.9e-07) l=4.5e-08 nf=1 \
        as=5.46e-14 ad=2.34e-14 ps=1.06e-06 pd=9e-07 nrd=1.16667 \
        nrs=1.16667 sa=1.4e-07 sb=1.13e-06 sd=160n sca=19.3961 \
        scb=0.0212947 scc=0.000662871 m=(1)
mp1 (\4\:Y \1\:A1 n2 VDD) g45p1hvt w=(3.9e-07) l=4.5e-08 nf=1 as=2.34e-14 \
        ad=1.2675e-13 ps=9e-07 pd=1.43e-06 nrd=1.16667 nrs=1.16667 \
        sa=2.45e-07 sb=1.025e-06 sd=160n sca=15.6981 scb=0.0150296 \
        scc=0.000323375 m=(1)
mp3 (\4\:Y \1\:B1 n3 VDD) g45p1hvt w=(3.9e-07) l=4.5e-08 nf=1 as=6.24e-14 \
        ad=1.2675e-13 ps=1.1e-06 pd=1.43e-06 nrd=1.16667 nrs=1.16667 \
        sa=6.15e-07 sb=6.55e-07 sd=160n sca=12.3518 scb=0.0100158 \
        scc=0.000258343 m=(1)
mp2 (n3 \1\:B0 \1\:VDD VDD) g45p1hvt w=(3.9e-07) l=4.5e-08 nf=1 \
        as=6.24e-14 ad=6.24e-14 ps=1.1e-06 pd=1.1e-06 nrd=1.16667 \
        nrs=1.16667 sa=8.2e-07 sb=4.5e-07 sd=160n sca=12.6156 \
        scb=0.0103368 scc=0.000258831 m=(1)
mp4 (n4 \1\:C0 \1\:VDD VDD) g45p1hvt w=(3.9e-07) l=4.5e-08 nf=1 \
        as=6.24e-14 ad=2.34e-14 ps=1.1e-06 pd=9e-07 nrd=1.16667 \
        nrs=1.16667 sa=1.025e-06 sb=2.45e-07 sd=160n sca=14.6264 \
        scb=0.0131608 scc=0.000282649 m=(1)
mp5 (\6\:Y \3\:C1 n4 VDD) g45p1hvt w=(3.9e-07) l=4.5e-08 nf=1 as=2.34e-14 \
        ad=5.46e-14 ps=9e-07 pd=1.06e-06 nrd=1.16667 nrs=1.16667 \
        sa=1.13e-06 sb=1.4e-07 sd=160n sca=17.0903 scb=0.0174873 \
        scc=0.00041511 m=(1)
C1 (B0 VSS) capacitor c=5.21961e-17
C2 (A0 VSS) capacitor c=2.43549e-17
C3 (C1 VSS) capacitor c=2.02808e-17
C4 (VDD VSS) capacitor c=1.27921e-16
C5 (A1 VSS) capacitor c=4.78686e-17
C6 (Y VSS) capacitor c=2.35612e-17
C7 (n1 VSS) capacitor c=9.59904e-17
C8 (n0 VSS) capacitor c=6.28785e-17
C9 (n2 VSS) capacitor c=1.65716e-18
C10 (n3 VSS) capacitor c=6.31835e-18
C11 (n4 VSS) capacitor c=2.99166e-18
C12 (\3\:C1 VSS) capacitor c=7.49377e-17
C13 (\1\:C0 VSS) capacitor c=1.05572e-16
C14 (\1\:B0 VSS) capacitor c=5.63231e-17
C15 (\1\:B1 VSS) capacitor c=4.57237e-17
C16 (\1\:A1 VSS) capacitor c=7.39795e-17
C17 (\1\:A0 VSS) capacitor c=6.19781e-17
C18 (\1\:C1 VSS) capacitor c=4.36773e-17
C19 (\3\:C0 VSS) capacitor c=4.20834e-17
C20 (\3\:B0 VSS) capacitor c=5.5923e-17
C21 (\3\:B1 VSS) capacitor c=5.10351e-17
C22 (\3\:A1 VSS) capacitor c=4.4559e-17
C23 (\3\:A0 VSS) capacitor c=4.39191e-17
C24 (\2\:C1 VSS) capacitor c=6.13779e-17
C25 (\2\:C0 VSS) capacitor c=6.04915e-17
C26 (\2\:B0 VSS) capacitor c=5.98508e-17
C27 (\2\:B1 VSS) capacitor c=4.86431e-17
C28 (\2\:A1 VSS) capacitor c=4.16473e-17
C29 (\2\:A0 VSS) capacitor c=4.6931e-17
C30 (\6\:Y VSS) capacitor c=3.0091e-17
C31 (\1\:VDD VSS) capacitor c=5.42252e-17
C32 (\4\:Y VSS) capacitor c=1.17565e-16
C33 (\6\:VDD VSS) capacitor c=2.92612e-17
C34 (\1\:Y VSS) capacitor c=1.0401e-16
C35 (\3\:n0 VSS) capacitor c=8.04284e-17
C36 (\5\:n0 VSS) capacitor c=6.63917e-17
C37 (\3\:n1 VSS) capacitor c=5.20822e-17
C38 (\4\:A0 VSS) capacitor c=5.99106e-17
C39 (\4\:A1 VSS) capacitor c=1.06595e-16
C40 (\4\:B1 VSS) capacitor c=1.13366e-16
C41 (\4\:B0 VSS) capacitor c=3.97293e-17
C42 (\4\:C0 VSS) capacitor c=5.0917e-17
C43 (\5\:C0 VSS) capacitor c=3.90618e-17
C44 (\4\:C1 VSS) capacitor c=3.91342e-17
C45 (\3\:Y VSS) capacitor c=1.11322e-16
C46 (\4\:VDD VSS) capacitor c=6.05554e-17
C47 (\5\:VDD VSS) capacitor c=1.46089e-17
Rk5 (B0 \4\:B0) resistor r=0.1139 c=0
Rk1 (\4\:A0 A0) resistor r=0.03923 c=0
Rk9 (C1 \4\:C1) resistor r=0.01123 c=0
Rk16 (\2\:VDD \4\:VDD) resistor r=0.3549 c=0
Rk18 (\5\:VDD VDD) resistor r=0.03721 c=0
Rk17 (\4\:VDD \5\:VDD) resistor r=0.3136 c=0
Rk19 (\5\:VDD \7\:VDD) resistor r=0.2435 c=0
Rk21 (\3\:VSS VSS) resistor r=0.1751 c=0
Rk22 (VSS \5\:VSS) resistor r=0.07638 c=0
Rk23 (\3\:VSS \7\:VSS) resistor r=0.05844 c=0
Rk3 (B1 \4\:B1) resistor r=0.00365 c=0
Rk6 (C0 \4\:C0) resistor r=0.003363 c=0
Rk8 (\4\:C0 \5\:C0) resistor r=0.09016 c=0
Rk7 (\5\:C0 \6\:C0) resistor r=0.003462 c=0
Rk2 (A1 \4\:A1) resistor r=0.1575 c=0
Rk12 (\2\:Y \3\:Y) resistor r=0.5951 c=0
Rk13 (\3\:Y \5\:Y) resistor r=0.6465 c=0
Rk15 (\7\:Y Y) resistor r=0.06034 c=0
Rk14 (\3\:Y \7\:Y) resistor r=0.06822 c=0
Rk4 (\2\:n1 \4\:n1) resistor r=0.5007 c=0
Rk10 (\2\:n0 \4\:n0) resistor r=0.3063 c=0
Rk11 (\4\:n0 \6\:n0) resistor r=0.3082 c=0
Rl7 (\1\:B0 \2\:B0) resistor r=72.2519 c=0
Rl8 (\2\:B0 \3\:B0) resistor r=122.252 c=0
Rl1 (\1\:A0 \2\:A0) resistor r=30.7692 c=0
Rl2 (\2\:A0 \3\:A0) resistor r=110.372 c=0
Rl12 (\2\:C1 \3\:C1) resistor r=78.9444 c=0
Rl11 (\1\:C1 \2\:C1) resistor r=126.923 c=0
Rl5 (\1\:B1 \2\:B1) resistor r=75.6918 c=0
Rl6 (\2\:B1 \3\:B1) resistor r=125.692 c=0
Rl9 (\1\:C0 \2\:C0) resistor r=152.615 c=0
Rl10 (\2\:C0 \3\:C0) resistor r=48.7687 c=0
Rl3 (\1\:A1 \2\:A1) resistor r=79.9442 c=0
Rl4 (\2\:A1 \3\:A1) resistor r=49.1749 c=0
Rz8 (\4\:VSS \5\:VSS) resistor r=75 c=0
Rz9 (\6\:VSS \7\:VSS) resistor r=75 c=0
Rz6 (\1\:Y \2\:Y) resistor r=75 c=0
Rz1 (n1 \2\:n1) resistor r=75 c=0
Rz2 (\3\:n1 \4\:n1) resistor r=75 c=0
Rz3 (n0 \2\:n0) resistor r=75 c=0
Rz4 (\3\:n0 \4\:n0) resistor r=75 c=0
Rz5 (\5\:n0 \6\:n0) resistor r=75 c=0
Ry3 (\1\:VDD \2\:VDD) resistor r=31 c=0
Ry4 (\6\:VDD \7\:VDD) resistor r=31 c=0
Ry1 (\4\:Y \5\:Y) resistor r=31 c=0
Ry2 (\6\:Y \7\:Y) resistor r=31 c=0
Rx4 (\2\:B0 \4\:B0) resistor r=45 c=0
Rx1 (\2\:A0 \4\:A0) resistor r=45 c=0
Rx6 (\2\:C1 \4\:C1) resistor r=45 c=0
Rx3 (\2\:B1 \4\:B1) resistor r=45 c=0
Rx5 (\2\:C0 \6\:C0) resistor r=45 c=0
Rx2 (\2\:A1 \4\:A1) resistor r=45 c=0
mn0 (\3\:n1 \3\:A0 \4\:VSS VSS) g45n1hvt w=(2.6e-07) l=4.5e-08 nf=1 \
        as=5.25e-14 ad=4.16e-14 ps=1.5e-06 pd=8.4e-07 nrd=1.16667 \
        nrs=1.16667 sa=1e-07 sb=3.1e-07 sd=160n sca=17.5885 scb=0.0172826 \
        scc=0.00162584 m=(1)
mn1 (\3\:n1 \3\:A1 \6\:VSS VSS) g45n1hvt w=(2.6e-07) l=4.5e-08 nf=1 \
        as=5.465e-14 ad=4.16e-14 ps=1.5e-06 pd=8.4e-07 nrd=1.16667 \
        nrs=1.16667 sa=3.05e-07 sb=1.05e-07 sd=160n sca=17.5885 \
        scb=0.0172826 scc=0.00162584 m=(1)
mn3 (\5\:n0 \3\:B1 n1 VSS) g45n1hvt w=(2.6e-07) l=4.5e-08 nf=1 \
        as=4.16e-14 ad=3.64e-14 ps=8.4e-07 pd=8e-07 nrd=1.16667 \
        nrs=1.16667 sa=1.4e-07 sb=7.55e-07 sd=160n sca=7.84363 \
        scb=0.00546499 scc=9.84911e-05 m=(1)
mn2 (\3\:n0 \3\:B0 n1 VSS) g45n1hvt w=(2.6e-07) l=4.5e-08 nf=1 \
        as=4.16e-14 ad=4.16e-14 ps=8.4e-07 pd=8.4e-07 nrd=1.16667 \
        nrs=1.16667 sa=3.45e-07 sb=5.5e-07 sd=160n sca=7.84363 \
        scb=0.00546499 scc=9.84911e-05 m=(1)
mn4 (\1\:Y \3\:C0 \3\:n0 VSS) g45n1hvt w=(2.6e-07) l=4.5e-08 nf=1 \
        as=4.16e-14 ad=4.16e-14 ps=8.4e-07 pd=8.4e-07 nrd=1.16667 \
        nrs=1.16667 sa=5.5e-07 sb=3.45e-07 sd=160n sca=7.84363 \
        scb=0.00546499 scc=9.84911e-05 m=(1)
mn5 (\1\:Y \1\:C1 n0 VSS) g45n1hvt w=(2.6e-07) l=4.5e-08 nf=1 as=3.64e-14 \
        ad=4.16e-14 ps=8e-07 pd=8.4e-07 nrd=1.16667 nrs=1.16667 \
        sa=7.55e-07 sb=1.4e-07 sd=160n sca=7.84363 scb=0.00546499 \
        scc=9.84911e-05 m=(1)
ends OAI222X1
// End of subcircuit definition.
