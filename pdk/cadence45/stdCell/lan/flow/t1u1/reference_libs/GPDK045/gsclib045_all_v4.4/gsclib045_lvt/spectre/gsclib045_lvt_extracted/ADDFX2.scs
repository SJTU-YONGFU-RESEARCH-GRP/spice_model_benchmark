// Generated for: spectre (May  1 09:10:59 2013 )
// Library name: gsclib045_lvt
// Cell name: ADDFX2
// View name: extracted

simulator lang=spectre

subckt ADDFX2 A B CI CO S VDD VSS
mp13 (\3\:S Sb \1\:VDD VDD) g45p1lvt w=(3.9e-07) l=4.5e-08 nf=1 \
        as=6.83e-14 ad=6.24e-14 ps=1.22e-06 pd=1.1e-06 nrd=1.16667 \
        nrs=1.16667 sa=4.44551e-07 sb=3.45e-07 sd=160n sca=17.8374 \
        scb=0.0170197 scc=0.000849186 m=(2)
mp12_1__rcx (\1\:CO COb VDD VDD) g45p1lvt w=(3.9e-07) l=4.5e-08 nf=1 \
        as=5.46e-14 ad=6.24e-14 ps=1.06e-06 pd=1.1e-06 nrd=1.16667 \
        nrs=1.16667 sa=1.4e-07 sb=3.45e-07 sd=160n sca=38.0983 \
        scb=0.0376779 scc=0.00400735 m=(2)
C1 (CO VSS) capacitor c=3.33229e-17
C2 (A VSS) capacitor c=3.34305e-17
C3 (S VSS) capacitor c=4.58073e-17
C4 (VDD VSS) capacitor c=3.56267e-16
C5 (B VSS) capacitor c=3.72615e-17
C6 (CI VSS) capacitor c=7.89726e-17
C7 (COb VSS) capacitor c=1.06072e-16
C8 (n2 VSS) capacitor c=6.60678e-17
C9 (n4 VSS) capacitor c=7.74034e-17
C10 (Sb VSS) capacitor c=7.06273e-17
C11 (n7 VSS) capacitor c=1.94584e-18
C12 (n6 VSS) capacitor c=2.26118e-18
C13 (n3 VSS) capacitor c=6.34467e-17
C14 (n5 VSS) capacitor c=7.29765e-17
C15 (n9 VSS) capacitor c=1.29749e-18
C16 (n8 VSS) capacitor c=1.94624e-18
C17 (\10\:A VSS) capacitor c=6.60446e-17
C18 (\11\:B VSS) capacitor c=8.65718e-17
C19 (\8\:CI VSS) capacitor c=1.25021e-16
C20 (\8\:COb VSS) capacitor c=2.22177e-17
C21 (\9\:A VSS) capacitor c=5.70405e-17
C22 (\10\:B VSS) capacitor c=4.31113e-17
C23 (\7\:CI VSS) capacitor c=5.28966e-17
C24 (\6\:A VSS) capacitor c=6.59819e-17
C25 (\7\:B VSS) capacitor c=4.93572e-17
C26 (\1\:CI VSS) capacitor c=4.99186e-17
C27 (\4\:B VSS) capacitor c=4.37965e-17
C28 (\1\:A VSS) capacitor c=3.89438e-17
C29 (\12\:A VSS) capacitor c=4.90267e-17
C30 (\13\:B VSS) capacitor c=8.7611e-17
C31 (\11\:CI VSS) capacitor c=4.56463e-17
C32 (\10\:COb VSS) capacitor c=5.3484e-17
C33 (\7\:A VSS) capacitor c=4.34393e-17
C34 (\8\:B VSS) capacitor c=5.48712e-17
C35 (\5\:CI VSS) capacitor c=2.64619e-17
C36 (\4\:A VSS) capacitor c=5.59087e-17
C37 (\5\:B VSS) capacitor c=8.58203e-17
C38 (\3\:CI VSS) capacitor c=2.65576e-17
C39 (\3\:B VSS) capacitor c=5.17245e-17
C40 (\3\:A VSS) capacitor c=3.84866e-17
C41 (\4\:Sb VSS) capacitor c=1.52325e-17
C42 (\11\:A VSS) capacitor c=6.83762e-17
C43 (\12\:B VSS) capacitor c=9.089e-17
C44 (\10\:CI VSS) capacitor c=2.04868e-17
C45 (\11\:COb VSS) capacitor c=4.91813e-17
C46 (\8\:A VSS) capacitor c=6.71098e-17
C47 (\9\:B VSS) capacitor c=5.78137e-17
C48 (\6\:CI VSS) capacitor c=4.43419e-17
C49 (\5\:A VSS) capacitor c=6.31171e-17
C50 (\6\:B VSS) capacitor c=5.61083e-17
C51 (\4\:CI VSS) capacitor c=3.89646e-17
C52 (\1\:B VSS) capacitor c=2.35634e-17
C53 (\2\:A VSS) capacitor c=2.8336e-17
C54 (\6\:COb VSS) capacitor c=7.40327e-18
C55 (\1\:VDD VSS) capacitor c=9.45295e-17
C56 (\3\:S VSS) capacitor c=5.45039e-17
C57 (\8\:Sb VSS) capacitor c=1.22985e-17
C58 (\16\:Sb VSS) capacitor c=4.37628e-17
C59 (\15\:VDD VSS) capacitor c=1.38272e-17
C60 (\3\:n5 VSS) capacitor c=7.42195e-17
C61 (\17\:VDD VSS) capacitor c=1.07441e-17
C62 (\17\:COb VSS) capacitor c=1.93089e-17
C63 (\19\:COb VSS) capacitor c=1.3071e-17
C64 (\19\:VDD VSS) capacitor c=1.15798e-17
C65 (\3\:n3 VSS) capacitor c=6.57698e-17
C66 (\1\:CO VSS) capacitor c=6.49112e-17
C67 (\4\:VDD VSS) capacitor c=5.4126e-17
C68 (\1\:S VSS) capacitor c=1.9044e-17
C69 (\12\:Sb VSS) capacitor c=7.80586e-17
C70 (\14\:Sb VSS) capacitor c=4.62149e-17
C71 (\3\:n4 VSS) capacitor c=7.45252e-17
C72 (\24\:COb VSS) capacitor c=6.19502e-17
C73 (\22\:COb VSS) capacitor c=4.05389e-17
C74 (\3\:n2 VSS) capacitor c=6.8621e-17
C75 (\4\:CO VSS) capacitor c=1.59265e-17
C76 (\2\:B VSS) capacitor c=3.19117e-17
C77 (\2\:CI VSS) capacitor c=3.44383e-17
C78 (\9\:COb VSS) capacitor c=3.84342e-17
C79 (\9\:CI VSS) capacitor c=5.826e-17
C80 (\3\:Sb VSS) capacitor c=6.70913e-17
C81 (\3\:CO VSS) capacitor c=1.76134e-17
C82 (\12\:COb VSS) capacitor c=1.99577e-16
C83 (\13\:COb VSS) capacitor c=1.28624e-16
C84 (\14\:COb VSS) capacitor c=1.07942e-16
C85 (\15\:COb VSS) capacitor c=1.59564e-16
C86 (\16\:COb VSS) capacitor c=2.42814e-17
C87 (\21\:COb VSS) capacitor c=1.3148e-16
C88 (\12\:CI VSS) capacitor c=1.43462e-16
C89 (\13\:CI VSS) capacitor c=1.89068e-16
C90 (\14\:CI VSS) capacitor c=3.04929e-17
C91 (\14\:B VSS) capacitor c=1.46739e-16
C92 (\15\:B VSS) capacitor c=1.69269e-16
C93 (\16\:B VSS) capacitor c=6.15861e-17
C94 (\17\:B VSS) capacitor c=7.24361e-17
C95 (\18\:B VSS) capacitor c=9.10858e-17
C96 (\13\:A VSS) capacitor c=1.32103e-16
C97 (\14\:A VSS) capacitor c=2.11599e-16
C98 (\15\:A VSS) capacitor c=2.0913e-16
C99 (\16\:A VSS) capacitor c=1.4046e-16
C100 (\10\:Sb VSS) capacitor c=8.46426e-17
C101 (\11\:Sb VSS) capacitor c=1.81641e-16
C102 (\6\:VDD VSS) capacitor c=2.19359e-17
C103 (\7\:VDD VSS) capacitor c=2.5277e-17
C104 (\9\:VDD VSS) capacitor c=8.77378e-18
Rk2 (\3\:CO CO) resistor r=0.1357 c=0
Rk1 (\2\:CO \3\:CO) resistor r=0.2202 c=0
Rk3 (\3\:CO \5\:CO) resistor r=0.1623 c=0
Rk25 (\13\:A A) resistor r=0.06557 c=0
Rk26 (\13\:A \14\:A) resistor r=0.7932 c=0
Rk27 (\14\:A \15\:A) resistor r=0.6933 c=0
Rk28 (\15\:A \16\:A) resistor r=0.8404 c=0
Rk34 (\2\:S S) resistor r=0.1254 c=0
Rk35 (S \4\:S) resistor r=0.2559 c=0
Rk37 (\1\:VDD \5\:VDD) resistor r=0.2054 c=0
Rk38 (\5\:VDD \6\:VDD) resistor r=0.4327 c=0
Rk39 (\6\:VDD \7\:VDD) resistor r=0.2419 c=0
Rk40 (\7\:VDD \8\:VDD) resistor r=0.4763 c=0
Rk42 (\9\:VDD VDD) resistor r=0.2353 c=0
Rk41 (\8\:VDD \9\:VDD) resistor r=0.1252 c=0
Rk46 (\6\:VDD \16\:VDD) resistor r=0.04331 c=0
Rk47 (\7\:VDD \18\:VDD) resistor r=0.07393 c=0
Rk48 (\9\:VDD \20\:VDD) resistor r=0.07393 c=0
Rk20 (\14\:B \15\:B) resistor r=0.8613 c=0
Rk24 (\16\:B B) resistor r=0.09945 c=0
Rk21 (\15\:B \16\:B) resistor r=0.4055 c=0
Rk22 (\16\:B \17\:B) resistor r=0.1781 c=0
Rk23 (\17\:B \18\:B) resistor r=0.4817 c=0
Rk18 (\13\:CI CI) resistor r=0.5487 c=0
Rk17 (\12\:CI \13\:CI) resistor r=0.8562 c=0
Rk19 (CI \14\:CI) resistor r=0.01762 c=0
Rk51 (\1\:VSS \5\:VSS) resistor r=0.2205 c=0
Rk52 (\5\:VSS \6\:VSS) resistor r=0.376 c=0
Rk53 (\6\:VSS \7\:VSS) resistor r=0.288 c=0
Rk58 (\8\:VSS VSS) resistor r=0.3471 c=0
Rk54 (\7\:VSS \8\:VSS) resistor r=0.4888 c=0
Rk56 (\6\:VSS \12\:VSS) resistor r=0.1026 c=0
Rk57 (\7\:VSS \14\:VSS) resistor r=0.2029 c=0
Rk60 (\8\:VSS \17\:VSS) resistor r=0.07147 c=0
Rk8 (\12\:COb \13\:COb) resistor r=1.326 c=0
Rk9 (\13\:COb \14\:COb) resistor r=0.2254 c=0
Rk10 (\14\:COb \15\:COb) resistor r=0.8921 c=0
Rk11 (\15\:COb \16\:COb) resistor r=0.1482 c=0
Rk12 (\13\:COb \18\:COb) resistor r=0.07468 c=0
Rk13 (\14\:COb \20\:COb) resistor r=0.07468 c=0
Rk14 (\15\:COb \21\:COb) resistor r=0.9012 c=0
Rk15 (\21\:COb \23\:COb) resistor r=0.115 c=0
Rk16 (\21\:COb \25\:COb) resistor r=0.2821 c=0
Rk5 (\2\:n2 \4\:n2) resistor r=0.2358 c=0
Rk7 (\2\:n4 \4\:n4) resistor r=0.2822 c=0
Rk29 (\9\:Sb \10\:Sb) resistor r=0.0279 c=0
Rk30 (\10\:Sb \11\:Sb) resistor r=0.789 c=0
Rk31 (\11\:Sb \13\:Sb) resistor r=0.6146 c=0
Rk32 (\13\:Sb \15\:Sb) resistor r=0.1664 c=0
Rk33 (\10\:Sb \17\:Sb) resistor r=0.1905 c=0
Rk4 (\2\:n3 \4\:n3) resistor r=0.2358 c=0
Rk6 (\2\:n5 \4\:n5) resistor r=0.2358 c=0
Rl33 (\10\:A \11\:A) resistor r=162.23 c=0
Rl34 (\11\:A \12\:A) resistor r=100.692 c=0
Rl24 (\8\:A \9\:A) resistor r=132.669 c=0
Rl23 (\7\:A \8\:A) resistor r=84.4104 c=0
Rl18 (\5\:A \6\:A) resistor r=83.9406 c=0
Rl17 (\4\:A \5\:A) resistor r=89.6422 c=0
Rl7 (\1\:A \2\:A) resistor r=58.3841 c=0
Rl8 (\2\:A \3\:A) resistor r=29.5379 c=0
Rl31 (\11\:B \12\:B) resistor r=112.23 c=0
Rl32 (\12\:B \13\:B) resistor r=150.692 c=0
Rl22 (\9\:B \10\:B) resistor r=26.3736 c=0
Rl21 (\8\:B \9\:B) resistor r=151.923 c=0
Rl16 (\6\:B \7\:B) resistor r=24.2328 c=0
Rl15 (\5\:B \6\:B) resistor r=164.183 c=0
Rl11 (\2\:B \4\:B) resistor r=37.3411 c=0
Rl10 (\2\:B \3\:B) resistor r=96.9565 c=0
Rl9 (\1\:B \2\:B) resistor r=0.6084 c=0
Rl20 (\6\:CI \7\:CI) resistor r=149.451 c=0
Rl19 (\5\:CI \6\:CI) resistor r=28.8462 c=0
Rl12 (\1\:CI \2\:CI) resistor r=112.695 c=0
Rl13 (\2\:CI \3\:CI) resistor r=28.0797 c=0
Rl14 (\2\:CI \4\:CI) resistor r=120.348 c=0
Rl28 (\8\:CI \9\:CI) resistor r=235.905 c=0
Rl30 (\9\:CI \11\:CI) resistor r=49.1216 c=0
Rl29 (\9\:CI \10\:CI) resistor r=10.5855 c=0
Rl5 (COb \6\:COb) resistor r=9.5287 c=0
Rl25 (\9\:COb \8\:COb) resistor r=35.772 c=0
Rl26 (\9\:COb \10\:COb) resistor r=187.695 c=0
Rl27 (\9\:COb \11\:COb) resistor r=97.2715 c=0
Rl36 (\3\:Sb Sb) resistor r=79.8492 c=0
Rl37 (\3\:Sb \4\:Sb) resistor r=4.3693 c=0
Rz1 (\5\:CO \4\:CO) resistor r=75 c=0
Rz10 (\2\:S \1\:S) resistor r=75 c=0
Rz11 (\5\:VDD \4\:VDD) resistor r=6.8182 c=0
Rz12 (\8\:VDD \4\:VDD) resistor r=6.25 c=0
Rz15 (\12\:VSS \11\:VSS) resistor r=75 c=0
Rz16 (\14\:VSS \13\:VSS) resistor r=75 c=0
Rz17 (\17\:VSS \16\:VSS) resistor r=75 c=0
Rz6 (\23\:COb \22\:COb) resistor r=75 c=0
Rz7 (\25\:COb \24\:COb) resistor r=75 c=0
Rz2 (n2 \2\:n2) resistor r=75 c=0
Rz3 (\3\:n2 \4\:n2) resistor r=75 c=0
Rz4 (n4 \2\:n4) resistor r=75 c=0
Rz5 (\3\:n4 \4\:n4) resistor r=75 c=0
Rz8 (\13\:Sb \12\:Sb) resistor r=75 c=0
Rz9 (\15\:Sb \14\:Sb) resistor r=75 c=0
Ry1 (\2\:CO \1\:CO) resistor r=20.6667 c=0
Ry10 (\4\:S \3\:S) resistor r=62 c=0
Ry14 (\16\:VDD \15\:VDD) resistor r=62 c=0
Ry15 (\18\:VDD \17\:VDD) resistor r=62 c=0
Ry16 (\20\:VDD \19\:VDD) resistor r=62 c=0
Ry18 (\5\:VSS \4\:VSS) resistor r=5.6364 c=0
Ry19 (\8\:VSS \4\:VSS) resistor r=5.1667 c=0
Ry6 (\18\:COb \17\:COb) resistor r=62 c=0
Ry7 (\20\:COb \19\:COb) resistor r=62 c=0
Ry8 (\9\:Sb \8\:Sb) resistor r=62 c=0
Ry9 (\17\:Sb \16\:Sb) resistor r=62 c=0
Ry2 (n3 \2\:n3) resistor r=62 c=0
Ry3 (\3\:n3 \4\:n3) resistor r=62 c=0
Ry4 (n5 \2\:n5) resistor r=62 c=0
Ry5 (\3\:n5 \4\:n5) resistor r=62 c=0
Rx10 (\11\:A \13\:A) resistor r=45 c=0
Rx11 (\8\:A \14\:A) resistor r=45 c=0
Rx12 (\5\:A \15\:A) resistor r=45 c=0
Rx13 (\2\:A \16\:A) resistor r=45 c=0
Rx6 (\12\:B \14\:B) resistor r=45 c=0
Rx7 (\9\:B \15\:B) resistor r=45 c=0
Rx8 (\6\:B \17\:B) resistor r=45 c=0
Rx9 (\1\:B \18\:B) resistor r=45 c=0
Rx3 (\10\:CI \12\:CI) resistor r=45 c=0
Rx4 (\6\:CI \13\:CI) resistor r=45 c=0
Rx5 (\4\:CI \14\:CI) resistor r=45 c=0
Rx1 (\12\:COb \11\:COb) resistor r=45 c=0
Rx2 (\16\:COb \6\:COb) resistor r=45 c=0
Rx14 (\11\:Sb \4\:Sb) resistor r=45 c=0
mn13_1__rcx (\1\:S \3\:Sb \1\:VSS VSS) g45n1lvt w=(2.6e-07) l=4.5e-08 \
        nf=1 as=4.57e-14 ad=4.16e-14 ps=9.6e-07 pd=8.4e-07 nrd=1.16667 \
        nrs=1.16667 sa=4.48558e-07 sb=3.45e-07 sd=160n sca=9.32128 \
        scb=0.00786794 scc=0.000232361 m=(2)
mn12 (\4\:CO COb VSS VSS) g45n1lvt w=(2.6e-07) l=4.5e-08 nf=1 \
        as=3.64e-14 ad=4.16e-14 ps=8e-07 pd=8.4e-07 nrd=1.16667 \
        nrs=1.16667 sa=1.4e-07 sb=3.45e-07 sd=160n sca=17.5885 \
        scb=0.0172826 scc=0.00162584 m=(2)
mn2 (\3\:n2 \3\:A \16\:VSS VSS) g45n1lvt w=(1.45e-07) l=4.5e-08 nf=1 \
        as=4.915e-14 ad=2.03e-14 ps=1.49e-06 pd=5.7e-07 nrd=1.16667 \
        nrs=1.16667 sa=1.4e-07 sb=4.48966e-07 sd=160n sca=15.7071 \
        scb=0.0167369 scc=0.00113434 m=(1)
mn3 (n2 \3\:B \16\:VSS VSS) g45n1lvt w=(1.45e-07) l=4.5e-08 nf=1 \
        as=4.915e-14 ad=2.32e-14 ps=1.49e-06 pd=6.1e-07 nrd=1.16667 \
        nrs=1.16667 sa=2.86379e-07 sb=3.45e-07 sd=160n sca=13.253 \
        scb=0.0137915 scc=0.000695334 m=(1)
mn4 (\22\:COb \3\:CI n2 VSS) g45n1lvt w=(1.45e-07) l=4.5e-08 nf=1 \
        as=2.32e-14 ad=2.03e-14 ps=6.1e-07 pd=5.7e-07 nrd=1.16667 \
        nrs=1.16667 sa=4.91379e-07 sb=1.4e-07 sd=160n sca=13.253 \
        scb=0.0137915 scc=0.000695334 m=(1)
mn1 (\24\:COb \5\:B n0 VSS) g45n1lvt w=(1.45e-07) l=4.5e-08 nf=1 \
        as=8.7e-15 ad=2.03e-14 ps=4.1e-07 pd=5.7e-07 nrd=1.16667 \
        nrs=1.16667 sa=1.4e-07 sb=1.29e-06 sd=160n sca=7.47547 \
        scb=0.00467957 scc=5.27432e-05 m=(1)
mn0 (n0 \4\:A \13\:VSS VSS) g45n1lvt w=(1.45e-07) l=4.5e-08 nf=1 \
        as=4.278e-14 ad=8.7e-15 ps=8.8e-07 pd=4.1e-07 nrd=1.16667 \
        nrs=1.16667 sa=2.45e-07 sb=1.185e-06 sd=160n sca=7.47547 \
        scb=0.00467957 scc=5.27432e-05 m=(1)
mn7 (\3\:n4 \5\:CI \13\:VSS VSS) g45n1lvt w=(1.45e-07) l=4.5e-08 nf=1 \
        as=4.278e-14 ad=2.32e-14 ps=8.8e-07 pd=6.1e-07 nrd=1.16667 \
        nrs=1.16667 sa=5.85e-07 sb=8.45e-07 sd=160n sca=7.47547 \
        scb=0.00467957 scc=5.27432e-05 m=(1)
mn6 (\3\:n4 \8\:B \11\:VSS VSS) g45n1lvt w=(1.45e-07) l=4.5e-08 nf=1 \
        as=5.59e-14 ad=2.32e-14 ps=1.13e-06 pd=6.1e-07 nrd=1.16667 \
        nrs=1.16667 sa=7.9e-07 sb=6.4e-07 sd=160n sca=7.47547 \
        scb=0.00467957 scc=5.27432e-05 m=(1)
mn5 (n4 \7\:A \11\:VSS VSS) g45n1lvt w=(1.45e-07) l=4.5e-08 nf=1 \
        as=5.59e-14 ad=2.755e-14 ps=1.13e-06 pd=6.7e-07 nrd=1.16667 \
        nrs=1.16667 sa=1.055e-06 sb=3.75e-07 sd=160n sca=7.47547 \
        scb=0.00467957 scc=5.27432e-05 m=(1)
mn8 (\14\:Sb \10\:COb n4 VSS) g45n1lvt w=(1.45e-07) l=4.5e-08 nf=1 \
        as=2.755e-14 ad=2.03e-14 ps=6.7e-07 pd=5.7e-07 nrd=1.16667 \
        nrs=1.16667 sa=1.29e-06 sb=1.4e-07 sd=160n sca=7.47547 \
        scb=0.00467957 scc=5.27432e-05 m=(1)
mn11 (\12\:Sb \11\:CI n7 VSS) g45n1lvt w=(1.45e-07) l=4.5e-08 nf=1 \
        as=8.7e-15 ad=2.03e-14 ps=4.1e-07 pd=5.7e-07 nrd=1.16667 \
        nrs=1.16667 sa=1.4e-07 sb=9.3e-07 sd=160n sca=7.47547 \
        scb=0.00467957 scc=5.27432e-05 m=(1)
mn10 (n7 \13\:B n6 VSS) g45n1lvt w=(1.45e-07) l=4.5e-08 nf=1 as=1.305e-14 \
        ad=8.7e-15 ps=4.7e-07 pd=4.1e-07 nrd=1.16667 nrs=1.16667 \
        sa=2.45e-07 sb=8.25e-07 sd=160n sca=7.47547 scb=0.00467957 \
        scc=5.27432e-05 m=(1)
mn9 (n6 \12\:A \1\:VSS VSS) g45n1lvt w=(1.45e-07) l=4.5e-08 nf=1 \
        as=5.5e-14 ad=1.305e-14 ps=1.12e-06 pd=4.7e-07 nrd=1.16667 \
        nrs=1.16667 sa=3.8e-07 sb=6.9e-07 sd=160n sca=7.47547 \
        scb=0.00467957 scc=5.27432e-05 m=(1)
mp2 (\3\:n3 \1\:A \19\:VDD VDD) g45p1lvt w=(2.15e-07) l=4.5e-08 nf=1 \
        as=7.285e-14 ad=3.01e-14 ps=2.13e-06 pd=7.1e-07 nrd=1.16667 \
        nrs=1.16667 sa=1.4e-07 sb=4.37674e-07 sd=160n sca=45.7906 \
        scb=0.0283307 scc=0.00588417 m=(1)
mp3 (n3 \4\:B \19\:VDD VDD) g45p1lvt w=(2.15e-07) l=4.5e-08 nf=1 \
        as=7.285e-14 ad=3.44e-14 ps=2.13e-06 pd=7.5e-07 nrd=1.16667 \
        nrs=1.16667 sa=2.80349e-07 sb=3.45e-07 sd=160n sca=25.9192 \
        scb=0.0230503 scc=0.00301683 m=(1)
mp4 (\19\:COb \1\:CI n3 VDD) g45p1lvt w=(2.15e-07) l=4.5e-08 nf=1 \
        as=3.44e-14 ad=3.01e-14 ps=7.5e-07 pd=7.1e-07 nrd=1.16667 \
        nrs=1.16667 sa=4.85349e-07 sb=1.4e-07 sd=160n sca=25.9192 \
        scb=0.0230503 scc=0.00301683 m=(1)
mp1 (\17\:COb \7\:B n1 VDD) g45p1lvt w=(2.15e-07) l=4.5e-08 nf=1 \
        as=1.29e-14 ad=3.01e-14 ps=5.5e-07 pd=7.1e-07 nrd=1.16667 \
        nrs=1.16667 sa=1.4e-07 sb=1.18907e-06 sd=160n sca=25.9192 \
        scb=0.0230503 scc=0.00301683 m=(1)
mp0 (n1 \6\:A \17\:VDD VDD) g45p1lvt w=(2.15e-07) l=4.5e-08 nf=1 \
        as=9.723e-14 ad=1.29e-14 ps=2.11e-06 pd=5.5e-07 nrd=1.16667 \
        nrs=1.16667 sa=2.45e-07 sb=1.08407e-06 sd=160n sca=25.9192 \
        scb=0.0230503 scc=0.00301683 m=(1)
mp7 (\3\:n5 \7\:CI \17\:VDD VDD) g45p1lvt w=(2.15e-07) l=4.5e-08 nf=1 \
        as=9.723e-14 ad=3.44e-14 ps=2.11e-06 pd=7.5e-07 nrd=1.16667 \
        nrs=1.16667 sa=5.95e-07 sb=7.3407e-07 sd=160n sca=25.9192 \
        scb=0.0230503 scc=0.00301683 m=(1)
mp6 (\3\:n5 \10\:B \15\:VDD VDD) g45p1lvt w=(2.15e-07) l=4.5e-08 nf=1 \
        as=6.39e-14 ad=3.44e-14 ps=1.8e-06 pd=7.5e-07 nrd=1.16667 \
        nrs=1.16667 sa=8e-07 sb=5.2907e-07 sd=160n sca=25.9192 \
        scb=0.0230503 scc=0.00301683 m=(1)
mp5 (n5 \9\:A \15\:VDD VDD) g45p1lvt w=(2.15e-07) l=4.5e-08 nf=1 \
        as=6.39e-14 ad=7.202e-14 ps=1.8e-06 pd=1.1e-06 nrd=1.16667 \
        nrs=1.16667 sa=7.24419e-07 sb=5.2e-07 sd=160n sca=16.4667 \
        scb=0.0163489 scc=0.00112485 m=(1)
mp8 (\16\:Sb \8\:COb n5 VDD) g45p1lvt w=(2.15e-07) l=4.5e-08 nf=1 \
        as=7.202e-14 ad=3.01e-14 ps=1.1e-06 pd=7.1e-07 nrd=1.16667 \
        nrs=1.16667 sa=1.10442e-06 sb=1.4e-07 sd=160n sca=16.4667 \
        scb=0.0163489 scc=0.00112485 m=(1)
mp11 (\8\:Sb \8\:CI n9 VDD) g45p1lvt w=(2.15e-07) l=4.5e-08 nf=1 \
        as=1.29e-14 ad=3.01e-14 ps=5.5e-07 pd=7.1e-07 nrd=1.16667 \
        nrs=1.16667 sa=1.4e-07 sb=9.3e-07 sd=160n sca=10.3256 \
        scb=0.00769229 scc=9.29431e-05 m=(1)
mp10 (n9 \11\:B n8 VDD) g45p1lvt w=(2.15e-07) l=4.5e-08 nf=1 as=1.935e-14 \
        ad=1.29e-14 ps=6.1e-07 pd=5.5e-07 nrd=1.16667 nrs=1.16667 \
        sa=2.45e-07 sb=8.25e-07 sd=160n sca=10.46 scb=0.0077219 \
        scc=9.29465e-05 m=(1)
mp9 (n8 \10\:A \1\:VDD VDD) g45p1lvt w=(2.15e-07) l=4.5e-08 nf=1 \
        as=8.2e-14 ad=1.935e-14 ps=1.38e-06 pd=6.1e-07 nrd=1.16667 \
        nrs=1.16667 sa=3.8e-07 sb=6.9e-07 sd=160n sca=10.848 scb=0.0078767 \
        scc=9.30025e-05 m=(1)
ends ADDFX2
// End of subcircuit definition.
