// Generated for: spectre (May  1 09:18:54 2013 )
// Library name: gsclib045_lvt
// Cell name: OR4X2
// View name: extracted

simulator lang=spectre

subckt OR4X2 A B C D VDD VSS Y
mp3 (\11\:n0 \1\:D n3 VDD) g45p1lvt w=(2.15e-07) l=4.5e-08 nf=1 \
        as=2.472e-14 ad=3.01e-14 ps=6.6e-07 pd=7.1e-07 nrd=1.16667 \
        nrs=1.16667 sa=1.4e-07 sb=1.535e-06 sd=160n sca=26.6819 \
        scb=0.0261048 scc=0.0024743 m=(1)
mp2 (n3 \1\:C n2 VDD) g45p1lvt w=(2.15e-07) l=4.5e-08 nf=1 as=6.342e-14 \
        ad=2.472e-14 ps=1.02e-06 pd=6.6e-07 nrd=1.16667 nrs=1.16667 \
        sa=3e-07 sb=1.375e-06 sd=160n sca=24.5186 scb=0.0226595 \
        scc=0.00242717 m=(1)
mp1 (n2 \1\:B n1 VDD) g45p1lvt w=(2.15e-07) l=4.5e-08 nf=1 as=5.483e-14 \
        ad=6.342e-14 ps=9.4e-07 pd=1.02e-06 nrd=1.16667 nrs=1.16667 \
        sa=6.4e-07 sb=1.035e-06 sd=160n sca=22.9839 scb=0.0214342 \
        scc=0.00242442 m=(1)
mp0 (n1 \3\:A \1\:VDD VDD) g45p1lvt w=(2.15e-07) l=4.5e-08 nf=1 \
        as=9.867e-14 ad=5.482e-14 ps=1.47e-06 pd=9.4e-07 nrd=1.16667 \
        nrs=1.16667 sa=9.4e-07 sb=7.35e-07 sd=160n sca=23.2378 \
        scb=0.0215231 scc=0.00242444 m=(1)
C1 (B VSS) capacitor c=4.22631e-17
C2 (Y VSS) capacitor c=3.15631e-17
C3 (VDD VSS) capacitor c=9.59621e-17
C4 (C VSS) capacitor c=1.18375e-16
C5 (D VSS) capacitor c=6.73593e-17
C6 (A VSS) capacitor c=2.1485e-17
C7 (n0 VSS) capacitor c=1.47342e-16
C8 (n3 VSS) capacitor c=4.10478e-18
C9 (n2 VSS) capacitor c=1.16927e-17
C10 (n1 VSS) capacitor c=8.49871e-18
C11 (\3\:A VSS) capacitor c=3.47821e-17
C12 (\1\:B VSS) capacitor c=4.12124e-17
C13 (\1\:C VSS) capacitor c=3.52241e-17
C14 (\1\:D VSS) capacitor c=5.83094e-17
C15 (\1\:A VSS) capacitor c=3.05497e-17
C16 (\3\:B VSS) capacitor c=2.8412e-17
C17 (\3\:C VSS) capacitor c=5.54303e-17
C18 (\3\:D VSS) capacitor c=2.86843e-17
C19 (\5\:n0 VSS) capacitor c=1.34772e-17
C20 (\2\:A VSS) capacitor c=3.85523e-17
C21 (\2\:B VSS) capacitor c=3.22804e-17
C22 (\2\:C VSS) capacitor c=5.28035e-17
C23 (\2\:D VSS) capacitor c=4.20667e-17
C24 (\1\:VDD VSS) capacitor c=1.29575e-16
C25 (\3\:Y VSS) capacitor c=1.06527e-16
C26 (\11\:n0 VSS) capacitor c=7.28429e-17
C27 (\1\:Y VSS) capacitor c=1.90432e-17
C28 (\13\:n0 VSS) capacitor c=1.01241e-16
C29 (\15\:n0 VSS) capacitor c=6.36491e-17
C30 (\4\:D VSS) capacitor c=3.06538e-17
C31 (\4\:B VSS) capacitor c=6.31953e-17
C32 (\4\:A VSS) capacitor c=8.5512e-17
C33 (\9\:n0 VSS) capacitor c=6.1193e-17
C34 (\10\:n0 VSS) capacitor c=1.12525e-16
C35 (\5\:VDD VSS) capacitor c=2.12764e-17
Rk3 (\4\:B B) resistor r=0.152 c=0
Rk9 (Y \2\:Y) resistor r=0.1223 c=0
Rk10 (Y \4\:Y) resistor r=0.2953 c=0
Rk13 (\5\:VDD VDD) resistor r=0.4491 c=0
Rk12 (\1\:VDD \5\:VDD) resistor r=0.2419 c=0
Rk2 (\4\:C C) resistor r=0.003667 c=0
Rk1 (\4\:D D) resistor r=0.1867 c=0
Rk4 (A \4\:A) resistor r=0.02802 c=0
Rk17 (\1\:VSS \5\:VSS) resistor r=0.2419 c=0
Rk18 (\5\:VSS \6\:VSS) resistor r=0.1546 c=0
Rk20 (\7\:VSS VSS) resistor r=0.07444 c=0
Rk19 (\6\:VSS \7\:VSS) resistor r=0.2193 c=0
Rk22 (\6\:VSS \11\:VSS) resistor r=0.07277 c=0
Rk23 (\7\:VSS \13\:VSS) resistor r=0.1958 c=0
Rk5 (\9\:n0 \10\:n0) resistor r=0.312 c=0
Rk6 (\10\:n0 \12\:n0) resistor r=0.6423 c=0
Rk7 (\10\:n0 \14\:n0) resistor r=0.4307 c=0
Rk8 (\14\:n0 \16\:n0) resistor r=0.3991 c=0
Rl5 (\1\:B \2\:B) resistor r=150.692 c=0
Rl6 (\2\:B \3\:B) resistor r=39.1533 c=0
Rl3 (\1\:C \2\:C) resistor r=31.461 c=0
Rl4 (\2\:C \3\:C) resistor r=158.384 c=0
Rl1 (\1\:D \2\:D) resistor r=156.735 c=0
Rl2 (\2\:D \3\:D) resistor r=37.6944 c=0
Rl8 (\2\:A \3\:A) resistor r=95.3297 c=0
Rl7 (\1\:A \2\:A) resistor r=96.1538 c=0
Rl12 (n0 \5\:n0) resistor r=1.2666 c=0
Rz3 (\2\:Y \1\:Y) resistor r=75 c=0
Rz7 (\11\:VSS \10\:VSS) resistor r=75 c=0
Rz8 (\13\:VSS \12\:VSS) resistor r=75 c=0
Rz1 (\14\:n0 \13\:n0) resistor r=75 c=0
Rz2 (\16\:n0 \15\:n0) resistor r=75 c=0
Ry2 (\4\:Y \3\:Y) resistor r=20.6667 c=0
Ry1 (\12\:n0 \11\:n0) resistor r=62 c=0
Rx3 (\2\:B \4\:B) resistor r=45 c=0
Rx2 (\2\:C \4\:C) resistor r=45 c=0
Rx1 (\2\:D \4\:D) resistor r=45 c=0
Rx4 (\2\:A \4\:A) resistor r=45 c=0
Rx5 (\9\:n0 \5\:n0) resistor r=45 c=0
mn3 (\15\:n0 \3\:D \12\:VSS VSS) g45n1lvt w=(1.45e-07) l=4.5e-08 nf=1 \
        as=2.03e-14 ad=2.32e-14 ps=5.7e-07 pd=6.1e-07 nrd=1.16667 \
        nrs=1.16667 sa=1.4e-07 sb=1.58e-06 sd=160n sca=7.09016 \
        scb=0.00401586 scc=3.69756e-05 m=(1)
mn2 (\15\:n0 \3\:C \10\:VSS VSS) g45n1lvt w=(1.45e-07) l=4.5e-08 nf=1 \
        as=6.437e-14 ad=2.32e-14 ps=1.24e-06 pd=6.1e-07 nrd=1.16667 \
        nrs=1.16667 sa=3.45e-07 sb=1.375e-06 sd=160n sca=7.09016 \
        scb=0.00401586 scc=3.69756e-05 m=(1)
mn1 (\13\:n0 \3\:B \10\:VSS VSS) g45n1lvt w=(1.45e-07) l=4.5e-08 nf=1 \
        as=6.437e-14 ad=4.495e-14 ps=1.24e-06 pd=9.1e-07 nrd=1.16667 \
        nrs=1.16667 sa=6.85e-07 sb=1.035e-06 sd=160n sca=7.09016 \
        scb=0.00401586 scc=3.69756e-05 m=(1)
mn0 (\13\:n0 \1\:A \1\:VSS VSS) g45n1lvt w=(1.45e-07) l=4.5e-08 nf=1 \
        as=5.355e-14 ad=4.495e-14 ps=1.1e-06 pd=9.1e-07 nrd=1.16667 \
        nrs=1.16667 sa=1.04e-06 sb=6.8e-07 sd=160n sca=7.09016 \
        scb=0.00401586 scc=3.69756e-05 m=(1)
mn4 (\1\:Y n0 \1\:VSS VSS) g45n1lvt w=(2.6e-07) l=4.5e-08 nf=1 \
        as=4.497e-14 ad=4.16e-14 ps=9.5e-07 pd=8.4e-07 nrd=1.16667 \
        nrs=1.16667 sa=8.11058e-07 sb=3.45e-07 sd=160n sca=8.65991 \
        scb=0.00681295 scc=0.000165238 m=(2)
mp4 (\3\:Y n0 \1\:VDD VDD) g45p1lvt w=(3.9e-07) l=4.5e-08 nf=1 \
        as=7.664e-14 ad=6.24e-14 ps=1.265e-06 pd=1.1e-06 nrd=1.16667 \
        nrs=1.16667 sa=7.96026e-07 sb=3.45e-07 sd=160n sca=20.7709 \
        scb=0.0194441 scc=0.0014171 m=(2)
ends OR4X2
// End of subcircuit definition.
