// Generated for: spectre (May  1 11:27:41 2013 )
// Library name: gsclib045_backbias
// Cell name: AOI22X4
// View name: extracted

simulator lang=spectre

subckt AOI22X4 A0 A1 B0 B1 NW VDD VSS Y
mp0_1__rcx (net89 \2\:A0 \1\:VDD NW) g45p1svt w=(3.9e-07) l=4.5e-08 nf=1 \
        as=6.24e-14 ad=6.045e-14 ps=1.1e-06 pd=1.09e-06 nrd=1.16667 \
        nrs=1.16667 sa=1.4e-07 sb=2e-06 sd=160n sca=28.0553 scb=0.030197 \
        scc=0.00226721 m=(4)
mp1_1__rcx (net89 A1 \1\:VDD NW) g45p1svt w=(3.9e-07) l=4.5e-08 nf=1 \
        as=6.24e-14 ad=6.24e-14 ps=1.1e-06 pd=1.1e-06 nrd=1.16667 \
        nrs=1.16667 sa=3.45e-07 sb=2e-06 sd=160n sca=21.2373 scb=0.019015 \
        scc=0.00161477 m=(4)
mp2_1__rcx (\10\:Y B0 net89 NW) g45p1svt w=(3.9e-07) l=4.5e-08 nf=1 \
        as=6.045e-14 ad=6.24e-14 ps=1.09e-06 pd=1.1e-06 nrd=1.16667 \
        nrs=1.16667 sa=1.78e-06 sb=1.575e-06 sd=160n sca=18.3796 \
        scb=0.0159892 scc=0.00159615 m=(4)
mp3_1__rcx (\10\:Y B1 net89 NW) g45p1svt w=(3.9e-07) l=4.5e-08 nf=1 \
        as=6.24e-14 ad=6.24e-14 ps=1.1e-06 pd=1.1e-06 nrd=1.16667 \
        nrs=1.16667 sa=1.985e-06 sb=1.37e-06 sd=160n sca=18.3796 \
        scb=0.0159892 scc=0.00159615 m=(4)
C1 (Y VSS) capacitor c=6.42597e-17
C2 (B1 VSS) capacitor c=3.99413e-16
C3 (A0 VSS) capacitor c=3.54318e-17
C4 (VDD VSS) capacitor c=3.73399e-17
C5 (NW VSS) capacitor c=4.04437e-16
C6 (B0 VSS) capacitor c=6.07684e-16
C7 (A1 VSS) capacitor c=3.83385e-16
C8 (10 VSS) capacitor c=1.77435e-18
C9 (11 VSS) capacitor c=1.76875e-18
C10 (12 VSS) capacitor c=4.21738e-18
C11 (13 VSS) capacitor c=4.18161e-18
C12 (14 VSS) capacitor c=1.75671e-18
C13 (15 VSS) capacitor c=2.07872e-18
C14 (net89 VSS) capacitor c=6.00271e-16
C15 (\13\:B0 VSS) capacitor c=7.33347e-17
C16 (\12\:B1 VSS) capacitor c=4.7138e-17
C17 (\10\:B1 VSS) capacitor c=6.74335e-17
C18 (\10\:B0 VSS) capacitor c=4.88594e-17
C19 (\9\:B0 VSS) capacitor c=5.11682e-17
C20 (\4\:B1 VSS) capacitor c=5.37334e-17
C21 (\6\:B1 VSS) capacitor c=4.06327e-17
C22 (\3\:B0 VSS) capacitor c=4.09926e-17
C23 (\14\:A0 VSS) capacitor c=4.07889e-17
C24 (\12\:A1 VSS) capacitor c=3.90291e-17
C25 (\10\:A1 VSS) capacitor c=5.40902e-17
C26 (\4\:A0 VSS) capacitor c=6.65438e-17
C27 (\9\:A0 VSS) capacitor c=4.80871e-17
C28 (\1\:A1 VSS) capacitor c=6.709e-17
C29 (\4\:A1 VSS) capacitor c=4.71301e-17
C30 (\1\:A0 VSS) capacitor c=7.49357e-17
C31 (\2\:A0 VSS) capacitor c=5.62456e-16
C32 (\10\:Y VSS) capacitor c=2.77968e-16
C33 (\1\:VDD VSS) capacitor c=5.54626e-16
C34 (\8\:Y VSS) capacitor c=6.40772e-17
C35 (\1\:Y VSS) capacitor c=9.51269e-17
C36 (\4\:Y VSS) capacitor c=8.49395e-17
C37 (\6\:Y VSS) capacitor c=6.80517e-17
C38 (\2\:A1 VSS) capacitor c=2.7788e-17
C39 (\5\:A0 VSS) capacitor c=2.04e-17
C40 (\9\:A1 VSS) capacitor c=3.72581e-17
C41 (\3\:B1 VSS) capacitor c=3.61156e-17
C42 (\9\:B1 VSS) capacitor c=1.93489e-17
C43 (\3\:Y VSS) capacitor c=7.58978e-17
Rk14 (Y \10\:Y) resistor r=0.1778 c=0
Rk13 (\3\:Y Y) resistor r=0.2982 c=0
Rk9 (\2\:Y \3\:Y) resistor r=0.3131 c=0
Rk10 (\3\:Y \5\:Y) resistor r=0.2888 c=0
Rk11 (\5\:Y \7\:Y) resistor r=0.4656 c=0
Rk12 (\2\:Y \9\:Y) resistor r=0.4593 c=0
Rk3 (A0 \2\:A0) resistor r=0.06806 c=0
Rk32 (\2\:VSS \4\:VSS) resistor r=0.2663 c=0
Rk33 (\4\:VSS \5\:VSS) resistor r=0.2628 c=0
Rk34 (\5\:VSS \6\:VSS) resistor r=0.3603 c=0
Rk35 (\6\:VSS \7\:VSS) resistor r=0.2778 c=0
Rk36 (\7\:VSS \8\:VSS) resistor r=0.08245 c=0
Rk38 (\9\:VSS VSS) resistor r=0.1724 c=0
Rk37 (\8\:VSS \9\:VSS) resistor r=0.2951 c=0
Rk39 (\5\:VSS \11\:VSS) resistor r=0.1979 c=0
Rk40 (\6\:VSS \13\:VSS) resistor r=0.1979 c=0
Rk41 (\8\:VSS \15\:VSS) resistor r=0.1979 c=0
Rk42 (\9\:VSS \17\:VSS) resistor r=0.2024 c=0
Rk46 (\1\:VDD VDD) resistor r=0.1248 c=0
Rl26 (\3\:B1 B1) resistor r=10.2925 c=0
Rl27 (\3\:B1 \4\:B1) resistor r=78.9095 c=0
Rl29 (\3\:B1 \6\:B1) resistor r=128.331 c=0
Rl36 (\9\:B1 B1) resistor r=27.337 c=0
Rl39 (\9\:B1 \12\:B1) resistor r=32.6005 c=0
Rl37 (\9\:B1 \10\:B1) resistor r=80.4523 c=0
Rl21 (\2\:A0 \14\:A0) resistor r=52.7257 c=0
Rl1 (\2\:A0 \1\:A0) resistor r=124.977 c=0
Rl8 (\5\:A0 \4\:A0) resistor r=82.1768 c=0
Rl12 (\5\:A0 \9\:A0) resistor r=32.7557 c=0
Rl9 (\5\:A0 \2\:A0) resistor r=3.9095 c=0
Rl41 (B0 \13\:B0) resistor r=121.131 c=0
Rl34 (B0 \10\:B0) resistor r=45.9329 c=0
Rl33 (B0 \9\:B0) resistor r=67.3652 c=0
Rl23 (B0 \3\:B0) resistor r=48.8796 c=0
Rl4 (\2\:A1 A1) resistor r=28.05 c=0
Rl3 (\2\:A1 \1\:A1) resistor r=80.4523 c=0
Rl5 (\2\:A1 \4\:A1) resistor r=32.6005 c=0
Rl15 (\9\:A1 A1) resistor r=10.2925 c=0
Rl18 (\9\:A1 \12\:A1) resistor r=128.331 c=0
Rl16 (\9\:A1 \10\:A1) resistor r=78.9095 c=0
Rz1 (\2\:Y \1\:Y) resistor r=75 c=0
Rz2 (\5\:Y \4\:Y) resistor r=75 c=0
Rz3 (\7\:Y \6\:Y) resistor r=75 c=0
Rz4 (\9\:Y \8\:Y) resistor r=75 c=0
Rz5 (\1\:VSS \2\:VSS) resistor r=75 c=0
Rz6 (\10\:VSS \11\:VSS) resistor r=75 c=0
Rz7 (\12\:VSS \13\:VSS) resistor r=75 c=0
Rz8 (\14\:VSS \15\:VSS) resistor r=75 c=0
Rz9 (\16\:VSS \17\:VSS) resistor r=75 c=0
Ry14 (\3\:VSS \4\:VSS) resistor r=10.3333 c=0
Ry15 (\3\:VSS \7\:VSS) resistor r=5.1667 c=0
mn0_1__rcx (9 \1\:A0 \16\:VSS VSS) g45n1svt w=(2.6e-07) l=4.5e-08 nf=1 \
        as=3.64e-14 ad=1.56e-14 ps=8e-07 pd=6.4e-07 nrd=1.16667 \
        nrs=1.16667 sa=1.4e-07 sb=2e-06 sd=160n sca=9.14564 scb=0.00759168 \
        scc=0.000213449 m=(1)
mn1_1__rcx (\6\:Y \4\:A1 9 VSS) g45n1svt w=(2.6e-07) l=4.5e-08 nf=1 \
        as=1.56e-14 ad=4.16e-14 ps=6.4e-07 pd=8.4e-07 nrd=1.16667 \
        nrs=1.16667 sa=2.45e-07 sb=2e-06 sd=160n sca=9.14564 \
        scb=0.00759168 scc=0.000213449 m=(1)
mn1_2__rcx (\6\:Y \1\:A1 10 VSS) g45n1svt w=(2.6e-07) l=4.5e-08 nf=1 \
        as=1.56e-14 ad=4.16e-14 ps=6.4e-07 pd=8.4e-07 nrd=1.16667 \
        nrs=1.16667 sa=4.5e-07 sb=2e-06 sd=160n sca=9.14564 scb=0.00759168 \
        scc=0.000213449 m=(1)
mn0_2__rcx (10 \9\:A0 \14\:VSS VSS) g45n1svt w=(2.6e-07) l=4.5e-08 nf=1 \
        as=4.16e-14 ad=1.56e-14 ps=8.4e-07 pd=6.4e-07 nrd=1.16667 \
        nrs=1.16667 sa=5.55e-07 sb=2e-06 sd=160n sca=9.14564 \
        scb=0.00759168 scc=0.000213449 m=(1)
mn0_3__rcx (11 \4\:A0 \14\:VSS VSS) g45n1svt w=(2.6e-07) l=4.5e-08 nf=1 \
        as=4.16e-14 ad=1.56e-14 ps=8.4e-07 pd=6.4e-07 nrd=1.16667 \
        nrs=1.16667 sa=7.6e-07 sb=1.995e-06 sd=160n sca=9.14564 \
        scb=0.00759168 scc=0.000213449 m=(1)
mn1_3__rcx (\4\:Y \10\:A1 11 VSS) g45n1svt w=(2.6e-07) l=4.5e-08 nf=1 \
        as=1.56e-14 ad=4.16e-14 ps=6.4e-07 pd=8.4e-07 nrd=1.16667 \
        nrs=1.16667 sa=8.65e-07 sb=1.89e-06 sd=160n sca=9.14564 \
        scb=0.00759168 scc=0.000213449 m=(1)
mn1 (\4\:Y \12\:A1 12 VSS) g45n1svt w=(2.6e-07) l=4.5e-08 nf=1 \
        as=4.16e-14 ad=4.16e-14 ps=8.4e-07 pd=8.4e-07 nrd=1.16667 \
        nrs=1.16667 sa=1.07e-06 sb=1.685e-06 sd=160n sca=9.14564 \
        scb=0.00759168 scc=0.000213449 m=(1)
mn0 (12 \14\:A0 \12\:VSS VSS) g45n1svt w=(2.6e-07) l=4.5e-08 nf=1 \
        as=4.16e-14 ad=4.16e-14 ps=8.4e-07 pd=8.4e-07 nrd=1.16667 \
        nrs=1.16667 sa=1.275e-06 sb=1.48e-06 sd=160n sca=9.14564 \
        scb=0.00759168 scc=0.000213449 m=(1)
mn2_1__rcx (13 \3\:B0 \12\:VSS VSS) g45n1svt w=(2.6e-07) l=4.5e-08 nf=1 \
        as=4.16e-14 ad=4.16e-14 ps=8.4e-07 pd=8.4e-07 nrd=1.16667 \
        nrs=1.16667 sa=1.48e-06 sb=1.275e-06 sd=160n sca=9.14564 \
        scb=0.00759168 scc=0.000213449 m=(1)
mn3_1__rcx (\1\:Y \6\:B1 13 VSS) g45n1svt w=(2.6e-07) l=4.5e-08 nf=1 \
        as=4.16e-14 ad=4.16e-14 ps=8.4e-07 pd=8.4e-07 nrd=1.16667 \
        nrs=1.16667 sa=1.685e-06 sb=1.07e-06 sd=160n sca=9.14564 \
        scb=0.00759168 scc=0.000213449 m=(1)
mn3_2__rcx (\1\:Y \4\:B1 14 VSS) g45n1svt w=(2.6e-07) l=4.5e-08 nf=1 \
        as=1.56e-14 ad=4.16e-14 ps=6.4e-07 pd=8.4e-07 nrd=1.16667 \
        nrs=1.16667 sa=1.89e-06 sb=8.65e-07 sd=160n sca=9.14564 \
        scb=0.00759168 scc=0.000213449 m=(1)
mn2_2__rcx (14 \9\:B0 \10\:VSS VSS) g45n1svt w=(2.6e-07) l=4.5e-08 nf=1 \
        as=4.16e-14 ad=1.56e-14 ps=8.4e-07 pd=6.4e-07 nrd=1.16667 \
        nrs=1.16667 sa=1.995e-06 sb=7.6e-07 sd=160n sca=9.14564 \
        scb=0.00759168 scc=0.000213449 m=(1)
mn2_3__rcx (15 \10\:B0 \10\:VSS VSS) g45n1svt w=(2.6e-07) l=4.5e-08 nf=1 \
        as=4.16e-14 ad=1.56e-14 ps=8.4e-07 pd=6.4e-07 nrd=1.16667 \
        nrs=1.16667 sa=2e-06 sb=5.55e-07 sd=160n sca=9.14564 \
        scb=0.00759168 scc=0.000213449 m=(1)
mn3_3__rcx (\8\:Y \10\:B1 15 VSS) g45n1svt w=(2.6e-07) l=4.5e-08 nf=1 \
        as=1.56e-14 ad=4.16e-14 ps=6.4e-07 pd=8.4e-07 nrd=1.16667 \
        nrs=1.16667 sa=2e-06 sb=4.5e-07 sd=160n sca=9.14564 scb=0.00759168 \
        scc=0.000213449 m=(1)
mn3 (\8\:Y \12\:B1 16 VSS) g45n1svt w=(2.6e-07) l=4.5e-08 nf=1 \
        as=1.56e-14 ad=4.16e-14 ps=6.4e-07 pd=8.4e-07 nrd=1.16667 \
        nrs=1.16667 sa=2e-06 sb=2.45e-07 sd=160n sca=9.14564 \
        scb=0.00759168 scc=0.000213449 m=(1)
mn2 (16 \13\:B0 \1\:VSS VSS) g45n1svt w=(2.6e-07) l=4.5e-08 nf=1 \
        as=3.64e-14 ad=1.56e-14 ps=8e-07 pd=6.4e-07 nrd=1.16667 \
        nrs=1.16667 sa=2e-06 sb=1.4e-07 sd=160n sca=9.14564 scb=0.00759168 \
        scc=0.000213449 m=(1)
ends AOI22X4
// End of subcircuit definition.
