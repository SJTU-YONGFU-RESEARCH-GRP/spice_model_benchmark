// Generated for: spectre (May  1 08:12:21 2013 )
// Library name: gsclib045
// Cell name: RDFFSRQX1
// View name: extracted

simulator lang=spectre

subckt RDFFSRQX1 CK D ExtVDD Q RN RT SN VDD VSS
mp20 (\17\:CKb \4\:CK \23\:VDD VDD) g45p1svt w=(2.15e-07) l=4.5e-08 nf=1 \
        as=3.01e-14 ad=3.44e-14 ps=7.1e-07 pd=7.5e-07 nrd=1.16667 \
        nrs=1.16667 sa=3.45e-07 sb=1.4e-07 sd=160n sca=14.7851 \
        scb=0.0152025 scc=0.00103799 m=(1)
mp21 (\18\:CKbb \5\:CKb \23\:VDD VDD) g45p1svt w=(2.15e-07) l=4.5e-08 \
        nf=1 as=3.44e-14 ad=3.01e-14 ps=7.5e-07 pd=7.1e-07 nrd=1.16667 \
        nrs=1.16667 sa=1.4e-07 sb=3.45e-07 sd=160n sca=14.7851 \
        scb=0.0152025 scc=0.00103799 m=(1)
mp25 (n22 \3\:D \13\:VDD VDD) g45p1svt w=(2.15e-07) l=4.5e-08 nf=1 \
        as=3.01e-14 ad=1.29e-14 ps=7.1e-07 pd=5.5e-07 nrd=1.16667 \
        nrs=1.16667 sa=1.4e-07 sb=2.45e-07 sd=160n sca=20.3407 \
        scb=0.022946 scc=0.00119484 m=(1)
mp26 (\16\:n20 \2\:CKbb n22 VDD) g45p1svt w=(2.15e-07) l=4.5e-08 nf=1 \
        as=1.29e-14 ad=3.01e-14 ps=5.5e-07 pd=7.1e-07 nrd=1.16667 \
        nrs=1.16667 sa=2.45e-07 sb=1.4e-07 sd=160n sca=17.8768 \
        scb=0.0186195 scc=0.00106238 m=(1)
mp36 (\8\:n20 \7\:CKb n31 VDD) g45p1svt w=(2.15e-07) l=4.5e-08 nf=1 \
        as=1.29e-14 ad=3.01e-14 ps=5.5e-07 pd=7.1e-07 nrd=1.16667 \
        nrs=1.16667 sa=1.4e-07 sb=4.5e-07 sd=160n sca=6.79882 \
        scb=0.00278203 scc=1.42286e-05 m=(1)
mp35 (n31 mout \25\:VDD VDD) g45p1svt w=(2.15e-07) l=4.5e-08 nf=1 \
        as=3.44e-14 ad=1.29e-14 ps=7.5e-07 pd=5.5e-07 nrd=1.16667 \
        nrs=1.16667 sa=2.45e-07 sb=3.45e-07 sd=160n sca=6.42122 \
        scb=0.00257522 scc=1.4095e-05 m=(1)
mp30 (\16\:mout \1\:SN \25\:VDD VDD) g45p1svt w=(2.15e-07) l=4.5e-08 \
        nf=1 as=3.44e-14 ad=3.01e-14 ps=7.5e-07 pd=7.1e-07 nrd=1.16667 \
        nrs=1.16667 sa=4.5e-07 sb=1.4e-07 sd=160n sca=6.07861 \
        scb=0.00247604 scc=1.40748e-05 m=(1)
mp32 (\19\:mout \3\:n20 net402 VDD) g45p1svt w=(2.15e-07) l=4.5e-08 nf=1 \
        as=1.29e-14 ad=3.01e-14 ps=5.5e-07 pd=7.1e-07 nrd=1.16667 \
        nrs=1.16667 sa=1.4e-07 sb=2.45e-07 sd=160n sca=6.79882 \
        scb=0.00278203 scc=1.42286e-05 m=(1)
mp31 (net402 \7\:RNb \19\:VDD VDD) g45p1svt w=(2.15e-07) l=4.5e-08 nf=1 \
        as=3.01e-14 ad=1.29e-14 ps=7.1e-07 pd=5.5e-07 nrd=1.16667 \
        nrs=1.16667 sa=2.45e-07 sb=1.4e-07 sd=160n sca=7.36861 \
        scb=0.00328614 scc=1.51674e-05 m=(1)
mp22 (\13\:RNb \4\:RN \21\:VDD VDD) g45p1svt w=(2.15e-07) l=4.5e-08 nf=1 \
        as=3.01e-14 ad=3.01e-14 ps=7.1e-07 pd=7.1e-07 nrd=1.16667 \
        nrs=1.16667 sa=1.4e-07 sb=1.4e-07 sd=160n sca=15.0221 scb=0.014826 \
        scc=0.000817388 m=(1)
mp40 (\4\:n35 \9\:CKb \5\:mout VDD) g45p1svt w=(2.15e-07) l=4.5e-08 nf=1 \
        as=3.01e-14 ad=3.01e-14 ps=7.1e-07 pd=7.1e-07 nrd=1.16667 \
        nrs=1.16667 sa=1.4e-07 sb=1.4e-07 sd=160n sca=25.5298 \
        scb=0.0265038 scc=0.00266093 m=(1)
PM0 (\6\:n35g \5\:RT \9\:n35 ExtVDD) g45p1svt w=(2.15e-07) l=4.5e-08 nf=1 \
        as=3.01e-14 ad=3.01e-14 ps=7.1e-07 pd=7.1e-07 nrd=1.16667 \
        nrs=1.16667 sa=1.4e-07 sb=1.4e-07 sd=160n sca=26.0836 \
        scb=0.0271848 scc=0.00267095 m=(1)
PM1 (\14\:qbint \3\:n35g \1\:ExtVDD ExtVDD) g45p1svt w=(2.15e-07) \
        l=4.5e-08 nf=1 as=3.5882e-13 ad=3.01e-14 ps=3.6e-06 pd=7.1e-07 \
        nrd=1.16667 nrs=1.16667 sa=1.4e-07 sb=8.7e-07 sd=160n sca=25.2796 \
        scb=0.0259458 scc=0.00265434 m=(1)
PM2 (net205 \4\:qbint \1\:ExtVDD ExtVDD) g45p1svt w=(2.15e-07) l=4.5e-08 \
        nf=1 as=3.5882e-13 ad=1.29e-14 ps=3.6e-06 pd=5.5e-07 nrd=1.16667 \
        nrs=1.16667 sa=7.65e-07 sb=2.45e-07 sd=160n sca=14.5295 \
        scb=0.0144143 scc=0.000486924 m=(1)
mp45 (\6\:RTb \6\:RT \1\:ExtVDD ExtVDD) g45p1svt w=(2.15e-07) l=4.5e-08 \
        nf=1 as=3.5882e-13 ad=3.01e-14 ps=3.6e-06 pd=7.1e-07 nrd=1.16667 \
        nrs=1.16667 sa=3.3e-07 sb=1.4e-07 sd=160n sca=24.3731 \
        scb=0.0258873 scc=0.00229004 m=(1)
PM3 (\15\:n35g \4\:RTb net205 ExtVDD) g45p1svt w=(2.15e-07) l=4.5e-08 \
        nf=1 as=1.29e-14 ad=3.01e-14 ps=5.5e-07 pd=7.1e-07 nrd=1.16667 \
        nrs=1.16667 sa=8.7e-07 sb=1.4e-07 sd=160n sca=25.2796 \
        scb=0.0259458 scc=0.00265434 m=(1)
mp53 (\14\:n35 \10\:CKbb \3\:n41 VDD) g45p1svt w=(2.15e-07) l=4.5e-08 \
        nf=1 as=3.01e-14 ad=3.01e-14 ps=7.1e-07 pd=7.1e-07 nrd=1.16667 \
        nrs=1.16667 sa=1.4e-07 sb=1.4e-07 sd=160n sca=28.3325 \
        scb=0.0311878 scc=0.00281308 m=(1)
mp51 (n43 \4\:RNb \17\:VDD VDD) g45p1svt w=(2.15e-07) l=4.5e-08 nf=1 \
        as=3.01e-14 ad=1.29e-14 ps=7.1e-07 pd=5.5e-07 nrd=1.16667 \
        nrs=1.16667 sa=1.4e-07 sb=4.5e-07 sd=160n sca=11.272 \
        scb=0.00858882 scc=0.000167946 m=(1)
mp52 (n41 \10\:qbint n43 VDD) g45p1svt w=(2.15e-07) l=4.5e-08 nf=1 \
        as=1.29e-14 ad=3.44e-14 ps=5.5e-07 pd=7.5e-07 nrd=1.16667 \
        nrs=1.16667 sa=2.45e-07 sb=3.45e-07 sd=160n sca=11.4972 \
        scb=0.00902054 scc=0.000170728 m=(1)
mp50 (n41 \7\:SN \1\:VDD VDD) g45p1svt w=(2.15e-07) l=4.5e-08 nf=1 \
        as=3.01e-14 ad=3.44e-14 ps=7.1e-07 pd=7.5e-07 nrd=1.16667 \
        nrs=1.16667 sa=4.5e-07 sb=1.4e-07 sd=160n sca=14.6968 \
        scb=0.0152164 scc=0.000337347 m=(1)
C1 (RN VSS) capacitor c=1.09915e-16
C2 (RT VSS) capacitor c=2.31477e-17
C3 (SN VSS) capacitor c=4.1094e-17
C4 (D VSS) capacitor c=5.43121e-17
C5 (VDD VSS) capacitor c=6.6006e-16
C6 (Q VSS) capacitor c=3.79057e-17
C7 (ExtVDD VSS) capacitor c=1.94929e-16
C8 (CKbb VSS) capacitor c=5.53719e-17
C9 (mout VSS) capacitor c=5.37227e-17
C10 (n20 VSS) capacitor c=8.28153e-17
C11 (RNb VSS) capacitor c=3.88111e-17
C12 (CKb VSS) capacitor c=2.36035e-17
C13 (n35g VSS) capacitor c=1.81021e-17
C14 (qbint VSS) capacitor c=4.50329e-17
C15 (RTb VSS) capacitor c=5.18542e-17
C16 (n35 VSS) capacitor c=1.72345e-16
C17 (n41 VSS) capacitor c=8.4668e-17
C18 (n42 VSS) capacitor c=7.97453e-17
C19 (n40 VSS) capacitor c=8.4714e-17
C20 (net426 VSS) capacitor c=8.72419e-17
C21 (\7\:SN VSS) capacitor c=7.07664e-17
C22 (\7\:qbint VSS) capacitor c=3.82685e-17
C23 (\10\:qbint VSS) capacitor c=1.41882e-16
C24 (\4\:RNb VSS) capacitor c=3.13132e-16
C25 (\10\:CKbb VSS) capacitor c=5.82141e-17
C26 (\4\:RTb VSS) capacitor c=9.85629e-17
C27 (\6\:RT VSS) capacitor c=2.30123e-17
C28 (\4\:qbint VSS) capacitor c=5.41903e-17
C29 (\3\:n35g VSS) capacitor c=6.31294e-17
C30 (\5\:RT VSS) capacitor c=8.57855e-17
C31 (\9\:CKb VSS) capacitor c=1.14015e-16
C32 (\4\:RN VSS) capacitor c=3.23911e-17
C33 (\7\:RNb VSS) capacitor c=6.92464e-17
C34 (\3\:n20 VSS) capacitor c=4.64244e-17
C35 (\4\:CK VSS) capacitor c=5.76342e-17
C36 (\1\:SN VSS) capacitor c=2.99882e-17
C37 (\5\:CKb VSS) capacitor c=2.94704e-17
C38 (\7\:CKb VSS) capacitor c=9.31732e-17
C39 (\2\:CKbb VSS) capacitor c=1.52805e-16
C40 (\3\:D VSS) capacitor c=7.3271e-17
C41 (\8\:SN VSS) capacitor c=1.34409e-16
C42 (\6\:qbint VSS) capacitor c=4.25234e-17
C43 (\11\:qbint VSS) capacitor c=8.09839e-17
C44 (\3\:RNb VSS) capacitor c=6.84518e-17
C45 (\11\:CKb VSS) capacitor c=2.24377e-16
C46 (\8\:RT VSS) capacitor c=1.21809e-16
C47 (\2\:RT VSS) capacitor c=6.2495e-17
C48 (\5\:qbint VSS) capacitor c=3.87746e-17
C49 (\5\:n35g VSS) capacitor c=2.76477e-17
C50 (\2\:RTb VSS) capacitor c=4.95977e-17
C51 (\4\:CKbb VSS) capacitor c=3.28382e-17
C52 (\1\:RN VSS) capacitor c=3.44907e-17
C53 (\6\:n20 VSS) capacitor c=6.17351e-17
C54 (\6\:SN VSS) capacitor c=4.7386e-17
C55 (\1\:CK VSS) capacitor c=2.85387e-17
C56 (\8\:CKb VSS) capacitor c=2.56312e-17
C57 (\3\:mout VSS) capacitor c=4.58549e-17
C58 (\9\:CKbb VSS) capacitor c=4.97927e-17
C59 (\4\:CKb VSS) capacitor c=8.43277e-17
C60 (\1\:D VSS) capacitor c=4.88945e-17
C61 (\9\:qbint VSS) capacitor c=9.42346e-17
C62 (\11\:CKbb VSS) capacitor c=7.94741e-17
C63 (\3\:SN VSS) capacitor c=3.75734e-16
C64 (\9\:SN VSS) capacitor c=9.18515e-17
C65 (\7\:RT VSS) capacitor c=1.56777e-16
C66 (\8\:CKbb VSS) capacitor c=1.6797e-16
C67 (\3\:RT VSS) capacitor c=5.76455e-17
C68 (\1\:RT VSS) capacitor c=5.31416e-17
C69 (\3\:RTb VSS) capacitor c=7.59471e-17
C70 (\3\:qbint VSS) capacitor c=4.40973e-17
C71 (\2\:n35 VSS) capacitor c=2.52679e-16
C72 (\4\:n35g VSS) capacitor c=7.1451e-17
C73 (\10\:CKb VSS) capacitor c=5.38762e-17
C74 (\12\:CKb VSS) capacitor c=2.18316e-16
C75 (\3\:n35 VSS) capacitor c=1.15997e-16
C76 (\2\:RNb VSS) capacitor c=3.49956e-17
C77 (\9\:RNb VSS) capacitor c=1.06902e-17
C78 (\8\:RNb VSS) capacitor c=8.84503e-17
C79 (\7\:n20 VSS) capacitor c=5.42065e-17
C80 (\3\:RN VSS) capacitor c=4.64337e-17
C81 (\4\:n20 VSS) capacitor c=9.47299e-17
C82 (\3\:CK VSS) capacitor c=2.3787e-17
C83 (\2\:SN VSS) capacitor c=4.19214e-17
C84 (\5\:SN VSS) capacitor c=2.03017e-17
C85 (\2\:mout VSS) capacitor c=4.69787e-17
C86 (\4\:mout VSS) capacitor c=3.16305e-17
C87 (\5\:n20 VSS) capacitor c=7.77938e-17
C88 (\2\:n20 VSS) capacitor c=7.16689e-17
C89 (\3\:CKbb VSS) capacitor c=8.27649e-17
C90 (\7\:CKbb VSS) capacitor c=3.21371e-17
C91 (\2\:D VSS) capacitor c=5.22539e-17
C92 (\1\:VDD VSS) capacitor c=3.00365e-17
C93 (\15\:VDD VSS) capacitor c=4.73257e-17
C94 (\3\:Q VSS) capacitor c=5.30831e-17
C95 (\17\:VDD VSS) capacitor c=4.91148e-17
C96 (\3\:n41 VSS) capacitor c=9.86355e-17
C97 (\14\:n35 VSS) capacitor c=5.35943e-17
C98 (\15\:n35g VSS) capacitor c=5.75592e-17
C99 (\6\:RTb VSS) capacitor c=7.32659e-17
C100 (\1\:ExtVDD VSS) capacitor c=2.78392e-16
C101 (\9\:n35 VSS) capacitor c=6.17939e-17
C102 (\14\:qbint VSS) capacitor c=6.71048e-17
C103 (\6\:n35g VSS) capacitor c=9.14819e-17
C104 (\4\:n35 VSS) capacitor c=6.9148e-17
C105 (\5\:mout VSS) capacitor c=1.2787e-16
C106 (\13\:RNb VSS) capacitor c=2.66592e-17
C107 (\19\:VDD VSS) capacitor c=4.32869e-17
C108 (\21\:VDD VSS) capacitor c=5.20244e-17
C109 (\19\:mout VSS) capacitor c=3.67249e-17
C110 (\17\:CKb VSS) capacitor c=4.52009e-17
C111 (\16\:mout VSS) capacitor c=4.35465e-17
C112 (\23\:VDD VSS) capacitor c=6.01667e-17
C113 (\25\:VDD VSS) capacitor c=4.9829e-17
C114 (\18\:CKbb VSS) capacitor c=4.01279e-17
C115 (\8\:n20 VSS) capacitor c=4.1099e-17
C116 (\16\:n20 VSS) capacitor c=5.58221e-17
C117 (\13\:VDD VSS) capacitor c=4.10945e-17
C118 (\1\:Q VSS) capacitor c=3.75243e-17
C119 (\3\:n42 VSS) capacitor c=8.11087e-17
C120 (\3\:n40 VSS) capacitor c=7.8716e-17
C121 (\17\:n35 VSS) capacitor c=4.83257e-17
C122 (\11\:n35g VSS) capacitor c=2.62818e-17
C123 (\10\:RTb VSS) capacitor c=5.82842e-17
C124 (\12\:n35 VSS) capacitor c=6.35994e-17
C125 (\16\:qbint VSS) capacitor c=2.27723e-17
C126 (\9\:n35g VSS) capacitor c=8.02839e-17
C127 (\7\:n35 VSS) capacitor c=4.90555e-17
C128 (\11\:mout VSS) capacitor c=3.72589e-17
C129 (\10\:RNb VSS) capacitor c=4.39841e-17
C130 (\13\:mout VSS) capacitor c=3.83153e-17
C131 (\3\:net426 VSS) capacitor c=1.00658e-16
C132 (\13\:CKb VSS) capacitor c=6.39513e-17
C133 (\14\:CKbb VSS) capacitor c=5.13409e-17
C134 (\12\:n20 VSS) capacitor c=6.63607e-17
C135 (\14\:n20 VSS) capacitor c=7.0355e-17
C136 (\2\:CK VSS) capacitor c=3.45437e-17
C137 (\2\:CKb VSS) capacitor c=2.81799e-17
C138 (\3\:CKb VSS) capacitor c=5.58221e-17
C139 (\6\:CKb VSS) capacitor c=1.11586e-16
C140 (VDD VSS) capacitor c=2.40866e-16
C141 (\2\:n35g VSS) capacitor c=3.35493e-17
C142 (ExtVDD VSS) capacitor c=3.93333e-17
C143 (\4\:RT VSS) capacitor c=7.57031e-17
C144 (\2\:qbint VSS) capacitor c=4.13898e-17
C145 (\5\:CKbb VSS) capacitor c=1.373e-16
C146 (\6\:CKbb VSS) capacitor c=7.78321e-17
C147 (\4\:SN VSS) capacitor c=3.39868e-16
C148 (\5\:RNb VSS) capacitor c=5.2317e-16
C149 (\6\:RNb VSS) capacitor c=1.20832e-16
C150 (\12\:CKbb VSS) capacitor c=6.36827e-17
C151 (\13\:CKbb VSS) capacitor c=7.35128e-17
C152 (\8\:qbint VSS) capacitor c=1.07542e-16
C153 (\10\:n20 VSS) capacitor c=2.98554e-17
C154 (\11\:n20 VSS) capacitor c=6.92235e-17
C155 (\18\:n20 VSS) capacitor c=3.08809e-17
C156 (\17\:CKbb VSS) capacitor c=7.37764e-17
C157 (\10\:SN VSS) capacitor c=4.03516e-17
C158 (\11\:SN VSS) capacitor c=4.49784e-17
C159 (\5\:CK VSS) capacitor c=4.78289e-17
C160 (\6\:CK VSS) capacitor c=3.68931e-17
C161 (\15\:CKb VSS) capacitor c=7.13727e-17
C162 (\16\:CKb VSS) capacitor c=5.00922e-17
C163 (\19\:n20 VSS) capacitor c=8.20287e-17
C164 (\20\:n20 VSS) capacitor c=7.97445e-17
C165 (\12\:RNb VSS) capacitor c=5.97823e-17
C166 (\15\:RNb VSS) capacitor c=7.17668e-17
C167 (\16\:RNb VSS) capacitor c=8.30407e-17
C168 (\7\:mout VSS) capacitor c=1.56448e-16
C169 (\8\:mout VSS) capacitor c=5.30152e-17
C170 (\9\:mout VSS) capacitor c=1.07074e-16
C171 (\10\:mout VSS) capacitor c=8.52594e-17
C172 (\15\:mout VSS) capacitor c=6.17414e-17
C173 (\18\:mout VSS) capacitor c=7.29189e-17
C174 (\6\:n35 VSS) capacitor c=1.07027e-16
C175 (\19\:CKb VSS) capacitor c=3.95005e-17
C176 (\20\:CKb VSS) capacitor c=4.14738e-17
C177 (\8\:n35g VSS) capacitor c=3.22942e-17
C178 (\11\:n35 VSS) capacitor c=7.56753e-17
C179 (\12\:qbint VSS) capacitor c=8.78238e-17
C180 (\13\:qbint VSS) capacitor c=1.08917e-16
C181 (\13\:n35g VSS) capacitor c=1.01787e-16
C182 (\14\:n35g VSS) capacitor c=1.16156e-16
C183 (\5\:RTb VSS) capacitor c=4.89967e-17
C184 (\8\:RTb VSS) capacitor c=1.00781e-16
C185 (\9\:RTb VSS) capacitor c=9.16754e-17
C186 (\9\:RT VSS) capacitor c=1.10726e-16
C187 (\10\:RT VSS) capacitor c=1.18231e-16
C188 (\11\:RT VSS) capacitor c=3.85572e-17
C189 (\12\:SN VSS) capacitor c=8.28002e-17
C190 (\13\:SN VSS) capacitor c=8.05138e-17
C191 (\20\:CKbb VSS) capacitor c=1.31647e-16
C192 (\21\:CKbb VSS) capacitor c=1.34072e-16
C193 (\18\:qbint VSS) capacitor c=1.95246e-17
C194 (\19\:qbint VSS) capacitor c=2.99077e-17
C195 (\16\:n35 VSS) capacitor c=4.78259e-17
C196 (\3\:VDD VSS) capacitor c=3.24403e-17
C197 (\4\:VDD VSS) capacitor c=2.75945e-17
C198 (\6\:VDD VSS) capacitor c=1.15416e-16
C199 (\7\:VDD VSS) capacitor c=6.1247e-17
C200 (\8\:VDD VSS) capacitor c=2.25649e-17
C201 (\10\:VDD VSS) capacitor c=2.5853e-17
C202 (\11\:VDD VSS) capacitor c=1.83035e-17
C203 (\12\:VDD VSS) capacitor c=2.52272e-17
Rk19 (\5\:RN RN) resistor r=0.04968 c=0
Rk57 (RT \9\:RT) resistor r=0.182 c=0
Rk58 (\9\:RT \10\:RT) resistor r=0.6461 c=0
Rk59 (RT \11\:RT) resistor r=0.0166 c=0
Rk11 (SN \10\:SN) resistor r=0.01265 c=0
Rk12 (\10\:SN \11\:SN) resistor r=0.3244 c=0
Rk60 (\12\:SN \13\:SN) resistor r=0.5357 c=0
Rk2 (\4\:D D) resistor r=0.006097 c=0
Rk78 (\2\:VDD \3\:VDD) resistor r=0.3366 c=0
Rk79 (\3\:VDD \4\:VDD) resistor r=0.2178 c=0
Rk81 (\6\:VDD VDD) resistor r=1.0549 c=0
Rk80 (\4\:VDD \6\:VDD) resistor r=0.06676 c=0
Rk82 (VDD \7\:VDD) resistor r=0.6386 c=0
Rk83 (\7\:VDD \8\:VDD) resistor r=0.08888 c=0
Rk84 (\8\:VDD \10\:VDD) resistor r=0.1312 c=0
Rk85 (\10\:VDD \11\:VDD) resistor r=0.08907 c=0
Rk87 (\12\:VDD VDD) resistor r=0.1955 c=0
Rk86 (\11\:VDD \12\:VDD) resistor r=0.08144 c=0
Rk88 (VDD \14\:VDD) resistor r=0.5113 c=0
Rk89 (\3\:VDD \16\:VDD) resistor r=0.3564 c=0
Rk90 (\4\:VDD \18\:VDD) resistor r=0.2927 c=0
Rk91 (\7\:VDD \20\:VDD) resistor r=0.2015 c=0
Rk92 (\8\:VDD \22\:VDD) resistor r=0.359 c=0
Rk93 (\11\:VDD \24\:VDD) resistor r=0.3797 c=0
Rk94 (\12\:VDD \26\:VDD) resistor r=0.2069 c=0
Rk66 (\2\:Q Q) resistor r=0.1703 c=0
Rk67 (Q \4\:Q) resistor r=0.2987 c=0
Rk70 (\2\:VSS \4\:VSS) resistor r=0.4654 c=0
Rk71 (\4\:VSS \5\:VSS) resistor r=0.8135 c=0
Rk73 (\6\:VSS VSS) resistor r=0.2973 c=0
Rk72 (\5\:VSS \6\:VSS) resistor r=0.07916 c=0
Rk75 (\7\:VSS VSS) resistor r=0.1213 c=0
Rk74 (VSS \7\:VSS) resistor r=0.8929 c=0
Rk76 (\5\:VSS \9\:VSS) resistor r=0.2434 c=0
Rk77 (VSS \11\:VSS) resistor r=0.3081 c=0
Rk95 (\13\:VSS \15\:VSS) resistor r=0.4109 c=0
Rk96 (\15\:VSS \16\:VSS) resistor r=0.8603 c=0
Rk97 (\16\:VSS \17\:VSS) resistor r=0.03204 c=0
Rk99 (\18\:VSS VSS) resistor r=0.1211 c=0
Rk98 (\17\:VSS \18\:VSS) resistor r=0.1759 c=0
Rk100 (VSS \19\:VSS) resistor r=0.7291 c=0
Rk102 (\20\:VSS VSS) resistor r=0.01959 c=0
Rk101 (\19\:VSS \20\:VSS) resistor r=0.1635 c=0
Rk103 (VSS \21\:VSS) resistor r=0.03725 c=0
Rk104 (\21\:VSS \23\:VSS) resistor r=0.6579 c=0
Rk105 (\16\:VSS \25\:VSS) resistor r=0.1891 c=0
Rk106 (\18\:VSS \27\:VSS) resistor r=0.1942 c=0
Rk107 (\19\:VSS \29\:VSS) resistor r=0.2359 c=0
Rk108 (\21\:VSS \31\:VSS) resistor r=0.2364 c=0
Rk44 (ExtVDD ExtVDD) resistor r=0.002061 c=0
Rk42 (\2\:ExtVDD ExtVDD) resistor r=0.02215 c=0
Rk45 (ExtVDD \5\:ExtVDD) resistor r=0.02014 c=0
Rk46 (ExtVDD \6\:ExtVDD) resistor r=0.1056 c=0
Rk13 (CK \5\:CK) resistor r=0.004352 c=0
Rk15 (\5\:CK \6\:CK) resistor r=0.01406 c=0
Rk14 (\6\:CK \7\:CK) resistor r=0.004534 c=0
Rk1 (\12\:CKbb \13\:CKbb) resistor r=0.6841 c=0
Rk8 (\15\:CKbb \16\:CKbb) resistor r=0.3494 c=0
Rk9 (\16\:CKbb \17\:CKbb) resistor r=0.01514 c=0
Rk10 (\16\:CKbb \19\:CKbb) resistor r=0.2035 c=0
Rk61 (\20\:CKbb \21\:CKbb) resistor r=0.8245 c=0
Rk25 (\6\:mout \7\:mout) resistor r=0.7619 c=0
Rk26 (\7\:mout \8\:mout) resistor r=0.3523 c=0
Rk27 (\8\:mout \9\:mout) resistor r=0.1709 c=0
Rk28 (\9\:mout \10\:mout) resistor r=0.3404 c=0
Rk29 (\7\:mout \12\:mout) resistor r=0.1231 c=0
Rk30 (\8\:mout \14\:mout) resistor r=0.09956 c=0
Rk31 (\9\:mout \15\:mout) resistor r=0.5241 c=0
Rk32 (\15\:mout \17\:mout) resistor r=0.04481 c=0
Rk33 (\10\:mout \18\:mout) resistor r=0.425 c=0
Rk34 (\15\:mout \20\:mout) resistor r=0.03462 c=0
Rk3 (\9\:n20 \10\:n20) resistor r=0.2067 c=0
Rk4 (\9\:n20 \11\:n20) resistor r=0.2104 c=0
Rk5 (\11\:n20 \13\:n20) resistor r=0.4456 c=0
Rk6 (\15\:n20 \17\:n20) resistor r=0.4887 c=0
Rk7 (\17\:n20 \18\:n20) resistor r=0.1577 c=0
Rk20 (\19\:n20 \20\:n20) resistor r=0.4615 c=0
Rk22 (\11\:RNb \12\:RNb) resistor r=0.3432 c=0
Rk23 (\12\:RNb \14\:RNb) resistor r=0.1482 c=0
Rk24 (\15\:RNb \16\:RNb) resistor r=0.3465 c=0
Rk16 (\14\:CKb \15\:CKb) resistor r=0.3583 c=0
Rk17 (\15\:CKb \16\:CKb) resistor r=0.1632 c=0
Rk18 (\15\:CKb \18\:CKb) resistor r=0.2066 c=0
Rk37 (\19\:CKb \20\:CKb) resistor r=0.3681 c=0
Rk38 (\7\:n35g \8\:n35g) resistor r=0.2407 c=0
Rk39 (\7\:n35g \10\:n35g) resistor r=0.6914 c=0
Rk50 (\12\:n35g \13\:n35g) resistor r=0.2429 c=0
Rk51 (\13\:n35g \14\:n35g) resistor r=0.5654 c=0
Rk52 (\13\:n35g \16\:n35g) resistor r=0.4319 c=0
Rk47 (\12\:qbint \13\:qbint) resistor r=0.4944 c=0
Rk48 (\13\:qbint \15\:qbint) resistor r=0.567 c=0
Rk49 (\13\:qbint \17\:qbint) resistor r=0.1463 c=0
Rk62 (\18\:qbint \19\:qbint) resistor r=0.2118 c=0
Rk53 (\5\:RTb \7\:RTb) resistor r=0.2162 c=0
Rk54 (\7\:RTb \8\:RTb) resistor r=0.4165 c=0
Rk55 (\8\:RTb \9\:RTb) resistor r=0.6885 c=0
Rk56 (\8\:RTb \11\:RTb) resistor r=0.3065 c=0
Rk35 (\5\:n35 \6\:n35) resistor r=0.4289 c=0
Rk36 (\6\:n35 \8\:n35) resistor r=0.3027 c=0
Rk40 (\10\:n35 \11\:n35) resistor r=0.4009 c=0
Rk41 (\11\:n35 \13\:n35) resistor r=0.3298 c=0
Rk63 (\15\:n35 \16\:n35) resistor r=0.3037 c=0
Rk64 (\16\:n35 \18\:n35) resistor r=0.2874 c=0
Rk68 (\2\:n41 \4\:n41) resistor r=0.7136 c=0
Rk69 (\2\:n42 \4\:n42) resistor r=0.5301 c=0
Rk65 (\2\:n40 \4\:n40) resistor r=0.6255 c=0
Rk21 (\2\:net426 \4\:net426) resistor r=0.5521 c=0
Rl16 (\2\:RN \4\:RN) resistor r=62.3411 c=0
Rl14 (\1\:RN \2\:RN) resistor r=152.726 c=0
Rl15 (\2\:RN \3\:RN) resistor r=0.6051 c=0
Rl47 (\7\:RT \8\:RT) resistor r=651.902 c=0
Rl34 (\1\:RT \2\:RT) resistor r=169.515 c=0
Rl37 (\4\:RT \6\:RT) resistor r=21.372 c=0
Rl36 (\4\:RT \5\:RT) resistor r=264.027 c=0
Rl35 (\3\:RT \4\:RT) resistor r=96.114 c=0
Rl66 (\7\:SN \8\:SN) resistor r=237.735 c=0
Rl67 (\8\:SN \9\:SN) resistor r=491.014 c=0
Rl8 (\1\:SN \2\:SN) resistor r=24.2328 c=0
Rl50 (\4\:SN \6\:SN) resistor r=95.229 c=0
Rl48 (\3\:SN \4\:SN) resistor r=1129.61 c=0
Rl49 (\4\:SN \5\:SN) resistor r=14.5488 c=0
Rl2 (\2\:D \3\:D) resistor r=108.118 c=0
Rl1 (\1\:D \2\:D) resistor r=70.6183 c=0
Rl11 (\2\:CK \4\:CK) resistor r=147.791 c=0
Rl9 (\1\:CK \2\:CK) resistor r=63.1757 c=0
Rl10 (\2\:CK \3\:CK) resistor r=2.0166 c=0
Rl53 (\10\:CKbb \11\:CKbb) resistor r=166.412 c=0
Rl4 (CKbb \2\:CKbb) resistor r=167.403 c=0
Rl5 (\2\:CKbb \3\:CKbb) resistor r=349.426 c=0
Rl42 (\4\:CKbb \5\:CKbb) resistor r=66.1349 c=0
Rl45 (\5\:CKbb \8\:CKbb) resistor r=762.322 c=0
Rl46 (\6\:CKbb \9\:CKbb) resistor r=66.8717 c=0
Rl44 (\6\:CKbb \7\:CKbb) resistor r=132.647 c=0
Rl43 (\5\:CKbb \6\:CKbb) resistor r=465.929 c=0
Rl6 (mout \2\:mout) resistor r=24.2328 c=0
Rl7 (\3\:mout \4\:mout) resistor r=24.2328 c=0
Rl17 (\6\:n20 \7\:n20) resistor r=136.213 c=0
Rl12 (\3\:n20 \4\:n20) resistor r=24.848 c=0
Rl13 (\4\:n20 \5\:n20) resistor r=281.721 c=0
Rl3 (n20 \2\:n20) resistor r=205.495 c=0
Rl55 (\3\:RNb \4\:RNb) resistor r=234.8 c=0
Rl18 (RNb \2\:RNb) resistor r=62.7075 c=0
Rl56 (\4\:RNb \5\:RNb) resistor r=1125.6 c=0
Rl59 (\5\:RNb \8\:RNb) resistor r=775.703 c=0
Rl58 (\6\:RNb \7\:RNb) resistor r=142.538 c=0
Rl60 (\6\:RNb \9\:RNb) resistor r=2.7666 c=0
Rl57 (\5\:RNb \6\:RNb) resistor r=283.029 c=0
Rl27 (\9\:CKb \10\:CKb) resistor r=163.736 c=0
Rl54 (\11\:CKb \12\:CKb) resistor r=870.726 c=0
Rl22 (\2\:CKb \5\:CKb) resistor r=60.4181 c=0
Rl19 (CKb \2\:CKb) resistor r=1.2334 c=0
Rl25 (\3\:CKb \8\:CKb) resistor r=67.2828 c=0
Rl21 (\3\:CKb \4\:CKb) resistor r=234.553 c=0
Rl20 (\2\:CKb \3\:CKb) resistor r=77.7008 c=0
Rl26 (\6\:CKb \9\:CKb) resistor r=506.359 c=0
Rl23 (\5\:CKb \6\:CKb) resistor r=86.9066 c=0
Rl24 (\6\:CKb \7\:CKb) resistor r=234.725 c=0
Rl30 (\3\:n35g \4\:n35g) resistor r=250.512 c=0
Rl29 (\2\:n35g \3\:n35g) resistor r=181.74 c=0
Rl31 (\2\:n35g \5\:n35g) resistor r=94.1963 c=0
Rl28 (n35g \2\:n35g) resistor r=2.4834 c=0
Rl61 (\6\:qbint \7\:qbint) resistor r=149.805 c=0
Rl65 (\10\:qbint \11\:qbint) resistor r=237.758 c=0
Rl41 (\3\:qbint \5\:qbint) resistor r=35.3072 c=0
Rl40 (\2\:qbint \4\:qbint) resistor r=70.093 c=0
Rl38 (qbint \2\:qbint) resistor r=112.732 c=0
Rl39 (\2\:qbint \3\:qbint) resistor r=152.601 c=0
Rl62 (\7\:qbint \8\:qbint) resistor r=99.804 c=0
Rl64 (\8\:qbint \10\:qbint) resistor r=180.657 c=0
Rl63 (\8\:qbint \9\:qbint) resistor r=494.685 c=0
Rl33 (\3\:RTb \4\:RTb) resistor r=239.402 c=0
Rl32 (RTb \2\:RTb) resistor r=112.412 c=0
Rl51 (n35 \2\:n35) resistor r=508.667 c=0
Rl52 (\2\:n35 \3\:n35) resistor r=334.803 c=0
Rz20 (\1\:Q \2\:Q) resistor r=37.5 c=0
Rz23 (\1\:VSS \2\:VSS) resistor r=75 c=0
Rz24 (\8\:VSS \9\:VSS) resistor r=75 c=0
Rz25 (\10\:VSS \11\:VSS) resistor r=37.5 c=0
Rz28 (\12\:VSS \13\:VSS) resistor r=37.5 c=0
Rz29 (\22\:VSS \23\:VSS) resistor r=75 c=0
Rz30 (\24\:VSS \25\:VSS) resistor r=75 c=0
Rz31 (\26\:VSS \27\:VSS) resistor r=75 c=0
Rz32 (\28\:VSS \29\:VSS) resistor r=75 c=0
Rz33 (\30\:VSS \31\:VSS) resistor r=75 c=0
Rz3 (\14\:CKbb \15\:CKbb) resistor r=75 c=0
Rz8 (\11\:mout \12\:mout) resistor r=75 c=0
Rz9 (\13\:mout \14\:mout) resistor r=75 c=0
Rz1 (\12\:n20 \13\:n20) resistor r=75 c=0
Rz2 (\14\:n20 \15\:n20) resistor r=75 c=0
Rz7 (\10\:RNb \11\:RNb) resistor r=75 c=0
Rz4 (\13\:CKb \14\:CKb) resistor r=75 c=0
Rz11 (\9\:n35g \10\:n35g) resistor r=75 c=0
Rz15 (\11\:n35g \12\:n35g) resistor r=75 c=0
Rz14 (\16\:qbint \17\:qbint) resistor r=75 c=0
Rz16 (\10\:RTb \11\:RTb) resistor r=75 c=0
Rz10 (\7\:n35 \8\:n35) resistor r=75 c=0
Rz12 (\12\:n35 \13\:n35) resistor r=75 c=0
Rz17 (\17\:n35 \18\:n35) resistor r=75 c=0
Rz21 (n42 \2\:n42) resistor r=75 c=0
Rz22 (\3\:n42 \4\:n42) resistor r=75 c=0
Rz18 (n40 \2\:n40) resistor r=75 c=0
Rz19 (\3\:n40 \4\:n40) resistor r=75 c=0
Rz5 (net426 \2\:net426) resistor r=75 c=0
Rz6 (\3\:net426 \4\:net426) resistor r=75 c=0
Ry25 (\1\:VDD \2\:VDD) resistor r=62 c=0
Ry26 (\13\:VDD \14\:VDD) resistor r=62 c=0
Ry27 (\15\:VDD \16\:VDD) resistor r=20.6667 c=0
Ry28 (\17\:VDD \18\:VDD) resistor r=62 c=0
Ry29 (\19\:VDD \20\:VDD) resistor r=62 c=0
Ry30 (\21\:VDD \22\:VDD) resistor r=62 c=0
Ry31 (\23\:VDD \24\:VDD) resistor r=62 c=0
Ry32 (\25\:VDD \26\:VDD) resistor r=62 c=0
Ry19 (\3\:Q \4\:Q) resistor r=20.6667 c=0
Ry22 (\3\:VSS \4\:VSS) resistor r=10.3333 c=0
Ry23 (\3\:VSS \6\:VSS) resistor r=5.1667 c=0
Ry24 (\3\:VSS \7\:VSS) resistor r=5.1667 c=0
Ry33 (\14\:VSS \15\:VSS) resistor r=10.3333 c=0
Ry34 (\14\:VSS \17\:VSS) resistor r=5.1667 c=0
Ry35 (\14\:VSS \20\:VSS) resistor r=5.1667 c=0
Ry12 (\1\:ExtVDD \2\:ExtVDD) resistor r=62 c=0
Ry13 (\1\:ExtVDD \5\:ExtVDD) resistor r=62 c=0
Ry14 (\1\:ExtVDD \6\:ExtVDD) resistor r=62 c=0
Ry3 (\18\:CKbb \19\:CKbb) resistor r=62 c=0
Ry6 (\5\:mout \6\:mout) resistor r=62 c=0
Ry7 (\16\:mout \17\:mout) resistor r=62 c=0
Ry8 (\19\:mout \20\:mout) resistor r=62 c=0
Ry1 (\8\:n20 \9\:n20) resistor r=62 c=0
Ry2 (\16\:n20 \17\:n20) resistor r=62 c=0
Ry5 (\13\:RNb \14\:RNb) resistor r=62 c=0
Ry4 (\17\:CKb \18\:CKb) resistor r=62 c=0
Ry10 (\6\:n35g \7\:n35g) resistor r=62 c=0
Ry16 (\15\:n35g \16\:n35g) resistor r=62 c=0
Ry15 (\14\:qbint \15\:qbint) resistor r=62 c=0
Ry17 (\6\:RTb \7\:RTb) resistor r=62 c=0
Ry9 (\4\:n35 \5\:n35) resistor r=62 c=0
Ry11 (\9\:n35 \10\:n35) resistor r=62 c=0
Ry18 (\14\:n35 \15\:n35) resistor r=62 c=0
Ry20 (n41 \2\:n41) resistor r=62 c=0
Ry21 (\3\:n41 \4\:n41) resistor r=62 c=0
Rx12 (\3\:RN \5\:RN) resistor r=45 c=0
Rx29 (\3\:RT \9\:RT) resistor r=45 c=0
Rx30 (\1\:RT \10\:RT) resistor r=45 c=0
Rx31 (\7\:RT \11\:RT) resistor r=45 c=0
Rx8 (\5\:SN \10\:SN) resistor r=45 c=0
Rx9 (\2\:SN \11\:SN) resistor r=45 c=0
Rx32 (\3\:SN \12\:SN) resistor r=45 c=0
Rx33 (\9\:SN \13\:SN) resistor r=45 c=0
Rx3 (\2\:D \4\:D) resistor r=45 c=0
Rx10 (\3\:CK \7\:CK) resistor r=45 c=0
Rx1 (\3\:CKbb \12\:CKbb) resistor r=45 c=0
Rx2 (\7\:CKbb \13\:CKbb) resistor r=45 c=0
Rx7 (CKbb \17\:CKbb) resistor r=45 c=0
Rx34 (\11\:CKbb \20\:CKbb) resistor r=45 c=0
Rx35 (\8\:CKbb \21\:CKbb) resistor r=45 c=0
Rx18 (\4\:mout \10\:mout) resistor r=45 c=0
Rx19 (\2\:mout \18\:mout) resistor r=45 c=0
Rx4 (\2\:n20 \10\:n20) resistor r=45 c=0
Rx5 (\5\:n20 \11\:n20) resistor r=45 c=0
Rx6 (n20 \18\:n20) resistor r=45 c=0
Rx13 (\7\:n20 \19\:n20) resistor r=45 c=0
Rx14 (\4\:n20 \20\:n20) resistor r=45 c=0
Rx15 (\8\:RNb \12\:RNb) resistor r=45 c=0
Rx16 (\9\:RNb \15\:RNb) resistor r=45 c=0
Rx17 (\2\:RNb \16\:RNb) resistor r=45 c=0
Rx11 (CKb \16\:CKb) resistor r=45 c=0
Rx21 (\10\:CKb \19\:CKb) resistor r=45 c=0
Rx22 (\12\:CKb \20\:CKb) resistor r=45 c=0
Rx23 (\4\:n35g \8\:n35g) resistor r=45 c=0
Rx26 (n35g \14\:n35g) resistor r=45 c=0
Rx25 (\3\:qbint \12\:qbint) resistor r=45 c=0
Rx36 (\9\:qbint \18\:qbint) resistor r=45 c=0
Rx37 (qbint \19\:qbint) resistor r=45 c=0
Rx27 (\3\:RTb \5\:RTb) resistor r=45 c=0
Rx28 (RTb \9\:RTb) resistor r=45 c=0
Rx20 (\3\:n35 \6\:n35) resistor r=45 c=0
Rx24 (\2\:n35 \11\:n35) resistor r=45 c=0
Rx38 (n35 \16\:n35) resistor r=45 c=0
mn26 (\14\:n20 \4\:CKb n21 VSS) g45n1svt w=(1.45e-07) l=4.5e-08 nf=1 \
        as=8.7e-15 ad=2.03e-14 ps=4.1e-07 pd=5.7e-07 nrd=1.16667 \
        nrs=1.16667 sa=2.45e-07 sb=1.4e-07 sd=160n sca=8.0352 \
        scb=0.00565402 scc=8.19771e-05 m=(1)
mn25 (n21 \1\:D \22\:VSS VSS) g45n1svt w=(1.45e-07) l=4.5e-08 nf=1 \
        as=2.03e-14 ad=8.7e-15 ps=5.7e-07 pd=4.1e-07 nrd=1.16667 \
        nrs=1.16667 sa=2.45e-07 sb=1.4e-07 sd=160n sca=8.0352 \
        scb=0.00565402 scc=8.19771e-05 m=(1)
mn32 (\13\:mout \6\:n20 \3\:net426 VSS) g45n1svt w=(1.45e-07) l=4.5e-08 \
        nf=1 as=2.03e-14 ad=2.32e-14 ps=5.7e-07 pd=6.1e-07 nrd=1.16667 \
        nrs=1.16667 sa=8.3e-07 sb=1.4e-07 sd=160n sca=8.42104 \
        scb=0.00632542 scc=0.000106623 m=(1)
mn52 (n40 \11\:qbint n42 VSS) g45n1svt w=(1.45e-07) l=4.5e-08 nf=1 \
        as=2.32e-14 ad=2.32e-14 ps=6.1e-07 pd=6.1e-07 nrd=1.16667 \
        nrs=1.16667 sa=3.45e-07 sb=3.45e-07 sd=160n sca=8.42104 \
        scb=0.00632542 scc=0.000106623 m=(1)
mn30 (\3\:net426 \6\:SN \10\:VSS VSS) g45n1svt w=(1.45e-07) l=4.5e-08 \
        nf=1 as=2.32e-14 ad=4.858e-14 ps=6.1e-07 pd=9.6e-07 nrd=1.16667 \
        nrs=1.16667 sa=6.25e-07 sb=3.45e-07 sd=160n sca=8.42104 \
        scb=0.00632542 scc=0.000106623 m=(1)
mn51 (n40 \3\:RNb \3\:n42 VSS) g45n1svt w=(1.45e-07) l=4.5e-08 nf=1 \
        as=2.32e-14 ad=2.03e-14 ps=6.1e-07 pd=5.7e-07 nrd=1.16667 \
        nrs=1.16667 sa=1.4e-07 sb=5.5e-07 sd=160n sca=8.42104 \
        scb=0.00632542 scc=0.000106623 m=(1)
mn50 (n42 \8\:SN \1\:VSS VSS) g45n1svt w=(1.45e-07) l=4.5e-08 nf=1 \
        as=2.03e-14 ad=2.32e-14 ps=5.7e-07 pd=6.1e-07 nrd=1.16667 \
        nrs=1.16667 sa=5.5e-07 sb=1.4e-07 sd=160n sca=8.42104 \
        scb=0.00632542 scc=0.000106623 m=(1)
mn36 (\12\:n20 \9\:CKbb n30 VSS) g45n1svt w=(1.45e-07) l=4.5e-08 nf=1 \
        as=8.7e-15 ad=2.03e-14 ps=4.1e-07 pd=5.7e-07 nrd=1.16667 \
        nrs=1.16667 sa=1.4e-07 sb=8.3e-07 sd=160n sca=8.42104 \
        scb=0.00632542 scc=0.000106623 m=(1)
mn35 (n30 \3\:mout \10\:VSS VSS) g45n1svt w=(1.45e-07) l=4.5e-08 nf=1 \
        as=4.858e-14 ad=8.7e-15 ps=9.6e-07 pd=4.1e-07 nrd=1.16667 \
        nrs=1.16667 sa=2.45e-07 sb=7.25e-07 sd=160n sca=8.42104 \
        scb=0.00632542 scc=0.000106623 m=(1)
mn21 (\14\:CKbb \8\:CKb \30\:VSS VSS) g45n1svt w=(1.45e-07) l=4.5e-08 \
        nf=1 as=2.32e-14 ad=2.03e-14 ps=6.1e-07 pd=5.7e-07 nrd=1.16667 \
        nrs=1.16667 sa=1.4e-07 sb=3.45e-07 sd=160n sca=8.0352 \
        scb=0.00565402 scc=8.19771e-05 m=(1)
mn20 (\13\:CKb \1\:CK \30\:VSS VSS) g45n1svt w=(1.45e-07) l=4.5e-08 nf=1 \
        as=2.32e-14 ad=2.03e-14 ps=6.1e-07 pd=5.7e-07 nrd=1.16667 \
        nrs=1.16667 sa=3.45e-07 sb=1.4e-07 sd=160n sca=8.0352 \
        scb=0.00565402 scc=8.19771e-05 m=(1)
mn22 (\10\:RNb \1\:RN \28\:VSS VSS) g45n1svt w=(1.45e-07) l=4.5e-08 nf=1 \
        as=2.03e-14 ad=2.03e-14 ps=5.7e-07 pd=5.7e-07 nrd=1.16667 \
        nrs=1.16667 sa=1.4e-07 sb=1.4e-07 sd=160n sca=8.0352 \
        scb=0.00565402 scc=8.19771e-05 m=(1)
mn31 (\11\:mout RNb net426 VSS) g45n1svt w=(1.45e-07) l=4.5e-08 nf=1 \
        as=2.03e-14 ad=2.32e-14 ps=5.7e-07 pd=6.1e-07 nrd=1.16667 \
        nrs=1.16667 sa=1.4e-07 sb=3.45e-07 sd=160n sca=8.42104 \
        scb=0.00632542 scc=0.000106623 m=(1)
mn40 (\7\:n35 \4\:CKbb \11\:mout VSS) g45n1svt w=(1.45e-07) l=4.5e-08 \
        nf=1 as=2.32e-14 ad=2.03e-14 ps=6.1e-07 pd=5.7e-07 nrd=1.16667 \
        nrs=1.16667 sa=3.45e-07 sb=1.4e-07 sd=160n sca=8.42104 \
        scb=0.00632542 scc=0.000106623 m=(1)
NM0 (\9\:n35g \2\:RTb \12\:n35 VSS) g45n1svt w=(1.45e-07) l=4.5e-08 nf=1 \
        as=2.03e-14 ad=2.03e-14 ps=5.7e-07 pd=5.7e-07 nrd=1.16667 \
        nrs=1.16667 sa=1.4e-07 sb=1.4e-07 sd=160n sca=8.42104 \
        scb=0.00632542 scc=0.000106623 m=(1)
NM1 (\16\:qbint \5\:n35g \26\:VSS VSS) g45n1svt w=(1.45e-07) l=4.5e-08 \
        nf=1 as=2.03e-14 ad=2.03e-14 ps=5.7e-07 pd=5.7e-07 nrd=1.16667 \
        nrs=1.16667 sa=1.4e-07 sb=1.4e-07 sd=160n sca=9.33388 \
        scb=0.00788941 scc=0.00017958 m=(1)
NM3 (net0121 \5\:qbint \24\:VSS VSS) g45n1svt w=(1.45e-07) l=4.5e-08 \
        nf=1 as=2.03e-14 ad=8.7e-15 ps=5.7e-07 pd=4.1e-07 nrd=1.16667 \
        nrs=1.16667 sa=1.4e-07 sb=2.45e-07 sd=160n sca=9.33388 \
        scb=0.00788941 scc=0.00017958 m=(1)
mn45 (\10\:RTb \2\:RT \8\:VSS VSS) g45n1svt w=(1.45e-07) l=4.5e-08 nf=1 \
        as=2.03e-14 ad=2.03e-14 ps=5.7e-07 pd=5.7e-07 nrd=1.16667 \
        nrs=1.16667 sa=1.4e-07 sb=1.4e-07 sd=160n sca=8.42104 \
        scb=0.00632542 scc=0.000106623 m=(1)
NM2 (\11\:n35g \8\:RT net0121 VSS) g45n1svt w=(1.45e-07) l=4.5e-08 nf=1 \
        as=8.7e-15 ad=2.03e-14 ps=4.1e-07 pd=5.7e-07 nrd=1.16667 \
        nrs=1.16667 sa=2.45e-07 sb=1.4e-07 sd=160n sca=9.33388 \
        scb=0.00788941 scc=0.00017958 m=(1)
mn53 (\17\:n35 \11\:CKb \3\:n40 VSS) g45n1svt w=(1.45e-07) l=4.5e-08 nf=1 \
        as=2.03e-14 ad=2.03e-14 ps=5.7e-07 pd=5.7e-07 nrd=1.16667 \
        nrs=1.16667 sa=1.4e-07 sb=1.4e-07 sd=160n sca=8.42104 \
        scb=0.00632542 scc=0.000106623 m=(1)
mn55 (\1\:Q \6\:qbint \12\:VSS VSS) g45n1svt w=(2.6e-07) l=4.5e-08 nf=1 \
        as=3.64e-14 ad=3.64e-14 ps=8e-07 pd=8e-07 nrd=1.16667 nrs=1.16667 \
        sa=1.4e-07 sb=1.4e-07 sd=160n sca=9.50447 scb=0.0081528 \
        scc=0.00025289 m=(1)
mp55 (\3\:Q \7\:qbint \15\:VDD VDD) g45p1svt w=(3.9e-07) l=4.5e-08 nf=1 \
        as=5.46e-14 ad=5.46e-14 ps=1.06e-06 pd=1.06e-06 nrd=1.16667 \
        nrs=1.16667 sa=1.4e-07 sb=1.4e-07 sd=160n sca=20.1111 \
        scb=0.0190466 scc=0.00152507 m=(1)
ends RDFFSRQX1
// End of subcircuit definition.
