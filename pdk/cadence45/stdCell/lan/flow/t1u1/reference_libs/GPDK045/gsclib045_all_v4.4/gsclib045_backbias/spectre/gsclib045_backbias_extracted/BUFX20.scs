// Generated for: spectre (May  1 11:28:04 2013 )
// Library name: gsclib045_backbias
// Cell name: BUFX20
// View name: extracted

simulator lang=spectre

subckt BUFX20 A NW VDD VSS Y
mp1_1__rcx (\1\:Y n0 \1\:VDD NW) g45p1svt w=(4.6e-07) l=4.5e-08 nf=1 \
        as=7.335e-14 ad=7.306e-14 ps=1.24e-06 pd=1.23765e-06 nrd=1.16667 \
        nrs=1.16667 sa=1.4e-07 sb=2e-06 sd=160n sca=39.4883 scb=0.0368308 \
        scc=0.00409097 m=(17)
C1 (NW VSS) capacitor c=5.16785e-16
C2 (VDD VSS) capacitor c=3.63739e-17
C3 (A VSS) capacitor c=4.25709e-17
C4 (Y VSS) capacitor c=1.50751e-17
C5 (n0 VSS) capacitor c=1.65939e-15
C6 (\1\:A VSS) capacitor c=3.79181e-16
C7 (\52\:n0 VSS) capacitor c=2.5437e-16
C8 (\1\:VDD VSS) capacitor c=1.27694e-15
C9 (\1\:Y VSS) capacitor c=1.11863e-15
C10 (\11\:Y VSS) capacitor c=1.11365e-15
C11 (\56\:n0 VSS) capacitor c=2.00956e-17
C12 (\69\:n0 VSS) capacitor c=2.32805e-16
Rk88 (\1\:VSS VSS) resistor r=0.1026 c=0
Rk65 (\1\:VDD VDD) resistor r=0.1026 c=0
Rk35 (A \1\:A) resistor r=0.1211 c=0
Rk9 (\1\:Y Y) resistor r=0.09454 c=0
Rk10 (Y \11\:Y) resistor r=0.0734 c=0
Rk40 (\56\:n0 n0) resistor r=0.1469 c=0
Rk39 (\52\:n0 \56\:n0) resistor r=0.2067 c=0
Rk50 (\56\:n0 \69\:n0) resistor r=0.1315 c=0
mn1_1__rcx (\1\:VSS n0 \11\:Y VSS) g45n1svt w=(3.05e-07) l=4.5e-08 nf=1 \
        as=4.844e-14 ad=4.864e-14 ps=9.2765e-07 pd=9.3e-07 nrd=1.16667 \
        nrs=1.16667 sa=1.4e-07 sb=2e-06 sd=160n sca=16.121 scb=0.0155296 \
        scc=0.00139557 m=(17)
mn0_1__rcx (\1\:VSS \1\:A \69\:n0 VSS) g45n1svt w=(2.6e-07) l=4.5e-08 \
        nf=1 as=4.056e-14 ad=4.25e-14 ps=8.32e-07 pd=8.58e-07 nrd=1.16667 \
        nrs=1.16667 sa=2e-06 sb=9.6e-07 sd=160n sca=17.5885 scb=0.0172826 \
        scc=0.00162584 m=(5)
mp0_1__rcx (\52\:n0 \1\:A \1\:VDD NW) g45p1svt w=(3.9e-07) l=4.5e-08 \
        nf=1 as=6.38e-14 ad=6.084e-14 ps=1.128e-06 pd=1.092e-06 \
        nrd=1.16667 nrs=1.16667 sa=2e-06 sb=9.6e-07 sd=160n sca=16.2669 \
        scb=0.0145797 scc=0.00118861 m=(5)
ends BUFX20
// End of subcircuit definition.
