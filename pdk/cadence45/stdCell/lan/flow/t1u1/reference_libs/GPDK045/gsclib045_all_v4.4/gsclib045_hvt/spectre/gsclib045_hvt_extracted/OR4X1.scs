// Generated for: spectre (May  1 09:19:43 2013 )
// Library name: gsclib045_hvt
// Cell name: OR4X1
// View name: extracted

simulator lang=spectre

subckt OR4X1 A B C D VDD VSS Y
mp3 (\7\:n0 \1\:D n3 VDD) g45p1hvt w=(2.15e-07) l=4.5e-08 nf=1 \
        as=1.29e-14 ad=3.01e-14 ps=5.5e-07 pd=7.1e-07 nrd=1.16667 \
        nrs=1.16667 sa=1.4e-07 sb=8.4e-07 sd=160n sca=21.9447 \
        scb=0.0249743 scc=0.00106646 m=(1)
mp2 (n3 \1\:C n2 VDD) g45p1hvt w=(2.15e-07) l=4.5e-08 nf=1 as=2.795e-14 \
        ad=1.29e-14 ps=6.9e-07 pd=5.5e-07 nrd=1.16667 nrs=1.16667 \
        sa=2.45e-07 sb=7.35e-07 sd=160n sca=18.6566 scb=0.0189947 \
        scc=0.000754481 m=(1)
mp1 (n2 \1\:B n1 VDD) g45p1hvt w=(2.15e-07) l=4.5e-08 nf=1 as=3.44e-14 \
        ad=2.795e-14 ps=7.5e-07 pd=6.9e-07 nrd=1.16667 nrs=1.16667 \
        sa=4.2e-07 sb=5.6e-07 sd=160n sca=16.9775 scb=0.0156264 \
        scc=0.000698003 m=(1)
mp0 (n1 \1\:A \1\:VDD VDD) g45p1hvt w=(2.15e-07) l=4.5e-08 nf=1 \
        as=8.22e-14 ad=3.44e-14 ps=1.71e-06 pd=7.5e-07 nrd=1.16667 \
        nrs=1.16667 sa=6.25e-07 sb=3.55e-07 sd=160n sca=17.9287 \
        scb=0.0175381 scc=0.000721605 m=(1)
C1 (B VSS) capacitor c=7.53621e-17
C2 (Y VSS) capacitor c=5.1243e-17
C3 (VDD VSS) capacitor c=9.86554e-17
C4 (C VSS) capacitor c=6.26809e-17
C5 (D VSS) capacitor c=3.16018e-17
C6 (A VSS) capacitor c=2.25446e-17
C7 (n0 VSS) capacitor c=4.2542e-17
C8 (n3 VSS) capacitor c=6.34833e-19
C9 (n2 VSS) capacitor c=7.74952e-18
C10 (n1 VSS) capacitor c=3.35121e-18
C11 (\1\:A VSS) capacitor c=5.97332e-17
C12 (\1\:B VSS) capacitor c=4.98772e-17
C13 (\1\:C VSS) capacitor c=8.28354e-17
C14 (\1\:D VSS) capacitor c=6.75879e-17
C15 (\4\:n0 VSS) capacitor c=5.5953e-17
C16 (\3\:A VSS) capacitor c=4.01531e-17
C17 (\3\:B VSS) capacitor c=4.28931e-17
C18 (\3\:C VSS) capacitor c=3.88825e-17
C19 (\3\:D VSS) capacitor c=3.51877e-17
C20 (\3\:n0 VSS) capacitor c=2.5803e-17
C21 (\2\:A VSS) capacitor c=6.01701e-17
C22 (\2\:B VSS) capacitor c=5.47057e-17
C23 (\2\:C VSS) capacitor c=6.61964e-17
C24 (\2\:D VSS) capacitor c=5.04783e-17
C25 (\1\:Y VSS) capacitor c=7.34422e-17
C26 (\1\:VDD VSS) capacitor c=8.35993e-17
C27 (\7\:n0 VSS) capacitor c=5.70911e-17
C28 (\3\:Y VSS) capacitor c=3.09435e-17
C29 (\9\:n0 VSS) capacitor c=5.95102e-17
C30 (\11\:n0 VSS) capacitor c=3.58386e-17
C31 (\2\:n0 VSS) capacitor c=2.72658e-17
C32 (\4\:D VSS) capacitor c=2.63638e-17
C33 (\4\:C VSS) capacitor c=4.45081e-17
C34 (\4\:B VSS) capacitor c=5.99338e-17
C35 (\4\:A VSS) capacitor c=5.83188e-17
C36 (\5\:n0 VSS) capacitor c=4.84941e-17
C37 (\6\:n0 VSS) capacitor c=1.28558e-16
C38 (\5\:VDD VSS) capacitor c=1.95132e-17
Rk3 (\4\:B B) resistor r=0.1951 c=0
Rk9 (\2\:Y Y) resistor r=0.4801 c=0
Rk10 (Y \4\:Y) resistor r=0.06502 c=0
Rk11 (\2\:VDD \3\:VDD) resistor r=0.3038 c=0
Rk13 (\5\:VDD VDD) resistor r=0.2506 c=0
Rk12 (\3\:VDD \5\:VDD) resistor r=0.1965 c=0
Rk2 (\4\:C C) resistor r=0.1309 c=0
Rk1 (\4\:D D) resistor r=0.07059 c=0
Rk4 (A \4\:A) resistor r=0.08218 c=0
Rk14 (\2\:VSS \4\:VSS) resistor r=0.432 c=0
Rk16 (\5\:VSS VSS) resistor r=0.2 c=0
Rk15 (\4\:VSS \5\:VSS) resistor r=0.04902 c=0
Rk17 (VSS \7\:VSS) resistor r=0.06384 c=0
Rk18 (\5\:VSS \9\:VSS) resistor r=0.04332 c=0
Rk5 (\5\:n0 \6\:n0) resistor r=0.1655 c=0
Rk6 (\6\:n0 \8\:n0) resistor r=0.5921 c=0
Rk7 (\6\:n0 \10\:n0) resistor r=0.3734 c=0
Rk8 (\10\:n0 \12\:n0) resistor r=0.2679 c=0
Rl5 (\1\:B \2\:B) resistor r=108.79 c=0
Rl6 (\2\:B \3\:B) resistor r=62.6365 c=0
Rl3 (\1\:C \2\:C) resistor r=139.666 c=0
Rl4 (\2\:C \3\:C) resistor r=34.4104 c=0
Rl1 (\1\:D \2\:D) resistor r=132.996 c=0
Rl2 (\2\:D \3\:D) resistor r=81.9251 c=0
Rl7 (\1\:A \2\:A) resistor r=110.713 c=0
Rl8 (\2\:A \3\:A) resistor r=60.7134 c=0
Rl9 (n0 \2\:n0) resistor r=34.3295 c=0
Rl11 (\2\:n0 \4\:n0) resistor r=142.022 c=0
Rl10 (\2\:n0 \3\:n0) resistor r=3.5166 c=0
Rz3 (\3\:Y \4\:Y) resistor r=37.5 c=0
Rz5 (\1\:VSS \2\:VSS) resistor r=75 c=0
Rz6 (\6\:VSS \7\:VSS) resistor r=75 c=0
Rz7 (\8\:VSS \9\:VSS) resistor r=75 c=0
Rz1 (\9\:n0 \10\:n0) resistor r=75 c=0
Rz2 (\11\:n0 \12\:n0) resistor r=75 c=0
Ry2 (\1\:Y \2\:Y) resistor r=20.6667 c=0
Ry3 (\1\:VDD \2\:VDD) resistor r=62 c=0
Ry4 (\1\:VDD \3\:VDD) resistor r=62 c=0
Ry1 (\7\:n0 \8\:n0) resistor r=62 c=0
Rx3 (\2\:B \4\:B) resistor r=45 c=0
Rx2 (\2\:C \4\:C) resistor r=45 c=0
Rx1 (\2\:D \4\:D) resistor r=45 c=0
Rx4 (\2\:A \4\:A) resistor r=45 c=0
Rx5 (\3\:n0 \5\:n0) resistor r=45 c=0
mn3 (\11\:n0 \3\:D \6\:VSS VSS) g45n1hvt w=(1.45e-07) l=4.5e-08 nf=1 \
        as=3.78e-14 ad=2.32e-14 ps=1.23e-06 pd=6.1e-07 nrd=1.16667 \
        nrs=1.16667 sa=1e-07 sb=9.6e-07 sd=160n sca=10.0732 scb=0.00911402 \
        scc=0.000253284 m=(1)
mn2 (\11\:n0 \3\:C \8\:VSS VSS) g45n1hvt w=(1.45e-07) l=4.5e-08 nf=1 \
        as=4.465e-14 ad=2.32e-14 ps=1.31e-06 pd=6.1e-07 nrd=1.16667 \
        nrs=1.16667 sa=3.05e-07 sb=7.55e-07 sd=160n sca=10.0732 \
        scb=0.00911402 scc=0.000253284 m=(1)
mn1 (\9\:n0 \3\:B \8\:VSS VSS) g45n1hvt w=(1.45e-07) l=4.5e-08 nf=1 \
        as=4.465e-14 ad=2.32e-14 ps=1.31e-06 pd=6.1e-07 nrd=1.16667 \
        nrs=1.16667 sa=5e-07 sb=5.6e-07 sd=160n sca=10.0732 scb=0.00911402 \
        scc=0.000253284 m=(1)
mn0 (\9\:n0 \3\:A \1\:VSS VSS) g45n1hvt w=(1.45e-07) l=4.5e-08 nf=1 \
        as=3.615e-14 ad=2.32e-14 ps=8.6e-07 pd=6.1e-07 nrd=1.16667 \
        nrs=1.16667 sa=7.05e-07 sb=3.55e-07 sd=160n sca=10.0732 \
        scb=0.00911402 scc=0.000253284 m=(1)
mn4 (\3\:Y \4\:n0 \1\:VSS VSS) g45n1hvt w=(2.6e-07) l=4.5e-08 nf=1 \
        as=3.615e-14 ad=3.64e-14 ps=8.6e-07 pd=8e-07 nrd=1.16667 \
        nrs=1.16667 sa=5.57308e-07 sb=1.4e-07 sd=160n sca=8.51051 \
        scb=0.00656948 scc=0.000151659 m=(1)
mp4 (\1\:Y n0 \1\:VDD VDD) g45p1hvt w=(3.9e-07) l=4.5e-08 nf=1 \
        as=8.22e-14 ad=5.46e-14 ps=1.71e-06 pd=1.06e-06 nrd=1.16667 \
        nrs=1.16667 sa=5.14359e-07 sb=1.4e-07 sd=160n sca=26.8339 \
        scb=0.0306087 scc=0.00198091 m=(1)
ends OR4X1
// End of subcircuit definition.
