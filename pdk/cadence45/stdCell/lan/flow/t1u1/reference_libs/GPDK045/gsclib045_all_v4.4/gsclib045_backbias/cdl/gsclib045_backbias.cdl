************************************************************************
* auCdl Netlist:
*
* Library Name:  gsclib045_backbias
* View Name:     schematic
* Netlisted on:  May  3 11:25:42 2013
************************************************************************

.SUBCKT ACHCONX2 A B CI CON NW VDD VSS
*.PININFO A:I B:I CI:I NW:I VDD:I VSS:I CON:O
Mmn6 n15 A VSS VSS g45n1svt m=1 l=45n w=390n
Mmn10 net0370 CI VSS VSS g45n1svt m=1 l=45n w=390n
Mmn11 n13 B VSS VSS g45n1svt m=1 l=45n w=390n
Mmn7 n12 B VSS VSS g45n1svt m=1 l=45n w=390n
Mmn8 net0370 n10 CON VSS g45n1svt m=1 l=45n w=390n
Mmn3 n9 n13 n15 VSS g45n1svt m=1 l=45n w=390n
Mmn1 n10 n13 n11 VSS g45n1svt m=1 l=45n w=310n
Mmn4 n11 B n9 VSS g45n1svt m=1 l=45n w=310n
Mmn5 n11 n15 VSS VSS g45n1svt m=1 l=45n w=310n
Mmn2 n15 B n10 VSS g45n1svt m=1 l=45n w=390n
Mmn9 n12 n9 CON VSS g45n1svt m=1 l=45n w=390n
Mmp6 n15 A VDD NW g45p1svt m=1 l=45n w=770n
Mmp10 net0370 CI VDD NW g45p1svt m=1 l=45n w=770n
Mmp8 net0370 n9 CON NW g45p1svt m=1 l=45n w=770n
Mmp7 n12 B VDD NW g45p1svt m=1 l=45n w=770n
Mmp5 n11 n15 VDD NW g45p1svt m=1 l=45n w=520n
Mmp1 n10 B n11 NW g45p1svt m=1 l=45n w=520n
Mmp2 n15 n13 n10 NW g45p1svt m=1 l=45n w=770n
Mmp11 n13 B VDD NW g45p1svt m=1 l=45n w=770n
Mmp4 n11 n13 n9 NW g45p1svt m=1 l=45n w=520n
Mmp3 n9 B n15 NW g45p1svt m=1 l=45n w=770n
Mmp9 n12 n10 CON NW g45p1svt m=1 l=45n w=770n
.ENDS

.SUBCKT ADDFHX1 A B CI CO NW S VDD VSS
*.PININFO A:I B:I CI:I NW:I VDD:I VSS:I CO:O S:O
Mmn5 n4 A VSS VSS g45n1svt m=1 l=45n w=205n
Mmn6 n4 B VSS VSS g45n1svt m=1 l=45n w=205n
Mmn4 COb CI n2 VSS g45n1svt m=1 l=45n w=205n
Mmn3 n2 B VSS VSS g45n1svt m=1 l=45n w=205n
Mmn2 n2 A VSS VSS g45n1svt m=1 l=45n w=205n
Mmn7 n4 CI VSS VSS g45n1svt m=1 l=45n w=205n
Mmn8 Sb COb n4 VSS g45n1svt m=1 l=45n w=205n
Mmn0 n0 A VSS VSS g45n1svt m=1 l=45n w=205n
Mmn1 COb B n0 VSS g45n1svt m=1 l=45n w=205n
Mmn12 CO COb VSS VSS g45n1svt m=1 l=45n w=260n
Mmn13 S Sb VSS VSS g45n1svt m=1 l=45n w=260n
Mmn11 Sb CI n7 VSS g45n1svt m=1 l=45n w=205n
Mmn10 n7 B n6 VSS g45n1svt m=1 l=45n w=205n
Mmn9 n6 A VSS VSS g45n1svt m=1 l=45n w=205n
Mmp2 n3 A VDD NW g45p1svt m=1 l=45n w=310n
Mmp3 n3 B VDD NW g45p1svt m=1 l=45n w=310n
Mmp4 COb CI n3 NW g45p1svt m=1 l=45n w=310n
Mmp5 n5 A VDD NW g45p1svt m=1 l=45n w=310n
Mmp6 n5 B VDD NW g45p1svt m=1 l=45n w=310n
Mmp7 n5 CI VDD NW g45p1svt m=1 l=45n w=310n
Mmp8 Sb COb n5 NW g45p1svt m=1 l=45n w=310n
Mmp0 n1 A VDD NW g45p1svt m=1 l=45n w=310n
Mmp1 COb B n1 NW g45p1svt m=1 l=45n w=310n
Mmp12 CO COb VDD NW g45p1svt m=1 l=45n w=390n
Mmp13 S Sb VDD NW g45p1svt m=1 l=45n w=390n
Mmp11 Sb CI n9 NW g45p1svt m=1 l=45n w=310n
Mmp10 n9 B n8 NW g45p1svt m=1 l=45n w=310n
Mmp9 n8 A VDD NW g45p1svt m=1 l=45n w=310n
.ENDS

.SUBCKT ADDFHX2 A B CI CO NW S VDD VSS
*.PININFO A:I B:I CI:I NW:I VDD:I VSS:I CO:O S:O
Mmn5 n4 A VSS VSS g45n1svt m=1 l=45n w=205n
Mmn6 n4 B VSS VSS g45n1svt m=1 l=45n w=205n
Mmn4 COb CI n2 VSS g45n1svt m=1 l=45n w=205n
Mmn3 n2 B VSS VSS g45n1svt m=1 l=45n w=205n
Mmn2 n2 A VSS VSS g45n1svt m=1 l=45n w=205n
Mmn7 n4 CI VSS VSS g45n1svt m=1 l=45n w=205n
Mmn8 Sb COb n4 VSS g45n1svt m=1 l=45n w=205n
Mmn0 n0 A VSS VSS g45n1svt m=1 l=45n w=205n
Mmn1 COb B n0 VSS g45n1svt m=1 l=45n w=205n
Mmn12 CO COb VSS VSS g45n1svt m=1 l=45n w=520n
Mmn13 S Sb VSS VSS g45n1svt m=1 l=45n w=520n
Mmn11 Sb CI n7 VSS g45n1svt m=1 l=45n w=205n
Mmn10 n7 B n6 VSS g45n1svt m=1 l=45n w=205n
Mmn9 n6 A VSS VSS g45n1svt m=1 l=45n w=205n
Mmp2 n3 A VDD NW g45p1svt m=1 l=45n w=310n
Mmp3 n3 B VDD NW g45p1svt m=1 l=45n w=310n
Mmp4 COb CI n3 NW g45p1svt m=1 l=45n w=310n
Mmp5 n5 A VDD NW g45p1svt m=1 l=45n w=310n
Mmp6 n5 B VDD NW g45p1svt m=1 l=45n w=310n
Mmp7 n5 CI VDD NW g45p1svt m=1 l=45n w=310n
Mmp8 Sb COb n5 NW g45p1svt m=1 l=45n w=310n
Mmp0 n1 A VDD NW g45p1svt m=1 l=45n w=310n
Mmp1 COb B n1 NW g45p1svt m=1 l=45n w=310n
Mmp12 CO COb VDD NW g45p1svt m=1 l=45n w=780n
Mmp13 S Sb VDD NW g45p1svt m=1 l=45n w=780n
Mmp11 Sb CI n9 NW g45p1svt m=1 l=45n w=310n
Mmp10 n9 B n8 NW g45p1svt m=1 l=45n w=310n
Mmp9 n8 A VDD NW g45p1svt m=1 l=45n w=310n
.ENDS

.SUBCKT ADDFHX4 A B CI CO NW S VDD VSS
*.PININFO A:I B:I CI:I NW:I VDD:I VSS:I CO:O S:O
Mmn5 n4 A VSS VSS g45n1svt m=1 l=45n w=260n
Mmn6 n4 B VSS VSS g45n1svt m=1 l=45n w=260n
Mmn4 COb CI n2 VSS g45n1svt m=1 l=45n w=260n
Mmn3 n2 B VSS VSS g45n1svt m=1 l=45n w=260n
Mmn2 n2 A VSS VSS g45n1svt m=1 l=45n w=260n
Mmn7 n4 CI VSS VSS g45n1svt m=1 l=45n w=260n
Mmn8 Sb COb n4 VSS g45n1svt m=1 l=45n w=260n
Mmn0 n0 A VSS VSS g45n1svt m=1 l=45n w=260n
Mmn1 COb B n0 VSS g45n1svt m=1 l=45n w=260n
Mmn12 CO COb VSS VSS g45n1svt m=1 l=45n w=1.04u
Mmn13 S Sb VSS VSS g45n1svt m=1 l=45n w=1.04u
Mmn11 Sb CI n7 VSS g45n1svt m=1 l=45n w=260n
Mmn10 n7 B n6 VSS g45n1svt m=1 l=45n w=260n
Mmn9 n6 A VSS VSS g45n1svt m=1 l=45n w=260n
Mmp2 n3 A VDD NW g45p1svt m=1 l=45n w=390n
Mmp3 n3 B VDD NW g45p1svt m=1 l=45n w=390n
Mmp4 COb CI n3 NW g45p1svt m=1 l=45n w=390n
Mmp5 n5 A VDD NW g45p1svt m=1 l=45n w=390n
Mmp6 n5 B VDD NW g45p1svt m=1 l=45n w=390n
Mmp7 n5 CI VDD NW g45p1svt m=1 l=45n w=390n
Mmp8 Sb COb n5 NW g45p1svt m=1 l=45n w=390n
Mmp0 n1 A VDD NW g45p1svt m=1 l=45n w=390n
Mmp1 COb B n1 NW g45p1svt m=1 l=45n w=390n
Mmp12 CO COb VDD NW g45p1svt m=1 l=45n w=1.56u
Mmp13 S Sb VDD NW g45p1svt m=1 l=45n w=1.56u
Mmp11 Sb CI n9 NW g45p1svt m=1 l=45n w=390n
Mmp10 n9 B n8 NW g45p1svt m=1 l=45n w=390n
Mmp9 n8 A VDD NW g45p1svt m=1 l=45n w=390n
.ENDS

.SUBCKT ADDFHXL A B CI CO NW S VDD VSS
*.PININFO A:I B:I CI:I NW:I VDD:I VSS:I CO:O S:O
Mmn5 n4 A VSS VSS g45n1svt m=1 l=45n w=205n
Mmn6 n4 B VSS VSS g45n1svt m=1 l=45n w=205n
Mmn4 COb CI n2 VSS g45n1svt m=1 l=45n w=205n
Mmn3 n2 B VSS VSS g45n1svt m=1 l=45n w=205n
Mmn2 n2 A VSS VSS g45n1svt m=1 l=45n w=205n
Mmn7 n4 CI VSS VSS g45n1svt m=1 l=45n w=205n
Mmn8 Sb COb n4 VSS g45n1svt m=1 l=45n w=205n
Mmn0 n0 A VSS VSS g45n1svt m=1 l=45n w=205n
Mmn1 COb B n0 VSS g45n1svt m=1 l=45n w=205n
Mmn12 CO COb VSS VSS g45n1svt m=1 l=45n w=205n
Mmn13 S Sb VSS VSS g45n1svt m=1 l=45n w=205n
Mmn11 Sb CI n7 VSS g45n1svt m=1 l=45n w=205n
Mmn10 n7 B n6 VSS g45n1svt m=1 l=45n w=205n
Mmn9 n6 A VSS VSS g45n1svt m=1 l=45n w=205n
Mmp2 n3 A VDD NW g45p1svt m=1 l=45n w=310n
Mmp3 n3 B VDD NW g45p1svt m=1 l=45n w=310n
Mmp4 COb CI n3 NW g45p1svt m=1 l=45n w=310n
Mmp5 n5 A VDD NW g45p1svt m=1 l=45n w=310n
Mmp6 n5 B VDD NW g45p1svt m=1 l=45n w=310n
Mmp7 n5 CI VDD NW g45p1svt m=1 l=45n w=310n
Mmp8 Sb COb n5 NW g45p1svt m=1 l=45n w=310n
Mmp0 n1 A VDD NW g45p1svt m=1 l=45n w=310n
Mmp1 COb B n1 NW g45p1svt m=1 l=45n w=310n
Mmp12 CO COb VDD NW g45p1svt m=1 l=45n w=310n
Mmp13 S Sb VDD NW g45p1svt m=1 l=45n w=310n
Mmp11 Sb CI n9 NW g45p1svt m=1 l=45n w=310n
Mmp10 n9 B n8 NW g45p1svt m=1 l=45n w=310n
Mmp9 n8 A VDD NW g45p1svt m=1 l=45n w=310n
.ENDS

.SUBCKT ADDFX1 A B CI CO NW S VDD VSS
*.PININFO A:I B:I CI:I NW:I VDD:I VSS:I CO:O S:O
Mmn9 n6 A VSS VSS g45n1svt m=1 l=45n w=145n
Mmn10 n7 B n6 VSS g45n1svt m=1 l=45n w=145n
Mmn11 Sb CI n7 VSS g45n1svt m=1 l=45n w=145n
Mmn13 S Sb VSS VSS g45n1svt m=1 l=45n w=260n
Mmn12 CO COb VSS VSS g45n1svt m=1 l=45n w=260n
Mmn1 COb B n0 VSS g45n1svt m=1 l=45n w=145n
Mmn2 n2 A VSS VSS g45n1svt m=1 l=45n w=145n
Mmn0 n0 A VSS VSS g45n1svt m=1 l=45n w=145n
Mmn7 n4 CI VSS VSS g45n1svt m=1 l=45n w=145n
Mmn8 Sb COb n4 VSS g45n1svt m=1 l=45n w=145n
Mmn3 n2 B VSS VSS g45n1svt m=1 l=45n w=145n
Mmn6 n4 B VSS VSS g45n1svt m=1 l=45n w=145n
Mmn5 n4 A VSS VSS g45n1svt m=1 l=45n w=145n
Mmn4 COb CI n2 VSS g45n1svt m=1 l=45n w=145n
Mmp9 n8 A VDD NW g45p1svt m=1 l=45n w=215n
Mmp10 n9 B n8 NW g45p1svt m=1 l=45n w=215n
Mmp11 Sb CI n9 NW g45p1svt m=1 l=45n w=215n
Mmp13 S Sb VDD NW g45p1svt m=1 l=45n w=390n
Mmp12 CO COb VDD NW g45p1svt m=1 l=45n w=390n
Mmp1 COb B n1 NW g45p1svt m=1 l=45n w=215n
Mmp0 n1 A VDD NW g45p1svt m=1 l=45n w=215n
Mmp2 n3 A VDD NW g45p1svt m=1 l=45n w=215n
Mmp4 COb CI n3 NW g45p1svt m=1 l=45n w=215n
Mmp5 n5 A VDD NW g45p1svt m=1 l=45n w=215n
Mmp6 n5 B VDD NW g45p1svt m=1 l=45n w=215n
Mmp7 n5 CI VDD NW g45p1svt m=1 l=45n w=215n
Mmp3 n3 B VDD NW g45p1svt m=1 l=45n w=215n
Mmp8 Sb COb n5 NW g45p1svt m=1 l=45n w=215n
.ENDS

.SUBCKT ADDFX2 A B CI CO NW S VDD VSS
*.PININFO A:I B:I CI:I NW:I VDD:I VSS:I CO:O S:O
Mmn9 n6 A VSS VSS g45n1svt m=1 l=45n w=145n
Mmn10 n7 B n6 VSS g45n1svt m=1 l=45n w=145n
Mmn11 Sb CI n7 VSS g45n1svt m=1 l=45n w=145n
Mmn13 S Sb VSS VSS g45n1svt m=1 l=45n w=520n
Mmn12 CO COb VSS VSS g45n1svt m=1 l=45n w=520n
Mmn1 COb B n0 VSS g45n1svt m=1 l=45n w=145n
Mmn2 n2 A VSS VSS g45n1svt m=1 l=45n w=145n
Mmn0 n0 A VSS VSS g45n1svt m=1 l=45n w=145n
Mmn7 n4 CI VSS VSS g45n1svt m=1 l=45n w=145n
Mmn8 Sb COb n4 VSS g45n1svt m=1 l=45n w=145n
Mmn3 n2 B VSS VSS g45n1svt m=1 l=45n w=145n
Mmn6 n4 B VSS VSS g45n1svt m=1 l=45n w=145n
Mmn5 n4 A VSS VSS g45n1svt m=1 l=45n w=145n
Mmn4 COb CI n2 VSS g45n1svt m=1 l=45n w=145n
Mmp9 n8 A VDD NW g45p1svt m=1 l=45n w=215n
Mmp10 n9 B n8 NW g45p1svt m=1 l=45n w=215n
Mmp11 Sb CI n9 NW g45p1svt m=1 l=45n w=215n
Mmp13 S Sb VDD NW g45p1svt m=1 l=45n w=780n
Mmp12 CO COb VDD NW g45p1svt m=1 l=45n w=780n
Mmp1 COb B n1 NW g45p1svt m=1 l=45n w=215n
Mmp0 n1 A VDD NW g45p1svt m=1 l=45n w=215n
Mmp2 n3 A VDD NW g45p1svt m=1 l=45n w=215n
Mmp4 COb CI n3 NW g45p1svt m=1 l=45n w=215n
Mmp5 n5 A VDD NW g45p1svt m=1 l=45n w=215n
Mmp6 n5 B VDD NW g45p1svt m=1 l=45n w=215n
Mmp7 n5 CI VDD NW g45p1svt m=1 l=45n w=215n
Mmp3 n3 B VDD NW g45p1svt m=1 l=45n w=215n
Mmp8 Sb COb n5 NW g45p1svt m=1 l=45n w=215n
.ENDS

.SUBCKT ADDFX4 A B CI CO NW S VDD VSS
*.PININFO A:I B:I CI:I NW:I VDD:I VSS:I CO:O S:O
Mmn9 n6 A VSS VSS g45n1svt m=1 l=45n w=260n
Mmn10 n7 B n6 VSS g45n1svt m=1 l=45n w=260n
Mmn11 Sb CI n7 VSS g45n1svt m=1 l=45n w=260n
Mmn13 S Sb VSS VSS g45n1svt m=1 l=45n w=1.04u
Mmn12 CO COb VSS VSS g45n1svt m=1 l=45n w=1.04u
Mmn1 COb B n0 VSS g45n1svt m=1 l=45n w=260n
Mmn2 n2 A VSS VSS g45n1svt m=1 l=45n w=260n
Mmn0 n0 A VSS VSS g45n1svt m=1 l=45n w=260n
Mmn7 n4 CI VSS VSS g45n1svt m=1 l=45n w=260n
Mmn8 Sb COb n4 VSS g45n1svt m=1 l=45n w=260n
Mmn3 n2 B VSS VSS g45n1svt m=1 l=45n w=260n
Mmn6 n4 B VSS VSS g45n1svt m=1 l=45n w=260n
Mmn5 n4 A VSS VSS g45n1svt m=1 l=45n w=260n
Mmn4 COb CI n2 VSS g45n1svt m=1 l=45n w=260n
Mmp9 n8 A VDD NW g45p1svt m=1 l=45n w=390n
Mmp10 n9 B n8 NW g45p1svt m=1 l=45n w=390n
Mmp11 Sb CI n9 NW g45p1svt m=1 l=45n w=390n
Mmp13 S Sb VDD NW g45p1svt m=1 l=45n w=1.56u
Mmp12 CO COb VDD NW g45p1svt m=1 l=45n w=1.56u
Mmp1 COb B n1 NW g45p1svt m=1 l=45n w=390n
Mmp0 n1 A VDD NW g45p1svt m=1 l=45n w=390n
Mmp2 n3 A VDD NW g45p1svt m=1 l=45n w=390n
Mmp4 COb CI n3 NW g45p1svt m=1 l=45n w=390n
Mmp5 n5 A VDD NW g45p1svt m=1 l=45n w=390n
Mmp6 n5 B VDD NW g45p1svt m=1 l=45n w=390n
Mmp7 n5 CI VDD NW g45p1svt m=1 l=45n w=390n
Mmp3 n3 B VDD NW g45p1svt m=1 l=45n w=390n
Mmp8 Sb COb n5 NW g45p1svt m=1 l=45n w=390n
.ENDS

.SUBCKT ADDFXL A B CI CO NW S VDD VSS
*.PININFO A:I B:I CI:I NW:I VDD:I VSS:I CO:O S:O
Mmn9 n6 A VSS VSS g45n1svt m=1 l=45n w=145n
Mmn10 n7 B n6 VSS g45n1svt m=1 l=45n w=145n
Mmn11 Sb CI n7 VSS g45n1svt m=1 l=45n w=145n
Mmn13 S Sb VSS VSS g45n1svt m=1 l=45n w=145n
Mmn12 CO COb VSS VSS g45n1svt m=1 l=45n w=145n
Mmn1 COb B n0 VSS g45n1svt m=1 l=45n w=145n
Mmn2 n2 A VSS VSS g45n1svt m=1 l=45n w=145n
Mmn0 n0 A VSS VSS g45n1svt m=1 l=45n w=145n
Mmn7 n4 CI VSS VSS g45n1svt m=1 l=45n w=145n
Mmn8 Sb COb n4 VSS g45n1svt m=1 l=45n w=145n
Mmn3 n2 B VSS VSS g45n1svt m=1 l=45n w=145n
Mmn6 n4 B VSS VSS g45n1svt m=1 l=45n w=145n
Mmn5 n4 A VSS VSS g45n1svt m=1 l=45n w=145n
Mmn4 COb CI n2 VSS g45n1svt m=1 l=45n w=145n
Mmp9 n8 A VDD NW g45p1svt m=1 l=45n w=215n
Mmp10 n9 B n8 NW g45p1svt m=1 l=45n w=215n
Mmp11 Sb CI n9 NW g45p1svt m=1 l=45n w=215n
Mmp13 S Sb VDD NW g45p1svt m=1 l=45n w=215n
Mmp12 CO COb VDD NW g45p1svt m=1 l=45n w=215n
Mmp1 COb B n1 NW g45p1svt m=1 l=45n w=215n
Mmp0 n1 A VDD NW g45p1svt m=1 l=45n w=215n
Mmp2 n3 A VDD NW g45p1svt m=1 l=45n w=215n
Mmp4 COb CI n3 NW g45p1svt m=1 l=45n w=215n
Mmp5 n5 A VDD NW g45p1svt m=1 l=45n w=215n
Mmp6 n5 B VDD NW g45p1svt m=1 l=45n w=215n
Mmp7 n5 CI VDD NW g45p1svt m=1 l=45n w=215n
Mmp3 n3 B VDD NW g45p1svt m=1 l=45n w=215n
Mmp8 Sb COb n5 NW g45p1svt m=1 l=45n w=215n
.ENDS

.SUBCKT ADDHX1 A B CO NW S VDD VSS
*.PININFO A:I B:I NW:I VDD:I VSS:I CO:O S:O
Mmn8 CO COb VSS VSS g45n1svt m=1 l=45n w=260n
Mmn7 COb B n4 VSS g45n1svt m=1 l=45n w=145n
Mmn6 n4 A VSS VSS g45n1svt m=1 l=45n w=145n
Mmn5 S Sb VSS VSS g45n1svt m=1 l=45n w=260n
Mmn3 Sb B n2 VSS g45n1svt m=1 l=45n w=145n
Mmn2 n2 n0 VSS VSS g45n1svt m=1 l=45n w=145n
Mmn1 n1 B VSS VSS g45n1svt m=1 l=45n w=145n
Mmn4 Sb n1 n0 VSS g45n1svt m=1 l=45n w=145n
Mmn0 n0 A VSS VSS g45n1svt m=1 l=45n w=145n
Mmp8 CO COb VDD NW g45p1svt m=1 l=45n w=390n
Mmp5 S Sb VDD NW g45p1svt m=1 l=45n w=390n
Mmp2 n3 n0 VDD NW g45p1svt m=1 l=45n w=215n
Mmp3 Sb n1 n3 NW g45p1svt m=1 l=45n w=215n
Mmp4 Sb B n0 NW g45p1svt m=1 l=45n w=215n
Mmp1 n1 B VDD NW g45p1svt m=1 l=45n w=215n
Mmp7 COb B VDD NW g45p1svt m=1 l=45n w=215n
Mmp0 n0 A VDD NW g45p1svt m=1 l=45n w=215n
Mmp6 COb A VDD NW g45p1svt m=1 l=45n w=215n
.ENDS

.SUBCKT ADDHX2 A B CO NW S VDD VSS
*.PININFO A:I B:I NW:I VDD:I VSS:I CO:O S:O
Mmn8 CO COb VSS VSS g45n1svt m=1 l=45n w=520n
Mmn7 COb B n4 VSS g45n1svt m=1 l=45n w=145n
Mmn6 n4 A VSS VSS g45n1svt m=1 l=45n w=145n
Mmn5 S Sb VSS VSS g45n1svt m=1 l=45n w=520n
Mmn3 Sb B n2 VSS g45n1svt m=1 l=45n w=145n
Mmn2 n2 n0 VSS VSS g45n1svt m=1 l=45n w=145n
Mmn1 n1 B VSS VSS g45n1svt m=1 l=45n w=145n
Mmn4 Sb n1 n0 VSS g45n1svt m=1 l=45n w=145n
Mmn0 n0 A VSS VSS g45n1svt m=1 l=45n w=145n
Mmp8 CO COb VDD NW g45p1svt m=1 l=45n w=780n
Mmp5 S Sb VDD NW g45p1svt m=1 l=45n w=780n
Mmp2 n3 n0 VDD NW g45p1svt m=1 l=45n w=215n
Mmp3 Sb n1 n3 NW g45p1svt m=1 l=45n w=215n
Mmp4 Sb B n0 NW g45p1svt m=1 l=45n w=215n
Mmp1 n1 B VDD NW g45p1svt m=1 l=45n w=215n
Mmp7 COb B VDD NW g45p1svt m=1 l=45n w=215n
Mmp0 n0 A VDD NW g45p1svt m=1 l=45n w=215n
Mmp6 COb A VDD NW g45p1svt m=1 l=45n w=215n
.ENDS

.SUBCKT ADDHX4 A B CO NW S VDD VSS
*.PININFO A:I B:I NW:I VDD:I VSS:I CO:O S:O
Mmn8 CO COb VSS VSS g45n1svt m=1 l=45n w=1.04u
Mmn7 COb B n4 VSS g45n1svt m=1 l=45n w=260n
Mmn6 n4 A VSS VSS g45n1svt m=1 l=45n w=260n
Mmn5 S Sb VSS VSS g45n1svt m=1 l=45n w=1.04u
Mmn3 Sb B n2 VSS g45n1svt m=1 l=45n w=260n
Mmn2 n2 n0 VSS VSS g45n1svt m=1 l=45n w=260n
Mmn1 n1 B VSS VSS g45n1svt m=1 l=45n w=145n
Mmn4 Sb n1 n0 VSS g45n1svt m=1 l=45n w=260n
Mmn0 n0 A VSS VSS g45n1svt m=1 l=45n w=145n
Mmp8 CO COb VDD NW g45p1svt m=1 l=45n w=1.56u
Mmp5 S Sb VDD NW g45p1svt m=1 l=45n w=1.56u
Mmp2 n3 n0 VDD NW g45p1svt m=1 l=45n w=390n
Mmp3 Sb n1 n3 NW g45p1svt m=1 l=45n w=390n
Mmp4 Sb B n0 NW g45p1svt m=1 l=45n w=390n
Mmp1 n1 B VDD NW g45p1svt m=1 l=45n w=215n
Mmp7 COb B VDD NW g45p1svt m=1 l=45n w=390n
Mmp0 n0 A VDD NW g45p1svt m=1 l=45n w=215n
Mmp6 COb A VDD NW g45p1svt m=1 l=45n w=390n
.ENDS

.SUBCKT ADDHXL A B CO NW S VDD VSS
*.PININFO A:I B:I NW:I VDD:I VSS:I CO:O S:O
Mmn8 CO COb VSS VSS g45n1svt m=1 l=45n w=145n
Mmn7 COb B n4 VSS g45n1svt m=1 l=45n w=145n
Mmn6 n4 A VSS VSS g45n1svt m=1 l=45n w=145n
Mmn5 S Sb VSS VSS g45n1svt m=1 l=45n w=145n
Mmn3 Sb B n2 VSS g45n1svt m=1 l=45n w=145n
Mmn2 n2 n0 VSS VSS g45n1svt m=1 l=45n w=145n
Mmn1 n1 B VSS VSS g45n1svt m=1 l=45n w=145n
Mmn4 Sb n1 n0 VSS g45n1svt m=1 l=45n w=145n
Mmn0 n0 A VSS VSS g45n1svt m=1 l=45n w=145n
Mmp8 CO COb VDD NW g45p1svt m=1 l=45n w=215n
Mmp5 S Sb VDD NW g45p1svt m=1 l=45n w=215n
Mmp2 n3 n0 VDD NW g45p1svt m=1 l=45n w=215n
Mmp3 Sb n1 n3 NW g45p1svt m=1 l=45n w=215n
Mmp4 Sb B n0 NW g45p1svt m=1 l=45n w=215n
Mmp1 n1 B VDD NW g45p1svt m=1 l=45n w=215n
Mmp7 COb B VDD NW g45p1svt m=1 l=45n w=215n
Mmp0 n0 A VDD NW g45p1svt m=1 l=45n w=215n
Mmp6 COb A VDD NW g45p1svt m=1 l=45n w=215n
.ENDS

.SUBCKT AND2X1 A B NW VDD VSS Y
*.PININFO A:I B:I NW:I VDD:I VSS:I Y:O
Mmn2 Y n0 VSS VSS g45n1svt m=1 l=45n w=260n
Mmn0 net127 B VSS VSS g45n1svt m=1 l=45n w=145n
Mmn1 n0 A net127 VSS g45n1svt m=1 l=45n w=145n
Mmp1 n0 B VDD NW g45p1svt m=1 l=45n w=215n
Mmp0 n0 A VDD NW g45p1svt m=1 l=45n w=215n
Mmp2 Y n0 VDD NW g45p1svt m=1 l=45n w=390n
.ENDS

.SUBCKT AND2X2 A B NW VDD VSS Y
*.PININFO A:I B:I NW:I VDD:I VSS:I Y:O
Mmn2 Y n0 VSS VSS g45n1svt m=1 l=45n w=520n
Mmn0 net73 A VSS VSS g45n1svt m=1 l=45n w=145n
Mmn1 n0 B net73 VSS g45n1svt m=1 l=45n w=145n
Mmp1 n0 B VDD NW g45p1svt m=1 l=45n w=215n
Mmp0 n0 A VDD NW g45p1svt m=1 l=45n w=215n
Mmp2 Y n0 VDD NW g45p1svt m=1 l=45n w=780n
.ENDS

.SUBCKT AND2X4 A B NW VDD VSS Y
*.PININFO A:I B:I NW:I VDD:I VSS:I Y:O
Mmn2 Y net61 VSS VSS g45n1svt m=1 l=45n w=1.04u
Mmn0 net69 A VSS VSS g45n1svt m=1 l=45n w=260n
Mmn1 net61 B net69 VSS g45n1svt m=1 l=45n w=260n
Mmp1 net61 B VDD NW g45p1svt m=1 l=45n w=390n
Mmp0 net61 A VDD NW g45p1svt m=1 l=45n w=390n
Mmp2 Y net61 VDD NW g45p1svt m=1 l=45n w=1.56u
.ENDS

.SUBCKT AND2X6 A B NW VDD VSS Y
*.PININFO A:I B:I NW:I VDD:I VSS:I Y:O
Mmn2 Y net61 VSS VSS g45n1svt m=1 l=45n w=1.55u
Mmn0 net61 B net69 VSS g45n1svt m=1 l=45n w=520n
Mmn1 net69 A VSS VSS g45n1svt m=1 l=45n w=520n
Mmp1 net61 B VDD NW g45p1svt m=1 l=45n w=780n
Mmp0 net61 A VDD NW g45p1svt m=1 l=45n w=780n
Mmp2 Y net61 VDD NW g45p1svt m=1 l=45n w=2.35u
.ENDS

.SUBCKT AND2X8 A B NW VDD VSS Y
*.PININFO A:I B:I NW:I VDD:I VSS:I Y:O
Mmn2 Y n0 VSS VSS g45n1svt m=1 l=45n w=2.065u
Mmn0 net69 A VSS VSS g45n1svt m=1 l=45n w=520n
Mmn1 n0 B net69 VSS g45n1svt m=1 l=45n w=520n
Mmp1 n0 B VDD NW g45p1svt m=1 l=45n w=780n
Mmp0 n0 A VDD NW g45p1svt m=1 l=45n w=780n
Mmp2 Y n0 VDD NW g45p1svt m=1 l=45n w=3.115u
.ENDS

.SUBCKT AND2XL A B NW VDD VSS Y
*.PININFO A:I B:I NW:I VDD:I VSS:I Y:O
Mmn2 Y net57 VSS VSS g45n1svt m=1 l=45n w=145n
Mmn0 net73 A VSS VSS g45n1svt m=1 l=45n w=145n
Mmn1 net57 B net73 VSS g45n1svt m=1 l=45n w=145n
Mmp1 net57 B VDD NW g45p1svt m=1 l=45n w=215n
Mmp0 net57 A VDD NW g45p1svt m=1 l=45n w=215n
Mmp2 Y net57 VDD NW g45p1svt m=1 l=45n w=215n
.ENDS

.SUBCKT AND3X1 A B C NW VDD VSS Y
*.PININFO A:I B:I C:I NW:I VDD:I VSS:I Y:O
Mmn3 Y net086 VSS VSS g45n1svt m=1 l=45n w=260n
Mmn1 net0106 B net0102 VSS g45n1svt m=1 l=45n w=145n
Mmn0 net0102 A VSS VSS g45n1svt m=1 l=45n w=145n
Mmn2 net086 C net0106 VSS g45n1svt m=1 l=45n w=145n
Mmp1 net086 B VDD NW g45p1svt m=1 l=45n w=215n
Mmp2 net086 C VDD NW g45p1svt m=1 l=45n w=215n
Mmp0 net086 A VDD NW g45p1svt m=1 l=45n w=215n
Mmp3 Y net086 VDD NW g45p1svt m=1 l=45n w=390n
.ENDS

.SUBCKT AND3X2 A B C NW VDD VSS Y
*.PININFO A:I B:I C:I NW:I VDD:I VSS:I Y:O
Mmn3 Y net95 VSS VSS g45n1svt m=1 l=45n w=520n
Mmn1 net111 B net103 VSS g45n1svt m=1 l=45n w=145n
Mmn0 net103 A VSS VSS g45n1svt m=1 l=45n w=145n
Mmn2 net95 C net111 VSS g45n1svt m=1 l=45n w=145n
Mmp1 net95 B VDD NW g45p1svt m=1 l=45n w=215n
Mmp2 net95 C VDD NW g45p1svt m=1 l=45n w=215n
Mmp0 net95 A VDD NW g45p1svt m=1 l=45n w=215n
Mmp3 Y net95 VDD NW g45p1svt m=1 l=45n w=780n
.ENDS

.SUBCKT AND3X4 A B C NW VDD VSS Y
*.PININFO A:I B:I C:I NW:I VDD:I VSS:I Y:O
Mmn3 Y net95 VSS VSS g45n1svt m=1 l=45n w=1.04u
Mmn1 net111 B net107 VSS g45n1svt m=1 l=45n w=260n
Mmn0 net107 A VSS VSS g45n1svt m=1 l=45n w=260n
Mmn2 net95 C net111 VSS g45n1svt m=1 l=45n w=260n
Mmp1 net95 B VDD NW g45p1svt m=1 l=45n w=390n
Mmp2 net95 C VDD NW g45p1svt m=1 l=45n w=390n
Mmp0 net95 A VDD NW g45p1svt m=1 l=45n w=390n
Mmp3 Y net95 VDD NW g45p1svt m=1 l=45n w=1.56u
.ENDS

.SUBCKT AND3X6 A B C NW VDD VSS Y
*.PININFO A:I B:I C:I NW:I VDD:I VSS:I Y:O
Mmn3 Y net95 VSS VSS g45n1svt m=1 l=45n w=1.55u
Mmn1 net107 B net103 VSS g45n1svt m=1 l=45n w=520n
Mmn0 net103 A VSS VSS g45n1svt m=1 l=45n w=520n
Mmn2 net95 C net107 VSS g45n1svt m=1 l=45n w=520n
Mmp1 net95 B VDD NW g45p1svt m=1 l=45n w=780n
Mmp2 net95 C VDD NW g45p1svt m=1 l=45n w=780n
Mmp0 net95 A VDD NW g45p1svt m=1 l=45n w=780n
Mmp3 Y net95 VDD NW g45p1svt m=1 l=45n w=2.35u
.ENDS

.SUBCKT AND3X8 A B C NW VDD VSS Y
*.PININFO A:I B:I C:I NW:I VDD:I VSS:I Y:O
Mmn3 Y net95 VSS VSS g45n1svt m=1 l=45n w=2.065u
Mmn1 net107 B net103 VSS g45n1svt m=1 l=45n w=520n
Mmn0 net103 A VSS VSS g45n1svt m=1 l=45n w=520n
Mmn2 net95 C net107 VSS g45n1svt m=1 l=45n w=520n
Mmp1 net95 B VDD NW g45p1svt m=1 l=45n w=780n
Mmp2 net95 C VDD NW g45p1svt m=1 l=45n w=780n
Mmp0 net95 A VDD NW g45p1svt m=1 l=45n w=780n
Mmp3 Y net95 VDD NW g45p1svt m=1 l=45n w=3.115u
.ENDS

.SUBCKT AND3XL A B C NW VDD VSS Y
*.PININFO A:I B:I C:I NW:I VDD:I VSS:I Y:O
Mmn3 Y net87 VSS VSS g45n1svt m=1 l=45n w=145n
Mmn1 net107 B net103 VSS g45n1svt m=1 l=45n w=145n
Mmn0 net103 A VSS VSS g45n1svt m=1 l=45n w=145n
Mmn2 net87 C net107 VSS g45n1svt m=1 l=45n w=145n
Mmp1 net87 B VDD NW g45p1svt m=1 l=45n w=215n
Mmp2 net87 C VDD NW g45p1svt m=1 l=45n w=215n
Mmp0 net87 A VDD NW g45p1svt m=1 l=45n w=215n
Mmp3 Y net87 VDD NW g45p1svt m=1 l=45n w=215n
.ENDS

.SUBCKT AND4X1 A B C D NW VDD VSS Y
*.PININFO A:I B:I C:I D:I NW:I VDD:I VSS:I Y:O
Mmn3 net116 D net132 VSS g45n1svt m=1 l=45n w=145n
Mmn2 net132 C net128 VSS g45n1svt m=1 l=45n w=145n
Mmn4 Y net116 VSS VSS g45n1svt m=1 l=45n w=260n
Mmn1 net128 B net124 VSS g45n1svt m=1 l=45n w=145n
Mmn0 net124 A VSS VSS g45n1svt m=1 l=45n w=145n
Mmp3 net116 D VDD NW g45p1svt m=1 l=45n w=215n
Mmp2 net116 C VDD NW g45p1svt m=1 l=45n w=215n
Mmp1 net116 B VDD NW g45p1svt m=1 l=45n w=215n
Mmp4 Y net116 VDD NW g45p1svt m=1 l=45n w=390n
Mmp0 net116 A VDD NW g45p1svt m=1 l=45n w=215n
.ENDS

.SUBCKT AND4X2 A B C D NW VDD VSS Y
*.PININFO A:I B:I C:I D:I NW:I VDD:I VSS:I Y:O
Mmn3 net100 D net132 VSS g45n1svt m=1 l=45n w=145n
Mmn2 net132 C net124 VSS g45n1svt m=1 l=45n w=145n
Mmn4 Y net100 VSS VSS g45n1svt m=1 l=45n w=520n
Mmn1 net124 B net120 VSS g45n1svt m=1 l=45n w=145n
Mmn0 net120 A VSS VSS g45n1svt m=1 l=45n w=145n
Mmp3 net100 D VDD NW g45p1svt m=1 l=45n w=215n
Mmp2 net100 C VDD NW g45p1svt m=1 l=45n w=215n
Mmp1 net100 B VDD NW g45p1svt m=1 l=45n w=215n
Mmp4 Y net100 VDD NW g45p1svt m=1 l=45n w=780n
Mmp0 net100 A VDD NW g45p1svt m=1 l=45n w=215n
.ENDS

.SUBCKT AND4X4 A B C D NW VDD VSS Y
*.PININFO A:I B:I C:I D:I NW:I VDD:I VSS:I Y:O
Mmn3 net100 D net132 VSS g45n1svt m=1 l=45n w=260n
Mmn2 net132 C net124 VSS g45n1svt m=1 l=45n w=260n
Mmn4 Y net100 VSS VSS g45n1svt m=1 l=45n w=1.04u
Mmn1 net124 B net120 VSS g45n1svt m=1 l=45n w=260n
Mmn0 net120 A VSS VSS g45n1svt m=1 l=45n w=260n
Mmp3 net100 D VDD NW g45p1svt m=1 l=45n w=390n
Mmp2 net100 C VDD NW g45p1svt m=1 l=45n w=390n
Mmp1 net100 B VDD NW g45p1svt m=1 l=45n w=390n
Mmp4 Y net100 VDD NW g45p1svt m=1 l=45n w=1.56u
Mmp0 net100 A VDD NW g45p1svt m=1 l=45n w=390n
.ENDS

.SUBCKT AND4X6 A B C D NW VDD VSS Y
*.PININFO A:I B:I C:I D:I NW:I VDD:I VSS:I Y:O
Mmn3 net116 D net132 VSS g45n1svt m=1 l=45n w=520n
Mmn2 net132 C net128 VSS g45n1svt m=1 l=45n w=520n
Mmn4 Y net116 VSS VSS g45n1svt m=1 l=45n w=1.55u
Mmn1 net128 B net124 VSS g45n1svt m=1 l=45n w=520n
Mmn0 net124 A VSS VSS g45n1svt m=1 l=45n w=520n
Mmp3 net116 D VDD NW g45p1svt m=1 l=45n w=780n
Mmp2 net116 C VDD NW g45p1svt m=1 l=45n w=780n
Mmp1 net116 B VDD NW g45p1svt m=1 l=45n w=780n
Mmp4 Y net116 VDD NW g45p1svt m=1 l=45n w=2.35u
Mmp0 net116 A VDD NW g45p1svt m=1 l=45n w=780n
.ENDS

.SUBCKT AND4X8 A B C D NW VDD VSS Y
*.PININFO A:I B:I C:I D:I NW:I VDD:I VSS:I Y:O
Mmn3 net116 D net132 VSS g45n1svt m=1 l=45n w=520n
Mmn2 net132 C net128 VSS g45n1svt m=1 l=45n w=520n
Mmn4 Y net116 VSS VSS g45n1svt m=1 l=45n w=2.065u
Mmn1 net128 B net124 VSS g45n1svt m=1 l=45n w=520n
Mmn0 net124 A VSS VSS g45n1svt m=1 l=45n w=520n
Mmp3 net116 D VDD NW g45p1svt m=1 l=45n w=780n
Mmp2 net116 C VDD NW g45p1svt m=1 l=45n w=780n
Mmp1 net116 B VDD NW g45p1svt m=1 l=45n w=780n
Mmp4 Y net116 VDD NW g45p1svt m=1 l=45n w=3.115u
Mmp0 net116 A VDD NW g45p1svt m=1 l=45n w=780n
.ENDS

.SUBCKT AND4XL A B C D NW VDD VSS Y
*.PININFO A:I B:I C:I D:I NW:I VDD:I VSS:I Y:O
Mmn3 net100 D net136 VSS g45n1svt m=1 l=45n w=145n
Mmn2 net136 C net128 VSS g45n1svt m=1 l=45n w=145n
Mmn4 Y net100 VSS VSS g45n1svt m=1 l=45n w=145n
Mmn1 net128 B net124 VSS g45n1svt m=1 l=45n w=145n
Mmn0 net124 A VSS VSS g45n1svt m=1 l=45n w=145n
Mmp3 net100 D VDD NW g45p1svt m=1 l=45n w=215n
Mmp2 net100 C VDD NW g45p1svt m=1 l=45n w=215n
Mmp1 net100 B VDD NW g45p1svt m=1 l=45n w=215n
Mmp4 Y net100 VDD NW g45p1svt m=1 l=45n w=215n
Mmp0 net100 A VDD NW g45p1svt m=1 l=45n w=215n
.ENDS

.SUBCKT ANTENNA A VDD VSS
*.PININFO A:I VDD:I VSS:I
DD1 A VDD g45pd1svt 188.8f 1.82u m=1
DD0 VSS A g45nd1svt 155.1f 1.6u m=1
.ENDS

.SUBCKT AO21X1 A0 A1 B0 NW VDD VSS Y
*.PININFO A0:I A1:I B0:I NW:I VDD:I VSS:I Y:O
Mmn1 net049 A1 net104 VSS g45n1svt m=1 l=45n w=145n
Mmn0 net104 A0 VSS VSS g45n1svt m=1 l=45n w=145n
Mmn3 Y net049 VSS VSS g45n1svt m=1 l=45n w=260n
Mmn2 net049 B0 VSS VSS g45n1svt m=1 l=45n w=145n
Mmp1 net96 A1 VDD NW g45p1svt m=1 l=45n w=215n
Mmp0 net96 A0 VDD NW g45p1svt m=1 l=45n w=215n
Mmp3 Y net049 VDD NW g45p1svt m=1 l=45n w=390n
Mmp2 net049 B0 net96 NW g45p1svt m=1 l=45n w=215n
.ENDS

.SUBCKT AO21X2 A0 A1 B0 NW VDD VSS Y
*.PININFO A0:I A1:I B0:I NW:I VDD:I VSS:I Y:O
Mmn1 net100 A1 net104 VSS g45n1svt m=1 l=45n w=145n
Mmn0 net104 A0 VSS VSS g45n1svt m=1 l=45n w=145n
Mmn3 Y net100 VSS VSS g45n1svt m=1 l=45n w=520n
Mmn2 net100 B0 VSS VSS g45n1svt m=1 l=45n w=145n
Mmp1 net84 A1 VDD NW g45p1svt m=1 l=45n w=215n
Mmp0 net84 A0 VDD NW g45p1svt m=1 l=45n w=215n
Mmp3 Y net100 VDD NW g45p1svt m=1 l=45n w=780n
Mmp2 net100 B0 net84 NW g45p1svt m=1 l=45n w=215n
.ENDS

.SUBCKT AO21X4 A0 A1 B0 NW VDD VSS Y
*.PININFO A0:I A1:I B0:I NW:I VDD:I VSS:I Y:O
Mmn1 net100 A1 net104 VSS g45n1svt m=1 l=45n w=260n
Mmn0 net104 A0 VSS VSS g45n1svt m=1 l=45n w=260n
Mmn3 Y net100 VSS VSS g45n1svt m=1 l=45n w=1.04u
Mmn2 net100 B0 VSS VSS g45n1svt m=1 l=45n w=260n
Mmp1 net88 A1 VDD NW g45p1svt m=1 l=45n w=390n
Mmp0 net88 A0 VDD NW g45p1svt m=1 l=45n w=390n
Mmp3 Y net100 VDD NW g45p1svt m=1 l=45n w=1.56u
Mmp2 net100 B0 net88 NW g45p1svt m=1 l=45n w=390n
.ENDS

.SUBCKT AO21XL A0 A1 B0 NW VDD VSS Y
*.PININFO A0:I A1:I B0:I NW:I VDD:I VSS:I Y:O
Mmn1 n0 A1 n1 VSS g45n1svt m=1 l=45n w=145n
Mmn0 n1 A0 VSS VSS g45n1svt m=1 l=45n w=145n
Mmn3 Y n0 VSS VSS g45n1svt m=1 l=45n w=145n
Mmn2 n0 B0 VSS VSS g45n1svt m=1 l=45n w=145n
Mmp1 n2 A1 VDD NW g45p1svt m=1 l=45n w=215n
Mmp0 n2 A0 VDD NW g45p1svt m=1 l=45n w=215n
Mmp3 Y n0 VDD NW g45p1svt m=1 l=45n w=215n
Mmp2 n0 B0 n2 NW g45p1svt m=1 l=45n w=215n
.ENDS

.SUBCKT AO22X1 A0 A1 B0 B1 NW VDD VSS Y
*.PININFO A0:I A1:I B0:I B1:I NW:I VDD:I VSS:I Y:O
Mmn3 n0 B1 n2 VSS g45n1svt m=1 l=45n w=145n
Mmn2 n2 B0 VSS VSS g45n1svt m=1 l=45n w=145n
Mmn1 n0 A1 n1 VSS g45n1svt m=1 l=45n w=145n
Mmn0 n1 A0 VSS VSS g45n1svt m=1 l=45n w=145n
Mmn4 Y n0 VSS VSS g45n1svt m=1 l=45n w=260n
Mmp3 n0 B1 n3 NW g45p1svt m=1 l=45n w=215n
Mmp2 n0 B0 n3 NW g45p1svt m=1 l=45n w=215n
Mmp1 n3 A1 VDD NW g45p1svt m=1 l=45n w=215n
Mmp0 n3 A0 VDD NW g45p1svt m=1 l=45n w=215n
Mmp4 Y n0 VDD NW g45p1svt m=1 l=45n w=390n
.ENDS

.SUBCKT AO22X2 A0 A1 B0 B1 NW VDD VSS Y
*.PININFO A0:I A1:I B0:I B1:I NW:I VDD:I VSS:I Y:O
Mmn3 net128 B1 net132 VSS g45n1svt m=1 l=45n w=145n
Mmn2 net132 B0 VSS VSS g45n1svt m=1 l=45n w=145n
Mmn1 net128 A1 net124 VSS g45n1svt m=1 l=45n w=145n
Mmn0 net124 A0 VSS VSS g45n1svt m=1 l=45n w=145n
Mmn4 Y net128 VSS VSS g45n1svt m=1 l=45n w=520n
Mmp3 net128 B1 net111 NW g45p1svt m=1 l=45n w=215n
Mmp2 net128 B0 net111 NW g45p1svt m=1 l=45n w=215n
Mmp1 net111 A1 VDD NW g45p1svt m=1 l=45n w=215n
Mmp0 net111 A0 VDD NW g45p1svt m=1 l=45n w=215n
Mmp4 Y net128 VDD NW g45p1svt m=1 l=45n w=780n
.ENDS

.SUBCKT AO22X4 A0 A1 B0 B1 NW VDD VSS Y
*.PININFO A0:I A1:I B0:I B1:I NW:I VDD:I VSS:I Y:O
Mmn3 n0 B1 n2 VSS g45n1svt m=1 l=45n w=260n
Mmn2 n2 B0 VSS VSS g45n1svt m=1 l=45n w=260n
Mmn1 n0 A1 n1 VSS g45n1svt m=1 l=45n w=260n
Mmn0 n1 A0 VSS VSS g45n1svt m=1 l=45n w=260n
Mmn4 Y n0 VSS VSS g45n1svt m=1 l=45n w=1.04u
Mmp3 n0 B1 n3 NW g45p1svt m=1 l=45n w=390n
Mmp2 n0 B0 n3 NW g45p1svt m=1 l=45n w=390n
Mmp1 n3 A1 VDD NW g45p1svt m=1 l=45n w=390n
Mmp0 n3 A0 VDD NW g45p1svt m=1 l=45n w=390n
Mmp4 Y n0 VDD NW g45p1svt m=1 l=45n w=1.56u
.ENDS

.SUBCKT AO22XL A0 A1 B0 B1 NW VDD VSS Y
*.PININFO A0:I A1:I B0:I B1:I NW:I VDD:I VSS:I Y:O
Mmn3 n0 B1 n2 VSS g45n1svt m=1 l=45n w=145n
Mmn2 n2 B0 VSS VSS g45n1svt m=1 l=45n w=145n
Mmn1 n0 A1 n1 VSS g45n1svt m=1 l=45n w=145n
Mmn0 n1 A0 VSS VSS g45n1svt m=1 l=45n w=145n
Mmn4 Y n0 VSS VSS g45n1svt m=1 l=45n w=145n
Mmp3 n0 B1 n3 NW g45p1svt m=1 l=45n w=215n
Mmp2 n0 B0 n3 NW g45p1svt m=1 l=45n w=215n
Mmp1 n3 A1 VDD NW g45p1svt m=1 l=45n w=215n
Mmp0 n3 A0 VDD NW g45p1svt m=1 l=45n w=215n
Mmp4 Y n0 VDD NW g45p1svt m=1 l=45n w=215n
.ENDS

.SUBCKT AOI211X1 A0 A1 B0 C0 NW VDD VSS Y
*.PININFO A0:I A1:I B0:I C0:I NW:I VDD:I VSS:I Y:O
Mmn2 Y B0 VSS VSS g45n1svt m=1 l=45n w=260n
Mmn3 Y C0 VSS VSS g45n1svt m=1 l=45n w=260n
Mmn1 Y A1 net95 VSS g45n1svt m=1 l=45n w=260n
Mmn0 net95 A0 VSS VSS g45n1svt m=1 l=45n w=260n
Mmp3 Y C0 net82 NW g45p1svt m=1 l=45n w=390n
Mmp2 net82 B0 net91 NW g45p1svt m=1 l=45n w=390n
Mmp1 net91 A1 VDD NW g45p1svt m=1 l=45n w=390n
Mmp0 net91 A0 VDD NW g45p1svt m=1 l=45n w=390n
.ENDS

.SUBCKT AOI211X2 A0 A1 B0 C0 NW VDD VSS Y
*.PININFO A0:I A1:I B0:I C0:I NW:I VDD:I VSS:I Y:O
Mmn2 Y B0 VSS VSS g45n1svt m=1 l=45n w=520n
Mmn3 Y C0 VSS VSS g45n1svt m=1 l=45n w=520n
Mmn1 Y A1 net95 VSS g45n1svt m=1 l=45n w=520n
Mmn0 net95 A0 VSS VSS g45n1svt m=1 l=45n w=520n
Mmp3 Y C0 net82 NW g45p1svt m=1 l=45n w=780n
Mmp2 net82 B0 net91 NW g45p1svt m=1 l=45n w=780n
Mmp1 net91 A1 VDD NW g45p1svt m=1 l=45n w=780n
Mmp0 net91 A0 VDD NW g45p1svt m=1 l=45n w=780n
.ENDS

.SUBCKT AOI211X4 A0 A1 B0 C0 NW VDD VSS Y
*.PININFO A0:I A1:I B0:I C0:I NW:I VDD:I VSS:I Y:O
Mmn2 Y B0 VSS VSS g45n1svt m=1 l=45n w=1.04u
Mmn3 Y C0 VSS VSS g45n1svt m=1 l=45n w=1.04u
Mmn1 Y A1 net99 VSS g45n1svt m=1 l=45n w=1.04u
Mmn0 net99 A0 VSS VSS g45n1svt m=1 l=45n w=1.04u
Mmp3 Y C0 net82 NW g45p1svt m=1 l=45n w=1.56u
Mmp2 net82 B0 net91 NW g45p1svt m=1 l=45n w=1.56u
Mmp1 net91 A1 VDD NW g45p1svt m=1 l=45n w=1.56u
Mmp0 net91 A0 VDD NW g45p1svt m=1 l=45n w=1.56u
.ENDS

.SUBCKT AOI211XL A0 A1 B0 C0 NW VDD VSS Y
*.PININFO A0:I A1:I B0:I C0:I NW:I VDD:I VSS:I Y:O
Mmn2 Y B0 VSS VSS g45n1svt m=1 l=45n w=145n
Mmn3 Y C0 VSS VSS g45n1svt m=1 l=45n w=145n
Mmn1 Y A1 net95 VSS g45n1svt m=1 l=45n w=145n
Mmn0 net95 A0 VSS VSS g45n1svt m=1 l=45n w=145n
Mmp3 Y C0 net82 NW g45p1svt m=1 l=45n w=215n
Mmp2 net82 B0 net91 NW g45p1svt m=1 l=45n w=215n
Mmp1 net91 A1 VDD NW g45p1svt m=1 l=45n w=215n
Mmp0 net91 A0 VDD NW g45p1svt m=1 l=45n w=215n
.ENDS

.SUBCKT AOI21X1 A0 A1 B0 NW VDD VSS Y
*.PININFO A0:I A1:I B0:I NW:I VDD:I VSS:I Y:O
Mmn2 Y B0 VSS VSS g45n1svt m=1 l=45n w=260n
Mmn0 net78 A0 VSS VSS g45n1svt m=1 l=45n w=260n
Mmn1 Y A1 net78 VSS g45n1svt m=1 l=45n w=260n
Mmp2 Y B0 net62 NW g45p1svt m=1 l=45n w=390n
Mmp1 net62 A1 VDD NW g45p1svt m=1 l=45n w=390n
Mmp0 net62 A0 VDD NW g45p1svt m=1 l=45n w=390n
.ENDS

.SUBCKT AOI21X2 A0 A1 B0 NW VDD VSS Y
*.PININFO A0:I A1:I B0:I NW:I VDD:I VSS:I Y:O
Mmn2 Y B0 VSS VSS g45n1svt m=1 l=45n w=520n
Mmn0 net74 A0 VSS VSS g45n1svt m=1 l=45n w=520n
Mmn1 Y A1 net74 VSS g45n1svt m=1 l=45n w=520n
Mmp2 Y B0 net70 NW g45p1svt m=1 l=45n w=780n
Mmp1 net70 A1 VDD NW g45p1svt m=1 l=45n w=780n
Mmp0 net70 A0 VDD NW g45p1svt m=1 l=45n w=780n
.ENDS

.SUBCKT AOI21X4 A0 A1 B0 NW VDD VSS Y
*.PININFO A0:I A1:I B0:I NW:I VDD:I VSS:I Y:O
Mmn2 Y B0 VSS VSS g45n1svt m=1 l=45n w=1.04u
Mmn0 net82 A0 VSS VSS g45n1svt m=1 l=45n w=1.04u
Mmn1 Y A1 net82 VSS g45n1svt m=1 l=45n w=1.04u
Mmp2 Y B0 net70 NW g45p1svt m=1 l=45n w=1.56u
Mmp1 net70 A1 VDD NW g45p1svt m=1 l=45n w=1.56u
Mmp0 net70 A0 VDD NW g45p1svt m=1 l=45n w=1.56u
.ENDS

.SUBCKT AOI21XL A0 A1 B0 NW VDD VSS Y
*.PININFO A0:I A1:I B0:I NW:I VDD:I VSS:I Y:O
Mmn2 Y B0 VSS VSS g45n1svt m=1 l=45n w=145n
Mmn0 net74 A0 VSS VSS g45n1svt m=1 l=45n w=145n
Mmn1 Y A1 net74 VSS g45n1svt m=1 l=45n w=145n
Mmp2 Y B0 net70 NW g45p1svt m=1 l=45n w=215n
Mmp1 net70 A1 VDD NW g45p1svt m=1 l=45n w=215n
Mmp0 net70 A0 VDD NW g45p1svt m=1 l=45n w=215n
.ENDS

.SUBCKT AOI221X1 A0 A1 B0 B1 C0 NW VDD VSS Y
*.PININFO A0:I A1:I B0:I B1:I C0:I NW:I VDD:I VSS:I Y:O
Mmn2 net120 B0 VSS VSS g45n1svt m=1 l=45n w=260n
Mmn3 Y B1 net120 VSS g45n1svt m=1 l=45n w=260n
Mmn4 Y C0 VSS VSS g45n1svt m=1 l=45n w=260n
Mmn1 Y A1 net128 VSS g45n1svt m=1 l=45n w=260n
Mmn0 net128 A0 VSS VSS g45n1svt m=1 l=45n w=260n
Mmp3 net108 B1 net111 NW g45p1svt m=1 l=45n w=390n
Mmp2 net108 B0 net111 NW g45p1svt m=1 l=45n w=390n
Mmp0 net111 A0 VDD NW g45p1svt m=1 l=45n w=390n
Mmp1 net111 A1 VDD NW g45p1svt m=1 l=45n w=390n
Mmp4 Y C0 net108 NW g45p1svt m=1 l=45n w=390n
.ENDS

.SUBCKT AOI221X2 A0 A1 B0 B1 C0 NW VDD VSS Y
*.PININFO A0:I A1:I B0:I B1:I C0:I NW:I VDD:I VSS:I Y:O
Mmn2 Y B0 net116 VSS g45n1svt m=1 l=45n w=520n
Mmn3 net116 B1 VSS VSS g45n1svt m=1 l=45n w=520n
Mmn4 Y C0 VSS VSS g45n1svt m=1 l=45n w=520n
Mmn1 Y A1 net124 VSS g45n1svt m=1 l=45n w=520n
Mmn0 net124 A0 VSS VSS g45n1svt m=1 l=45n w=520n
Mmp3 net104 B1 net103 NW g45p1svt m=1 l=45n w=780n
Mmp2 net104 B0 net103 NW g45p1svt m=1 l=45n w=780n
Mmp0 net103 A0 VDD NW g45p1svt m=1 l=45n w=780n
Mmp1 net103 A1 VDD NW g45p1svt m=1 l=45n w=780n
Mmp4 Y C0 net104 NW g45p1svt m=1 l=45n w=780n
.ENDS

.SUBCKT AOI221X4 A0 A1 B0 B1 C0 NW VDD VSS Y
*.PININFO A0:I A1:I B0:I B1:I C0:I NW:I VDD:I VSS:I Y:O
Mmn2 net116 B0 VSS VSS g45n1svt m=1 l=45n w=1.04u
Mmn3 Y B1 net116 VSS g45n1svt m=1 l=45n w=1.04u
Mmn4 Y C0 VSS VSS g45n1svt m=1 l=45n w=1.04u
Mmn1 Y A1 net120 VSS g45n1svt m=1 l=45n w=1.04u
Mmn0 net120 A0 VSS VSS g45n1svt m=1 l=45n w=1.04u
Mmp3 net104 B1 net107 NW g45p1svt m=1 l=45n w=1.56u
Mmp2 net104 B0 net107 NW g45p1svt m=1 l=45n w=1.56u
Mmp0 net107 A0 VDD NW g45p1svt m=1 l=45n w=1.56u
Mmp1 net107 A1 VDD NW g45p1svt m=1 l=45n w=1.56u
Mmp4 Y C0 net104 NW g45p1svt m=1 l=45n w=1.56u
.ENDS

.SUBCKT AOI221XL A0 A1 B0 B1 C0 NW VDD VSS Y
*.PININFO A0:I A1:I B0:I B1:I C0:I NW:I VDD:I VSS:I Y:O
Mmn2 net116 B0 VSS VSS g45n1svt m=1 l=45n w=145n
Mmn3 Y B1 net116 VSS g45n1svt m=1 l=45n w=145n
Mmn4 Y C0 VSS VSS g45n1svt m=1 l=45n w=145n
Mmn1 Y A1 net124 VSS g45n1svt m=1 l=45n w=145n
Mmn0 net124 A0 VSS VSS g45n1svt m=1 l=45n w=145n
Mmp3 net104 B1 net107 NW g45p1svt m=1 l=45n w=215n
Mmp2 net104 B0 net107 NW g45p1svt m=1 l=45n w=215n
Mmp0 net107 A0 VDD NW g45p1svt m=1 l=45n w=215n
Mmp1 net107 A1 VDD NW g45p1svt m=1 l=45n w=215n
Mmp4 Y C0 net104 NW g45p1svt m=1 l=45n w=215n
.ENDS

.SUBCKT AOI222X1 A0 A1 B0 B1 C0 C1 NW VDD VSS Y
*.PININFO A0:I A1:I B0:I B1:I C0:I C1:I NW:I VDD:I VSS:I Y:O
Mmn5 Y C1 net155 VSS g45n1svt m=1 l=45n w=260n
Mmn4 net155 C0 VSS VSS g45n1svt m=1 l=45n w=260n
Mmn2 net147 B0 VSS VSS g45n1svt m=1 l=45n w=260n
Mmn0 net139 A0 VSS VSS g45n1svt m=1 l=45n w=260n
Mmn1 Y A1 net139 VSS g45n1svt m=1 l=45n w=260n
Mmn3 Y B1 net147 VSS g45n1svt m=1 l=45n w=260n
Mmp5 Y C1 net118 NW g45p1svt m=1 l=45n w=390n
Mmp4 Y C0 net118 NW g45p1svt m=1 l=45n w=390n
Mmp3 net118 B1 net122 NW g45p1svt m=1 l=45n w=390n
Mmp2 net118 B0 net122 NW g45p1svt m=1 l=45n w=390n
Mmp0 net122 A0 VDD NW g45p1svt m=1 l=45n w=390n
Mmp1 net122 A1 VDD NW g45p1svt m=1 l=45n w=390n
.ENDS

.SUBCKT AOI222X2 A0 A1 B0 B1 C0 C1 NW VDD VSS Y
*.PININFO A0:I A1:I B0:I B1:I C0:I C1:I NW:I VDD:I VSS:I Y:O
Mmn5 Y C1 net155 VSS g45n1svt m=1 l=45n w=520n
Mmn4 net155 C0 VSS VSS g45n1svt m=1 l=45n w=520n
Mmn2 net151 B0 VSS VSS g45n1svt m=1 l=45n w=520n
Mmn0 net147 A0 VSS VSS g45n1svt m=1 l=45n w=520n
Mmn1 Y A1 net147 VSS g45n1svt m=1 l=45n w=520n
Mmn3 Y B1 net151 VSS g45n1svt m=1 l=45n w=520n
Mmp5 Y C1 net134 NW g45p1svt m=1 l=45n w=780n
Mmp4 Y C0 net134 NW g45p1svt m=1 l=45n w=780n
Mmp3 net134 B1 net126 NW g45p1svt m=1 l=45n w=780n
Mmp2 net134 B0 net126 NW g45p1svt m=1 l=45n w=780n
Mmp0 net126 A0 VDD NW g45p1svt m=1 l=45n w=780n
Mmp1 net126 A1 VDD NW g45p1svt m=1 l=45n w=780n
.ENDS

.SUBCKT AOI222X4 A0 A1 B0 B1 C0 C1 NW VDD VSS Y
*.PININFO A0:I A1:I B0:I B1:I C0:I C1:I NW:I VDD:I VSS:I Y:O
Mmn5 Y C1 net139 VSS g45n1svt m=1 l=45n w=1.04u
Mmn4 net139 C0 VSS VSS g45n1svt m=1 l=45n w=1.04u
Mmn2 net143 B0 VSS VSS g45n1svt m=1 l=45n w=1.04u
Mmn0 net147 A0 VSS VSS g45n1svt m=1 l=45n w=1.04u
Mmn1 Y A1 net147 VSS g45n1svt m=1 l=45n w=1.04u
Mmn3 Y B1 net143 VSS g45n1svt m=1 l=45n w=1.04u
Mmp5 Y C1 net122 NW g45p1svt m=1 l=45n w=1.56u
Mmp4 Y C0 net122 NW g45p1svt m=1 l=45n w=1.56u
Mmp3 net122 B1 net130 NW g45p1svt m=1 l=45n w=1.56u
Mmp2 net122 B0 net130 NW g45p1svt m=1 l=45n w=1.56u
Mmp0 net130 A0 VDD NW g45p1svt m=1 l=45n w=1.56u
Mmp1 net130 A1 VDD NW g45p1svt m=1 l=45n w=1.56u
.ENDS

.SUBCKT AOI222XL A0 A1 B0 B1 C0 C1 NW VDD VSS Y
*.PININFO A0:I A1:I B0:I B1:I C0:I C1:I NW:I VDD:I VSS:I Y:O
Mmn5 Y C1 net155 VSS g45n1svt m=1 l=45n w=145n
Mmn4 net155 C0 VSS VSS g45n1svt m=1 l=45n w=145n
Mmn2 net147 B0 VSS VSS g45n1svt m=1 l=45n w=145n
Mmn0 net139 A0 VSS VSS g45n1svt m=1 l=45n w=145n
Mmn1 Y A1 net139 VSS g45n1svt m=1 l=45n w=145n
Mmn3 Y B1 net147 VSS g45n1svt m=1 l=45n w=145n
Mmp5 Y C1 net122 NW g45p1svt m=1 l=45n w=215n
Mmp4 Y C0 net122 NW g45p1svt m=1 l=45n w=215n
Mmp3 net122 B1 net134 NW g45p1svt m=1 l=45n w=215n
Mmp2 net122 B0 net134 NW g45p1svt m=1 l=45n w=215n
Mmp0 net134 A0 VDD NW g45p1svt m=1 l=45n w=215n
Mmp1 net134 A1 VDD NW g45p1svt m=1 l=45n w=215n
.ENDS

.SUBCKT AOI22X1 A0 A1 B0 B1 NW VDD VSS Y
*.PININFO A0:I A1:I B0:I B1:I NW:I VDD:I VSS:I Y:O
Mmn3 Y B1 net98 VSS g45n1svt m=1 l=45n w=260n
Mmn0 net102 A0 VSS VSS g45n1svt m=1 l=45n w=260n
Mmn2 net98 B0 VSS VSS g45n1svt m=1 l=45n w=260n
Mmn1 Y A1 net102 VSS g45n1svt m=1 l=45n w=260n
Mmp3 Y B1 net89 NW g45p1svt m=1 l=45n w=390n
Mmp0 net89 A0 VDD NW g45p1svt m=1 l=45n w=390n
Mmp1 net89 A1 VDD NW g45p1svt m=1 l=45n w=390n
Mmp2 Y B0 net89 NW g45p1svt m=1 l=45n w=390n
.ENDS

.SUBCKT AOI22X2 A0 A1 B0 B1 NW VDD VSS Y
*.PININFO A0:I A1:I B0:I B1:I NW:I VDD:I VSS:I Y:O
Mmn3 Y B1 net106 VSS g45n1svt m=1 l=45n w=520n
Mmn0 net98 A0 VSS VSS g45n1svt m=1 l=45n w=520n
Mmn2 net106 B0 VSS VSS g45n1svt m=1 l=45n w=520n
Mmn1 Y A1 net98 VSS g45n1svt m=1 l=45n w=520n
Mmp3 Y B1 net89 NW g45p1svt m=1 l=45n w=780n
Mmp0 net89 A0 VDD NW g45p1svt m=1 l=45n w=780n
Mmp1 net89 A1 VDD NW g45p1svt m=1 l=45n w=780n
Mmp2 Y B0 net89 NW g45p1svt m=1 l=45n w=780n
.ENDS

.SUBCKT AOI22X4 A0 A1 B0 B1 NW VDD VSS Y
*.PININFO A0:I A1:I B0:I B1:I NW:I VDD:I VSS:I Y:O
Mmn3 Y B1 net102 VSS g45n1svt m=1 l=45n w=1.04u
Mmn0 net98 A0 VSS VSS g45n1svt m=1 l=45n w=1.04u
Mmn2 net102 B0 VSS VSS g45n1svt m=1 l=45n w=1.04u
Mmn1 Y A1 net98 VSS g45n1svt m=1 l=45n w=1.04u
Mmp3 Y B1 net89 NW g45p1svt m=1 l=45n w=1.56u
Mmp0 net89 A0 VDD NW g45p1svt m=1 l=45n w=1.56u
Mmp1 net89 A1 VDD NW g45p1svt m=1 l=45n w=1.56u
Mmp2 Y B0 net89 NW g45p1svt m=1 l=45n w=1.56u
.ENDS

.SUBCKT AOI22XL A0 A1 B0 B1 NW VDD VSS Y
*.PININFO A0:I A1:I B0:I B1:I NW:I VDD:I VSS:I Y:O
Mmn3 Y B1 net98 VSS g45n1svt m=1 l=45n w=145n
Mmn0 net106 A0 VSS VSS g45n1svt m=1 l=45n w=145n
Mmn2 net98 B0 VSS VSS g45n1svt m=1 l=45n w=145n
Mmn1 Y A1 net106 VSS g45n1svt m=1 l=45n w=145n
Mmp3 Y B1 net89 NW g45p1svt m=1 l=45n w=215n
Mmp0 net89 A0 VDD NW g45p1svt m=1 l=45n w=215n
Mmp1 net89 A1 VDD NW g45p1svt m=1 l=45n w=215n
Mmp2 Y B0 net89 NW g45p1svt m=1 l=45n w=215n
.ENDS

.SUBCKT AOI2BB1X1 A0N A1N B0 NW VDD VSS Y
*.PININFO A0N:I A1N:I B0:I NW:I VDD:I VSS:I Y:O
Mmn2 Y B0 VSS VSS g45n1svt m=1 l=45n w=260n
Mmn1 n0 A1N VSS VSS g45n1svt m=1 l=45n w=145n
Mmn3 Y n0 VSS VSS g45n1svt m=1 l=45n w=260n
Mmn0 n0 A0N VSS VSS g45n1svt m=1 l=45n w=145n
Mmp3 Y n0 n2 NW g45p1svt m=1 l=45n w=390n
Mmp2 n2 B0 VDD NW g45p1svt m=1 l=45n w=390n
Mmp1 n0 A1N n1 NW g45p1svt m=1 l=45n w=215n
Mmp0 n1 A0N VDD NW g45p1svt m=1 l=45n w=215n
.ENDS

.SUBCKT AOI2BB1X2 A0N A1N B0 NW VDD VSS Y
*.PININFO A0N:I A1N:I B0:I NW:I VDD:I VSS:I Y:O
Mmn2 Y B0 VSS VSS g45n1svt m=1 l=45n w=520n
Mmn1 net104 A1N VSS VSS g45n1svt m=1 l=45n w=145n
Mmn3 Y net104 VSS VSS g45n1svt m=1 l=45n w=520n
Mmn0 net104 A0N VSS VSS g45n1svt m=1 l=45n w=145n
Mmp3 Y net104 net79 NW g45p1svt m=1 l=45n w=780n
Mmp2 net79 B0 VDD NW g45p1svt m=1 l=45n w=780n
Mmp1 net104 A1N net87 NW g45p1svt m=1 l=45n w=215n
Mmp0 net87 A0N VDD NW g45p1svt m=1 l=45n w=215n
.ENDS

.SUBCKT AOI2BB1X4 A0N A1N B0 NW VDD VSS Y
*.PININFO A0N:I A1N:I B0:I NW:I VDD:I VSS:I Y:O
Mmn2 Y B0 VSS VSS g45n1svt m=1 l=45n w=1.04u
Mmn1 net104 A1N VSS VSS g45n1svt m=1 l=45n w=260n
Mmn3 Y net104 VSS VSS g45n1svt m=1 l=45n w=1.04u
Mmn0 net104 A0N VSS VSS g45n1svt m=1 l=45n w=260n
Mmp3 Y net104 net79 NW g45p1svt m=1 l=45n w=1.56u
Mmp2 net79 B0 VDD NW g45p1svt m=1 l=45n w=1.56u
Mmp1 net104 A1N net87 NW g45p1svt m=1 l=45n w=390n
Mmp0 net87 A0N VDD NW g45p1svt m=1 l=45n w=390n
.ENDS

.SUBCKT AOI2BB1XL A0N A1N B0 NW VDD VSS Y
*.PININFO A0N:I A1N:I B0:I NW:I VDD:I VSS:I Y:O
Mmn2 Y B0 VSS VSS g45n1svt m=1 l=45n w=145n
Mmn1 net100 A1N VSS VSS g45n1svt m=1 l=45n w=145n
Mmn3 Y net100 VSS VSS g45n1svt m=1 l=45n w=145n
Mmn0 net100 A0N VSS VSS g45n1svt m=1 l=45n w=145n
Mmp3 Y net100 net79 NW g45p1svt m=1 l=45n w=215n
Mmp2 net79 B0 VDD NW g45p1svt m=1 l=45n w=215n
Mmp1 net100 A1N net87 NW g45p1svt m=1 l=45n w=215n
Mmp0 net87 A0N VDD NW g45p1svt m=1 l=45n w=215n
.ENDS

.SUBCKT AOI2BB2X1 A0N A1N B0 B1 NW VDD VSS Y
*.PININFO A0N:I A1N:I B0:I B1:I NW:I VDD:I VSS:I Y:O
Mmn5 n3 B1 VSS VSS g45n1svt m=1 l=45n w=260n
Mmn4 Y B0 n3 VSS g45n1svt m=1 l=45n w=260n
Mmn3 Y n1 n2 VSS g45n1svt m=1 l=45n w=260n
Mmn2 n2 n0 VSS VSS g45n1svt m=1 l=45n w=260n
Mmn0 n0 A0N VSS VSS g45n1svt m=1 l=45n w=145n
Mmn1 n1 A1N VSS VSS g45n1svt m=1 l=45n w=145n
Mmp5 Y B1 n4 NW g45p1svt m=1 l=45n w=390n
Mmp4 Y B0 n4 NW g45p1svt m=1 l=45n w=390n
Mmp2 n4 n0 VDD NW g45p1svt m=1 l=45n w=390n
Mmp0 n0 A0N VDD NW g45p1svt m=1 l=45n w=215n
Mmp1 n1 A1N VDD NW g45p1svt m=1 l=45n w=215n
Mmp3 n4 n1 VDD NW g45p1svt m=1 l=45n w=390n
.ENDS

.SUBCKT AOI2BB2X2 A0N A1N B0 B1 NW VDD VSS Y
*.PININFO A0N:I A1N:I B0:I B1:I NW:I VDD:I VSS:I Y:O
Mmn5 n3 B1 VSS VSS g45n1svt m=1 l=45n w=520n
Mmn4 Y B0 n3 VSS g45n1svt m=1 l=45n w=520n
Mmn3 Y n1 n2 VSS g45n1svt m=1 l=45n w=520n
Mmn2 n2 n0 VSS VSS g45n1svt m=1 l=45n w=520n
Mmn0 n0 A0N VSS VSS g45n1svt m=1 l=45n w=145n
Mmn1 n1 A1N VSS VSS g45n1svt m=1 l=45n w=145n
Mmp5 Y B1 n4 NW g45p1svt m=1 l=45n w=780n
Mmp4 Y B0 n4 NW g45p1svt m=1 l=45n w=780n
Mmp2 n4 n0 VDD NW g45p1svt m=1 l=45n w=780n
Mmp0 n0 A0N VDD NW g45p1svt m=1 l=45n w=215n
Mmp1 n1 A1N VDD NW g45p1svt m=1 l=45n w=215n
Mmp3 n4 n1 VDD NW g45p1svt m=1 l=45n w=780n
.ENDS

.SUBCKT AOI2BB2X4 A0N A1N B0 B1 NW VDD VSS Y
*.PININFO A0N:I A1N:I B0:I B1:I NW:I VDD:I VSS:I Y:O
Mmn5 net152 B1 VSS VSS g45n1svt m=1 l=45n w=1.04u
Mmn4 Y B0 net152 VSS g45n1svt m=1 l=45n w=1.04u
Mmn3 Y net144 net160 VSS g45n1svt m=1 l=45n w=1.04u
Mmn2 net160 net148 VSS VSS g45n1svt m=1 l=45n w=1.04u
Mmn0 net148 A0N VSS VSS g45n1svt m=1 l=45n w=260n
Mmn1 net144 A1N VSS VSS g45n1svt m=1 l=45n w=260n
Mmp5 Y B1 net127 NW g45p1svt m=1 l=45n w=1.56u
Mmp4 Y B0 net127 NW g45p1svt m=1 l=45n w=1.56u
Mmp2 net127 net148 VDD NW g45p1svt m=1 l=45n w=1.56u
Mmp0 net148 A0N VDD NW g45p1svt m=1 l=45n w=390n
Mmp1 net144 A1N VDD NW g45p1svt m=1 l=45n w=390n
Mmp3 net127 net144 VDD NW g45p1svt m=1 l=45n w=1.56u
.ENDS

.SUBCKT AOI2BB2XL A0N A1N B0 B1 NW VDD VSS Y
*.PININFO A0N:I A1N:I B0:I B1:I NW:I VDD:I VSS:I Y:O
Mmn5 net156 B1 VSS VSS g45n1svt m=1 l=45n w=145n
Mmn4 Y B0 net156 VSS g45n1svt m=1 l=45n w=145n
Mmn3 Y net164 net144 VSS g45n1svt m=1 l=45n w=145n
Mmn2 net144 net146 VSS VSS g45n1svt m=1 l=45n w=145n
Mmn0 net146 A0N VSS VSS g45n1svt m=1 l=45n w=145n
Mmn1 net164 A1N VSS VSS g45n1svt m=1 l=45n w=145n
Mmp5 Y B1 net124 NW g45p1svt m=1 l=45n w=215n
Mmp4 Y B0 net124 NW g45p1svt m=1 l=45n w=215n
Mmp2 net124 net146 VDD NW g45p1svt m=1 l=45n w=215n
Mmp0 net146 A0N VDD NW g45p1svt m=1 l=45n w=215n
Mmp1 net164 A1N VDD NW g45p1svt m=1 l=45n w=215n
Mmp3 net124 net164 VDD NW g45p1svt m=1 l=45n w=215n
.ENDS

.SUBCKT AOI31X1 A0 A1 A2 B0 NW VDD VSS Y
*.PININFO A0:I A1:I A2:I B0:I NW:I VDD:I VSS:I Y:O
Mmn3 Y B0 VSS VSS g45n1svt m=1 l=45n w=260n
Mmn1 net97 A1 net93 VSS g45n1svt m=1 l=45n w=260n
Mmn2 Y A2 net97 VSS g45n1svt m=1 l=45n w=260n
Mmn0 net93 A0 VSS VSS g45n1svt m=1 l=45n w=260n
Mmp2 net81 A2 VDD NW g45p1svt m=1 l=45n w=390n
Mmp3 Y B0 net81 NW g45p1svt m=1 l=45n w=390n
Mmp1 net81 A1 VDD NW g45p1svt m=1 l=45n w=390n
Mmp0 net81 A0 VDD NW g45p1svt m=1 l=45n w=390n
.ENDS

.SUBCKT AOI31X2 A0 A1 A2 B0 NW VDD VSS Y
*.PININFO A0:I A1:I A2:I B0:I NW:I VDD:I VSS:I Y:O
Mmn3 Y B0 VSS VSS g45n1svt m=1 l=45n w=520n
Mmn1 net100 A1 net104 VSS g45n1svt m=1 l=45n w=520n
Mmn2 Y A2 net100 VSS g45n1svt m=1 l=45n w=520n
Mmn0 net104 A0 VSS VSS g45n1svt m=1 l=45n w=520n
Mmp2 net81 A2 VDD NW g45p1svt m=1 l=45n w=780n
Mmp3 Y B0 net81 NW g45p1svt m=1 l=45n w=780n
Mmp1 net81 A1 VDD NW g45p1svt m=1 l=45n w=780n
Mmp0 net81 A0 VDD NW g45p1svt m=1 l=45n w=780n
.ENDS

.SUBCKT AOI31X4 A0 A1 A2 B0 NW VDD VSS Y
*.PININFO A0:I A1:I A2:I B0:I NW:I VDD:I VSS:I Y:O
Mmn3 Y B0 VSS VSS g45n1svt m=1 l=45n w=1.04u
Mmn1 net101 A1 net97 VSS g45n1svt m=1 l=45n w=1.04u
Mmn2 Y A2 net101 VSS g45n1svt m=1 l=45n w=1.04u
Mmn0 net97 A0 VSS VSS g45n1svt m=1 l=45n w=1.04u
Mmp2 net89 A2 VDD NW g45p1svt m=1 l=45n w=1.56u
Mmp3 Y B0 net89 NW g45p1svt m=1 l=45n w=1.56u
Mmp1 net89 A1 VDD NW g45p1svt m=1 l=45n w=1.56u
Mmp0 net89 A0 VDD NW g45p1svt m=1 l=45n w=1.56u
.ENDS

.SUBCKT AOI31XL A0 A1 A2 B0 NW VDD VSS Y
*.PININFO A0:I A1:I A2:I B0:I NW:I VDD:I VSS:I Y:O
Mmn3 Y B0 VSS VSS g45n1svt m=1 l=45n w=145n
Mmn1 net101 A1 net97 VSS g45n1svt m=1 l=45n w=145n
Mmn2 Y A2 net101 VSS g45n1svt m=1 l=45n w=145n
Mmn0 net97 A0 VSS VSS g45n1svt m=1 l=45n w=145n
Mmp2 net89 A2 VDD NW g45p1svt m=1 l=45n w=215n
Mmp3 Y B0 net89 NW g45p1svt m=1 l=45n w=215n
Mmp1 net89 A1 VDD NW g45p1svt m=1 l=45n w=215n
Mmp0 net89 A0 VDD NW g45p1svt m=1 l=45n w=215n
.ENDS

.SUBCKT AOI32X1 A0 A1 A2 B0 B1 NW VDD VSS Y
*.PININFO A0:I A1:I A2:I B0:I B1:I NW:I VDD:I VSS:I Y:O
Mmn3 net118 B0 VSS VSS g45n1svt m=1 l=45n w=260n
Mmn2 Y A2 net126 VSS g45n1svt m=1 l=45n w=260n
Mmn0 net122 A0 VSS VSS g45n1svt m=1 l=45n w=260n
Mmn1 net126 A1 net122 VSS g45n1svt m=1 l=45n w=260n
Mmn4 Y B1 net118 VSS g45n1svt m=1 l=45n w=260n
Mmp3 Y B0 net114 NW g45p1svt m=1 l=45n w=390n
Mmp4 Y B1 net114 NW g45p1svt m=1 l=45n w=390n
Mmp2 net114 A2 VDD NW g45p1svt m=1 l=45n w=390n
Mmp1 net114 A1 VDD NW g45p1svt m=1 l=45n w=390n
Mmp0 net114 A0 VDD NW g45p1svt m=1 l=45n w=390n
.ENDS

.SUBCKT AOI32X2 A0 A1 A2 B0 B1 NW VDD VSS Y
*.PININFO A0:I A1:I A2:I B0:I B1:I NW:I VDD:I VSS:I Y:O
Mmn3 net83 B0 VSS VSS g45n1svt m=1 l=45n w=520n
Mmn2 Y A2 net71 VSS g45n1svt m=1 l=45n w=520n
Mmn0 net75 A0 VSS VSS g45n1svt m=1 l=45n w=520n
Mmn1 net71 A1 net75 VSS g45n1svt m=1 l=45n w=520n
Mmn4 Y B1 net83 VSS g45n1svt m=1 l=45n w=520n
Mmp3 Y B0 net47 NW g45p1svt m=1 l=45n w=780n
Mmp4 Y B1 net47 NW g45p1svt m=1 l=45n w=780n
Mmp2 net47 A2 VDD NW g45p1svt m=1 l=45n w=780n
Mmp1 net47 A1 VDD NW g45p1svt m=1 l=45n w=780n
Mmp0 net47 A0 VDD NW g45p1svt m=1 l=45n w=780n
.ENDS

.SUBCKT AOI32X4 A0 A1 A2 B0 B1 NW VDD VSS Y
*.PININFO A0:I A1:I A2:I B0:I B1:I NW:I VDD:I VSS:I Y:O
Mmn3 net118 B0 VSS VSS g45n1svt m=1 l=45n w=1.04u
Mmn2 Y A2 net126 VSS g45n1svt m=1 l=45n w=1.04u
Mmn0 net122 A0 VSS VSS g45n1svt m=1 l=45n w=1.04u
Mmn1 net126 A1 net122 VSS g45n1svt m=1 l=45n w=1.04u
Mmn4 Y B1 net118 VSS g45n1svt m=1 l=45n w=1.04u
Mmp3 Y B0 net106 NW g45p1svt m=1 l=45n w=1.56u
Mmp4 Y B1 net106 NW g45p1svt m=1 l=45n w=1.56u
Mmp2 net106 A2 VDD NW g45p1svt m=1 l=45n w=1.56u
Mmp1 net106 A1 VDD NW g45p1svt m=1 l=45n w=1.56u
Mmp0 net106 A0 VDD NW g45p1svt m=1 l=45n w=1.56u
.ENDS

.SUBCKT AOI32XL A0 A1 A2 B0 B1 NW VDD VSS Y
*.PININFO A0:I A1:I A2:I B0:I B1:I NW:I VDD:I VSS:I Y:O
Mmn3 net118 B0 VSS VSS g45n1svt m=1 l=45n w=145n
Mmn2 Y A2 net130 VSS g45n1svt m=1 l=45n w=145n
Mmn0 net126 A0 VSS VSS g45n1svt m=1 l=45n w=145n
Mmn1 net130 A1 net126 VSS g45n1svt m=1 l=45n w=145n
Mmn4 Y B1 net118 VSS g45n1svt m=1 l=45n w=145n
Mmp3 Y B0 net114 NW g45p1svt m=1 l=45n w=215n
Mmp4 Y B1 net114 NW g45p1svt m=1 l=45n w=215n
Mmp2 net114 A2 VDD NW g45p1svt m=1 l=45n w=215n
Mmp1 net114 A1 VDD NW g45p1svt m=1 l=45n w=215n
Mmp0 net114 A0 VDD NW g45p1svt m=1 l=45n w=215n
.ENDS

.SUBCKT AOI33X1 A0 A1 A2 B0 B1 B2 NW VDD VSS Y
*.PININFO A0:I A1:I A2:I B0:I B1:I B2:I NW:I VDD:I VSS:I Y:O
Mmn1 net157 A1 net149 VSS g45n1svt m=1 l=45n w=260n
Mmn4 net141 B1 net137 VSS g45n1svt m=1 l=45n w=260n
Mmn3 net137 B0 VSS VSS g45n1svt m=1 l=45n w=260n
Mmn5 Y B2 net141 VSS g45n1svt m=1 l=45n w=260n
Mmn0 net149 A0 VSS VSS g45n1svt m=1 l=45n w=260n
Mmn2 Y A2 net157 VSS g45n1svt m=1 l=45n w=260n
Mmp0 net059 A0 VDD NW g45p1svt m=1 l=45n w=390n
Mmp1 net059 A1 VDD NW g45p1svt m=1 l=45n w=390n
Mmp4 Y B1 net059 NW g45p1svt m=1 l=45n w=390n
Mmp5 Y B2 net059 NW g45p1svt m=1 l=45n w=390n
Mmp2 net059 A2 VDD NW g45p1svt m=1 l=45n w=390n
Mmp3 Y B0 net059 NW g45p1svt m=1 l=45n w=390n
.ENDS

.SUBCKT AOI33X2 A0 A1 A2 B0 B1 B2 NW VDD VSS Y
*.PININFO A0:I A1:I A2:I B0:I B1:I B2:I NW:I VDD:I VSS:I Y:O
Mmn1 net153 A1 net149 VSS g45n1svt m=1 l=45n w=520n
Mmn4 net141 B1 net137 VSS g45n1svt m=1 l=45n w=520n
Mmn3 net137 B0 VSS VSS g45n1svt m=1 l=45n w=520n
Mmn5 Y B2 net141 VSS g45n1svt m=1 l=45n w=520n
Mmn0 net149 A0 VSS VSS g45n1svt m=1 l=45n w=520n
Mmn2 Y A2 net153 VSS g45n1svt m=1 l=45n w=520n
Mmp0 net124 A0 VDD NW g45p1svt m=1 l=45n w=780n
Mmp1 net124 A1 VDD NW g45p1svt m=1 l=45n w=780n
Mmp4 Y B1 net124 NW g45p1svt m=1 l=45n w=780n
Mmp5 Y B2 net124 NW g45p1svt m=1 l=45n w=780n
Mmp2 net124 A2 VDD NW g45p1svt m=1 l=45n w=780n
Mmp3 Y B0 net124 NW g45p1svt m=1 l=45n w=780n
.ENDS

.SUBCKT AOI33X4 A0 A1 A2 B0 B1 B2 NW VDD VSS Y
*.PININFO A0:I A1:I A2:I B0:I B1:I B2:I NW:I VDD:I VSS:I Y:O
Mmn1 net153 A1 net149 VSS g45n1svt m=1 l=45n w=1.04u
Mmn4 net141 B1 net137 VSS g45n1svt m=1 l=45n w=1.04u
Mmn3 net137 B0 VSS VSS g45n1svt m=1 l=45n w=1.04u
Mmn5 Y B2 net141 VSS g45n1svt m=1 l=45n w=1.04u
Mmn0 net149 A0 VSS VSS g45n1svt m=1 l=45n w=1.04u
Mmn2 Y A2 net153 VSS g45n1svt m=1 l=45n w=1.04u
Mmp0 net124 A0 VDD NW g45p1svt m=1 l=45n w=1.56u
Mmp1 net124 A1 VDD NW g45p1svt m=1 l=45n w=1.56u
Mmp4 Y B1 net124 NW g45p1svt m=1 l=45n w=1.56u
Mmp5 Y B2 net124 NW g45p1svt m=1 l=45n w=1.56u
Mmp2 net124 A2 VDD NW g45p1svt m=1 l=45n w=1.56u
Mmp3 Y B0 net124 NW g45p1svt m=1 l=45n w=1.56u
.ENDS

.SUBCKT AOI33XL A0 A1 A2 B0 B1 B2 NW VDD VSS Y
*.PININFO A0:I A1:I A2:I B0:I B1:I B2:I NW:I VDD:I VSS:I Y:O
Mmn1 net153 A1 net149 VSS g45n1svt m=1 l=45n w=145n
Mmn4 net137 B1 VSS VSS g45n1svt m=1 l=45n w=145n
Mmn3 net141 B0 net137 VSS g45n1svt m=1 l=45n w=145n
Mmn5 Y B2 net141 VSS g45n1svt m=1 l=45n w=145n
Mmn0 net149 A0 VSS VSS g45n1svt m=1 l=45n w=145n
Mmn2 Y A2 net153 VSS g45n1svt m=1 l=45n w=145n
Mmp0 net124 A0 VDD NW g45p1svt m=1 l=45n w=215n
Mmp1 net124 A1 VDD NW g45p1svt m=1 l=45n w=215n
Mmp4 Y B1 net124 NW g45p1svt m=1 l=45n w=215n
Mmp5 Y B2 net124 NW g45p1svt m=1 l=45n w=215n
Mmp2 net124 A2 VDD NW g45p1svt m=1 l=45n w=215n
Mmp3 Y B0 net124 NW g45p1svt m=1 l=45n w=215n
.ENDS

.SUBCKT BMXIX2 A M0 M1 NW PPN S VDD VSS X2
*.PININFO A:I M0:I M1:I NW:I S:I VDD:I VSS:I X2:I PPN:O
Mmn10 n1 M1 n9 VSS g45n1svt m=1 l=45n w=145n
Mmn9 n9 A VSS VSS g45n1svt m=1 l=45n w=145n
Mmn8 n1 M1b n7 VSS g45n1svt m=1 l=45n w=145n
Mmn7 n7 S VSS VSS g45n1svt m=1 l=45n w=145n
Mmn3 n3 S VSS VSS g45n1svt m=1 l=45n w=145n
Mmn4 n0 M0b n3 VSS g45n1svt m=1 l=45n w=145n
Mmn11 net293 X2 n0 VSS g45n1svt m=1 l=45n w=145n
Mmn6 n0 M0 n5 VSS g45n1svt m=1 l=45n w=145n
Mmn13 PPN net293 VSS VSS g45n1svt m=1 l=45n w=520n
Mmn5 n5 A VSS VSS g45n1svt m=1 l=45n w=145n
Mmn12 n1 X2b net293 VSS g45n1svt m=1 l=45n w=145n
Mmn0 M0b M0 VSS VSS g45n1svt m=1 l=45n w=145n
Mmn1 M1b M1 VSS VSS g45n1svt m=1 l=45n w=145n
Mmn2 X2b X2 VSS VSS g45n1svt m=1 l=45n w=145n
Mmp8 n1 M1 n8 NW g45p1svt m=1 l=45n w=215n
Mmp7 n8 S VDD NW g45p1svt m=1 l=45n w=215n
Mmp3 n4 S VDD NW g45p1svt m=1 l=45n w=215n
Mmp4 n0 M0 n4 NW g45p1svt m=1 l=45n w=215n
Mmp9 n10 A VDD NW g45p1svt m=1 l=45n w=215n
Mmp10 n1 M1b n10 NW g45p1svt m=1 l=45n w=215n
Mmp2 X2b X2 VDD NW g45p1svt m=1 l=45n w=215n
Mmp6 n0 M0b n6 NW g45p1svt m=1 l=45n w=215n
Mmp0 M0b M0 VDD NW g45p1svt m=1 l=45n w=215n
Mmp1 M1b M1 VDD NW g45p1svt m=1 l=45n w=215n
Mmp13 PPN net293 VDD NW g45p1svt m=1 l=45n w=780n
Mmp12 n1 X2 net293 NW g45p1svt m=1 l=45n w=215n
Mmp11 net293 X2b n0 NW g45p1svt m=1 l=45n w=215n
Mmp5 n6 A VDD NW g45p1svt m=1 l=45n w=215n
.ENDS

.SUBCKT BMXIX4 A M0 M1 NW PPN S VDD VSS X2
*.PININFO A:I M0:I M1:I NW:I S:I VDD:I VSS:I X2:I PPN:O
Mmn10 n1 M1 n9 VSS g45n1svt m=1 l=45n w=145n
Mmn9 n9 A VSS VSS g45n1svt m=1 l=45n w=145n
Mmn8 n1 M1b n7 VSS g45n1svt m=1 l=45n w=145n
Mmn7 n7 S VSS VSS g45n1svt m=1 l=45n w=145n
Mmn3 n3 S VSS VSS g45n1svt m=1 l=45n w=145n
Mmn4 n0 M0b n3 VSS g45n1svt m=1 l=45n w=145n
Mmn11 net293 X2 n0 VSS g45n1svt m=1 l=45n w=260n
Mmn6 n0 M0 n5 VSS g45n1svt m=1 l=45n w=145n
Mmn13 PPN net293 VSS VSS g45n1svt m=1 l=45n w=1.04u
Mmn5 n5 A VSS VSS g45n1svt m=1 l=45n w=145n
Mmn12 n1 X2b net293 VSS g45n1svt m=1 l=45n w=260n
Mmn0 M0b M0 VSS VSS g45n1svt m=1 l=45n w=145n
Mmn1 M1b M1 VSS VSS g45n1svt m=1 l=45n w=145n
Mmn2 X2b X2 VSS VSS g45n1svt m=1 l=45n w=145n
Mmp8 n1 M1 n8 NW g45p1svt m=1 l=45n w=215n
Mmp7 n8 S VDD NW g45p1svt m=1 l=45n w=215n
Mmp3 n4 S VDD NW g45p1svt m=1 l=45n w=215n
Mmp4 n0 M0 n4 NW g45p1svt m=1 l=45n w=215n
Mmp9 n10 A VDD NW g45p1svt m=1 l=45n w=215n
Mmp10 n1 M1b n10 NW g45p1svt m=1 l=45n w=215n
Mmp2 X2b X2 VDD NW g45p1svt m=1 l=45n w=215n
Mmp6 n0 M0b n6 NW g45p1svt m=1 l=45n w=215n
Mmp0 M0b M0 VDD NW g45p1svt m=1 l=45n w=215n
Mmp1 M1b M1 VDD NW g45p1svt m=1 l=45n w=215n
Mmp13 PPN net293 VDD NW g45p1svt m=1 l=45n w=1.56u
Mmp12 n1 X2 net293 NW g45p1svt m=1 l=45n w=390n
Mmp11 net293 X2b n0 NW g45p1svt m=1 l=45n w=390n
Mmp5 n6 A VDD NW g45p1svt m=1 l=45n w=215n
.ENDS

.SUBCKT BUFX12 A NW VDD VSS Y
*.PININFO A:I NW:I VDD:I VSS:I Y:O
Mmn1 VSS n0 Y VSS g45n1svt m=1 l=45n w=3.1u
Mmn0 VSS A n0 VSS g45n1svt m=1 l=45n w=780n
Mmp1 Y n0 VDD NW g45p1svt m=1 l=45n w=4.7u
Mmp0 n0 A VDD NW g45p1svt m=1 l=45n w=1.17u
.ENDS

.SUBCKT BUFX16 A NW VDD VSS Y
*.PININFO A:I NW:I VDD:I VSS:I Y:O
Mmn1 VSS n0 Y VSS g45n1svt m=1 l=45n w=4.13u
Mmn0 VSS A n0 VSS g45n1svt m=1 l=45n w=1.04u
Mmp1 Y n0 VDD NW g45p1svt m=1 l=45n w=6.23u
Mmp0 n0 A VDD NW g45p1svt m=1 l=45n w=1.56u
.ENDS

.SUBCKT BUFX20 A NW VDD VSS Y
*.PININFO A:I NW:I VDD:I VSS:I Y:O
Mmn1 VSS n0 Y VSS g45n1svt m=1 l=45n w=5.185u
Mmn0 VSS A n0 VSS g45n1svt m=1 l=45n w=1.3u
Mmp1 Y n0 VDD NW g45p1svt m=1 l=45n w=7.82u
Mmp0 n0 A VDD NW g45p1svt m=1 l=45n w=1.95u
.ENDS

.SUBCKT BUFX2 A NW VDD VSS Y
*.PININFO A:I NW:I VDD:I VSS:I Y:O
Mmn1 VSS n0 Y VSS g45n1svt m=1 l=45n w=520n
Mmn0 VSS A n0 VSS g45n1svt m=1 l=45n w=145n
Mmp1 Y n0 VDD NW g45p1svt m=1 l=45n w=780n
Mmp0 n0 A VDD NW g45p1svt m=1 l=45n w=215n
.ENDS

.SUBCKT BUFX3 A NW VDD VSS Y
*.PININFO A:I NW:I VDD:I VSS:I Y:O
Mmn1 VSS n0 Y VSS g45n1svt m=1 l=45n w=780n
Mmn0 VSS A n0 VSS g45n1svt m=1 l=45n w=260n
Mmp1 Y n0 VDD NW g45p1svt m=1 l=45n w=1.17u
Mmp0 n0 A VDD NW g45p1svt m=1 l=45n w=390n
.ENDS

.SUBCKT BUFX4 A NW VDD VSS Y
*.PININFO A:I NW:I VDD:I VSS:I Y:O
Mmn1 VSS n0 Y VSS g45n1svt m=1 l=45n w=1.04u
Mmn0 VSS A n0 VSS g45n1svt m=1 l=45n w=260n
Mmp1 Y n0 VDD NW g45p1svt m=1 l=45n w=1.56u
Mmp0 n0 A VDD NW g45p1svt m=1 l=45n w=390n
.ENDS

.SUBCKT BUFX6 A NW VDD VSS Y
*.PININFO A:I NW:I VDD:I VSS:I Y:O
Mmn1 VSS n0 Y VSS g45n1svt m=1 l=45n w=1.55u
Mmn0 VSS A n0 VSS g45n1svt m=1 l=45n w=520n
Mmp1 Y n0 VDD NW g45p1svt m=1 l=45n w=2.35u
Mmp0 n0 A VDD NW g45p1svt m=1 l=45n w=780n
.ENDS

.SUBCKT BUFX8 A NW VDD VSS Y
*.PININFO A:I NW:I VDD:I VSS:I Y:O
Mmn1 VSS n0 Y VSS g45n1svt m=1 l=45n w=2.065u
Mmn0 VSS A n0 VSS g45n1svt m=1 l=45n w=520n
Mmp1 Y n0 VDD NW g45p1svt m=1 l=45n w=3.115u
Mmp0 n0 A VDD NW g45p1svt m=1 l=45n w=780n
.ENDS

.SUBCKT CLKAND2X12 A B NW VDD VSS Y
*.PININFO A:I B:I NW:I VDD:I VSS:I Y:O
Mmn2 Y net61 VSS VSS g45n1svt m=1 l=45n w=3.1u
Mmn0 net69 A VSS VSS g45n1svt m=1 l=45n w=1.55u
Mmn1 net61 B net69 VSS g45n1svt m=1 l=45n w=1.55u
Mmp1 net61 B VDD NW g45p1svt m=1 l=45n w=1.175u
Mmp0 net61 A VDD NW g45p1svt m=1 l=45n w=1.175u
Mmp2 Y net61 VDD NW g45p1svt m=1 l=45n w=4.7u
.ENDS

.SUBCKT CLKAND2X2 A B NW VDD VSS Y
*.PININFO A:I B:I NW:I VDD:I VSS:I Y:O
Mmn2 Y net61 VSS VSS g45n1svt m=1 l=45n w=520n
Mmn0 net69 A VSS VSS g45n1svt m=1 l=45n w=290n
Mmn1 net61 B net69 VSS g45n1svt m=1 l=45n w=290n
Mmp1 net61 B VDD NW g45p1svt m=1 l=45n w=215n
Mmp0 net61 A VDD NW g45p1svt m=1 l=45n w=215n
Mmp2 Y net61 VDD NW g45p1svt m=1 l=45n w=780n
.ENDS

.SUBCKT CLKAND2X3 A B NW VDD VSS Y
*.PININFO A:I B:I NW:I VDD:I VSS:I Y:O
Mmn2 Y net61 VSS VSS g45n1svt m=1 l=45n w=780n
Mmn0 net69 A VSS VSS g45n1svt m=1 l=45n w=520n
Mmn1 net61 B net69 VSS g45n1svt m=1 l=45n w=520n
Mmp1 net61 B VDD NW g45p1svt m=1 l=45n w=390n
Mmp0 net61 A VDD NW g45p1svt m=1 l=45n w=390n
Mmp2 Y net61 VDD NW g45p1svt m=1 l=45n w=1.17u
.ENDS

.SUBCKT CLKAND2X4 A B NW VDD VSS Y
*.PININFO A:I B:I NW:I VDD:I VSS:I Y:O
Mmn2 Y net61 VSS VSS g45n1svt m=1 l=45n w=1.04u
Mmn0 net69 A VSS VSS g45n1svt m=1 l=45n w=520n
Mmn1 net61 B net69 VSS g45n1svt m=1 l=45n w=520n
Mmp1 net61 B VDD NW g45p1svt m=1 l=45n w=390n
Mmp0 net61 A VDD NW g45p1svt m=1 l=45n w=390n
Mmp2 Y net61 VDD NW g45p1svt m=1 l=45n w=1.56u
.ENDS

.SUBCKT CLKAND2X6 A B NW VDD VSS Y
*.PININFO A:I B:I NW:I VDD:I VSS:I Y:O
Mmn2 Y net61 VSS VSS g45n1svt m=1 l=45n w=1.55u
Mmn0 net69 A VSS VSS g45n1svt m=1 l=45n w=1.04u
Mmn1 net61 B net69 VSS g45n1svt m=1 l=45n w=1.04u
Mmp1 net61 B VDD NW g45p1svt m=1 l=45n w=780n
Mmp0 net61 A VDD NW g45p1svt m=1 l=45n w=780n
Mmp2 Y net61 VDD NW g45p1svt m=1 l=45n w=2.35u
.ENDS

.SUBCKT CLKAND2X8 A B NW VDD VSS Y
*.PININFO A:I B:I NW:I VDD:I VSS:I Y:O
Mmn2 Y net61 VSS VSS g45n1svt m=1 l=45n w=2.065u
Mmn0 net69 A VSS VSS g45n1svt m=1 l=45n w=1.04u
Mmn1 net61 B net69 VSS g45n1svt m=1 l=45n w=1.04u
Mmp1 net61 B VDD NW g45p1svt m=1 l=45n w=780n
Mmp0 net61 A VDD NW g45p1svt m=1 l=45n w=780n
Mmp2 Y net61 VDD NW g45p1svt m=1 l=45n w=3.115u
.ENDS

.SUBCKT CLKBUFX12 A NW VDD VSS Y
*.PININFO A:I NW:I VDD:I VSS:I Y:O
Mmn1 Y net44 VSS VSS g45n1svt m=1 l=45n w=3.1u
Mmn0 net44 A VSS VSS g45n1svt m=1 l=45n w=780n
Mmp1 Y net44 VDD NW g45p1svt m=1 l=45n w=4.7u
Mmp0 net44 A VDD NW g45p1svt m=1 l=45n w=1.17u
.ENDS

.SUBCKT CLKBUFX16 A NW VDD VSS Y
*.PININFO A:I NW:I VDD:I VSS:I Y:O
Mmn1 Y net44 VSS VSS g45n1svt m=1 l=45n w=4.13u
Mmn0 net44 A VSS VSS g45n1svt m=1 l=45n w=1.04u
Mmp1 Y net44 VDD NW g45p1svt m=1 l=45n w=6.23u
Mmp0 net44 A VDD NW g45p1svt m=1 l=45n w=1.56u
.ENDS

.SUBCKT CLKBUFX20 A NW VDD VSS Y
*.PININFO A:I NW:I VDD:I VSS:I Y:O
Mmn1 Y net44 VSS VSS g45n1svt m=1 l=45n w=5.185u
Mmn0 net44 A VSS VSS g45n1svt m=1 l=45n w=1.3u
Mmp1 Y net44 VDD NW g45p1svt m=1 l=45n w=7.815u
Mmp0 net44 A VDD NW g45p1svt m=1 l=45n w=1.95u
.ENDS

.SUBCKT CLKBUFX2 A NW VDD VSS Y
*.PININFO A:I NW:I VDD:I VSS:I Y:O
Mmn1 Y net44 VSS VSS g45n1svt m=1 l=45n w=520n
Mmn0 net44 A VSS VSS g45n1svt m=1 l=45n w=145n
Mmp1 Y net44 VDD NW g45p1svt m=1 l=45n w=780n
Mmp0 net44 A VDD NW g45p1svt m=1 l=45n w=215n
.ENDS

.SUBCKT CLKBUFX3 A NW VDD VSS Y
*.PININFO A:I NW:I VDD:I VSS:I Y:O
Mmn1 Y net44 VSS VSS g45n1svt m=1 l=45n w=780n
Mmn0 net44 A VSS VSS g45n1svt m=1 l=45n w=260n
Mmp1 Y net44 VDD NW g45p1svt m=1 l=45n w=1.17u
Mmp0 net44 A VDD NW g45p1svt m=1 l=45n w=390n
.ENDS

.SUBCKT CLKBUFX4 A NW VDD VSS Y
*.PININFO A:I NW:I VDD:I VSS:I Y:O
Mmn1 Y net44 VSS VSS g45n1svt m=1 l=45n w=1.04u
Mmn0 net44 A VSS VSS g45n1svt m=1 l=45n w=260n
Mmp1 Y net44 VDD NW g45p1svt m=1 l=45n w=1.56u
Mmp0 net44 A VDD NW g45p1svt m=1 l=45n w=390n
.ENDS

.SUBCKT CLKBUFX6 A NW VDD VSS Y
*.PININFO A:I NW:I VDD:I VSS:I Y:O
Mmn1 Y net44 VSS VSS g45n1svt m=1 l=45n w=1.55u
Mmn0 net44 A VSS VSS g45n1svt m=1 l=45n w=520n
Mmp1 Y net44 VDD NW g45p1svt m=1 l=45n w=2.35u
Mmp0 net44 A VDD NW g45p1svt m=1 l=45n w=780n
.ENDS

.SUBCKT CLKBUFX8 A NW VDD VSS Y
*.PININFO A:I NW:I VDD:I VSS:I Y:O
Mmn1 Y net44 VSS VSS g45n1svt m=1 l=45n w=2.065u
Mmn0 net44 A VSS VSS g45n1svt m=1 l=45n w=520n
Mmp1 Y net44 VDD NW g45p1svt m=1 l=45n w=3.115u
Mmp0 net44 A VDD NW g45p1svt m=1 l=45n w=780n
.ENDS

.SUBCKT CLKINVX12 A NW VDD VSS Y
*.PININFO A:I NW:I VDD:I VSS:I Y:O
Mmp0 Y A VDD NW g45p1svt m=1 l=45n w=4.7u
Mmn0 Y A VSS VSS g45n1svt m=1 l=45n w=3.1u
.ENDS

.SUBCKT CLKINVX16 A NW VDD VSS Y
*.PININFO A:I NW:I VDD:I VSS:I Y:O
Mmp0 Y A VDD NW g45p1svt m=1 l=45n w=6.23u
Mmn0 Y A VSS VSS g45n1svt m=1 l=45n w=4.13u
.ENDS

.SUBCKT CLKINVX1 A NW VDD VSS Y
*.PININFO A:I NW:I VDD:I VSS:I Y:O
Mmp0 Y A VDD NW g45p1svt m=1 l=45n w=390n
Mmn0 Y A VSS VSS g45n1svt m=1 l=45n w=260n
.ENDS

.SUBCKT CLKINVX20 A NW VDD VSS Y
*.PININFO A:I NW:I VDD:I VSS:I Y:O
Mmp0 Y A VDD NW g45p1svt m=1 l=45n w=7.815u
Mmn0 Y A VSS VSS g45n1svt m=1 l=45n w=5.185u
.ENDS

.SUBCKT CLKINVX2 A NW VDD VSS Y
*.PININFO A:I NW:I VDD:I VSS:I Y:O
Mmp0 Y A VDD NW g45p1svt m=1 l=45n w=780n
Mmn0 Y A VSS VSS g45n1svt m=1 l=45n w=520n
.ENDS

.SUBCKT CLKINVX3 A NW VDD VSS Y
*.PININFO A:I NW:I VDD:I VSS:I Y:O
Mmp0 Y A VDD NW g45p1svt m=1 l=45n w=1.17u
Mmn0 Y A VSS VSS g45n1svt m=1 l=45n w=780n
.ENDS

.SUBCKT CLKINVX4 A NW VDD VSS Y
*.PININFO A:I NW:I VDD:I VSS:I Y:O
Mmp0 Y A VDD NW g45p1svt m=1 l=45n w=1.56u
Mmn0 Y A VSS VSS g45n1svt m=1 l=45n w=1.04u
.ENDS

.SUBCKT CLKINVX6 A NW VDD VSS Y
*.PININFO A:I NW:I VDD:I VSS:I Y:O
Mmp0 Y A VDD NW g45p1svt m=1 l=45n w=2.35u
Mmn0 Y A VSS VSS g45n1svt m=1 l=45n w=1.55u
.ENDS

.SUBCKT CLKINVX8 A NW VDD VSS Y
*.PININFO A:I NW:I VDD:I VSS:I Y:O
Mmp0 Y A VDD NW g45p1svt m=1 l=45n w=3.115u
Mmn0 Y A VSS VSS g45n1svt m=1 l=45n w=2.065u
.ENDS

.SUBCKT CLKMX2X12 A B NW S0 VDD VSS Y
*.PININFO A:I B:I NW:I S0:I VDD:I VSS:I Y:O
Mmn3 net140 B VSS VSS g45n1svt m=1 l=45n w=205n
Mmn0 S0b S0 VSS VSS g45n1svt m=1 l=45n w=260n
Mmn2 n0 S0b net148 VSS g45n1svt m=1 l=45n w=205n
Mmn1 net148 A VSS VSS g45n1svt m=1 l=45n w=205n
Mmn5 Y n0 VSS VSS g45n1svt m=1 l=45n w=3.1u
Mmn4 n0 S0 net140 VSS g45n1svt m=1 l=45n w=205n
Mmp4 n0 S0b net115 NW g45p1svt m=1 l=45n w=310n
Mmp3 net115 B VDD NW g45p1svt m=1 l=45n w=310n
Mmp5 Y n0 VDD NW g45p1svt m=1 l=45n w=4.7u
Mmp2 n0 S0 net123 NW g45p1svt m=1 l=45n w=310n
Mmp0 S0b S0 VDD NW g45p1svt m=1 l=45n w=390n
Mmp1 net123 A VDD NW g45p1svt m=1 l=45n w=310n
.ENDS

.SUBCKT CLKMX2X2 A B NW S0 VDD VSS Y
*.PININFO A:I B:I NW:I S0:I VDD:I VSS:I Y:O
Mmn3 net140 B VSS VSS g45n1svt m=1 l=45n w=145n
Mmn0 S0b S0 VSS VSS g45n1svt m=1 l=45n w=145n
Mmn2 n0 S0b net148 VSS g45n1svt m=1 l=45n w=145n
Mmn1 net148 A VSS VSS g45n1svt m=1 l=45n w=145n
Mmn5 Y n0 VSS VSS g45n1svt m=1 l=45n w=520n
Mmn4 n0 S0 net140 VSS g45n1svt m=1 l=45n w=145n
Mmp4 n0 S0b net115 NW g45p1svt m=1 l=45n w=215n
Mmp3 net115 B VDD NW g45p1svt m=1 l=45n w=215n
Mmp5 Y n0 VDD NW g45p1svt m=1 l=45n w=780n
Mmp2 n0 S0 net123 NW g45p1svt m=1 l=45n w=215n
Mmp0 S0b S0 VDD NW g45p1svt m=1 l=45n w=215n
Mmp1 net123 A VDD NW g45p1svt m=1 l=45n w=215n
.ENDS

.SUBCKT CLKMX2X3 A B NW S0 VDD VSS Y
*.PININFO A:I B:I NW:I S0:I VDD:I VSS:I Y:O
Mmn3 net140 B VSS VSS g45n1svt m=1 l=45n w=260n
Mmn0 S0b S0 VSS VSS g45n1svt m=1 l=45n w=145n
Mmn2 n0 S0b net148 VSS g45n1svt m=1 l=45n w=260n
Mmn1 net148 A VSS VSS g45n1svt m=1 l=45n w=260n
Mmn5 Y n0 VSS VSS g45n1svt m=1 l=45n w=780n
Mmn4 n0 S0 net140 VSS g45n1svt m=1 l=45n w=260n
Mmp4 n0 S0b net115 NW g45p1svt m=1 l=45n w=390n
Mmp3 net115 B VDD NW g45p1svt m=1 l=45n w=390n
Mmp5 Y n0 VDD NW g45p1svt m=1 l=45n w=1.17u
Mmp2 n0 S0 net123 NW g45p1svt m=1 l=45n w=390n
Mmp0 S0b S0 VDD NW g45p1svt m=1 l=45n w=215n
Mmp1 net123 A VDD NW g45p1svt m=1 l=45n w=390n
.ENDS

.SUBCKT CLKMX2X4 A B NW S0 VDD VSS Y
*.PININFO A:I B:I NW:I S0:I VDD:I VSS:I Y:O
Mmn3 net140 B VSS VSS g45n1svt m=1 l=45n w=205n
Mmn0 S0b S0 VSS VSS g45n1svt m=1 l=45n w=145n
Mmn2 n0 S0b net148 VSS g45n1svt m=1 l=45n w=205n
Mmn1 net148 A VSS VSS g45n1svt m=1 l=45n w=205n
Mmn5 Y n0 VSS VSS g45n1svt m=1 l=45n w=1.04u
Mmn4 n0 S0 net140 VSS g45n1svt m=1 l=45n w=205n
Mmp4 n0 S0b net115 NW g45p1svt m=1 l=45n w=310n
Mmp3 net115 B VDD NW g45p1svt m=1 l=45n w=310n
Mmp5 Y n0 VDD NW g45p1svt m=1 l=45n w=1.56u
Mmp2 n0 S0 net123 NW g45p1svt m=1 l=45n w=310n
Mmp0 S0b S0 VDD NW g45p1svt m=1 l=45n w=215n
Mmp1 net123 A VDD NW g45p1svt m=1 l=45n w=310n
.ENDS

.SUBCKT CLKMX2X6 A B NW S0 VDD VSS Y
*.PININFO A:I B:I NW:I S0:I VDD:I VSS:I Y:O
Mmn3 net140 B VSS VSS g45n1svt m=1 l=45n w=205n
Mmn0 S0b S0 VSS VSS g45n1svt m=1 l=45n w=145n
Mmn2 n0 S0b net148 VSS g45n1svt m=1 l=45n w=205n
Mmn1 net148 A VSS VSS g45n1svt m=1 l=45n w=205n
Mmn5 Y n0 VSS VSS g45n1svt m=1 l=45n w=1.55u
Mmn4 n0 S0 net140 VSS g45n1svt m=1 l=45n w=205n
Mmp4 n0 S0b net115 NW g45p1svt m=1 l=45n w=310n
Mmp3 net115 B VDD NW g45p1svt m=1 l=45n w=310n
Mmp5 Y n0 VDD NW g45p1svt m=1 l=45n w=2.35u
Mmp2 n0 S0 net123 NW g45p1svt m=1 l=45n w=310n
Mmp0 S0b S0 VDD NW g45p1svt m=1 l=45n w=215n
Mmp1 net123 A VDD NW g45p1svt m=1 l=45n w=310n
.ENDS

.SUBCKT CLKMX2X8 A B NW S0 VDD VSS Y
*.PININFO A:I B:I NW:I S0:I VDD:I VSS:I Y:O
Mmn3 net140 B VSS VSS g45n1svt m=1 l=45n w=205n
Mmn0 S0b S0 VSS VSS g45n1svt m=1 l=45n w=145n
Mmn2 n0 S0b net148 VSS g45n1svt m=1 l=45n w=205n
Mmn1 net148 A VSS VSS g45n1svt m=1 l=45n w=205n
Mmn5 Y n0 VSS VSS g45n1svt m=1 l=45n w=2.065u
Mmn4 n0 S0 net140 VSS g45n1svt m=1 l=45n w=205n
Mmp4 n0 S0b net115 NW g45p1svt m=1 l=45n w=310n
Mmp3 net115 B VDD NW g45p1svt m=1 l=45n w=310n
Mmp5 Y n0 VDD NW g45p1svt m=1 l=45n w=3.115u
Mmp2 n0 S0 net123 NW g45p1svt m=1 l=45n w=310n
Mmp0 S0b S0 VDD NW g45p1svt m=1 l=45n w=215n
Mmp1 net123 A VDD NW g45p1svt m=1 l=45n w=310n
.ENDS

.SUBCKT CLKXOR2X1 A B NW VDD VSS Y
*.PININFO A:I B:I NW:I VDD:I VSS:I Y:O
Mmn1 n2 B VSS VSS g45n1svt m=1 l=45n w=145n
Mmn0 n1 A VSS VSS g45n1svt m=1 l=45n w=145n
Mmn5 Y n0 VSS VSS g45n1svt m=1 l=45n w=260n
Mmn3 n0 B net139 VSS g45n1svt m=1 l=45n w=145n
Mmn4 n0 n2 n1 VSS g45n1svt m=1 l=45n w=145n
Mmn2 net139 n1 VSS VSS g45n1svt m=1 l=45n w=145n
Mmp3 n0 n2 net130 NW g45p1svt m=1 l=45n w=215n
Mmp1 n2 B VDD NW g45p1svt m=1 l=45n w=215n
Mmp4 n0 B n1 NW g45p1svt m=1 l=45n w=215n
Mmp0 n1 A VDD NW g45p1svt m=1 l=45n w=215n
Mmp5 Y n0 VDD NW g45p1svt m=1 l=45n w=390n
Mmp2 net130 n1 VDD NW g45p1svt m=1 l=45n w=215n
.ENDS

.SUBCKT CLKXOR2X2 A B NW VDD VSS Y
*.PININFO A:I B:I NW:I VDD:I VSS:I Y:O
Mmn1 n2 B VSS VSS g45n1svt m=1 l=45n w=145n
Mmn0 n1 A VSS VSS g45n1svt m=1 l=45n w=145n
Mmn5 Y n0 VSS VSS g45n1svt m=1 l=45n w=520n
Mmn3 n0 B net139 VSS g45n1svt m=1 l=45n w=145n
Mmn4 n0 n2 n1 VSS g45n1svt m=1 l=45n w=145n
Mmn2 net139 n1 VSS VSS g45n1svt m=1 l=45n w=145n
Mmp3 n0 n2 net130 NW g45p1svt m=1 l=45n w=215n
Mmp1 n2 B VDD NW g45p1svt m=1 l=45n w=215n
Mmp4 n0 B n1 NW g45p1svt m=1 l=45n w=215n
Mmp0 n1 A VDD NW g45p1svt m=1 l=45n w=215n
Mmp5 Y n0 VDD NW g45p1svt m=1 l=45n w=780n
Mmp2 net130 n1 VDD NW g45p1svt m=1 l=45n w=215n
.ENDS

.SUBCKT CLKXOR2X4 A B NW VDD VSS Y
*.PININFO A:I B:I NW:I VDD:I VSS:I Y:O
Mmn1 n2 B VSS VSS g45n1svt m=1 l=45n w=145n
Mmn0 n1 A VSS VSS g45n1svt m=1 l=45n w=145n
Mmn5 Y n0 VSS VSS g45n1svt m=1 l=45n w=1.04u
Mmn3 n0 B net139 VSS g45n1svt m=1 l=45n w=205n
Mmn4 n0 n2 n1 VSS g45n1svt m=1 l=45n w=205n
Mmn2 net139 n1 VSS VSS g45n1svt m=1 l=45n w=205n
Mmp3 n0 n2 net130 NW g45p1svt m=1 l=45n w=310n
Mmp1 n2 B VDD NW g45p1svt m=1 l=45n w=215n
Mmp4 n0 B n1 NW g45p1svt m=1 l=45n w=310n
Mmp0 n1 A VDD NW g45p1svt m=1 l=45n w=215n
Mmp5 Y n0 VDD NW g45p1svt m=1 l=45n w=1.56u
Mmp2 net130 n1 VDD NW g45p1svt m=1 l=45n w=310n
.ENDS

.SUBCKT CLKXOR2X8 A B NW VDD VSS Y
*.PININFO A:I B:I NW:I VDD:I VSS:I Y:O
Mmn1 n2 B VSS VSS g45n1svt m=1 l=45n w=145n
Mmn0 n1 A VSS VSS g45n1svt m=1 l=45n w=145n
Mmn5 Y n0 VSS VSS g45n1svt m=1 l=45n w=2.065u
Mmn3 n0 B net139 VSS g45n1svt m=1 l=45n w=205n
Mmn4 n0 n2 n1 VSS g45n1svt m=1 l=45n w=205n
Mmn2 net139 n1 VSS VSS g45n1svt m=1 l=45n w=205n
Mmp3 n0 n2 net130 NW g45p1svt m=1 l=45n w=310n
Mmp1 n2 B VDD NW g45p1svt m=1 l=45n w=215n
Mmp4 n0 B n1 NW g45p1svt m=1 l=45n w=310n
Mmp0 n1 A VDD NW g45p1svt m=1 l=45n w=215n
Mmp5 Y n0 VDD NW g45p1svt m=1 l=45n w=3.115u
Mmp2 net130 n1 VDD NW g45p1svt m=1 l=45n w=310n
.ENDS

.SUBCKT DFFHQX1 CK D NW Q VDD VSS
*.PININFO CK:I D:I NW:I VDD:I VSS:I Q:O
Mmn26 n20 CKb n21 VSS g45n1svt m=1 l=45n w=205n
Mmn25 n21 D VSS VSS g45n1svt m=1 l=45n w=205n
Mmn55 Q qbint VSS VSS g45n1svt m=1 l=45n w=260n
Mmn50 net172 qbint VSS VSS g45n1svt m=1 l=45n w=205n
Mmn51 n30 CKb net172 VSS g45n1svt m=1 l=45n w=205n
Mmn30 mout n20 VSS VSS g45n1svt m=1 l=45n w=205n
Mmn36 n20 CKbb net192 VSS g45n1svt m=1 l=45n w=205n
Mmn20 CKb CK VSS VSS g45n1svt m=1 l=45n w=145n
Mmn45 qbint n30 VSS VSS g45n1svt m=1 l=45n w=205n
Mmn40 mout CKbb n30 VSS g45n1svt m=1 l=45n w=205n
Mmn21 CKbb CKb VSS VSS g45n1svt m=1 l=45n w=145n
Mmn35 net192 mout VSS VSS g45n1svt m=1 l=45n w=205n
Mmp26 n20 CKbb n22 NW g45p1svt m=1 l=45n w=310n
Mmp25 n22 D VDD NW g45p1svt m=1 l=45n w=310n
Mmp51 n30 CKbb net123 NW g45p1svt m=1 l=45n w=310n
Mmp50 net123 qbint VDD NW g45p1svt m=1 l=45n w=310n
Mmp55 Q qbint VDD NW g45p1svt m=1 l=45n w=390n
Mmp35 net147 mout VDD NW g45p1svt m=1 l=45n w=310n
Mmp36 n20 CKb net147 NW g45p1svt m=1 l=45n w=310n
Mmp45 qbint n30 VDD NW g45p1svt m=1 l=45n w=310n
Mmp20 CKb CK VDD NW g45p1svt m=1 l=45n w=215n
Mmp40 mout CKb n30 NW g45p1svt m=1 l=45n w=310n
Mmp30 mout n20 VDD NW g45p1svt m=1 l=45n w=310n
Mmp21 CKbb CKb VDD NW g45p1svt m=1 l=45n w=215n
.ENDS

.SUBCKT DFFHQX2 CK D NW Q VDD VSS
*.PININFO CK:I D:I NW:I VDD:I VSS:I Q:O
Mmn26 n20 CKb n21 VSS g45n1svt m=1 l=45n w=205n
Mmn25 n21 D VSS VSS g45n1svt m=1 l=45n w=205n
Mmn55 Q qbint VSS VSS g45n1svt m=1 l=45n w=520n
Mmn50 net172 qbint VSS VSS g45n1svt m=1 l=45n w=205n
Mmn51 n30 CKb net172 VSS g45n1svt m=1 l=45n w=205n
Mmn30 mout n20 VSS VSS g45n1svt m=1 l=45n w=205n
Mmn36 n20 CKbb net192 VSS g45n1svt m=1 l=45n w=205n
Mmn20 CKb CK VSS VSS g45n1svt m=1 l=45n w=145n
Mmn45 qbint n30 VSS VSS g45n1svt m=1 l=45n w=205n
Mmn40 mout CKbb n30 VSS g45n1svt m=1 l=45n w=205n
Mmn21 CKbb CKb VSS VSS g45n1svt m=1 l=45n w=145n
Mmn35 net192 mout VSS VSS g45n1svt m=1 l=45n w=205n
Mmp26 n20 CKbb n22 NW g45p1svt m=1 l=45n w=310n
Mmp25 n22 D VDD NW g45p1svt m=1 l=45n w=310n
Mmp51 n30 CKbb net123 NW g45p1svt m=1 l=45n w=310n
Mmp50 net123 qbint VDD NW g45p1svt m=1 l=45n w=310n
Mmp55 Q qbint VDD NW g45p1svt m=1 l=45n w=780n
Mmp35 net147 mout VDD NW g45p1svt m=1 l=45n w=310n
Mmp36 n20 CKb net147 NW g45p1svt m=1 l=45n w=310n
Mmp45 qbint n30 VDD NW g45p1svt m=1 l=45n w=310n
Mmp20 CKb CK VDD NW g45p1svt m=1 l=45n w=215n
Mmp40 mout CKb n30 NW g45p1svt m=1 l=45n w=310n
Mmp30 mout n20 VDD NW g45p1svt m=1 l=45n w=310n
Mmp21 CKbb CKb VDD NW g45p1svt m=1 l=45n w=215n
.ENDS

.SUBCKT DFFHQX4 CK D NW Q VDD VSS
*.PININFO CK:I D:I NW:I VDD:I VSS:I Q:O
Mmn26 n20 CKb n21 VSS g45n1svt m=1 l=45n w=205n
Mmn25 n21 D VSS VSS g45n1svt m=1 l=45n w=205n
Mmn55 Q qbint VSS VSS g45n1svt m=1 l=45n w=1.04u
Mmn50 net172 qbint VSS VSS g45n1svt m=1 l=45n w=205n
Mmn51 n30 CKb net172 VSS g45n1svt m=1 l=45n w=205n
Mmn30 mout n20 VSS VSS g45n1svt m=1 l=45n w=205n
Mmn36 n20 CKbb net192 VSS g45n1svt m=1 l=45n w=205n
Mmn20 CKb CK VSS VSS g45n1svt m=1 l=45n w=145n
Mmn45 qbint n30 VSS VSS g45n1svt m=1 l=45n w=410n
Mmn40 mout CKbb n30 VSS g45n1svt m=1 l=45n w=205n
Mmn21 CKbb CKb VSS VSS g45n1svt m=1 l=45n w=145n
Mmn35 net192 mout VSS VSS g45n1svt m=1 l=45n w=205n
Mmp26 n20 CKbb n22 NW g45p1svt m=1 l=45n w=310n
Mmp25 n22 D VDD NW g45p1svt m=1 l=45n w=310n
Mmp51 n30 CKbb net123 NW g45p1svt m=1 l=45n w=310n
Mmp50 net123 qbint VDD NW g45p1svt m=1 l=45n w=310n
Mmp55 Q qbint VDD NW g45p1svt m=1 l=45n w=1.56u
Mmp35 net147 mout VDD NW g45p1svt m=1 l=45n w=310n
Mmp36 n20 CKb net147 NW g45p1svt m=1 l=45n w=310n
Mmp45 qbint n30 VDD NW g45p1svt m=1 l=45n w=620n
Mmp20 CKb CK VDD NW g45p1svt m=1 l=45n w=215n
Mmp40 mout CKb n30 NW g45p1svt m=1 l=45n w=310n
Mmp30 mout n20 VDD NW g45p1svt m=1 l=45n w=310n
Mmp21 CKbb CKb VDD NW g45p1svt m=1 l=45n w=215n
.ENDS

.SUBCKT DFFHQX8 CK D NW Q VDD VSS
*.PININFO CK:I D:I NW:I VDD:I VSS:I Q:O
Mmn26 n20 CKb n21 VSS g45n1svt m=1 l=45n w=205n
Mmn25 n21 D VSS VSS g45n1svt m=1 l=45n w=205n
Mmn55 Q qbint VSS VSS g45n1svt m=1 l=45n w=2.065u
Mmn50 net172 qbint VSS VSS g45n1svt m=1 l=45n w=205n
Mmn51 n30 CKb net172 VSS g45n1svt m=1 l=45n w=205n
Mmn30 mout n20 VSS VSS g45n1svt m=1 l=45n w=205n
Mmn36 n20 CKbb net192 VSS g45n1svt m=1 l=45n w=205n
Mmn20 CKb CK VSS VSS g45n1svt m=1 l=45n w=145n
Mmn45 qbint n30 VSS VSS g45n1svt m=1 l=45n w=780n
Mmn40 mout CKbb n30 VSS g45n1svt m=1 l=45n w=205n
Mmn21 CKbb CKb VSS VSS g45n1svt m=1 l=45n w=145n
Mmn35 net192 mout VSS VSS g45n1svt m=1 l=45n w=205n
Mmp26 n20 CKbb n22 NW g45p1svt m=1 l=45n w=310n
Mmp25 n22 D VDD NW g45p1svt m=1 l=45n w=310n
Mmp51 n30 CKbb net123 NW g45p1svt m=1 l=45n w=310n
Mmp50 net123 qbint VDD NW g45p1svt m=1 l=45n w=310n
Mmp55 Q qbint VDD NW g45p1svt m=1 l=45n w=3.115u
Mmp35 net147 mout VDD NW g45p1svt m=1 l=45n w=310n
Mmp36 n20 CKb net147 NW g45p1svt m=1 l=45n w=310n
Mmp45 qbint n30 VDD NW g45p1svt m=1 l=45n w=1.17u
Mmp20 CKb CK VDD NW g45p1svt m=1 l=45n w=215n
Mmp40 mout CKb n30 NW g45p1svt m=1 l=45n w=310n
Mmp30 mout n20 VDD NW g45p1svt m=1 l=45n w=310n
Mmp21 CKbb CKb VDD NW g45p1svt m=1 l=45n w=215n
.ENDS

.SUBCKT DFFNSRX1 CKN D NW Q QN RN SN VDD VSS
*.PININFO CKN:I D:I NW:I RN:I SN:I VDD:I VSS:I Q:O QN:O
Mmn26 n20 CKNbb n21 VSS g45n1svt m=1 l=45n w=145n
Mmn25 n21 D VSS VSS g45n1svt m=1 l=45n w=145n
Mmn57 QN qint VSS VSS g45n1svt m=1 l=45n w=260n
Mmn55 Q qbint VSS VSS g45n1svt m=1 l=45n w=260n
Mmn36 n20 CKNb n30 VSS g45n1svt m=1 l=45n w=145n
Mmn35 n30 mout VSS VSS g45n1svt m=1 l=45n w=145n
Mmn22 RNb RN VSS VSS g45n1svt m=1 l=45n w=145n
Mmn20 CKNb CKN VSS VSS g45n1svt m=1 l=45n w=145n
Mmn45 qbint n35 VSS VSS g45n1svt m=1 l=45n w=145n
Mmn56 qint qbint VSS VSS g45n1svt m=1 l=45n w=145n
Mmn52 n40 qbint n42 VSS g45n1svt m=1 l=45n w=145n
Mmn51 n40 RNb n42 VSS g45n1svt m=1 l=45n w=145n
Mmn50 n42 SN VSS VSS g45n1svt m=1 l=45n w=145n
Mmn53 n40 CKNbb n35 VSS g45n1svt m=1 l=45n w=145n
Mmn21 CKNbb CKNb VSS VSS g45n1svt m=1 l=45n w=145n
Mmn32 mout n20 n25 VSS g45n1svt m=1 l=45n w=145n
Mmn31 n25 RNb mout VSS g45n1svt m=1 l=45n w=145n
Mmn30 n25 SN VSS VSS g45n1svt m=1 l=45n w=145n
Mmn40 n35 CKNb mout VSS g45n1svt m=1 l=45n w=145n
Mmp25 n22 D VDD NW g45p1svt m=1 l=45n w=215n
Mmp26 n20 CKNb n22 NW g45p1svt m=1 l=45n w=215n
Mmp51 n43 RNb VDD NW g45p1svt m=1 l=45n w=215n
Mmp57 QN qint VDD NW g45p1svt m=1 l=45n w=390n
Mmp55 Q qbint VDD NW g45p1svt m=1 l=45n w=390n
Mmp36 n20 CKNbb n31 NW g45p1svt m=1 l=45n w=215n
Mmp35 n31 mout VDD NW g45p1svt m=1 l=45n w=215n
Mmp32 mout n20 n26 NW g45p1svt m=1 l=45n w=215n
Mmp31 n26 RNb VDD NW g45p1svt m=1 l=45n w=215n
Mmp22 RNb RN VDD NW g45p1svt m=1 l=45n w=215n
Mmp20 CKNb CKN VDD NW g45p1svt m=1 l=45n w=215n
Mmp53 n41 CKNb n35 NW g45p1svt m=1 l=45n w=215n
Mmp50 n41 SN VDD NW g45p1svt m=1 l=45n w=215n
Mmp45 qbint n35 VDD NW g45p1svt m=1 l=45n w=215n
Mmp56 qint qbint VDD NW g45p1svt m=1 l=45n w=215n
Mmp21 CKNbb CKNb VDD NW g45p1svt m=1 l=45n w=215n
Mmp40 n35 CKNbb mout NW g45p1svt m=1 l=45n w=215n
Mmp52 n41 qbint n43 NW g45p1svt m=1 l=45n w=215n
Mmp30 mout SN VDD NW g45p1svt m=1 l=45n w=215n
.ENDS

.SUBCKT DFFNSRX2 CKN D NW Q QN RN SN VDD VSS
*.PININFO CKN:I D:I NW:I RN:I SN:I VDD:I VSS:I Q:O QN:O
Mmn26 n20 CKNbb n21 VSS g45n1svt m=1 l=45n w=145n
Mmn25 n21 D VSS VSS g45n1svt m=1 l=45n w=145n
Mmn57 QN qint VSS VSS g45n1svt m=1 l=45n w=520n
Mmn55 Q qbint VSS VSS g45n1svt m=1 l=45n w=520n
Mmn36 n20 CKNb n30 VSS g45n1svt m=1 l=45n w=145n
Mmn35 n30 mout VSS VSS g45n1svt m=1 l=45n w=145n
Mmn22 RNb RN VSS VSS g45n1svt m=1 l=45n w=145n
Mmn20 CKNb CKN VSS VSS g45n1svt m=1 l=45n w=145n
Mmn45 qbint n35 VSS VSS g45n1svt m=1 l=45n w=205n
Mmn56 qint qbint VSS VSS g45n1svt m=1 l=45n w=145n
Mmn52 n40 qbint n42 VSS g45n1svt m=1 l=45n w=145n
Mmn51 n40 RNb n42 VSS g45n1svt m=1 l=45n w=145n
Mmn50 n42 SN VSS VSS g45n1svt m=1 l=45n w=145n
Mmn53 n40 CKNbb n35 VSS g45n1svt m=1 l=45n w=145n
Mmn21 CKNbb CKNb VSS VSS g45n1svt m=1 l=45n w=145n
Mmn32 mout n20 n25 VSS g45n1svt m=1 l=45n w=145n
Mmn31 n25 RNb mout VSS g45n1svt m=1 l=45n w=145n
Mmn30 n25 SN VSS VSS g45n1svt m=1 l=45n w=145n
Mmn40 n35 CKNb mout VSS g45n1svt m=1 l=45n w=145n
Mmp25 n22 D VDD NW g45p1svt m=1 l=45n w=215n
Mmp26 n20 CKNb n22 NW g45p1svt m=1 l=45n w=215n
Mmp51 n43 RNb VDD NW g45p1svt m=1 l=45n w=215n
Mmp57 QN qint VDD NW g45p1svt m=1 l=45n w=780n
Mmp55 Q qbint VDD NW g45p1svt m=1 l=45n w=780n
Mmp36 n20 CKNbb n31 NW g45p1svt m=1 l=45n w=215n
Mmp35 n31 mout VDD NW g45p1svt m=1 l=45n w=215n
Mmp32 mout n20 n26 NW g45p1svt m=1 l=45n w=215n
Mmp31 n26 RNb VDD NW g45p1svt m=1 l=45n w=215n
Mmp22 RNb RN VDD NW g45p1svt m=1 l=45n w=215n
Mmp20 CKNb CKN VDD NW g45p1svt m=1 l=45n w=215n
Mmp53 n41 CKNb n35 NW g45p1svt m=1 l=45n w=215n
Mmp50 n41 SN VDD NW g45p1svt m=1 l=45n w=215n
Mmp45 qbint n35 VDD NW g45p1svt m=1 l=45n w=310n
Mmp56 qint qbint VDD NW g45p1svt m=1 l=45n w=215n
Mmp21 CKNbb CKNb VDD NW g45p1svt m=1 l=45n w=215n
Mmp40 n35 CKNbb mout NW g45p1svt m=1 l=45n w=215n
Mmp52 n41 qbint n43 NW g45p1svt m=1 l=45n w=215n
Mmp30 mout SN VDD NW g45p1svt m=1 l=45n w=215n
.ENDS

.SUBCKT DFFNSRX4 CKN D NW Q QN RN SN VDD VSS
*.PININFO CKN:I D:I NW:I RN:I SN:I VDD:I VSS:I Q:O QN:O
Mmn26 n20 CKNbb n21 VSS g45n1svt m=1 l=45n w=145n
Mmn25 n21 D VSS VSS g45n1svt m=1 l=45n w=145n
Mmn57 QN qint VSS VSS g45n1svt m=1 l=45n w=1.04u
Mmn55 Q qbint VSS VSS g45n1svt m=1 l=45n w=1.04u
Mmn36 n20 CKNb n30 VSS g45n1svt m=1 l=45n w=145n
Mmn35 n30 mout VSS VSS g45n1svt m=1 l=45n w=145n
Mmn22 RNb RN VSS VSS g45n1svt m=1 l=45n w=145n
Mmn20 CKNb CKN VSS VSS g45n1svt m=1 l=45n w=145n
Mmn45 qbint n35 VSS VSS g45n1svt m=1 l=45n w=410n
Mmn56 qint qbint VSS VSS g45n1svt m=1 l=45n w=260n
Mmn52 n40 qbint n42 VSS g45n1svt m=1 l=45n w=145n
Mmn51 n40 RNb n42 VSS g45n1svt m=1 l=45n w=145n
Mmn50 n42 SN VSS VSS g45n1svt m=1 l=45n w=145n
Mmn53 n40 CKNbb n35 VSS g45n1svt m=1 l=45n w=145n
Mmn21 CKNbb CKNb VSS VSS g45n1svt m=1 l=45n w=145n
Mmn32 mout n20 n25 VSS g45n1svt m=1 l=45n w=145n
Mmn31 n25 RNb mout VSS g45n1svt m=1 l=45n w=145n
Mmn30 n25 SN VSS VSS g45n1svt m=1 l=45n w=145n
Mmn40 n35 CKNb mout VSS g45n1svt m=1 l=45n w=145n
Mmp25 n22 D VDD NW g45p1svt m=1 l=45n w=215n
Mmp26 n20 CKNb n22 NW g45p1svt m=1 l=45n w=215n
Mmp51 n43 RNb VDD NW g45p1svt m=1 l=45n w=215n
Mmp57 QN qint VDD NW g45p1svt m=1 l=45n w=1.56u
Mmp55 Q qbint VDD NW g45p1svt m=1 l=45n w=1.56u
Mmp36 n20 CKNbb n31 NW g45p1svt m=1 l=45n w=215n
Mmp35 n31 mout VDD NW g45p1svt m=1 l=45n w=215n
Mmp32 mout n20 n26 NW g45p1svt m=1 l=45n w=215n
Mmp31 n26 RNb VDD NW g45p1svt m=1 l=45n w=215n
Mmp22 RNb RN VDD NW g45p1svt m=1 l=45n w=215n
Mmp20 CKNb CKN VDD NW g45p1svt m=1 l=45n w=215n
Mmp53 n41 CKNb n35 NW g45p1svt m=1 l=45n w=215n
Mmp50 n41 SN VDD NW g45p1svt m=1 l=45n w=215n
Mmp45 qbint n35 VDD NW g45p1svt m=1 l=45n w=620n
Mmp56 qint qbint VDD NW g45p1svt m=1 l=45n w=390n
Mmp21 CKNbb CKNb VDD NW g45p1svt m=1 l=45n w=215n
Mmp40 n35 CKNbb mout NW g45p1svt m=1 l=45n w=215n
Mmp52 n41 qbint n43 NW g45p1svt m=1 l=45n w=215n
Mmp30 mout SN VDD NW g45p1svt m=1 l=45n w=215n
.ENDS

.SUBCKT DFFNSRXL CKN D NW Q QN RN SN VDD VSS
*.PININFO CKN:I D:I NW:I RN:I SN:I VDD:I VSS:I Q:O QN:O
Mmn26 n20 CKNbb n21 VSS g45n1svt m=1 l=45n w=145n
Mmn25 n21 D VSS VSS g45n1svt m=1 l=45n w=145n
Mmn57 QN qint VSS VSS g45n1svt m=1 l=45n w=145n
Mmn55 Q qbint VSS VSS g45n1svt m=1 l=45n w=145n
Mmn36 n20 CKNb n30 VSS g45n1svt m=1 l=45n w=145n
Mmn35 n30 mout VSS VSS g45n1svt m=1 l=45n w=145n
Mmn22 RNb RN VSS VSS g45n1svt m=1 l=45n w=145n
Mmn20 CKNb CKN VSS VSS g45n1svt m=1 l=45n w=145n
Mmn45 qbint n35 VSS VSS g45n1svt m=1 l=45n w=145n
Mmn56 qint qbint VSS VSS g45n1svt m=1 l=45n w=145n
Mmn52 n40 qbint n42 VSS g45n1svt m=1 l=45n w=145n
Mmn51 n40 RNb n42 VSS g45n1svt m=1 l=45n w=145n
Mmn50 n42 SN VSS VSS g45n1svt m=1 l=45n w=145n
Mmn53 n40 CKNbb n35 VSS g45n1svt m=1 l=45n w=145n
Mmn21 CKNbb CKNb VSS VSS g45n1svt m=1 l=45n w=145n
Mmn32 mout n20 n25 VSS g45n1svt m=1 l=45n w=145n
Mmn31 n25 RNb mout VSS g45n1svt m=1 l=45n w=145n
Mmn30 n25 SN VSS VSS g45n1svt m=1 l=45n w=145n
Mmn40 n35 CKNb mout VSS g45n1svt m=1 l=45n w=145n
Mmp25 n22 D VDD NW g45p1svt m=1 l=45n w=215n
Mmp26 n20 CKNb n22 NW g45p1svt m=1 l=45n w=215n
Mmp51 n43 RNb VDD NW g45p1svt m=1 l=45n w=215n
Mmp57 QN qint VDD NW g45p1svt m=1 l=45n w=215n
Mmp55 Q qbint VDD NW g45p1svt m=1 l=45n w=215n
Mmp36 n20 CKNbb n31 NW g45p1svt m=1 l=45n w=215n
Mmp35 n31 mout VDD NW g45p1svt m=1 l=45n w=215n
Mmp32 mout n20 n26 NW g45p1svt m=1 l=45n w=215n
Mmp31 n26 RNb VDD NW g45p1svt m=1 l=45n w=215n
Mmp22 RNb RN VDD NW g45p1svt m=1 l=45n w=215n
Mmp20 CKNb CKN VDD NW g45p1svt m=1 l=45n w=215n
Mmp53 n41 CKNb n35 NW g45p1svt m=1 l=45n w=215n
Mmp50 n41 SN VDD NW g45p1svt m=1 l=45n w=215n
Mmp45 qbint n35 VDD NW g45p1svt m=1 l=45n w=215n
Mmp56 qint qbint VDD NW g45p1svt m=1 l=45n w=215n
Mmp21 CKNbb CKNb VDD NW g45p1svt m=1 l=45n w=215n
Mmp40 n35 CKNbb mout NW g45p1svt m=1 l=45n w=215n
Mmp52 n41 qbint n43 NW g45p1svt m=1 l=45n w=215n
Mmp30 mout SN VDD NW g45p1svt m=1 l=45n w=215n
.ENDS

.SUBCKT DFFQX1 CK D NW Q VDD VSS
*.PININFO CK:I D:I NW:I VDD:I VSS:I Q:O
Mmn26 n20 CKb n21 VSS g45n1svt m=1 l=45n w=145n
Mmn25 n21 D VSS VSS g45n1svt m=1 l=45n w=145n
Mmn55 Q qbint VSS VSS g45n1svt m=1 l=45n w=260n
Mmn50 n35 qbint VSS VSS g45n1svt m=1 l=45n w=145n
Mmn51 n30 CKb n35 VSS g45n1svt m=1 l=45n w=145n
Mmn35 n25 mout VSS VSS g45n1svt m=1 l=45n w=145n
Mmn30 mout n20 VSS VSS g45n1svt m=1 l=45n w=145n
Mmn40 n30 CKbb mout VSS g45n1svt m=1 l=45n w=145n
Mmn45 qbint n30 VSS VSS g45n1svt m=1 l=45n w=145n
Mmn21 CKbb CKb VSS VSS g45n1svt m=1 l=45n w=145n
Mmn36 n20 CKbb n25 VSS g45n1svt m=1 l=45n w=145n
Mmn20 CKb CK VSS VSS g45n1svt m=1 l=45n w=145n
Mmp26 n20 CKbb n22 NW g45p1svt m=1 l=45n w=215n
Mmp25 n22 D VDD NW g45p1svt m=1 l=45n w=215n
Mmp51 n30 CKbb n36 NW g45p1svt m=1 l=45n w=215n
Mmp50 n36 qbint VDD NW g45p1svt m=1 l=45n w=215n
Mmp55 Q qbint VDD NW g45p1svt m=1 l=45n w=390n
Mmp35 n26 mout VDD NW g45p1svt m=1 l=45n w=215n
Mmp36 n20 CKb n26 NW g45p1svt m=1 l=45n w=215n
Mmp21 CKbb CKb VDD NW g45p1svt m=1 l=45n w=215n
Mmp20 CKb CK VDD NW g45p1svt m=1 l=45n w=215n
Mmp45 qbint n30 VDD NW g45p1svt m=1 l=45n w=215n
Mmp40 n30 CKb mout NW g45p1svt m=1 l=45n w=215n
Mmp30 mout n20 VDD NW g45p1svt m=1 l=45n w=215n
.ENDS

.SUBCKT DFFQX2 CK D NW Q VDD VSS
*.PININFO CK:I D:I NW:I VDD:I VSS:I Q:O
Mmn26 n20 CKb n21 VSS g45n1svt m=1 l=45n w=145n
Mmn25 n21 D VSS VSS g45n1svt m=1 l=45n w=145n
Mmn55 Q qbint VSS VSS g45n1svt m=1 l=45n w=520n
Mmn50 n35 qbint VSS VSS g45n1svt m=1 l=45n w=145n
Mmn51 n30 CKb n35 VSS g45n1svt m=1 l=45n w=145n
Mmn35 n25 mout VSS VSS g45n1svt m=1 l=45n w=145n
Mmn30 mout n20 VSS VSS g45n1svt m=1 l=45n w=145n
Mmn40 n30 CKbb mout VSS g45n1svt m=1 l=45n w=145n
Mmn45 qbint n30 VSS VSS g45n1svt m=1 l=45n w=205n
Mmn21 CKbb CKb VSS VSS g45n1svt m=1 l=45n w=145n
Mmn36 n20 CKbb n25 VSS g45n1svt m=1 l=45n w=145n
Mmn20 CKb CK VSS VSS g45n1svt m=1 l=45n w=145n
Mmp26 n20 CKbb n22 NW g45p1svt m=1 l=45n w=215n
Mmp25 n22 D VDD NW g45p1svt m=1 l=45n w=215n
Mmp51 n30 CKbb n36 NW g45p1svt m=1 l=45n w=215n
Mmp50 n36 qbint VDD NW g45p1svt m=1 l=45n w=215n
Mmp55 Q qbint VDD NW g45p1svt m=1 l=45n w=780n
Mmp35 n26 mout VDD NW g45p1svt m=1 l=45n w=215n
Mmp36 n20 CKb n26 NW g45p1svt m=1 l=45n w=215n
Mmp21 CKbb CKb VDD NW g45p1svt m=1 l=45n w=215n
Mmp20 CKb CK VDD NW g45p1svt m=1 l=45n w=215n
Mmp45 qbint n30 VDD NW g45p1svt m=1 l=45n w=310n
Mmp40 n30 CKb mout NW g45p1svt m=1 l=45n w=215n
Mmp30 mout n20 VDD NW g45p1svt m=1 l=45n w=215n
.ENDS

.SUBCKT DFFQX4 CK D NW Q VDD VSS
*.PININFO CK:I D:I NW:I VDD:I VSS:I Q:O
Mmn26 n20 CKb n21 VSS g45n1svt m=1 l=45n w=145n
Mmn25 n21 D VSS VSS g45n1svt m=1 l=45n w=145n
Mmn55 Q qbint VSS VSS g45n1svt m=1 l=45n w=1.04u
Mmn50 n35 qbint VSS VSS g45n1svt m=1 l=45n w=145n
Mmn51 n30 CKb n35 VSS g45n1svt m=1 l=45n w=145n
Mmn35 n25 mout VSS VSS g45n1svt m=1 l=45n w=145n
Mmn30 mout n20 VSS VSS g45n1svt m=1 l=45n w=145n
Mmn40 n30 CKbb mout VSS g45n1svt m=1 l=45n w=145n
Mmn45 qbint n30 VSS VSS g45n1svt m=1 l=45n w=410n
Mmn21 CKbb CKb VSS VSS g45n1svt m=1 l=45n w=145n
Mmn36 n20 CKbb n25 VSS g45n1svt m=1 l=45n w=145n
Mmn20 CKb CK VSS VSS g45n1svt m=1 l=45n w=145n
Mmp26 n20 CKbb n22 NW g45p1svt m=1 l=45n w=215n
Mmp25 n22 D VDD NW g45p1svt m=1 l=45n w=215n
Mmp51 n30 CKbb n36 NW g45p1svt m=1 l=45n w=215n
Mmp50 n36 qbint VDD NW g45p1svt m=1 l=45n w=215n
Mmp55 Q qbint VDD NW g45p1svt m=1 l=45n w=1.56u
Mmp35 n26 mout VDD NW g45p1svt m=1 l=45n w=215n
Mmp36 n20 CKb n26 NW g45p1svt m=1 l=45n w=215n
Mmp21 CKbb CKb VDD NW g45p1svt m=1 l=45n w=215n
Mmp20 CKb CK VDD NW g45p1svt m=1 l=45n w=215n
Mmp45 qbint n30 VDD NW g45p1svt m=1 l=45n w=620n
Mmp40 n30 CKb mout NW g45p1svt m=1 l=45n w=215n
Mmp30 mout n20 VDD NW g45p1svt m=1 l=45n w=215n
.ENDS

.SUBCKT DFFQXL CK D NW Q VDD VSS
*.PININFO CK:I D:I NW:I VDD:I VSS:I Q:O
Mmn26 n20 CKb n21 VSS g45n1svt m=1 l=45n w=145n
Mmn25 n21 D VSS VSS g45n1svt m=1 l=45n w=145n
Mmn55 Q qbint VSS VSS g45n1svt m=1 l=45n w=145n
Mmn50 n35 qbint VSS VSS g45n1svt m=1 l=45n w=145n
Mmn51 n30 CKb n35 VSS g45n1svt m=1 l=45n w=145n
Mmn35 n25 mout VSS VSS g45n1svt m=1 l=45n w=145n
Mmn30 mout n20 VSS VSS g45n1svt m=1 l=45n w=145n
Mmn40 n30 CKbb mout VSS g45n1svt m=1 l=45n w=145n
Mmn45 qbint n30 VSS VSS g45n1svt m=1 l=45n w=145n
Mmn21 CKbb CKb VSS VSS g45n1svt m=1 l=45n w=145n
Mmn36 n20 CKbb n25 VSS g45n1svt m=1 l=45n w=145n
Mmn20 CKb CK VSS VSS g45n1svt m=1 l=45n w=145n
Mmp26 n20 CKbb n22 NW g45p1svt m=1 l=45n w=215n
Mmp25 n22 D VDD NW g45p1svt m=1 l=45n w=215n
Mmp51 n30 CKbb n36 NW g45p1svt m=1 l=45n w=215n
Mmp50 n36 qbint VDD NW g45p1svt m=1 l=45n w=215n
Mmp55 Q qbint VDD NW g45p1svt m=1 l=45n w=215n
Mmp35 n26 mout VDD NW g45p1svt m=1 l=45n w=215n
Mmp36 n20 CKb n26 NW g45p1svt m=1 l=45n w=215n
Mmp21 CKbb CKb VDD NW g45p1svt m=1 l=45n w=215n
Mmp20 CKb CK VDD NW g45p1svt m=1 l=45n w=215n
Mmp45 qbint n30 VDD NW g45p1svt m=1 l=45n w=215n
Mmp40 n30 CKb mout NW g45p1svt m=1 l=45n w=215n
Mmp30 mout n20 VDD NW g45p1svt m=1 l=45n w=215n
.ENDS

.SUBCKT DFFRHQX1 CK D NW Q RN VDD VSS
*.PININFO CK:I D:I NW:I RN:I VDD:I VSS:I Q:O
Mmn36 n25 mout n27 VSS g45n1svt m=1 l=45n w=205n
Mmn35 n27 RN VSS VSS g45n1svt m=1 l=45n w=205n
Mmn37 n20 CKbb n25 VSS g45n1svt m=1 l=45n w=205n
Mmn26 n20 CKb n21 VSS g45n1svt m=1 l=45n w=205n
Mmn25 n21 D VSS VSS g45n1svt m=1 l=45n w=205n
Mmn55 Q qbint VSS VSS g45n1svt m=1 l=45n w=260n
Mmn45 n35 RN VSS VSS g45n1svt m=1 l=45n w=205n
Mmn46 qbint n30 n35 VSS g45n1svt m=1 l=45n w=205n
Mmn51 n30 CKb n40 VSS g45n1svt m=1 l=45n w=205n
Mmn50 n40 qbint VSS VSS g45n1svt m=1 l=45n w=205n
Mmn20 CKb CK VSS VSS g45n1svt m=1 l=45n w=145n
Mmn21 CKbb CKb VSS VSS g45n1svt m=1 l=45n w=145n
Mmn40 n30 CKbb mout VSS g45n1svt m=1 l=45n w=205n
Mmn30 mout n20 VSS VSS g45n1svt m=1 l=45n w=205n
Mmp26 n20 CKbb n22 NW g45p1svt m=1 l=45n w=310n
Mmp25 n22 D VDD NW g45p1svt m=1 l=45n w=310n
Mmp51 n30 CKbb n41 NW g45p1svt m=1 l=45n w=310n
Mmp50 n41 qbint VDD NW g45p1svt m=1 l=45n w=310n
Mmp55 Q qbint VDD NW g45p1svt m=1 l=45n w=390n
Mmp20 CKb CK VDD NW g45p1svt m=1 l=45n w=215n
Mmp46 qbint n30 VDD NW g45p1svt m=1 l=45n w=310n
Mmp45 qbint RN VDD NW g45p1svt m=1 l=45n w=310n
Mmp35 n26 RN VDD NW g45p1svt m=1 l=45n w=310n
Mmp36 n26 mout VDD NW g45p1svt m=1 l=45n w=310n
Mmp37 n20 CKb n26 NW g45p1svt m=1 l=45n w=310n
Mmp40 n30 CKb mout NW g45p1svt m=1 l=45n w=310n
Mmp30 mout n20 VDD NW g45p1svt m=1 l=45n w=310n
Mmp21 CKbb CKb VDD NW g45p1svt m=1 l=45n w=215n
.ENDS

.SUBCKT DFFRHQX2 CK D NW Q RN VDD VSS
*.PININFO CK:I D:I NW:I RN:I VDD:I VSS:I Q:O
Mmn36 n25 mout n27 VSS g45n1svt m=1 l=45n w=205n
Mmn35 n27 RN VSS VSS g45n1svt m=1 l=45n w=205n
Mmn37 n20 CKbb n25 VSS g45n1svt m=1 l=45n w=205n
Mmn26 n20 CKb n21 VSS g45n1svt m=1 l=45n w=205n
Mmn25 n21 D VSS VSS g45n1svt m=1 l=45n w=205n
Mmn55 Q qbint VSS VSS g45n1svt m=1 l=45n w=520n
Mmn45 n35 RN VSS VSS g45n1svt m=1 l=45n w=205n
Mmn46 qbint n30 n35 VSS g45n1svt m=1 l=45n w=205n
Mmn51 n30 CKb n40 VSS g45n1svt m=1 l=45n w=205n
Mmn50 n40 qbint VSS VSS g45n1svt m=1 l=45n w=205n
Mmn20 CKb CK VSS VSS g45n1svt m=1 l=45n w=145n
Mmn21 CKbb CKb VSS VSS g45n1svt m=1 l=45n w=145n
Mmn40 n30 CKbb mout VSS g45n1svt m=1 l=45n w=205n
Mmn30 mout n20 VSS VSS g45n1svt m=1 l=45n w=205n
Mmp26 n20 CKbb n22 NW g45p1svt m=1 l=45n w=310n
Mmp25 n22 D VDD NW g45p1svt m=1 l=45n w=310n
Mmp51 n30 CKbb n41 NW g45p1svt m=1 l=45n w=310n
Mmp50 n41 qbint VDD NW g45p1svt m=1 l=45n w=310n
Mmp55 Q qbint VDD NW g45p1svt m=1 l=45n w=780n
Mmp20 CKb CK VDD NW g45p1svt m=1 l=45n w=215n
Mmp46 qbint n30 VDD NW g45p1svt m=1 l=45n w=310n
Mmp45 qbint RN VDD NW g45p1svt m=1 l=45n w=310n
Mmp35 n26 RN VDD NW g45p1svt m=1 l=45n w=310n
Mmp36 n26 mout VDD NW g45p1svt m=1 l=45n w=310n
Mmp37 n20 CKb n26 NW g45p1svt m=1 l=45n w=310n
Mmp40 n30 CKb mout NW g45p1svt m=1 l=45n w=310n
Mmp30 mout n20 VDD NW g45p1svt m=1 l=45n w=310n
Mmp21 CKbb CKb VDD NW g45p1svt m=1 l=45n w=215n
.ENDS

.SUBCKT DFFRHQX4 CK D NW Q RN VDD VSS
*.PININFO CK:I D:I NW:I RN:I VDD:I VSS:I Q:O
Mmn36 n25 mout n27 VSS g45n1svt m=1 l=45n w=205n
Mmn35 n27 RN VSS VSS g45n1svt m=1 l=45n w=205n
Mmn37 n20 CKbb n25 VSS g45n1svt m=1 l=45n w=205n
Mmn26 n20 CKb n21 VSS g45n1svt m=1 l=45n w=205n
Mmn25 n21 D VSS VSS g45n1svt m=1 l=45n w=205n
Mmn55 Q qbint VSS VSS g45n1svt m=1 l=45n w=1.04u
Mmn45 n35 RN VSS VSS g45n1svt m=1 l=45n w=410n
Mmn46 qbint n30 n35 VSS g45n1svt m=1 l=45n w=410n
Mmn51 n30 CKb n40 VSS g45n1svt m=1 l=45n w=205n
Mmn50 n40 qbint VSS VSS g45n1svt m=1 l=45n w=205n
Mmn20 CKb CK VSS VSS g45n1svt m=1 l=45n w=145n
Mmn21 CKbb CKb VSS VSS g45n1svt m=1 l=45n w=145n
Mmn40 n30 CKbb mout VSS g45n1svt m=1 l=45n w=205n
Mmn30 mout n20 VSS VSS g45n1svt m=1 l=45n w=205n
Mmp26 n20 CKbb n22 NW g45p1svt m=1 l=45n w=310n
Mmp25 n22 D VDD NW g45p1svt m=1 l=45n w=310n
Mmp51 n30 CKbb n41 NW g45p1svt m=1 l=45n w=310n
Mmp50 n41 qbint VDD NW g45p1svt m=1 l=45n w=310n
Mmp55 Q qbint VDD NW g45p1svt m=1 l=45n w=1.56u
Mmp20 CKb CK VDD NW g45p1svt m=1 l=45n w=215n
Mmp46 qbint n30 VDD NW g45p1svt m=1 l=45n w=620n
Mmp45 qbint RN VDD NW g45p1svt m=1 l=45n w=620n
Mmp35 n26 RN VDD NW g45p1svt m=1 l=45n w=310n
Mmp36 n26 mout VDD NW g45p1svt m=1 l=45n w=310n
Mmp37 n20 CKb n26 NW g45p1svt m=1 l=45n w=310n
Mmp40 n30 CKb mout NW g45p1svt m=1 l=45n w=310n
Mmp30 mout n20 VDD NW g45p1svt m=1 l=45n w=310n
Mmp21 CKbb CKb VDD NW g45p1svt m=1 l=45n w=215n
.ENDS

.SUBCKT DFFRHQX8 CK D NW Q RN VDD VSS
*.PININFO CK:I D:I NW:I RN:I VDD:I VSS:I Q:O
Mmn36 n25 mout n27 VSS g45n1svt m=1 l=45n w=205n
Mmn35 n27 RN VSS VSS g45n1svt m=1 l=45n w=205n
Mmn37 n20 CKbb n25 VSS g45n1svt m=1 l=45n w=205n
Mmn26 n20 CKb n21 VSS g45n1svt m=1 l=45n w=205n
Mmn25 n21 D VSS VSS g45n1svt m=1 l=45n w=205n
Mmn55 Q qbint VSS VSS g45n1svt m=1 l=45n w=2.065u
Mmn45 n35 RN VSS VSS g45n1svt m=1 l=45n w=780n
Mmn46 qbint n30 n35 VSS g45n1svt m=1 l=45n w=780n
Mmn51 n30 CKb n40 VSS g45n1svt m=1 l=45n w=205n
Mmn50 n40 qbint VSS VSS g45n1svt m=1 l=45n w=205n
Mmn20 CKb CK VSS VSS g45n1svt m=1 l=45n w=145n
Mmn21 CKbb CKb VSS VSS g45n1svt m=1 l=45n w=145n
Mmn40 n30 CKbb mout VSS g45n1svt m=1 l=45n w=205n
Mmn30 mout n20 VSS VSS g45n1svt m=1 l=45n w=205n
Mmp26 n20 CKbb n22 NW g45p1svt m=1 l=45n w=310n
Mmp25 n22 D VDD NW g45p1svt m=1 l=45n w=310n
Mmp51 n30 CKbb n41 NW g45p1svt m=1 l=45n w=310n
Mmp50 n41 qbint VDD NW g45p1svt m=1 l=45n w=310n
Mmp55 Q qbint VDD NW g45p1svt m=1 l=45n w=3.115u
Mmp20 CKb CK VDD NW g45p1svt m=1 l=45n w=215n
Mmp46 qbint n30 VDD NW g45p1svt m=1 l=45n w=1.17u
Mmp45 qbint RN VDD NW g45p1svt m=1 l=45n w=1.17u
Mmp35 n26 RN VDD NW g45p1svt m=1 l=45n w=310n
Mmp36 n26 mout VDD NW g45p1svt m=1 l=45n w=310n
Mmp37 n20 CKb n26 NW g45p1svt m=1 l=45n w=310n
Mmp40 n30 CKb mout NW g45p1svt m=1 l=45n w=310n
Mmp30 mout n20 VDD NW g45p1svt m=1 l=45n w=310n
Mmp21 CKbb CKb VDD NW g45p1svt m=1 l=45n w=215n
.ENDS

.SUBCKT DFFRX1 CK D NW Q QN RN VDD VSS
*.PININFO CK:I D:I NW:I RN:I VDD:I VSS:I Q:O QN:O
Mmn36 n25 mout n27 VSS g45n1svt m=1 l=45n w=145n
Mmn35 n27 RN VSS VSS g45n1svt m=1 l=45n w=145n
Mmn37 n20 CKbb n25 VSS g45n1svt m=1 l=45n w=145n
Mmn26 n20 CKb n21 VSS g45n1svt m=1 l=45n w=145n
Mmn25 n21 D VSS VSS g45n1svt m=1 l=45n w=145n
Mmn57 QN qint VSS VSS g45n1svt m=1 l=45n w=260n
Mmn55 Q qbint VSS VSS g45n1svt m=1 l=45n w=260n
Mmn45 n35 RN VSS VSS g45n1svt m=1 l=45n w=145n
Mmn46 qbint n30 n35 VSS g45n1svt m=1 l=45n w=145n
Mmn51 n30 CKb n40 VSS g45n1svt m=1 l=45n w=145n
Mmn50 n40 qbint VSS VSS g45n1svt m=1 l=45n w=145n
Mmn21 CKbb CKb VSS VSS g45n1svt m=1 l=45n w=145n
Mmn40 n30 CKbb mout VSS g45n1svt m=1 l=45n w=145n
Mmn30 mout n20 VSS VSS g45n1svt m=1 l=45n w=145n
Mmn56 qint qbint VSS VSS g45n1svt m=1 l=45n w=145n
Mmn20 CKb CK VSS VSS g45n1svt m=1 l=45n w=145n
Mmp26 n20 CKbb n22 NW g45p1svt m=1 l=45n w=215n
Mmp25 n22 D VDD NW g45p1svt m=1 l=45n w=215n
Mmp51 n30 CKbb n41 NW g45p1svt m=1 l=45n w=215n
Mmp50 n41 qbint VDD NW g45p1svt m=1 l=45n w=215n
Mmp57 QN qint VDD NW g45p1svt m=1 l=45n w=390n
Mmp55 Q qbint VDD NW g45p1svt m=1 l=45n w=390n
Mmp20 CKb CK VDD NW g45p1svt m=1 l=45n w=215n
Mmp21 CKbb CKb VDD NW g45p1svt m=1 l=45n w=215n
Mmp36 n26 mout VDD NW g45p1svt m=1 l=45n w=215n
Mmp30 mout n20 VDD NW g45p1svt m=1 l=45n w=215n
Mmp35 n26 RN VDD NW g45p1svt m=1 l=45n w=215n
Mmp37 n20 CKb n26 NW g45p1svt m=1 l=45n w=215n
Mmp46 qbint n30 VDD NW g45p1svt m=1 l=45n w=215n
Mmp40 n30 CKb mout NW g45p1svt m=1 l=45n w=215n
Mmp45 qbint RN VDD NW g45p1svt m=1 l=45n w=215n
Mmp56 qint qbint VDD NW g45p1svt m=1 l=45n w=215n
.ENDS

.SUBCKT DFFRX2 CK D NW Q QN RN VDD VSS
*.PININFO CK:I D:I NW:I RN:I VDD:I VSS:I Q:O QN:O
Mmn36 n25 mout n27 VSS g45n1svt m=1 l=45n w=145n
Mmn35 n27 RN VSS VSS g45n1svt m=1 l=45n w=145n
Mmn37 n20 CKbb n25 VSS g45n1svt m=1 l=45n w=145n
Mmn26 n20 CKb n21 VSS g45n1svt m=1 l=45n w=145n
Mmn25 n21 D VSS VSS g45n1svt m=1 l=45n w=145n
Mmn57 QN qint VSS VSS g45n1svt m=1 l=45n w=520n
Mmn55 Q qbint VSS VSS g45n1svt m=1 l=45n w=520n
Mmn45 n35 RN VSS VSS g45n1svt m=1 l=45n w=205n
Mmn46 qbint n30 n35 VSS g45n1svt m=1 l=45n w=205n
Mmn51 n30 CKb n40 VSS g45n1svt m=1 l=45n w=145n
Mmn50 n40 qbint VSS VSS g45n1svt m=1 l=45n w=145n
Mmn21 CKbb CKb VSS VSS g45n1svt m=1 l=45n w=145n
Mmn40 n30 CKbb mout VSS g45n1svt m=1 l=45n w=145n
Mmn30 mout n20 VSS VSS g45n1svt m=1 l=45n w=145n
Mmn56 qint qbint VSS VSS g45n1svt m=1 l=45n w=145n
Mmn20 CKb CK VSS VSS g45n1svt m=1 l=45n w=145n
Mmp26 n20 CKbb n22 NW g45p1svt m=1 l=45n w=215n
Mmp25 n22 D VDD NW g45p1svt m=1 l=45n w=215n
Mmp51 n30 CKbb n41 NW g45p1svt m=1 l=45n w=215n
Mmp50 n41 qbint VDD NW g45p1svt m=1 l=45n w=215n
Mmp57 QN qint VDD NW g45p1svt m=1 l=45n w=780n
Mmp55 Q qbint VDD NW g45p1svt m=1 l=45n w=780n
Mmp20 CKb CK VDD NW g45p1svt m=1 l=45n w=215n
Mmp21 CKbb CKb VDD NW g45p1svt m=1 l=45n w=215n
Mmp36 n26 mout VDD NW g45p1svt m=1 l=45n w=215n
Mmp30 mout n20 VDD NW g45p1svt m=1 l=45n w=215n
Mmp35 n26 RN VDD NW g45p1svt m=1 l=45n w=215n
Mmp37 n20 CKb n26 NW g45p1svt m=1 l=45n w=215n
Mmp46 qbint n30 VDD NW g45p1svt m=1 l=45n w=310n
Mmp40 n30 CKb mout NW g45p1svt m=1 l=45n w=215n
Mmp45 qbint RN VDD NW g45p1svt m=1 l=45n w=310n
Mmp56 qint qbint VDD NW g45p1svt m=1 l=45n w=215n
.ENDS

.SUBCKT DFFRX4 CK D NW Q QN RN VDD VSS
*.PININFO CK:I D:I NW:I RN:I VDD:I VSS:I Q:O QN:O
Mmn36 n25 mout n27 VSS g45n1svt m=1 l=45n w=145n
Mmn35 n27 RN VSS VSS g45n1svt m=1 l=45n w=145n
Mmn37 n20 CKbb n25 VSS g45n1svt m=1 l=45n w=145n
Mmn26 n20 CKb n21 VSS g45n1svt m=1 l=45n w=145n
Mmn25 n21 D VSS VSS g45n1svt m=1 l=45n w=145n
Mmn57 QN qint VSS VSS g45n1svt m=1 l=45n w=1.04u
Mmn55 Q qbint VSS VSS g45n1svt m=1 l=45n w=1.04u
Mmn45 n35 RN VSS VSS g45n1svt m=1 l=45n w=410n
Mmn46 qbint n30 n35 VSS g45n1svt m=1 l=45n w=410n
Mmn51 n30 CKb n40 VSS g45n1svt m=1 l=45n w=145n
Mmn50 n40 qbint VSS VSS g45n1svt m=1 l=45n w=145n
Mmn21 CKbb CKb VSS VSS g45n1svt m=1 l=45n w=145n
Mmn40 n30 CKbb mout VSS g45n1svt m=1 l=45n w=145n
Mmn30 mout n20 VSS VSS g45n1svt m=1 l=45n w=145n
Mmn56 qint qbint VSS VSS g45n1svt m=1 l=45n w=260n
Mmn20 CKb CK VSS VSS g45n1svt m=1 l=45n w=145n
Mmp26 n20 CKbb n22 NW g45p1svt m=1 l=45n w=215n
Mmp25 n22 D VDD NW g45p1svt m=1 l=45n w=215n
Mmp51 n30 CKbb n41 NW g45p1svt m=1 l=45n w=215n
Mmp50 n41 qbint VDD NW g45p1svt m=1 l=45n w=215n
Mmp57 QN qint VDD NW g45p1svt m=1 l=45n w=1.56u
Mmp55 Q qbint VDD NW g45p1svt m=1 l=45n w=1.56u
Mmp20 CKb CK VDD NW g45p1svt m=1 l=45n w=215n
Mmp21 CKbb CKb VDD NW g45p1svt m=1 l=45n w=215n
Mmp36 n26 mout VDD NW g45p1svt m=1 l=45n w=215n
Mmp30 mout n20 VDD NW g45p1svt m=1 l=45n w=215n
Mmp35 n26 RN VDD NW g45p1svt m=1 l=45n w=215n
Mmp37 n20 CKb n26 NW g45p1svt m=1 l=45n w=215n
Mmp46 qbint n30 VDD NW g45p1svt m=1 l=45n w=620n
Mmp40 n30 CKb mout NW g45p1svt m=1 l=45n w=215n
Mmp45 qbint RN VDD NW g45p1svt m=1 l=45n w=620n
Mmp56 qint qbint VDD NW g45p1svt m=1 l=45n w=390n
.ENDS

.SUBCKT DFFRXL CK D NW Q QN RN VDD VSS
*.PININFO CK:I D:I NW:I RN:I VDD:I VSS:I Q:O QN:O
Mmn36 n25 mout n27 VSS g45n1svt m=1 l=45n w=145n
Mmn35 n27 RN VSS VSS g45n1svt m=1 l=45n w=145n
Mmn37 n20 CKbb n25 VSS g45n1svt m=1 l=45n w=145n
Mmn26 n20 CKb n21 VSS g45n1svt m=1 l=45n w=145n
Mmn25 n21 D VSS VSS g45n1svt m=1 l=45n w=145n
Mmn57 QN qint VSS VSS g45n1svt m=1 l=45n w=145n
Mmn55 Q qbint VSS VSS g45n1svt m=1 l=45n w=145n
Mmn45 n35 RN VSS VSS g45n1svt m=1 l=45n w=145n
Mmn46 qbint n30 n35 VSS g45n1svt m=1 l=45n w=145n
Mmn51 n30 CKb n40 VSS g45n1svt m=1 l=45n w=145n
Mmn50 n40 qbint VSS VSS g45n1svt m=1 l=45n w=145n
Mmn21 CKbb CKb VSS VSS g45n1svt m=1 l=45n w=145n
Mmn40 n30 CKbb mout VSS g45n1svt m=1 l=45n w=145n
Mmn30 mout n20 VSS VSS g45n1svt m=1 l=45n w=145n
Mmn56 qint qbint VSS VSS g45n1svt m=1 l=45n w=145n
Mmn20 CKb CK VSS VSS g45n1svt m=1 l=45n w=145n
Mmp26 n20 CKbb n22 NW g45p1svt m=1 l=45n w=215n
Mmp25 n22 D VDD NW g45p1svt m=1 l=45n w=215n
Mmp51 n30 CKbb n41 NW g45p1svt m=1 l=45n w=215n
Mmp50 n41 qbint VDD NW g45p1svt m=1 l=45n w=215n
Mmp57 QN qint VDD NW g45p1svt m=1 l=45n w=215n
Mmp55 Q qbint VDD NW g45p1svt m=1 l=45n w=215n
Mmp20 CKb CK VDD NW g45p1svt m=1 l=45n w=215n
Mmp21 CKbb CKb VDD NW g45p1svt m=1 l=45n w=215n
Mmp36 n26 mout VDD NW g45p1svt m=1 l=45n w=215n
Mmp30 mout n20 VDD NW g45p1svt m=1 l=45n w=215n
Mmp35 n26 RN VDD NW g45p1svt m=1 l=45n w=215n
Mmp37 n20 CKb n26 NW g45p1svt m=1 l=45n w=215n
Mmp46 qbint n30 VDD NW g45p1svt m=1 l=45n w=215n
Mmp40 n30 CKb mout NW g45p1svt m=1 l=45n w=215n
Mmp45 qbint RN VDD NW g45p1svt m=1 l=45n w=215n
Mmp56 qint qbint VDD NW g45p1svt m=1 l=45n w=215n
.ENDS

.SUBCKT DFFSHQX1 CK D NW Q SN VDD VSS
*.PININFO CK:I D:I NW:I SN:I VDD:I VSS:I Q:O
Mmn51 n40 qbint n42 VSS g45n1svt m=1 l=45n w=205n
Mmn52 n35 CKb n40 VSS g45n1svt m=1 l=45n w=205n
Mmn50 n42 SN VSS VSS g45n1svt m=1 l=45n w=205n
Mmn26 n20 CKb n21 VSS g45n1svt m=1 l=45n w=205n
Mmn25 n21 D VSS VSS g45n1svt m=1 l=45n w=205n
Mmn55 Q qbint VSS VSS g45n1svt m=1 l=45n w=260n
Mmn30 n25 SN VSS VSS g45n1svt m=1 l=45n w=205n
Mmn31 mout n20 n25 VSS g45n1svt m=1 l=45n w=205n
Mmn35 n20 CKbb n30 VSS g45n1svt m=1 l=45n w=205n
Mmn36 n30 mout VSS VSS g45n1svt m=1 l=45n w=205n
Mmn20 CKb CK VSS VSS g45n1svt m=1 l=45n w=145n
Mmn40 n35 CKbb mout VSS g45n1svt m=1 l=45n w=205n
Mmn45 qbint n35 VSS VSS g45n1svt m=1 l=45n w=205n
Mmn21 CKbb CKb VSS VSS g45n1svt m=1 l=45n w=145n
Mmp26 n20 CKbb n22 NW g45p1svt m=1 l=45n w=310n
Mmp25 n22 D VDD NW g45p1svt m=1 l=45n w=310n
Mmp55 Q qbint VDD NW g45p1svt m=1 l=45n w=390n
Mmp36 n20 CKb n31 NW g45p1svt m=1 l=45n w=310n
Mmp35 n31 mout VDD NW g45p1svt m=1 l=45n w=310n
Mmp20 CKb CK VDD NW g45p1svt m=1 l=45n w=215n
Mmp52 n35 CKbb n41 NW g45p1svt m=1 l=45n w=310n
Mmp31 mout n20 VDD NW g45p1svt m=1 l=45n w=310n
Mmp21 CKbb CKb VDD NW g45p1svt m=1 l=45n w=215n
Mmp50 n41 SN VDD NW g45p1svt m=1 l=45n w=310n
Mmp30 mout SN VDD NW g45p1svt m=1 l=45n w=310n
Mmp45 qbint n35 VDD NW g45p1svt m=1 l=45n w=310n
Mmp51 n41 qbint VDD NW g45p1svt m=1 l=45n w=310n
Mmp40 n35 CKb mout NW g45p1svt m=1 l=45n w=310n
.ENDS

.SUBCKT DFFSHQX2 CK D NW Q SN VDD VSS
*.PININFO CK:I D:I NW:I SN:I VDD:I VSS:I Q:O
Mmn51 n40 qbint n42 VSS g45n1svt m=1 l=45n w=205n
Mmn52 n35 CKb n40 VSS g45n1svt m=1 l=45n w=205n
Mmn50 n42 SN VSS VSS g45n1svt m=1 l=45n w=205n
Mmn26 n20 CKb n21 VSS g45n1svt m=1 l=45n w=205n
Mmn25 n21 D VSS VSS g45n1svt m=1 l=45n w=205n
Mmn55 Q qbint VSS VSS g45n1svt m=1 l=45n w=520n
Mmn30 n25 SN VSS VSS g45n1svt m=1 l=45n w=205n
Mmn31 mout n20 n25 VSS g45n1svt m=1 l=45n w=205n
Mmn35 n20 CKbb n30 VSS g45n1svt m=1 l=45n w=205n
Mmn36 n30 mout VSS VSS g45n1svt m=1 l=45n w=205n
Mmn20 CKb CK VSS VSS g45n1svt m=1 l=45n w=145n
Mmn40 n35 CKbb mout VSS g45n1svt m=1 l=45n w=205n
Mmn45 qbint n35 VSS VSS g45n1svt m=1 l=45n w=205n
Mmn21 CKbb CKb VSS VSS g45n1svt m=1 l=45n w=145n
Mmp26 n20 CKbb n22 NW g45p1svt m=1 l=45n w=310n
Mmp25 n22 D VDD NW g45p1svt m=1 l=45n w=310n
Mmp55 Q qbint VDD NW g45p1svt m=1 l=45n w=780n
Mmp36 n20 CKb n31 NW g45p1svt m=1 l=45n w=310n
Mmp35 n31 mout VDD NW g45p1svt m=1 l=45n w=310n
Mmp20 CKb CK VDD NW g45p1svt m=1 l=45n w=215n
Mmp52 n35 CKbb n41 NW g45p1svt m=1 l=45n w=310n
Mmp31 mout n20 VDD NW g45p1svt m=1 l=45n w=310n
Mmp21 CKbb CKb VDD NW g45p1svt m=1 l=45n w=215n
Mmp50 n41 SN VDD NW g45p1svt m=1 l=45n w=310n
Mmp30 mout SN VDD NW g45p1svt m=1 l=45n w=310n
Mmp45 qbint n35 VDD NW g45p1svt m=1 l=45n w=310n
Mmp51 n41 qbint VDD NW g45p1svt m=1 l=45n w=310n
Mmp40 n35 CKb mout NW g45p1svt m=1 l=45n w=310n
.ENDS

.SUBCKT DFFSHQX4 CK D NW Q SN VDD VSS
*.PININFO CK:I D:I NW:I SN:I VDD:I VSS:I Q:O
Mmn51 n40 qbint n42 VSS g45n1svt m=1 l=45n w=205n
Mmn52 n35 CKb n40 VSS g45n1svt m=1 l=45n w=205n
Mmn50 n42 SN VSS VSS g45n1svt m=1 l=45n w=205n
Mmn26 n20 CKb n21 VSS g45n1svt m=1 l=45n w=205n
Mmn25 n21 D VSS VSS g45n1svt m=1 l=45n w=205n
Mmn55 Q qbint VSS VSS g45n1svt m=1 l=45n w=1.04u
Mmn30 n25 SN VSS VSS g45n1svt m=1 l=45n w=205n
Mmn31 mout n20 n25 VSS g45n1svt m=1 l=45n w=205n
Mmn35 n20 CKbb n30 VSS g45n1svt m=1 l=45n w=205n
Mmn36 n30 mout VSS VSS g45n1svt m=1 l=45n w=205n
Mmn20 CKb CK VSS VSS g45n1svt m=1 l=45n w=145n
Mmn40 n35 CKbb mout VSS g45n1svt m=1 l=45n w=205n
Mmn45 qbint n35 VSS VSS g45n1svt m=1 l=45n w=410n
Mmn21 CKbb CKb VSS VSS g45n1svt m=1 l=45n w=145n
Mmp26 n20 CKbb n22 NW g45p1svt m=1 l=45n w=310n
Mmp25 n22 D VDD NW g45p1svt m=1 l=45n w=310n
Mmp55 Q qbint VDD NW g45p1svt m=1 l=45n w=1.56u
Mmp36 n20 CKb n31 NW g45p1svt m=1 l=45n w=310n
Mmp35 n31 mout VDD NW g45p1svt m=1 l=45n w=310n
Mmp20 CKb CK VDD NW g45p1svt m=1 l=45n w=215n
Mmp52 n35 CKbb n41 NW g45p1svt m=1 l=45n w=310n
Mmp31 mout n20 VDD NW g45p1svt m=1 l=45n w=310n
Mmp21 CKbb CKb VDD NW g45p1svt m=1 l=45n w=215n
Mmp50 n41 SN VDD NW g45p1svt m=1 l=45n w=310n
Mmp30 mout SN VDD NW g45p1svt m=1 l=45n w=310n
Mmp45 qbint n35 VDD NW g45p1svt m=1 l=45n w=620n
Mmp51 n41 qbint VDD NW g45p1svt m=1 l=45n w=310n
Mmp40 n35 CKb mout NW g45p1svt m=1 l=45n w=310n
.ENDS

.SUBCKT DFFSHQX8 CK D NW Q SN VDD VSS
*.PININFO CK:I D:I NW:I SN:I VDD:I VSS:I Q:O
Mmn51 n40 qbint n42 VSS g45n1svt m=1 l=45n w=205n
Mmn52 n35 CKb n40 VSS g45n1svt m=1 l=45n w=205n
Mmn50 n42 SN VSS VSS g45n1svt m=1 l=45n w=205n
Mmn26 n20 CKb n21 VSS g45n1svt m=1 l=45n w=205n
Mmn25 n21 D VSS VSS g45n1svt m=1 l=45n w=205n
Mmn55 Q qbint VSS VSS g45n1svt m=1 l=45n w=2.065u
Mmn30 n25 SN VSS VSS g45n1svt m=1 l=45n w=205n
Mmn31 mout n20 n25 VSS g45n1svt m=1 l=45n w=205n
Mmn35 n20 CKbb n30 VSS g45n1svt m=1 l=45n w=205n
Mmn36 n30 mout VSS VSS g45n1svt m=1 l=45n w=205n
Mmn20 CKb CK VSS VSS g45n1svt m=1 l=45n w=145n
Mmn40 n35 CKbb mout VSS g45n1svt m=1 l=45n w=205n
Mmn45 qbint n35 VSS VSS g45n1svt m=1 l=45n w=780n
Mmn21 CKbb CKb VSS VSS g45n1svt m=1 l=45n w=145n
Mmp26 n20 CKbb n22 NW g45p1svt m=1 l=45n w=310n
Mmp25 n22 D VDD NW g45p1svt m=1 l=45n w=310n
Mmp55 Q qbint VDD NW g45p1svt m=1 l=45n w=3.115u
Mmp36 n20 CKb n31 NW g45p1svt m=1 l=45n w=310n
Mmp35 n31 mout VDD NW g45p1svt m=1 l=45n w=310n
Mmp20 CKb CK VDD NW g45p1svt m=1 l=45n w=215n
Mmp52 n35 CKbb n41 NW g45p1svt m=1 l=45n w=310n
Mmp31 mout n20 VDD NW g45p1svt m=1 l=45n w=310n
Mmp21 CKbb CKb VDD NW g45p1svt m=1 l=45n w=215n
Mmp50 n41 SN VDD NW g45p1svt m=1 l=45n w=310n
Mmp30 mout SN VDD NW g45p1svt m=1 l=45n w=310n
Mmp45 qbint n35 VDD NW g45p1svt m=1 l=45n w=1.17u
Mmp51 n41 qbint VDD NW g45p1svt m=1 l=45n w=310n
Mmp40 n35 CKb mout NW g45p1svt m=1 l=45n w=310n
.ENDS

.SUBCKT DFFSRHQX1 CK D NW Q RN SN VDD VSS
*.PININFO CK:I D:I NW:I RN:I SN:I VDD:I VSS:I Q:O
Mmn26 n20 CKb n21 VSS g45n1svt m=1 l=45n w=205n
Mmn25 n21 D VSS VSS g45n1svt m=1 l=45n w=205n
Mmn55 Q qbint VSS VSS g45n1svt m=1 l=45n w=260n
Mmn35 n30 mout VSS VSS g45n1svt m=1 l=45n w=205n
Mmn36 n20 CKbb n30 VSS g45n1svt m=1 l=45n w=205n
Mmn22 RNb RN VSS VSS g45n1svt m=1 l=45n w=145n
Mmn20 CKb CK VSS VSS g45n1svt m=1 l=45n w=145n
Mmn45 qbint n35 VSS VSS g45n1svt m=1 l=45n w=205n
Mmn52 n40 qbint n42 VSS g45n1svt m=1 l=45n w=205n
Mmn51 n40 RNb n42 VSS g45n1svt m=1 l=45n w=205n
Mmn32 mout n20 n25 VSS g45n1svt m=1 l=45n w=205n
Mmn50 n42 SN VSS VSS g45n1svt m=1 l=45n w=205n
Mmn30 n25 SN VSS VSS g45n1svt m=1 l=45n w=205n
Mmn40 n35 CKbb mout VSS g45n1svt m=1 l=45n w=205n
Mmn31 mout RNb n25 VSS g45n1svt m=1 l=45n w=205n
Mmn21 CKbb CKb VSS VSS g45n1svt m=1 l=45n w=145n
Mmn53 n35 CKb n40 VSS g45n1svt m=1 l=45n w=205n
Mmp26 n20 CKbb n22 NW g45p1svt m=1 l=45n w=310n
Mmp25 n22 D VDD NW g45p1svt m=1 l=45n w=310n
Mmp52 n43 qbint n41 NW g45p1svt m=1 l=45n w=310n
Mmp51 n43 RNb VDD NW g45p1svt m=1 l=45n w=310n
Mmp55 Q qbint VDD NW g45p1svt m=1 l=45n w=390n
Mmp36 n20 CKb n31 NW g45p1svt m=1 l=45n w=310n
Mmp35 n31 mout VDD NW g45p1svt m=1 l=45n w=310n
Mmp32 mout n20 n26 NW g45p1svt m=1 l=45n w=310n
Mmp31 n26 RNb VDD NW g45p1svt m=1 l=45n w=310n
Mmp22 RNb RN VDD NW g45p1svt m=1 l=45n w=215n
Mmp20 CKb CK VDD NW g45p1svt m=1 l=45n w=215n
Mmp53 n35 CKbb n41 NW g45p1svt m=1 l=45n w=310n
Mmp50 n41 SN VDD NW g45p1svt m=1 l=45n w=310n
Mmp45 qbint n35 VDD NW g45p1svt m=1 l=45n w=310n
Mmp21 CKbb CKb VDD NW g45p1svt m=1 l=45n w=215n
Mmp30 mout SN VDD NW g45p1svt m=1 l=45n w=310n
Mmp40 n35 CKb mout NW g45p1svt m=1 l=45n w=310n
.ENDS

.SUBCKT DFFSRHQX2 CK D NW Q RN SN VDD VSS
*.PININFO CK:I D:I NW:I RN:I SN:I VDD:I VSS:I Q:O
Mmn26 n20 CKb n21 VSS g45n1svt m=1 l=45n w=205n
Mmn25 n21 D VSS VSS g45n1svt m=1 l=45n w=205n
Mmn55 Q qbint VSS VSS g45n1svt m=1 l=45n w=520n
Mmn35 n30 mout VSS VSS g45n1svt m=1 l=45n w=205n
Mmn36 n20 CKbb n30 VSS g45n1svt m=1 l=45n w=205n
Mmn22 RNb RN VSS VSS g45n1svt m=1 l=45n w=145n
Mmn20 CKb CK VSS VSS g45n1svt m=1 l=45n w=145n
Mmn45 qbint n35 VSS VSS g45n1svt m=1 l=45n w=205n
Mmn52 n40 qbint n42 VSS g45n1svt m=1 l=45n w=205n
Mmn51 n40 RNb n42 VSS g45n1svt m=1 l=45n w=205n
Mmn32 mout n20 n25 VSS g45n1svt m=1 l=45n w=205n
Mmn50 n42 SN VSS VSS g45n1svt m=1 l=45n w=205n
Mmn30 n25 SN VSS VSS g45n1svt m=1 l=45n w=205n
Mmn40 n35 CKbb mout VSS g45n1svt m=1 l=45n w=205n
Mmn31 mout RNb n25 VSS g45n1svt m=1 l=45n w=205n
Mmn21 CKbb CKb VSS VSS g45n1svt m=1 l=45n w=145n
Mmn53 n35 CKb n40 VSS g45n1svt m=1 l=45n w=205n
Mmp26 n20 CKbb n22 NW g45p1svt m=1 l=45n w=310n
Mmp25 n22 D VDD NW g45p1svt m=1 l=45n w=310n
Mmp52 n43 qbint n41 NW g45p1svt m=1 l=45n w=310n
Mmp51 n43 RNb VDD NW g45p1svt m=1 l=45n w=310n
Mmp55 Q qbint VDD NW g45p1svt m=1 l=45n w=780n
Mmp36 n20 CKb n31 NW g45p1svt m=1 l=45n w=310n
Mmp35 n31 mout VDD NW g45p1svt m=1 l=45n w=310n
Mmp32 mout n20 n26 NW g45p1svt m=1 l=45n w=310n
Mmp31 n26 RNb VDD NW g45p1svt m=1 l=45n w=310n
Mmp22 RNb RN VDD NW g45p1svt m=1 l=45n w=215n
Mmp20 CKb CK VDD NW g45p1svt m=1 l=45n w=215n
Mmp53 n35 CKbb n41 NW g45p1svt m=1 l=45n w=310n
Mmp50 n41 SN VDD NW g45p1svt m=1 l=45n w=310n
Mmp45 qbint n35 VDD NW g45p1svt m=1 l=45n w=310n
Mmp21 CKbb CKb VDD NW g45p1svt m=1 l=45n w=215n
Mmp30 mout SN VDD NW g45p1svt m=1 l=45n w=310n
Mmp40 n35 CKb mout NW g45p1svt m=1 l=45n w=310n
.ENDS

.SUBCKT DFFSRHQX4 CK D NW Q RN SN VDD VSS
*.PININFO CK:I D:I NW:I RN:I SN:I VDD:I VSS:I Q:O
Mmn26 n20 CKb n21 VSS g45n1svt m=1 l=45n w=205n
Mmn25 n21 D VSS VSS g45n1svt m=1 l=45n w=205n
Mmn55 Q qbint VSS VSS g45n1svt m=1 l=45n w=1.04u
Mmn35 n30 mout VSS VSS g45n1svt m=1 l=45n w=205n
Mmn36 n20 CKbb n30 VSS g45n1svt m=1 l=45n w=205n
Mmn22 RNb RN VSS VSS g45n1svt m=1 l=45n w=145n
Mmn20 CKb CK VSS VSS g45n1svt m=1 l=45n w=145n
Mmn45 qbint n35 VSS VSS g45n1svt m=1 l=45n w=410n
Mmn52 n40 qbint n42 VSS g45n1svt m=1 l=45n w=205n
Mmn51 n40 RNb n42 VSS g45n1svt m=1 l=45n w=205n
Mmn32 mout n20 n25 VSS g45n1svt m=1 l=45n w=205n
Mmn50 n42 SN VSS VSS g45n1svt m=1 l=45n w=205n
Mmn30 n25 SN VSS VSS g45n1svt m=1 l=45n w=205n
Mmn40 n35 CKbb mout VSS g45n1svt m=1 l=45n w=205n
Mmn31 mout RNb n25 VSS g45n1svt m=1 l=45n w=205n
Mmn21 CKbb CKb VSS VSS g45n1svt m=1 l=45n w=145n
Mmn53 n35 CKb n40 VSS g45n1svt m=1 l=45n w=205n
Mmp26 n20 CKbb n22 NW g45p1svt m=1 l=45n w=310n
Mmp25 n22 D VDD NW g45p1svt m=1 l=45n w=310n
Mmp52 n43 qbint n41 NW g45p1svt m=1 l=45n w=310n
Mmp51 n43 RNb VDD NW g45p1svt m=1 l=45n w=310n
Mmp55 Q qbint VDD NW g45p1svt m=1 l=45n w=1.56u
Mmp36 n20 CKb n31 NW g45p1svt m=1 l=45n w=310n
Mmp35 n31 mout VDD NW g45p1svt m=1 l=45n w=310n
Mmp32 mout n20 n26 NW g45p1svt m=1 l=45n w=310n
Mmp31 n26 RNb VDD NW g45p1svt m=1 l=45n w=310n
Mmp22 RNb RN VDD NW g45p1svt m=1 l=45n w=215n
Mmp20 CKb CK VDD NW g45p1svt m=1 l=45n w=215n
Mmp53 n35 CKbb n41 NW g45p1svt m=1 l=45n w=310n
Mmp50 n41 SN VDD NW g45p1svt m=1 l=45n w=310n
Mmp45 qbint n35 VDD NW g45p1svt m=1 l=45n w=620n
Mmp21 CKbb CKb VDD NW g45p1svt m=1 l=45n w=215n
Mmp30 mout SN VDD NW g45p1svt m=1 l=45n w=310n
Mmp40 n35 CKb mout NW g45p1svt m=1 l=45n w=310n
.ENDS

.SUBCKT DFFSRHQX8 CK D NW Q RN SN VDD VSS
*.PININFO CK:I D:I NW:I RN:I SN:I VDD:I VSS:I Q:O
Mmn26 n20 CKb n21 VSS g45n1svt m=1 l=45n w=205n
Mmn25 n21 D VSS VSS g45n1svt m=1 l=45n w=205n
Mmn55 Q qbint VSS VSS g45n1svt m=1 l=45n w=2.065u
Mmn35 n30 mout VSS VSS g45n1svt m=1 l=45n w=205n
Mmn36 n20 CKbb n30 VSS g45n1svt m=1 l=45n w=205n
Mmn22 RNb RN VSS VSS g45n1svt m=1 l=45n w=145n
Mmn20 CKb CK VSS VSS g45n1svt m=1 l=45n w=145n
Mmn45 qbint n35 VSS VSS g45n1svt m=1 l=45n w=780n
Mmn52 n40 qbint n42 VSS g45n1svt m=1 l=45n w=205n
Mmn51 n40 RNb n42 VSS g45n1svt m=1 l=45n w=205n
Mmn32 mout n20 n25 VSS g45n1svt m=1 l=45n w=205n
Mmn50 n42 SN VSS VSS g45n1svt m=1 l=45n w=205n
Mmn30 n25 SN VSS VSS g45n1svt m=1 l=45n w=205n
Mmn40 n35 CKbb mout VSS g45n1svt m=1 l=45n w=205n
Mmn31 mout RNb n25 VSS g45n1svt m=1 l=45n w=205n
Mmn21 CKbb CKb VSS VSS g45n1svt m=1 l=45n w=145n
Mmn53 n35 CKb n40 VSS g45n1svt m=1 l=45n w=205n
Mmp26 n20 CKbb n22 NW g45p1svt m=1 l=45n w=310n
Mmp25 n22 D VDD NW g45p1svt m=1 l=45n w=310n
Mmp52 n43 qbint n41 NW g45p1svt m=1 l=45n w=310n
Mmp51 n43 RNb VDD NW g45p1svt m=1 l=45n w=310n
Mmp55 Q qbint VDD NW g45p1svt m=1 l=45n w=3.115u
Mmp36 n20 CKb n31 NW g45p1svt m=1 l=45n w=310n
Mmp35 n31 mout VDD NW g45p1svt m=1 l=45n w=310n
Mmp32 mout n20 n26 NW g45p1svt m=1 l=45n w=310n
Mmp31 n26 RNb VDD NW g45p1svt m=1 l=45n w=310n
Mmp22 RNb RN VDD NW g45p1svt m=1 l=45n w=215n
Mmp20 CKb CK VDD NW g45p1svt m=1 l=45n w=215n
Mmp53 n35 CKbb n41 NW g45p1svt m=1 l=45n w=310n
Mmp50 n41 SN VDD NW g45p1svt m=1 l=45n w=310n
Mmp45 qbint n35 VDD NW g45p1svt m=1 l=45n w=1.17u
Mmp21 CKbb CKb VDD NW g45p1svt m=1 l=45n w=215n
Mmp30 mout SN VDD NW g45p1svt m=1 l=45n w=310n
Mmp40 n35 CKb mout NW g45p1svt m=1 l=45n w=310n
.ENDS

.SUBCKT DFFSRX1 CK D NW Q QN RN SN VDD VSS
*.PININFO CK:I D:I NW:I RN:I SN:I VDD:I VSS:I Q:O QN:O
Mmn26 n20 CKb n21 VSS g45n1svt m=1 l=45n w=145n
Mmn25 n21 D VSS VSS g45n1svt m=1 l=45n w=145n
Mmn57 QN qint VSS VSS g45n1svt m=1 l=45n w=260n
Mmn55 Q qbint VSS VSS g45n1svt m=1 l=45n w=260n
Mmn35 n30 mout VSS VSS g45n1svt m=1 l=45n w=145n
Mmn36 n20 CKbb n30 VSS g45n1svt m=1 l=45n w=145n
Mmn22 RNb RN VSS VSS g45n1svt m=1 l=45n w=145n
Mmn20 CKb CK VSS VSS g45n1svt m=1 l=45n w=145n
Mmn45 qbint n35 VSS VSS g45n1svt m=1 l=45n w=145n
Mmn56 qint qbint VSS VSS g45n1svt m=1 l=45n w=145n
Mmn52 n40 qbint n42 VSS g45n1svt m=1 l=45n w=145n
Mmn51 n40 RNb n42 VSS g45n1svt m=1 l=45n w=145n
Mmn50 n42 SN VSS VSS g45n1svt m=1 l=45n w=145n
Mmn53 n35 CKb n40 VSS g45n1svt m=1 l=45n w=145n
Mmn21 CKbb CKb VSS VSS g45n1svt m=1 l=45n w=145n
Mmn32 mout n20 net426 VSS g45n1svt m=1 l=45n w=145n
Mmn31 mout RNb net426 VSS g45n1svt m=1 l=45n w=145n
Mmn40 n35 CKbb mout VSS g45n1svt m=1 l=45n w=145n
Mmn30 net426 SN VSS VSS g45n1svt m=1 l=45n w=145n
Mmp26 n20 CKbb n22 NW g45p1svt m=1 l=45n w=215n
Mmp25 n22 D VDD NW g45p1svt m=1 l=45n w=215n
Mmp52 n41 qbint n43 NW g45p1svt m=1 l=45n w=215n
Mmp51 n43 RNb VDD NW g45p1svt m=1 l=45n w=215n
Mmp57 QN qint VDD NW g45p1svt m=1 l=45n w=390n
Mmp55 Q qbint VDD NW g45p1svt m=1 l=45n w=390n
Mmp36 n20 CKb n31 NW g45p1svt m=1 l=45n w=215n
Mmp35 n31 mout VDD NW g45p1svt m=1 l=45n w=215n
Mmp32 mout n20 net402 NW g45p1svt m=1 l=45n w=215n
Mmp31 net402 RNb VDD NW g45p1svt m=1 l=45n w=215n
Mmp22 RNb RN VDD NW g45p1svt m=1 l=45n w=215n
Mmp20 CKb CK VDD NW g45p1svt m=1 l=45n w=215n
Mmp53 n35 CKbb n41 NW g45p1svt m=1 l=45n w=215n
Mmp50 n41 SN VDD NW g45p1svt m=1 l=45n w=215n
Mmp45 qbint n35 VDD NW g45p1svt m=1 l=45n w=215n
Mmp56 qint qbint VDD NW g45p1svt m=1 l=45n w=215n
Mmp21 CKbb CKb VDD NW g45p1svt m=1 l=45n w=215n
Mmp30 mout SN VDD NW g45p1svt m=1 l=45n w=215n
Mmp40 n35 CKb mout NW g45p1svt m=1 l=45n w=215n
.ENDS

.SUBCKT DFFSRX2 CK D NW Q QN RN SN VDD VSS
*.PININFO CK:I D:I NW:I RN:I SN:I VDD:I VSS:I Q:O QN:O
Mmn26 n20 CKb n21 VSS g45n1svt m=1 l=45n w=145n
Mmn25 n21 D VSS VSS g45n1svt m=1 l=45n w=145n
Mmn57 QN qint VSS VSS g45n1svt m=1 l=45n w=520n
Mmn55 Q qbint VSS VSS g45n1svt m=1 l=45n w=520n
Mmn35 n30 mout VSS VSS g45n1svt m=1 l=45n w=145n
Mmn36 n20 CKbb n30 VSS g45n1svt m=1 l=45n w=145n
Mmn22 RNb RN VSS VSS g45n1svt m=1 l=45n w=145n
Mmn20 CKb CK VSS VSS g45n1svt m=1 l=45n w=145n
Mmn45 qbint n35 VSS VSS g45n1svt m=1 l=45n w=205n
Mmn56 qint qbint VSS VSS g45n1svt m=1 l=45n w=145n
Mmn52 n40 qbint n42 VSS g45n1svt m=1 l=45n w=145n
Mmn51 n40 RNb n42 VSS g45n1svt m=1 l=45n w=145n
Mmn50 n42 SN VSS VSS g45n1svt m=1 l=45n w=145n
Mmn53 n35 CKb n40 VSS g45n1svt m=1 l=45n w=145n
Mmn21 CKbb CKb VSS VSS g45n1svt m=1 l=45n w=145n
Mmn32 mout n20 net426 VSS g45n1svt m=1 l=45n w=145n
Mmn31 mout RNb net426 VSS g45n1svt m=1 l=45n w=145n
Mmn40 n35 CKbb mout VSS g45n1svt m=1 l=45n w=145n
Mmn30 net426 SN VSS VSS g45n1svt m=1 l=45n w=145n
Mmp26 n20 CKbb n22 NW g45p1svt m=1 l=45n w=215n
Mmp25 n22 D VDD NW g45p1svt m=1 l=45n w=215n
Mmp52 n41 qbint n43 NW g45p1svt m=1 l=45n w=215n
Mmp51 n43 RNb VDD NW g45p1svt m=1 l=45n w=215n
Mmp57 QN qint VDD NW g45p1svt m=1 l=45n w=780n
Mmp55 Q qbint VDD NW g45p1svt m=1 l=45n w=780n
Mmp36 n20 CKb n31 NW g45p1svt m=1 l=45n w=215n
Mmp35 n31 mout VDD NW g45p1svt m=1 l=45n w=215n
Mmp32 mout n20 net402 NW g45p1svt m=1 l=45n w=215n
Mmp31 net402 RNb VDD NW g45p1svt m=1 l=45n w=215n
Mmp22 RNb RN VDD NW g45p1svt m=1 l=45n w=215n
Mmp20 CKb CK VDD NW g45p1svt m=1 l=45n w=215n
Mmp53 n35 CKbb n41 NW g45p1svt m=1 l=45n w=215n
Mmp50 n41 SN VDD NW g45p1svt m=1 l=45n w=215n
Mmp45 qbint n35 VDD NW g45p1svt m=1 l=45n w=310n
Mmp56 qint qbint VDD NW g45p1svt m=1 l=45n w=215n
Mmp21 CKbb CKb VDD NW g45p1svt m=1 l=45n w=215n
Mmp30 mout SN VDD NW g45p1svt m=1 l=45n w=215n
Mmp40 n35 CKb mout NW g45p1svt m=1 l=45n w=215n
.ENDS

.SUBCKT DFFSRX4 CK D NW Q QN RN SN VDD VSS
*.PININFO CK:I D:I NW:I RN:I SN:I VDD:I VSS:I Q:O QN:O
Mmn26 n20 CKb n21 VSS g45n1svt m=1 l=45n w=145n
Mmn25 n21 D VSS VSS g45n1svt m=1 l=45n w=145n
Mmn57 QN qint VSS VSS g45n1svt m=1 l=45n w=1.04u
Mmn55 Q qbint VSS VSS g45n1svt m=1 l=45n w=1.04u
Mmn35 n30 mout VSS VSS g45n1svt m=1 l=45n w=145n
Mmn36 n20 CKbb n30 VSS g45n1svt m=1 l=45n w=145n
Mmn22 RNb RN VSS VSS g45n1svt m=1 l=45n w=145n
Mmn20 CKb CK VSS VSS g45n1svt m=1 l=45n w=145n
Mmn45 qbint n35 VSS VSS g45n1svt m=1 l=45n w=410n
Mmn56 qint qbint VSS VSS g45n1svt m=1 l=45n w=260n
Mmn52 n40 qbint n42 VSS g45n1svt m=1 l=45n w=145n
Mmn51 n40 RNb n42 VSS g45n1svt m=1 l=45n w=145n
Mmn50 n42 SN VSS VSS g45n1svt m=1 l=45n w=145n
Mmn53 n35 CKb n40 VSS g45n1svt m=1 l=45n w=145n
Mmn21 CKbb CKb VSS VSS g45n1svt m=1 l=45n w=145n
Mmn32 mout n20 net426 VSS g45n1svt m=1 l=45n w=145n
Mmn31 mout RNb net426 VSS g45n1svt m=1 l=45n w=145n
Mmn40 n35 CKbb mout VSS g45n1svt m=1 l=45n w=145n
Mmn30 net426 SN VSS VSS g45n1svt m=1 l=45n w=145n
Mmp26 n20 CKbb n22 NW g45p1svt m=1 l=45n w=215n
Mmp25 n22 D VDD NW g45p1svt m=1 l=45n w=215n
Mmp52 n41 qbint n43 NW g45p1svt m=1 l=45n w=215n
Mmp51 n43 RNb VDD NW g45p1svt m=1 l=45n w=215n
Mmp57 QN qint VDD NW g45p1svt m=1 l=45n w=1.56u
Mmp55 Q qbint VDD NW g45p1svt m=1 l=45n w=1.56u
Mmp36 n20 CKb n31 NW g45p1svt m=1 l=45n w=215n
Mmp35 n31 mout VDD NW g45p1svt m=1 l=45n w=215n
Mmp32 mout n20 net402 NW g45p1svt m=1 l=45n w=215n
Mmp31 net402 RNb VDD NW g45p1svt m=1 l=45n w=215n
Mmp22 RNb RN VDD NW g45p1svt m=1 l=45n w=215n
Mmp20 CKb CK VDD NW g45p1svt m=1 l=45n w=215n
Mmp53 n35 CKbb n41 NW g45p1svt m=1 l=45n w=215n
Mmp50 n41 SN VDD NW g45p1svt m=1 l=45n w=215n
Mmp45 qbint n35 VDD NW g45p1svt m=1 l=45n w=620n
Mmp56 qint qbint VDD NW g45p1svt m=1 l=45n w=390n
Mmp21 CKbb CKb VDD NW g45p1svt m=1 l=45n w=215n
Mmp30 mout SN VDD NW g45p1svt m=1 l=45n w=215n
Mmp40 n35 CKb mout NW g45p1svt m=1 l=45n w=215n
.ENDS

.SUBCKT DFFSRXL CK D NW Q QN RN SN VDD VSS
*.PININFO CK:I D:I NW:I RN:I SN:I VDD:I VSS:I Q:O QN:O
Mmn26 n20 CKb n21 VSS g45n1svt m=1 l=45n w=145n
Mmn25 n21 D VSS VSS g45n1svt m=1 l=45n w=145n
Mmn57 QN qint VSS VSS g45n1svt m=1 l=45n w=145n
Mmn55 Q qbint VSS VSS g45n1svt m=1 l=45n w=145n
Mmn35 n30 mout VSS VSS g45n1svt m=1 l=45n w=145n
Mmn36 n20 CKbb n30 VSS g45n1svt m=1 l=45n w=145n
Mmn22 RNb RN VSS VSS g45n1svt m=1 l=45n w=145n
Mmn20 CKb CK VSS VSS g45n1svt m=1 l=45n w=145n
Mmn45 qbint n35 VSS VSS g45n1svt m=1 l=45n w=145n
Mmn56 qint qbint VSS VSS g45n1svt m=1 l=45n w=145n
Mmn52 n40 qbint n42 VSS g45n1svt m=1 l=45n w=145n
Mmn51 n40 RNb n42 VSS g45n1svt m=1 l=45n w=145n
Mmn50 n42 SN VSS VSS g45n1svt m=1 l=45n w=145n
Mmn53 n35 CKb n40 VSS g45n1svt m=1 l=45n w=145n
Mmn21 CKbb CKb VSS VSS g45n1svt m=1 l=45n w=145n
Mmn32 mout n20 net426 VSS g45n1svt m=1 l=45n w=145n
Mmn31 mout RNb net426 VSS g45n1svt m=1 l=45n w=145n
Mmn40 n35 CKbb mout VSS g45n1svt m=1 l=45n w=145n
Mmn30 net426 SN VSS VSS g45n1svt m=1 l=45n w=145n
Mmp26 n20 CKbb n22 NW g45p1svt m=1 l=45n w=215n
Mmp25 n22 D VDD NW g45p1svt m=1 l=45n w=215n
Mmp52 n41 qbint n43 NW g45p1svt m=1 l=45n w=215n
Mmp51 n43 RNb VDD NW g45p1svt m=1 l=45n w=215n
Mmp57 QN qint VDD NW g45p1svt m=1 l=45n w=215n
Mmp55 Q qbint VDD NW g45p1svt m=1 l=45n w=215n
Mmp36 n20 CKb n31 NW g45p1svt m=1 l=45n w=215n
Mmp35 n31 mout VDD NW g45p1svt m=1 l=45n w=215n
Mmp32 mout n20 net402 NW g45p1svt m=1 l=45n w=215n
Mmp31 net402 RNb VDD NW g45p1svt m=1 l=45n w=215n
Mmp22 RNb RN VDD NW g45p1svt m=1 l=45n w=215n
Mmp20 CKb CK VDD NW g45p1svt m=1 l=45n w=215n
Mmp53 n35 CKbb n41 NW g45p1svt m=1 l=45n w=215n
Mmp50 n41 SN VDD NW g45p1svt m=1 l=45n w=215n
Mmp45 qbint n35 VDD NW g45p1svt m=1 l=45n w=215n
Mmp56 qint qbint VDD NW g45p1svt m=1 l=45n w=215n
Mmp21 CKbb CKb VDD NW g45p1svt m=1 l=45n w=215n
Mmp30 mout SN VDD NW g45p1svt m=1 l=45n w=215n
Mmp40 n35 CKb mout NW g45p1svt m=1 l=45n w=215n
.ENDS

.SUBCKT DFFSX1 CK D NW Q QN SN VDD VSS
*.PININFO CK:I D:I NW:I SN:I VDD:I VSS:I Q:O QN:O
Mmn51 n40 qbint n42 VSS g45n1svt m=1 l=45n w=145n
Mmn52 n35 CKb n40 VSS g45n1svt m=1 l=45n w=145n
Mmn50 n42 SN VSS VSS g45n1svt m=1 l=45n w=145n
Mmn26 n20 CKb n21 VSS g45n1svt m=1 l=45n w=145n
Mmn25 n21 D VSS VSS g45n1svt m=1 l=45n w=145n
Mmn57 QN net331 VSS VSS g45n1svt m=1 l=45n w=260n
Mmn55 Q qbint VSS VSS g45n1svt m=1 l=45n w=260n
Mmn30 n25 SN VSS VSS g45n1svt m=1 l=45n w=145n
Mmn31 mout n20 n25 VSS g45n1svt m=1 l=45n w=145n
Mmn35 n20 CKbb n30 VSS g45n1svt m=1 l=45n w=145n
Mmn36 n30 mout VSS VSS g45n1svt m=1 l=45n w=145n
Mmn56 net331 qbint VSS VSS g45n1svt m=1 l=45n w=145n
Mmn20 CKb CK VSS VSS g45n1svt m=1 l=45n w=145n
Mmn21 CKbb CKb VSS VSS g45n1svt m=1 l=45n w=145n
Mmn45 qbint n35 VSS VSS g45n1svt m=1 l=45n w=145n
Mmn40 n35 CKbb mout VSS g45n1svt m=1 l=45n w=145n
Mmp26 n20 CKbb n22 NW g45p1svt m=1 l=45n w=215n
Mmp25 n22 D VDD NW g45p1svt m=1 l=45n w=215n
Mmp57 QN net331 VDD NW g45p1svt m=1 l=45n w=390n
Mmp55 Q qbint VDD NW g45p1svt m=1 l=45n w=390n
Mmp36 n20 CKb n31 NW g45p1svt m=1 l=45n w=215n
Mmp35 n31 mout VDD NW g45p1svt m=1 l=45n w=215n
Mmp20 CKb CK VDD NW g45p1svt m=1 l=45n w=215n
Mmp31 mout n20 VDD NW g45p1svt m=1 l=45n w=215n
Mmp40 n35 CKb mout NW g45p1svt m=1 l=45n w=215n
Mmp56 net331 qbint VDD NW g45p1svt m=1 l=45n w=215n
Mmp45 qbint n35 VDD NW g45p1svt m=1 l=45n w=215n
Mmp52 n35 CKbb n41 NW g45p1svt m=1 l=45n w=215n
Mmp21 CKbb CKb VDD NW g45p1svt m=1 l=45n w=215n
Mmp30 mout SN VDD NW g45p1svt m=1 l=45n w=215n
Mmp51 n41 qbint VDD NW g45p1svt m=1 l=45n w=215n
Mmp50 n41 SN VDD NW g45p1svt m=1 l=45n w=215n
.ENDS

.SUBCKT DFFSX2 CK D NW Q QN SN VDD VSS
*.PININFO CK:I D:I NW:I SN:I VDD:I VSS:I Q:O QN:O
Mmn51 n40 qbint n42 VSS g45n1svt m=1 l=45n w=145n
Mmn52 n35 CKb n40 VSS g45n1svt m=1 l=45n w=145n
Mmn50 n42 SN VSS VSS g45n1svt m=1 l=45n w=145n
Mmn26 n20 CKb n21 VSS g45n1svt m=1 l=45n w=145n
Mmn25 n21 D VSS VSS g45n1svt m=1 l=45n w=145n
Mmn57 QN net331 VSS VSS g45n1svt m=1 l=45n w=520n
Mmn55 Q qbint VSS VSS g45n1svt m=1 l=45n w=520n
Mmn30 n25 SN VSS VSS g45n1svt m=1 l=45n w=145n
Mmn31 mout n20 n25 VSS g45n1svt m=1 l=45n w=145n
Mmn35 n20 CKbb n30 VSS g45n1svt m=1 l=45n w=145n
Mmn36 n30 mout VSS VSS g45n1svt m=1 l=45n w=145n
Mmn56 net331 qbint VSS VSS g45n1svt m=1 l=45n w=145n
Mmn20 CKb CK VSS VSS g45n1svt m=1 l=45n w=145n
Mmn21 CKbb CKb VSS VSS g45n1svt m=1 l=45n w=145n
Mmn45 qbint n35 VSS VSS g45n1svt m=1 l=45n w=205n
Mmn40 n35 CKbb mout VSS g45n1svt m=1 l=45n w=145n
Mmp26 n20 CKbb n22 NW g45p1svt m=1 l=45n w=215n
Mmp25 n22 D VDD NW g45p1svt m=1 l=45n w=215n
Mmp57 QN net331 VDD NW g45p1svt m=1 l=45n w=780n
Mmp55 Q qbint VDD NW g45p1svt m=1 l=45n w=780n
Mmp36 n20 CKb n31 NW g45p1svt m=1 l=45n w=215n
Mmp35 n31 mout VDD NW g45p1svt m=1 l=45n w=215n
Mmp20 CKb CK VDD NW g45p1svt m=1 l=45n w=215n
Mmp31 mout n20 VDD NW g45p1svt m=1 l=45n w=215n
Mmp40 n35 CKb mout NW g45p1svt m=1 l=45n w=215n
Mmp56 net331 qbint VDD NW g45p1svt m=1 l=45n w=215n
Mmp45 qbint n35 VDD NW g45p1svt m=1 l=45n w=310n
Mmp52 n35 CKbb n41 NW g45p1svt m=1 l=45n w=215n
Mmp21 CKbb CKb VDD NW g45p1svt m=1 l=45n w=215n
Mmp30 mout SN VDD NW g45p1svt m=1 l=45n w=215n
Mmp51 n41 qbint VDD NW g45p1svt m=1 l=45n w=215n
Mmp50 n41 SN VDD NW g45p1svt m=1 l=45n w=215n
.ENDS

.SUBCKT DFFSX4 CK D NW Q QN SN VDD VSS
*.PININFO CK:I D:I NW:I SN:I VDD:I VSS:I Q:O QN:O
Mmn51 n40 qbint n42 VSS g45n1svt m=1 l=45n w=145n
Mmn52 n35 CKb n40 VSS g45n1svt m=1 l=45n w=145n
Mmn50 n42 SN VSS VSS g45n1svt m=1 l=45n w=145n
Mmn26 n20 CKb n21 VSS g45n1svt m=1 l=45n w=145n
Mmn25 n21 D VSS VSS g45n1svt m=1 l=45n w=145n
Mmn57 QN net331 VSS VSS g45n1svt m=1 l=45n w=1.04u
Mmn55 Q qbint VSS VSS g45n1svt m=1 l=45n w=1.04u
Mmn30 n25 SN VSS VSS g45n1svt m=1 l=45n w=145n
Mmn31 mout n20 n25 VSS g45n1svt m=1 l=45n w=145n
Mmn35 n20 CKbb n30 VSS g45n1svt m=1 l=45n w=145n
Mmn36 n30 mout VSS VSS g45n1svt m=1 l=45n w=145n
Mmn56 net331 qbint VSS VSS g45n1svt m=1 l=45n w=260n
Mmn20 CKb CK VSS VSS g45n1svt m=1 l=45n w=145n
Mmn21 CKbb CKb VSS VSS g45n1svt m=1 l=45n w=145n
Mmn45 qbint n35 VSS VSS g45n1svt m=1 l=45n w=410n
Mmn40 n35 CKbb mout VSS g45n1svt m=1 l=45n w=145n
Mmp26 n20 CKbb n22 NW g45p1svt m=1 l=45n w=215n
Mmp25 n22 D VDD NW g45p1svt m=1 l=45n w=215n
Mmp57 QN net331 VDD NW g45p1svt m=1 l=45n w=1.56u
Mmp55 Q qbint VDD NW g45p1svt m=1 l=45n w=1.56u
Mmp36 n20 CKb n31 NW g45p1svt m=1 l=45n w=215n
Mmp35 n31 mout VDD NW g45p1svt m=1 l=45n w=215n
Mmp20 CKb CK VDD NW g45p1svt m=1 l=45n w=215n
Mmp31 mout n20 VDD NW g45p1svt m=1 l=45n w=215n
Mmp40 n35 CKb mout NW g45p1svt m=1 l=45n w=215n
Mmp56 net331 qbint VDD NW g45p1svt m=1 l=45n w=390n
Mmp45 qbint n35 VDD NW g45p1svt m=1 l=45n w=620n
Mmp52 n35 CKbb n41 NW g45p1svt m=1 l=45n w=215n
Mmp21 CKbb CKb VDD NW g45p1svt m=1 l=45n w=215n
Mmp30 mout SN VDD NW g45p1svt m=1 l=45n w=215n
Mmp51 n41 qbint VDD NW g45p1svt m=1 l=45n w=215n
Mmp50 n41 SN VDD NW g45p1svt m=1 l=45n w=215n
.ENDS

.SUBCKT DFFSXL CK D NW Q QN SN VDD VSS
*.PININFO CK:I D:I NW:I SN:I VDD:I VSS:I Q:O QN:O
Mmn51 n40 qbint n42 VSS g45n1svt m=1 l=45n w=145n
Mmn52 n35 CKb n40 VSS g45n1svt m=1 l=45n w=145n
Mmn50 n42 SN VSS VSS g45n1svt m=1 l=45n w=145n
Mmn26 n20 CKb n21 VSS g45n1svt m=1 l=45n w=145n
Mmn25 n21 D VSS VSS g45n1svt m=1 l=45n w=145n
Mmn57 QN net331 VSS VSS g45n1svt m=1 l=45n w=145n
Mmn55 Q qbint VSS VSS g45n1svt m=1 l=45n w=145n
Mmn30 n25 SN VSS VSS g45n1svt m=1 l=45n w=145n
Mmn31 mout n20 n25 VSS g45n1svt m=1 l=45n w=145n
Mmn35 n20 CKbb n30 VSS g45n1svt m=1 l=45n w=145n
Mmn36 n30 mout VSS VSS g45n1svt m=1 l=45n w=145n
Mmn56 net331 qbint VSS VSS g45n1svt m=1 l=45n w=145n
Mmn20 CKb CK VSS VSS g45n1svt m=1 l=45n w=145n
Mmn21 CKbb CKb VSS VSS g45n1svt m=1 l=45n w=145n
Mmn45 qbint n35 VSS VSS g45n1svt m=1 l=45n w=145n
Mmn40 n35 CKbb mout VSS g45n1svt m=1 l=45n w=145n
Mmp26 n20 CKbb n22 NW g45p1svt m=1 l=45n w=215n
Mmp25 n22 D VDD NW g45p1svt m=1 l=45n w=215n
Mmp57 QN net331 VDD NW g45p1svt m=1 l=45n w=215n
Mmp55 Q qbint VDD NW g45p1svt m=1 l=45n w=215n
Mmp36 n20 CKb n31 NW g45p1svt m=1 l=45n w=215n
Mmp35 n31 mout VDD NW g45p1svt m=1 l=45n w=215n
Mmp20 CKb CK VDD NW g45p1svt m=1 l=45n w=215n
Mmp31 mout n20 VDD NW g45p1svt m=1 l=45n w=215n
Mmp40 n35 CKb mout NW g45p1svt m=1 l=45n w=215n
Mmp56 net331 qbint VDD NW g45p1svt m=1 l=45n w=215n
Mmp45 qbint n35 VDD NW g45p1svt m=1 l=45n w=215n
Mmp52 n35 CKbb n41 NW g45p1svt m=1 l=45n w=215n
Mmp21 CKbb CKb VDD NW g45p1svt m=1 l=45n w=215n
Mmp30 mout SN VDD NW g45p1svt m=1 l=45n w=215n
Mmp51 n41 qbint VDD NW g45p1svt m=1 l=45n w=215n
Mmp50 n41 SN VDD NW g45p1svt m=1 l=45n w=215n
.ENDS

.SUBCKT DFFTRX1 CK D NW Q QN RN VDD VSS
*.PININFO CK:I D:I NW:I RN:I VDD:I VSS:I Q:O QN:O
Mmn0 n0 RN VSS VSS g45n1svt m=1 l=45n w=145n
Mmn1 Db D n0 VSS g45n1svt m=1 l=45n w=145n
Mmn57 QN qint VSS VSS g45n1svt m=1 l=45n w=260n
Mmn55 Q qbint VSS VSS g45n1svt m=1 l=45n w=260n
Mmn50 n35 qbint VSS VSS g45n1svt m=1 l=45n w=145n
Mmn51 n30 CKb n35 VSS g45n1svt m=1 l=45n w=145n
Mmn25 n20 CKb Db VSS g45n1svt m=1 l=45n w=145n
Mmn20 CKb CK VSS VSS g45n1svt m=1 l=45n w=145n
Mmn35 n25 mout VSS VSS g45n1svt m=1 l=45n w=145n
Mmn21 CKbb CKb VSS VSS g45n1svt m=1 l=45n w=145n
Mmn36 n20 CKbb n25 VSS g45n1svt m=1 l=45n w=145n
Mmn40 n30 CKbb mout VSS g45n1svt m=1 l=45n w=145n
Mmn30 mout n20 VSS VSS g45n1svt m=1 l=45n w=145n
Mmn56 qint qbint VSS VSS g45n1svt m=1 l=45n w=145n
Mmn45 qbint n30 VSS VSS g45n1svt m=1 l=45n w=145n
Mmp1 Db D VDD NW g45p1svt m=1 l=45n w=215n
Mmp0 Db RN VDD NW g45p1svt m=1 l=45n w=215n
Mmp51 n30 CKbb n36 NW g45p1svt m=1 l=45n w=215n
Mmp50 n36 qbint VDD NW g45p1svt m=1 l=45n w=215n
Mmp57 QN qint VDD NW g45p1svt m=1 l=45n w=390n
Mmp55 Q qbint VDD NW g45p1svt m=1 l=45n w=390n
Mmp35 n26 mout VDD NW g45p1svt m=1 l=45n w=215n
Mmp56 qint qbint VDD NW g45p1svt m=1 l=45n w=215n
Mmp20 CKb CK VDD NW g45p1svt m=1 l=45n w=215n
Mmp36 n20 CKb n26 NW g45p1svt m=1 l=45n w=215n
Mmp45 qbint n30 VDD NW g45p1svt m=1 l=45n w=215n
Mmp30 mout n20 VDD NW g45p1svt m=1 l=45n w=215n
Mmp40 n30 CKb mout NW g45p1svt m=1 l=45n w=215n
Mmp21 CKbb CKb VDD NW g45p1svt m=1 l=45n w=215n
Mmp25 n20 CKbb Db NW g45p1svt m=1 l=45n w=215n
.ENDS

.SUBCKT DFFTRX2 CK D NW Q QN RN VDD VSS
*.PININFO CK:I D:I NW:I RN:I VDD:I VSS:I Q:O QN:O
Mmn0 n0 RN VSS VSS g45n1svt m=1 l=45n w=145n
Mmn1 Db D n0 VSS g45n1svt m=1 l=45n w=145n
Mmn57 QN qint VSS VSS g45n1svt m=1 l=45n w=520n
Mmn55 Q qbint VSS VSS g45n1svt m=1 l=45n w=520n
Mmn50 n35 qbint VSS VSS g45n1svt m=1 l=45n w=145n
Mmn51 n30 CKb n35 VSS g45n1svt m=1 l=45n w=145n
Mmn25 n20 CKb Db VSS g45n1svt m=1 l=45n w=145n
Mmn20 CKb CK VSS VSS g45n1svt m=1 l=45n w=145n
Mmn35 n25 mout VSS VSS g45n1svt m=1 l=45n w=145n
Mmn21 CKbb CKb VSS VSS g45n1svt m=1 l=45n w=145n
Mmn36 n20 CKbb n25 VSS g45n1svt m=1 l=45n w=145n
Mmn40 n30 CKbb mout VSS g45n1svt m=1 l=45n w=145n
Mmn30 mout n20 VSS VSS g45n1svt m=1 l=45n w=145n
Mmn56 qint qbint VSS VSS g45n1svt m=1 l=45n w=145n
Mmn45 qbint n30 VSS VSS g45n1svt m=1 l=45n w=205n
Mmp1 Db D VDD NW g45p1svt m=1 l=45n w=215n
Mmp0 Db RN VDD NW g45p1svt m=1 l=45n w=215n
Mmp51 n30 CKbb n36 NW g45p1svt m=1 l=45n w=215n
Mmp50 n36 qbint VDD NW g45p1svt m=1 l=45n w=215n
Mmp57 QN qint VDD NW g45p1svt m=1 l=45n w=780n
Mmp55 Q qbint VDD NW g45p1svt m=1 l=45n w=780n
Mmp35 n26 mout VDD NW g45p1svt m=1 l=45n w=215n
Mmp56 qint qbint VDD NW g45p1svt m=1 l=45n w=215n
Mmp20 CKb CK VDD NW g45p1svt m=1 l=45n w=215n
Mmp36 n20 CKb n26 NW g45p1svt m=1 l=45n w=215n
Mmp45 qbint n30 VDD NW g45p1svt m=1 l=45n w=310n
Mmp30 mout n20 VDD NW g45p1svt m=1 l=45n w=215n
Mmp40 n30 CKb mout NW g45p1svt m=1 l=45n w=215n
Mmp21 CKbb CKb VDD NW g45p1svt m=1 l=45n w=215n
Mmp25 n20 CKbb Db NW g45p1svt m=1 l=45n w=215n
.ENDS

.SUBCKT DFFTRX4 CK D NW Q QN RN VDD VSS
*.PININFO CK:I D:I NW:I RN:I VDD:I VSS:I Q:O QN:O
Mmn0 n0 RN VSS VSS g45n1svt m=1 l=45n w=145n
Mmn1 Db D n0 VSS g45n1svt m=1 l=45n w=145n
Mmn57 QN qint VSS VSS g45n1svt m=1 l=45n w=1.04u
Mmn55 Q qbint VSS VSS g45n1svt m=1 l=45n w=1.04u
Mmn50 n35 qbint VSS VSS g45n1svt m=1 l=45n w=145n
Mmn51 n30 CKb n35 VSS g45n1svt m=1 l=45n w=145n
Mmn25 n20 CKb Db VSS g45n1svt m=1 l=45n w=145n
Mmn20 CKb CK VSS VSS g45n1svt m=1 l=45n w=145n
Mmn35 n25 mout VSS VSS g45n1svt m=1 l=45n w=145n
Mmn21 CKbb CKb VSS VSS g45n1svt m=1 l=45n w=145n
Mmn36 n20 CKbb n25 VSS g45n1svt m=1 l=45n w=145n
Mmn40 n30 CKbb mout VSS g45n1svt m=1 l=45n w=145n
Mmn30 mout n20 VSS VSS g45n1svt m=1 l=45n w=145n
Mmn56 qint qbint VSS VSS g45n1svt m=1 l=45n w=260n
Mmn45 qbint n30 VSS VSS g45n1svt m=1 l=45n w=410n
Mmp1 Db D VDD NW g45p1svt m=1 l=45n w=215n
Mmp0 Db RN VDD NW g45p1svt m=1 l=45n w=215n
Mmp51 n30 CKbb n36 NW g45p1svt m=1 l=45n w=215n
Mmp50 n36 qbint VDD NW g45p1svt m=1 l=45n w=215n
Mmp57 QN qint VDD NW g45p1svt m=1 l=45n w=1.56u
Mmp55 Q qbint VDD NW g45p1svt m=1 l=45n w=1.56u
Mmp35 n26 mout VDD NW g45p1svt m=1 l=45n w=215n
Mmp56 qint qbint VDD NW g45p1svt m=1 l=45n w=390n
Mmp20 CKb CK VDD NW g45p1svt m=1 l=45n w=215n
Mmp36 n20 CKb n26 NW g45p1svt m=1 l=45n w=215n
Mmp45 qbint n30 VDD NW g45p1svt m=1 l=45n w=620n
Mmp30 mout n20 VDD NW g45p1svt m=1 l=45n w=215n
Mmp40 n30 CKb mout NW g45p1svt m=1 l=45n w=215n
Mmp21 CKbb CKb VDD NW g45p1svt m=1 l=45n w=215n
Mmp25 n20 CKbb Db NW g45p1svt m=1 l=45n w=215n
.ENDS

.SUBCKT DFFTRXL CK D NW Q QN RN VDD VSS
*.PININFO CK:I D:I NW:I RN:I VDD:I VSS:I Q:O QN:O
Mmn0 n0 RN VSS VSS g45n1svt m=1 l=45n w=145n
Mmn1 Db D n0 VSS g45n1svt m=1 l=45n w=145n
Mmn57 QN qint VSS VSS g45n1svt m=1 l=45n w=145n
Mmn55 Q qbint VSS VSS g45n1svt m=1 l=45n w=145n
Mmn50 n35 qbint VSS VSS g45n1svt m=1 l=45n w=145n
Mmn51 n30 CKb n35 VSS g45n1svt m=1 l=45n w=145n
Mmn25 n20 CKb Db VSS g45n1svt m=1 l=45n w=145n
Mmn20 CKb CK VSS VSS g45n1svt m=1 l=45n w=145n
Mmn35 n25 mout VSS VSS g45n1svt m=1 l=45n w=145n
Mmn21 CKbb CKb VSS VSS g45n1svt m=1 l=45n w=145n
Mmn36 n20 CKbb n25 VSS g45n1svt m=1 l=45n w=145n
Mmn40 n30 CKbb mout VSS g45n1svt m=1 l=45n w=145n
Mmn30 mout n20 VSS VSS g45n1svt m=1 l=45n w=145n
Mmn56 qint qbint VSS VSS g45n1svt m=1 l=45n w=145n
Mmn45 qbint n30 VSS VSS g45n1svt m=1 l=45n w=145n
Mmp1 Db D VDD NW g45p1svt m=1 l=45n w=215n
Mmp0 Db RN VDD NW g45p1svt m=1 l=45n w=215n
Mmp51 n30 CKbb n36 NW g45p1svt m=1 l=45n w=215n
Mmp50 n36 qbint VDD NW g45p1svt m=1 l=45n w=215n
Mmp57 QN qint VDD NW g45p1svt m=1 l=45n w=215n
Mmp55 Q qbint VDD NW g45p1svt m=1 l=45n w=215n
Mmp35 n26 mout VDD NW g45p1svt m=1 l=45n w=215n
Mmp56 qint qbint VDD NW g45p1svt m=1 l=45n w=215n
Mmp20 CKb CK VDD NW g45p1svt m=1 l=45n w=215n
Mmp36 n20 CKb n26 NW g45p1svt m=1 l=45n w=215n
Mmp45 qbint n30 VDD NW g45p1svt m=1 l=45n w=215n
Mmp30 mout n20 VDD NW g45p1svt m=1 l=45n w=215n
Mmp40 n30 CKb mout NW g45p1svt m=1 l=45n w=215n
Mmp21 CKbb CKb VDD NW g45p1svt m=1 l=45n w=215n
Mmp25 n20 CKbb Db NW g45p1svt m=1 l=45n w=215n
.ENDS

.SUBCKT DFFX1 CK D NW Q QN VDD VSS
*.PININFO CK:I D:I NW:I VDD:I VSS:I Q:O QN:O
Mmn26 n20 CKb n21 VSS g45n1svt m=1 l=45n w=145n
Mmn25 n21 D VSS VSS g45n1svt m=1 l=45n w=145n
Mmn57 QN qint VSS VSS g45n1svt m=1 l=45n w=260n
Mmn55 Q qbint VSS VSS g45n1svt m=1 l=45n w=260n
Mmn50 n35 qbint VSS VSS g45n1svt m=1 l=45n w=145n
Mmn51 n30 CKb n35 VSS g45n1svt m=1 l=45n w=145n
Mmn35 n25 mout VSS VSS g45n1svt m=1 l=45n w=145n
Mmn36 n20 CKbb n25 VSS g45n1svt m=1 l=45n w=145n
Mmn20 CKb CK VSS VSS g45n1svt m=1 l=45n w=145n
Mmn45 qbint n30 VSS VSS g45n1svt m=1 l=45n w=145n
Mmn56 qint qbint VSS VSS g45n1svt m=1 l=45n w=145n
Mmn21 CKbb CKb VSS VSS g45n1svt m=1 l=45n w=145n
Mmn30 mout n20 VSS VSS g45n1svt m=1 l=45n w=145n
Mmn40 n30 CKbb mout VSS g45n1svt m=1 l=45n w=145n
Mmp26 n20 CKbb n22 NW g45p1svt m=1 l=45n w=215n
Mmp25 n22 D VDD NW g45p1svt m=1 l=45n w=215n
Mmp51 n30 CKbb n36 NW g45p1svt m=1 l=45n w=215n
Mmp50 n36 qbint VDD NW g45p1svt m=1 l=45n w=215n
Mmp57 QN qint VDD NW g45p1svt m=1 l=45n w=390n
Mmp55 Q qbint VDD NW g45p1svt m=1 l=45n w=390n
Mmp35 n26 mout VDD NW g45p1svt m=1 l=45n w=215n
Mmp36 n20 CKb n26 NW g45p1svt m=1 l=45n w=215n
Mmp20 CKb CK VDD NW g45p1svt m=1 l=45n w=215n
Mmp45 qbint n30 VDD NW g45p1svt m=1 l=45n w=215n
Mmp56 qint qbint VDD NW g45p1svt m=1 l=45n w=215n
Mmp21 CKbb CKb VDD NW g45p1svt m=1 l=45n w=215n
Mmp40 n30 CKb mout NW g45p1svt m=1 l=45n w=215n
Mmp30 mout n20 VDD NW g45p1svt m=1 l=45n w=215n
.ENDS

.SUBCKT DFFX2 CK D NW Q QN VDD VSS
*.PININFO CK:I D:I NW:I VDD:I VSS:I Q:O QN:O
Mmn26 n20 CKb n21 VSS g45n1svt m=1 l=45n w=145n
Mmn25 n21 D VSS VSS g45n1svt m=1 l=45n w=145n
Mmn57 QN qint VSS VSS g45n1svt m=1 l=45n w=520n
Mmn55 Q qbint VSS VSS g45n1svt m=1 l=45n w=520n
Mmn50 n35 qbint VSS VSS g45n1svt m=1 l=45n w=145n
Mmn51 n30 CKb n35 VSS g45n1svt m=1 l=45n w=145n
Mmn35 n25 mout VSS VSS g45n1svt m=1 l=45n w=145n
Mmn36 n20 CKbb n25 VSS g45n1svt m=1 l=45n w=145n
Mmn20 CKb CK VSS VSS g45n1svt m=1 l=45n w=145n
Mmn45 qbint n30 VSS VSS g45n1svt m=1 l=45n w=205n
Mmn56 qint qbint VSS VSS g45n1svt m=1 l=45n w=145n
Mmn21 CKbb CKb VSS VSS g45n1svt m=1 l=45n w=145n
Mmn30 mout n20 VSS VSS g45n1svt m=1 l=45n w=145n
Mmn40 n30 CKbb mout VSS g45n1svt m=1 l=45n w=145n
Mmp26 n20 CKbb n22 NW g45p1svt m=1 l=45n w=215n
Mmp25 n22 D VDD NW g45p1svt m=1 l=45n w=215n
Mmp51 n30 CKbb n36 NW g45p1svt m=1 l=45n w=215n
Mmp50 n36 qbint VDD NW g45p1svt m=1 l=45n w=215n
Mmp57 QN qint VDD NW g45p1svt m=1 l=45n w=780n
Mmp55 Q qbint VDD NW g45p1svt m=1 l=45n w=780n
Mmp35 n26 mout VDD NW g45p1svt m=1 l=45n w=215n
Mmp36 n20 CKb n26 NW g45p1svt m=1 l=45n w=215n
Mmp20 CKb CK VDD NW g45p1svt m=1 l=45n w=215n
Mmp45 qbint n30 VDD NW g45p1svt m=1 l=45n w=310n
Mmp56 qint qbint VDD NW g45p1svt m=1 l=45n w=215n
Mmp21 CKbb CKb VDD NW g45p1svt m=1 l=45n w=215n
Mmp40 n30 CKb mout NW g45p1svt m=1 l=45n w=215n
Mmp30 mout n20 VDD NW g45p1svt m=1 l=45n w=215n
.ENDS

.SUBCKT DFFX4 CK D NW Q QN VDD VSS
*.PININFO CK:I D:I NW:I VDD:I VSS:I Q:O QN:O
Mmn26 n20 CKb n21 VSS g45n1svt m=1 l=45n w=145n
Mmn25 n21 D VSS VSS g45n1svt m=1 l=45n w=145n
Mmn57 QN qint VSS VSS g45n1svt m=1 l=45n w=1.04u
Mmn55 Q qbint VSS VSS g45n1svt m=1 l=45n w=1.04u
Mmn50 n35 qbint VSS VSS g45n1svt m=1 l=45n w=145n
Mmn51 n30 CKb n35 VSS g45n1svt m=1 l=45n w=145n
Mmn35 n25 mout VSS VSS g45n1svt m=1 l=45n w=145n
Mmn36 n20 CKbb n25 VSS g45n1svt m=1 l=45n w=145n
Mmn20 CKb CK VSS VSS g45n1svt m=1 l=45n w=145n
Mmn45 qbint n30 VSS VSS g45n1svt m=1 l=45n w=410n
Mmn56 qint qbint VSS VSS g45n1svt m=1 l=45n w=260n
Mmn21 CKbb CKb VSS VSS g45n1svt m=1 l=45n w=145n
Mmn30 mout n20 VSS VSS g45n1svt m=1 l=45n w=145n
Mmn40 n30 CKbb mout VSS g45n1svt m=1 l=45n w=145n
Mmp26 n20 CKbb n22 NW g45p1svt m=1 l=45n w=215n
Mmp25 n22 D VDD NW g45p1svt m=1 l=45n w=215n
Mmp51 n30 CKbb n36 NW g45p1svt m=1 l=45n w=215n
Mmp50 n36 qbint VDD NW g45p1svt m=1 l=45n w=215n
Mmp57 QN qint VDD NW g45p1svt m=1 l=45n w=1.56u
Mmp55 Q qbint VDD NW g45p1svt m=1 l=45n w=1.56u
Mmp35 n26 mout VDD NW g45p1svt m=1 l=45n w=215n
Mmp36 n20 CKb n26 NW g45p1svt m=1 l=45n w=215n
Mmp20 CKb CK VDD NW g45p1svt m=1 l=45n w=215n
Mmp45 qbint n30 VDD NW g45p1svt m=1 l=45n w=620n
Mmp56 qint qbint VDD NW g45p1svt m=1 l=45n w=390n
Mmp21 CKbb CKb VDD NW g45p1svt m=1 l=45n w=215n
Mmp40 n30 CKb mout NW g45p1svt m=1 l=45n w=215n
Mmp30 mout n20 VDD NW g45p1svt m=1 l=45n w=215n
.ENDS

.SUBCKT DFFXL CK D NW Q QN VDD VSS
*.PININFO CK:I D:I NW:I VDD:I VSS:I Q:O QN:O
Mmn26 n20 CKb n21 VSS g45n1svt m=1 l=45n w=145n
Mmn25 n21 D VSS VSS g45n1svt m=1 l=45n w=145n
Mmn57 QN qint VSS VSS g45n1svt m=1 l=45n w=145n
Mmn55 Q qbint VSS VSS g45n1svt m=1 l=45n w=145n
Mmn50 n35 qbint VSS VSS g45n1svt m=1 l=45n w=145n
Mmn51 n30 CKb n35 VSS g45n1svt m=1 l=45n w=145n
Mmn35 n25 mout VSS VSS g45n1svt m=1 l=45n w=145n
Mmn36 n20 CKbb n25 VSS g45n1svt m=1 l=45n w=145n
Mmn20 CKb CK VSS VSS g45n1svt m=1 l=45n w=145n
Mmn45 qbint n30 VSS VSS g45n1svt m=1 l=45n w=145n
Mmn56 qint qbint VSS VSS g45n1svt m=1 l=45n w=145n
Mmn21 CKbb CKb VSS VSS g45n1svt m=1 l=45n w=145n
Mmn30 mout n20 VSS VSS g45n1svt m=1 l=45n w=145n
Mmn40 n30 CKbb mout VSS g45n1svt m=1 l=45n w=145n
Mmp26 n20 CKbb n22 NW g45p1svt m=1 l=45n w=215n
Mmp25 n22 D VDD NW g45p1svt m=1 l=45n w=215n
Mmp51 n30 CKbb n36 NW g45p1svt m=1 l=45n w=215n
Mmp50 n36 qbint VDD NW g45p1svt m=1 l=45n w=215n
Mmp57 QN qint VDD NW g45p1svt m=1 l=45n w=215n
Mmp55 Q qbint VDD NW g45p1svt m=1 l=45n w=215n
Mmp35 n26 mout VDD NW g45p1svt m=1 l=45n w=215n
Mmp36 n20 CKb n26 NW g45p1svt m=1 l=45n w=215n
Mmp20 CKb CK VDD NW g45p1svt m=1 l=45n w=215n
Mmp45 qbint n30 VDD NW g45p1svt m=1 l=45n w=215n
Mmp56 qint qbint VDD NW g45p1svt m=1 l=45n w=215n
Mmp21 CKbb CKb VDD NW g45p1svt m=1 l=45n w=215n
Mmp40 n30 CKb mout NW g45p1svt m=1 l=45n w=215n
Mmp30 mout n20 VDD NW g45p1svt m=1 l=45n w=215n
.ENDS

.SUBCKT DLY1X1 A NW VDD VSS Y
*.PININFO A:I NW:I VDD:I VSS:I Y:O
Mmn2 n1 VDD n4 VSS g45n1svt m=1 l=45n w=145n
Mmn1 n4 n0 VSS VSS g45n1svt m=1 l=45n w=145n
Mmn4 Y n2 VSS VSS g45n1svt m=1 l=45n w=260n
Mmn0 n0 A VSS VSS g45n1svt m=1 l=45n w=145n
Mmn3 n2 n1 VSS VSS g45n1svt m=1 l=45n w=145n
Mmp2 n1 VSS n5 NW g45p1svt m=1 l=45n w=215n
Mmp1 n5 n0 VDD NW g45p1svt m=1 l=45n w=215n
Mmp4 Y n2 VDD NW g45p1svt m=1 l=45n w=390n
Mmp0 n0 A VDD NW g45p1svt m=1 l=45n w=215n
Mmp3 n2 n1 VDD NW g45p1svt m=1 l=45n w=215n
.ENDS

.SUBCKT DLY1X4 A NW VDD VSS Y
*.PININFO A:I NW:I VDD:I VSS:I Y:O
Mmn2 n1 VDD n4 VSS g45n1svt m=1 l=45n w=145n
Mmn1 n4 n0 VSS VSS g45n1svt m=1 l=45n w=145n
Mmn4 Y n2 VSS VSS g45n1svt m=1 l=45n w=1.04u
Mmn0 n0 A VSS VSS g45n1svt m=1 l=45n w=145n
Mmn3 n2 n1 VSS VSS g45n1svt m=1 l=45n w=260n
Mmp2 n1 VSS n5 NW g45p1svt m=1 l=45n w=215n
Mmp1 n5 n0 VDD NW g45p1svt m=1 l=45n w=215n
Mmp4 Y n2 VDD NW g45p1svt m=1 l=45n w=1.56u
Mmp0 n0 A VDD NW g45p1svt m=1 l=45n w=215n
Mmp3 n2 n1 VDD NW g45p1svt m=1 l=45n w=390n
.ENDS

.SUBCKT DLY2X1 A NW VDD VSS Y
*.PININFO A:I NW:I VDD:I VSS:I Y:O
Mmn6 n3 VDD n10 VSS g45n1svt m=1 l=45n w=145n
Mmn5 n10 n2 VSS VSS g45n1svt m=1 l=45n w=145n
Mmn8 Y n4 VSS VSS g45n1svt m=1 l=45n w=260n
Mmn4 n2 VDD n8 VSS g45n1svt m=1 l=45n w=145n
Mmn3 n8 n1 VSS VSS g45n1svt m=1 l=45n w=145n
Mmn2 n1 VDD n6 VSS g45n1svt m=1 l=45n w=145n
Mmn1 n6 n0 VSS VSS g45n1svt m=1 l=45n w=145n
Mmn7 n4 n3 VSS VSS g45n1svt m=1 l=45n w=145n
Mmn0 n0 A VSS VSS g45n1svt m=1 l=45n w=145n
Mmp6 n3 VSS n11 NW g45p1svt m=1 l=45n w=215n
Mmp5 n11 n2 VDD NW g45p1svt m=1 l=45n w=215n
Mmp8 Y n4 VDD NW g45p1svt m=1 l=45n w=390n
Mmp4 n2 VSS n9 NW g45p1svt m=1 l=45n w=215n
Mmp3 n9 n1 VDD NW g45p1svt m=1 l=45n w=215n
Mmp2 n1 VSS n7 NW g45p1svt m=1 l=45n w=215n
Mmp1 n7 n0 VDD NW g45p1svt m=1 l=45n w=215n
Mmp7 n4 n3 VDD NW g45p1svt m=1 l=45n w=215n
Mmp0 n0 A VDD NW g45p1svt m=1 l=45n w=215n
.ENDS

.SUBCKT DLY2X4 A NW VDD VSS Y
*.PININFO A:I NW:I VDD:I VSS:I Y:O
Mmn6 n3 VDD n10 VSS g45n1svt m=1 l=45n w=145n
Mmn5 n10 n2 VSS VSS g45n1svt m=1 l=45n w=145n
Mmn8 Y n4 VSS VSS g45n1svt m=1 l=45n w=1.04u
Mmn4 n2 VDD n8 VSS g45n1svt m=1 l=45n w=145n
Mmn3 n8 n1 VSS VSS g45n1svt m=1 l=45n w=145n
Mmn2 n1 VDD n6 VSS g45n1svt m=1 l=45n w=145n
Mmn1 n6 n0 VSS VSS g45n1svt m=1 l=45n w=145n
Mmn7 n4 n3 VSS VSS g45n1svt m=1 l=45n w=260n
Mmn0 n0 A VSS VSS g45n1svt m=1 l=45n w=145n
Mmp6 n3 VSS n11 NW g45p1svt m=1 l=45n w=215n
Mmp5 n11 n2 VDD NW g45p1svt m=1 l=45n w=215n
Mmp8 Y n4 VDD NW g45p1svt m=1 l=45n w=1.56u
Mmp4 n2 VSS n9 NW g45p1svt m=1 l=45n w=215n
Mmp3 n9 n1 VDD NW g45p1svt m=1 l=45n w=215n
Mmp2 n1 VSS n7 NW g45p1svt m=1 l=45n w=215n
Mmp1 n7 n0 VDD NW g45p1svt m=1 l=45n w=215n
Mmp7 n4 n3 VDD NW g45p1svt m=1 l=45n w=390n
Mmp0 n0 A VDD NW g45p1svt m=1 l=45n w=215n
.ENDS

.SUBCKT DLY3X1 A NW VDD VSS Y
*.PININFO A:I NW:I VDD:I VSS:I Y:O
Mmn10 n5 VDD n15 VSS g45n1svt m=1 l=45n w=145n
Mmn9 n15 n4 VSS VSS g45n1svt m=1 l=45n w=145n
Mmn8 n4 VDD n13 VSS g45n1svt m=1 l=45n w=145n
Mmn7 n13 n3 VSS VSS g45n1svt m=1 l=45n w=145n
Mmn6 n3 VDD n11 VSS g45n1svt m=1 l=45n w=145n
Mmn5 n11 n2 VSS VSS g45n1svt m=1 l=45n w=145n
Mmn4 n2 VDD n9 VSS g45n1svt m=1 l=45n w=145n
Mmn3 n9 n1 VSS VSS g45n1svt m=1 l=45n w=145n
Mmn2 n1 VDD n7 VSS g45n1svt m=1 l=45n w=145n
Mmn1 n7 n0 VSS VSS g45n1svt m=1 l=45n w=145n
Mmn11 n6 n5 VSS VSS g45n1svt m=1 l=45n w=145n
Mmn12 Y n6 VSS VSS g45n1svt m=1 l=45n w=260n
Mmn0 n0 A VSS VSS g45n1svt m=1 l=45n w=145n
Mmp8 n4 VSS n14 NW g45p1svt m=1 l=45n w=215n
Mmp7 n14 n3 VDD NW g45p1svt m=1 l=45n w=215n
Mmp9 n16 n4 VDD NW g45p1svt m=1 l=45n w=215n
Mmp10 n5 VSS n16 NW g45p1svt m=1 l=45n w=215n
Mmp6 n3 VSS n12 NW g45p1svt m=1 l=45n w=215n
Mmp5 n12 n2 VDD NW g45p1svt m=1 l=45n w=215n
Mmp4 n2 VSS n10 NW g45p1svt m=1 l=45n w=215n
Mmp3 n10 n1 VDD NW g45p1svt m=1 l=45n w=215n
Mmp2 n1 VSS n8 NW g45p1svt m=1 l=45n w=215n
Mmp1 n8 n0 VDD NW g45p1svt m=1 l=45n w=215n
Mmp12 Y n6 VDD NW g45p1svt m=1 l=45n w=390n
Mmp0 n0 A VDD NW g45p1svt m=1 l=45n w=215n
Mmp11 n6 n5 VDD NW g45p1svt m=1 l=45n w=215n
.ENDS

.SUBCKT DLY3X4 A NW VDD VSS Y
*.PININFO A:I NW:I VDD:I VSS:I Y:O
Mmn10 n5 VDD n15 VSS g45n1svt m=1 l=45n w=145n
Mmn9 n15 n4 VSS VSS g45n1svt m=1 l=45n w=145n
Mmn8 n4 VDD n13 VSS g45n1svt m=1 l=45n w=145n
Mmn7 n13 n3 VSS VSS g45n1svt m=1 l=45n w=145n
Mmn6 n3 VDD n11 VSS g45n1svt m=1 l=45n w=145n
Mmn5 n11 n2 VSS VSS g45n1svt m=1 l=45n w=145n
Mmn4 n2 VDD n9 VSS g45n1svt m=1 l=45n w=145n
Mmn3 n9 n1 VSS VSS g45n1svt m=1 l=45n w=145n
Mmn2 n1 VDD n7 VSS g45n1svt m=1 l=45n w=145n
Mmn1 n7 n0 VSS VSS g45n1svt m=1 l=45n w=145n
Mmn11 n6 n5 VSS VSS g45n1svt m=1 l=45n w=260n
Mmn12 Y n6 VSS VSS g45n1svt m=1 l=45n w=1.04u
Mmn0 n0 A VSS VSS g45n1svt m=1 l=45n w=145n
Mmp8 n4 VSS n14 NW g45p1svt m=1 l=45n w=215n
Mmp7 n14 n3 VDD NW g45p1svt m=1 l=45n w=215n
Mmp9 n16 n4 VDD NW g45p1svt m=1 l=45n w=215n
Mmp10 n5 VSS n16 NW g45p1svt m=1 l=45n w=215n
Mmp6 n3 VSS n12 NW g45p1svt m=1 l=45n w=215n
Mmp5 n12 n2 VDD NW g45p1svt m=1 l=45n w=215n
Mmp4 n2 VSS n10 NW g45p1svt m=1 l=45n w=215n
Mmp3 n10 n1 VDD NW g45p1svt m=1 l=45n w=215n
Mmp2 n1 VSS n8 NW g45p1svt m=1 l=45n w=215n
Mmp1 n8 n0 VDD NW g45p1svt m=1 l=45n w=215n
Mmp12 Y n6 VDD NW g45p1svt m=1 l=45n w=1.56u
Mmp0 n0 A VDD NW g45p1svt m=1 l=45n w=215n
Mmp11 n6 n5 VDD NW g45p1svt m=1 l=45n w=390n
.ENDS

.SUBCKT DLY4X1 A NW VDD VSS Y
*.PININFO A:I NW:I VDD:I VSS:I Y:O
Mmn14 net345 VDD net341 VSS g45n1svt m=1 l=45n w=145n
Mmn13 net341 net353 VSS VSS g45n1svt m=1 l=45n w=145n
Mmn12 net353 VDD net349 VSS g45n1svt m=1 l=45n w=145n
Mmn11 net349 net361 VSS VSS g45n1svt m=1 l=45n w=145n
Mmn10 net361 VDD net357 VSS g45n1svt m=1 l=45n w=145n
Mmn9 net357 net369 VSS VSS g45n1svt m=1 l=45n w=145n
Mmn15 net333 net345 VSS VSS g45n1svt m=1 l=45n w=145n
Mmn6 net377 VDD net373 VSS g45n1svt m=1 l=45n w=145n
Mmn0 net397 A VSS VSS g45n1svt m=1 l=45n w=145n
Mmn4 net385 VDD net381 VSS g45n1svt m=1 l=45n w=145n
Mmn1 net389 net397 VSS VSS g45n1svt m=1 l=45n w=145n
Mmn7 net365 net377 VSS VSS g45n1svt m=1 l=45n w=145n
Mmn16 Y net333 VSS VSS g45n1svt m=1 l=45n w=260n
Mmn3 net381 net393 VSS VSS g45n1svt m=1 l=45n w=145n
Mmn2 net393 VDD net389 VSS g45n1svt m=1 l=45n w=145n
Mmn8 net369 VDD net365 VSS g45n1svt m=1 l=45n w=145n
Mmn5 net373 net385 VSS VSS g45n1svt m=1 l=45n w=145n
Mmp8 net369 VSS net300 NW g45p1svt m=1 l=45n w=215n
Mmp7 net300 net377 VDD NW g45p1svt m=1 l=45n w=215n
Mmp9 net292 net369 VDD NW g45p1svt m=1 l=45n w=215n
Mmp10 net361 VSS net292 NW g45p1svt m=1 l=45n w=215n
Mmp6 net377 VSS net308 NW g45p1svt m=1 l=45n w=215n
Mmp5 net308 net385 VDD NW g45p1svt m=1 l=45n w=215n
Mmp4 net385 VSS net316 NW g45p1svt m=1 l=45n w=215n
Mmp3 net316 net393 VDD NW g45p1svt m=1 l=45n w=215n
Mmp2 net393 VSS net324 NW g45p1svt m=1 l=45n w=215n
Mmp1 net324 net397 VDD NW g45p1svt m=1 l=45n w=215n
Mmp11 net284 net361 VDD NW g45p1svt m=1 l=45n w=215n
Mmp12 net353 VSS net284 NW g45p1svt m=1 l=45n w=215n
Mmp13 net276 net353 VDD NW g45p1svt m=1 l=45n w=215n
Mmp14 net345 VSS net276 NW g45p1svt m=1 l=45n w=215n
Mmp15 net333 net345 VDD NW g45p1svt m=1 l=45n w=215n
Mmp0 net397 A VDD NW g45p1svt m=1 l=45n w=215n
Mmp16 Y net333 VDD NW g45p1svt m=1 l=45n w=390n
.ENDS

.SUBCKT DLY4X4 A NW VDD VSS Y
*.PININFO A:I NW:I VDD:I VSS:I Y:O
Mmn14 net345 VDD net341 VSS g45n1svt m=1 l=45n w=145n
Mmn13 net341 net353 VSS VSS g45n1svt m=1 l=45n w=145n
Mmn12 net353 VDD net349 VSS g45n1svt m=1 l=45n w=145n
Mmn11 net349 net361 VSS VSS g45n1svt m=1 l=45n w=145n
Mmn10 net361 VDD net357 VSS g45n1svt m=1 l=45n w=145n
Mmn9 net357 net369 VSS VSS g45n1svt m=1 l=45n w=145n
Mmn15 net333 net345 VSS VSS g45n1svt m=1 l=45n w=260n
Mmn6 net377 VDD net373 VSS g45n1svt m=1 l=45n w=145n
Mmn0 net397 A VSS VSS g45n1svt m=1 l=45n w=145n
Mmn4 net385 VDD net381 VSS g45n1svt m=1 l=45n w=145n
Mmn1 net389 net397 VSS VSS g45n1svt m=1 l=45n w=145n
Mmn7 net365 net377 VSS VSS g45n1svt m=1 l=45n w=145n
Mmn16 Y net333 VSS VSS g45n1svt m=1 l=45n w=1.04u
Mmn3 net381 net393 VSS VSS g45n1svt m=1 l=45n w=145n
Mmn2 net393 VDD net389 VSS g45n1svt m=1 l=45n w=145n
Mmn8 net369 VDD net365 VSS g45n1svt m=1 l=45n w=145n
Mmn5 net373 net385 VSS VSS g45n1svt m=1 l=45n w=145n
Mmp8 net369 VSS net300 NW g45p1svt m=1 l=45n w=215n
Mmp7 net300 net377 VDD NW g45p1svt m=1 l=45n w=215n
Mmp9 net292 net369 VDD NW g45p1svt m=1 l=45n w=215n
Mmp10 net361 VSS net292 NW g45p1svt m=1 l=45n w=215n
Mmp6 net377 VSS net308 NW g45p1svt m=1 l=45n w=215n
Mmp5 net308 net385 VDD NW g45p1svt m=1 l=45n w=215n
Mmp4 net385 VSS net316 NW g45p1svt m=1 l=45n w=215n
Mmp3 net316 net393 VDD NW g45p1svt m=1 l=45n w=215n
Mmp2 net393 VSS net324 NW g45p1svt m=1 l=45n w=215n
Mmp1 net324 net397 VDD NW g45p1svt m=1 l=45n w=215n
Mmp11 net284 net361 VDD NW g45p1svt m=1 l=45n w=215n
Mmp12 net353 VSS net284 NW g45p1svt m=1 l=45n w=215n
Mmp13 net276 net353 VDD NW g45p1svt m=1 l=45n w=215n
Mmp14 net345 VSS net276 NW g45p1svt m=1 l=45n w=215n
Mmp15 net333 net345 VDD NW g45p1svt m=1 l=45n w=390n
Mmp0 net397 A VDD NW g45p1svt m=1 l=45n w=215n
Mmp16 Y net333 VDD NW g45p1svt m=1 l=45n w=1.56u
.ENDS

.SUBCKT EDFFHQX1 CK D E NW Q VDD VSS
*.PININFO CK:I D:I E:I NW:I VDD:I VSS:I Q:O
Mmn3 Db E net333 VSS g45n1svt m=1 l=45n w=260n
Mmn2 net333 D VSS VSS g45n1svt m=1 l=45n w=260n
Mmn55 Q qbint VSS VSS g45n1svt m=1 l=45n w=260n
Mmn51 n30 CKb net380 VSS g45n1svt m=1 l=45n w=205n
Mmn50 net380 qbint VSS VSS g45n1svt m=1 l=45n w=205n
Mmn35 net340 mout VSS VSS g45n1svt m=1 l=45n w=205n
Mmn20 CKb CK VSS VSS g45n1svt m=1 l=45n w=145n
Mmn45 qbint n30 VSS VSS g45n1svt m=1 l=45n w=205n
Mmn21 CKbb CKb VSS VSS g45n1svt m=1 l=45n w=145n
Mmn40 mout CKbb n30 VSS g45n1svt m=1 l=45n w=205n
Mmn30 mout n20 VSS VSS g45n1svt m=1 l=45n w=205n
Mmn0 Eb E VSS VSS g45n1svt m=1 l=45n w=145n
Mmn1 qbint Eb Db VSS g45n1svt m=1 l=45n w=260n
Mmn25 n20 CKb Db VSS g45n1svt m=1 l=45n w=205n
Mmn36 n20 CKbb net340 VSS g45n1svt m=1 l=45n w=205n
Mmp3 Db Eb net328 NW g45p1svt m=1 l=45n w=390n
Mmp2 net328 D VDD NW g45p1svt m=1 l=45n w=390n
Mmp51 n30 CKbb net317 NW g45p1svt m=1 l=45n w=310n
Mmp50 net317 qbint VDD NW g45p1svt m=1 l=45n w=310n
Mmp55 Q qbint VDD NW g45p1svt m=1 l=45n w=390n
Mmp35 net309 mout VDD NW g45p1svt m=1 l=45n w=310n
Mmp36 n20 CKb net309 NW g45p1svt m=1 l=45n w=310n
Mmp45 qbint n30 VDD NW g45p1svt m=1 l=45n w=310n
Mmp21 CKbb CKb VDD NW g45p1svt m=1 l=45n w=215n
Mmp40 mout CKb n30 NW g45p1svt m=1 l=45n w=310n
Mmp30 mout n20 VDD NW g45p1svt m=1 l=45n w=310n
Mmp1 qbint E Db NW g45p1svt m=1 l=45n w=390n
Mmp20 CKb CK VDD NW g45p1svt m=1 l=45n w=215n
Mmp25 n20 CKbb Db NW g45p1svt m=1 l=45n w=310n
Mmp0 Eb E VDD NW g45p1svt m=1 l=45n w=215n
.ENDS

.SUBCKT EDFFHQX2 CK D E NW Q VDD VSS
*.PININFO CK:I D:I E:I NW:I VDD:I VSS:I Q:O
Mmn3 Db E net333 VSS g45n1svt m=1 l=45n w=260n
Mmn2 net333 D VSS VSS g45n1svt m=1 l=45n w=260n
Mmn55 Q qbint VSS VSS g45n1svt m=1 l=45n w=520n
Mmn51 n30 CKb net380 VSS g45n1svt m=1 l=45n w=205n
Mmn50 net380 qbint VSS VSS g45n1svt m=1 l=45n w=205n
Mmn35 net340 mout VSS VSS g45n1svt m=1 l=45n w=205n
Mmn20 CKb CK VSS VSS g45n1svt m=1 l=45n w=145n
Mmn45 qbint n30 VSS VSS g45n1svt m=1 l=45n w=260n
Mmn21 CKbb CKb VSS VSS g45n1svt m=1 l=45n w=145n
Mmn40 mout CKbb n30 VSS g45n1svt m=1 l=45n w=205n
Mmn30 mout n20 VSS VSS g45n1svt m=1 l=45n w=205n
Mmn0 Eb E VSS VSS g45n1svt m=1 l=45n w=145n
Mmn1 qbint Eb Db VSS g45n1svt m=1 l=45n w=260n
Mmn25 n20 CKb Db VSS g45n1svt m=1 l=45n w=205n
Mmn36 n20 CKbb net340 VSS g45n1svt m=1 l=45n w=205n
Mmp3 Db Eb net328 NW g45p1svt m=1 l=45n w=390n
Mmp2 net328 D VDD NW g45p1svt m=1 l=45n w=390n
Mmp51 n30 CKbb net317 NW g45p1svt m=1 l=45n w=310n
Mmp50 net317 qbint VDD NW g45p1svt m=1 l=45n w=310n
Mmp55 Q qbint VDD NW g45p1svt m=1 l=45n w=780n
Mmp35 net309 mout VDD NW g45p1svt m=1 l=45n w=310n
Mmp36 n20 CKb net309 NW g45p1svt m=1 l=45n w=310n
Mmp45 qbint n30 VDD NW g45p1svt m=1 l=45n w=390n
Mmp21 CKbb CKb VDD NW g45p1svt m=1 l=45n w=215n
Mmp40 mout CKb n30 NW g45p1svt m=1 l=45n w=310n
Mmp30 mout n20 VDD NW g45p1svt m=1 l=45n w=310n
Mmp1 qbint E Db NW g45p1svt m=1 l=45n w=390n
Mmp20 CKb CK VDD NW g45p1svt m=1 l=45n w=215n
Mmp25 n20 CKbb Db NW g45p1svt m=1 l=45n w=310n
Mmp0 Eb E VDD NW g45p1svt m=1 l=45n w=215n
.ENDS

.SUBCKT EDFFHQX4 CK D E NW Q VDD VSS
*.PININFO CK:I D:I E:I NW:I VDD:I VSS:I Q:O
Mmn3 Db E net333 VSS g45n1svt m=1 l=45n w=260n
Mmn2 net333 D VSS VSS g45n1svt m=1 l=45n w=260n
Mmn55 Q qbint VSS VSS g45n1svt m=1 l=45n w=1.04u
Mmn51 n30 CKb net380 VSS g45n1svt m=1 l=45n w=205n
Mmn50 net380 qbint VSS VSS g45n1svt m=1 l=45n w=205n
Mmn35 net340 mout VSS VSS g45n1svt m=1 l=45n w=205n
Mmn20 CKb CK VSS VSS g45n1svt m=1 l=45n w=145n
Mmn45 qbint n30 VSS VSS g45n1svt m=1 l=45n w=410n
Mmn21 CKbb CKb VSS VSS g45n1svt m=1 l=45n w=145n
Mmn40 mout CKbb n30 VSS g45n1svt m=1 l=45n w=205n
Mmn30 mout n20 VSS VSS g45n1svt m=1 l=45n w=205n
Mmn0 Eb E VSS VSS g45n1svt m=1 l=45n w=145n
Mmn1 qbint Eb Db VSS g45n1svt m=1 l=45n w=260n
Mmn25 n20 CKb Db VSS g45n1svt m=1 l=45n w=205n
Mmn36 n20 CKbb net340 VSS g45n1svt m=1 l=45n w=205n
Mmp3 Db Eb net328 NW g45p1svt m=1 l=45n w=390n
Mmp2 net328 D VDD NW g45p1svt m=1 l=45n w=390n
Mmp51 n30 CKbb net317 NW g45p1svt m=1 l=45n w=310n
Mmp50 net317 qbint VDD NW g45p1svt m=1 l=45n w=310n
Mmp55 Q qbint VDD NW g45p1svt m=1 l=45n w=1.56u
Mmp35 net309 mout VDD NW g45p1svt m=1 l=45n w=310n
Mmp36 n20 CKb net309 NW g45p1svt m=1 l=45n w=310n
Mmp45 qbint n30 VDD NW g45p1svt m=1 l=45n w=620n
Mmp21 CKbb CKb VDD NW g45p1svt m=1 l=45n w=215n
Mmp40 mout CKb n30 NW g45p1svt m=1 l=45n w=310n
Mmp30 mout n20 VDD NW g45p1svt m=1 l=45n w=310n
Mmp1 qbint E Db NW g45p1svt m=1 l=45n w=390n
Mmp20 CKb CK VDD NW g45p1svt m=1 l=45n w=215n
Mmp25 n20 CKbb Db NW g45p1svt m=1 l=45n w=310n
Mmp0 Eb E VDD NW g45p1svt m=1 l=45n w=215n
.ENDS

.SUBCKT EDFFHQX8 CK D E NW Q VDD VSS
*.PININFO CK:I D:I E:I NW:I VDD:I VSS:I Q:O
Mmn3 Db E net333 VSS g45n1svt m=1 l=45n w=260n
Mmn2 net333 D VSS VSS g45n1svt m=1 l=45n w=260n
Mmn55 Q qbint VSS VSS g45n1svt m=1 l=45n w=2.065u
Mmn51 n30 CKb net380 VSS g45n1svt m=1 l=45n w=205n
Mmn50 net380 qbint VSS VSS g45n1svt m=1 l=45n w=205n
Mmn35 net340 mout VSS VSS g45n1svt m=1 l=45n w=205n
Mmn20 CKb CK VSS VSS g45n1svt m=1 l=45n w=145n
Mmn45 qbint n30 VSS VSS g45n1svt m=1 l=45n w=780n
Mmn21 CKbb CKb VSS VSS g45n1svt m=1 l=45n w=145n
Mmn40 mout CKbb n30 VSS g45n1svt m=1 l=45n w=205n
Mmn30 mout n20 VSS VSS g45n1svt m=1 l=45n w=205n
Mmn0 Eb E VSS VSS g45n1svt m=1 l=45n w=145n
Mmn1 qbint Eb Db VSS g45n1svt m=1 l=45n w=260n
Mmn25 n20 CKb Db VSS g45n1svt m=1 l=45n w=205n
Mmn36 n20 CKbb net340 VSS g45n1svt m=1 l=45n w=205n
Mmp3 Db Eb net328 NW g45p1svt m=1 l=45n w=390n
Mmp2 net328 D VDD NW g45p1svt m=1 l=45n w=390n
Mmp51 n30 CKbb net317 NW g45p1svt m=1 l=45n w=310n
Mmp50 net317 qbint VDD NW g45p1svt m=1 l=45n w=310n
Mmp55 Q qbint VDD NW g45p1svt m=1 l=45n w=3.115u
Mmp35 net309 mout VDD NW g45p1svt m=1 l=45n w=310n
Mmp36 n20 CKb net309 NW g45p1svt m=1 l=45n w=310n
Mmp45 qbint n30 VDD NW g45p1svt m=1 l=45n w=1.17u
Mmp21 CKbb CKb VDD NW g45p1svt m=1 l=45n w=215n
Mmp40 mout CKb n30 NW g45p1svt m=1 l=45n w=310n
Mmp30 mout n20 VDD NW g45p1svt m=1 l=45n w=310n
Mmp1 qbint E Db NW g45p1svt m=1 l=45n w=390n
Mmp20 CKb CK VDD NW g45p1svt m=1 l=45n w=215n
Mmp25 n20 CKbb Db NW g45p1svt m=1 l=45n w=310n
Mmp0 Eb E VDD NW g45p1svt m=1 l=45n w=215n
.ENDS

.SUBCKT EDFFTRX1 CK D E NW Q QN RN VDD VSS
*.PININFO CK:I D:I E:I NW:I RN:I VDD:I VSS:I Q:O QN:O
Mmn35 net516 mout VSS VSS g45n1svt m=1 l=45n w=145n
Mmn36 n20 CKbb net516 VSS g45n1svt m=1 l=45n w=145n
Mmn26 n20 CKb n21 VSS g45n1svt m=1 l=45n w=145n
Mmn25 n21 Dp VSS VSS g45n1svt m=1 l=45n w=145n
Mmn51 n30 CKb net496 VSS g45n1svt m=1 l=45n w=145n
Mmn50 net496 qbint VSS VSS g45n1svt m=1 l=45n w=145n
Mmn57 QN qint VSS VSS g45n1svt m=1 l=45n w=260n
Mmn55 Q qbint VSS VSS g45n1svt m=1 l=45n w=260n
Mmn5 Dp qbint n0 VSS g45n1svt m=1 l=45n w=145n
Mmn4 n0 Eb VSS VSS g45n1svt m=1 l=45n w=145n
Mmn6 n1 E VSS VSS g45n1svt m=1 l=45n w=145n
Mmn7 Dp Db n1 VSS g45n1svt m=1 l=45n w=145n
Mmn20 CKb CK VSS VSS g45n1svt m=1 l=45n w=145n
Mmn2 RNb RN VSS VSS g45n1svt m=1 l=45n w=145n
Mmn1 Db D VSS VSS g45n1svt m=1 l=45n w=145n
Mmn30 mout n20 VSS VSS g45n1svt m=1 l=45n w=145n
Mmn21 CKbb CKb VSS VSS g45n1svt m=1 l=45n w=145n
Mmn40 n30 CKbb mout VSS g45n1svt m=1 l=45n w=145n
Mmn45 qbint n30 VSS VSS g45n1svt m=1 l=45n w=205n
Mmn56 qint qbint VSS VSS g45n1svt m=1 l=45n w=145n
Mmn3 Dp RNb VSS VSS g45n1svt m=1 l=45n w=145n
Mmn0 Eb E VSS VSS g45n1svt m=1 l=45n w=145n
Mmp25 n22 Dp VDD NW g45p1svt m=1 l=45n w=215n
Mmp26 n20 CKbb n22 NW g45p1svt m=1 l=45n w=215n
Mmp35 net427 mout VDD NW g45p1svt m=1 l=45n w=215n
Mmp36 n20 CKb net427 NW g45p1svt m=1 l=45n w=215n
Mmp51 n30 CKbb net411 NW g45p1svt m=1 l=45n w=215n
Mmp50 net411 qbint VDD NW g45p1svt m=1 l=45n w=215n
Mmp57 QN qint VDD NW g45p1svt m=1 l=45n w=390n
Mmp55 Q qbint VDD NW g45p1svt m=1 l=45n w=390n
Mmp20 CKb CK VDD NW g45p1svt m=1 l=45n w=215n
Mmp2 RNb RN VDD NW g45p1svt m=1 l=45n w=215n
Mmp1 Db D VDD NW g45p1svt m=1 l=45n w=215n
Mmp7 Dp Db n3 NW g45p1svt m=1 l=45n w=215n
Mmp6 Dp E n3 NW g45p1svt m=1 l=45n w=215n
Mmp30 mout n20 VDD NW g45p1svt m=1 l=45n w=215n
Mmp21 CKbb CKb VDD NW g45p1svt m=1 l=45n w=215n
Mmp40 n30 CKb mout NW g45p1svt m=1 l=45n w=215n
Mmp45 qbint n30 VDD NW g45p1svt m=1 l=45n w=310n
Mmp56 qint qbint VDD NW g45p1svt m=1 l=45n w=215n
Mmp5 n3 qbint n2 NW g45p1svt m=1 l=45n w=215n
Mmp0 Eb E VDD NW g45p1svt m=1 l=45n w=215n
Mmp4 n3 Eb n2 NW g45p1svt m=1 l=45n w=215n
Mmp3 n2 RNb VDD NW g45p1svt m=1 l=45n w=215n
.ENDS

.SUBCKT EDFFTRX2 CK D E NW Q QN RN VDD VSS
*.PININFO CK:I D:I E:I NW:I RN:I VDD:I VSS:I Q:O QN:O
Mmn35 net516 mout VSS VSS g45n1svt m=1 l=45n w=145n
Mmn36 n20 CKbb net516 VSS g45n1svt m=1 l=45n w=145n
Mmn26 n20 CKb n21 VSS g45n1svt m=1 l=45n w=145n
Mmn25 n21 Dp VSS VSS g45n1svt m=1 l=45n w=145n
Mmn51 n30 CKb net496 VSS g45n1svt m=1 l=45n w=145n
Mmn50 net496 qbint VSS VSS g45n1svt m=1 l=45n w=145n
Mmn57 QN qint VSS VSS g45n1svt m=1 l=45n w=520n
Mmn55 Q qbint VSS VSS g45n1svt m=1 l=45n w=520n
Mmn5 Dp qbint n0 VSS g45n1svt m=1 l=45n w=145n
Mmn4 n0 Eb VSS VSS g45n1svt m=1 l=45n w=145n
Mmn6 n1 E VSS VSS g45n1svt m=1 l=45n w=145n
Mmn7 Dp Db n1 VSS g45n1svt m=1 l=45n w=145n
Mmn20 CKb CK VSS VSS g45n1svt m=1 l=45n w=145n
Mmn2 RNb RN VSS VSS g45n1svt m=1 l=45n w=145n
Mmn1 Db D VSS VSS g45n1svt m=1 l=45n w=145n
Mmn30 mout n20 VSS VSS g45n1svt m=1 l=45n w=145n
Mmn21 CKbb CKb VSS VSS g45n1svt m=1 l=45n w=145n
Mmn40 n30 CKbb mout VSS g45n1svt m=1 l=45n w=145n
Mmn45 qbint n30 VSS VSS g45n1svt m=1 l=45n w=260n
Mmn56 qint qbint VSS VSS g45n1svt m=1 l=45n w=145n
Mmn3 Dp RNb VSS VSS g45n1svt m=1 l=45n w=145n
Mmn0 Eb E VSS VSS g45n1svt m=1 l=45n w=145n
Mmp25 n22 Dp VDD NW g45p1svt m=1 l=45n w=215n
Mmp26 n20 CKbb n22 NW g45p1svt m=1 l=45n w=215n
Mmp35 net427 mout VDD NW g45p1svt m=1 l=45n w=215n
Mmp36 n20 CKb net427 NW g45p1svt m=1 l=45n w=215n
Mmp51 n30 CKbb net411 NW g45p1svt m=1 l=45n w=215n
Mmp50 net411 qbint VDD NW g45p1svt m=1 l=45n w=215n
Mmp57 QN qint VDD NW g45p1svt m=1 l=45n w=780n
Mmp55 Q qbint VDD NW g45p1svt m=1 l=45n w=780n
Mmp20 CKb CK VDD NW g45p1svt m=1 l=45n w=215n
Mmp2 RNb RN VDD NW g45p1svt m=1 l=45n w=215n
Mmp1 Db D VDD NW g45p1svt m=1 l=45n w=215n
Mmp7 Dp Db n3 NW g45p1svt m=1 l=45n w=215n
Mmp6 Dp E n3 NW g45p1svt m=1 l=45n w=215n
Mmp30 mout n20 VDD NW g45p1svt m=1 l=45n w=215n
Mmp21 CKbb CKb VDD NW g45p1svt m=1 l=45n w=215n
Mmp40 n30 CKb mout NW g45p1svt m=1 l=45n w=215n
Mmp45 qbint n30 VDD NW g45p1svt m=1 l=45n w=390n
Mmp56 qint qbint VDD NW g45p1svt m=1 l=45n w=215n
Mmp5 n3 qbint n2 NW g45p1svt m=1 l=45n w=215n
Mmp0 Eb E VDD NW g45p1svt m=1 l=45n w=215n
Mmp4 n3 Eb n2 NW g45p1svt m=1 l=45n w=215n
Mmp3 n2 RNb VDD NW g45p1svt m=1 l=45n w=215n
.ENDS

.SUBCKT EDFFTRX4 CK D E NW Q QN RN VDD VSS
*.PININFO CK:I D:I E:I NW:I RN:I VDD:I VSS:I Q:O QN:O
Mmn35 net516 mout VSS VSS g45n1svt m=1 l=45n w=145n
Mmn36 n20 CKbb net516 VSS g45n1svt m=1 l=45n w=145n
Mmn26 n20 CKb n21 VSS g45n1svt m=1 l=45n w=145n
Mmn25 n21 Dp VSS VSS g45n1svt m=1 l=45n w=145n
Mmn51 n30 CKb net496 VSS g45n1svt m=1 l=45n w=145n
Mmn50 net496 qbint VSS VSS g45n1svt m=1 l=45n w=145n
Mmn57 QN qint VSS VSS g45n1svt m=1 l=45n w=1.04u
Mmn55 Q qbint VSS VSS g45n1svt m=1 l=45n w=1.04u
Mmn5 Dp qbint n0 VSS g45n1svt m=1 l=45n w=145n
Mmn4 n0 Eb VSS VSS g45n1svt m=1 l=45n w=145n
Mmn6 n1 E VSS VSS g45n1svt m=1 l=45n w=145n
Mmn7 Dp Db n1 VSS g45n1svt m=1 l=45n w=145n
Mmn20 CKb CK VSS VSS g45n1svt m=1 l=45n w=145n
Mmn2 RNb RN VSS VSS g45n1svt m=1 l=45n w=145n
Mmn1 Db D VSS VSS g45n1svt m=1 l=45n w=145n
Mmn30 mout n20 VSS VSS g45n1svt m=1 l=45n w=145n
Mmn21 CKbb CKb VSS VSS g45n1svt m=1 l=45n w=145n
Mmn40 n30 CKbb mout VSS g45n1svt m=1 l=45n w=145n
Mmn45 qbint n30 VSS VSS g45n1svt m=1 l=45n w=410n
Mmn56 qint qbint VSS VSS g45n1svt m=1 l=45n w=260n
Mmn3 Dp RNb VSS VSS g45n1svt m=1 l=45n w=145n
Mmn0 Eb E VSS VSS g45n1svt m=1 l=45n w=145n
Mmp25 n22 Dp VDD NW g45p1svt m=1 l=45n w=215n
Mmp26 n20 CKbb n22 NW g45p1svt m=1 l=45n w=215n
Mmp35 net427 mout VDD NW g45p1svt m=1 l=45n w=215n
Mmp36 n20 CKb net427 NW g45p1svt m=1 l=45n w=215n
Mmp51 n30 CKbb net411 NW g45p1svt m=1 l=45n w=215n
Mmp50 net411 qbint VDD NW g45p1svt m=1 l=45n w=215n
Mmp57 QN qint VDD NW g45p1svt m=1 l=45n w=1.56u
Mmp55 Q qbint VDD NW g45p1svt m=1 l=45n w=1.56u
Mmp20 CKb CK VDD NW g45p1svt m=1 l=45n w=215n
Mmp2 RNb RN VDD NW g45p1svt m=1 l=45n w=215n
Mmp1 Db D VDD NW g45p1svt m=1 l=45n w=215n
Mmp7 Dp Db n3 NW g45p1svt m=1 l=45n w=215n
Mmp6 Dp E n3 NW g45p1svt m=1 l=45n w=215n
Mmp30 mout n20 VDD NW g45p1svt m=1 l=45n w=215n
Mmp21 CKbb CKb VDD NW g45p1svt m=1 l=45n w=215n
Mmp40 n30 CKb mout NW g45p1svt m=1 l=45n w=215n
Mmp45 qbint n30 VDD NW g45p1svt m=1 l=45n w=620n
Mmp56 qint qbint VDD NW g45p1svt m=1 l=45n w=390n
Mmp5 n3 qbint n2 NW g45p1svt m=1 l=45n w=215n
Mmp0 Eb E VDD NW g45p1svt m=1 l=45n w=215n
Mmp4 n3 Eb n2 NW g45p1svt m=1 l=45n w=215n
Mmp3 n2 RNb VDD NW g45p1svt m=1 l=45n w=215n
.ENDS

.SUBCKT EDFFTRXL CK D E NW Q QN RN VDD VSS
*.PININFO CK:I D:I E:I NW:I RN:I VDD:I VSS:I Q:O QN:O
Mmn35 net516 mout VSS VSS g45n1svt m=1 l=45n w=145n
Mmn36 n20 CKbb net516 VSS g45n1svt m=1 l=45n w=145n
Mmn26 n20 CKb n21 VSS g45n1svt m=1 l=45n w=145n
Mmn25 n21 Dp VSS VSS g45n1svt m=1 l=45n w=145n
Mmn51 n30 CKb net496 VSS g45n1svt m=1 l=45n w=145n
Mmn50 net496 qbint VSS VSS g45n1svt m=1 l=45n w=145n
Mmn57 QN qint VSS VSS g45n1svt m=1 l=45n w=145n
Mmn55 Q qbint VSS VSS g45n1svt m=1 l=45n w=145n
Mmn5 Dp qbint n0 VSS g45n1svt m=1 l=45n w=145n
Mmn4 n0 Eb VSS VSS g45n1svt m=1 l=45n w=145n
Mmn6 n1 E VSS VSS g45n1svt m=1 l=45n w=145n
Mmn7 Dp Db n1 VSS g45n1svt m=1 l=45n w=145n
Mmn20 CKb CK VSS VSS g45n1svt m=1 l=45n w=145n
Mmn2 RNb RN VSS VSS g45n1svt m=1 l=45n w=145n
Mmn1 Db D VSS VSS g45n1svt m=1 l=45n w=145n
Mmn30 mout n20 VSS VSS g45n1svt m=1 l=45n w=145n
Mmn21 CKbb CKb VSS VSS g45n1svt m=1 l=45n w=145n
Mmn40 n30 CKbb mout VSS g45n1svt m=1 l=45n w=145n
Mmn45 qbint n30 VSS VSS g45n1svt m=1 l=45n w=145n
Mmn56 qint qbint VSS VSS g45n1svt m=1 l=45n w=145n
Mmn3 Dp RNb VSS VSS g45n1svt m=1 l=45n w=145n
Mmn0 Eb E VSS VSS g45n1svt m=1 l=45n w=145n
Mmp25 n22 Dp VDD NW g45p1svt m=1 l=45n w=215n
Mmp26 n20 CKbb n22 NW g45p1svt m=1 l=45n w=215n
Mmp35 net427 mout VDD NW g45p1svt m=1 l=45n w=215n
Mmp36 n20 CKb net427 NW g45p1svt m=1 l=45n w=215n
Mmp51 n30 CKbb net411 NW g45p1svt m=1 l=45n w=215n
Mmp50 net411 qbint VDD NW g45p1svt m=1 l=45n w=215n
Mmp57 QN qint VDD NW g45p1svt m=1 l=45n w=215n
Mmp55 Q qbint VDD NW g45p1svt m=1 l=45n w=215n
Mmp20 CKb CK VDD NW g45p1svt m=1 l=45n w=215n
Mmp2 RNb RN VDD NW g45p1svt m=1 l=45n w=215n
Mmp1 Db D VDD NW g45p1svt m=1 l=45n w=215n
Mmp7 Dp Db n3 NW g45p1svt m=1 l=45n w=215n
Mmp6 Dp E n3 NW g45p1svt m=1 l=45n w=215n
Mmp30 mout n20 VDD NW g45p1svt m=1 l=45n w=215n
Mmp21 CKbb CKb VDD NW g45p1svt m=1 l=45n w=215n
Mmp40 n30 CKb mout NW g45p1svt m=1 l=45n w=215n
Mmp45 qbint n30 VDD NW g45p1svt m=1 l=45n w=215n
Mmp56 qint qbint VDD NW g45p1svt m=1 l=45n w=215n
Mmp5 n3 qbint n2 NW g45p1svt m=1 l=45n w=215n
Mmp0 Eb E VDD NW g45p1svt m=1 l=45n w=215n
Mmp4 n3 Eb n2 NW g45p1svt m=1 l=45n w=215n
Mmp3 n2 RNb VDD NW g45p1svt m=1 l=45n w=215n
.ENDS

.SUBCKT EDFFX1 CK D E NW Q QN VDD VSS
*.PININFO CK:I D:I E:I NW:I VDD:I VSS:I Q:O QN:O
Mmn3 Db E n0 VSS g45n1svt m=1 l=45n w=145n
Mmn2 n0 D VSS VSS g45n1svt m=1 l=45n w=145n
Mmn57 QN qint VSS VSS g45n1svt m=1 l=45n w=260n
Mmn55 Q qbint VSS VSS g45n1svt m=1 l=45n w=260n
Mmn51 n30 Ckb net415 VSS g45n1svt m=1 l=45n w=145n
Mmn50 net415 qbint VSS VSS g45n1svt m=1 l=45n w=145n
Mmn35 net411 mout VSS VSS g45n1svt m=1 l=45n w=145n
Mmn36 n20 CKbb net411 VSS g45n1svt m=1 l=45n w=145n
Mmn20 Ckb CK VSS VSS g45n1svt m=1 l=45n w=145n
Mmn45 qbint n30 VSS VSS g45n1svt m=1 l=45n w=205n
Mmn56 qint qbint VSS VSS g45n1svt m=1 l=45n w=145n
Mmn0 Eb E VSS VSS g45n1svt m=1 l=45n w=145n
Mmn30 mout n20 VSS VSS g45n1svt m=1 l=45n w=145n
Mmn21 CKbb Ckb VSS VSS g45n1svt m=1 l=45n w=145n
Mmn40 mout CKbb n30 VSS g45n1svt m=1 l=45n w=145n
Mmn1 qbint Eb Db VSS g45n1svt m=1 l=45n w=145n
Mmn25 Db Ckb n20 VSS g45n1svt m=1 l=45n w=145n
Mmp3 Db Eb n1 NW g45p1svt m=1 l=45n w=215n
Mmp2 n1 D VDD NW g45p1svt m=1 l=45n w=215n
Mmp51 n30 CKbb net362 NW g45p1svt m=1 l=45n w=215n
Mmp50 net362 qbint VDD NW g45p1svt m=1 l=45n w=215n
Mmp57 QN qint VDD NW g45p1svt m=1 l=45n w=390n
Mmp55 Q qbint VDD NW g45p1svt m=1 l=45n w=390n
Mmp35 net342 mout VDD NW g45p1svt m=1 l=45n w=215n
Mmp36 n20 Ckb net342 NW g45p1svt m=1 l=45n w=215n
Mmp20 Ckb CK VDD NW g45p1svt m=1 l=45n w=215n
Mmp45 qbint n30 VDD NW g45p1svt m=1 l=45n w=310n
Mmp56 qint qbint VDD NW g45p1svt m=1 l=45n w=215n
Mmp21 CKbb Ckb VDD NW g45p1svt m=1 l=45n w=215n
Mmp40 n30 Ckb mout NW g45p1svt m=1 l=45n w=215n
Mmp30 mout n20 VDD NW g45p1svt m=1 l=45n w=215n
Mmp25 n20 CKbb Db NW g45p1svt m=1 l=45n w=215n
Mmp0 Eb E VDD NW g45p1svt m=1 l=45n w=215n
Mmp1 qbint E Db NW g45p1svt m=1 l=45n w=215n
.ENDS

.SUBCKT EDFFX2 CK D E NW Q QN VDD VSS
*.PININFO CK:I D:I E:I NW:I VDD:I VSS:I Q:O QN:O
Mmn3 Db E n0 VSS g45n1svt m=1 l=45n w=145n
Mmn2 n0 D VSS VSS g45n1svt m=1 l=45n w=145n
Mmn57 QN qint VSS VSS g45n1svt m=1 l=45n w=520n
Mmn55 Q qbint VSS VSS g45n1svt m=1 l=45n w=520n
Mmn51 n30 Ckb net415 VSS g45n1svt m=1 l=45n w=145n
Mmn50 net415 qbint VSS VSS g45n1svt m=1 l=45n w=145n
Mmn35 net411 mout VSS VSS g45n1svt m=1 l=45n w=145n
Mmn36 n20 CKbb net411 VSS g45n1svt m=1 l=45n w=145n
Mmn20 Ckb CK VSS VSS g45n1svt m=1 l=45n w=145n
Mmn45 qbint n30 VSS VSS g45n1svt m=1 l=45n w=260n
Mmn56 qint qbint VSS VSS g45n1svt m=1 l=45n w=145n
Mmn0 Eb E VSS VSS g45n1svt m=1 l=45n w=145n
Mmn30 mout n20 VSS VSS g45n1svt m=1 l=45n w=145n
Mmn21 CKbb Ckb VSS VSS g45n1svt m=1 l=45n w=145n
Mmn40 mout CKbb n30 VSS g45n1svt m=1 l=45n w=145n
Mmn1 qbint Eb Db VSS g45n1svt m=1 l=45n w=145n
Mmn25 Db Ckb n20 VSS g45n1svt m=1 l=45n w=145n
Mmp3 Db Eb n1 NW g45p1svt m=1 l=45n w=215n
Mmp2 n1 D VDD NW g45p1svt m=1 l=45n w=215n
Mmp51 n30 CKbb net362 NW g45p1svt m=1 l=45n w=215n
Mmp50 net362 qbint VDD NW g45p1svt m=1 l=45n w=215n
Mmp57 QN qint VDD NW g45p1svt m=1 l=45n w=780n
Mmp55 Q qbint VDD NW g45p1svt m=1 l=45n w=780n
Mmp35 net342 mout VDD NW g45p1svt m=1 l=45n w=215n
Mmp36 n20 Ckb net342 NW g45p1svt m=1 l=45n w=215n
Mmp20 Ckb CK VDD NW g45p1svt m=1 l=45n w=215n
Mmp45 qbint n30 VDD NW g45p1svt m=1 l=45n w=390n
Mmp56 qint qbint VDD NW g45p1svt m=1 l=45n w=215n
Mmp21 CKbb Ckb VDD NW g45p1svt m=1 l=45n w=215n
Mmp40 n30 Ckb mout NW g45p1svt m=1 l=45n w=215n
Mmp30 mout n20 VDD NW g45p1svt m=1 l=45n w=215n
Mmp25 n20 CKbb Db NW g45p1svt m=1 l=45n w=215n
Mmp0 Eb E VDD NW g45p1svt m=1 l=45n w=215n
Mmp1 qbint E Db NW g45p1svt m=1 l=45n w=215n
.ENDS

.SUBCKT EDFFX4 CK D E NW Q QN VDD VSS
*.PININFO CK:I D:I E:I NW:I VDD:I VSS:I Q:O QN:O
Mmn3 Db E n0 VSS g45n1svt m=1 l=45n w=145n
Mmn2 n0 D VSS VSS g45n1svt m=1 l=45n w=145n
Mmn57 QN qint VSS VSS g45n1svt m=1 l=45n w=1.04u
Mmn55 Q qbint VSS VSS g45n1svt m=1 l=45n w=1.04u
Mmn51 n30 Ckb net415 VSS g45n1svt m=1 l=45n w=145n
Mmn50 net415 qbint VSS VSS g45n1svt m=1 l=45n w=145n
Mmn35 net411 mout VSS VSS g45n1svt m=1 l=45n w=145n
Mmn36 n20 CKbb net411 VSS g45n1svt m=1 l=45n w=145n
Mmn20 Ckb CK VSS VSS g45n1svt m=1 l=45n w=145n
Mmn45 qbint n30 VSS VSS g45n1svt m=1 l=45n w=410n
Mmn56 qint qbint VSS VSS g45n1svt m=1 l=45n w=260n
Mmn0 Eb E VSS VSS g45n1svt m=1 l=45n w=145n
Mmn30 mout n20 VSS VSS g45n1svt m=1 l=45n w=145n
Mmn21 CKbb Ckb VSS VSS g45n1svt m=1 l=45n w=145n
Mmn40 mout CKbb n30 VSS g45n1svt m=1 l=45n w=145n
Mmn1 qbint Eb Db VSS g45n1svt m=1 l=45n w=145n
Mmn25 Db Ckb n20 VSS g45n1svt m=1 l=45n w=145n
Mmp3 Db Eb n1 NW g45p1svt m=1 l=45n w=215n
Mmp2 n1 D VDD NW g45p1svt m=1 l=45n w=215n
Mmp51 n30 CKbb net362 NW g45p1svt m=1 l=45n w=215n
Mmp50 net362 qbint VDD NW g45p1svt m=1 l=45n w=215n
Mmp57 QN qint VDD NW g45p1svt m=1 l=45n w=1.56u
Mmp55 Q qbint VDD NW g45p1svt m=1 l=45n w=1.56u
Mmp35 net342 mout VDD NW g45p1svt m=1 l=45n w=215n
Mmp36 n20 Ckb net342 NW g45p1svt m=1 l=45n w=215n
Mmp20 Ckb CK VDD NW g45p1svt m=1 l=45n w=215n
Mmp45 qbint n30 VDD NW g45p1svt m=1 l=45n w=620n
Mmp56 qint qbint VDD NW g45p1svt m=1 l=45n w=390n
Mmp21 CKbb Ckb VDD NW g45p1svt m=1 l=45n w=215n
Mmp40 n30 Ckb mout NW g45p1svt m=1 l=45n w=215n
Mmp30 mout n20 VDD NW g45p1svt m=1 l=45n w=215n
Mmp25 n20 CKbb Db NW g45p1svt m=1 l=45n w=215n
Mmp0 Eb E VDD NW g45p1svt m=1 l=45n w=215n
Mmp1 qbint E Db NW g45p1svt m=1 l=45n w=215n
.ENDS

.SUBCKT EDFFXL CK D E NW Q QN VDD VSS
*.PININFO CK:I D:I E:I NW:I VDD:I VSS:I Q:O QN:O
Mmn3 Db E n0 VSS g45n1svt m=1 l=45n w=145n
Mmn2 n0 D VSS VSS g45n1svt m=1 l=45n w=145n
Mmn57 QN qint VSS VSS g45n1svt m=1 l=45n w=145n
Mmn55 Q qbint VSS VSS g45n1svt m=1 l=45n w=145n
Mmn51 n30 Ckb net415 VSS g45n1svt m=1 l=45n w=145n
Mmn50 net415 qbint VSS VSS g45n1svt m=1 l=45n w=145n
Mmn35 net411 mout VSS VSS g45n1svt m=1 l=45n w=145n
Mmn36 n20 CKbb net411 VSS g45n1svt m=1 l=45n w=145n
Mmn20 Ckb CK VSS VSS g45n1svt m=1 l=45n w=145n
Mmn45 qbint n30 VSS VSS g45n1svt m=1 l=45n w=145n
Mmn56 qint qbint VSS VSS g45n1svt m=1 l=45n w=145n
Mmn0 Eb E VSS VSS g45n1svt m=1 l=45n w=145n
Mmn30 mout n20 VSS VSS g45n1svt m=1 l=45n w=145n
Mmn21 CKbb Ckb VSS VSS g45n1svt m=1 l=45n w=145n
Mmn40 mout CKbb n30 VSS g45n1svt m=1 l=45n w=145n
Mmn1 qbint Eb Db VSS g45n1svt m=1 l=45n w=145n
Mmn25 Db Ckb n20 VSS g45n1svt m=1 l=45n w=145n
Mmp3 Db Eb n1 NW g45p1svt m=1 l=45n w=215n
Mmp2 n1 D VDD NW g45p1svt m=1 l=45n w=215n
Mmp51 n30 CKbb net362 NW g45p1svt m=1 l=45n w=215n
Mmp50 net362 qbint VDD NW g45p1svt m=1 l=45n w=215n
Mmp57 QN qint VDD NW g45p1svt m=1 l=45n w=215n
Mmp55 Q qbint VDD NW g45p1svt m=1 l=45n w=215n
Mmp35 net342 mout VDD NW g45p1svt m=1 l=45n w=215n
Mmp36 n20 Ckb net342 NW g45p1svt m=1 l=45n w=215n
Mmp20 Ckb CK VDD NW g45p1svt m=1 l=45n w=215n
Mmp45 qbint n30 VDD NW g45p1svt m=1 l=45n w=215n
Mmp56 qint qbint VDD NW g45p1svt m=1 l=45n w=215n
Mmp21 CKbb Ckb VDD NW g45p1svt m=1 l=45n w=215n
Mmp40 n30 Ckb mout NW g45p1svt m=1 l=45n w=215n
Mmp30 mout n20 VDD NW g45p1svt m=1 l=45n w=215n
Mmp25 n20 CKbb Db NW g45p1svt m=1 l=45n w=215n
Mmp0 Eb E VDD NW g45p1svt m=1 l=45n w=215n
Mmp1 qbint E Db NW g45p1svt m=1 l=45n w=215n
.ENDS

.SUBCKT FILL16 VDD VSS
*.PININFO VDD:I VSS:I
.ENDS

.SUBCKT FILL1 VDD VSS
*.PININFO VDD:I VSS:I
.ENDS

.SUBCKT FILL2 VDD VSS
*.PININFO VDD:I VSS:I
.ENDS

.SUBCKT FILL32 VDD VSS
*.PININFO VDD:I VSS:I
.ENDS

.SUBCKT FILL4 VDD VSS
*.PININFO VDD:I VSS:I
.ENDS

.SUBCKT FILL64 VDD VSS
*.PININFO VDD:I VSS:I
.ENDS

.SUBCKT FILL8 VDD VSS
*.PININFO VDD:I VSS:I
.ENDS

.SUBCKT HOLDX1 NW VDD VSS Y
*.PININFO NW:I VDD:I VSS:I Y:B
Mmn1 Y n0 n1 VSS g45n1svt m=1 l=45n w=145n
Mmn0 n0 Y VSS VSS g45n1svt m=1 l=45n w=260n
Mmn2 n1 n0 n2 VSS g45n1svt m=1 l=45n w=145n
Mmn3 n2 n0 VSS VSS g45n1svt m=1 l=45n w=145n
Mmp2 p1 n0 p2 NW g45p1svt m=1 l=45n w=215n
Mmp1 Y n0 p1 NW g45p1svt m=1 l=45n w=215n
Mmp3 p2 n0 VDD NW g45p1svt m=1 l=45n w=215n
Mmp0 n0 Y VDD NW g45p1svt m=1 l=45n w=390n
.ENDS

.SUBCKT INVX12 A NW VDD VSS Y
*.PININFO A:I NW:I VDD:I VSS:I Y:O
Mmp0 Y A VDD NW g45p1svt m=1 l=45n w=4.7u
Mmn0 Y A VSS VSS g45n1svt m=1 l=45n w=3.1u
.ENDS

.SUBCKT INVX16 A NW VDD VSS Y
*.PININFO A:I NW:I VDD:I VSS:I Y:O
Mmp0 Y A VDD NW g45p1svt m=1 l=45n w=6.23u
Mmn0 Y A VSS VSS g45n1svt m=1 l=45n w=4.13u
.ENDS

.SUBCKT INVX1 A NW VDD VSS Y
*.PININFO A:I NW:I VDD:I VSS:I Y:O
Mmp0 Y A VDD NW g45p1svt m=1 l=45n w=390n
Mmn0 Y A VSS VSS g45n1svt m=1 l=45n w=260n
.ENDS

.SUBCKT INVX20 A NW VDD VSS Y
*.PININFO A:I NW:I VDD:I VSS:I Y:O
Mmp0 Y A VDD NW g45p1svt m=1 l=45n w=7.82u
Mmn0 Y A VSS VSS g45n1svt m=1 l=45n w=5.185u
.ENDS

.SUBCKT INVX2 A NW VDD VSS Y
*.PININFO A:I NW:I VDD:I VSS:I Y:O
Mmp0 Y A VDD NW g45p1svt m=1 l=45n w=780n
Mmn0 Y A VSS VSS g45n1svt m=1 l=45n w=520n
.ENDS

.SUBCKT INVX3 A NW VDD VSS Y
*.PININFO A:I NW:I VDD:I VSS:I Y:O
Mmp0 Y A VDD NW g45p1svt m=1 l=45n w=1.17u
Mmn0 Y A VSS VSS g45n1svt m=1 l=45n w=780n
.ENDS

.SUBCKT INVX4 A NW VDD VSS Y
*.PININFO A:I NW:I VDD:I VSS:I Y:O
Mmp0 Y A VDD NW g45p1svt m=1 l=45n w=1.56u
Mmn0 Y A VSS VSS g45n1svt m=1 l=45n w=1.04u
.ENDS

.SUBCKT INVX6 A NW VDD VSS Y
*.PININFO A:I NW:I VDD:I VSS:I Y:O
Mmp0 Y A VDD NW g45p1svt m=1 l=45n w=2.35u
Mmn0 Y A VSS VSS g45n1svt m=1 l=45n w=1.55u
.ENDS

.SUBCKT INVX8 A NW VDD VSS Y
*.PININFO A:I NW:I VDD:I VSS:I Y:O
Mmp0 Y A VDD NW g45p1svt m=1 l=45n w=3.115u
Mmn0 Y A VSS VSS g45n1svt m=1 l=45n w=2.065u
.ENDS

.SUBCKT INVXL A NW VDD VSS Y
*.PININFO A:I NW:I VDD:I VSS:I Y:O
Mmp0 Y A VDD NW g45p1svt m=1 l=45n w=215n
Mmn0 Y A VSS VSS g45n1svt m=1 l=45n w=145n
.ENDS

.SUBCKT MDFFHQX1 CK D0 D1 NW Q S0 VDD VSS
*.PININFO CK:I D0:I D1:I NW:I S0:I VDD:I VSS:I Q:O
Mmn13 n12 D1 VSS VSS g45n1svt m=1 l=45n w=260n
Mmn14 D0b S0 n12 VSS g45n1svt m=1 l=45n w=260n
Mmn12 D0b S0b n10 VSS g45n1svt m=1 l=45n w=260n
Mmn11 n10 D0 VSS VSS g45n1svt m=1 l=45n w=260n
Mmn55 Q qbint VSS VSS g45n1svt m=1 l=45n w=260n
Mmn50 n35 qbint VSS VSS g45n1svt m=1 l=45n w=205n
Mmn51 n30 CKb n35 VSS g45n1svt m=1 l=45n w=205n
Mmn10 S0b S0 VSS VSS g45n1svt m=1 l=45n w=145n
Mmn40 mout CKbb n30 VSS g45n1svt m=1 l=45n w=205n
Mmn35 n25 mout VSS VSS g45n1svt m=1 l=45n w=205n
Mmn36 n20 CKbb n25 VSS g45n1svt m=1 l=45n w=205n
Mmn21 CKbb CKb VSS VSS g45n1svt m=1 l=45n w=145n
Mmn45 qbint n30 VSS VSS g45n1svt m=1 l=45n w=205n
Mmn25 D0b CKb n20 VSS g45n1svt m=1 l=45n w=205n
Mmn30 mout n20 VSS VSS g45n1svt m=1 l=45n w=205n
Mmn20 CKb CK VSS VSS g45n1svt m=1 l=45n w=145n
Mmp14 D0b S0b n13 NW g45p1svt m=1 l=45n w=390n
Mmp13 n13 D1 VDD NW g45p1svt m=1 l=45n w=390n
Mmp12 D0b S0 n11 NW g45p1svt m=1 l=45n w=390n
Mmp11 n11 D0 VDD NW g45p1svt m=1 l=45n w=390n
Mmp51 n30 CKbb n36 NW g45p1svt m=1 l=45n w=310n
Mmp50 n36 qbint VDD NW g45p1svt m=1 l=45n w=310n
Mmp55 Q qbint VDD NW g45p1svt m=1 l=45n w=390n
Mmp35 n26 mout VDD NW g45p1svt m=1 l=45n w=310n
Mmp36 n20 CKb n26 NW g45p1svt m=1 l=45n w=310n
Mmp25 n20 CKbb D0b NW g45p1svt m=1 l=45n w=310n
Mmp21 CKbb CKb VDD NW g45p1svt m=1 l=45n w=215n
Mmp30 mout n20 VDD NW g45p1svt m=1 l=45n w=310n
Mmp40 n30 CKb mout NW g45p1svt m=1 l=45n w=310n
Mmp10 S0b S0 VDD NW g45p1svt m=1 l=45n w=215n
Mmp45 qbint n30 VDD NW g45p1svt m=1 l=45n w=310n
Mmp20 CKb CK VDD NW g45p1svt m=1 l=45n w=215n
.ENDS

.SUBCKT MDFFHQX2 CK D0 D1 NW Q S0 VDD VSS
*.PININFO CK:I D0:I D1:I NW:I S0:I VDD:I VSS:I Q:O
Mmn13 n12 D1 VSS VSS g45n1svt m=1 l=45n w=260n
Mmn14 D0b S0 n12 VSS g45n1svt m=1 l=45n w=260n
Mmn12 D0b S0b n10 VSS g45n1svt m=1 l=45n w=260n
Mmn11 n10 D0 VSS VSS g45n1svt m=1 l=45n w=260n
Mmn55 Q qbint VSS VSS g45n1svt m=1 l=45n w=520n
Mmn50 n35 qbint VSS VSS g45n1svt m=1 l=45n w=205n
Mmn51 n30 CKb n35 VSS g45n1svt m=1 l=45n w=205n
Mmn10 S0b S0 VSS VSS g45n1svt m=1 l=45n w=145n
Mmn40 mout CKbb n30 VSS g45n1svt m=1 l=45n w=205n
Mmn35 n25 mout VSS VSS g45n1svt m=1 l=45n w=205n
Mmn36 n20 CKbb n25 VSS g45n1svt m=1 l=45n w=205n
Mmn21 CKbb CKb VSS VSS g45n1svt m=1 l=45n w=145n
Mmn45 qbint n30 VSS VSS g45n1svt m=1 l=45n w=205n
Mmn25 D0b CKb n20 VSS g45n1svt m=1 l=45n w=205n
Mmn30 mout n20 VSS VSS g45n1svt m=1 l=45n w=205n
Mmn20 CKb CK VSS VSS g45n1svt m=1 l=45n w=145n
Mmp14 D0b S0b n13 NW g45p1svt m=1 l=45n w=390n
Mmp13 n13 D1 VDD NW g45p1svt m=1 l=45n w=390n
Mmp12 D0b S0 n11 NW g45p1svt m=1 l=45n w=390n
Mmp11 n11 D0 VDD NW g45p1svt m=1 l=45n w=390n
Mmp51 n30 CKbb n36 NW g45p1svt m=1 l=45n w=310n
Mmp50 n36 qbint VDD NW g45p1svt m=1 l=45n w=310n
Mmp55 Q qbint VDD NW g45p1svt m=1 l=45n w=780n
Mmp35 n26 mout VDD NW g45p1svt m=1 l=45n w=310n
Mmp36 n20 CKb n26 NW g45p1svt m=1 l=45n w=310n
Mmp25 n20 CKbb D0b NW g45p1svt m=1 l=45n w=310n
Mmp21 CKbb CKb VDD NW g45p1svt m=1 l=45n w=215n
Mmp30 mout n20 VDD NW g45p1svt m=1 l=45n w=310n
Mmp40 n30 CKb mout NW g45p1svt m=1 l=45n w=310n
Mmp10 S0b S0 VDD NW g45p1svt m=1 l=45n w=215n
Mmp45 qbint n30 VDD NW g45p1svt m=1 l=45n w=310n
Mmp20 CKb CK VDD NW g45p1svt m=1 l=45n w=215n
.ENDS

.SUBCKT MDFFHQX4 CK D0 D1 NW Q S0 VDD VSS
*.PININFO CK:I D0:I D1:I NW:I S0:I VDD:I VSS:I Q:O
Mmn13 n12 D1 VSS VSS g45n1svt m=1 l=45n w=260n
Mmn14 D0b S0 n12 VSS g45n1svt m=1 l=45n w=260n
Mmn12 D0b S0b n10 VSS g45n1svt m=1 l=45n w=260n
Mmn11 n10 D0 VSS VSS g45n1svt m=1 l=45n w=260n
Mmn55 Q qbint VSS VSS g45n1svt m=1 l=45n w=1.04u
Mmn50 n35 qbint VSS VSS g45n1svt m=1 l=45n w=205n
Mmn51 n30 CKb n35 VSS g45n1svt m=1 l=45n w=205n
Mmn10 S0b S0 VSS VSS g45n1svt m=1 l=45n w=145n
Mmn40 mout CKbb n30 VSS g45n1svt m=1 l=45n w=205n
Mmn35 n25 mout VSS VSS g45n1svt m=1 l=45n w=205n
Mmn36 n20 CKbb n25 VSS g45n1svt m=1 l=45n w=205n
Mmn21 CKbb CKb VSS VSS g45n1svt m=1 l=45n w=145n
Mmn45 qbint n30 VSS VSS g45n1svt m=1 l=45n w=410n
Mmn25 D0b CKb n20 VSS g45n1svt m=1 l=45n w=205n
Mmn30 mout n20 VSS VSS g45n1svt m=1 l=45n w=205n
Mmn20 CKb CK VSS VSS g45n1svt m=1 l=45n w=145n
Mmp14 D0b S0b n13 NW g45p1svt m=1 l=45n w=390n
Mmp13 n13 D1 VDD NW g45p1svt m=1 l=45n w=390n
Mmp12 D0b S0 n11 NW g45p1svt m=1 l=45n w=390n
Mmp11 n11 D0 VDD NW g45p1svt m=1 l=45n w=390n
Mmp51 n30 CKbb n36 NW g45p1svt m=1 l=45n w=310n
Mmp50 n36 qbint VDD NW g45p1svt m=1 l=45n w=310n
Mmp55 Q qbint VDD NW g45p1svt m=1 l=45n w=1.56u
Mmp35 n26 mout VDD NW g45p1svt m=1 l=45n w=310n
Mmp36 n20 CKb n26 NW g45p1svt m=1 l=45n w=310n
Mmp25 n20 CKbb D0b NW g45p1svt m=1 l=45n w=310n
Mmp21 CKbb CKb VDD NW g45p1svt m=1 l=45n w=215n
Mmp30 mout n20 VDD NW g45p1svt m=1 l=45n w=310n
Mmp40 n30 CKb mout NW g45p1svt m=1 l=45n w=310n
Mmp10 S0b S0 VDD NW g45p1svt m=1 l=45n w=215n
Mmp45 qbint n30 VDD NW g45p1svt m=1 l=45n w=620n
Mmp20 CKb CK VDD NW g45p1svt m=1 l=45n w=215n
.ENDS

.SUBCKT MDFFHQX8 CK D0 D1 NW Q S0 VDD VSS
*.PININFO CK:I D0:I D1:I NW:I S0:I VDD:I VSS:I Q:O
Mmn13 n12 D1 VSS VSS g45n1svt m=1 l=45n w=260n
Mmn14 D0b S0 n12 VSS g45n1svt m=1 l=45n w=260n
Mmn12 D0b S0b n10 VSS g45n1svt m=1 l=45n w=260n
Mmn11 n10 D0 VSS VSS g45n1svt m=1 l=45n w=260n
Mmn55 Q qbint VSS VSS g45n1svt m=1 l=45n w=2.065u
Mmn50 n35 qbint VSS VSS g45n1svt m=1 l=45n w=205n
Mmn51 n30 CKb n35 VSS g45n1svt m=1 l=45n w=205n
Mmn10 S0b S0 VSS VSS g45n1svt m=1 l=45n w=145n
Mmn40 mout CKbb n30 VSS g45n1svt m=1 l=45n w=205n
Mmn35 n25 mout VSS VSS g45n1svt m=1 l=45n w=205n
Mmn36 n20 CKbb n25 VSS g45n1svt m=1 l=45n w=205n
Mmn21 CKbb CKb VSS VSS g45n1svt m=1 l=45n w=145n
Mmn45 qbint n30 VSS VSS g45n1svt m=1 l=45n w=780n
Mmn25 D0b CKb n20 VSS g45n1svt m=1 l=45n w=205n
Mmn30 mout n20 VSS VSS g45n1svt m=1 l=45n w=205n
Mmn20 CKb CK VSS VSS g45n1svt m=1 l=45n w=145n
Mmp14 D0b S0b n13 NW g45p1svt m=1 l=45n w=390n
Mmp13 n13 D1 VDD NW g45p1svt m=1 l=45n w=390n
Mmp12 D0b S0 n11 NW g45p1svt m=1 l=45n w=390n
Mmp11 n11 D0 VDD NW g45p1svt m=1 l=45n w=390n
Mmp51 n30 CKbb n36 NW g45p1svt m=1 l=45n w=310n
Mmp50 n36 qbint VDD NW g45p1svt m=1 l=45n w=310n
Mmp55 Q qbint VDD NW g45p1svt m=1 l=45n w=3.115u
Mmp35 n26 mout VDD NW g45p1svt m=1 l=45n w=310n
Mmp36 n20 CKb n26 NW g45p1svt m=1 l=45n w=310n
Mmp25 n20 CKbb D0b NW g45p1svt m=1 l=45n w=310n
Mmp21 CKbb CKb VDD NW g45p1svt m=1 l=45n w=215n
Mmp30 mout n20 VDD NW g45p1svt m=1 l=45n w=310n
Mmp40 n30 CKb mout NW g45p1svt m=1 l=45n w=310n
Mmp10 S0b S0 VDD NW g45p1svt m=1 l=45n w=215n
Mmp45 qbint n30 VDD NW g45p1svt m=1 l=45n w=1.17u
Mmp20 CKb CK VDD NW g45p1svt m=1 l=45n w=215n
.ENDS

.SUBCKT MX2X1 A B NW S0 VDD VSS Y
*.PININFO A:I B:I NW:I S0:I VDD:I VSS:I Y:O
Mmn3 n5 B VSS VSS g45n1svt m=1 l=45n w=145n
Mmn4 n0 S0 n5 VSS g45n1svt m=1 l=45n w=145n
Mmn0 S0b S0 VSS VSS g45n1svt m=1 l=45n w=145n
Mmn1 n3 A VSS VSS g45n1svt m=1 l=45n w=145n
Mmn5 Y n0 VSS VSS g45n1svt m=1 l=45n w=260n
Mmn2 n0 S0b n3 VSS g45n1svt m=1 l=45n w=145n
Mmp4 n0 S0b n6 NW g45p1svt m=1 l=45n w=215n
Mmp3 n6 B VDD NW g45p1svt m=1 l=45n w=215n
Mmp5 Y n0 VDD NW g45p1svt m=1 l=45n w=390n
Mmp0 S0b S0 VDD NW g45p1svt m=1 l=45n w=215n
Mmp2 n0 S0 n4 NW g45p1svt m=1 l=45n w=215n
Mmp1 n4 A VDD NW g45p1svt m=1 l=45n w=215n
.ENDS

.SUBCKT MX2X2 A B NW S0 VDD VSS Y
*.PININFO A:I B:I NW:I S0:I VDD:I VSS:I Y:O
Mmn3 n5 B VSS VSS g45n1svt m=1 l=45n w=145n
Mmn4 n0 S0 n5 VSS g45n1svt m=1 l=45n w=145n
Mmn0 S0b S0 VSS VSS g45n1svt m=1 l=45n w=145n
Mmn1 n3 A VSS VSS g45n1svt m=1 l=45n w=145n
Mmn5 Y n0 VSS VSS g45n1svt m=1 l=45n w=520n
Mmn2 n0 S0b n3 VSS g45n1svt m=1 l=45n w=145n
Mmp4 n0 S0b n6 NW g45p1svt m=1 l=45n w=215n
Mmp3 n6 B VDD NW g45p1svt m=1 l=45n w=215n
Mmp5 Y n0 VDD NW g45p1svt m=1 l=45n w=780n
Mmp0 S0b S0 VDD NW g45p1svt m=1 l=45n w=215n
Mmp2 n0 S0 n4 NW g45p1svt m=1 l=45n w=215n
Mmp1 n4 A VDD NW g45p1svt m=1 l=45n w=215n
.ENDS

.SUBCKT MX2X4 A B NW S0 VDD VSS Y
*.PININFO A:I B:I NW:I S0:I VDD:I VSS:I Y:O
Mmn3 n5 B VSS VSS g45n1svt m=1 l=45n w=205n
Mmn4 n0 S0 n5 VSS g45n1svt m=1 l=45n w=205n
Mmn0 S0b S0 VSS VSS g45n1svt m=1 l=45n w=145n
Mmn1 n3 A VSS VSS g45n1svt m=1 l=45n w=205n
Mmn5 Y n0 VSS VSS g45n1svt m=1 l=45n w=1.04u
Mmn2 n0 S0b n3 VSS g45n1svt m=1 l=45n w=205n
Mmp4 n0 S0b n6 NW g45p1svt m=1 l=45n w=310n
Mmp3 n6 B VDD NW g45p1svt m=1 l=45n w=310n
Mmp5 Y n0 VDD NW g45p1svt m=1 l=45n w=1.56u
Mmp0 S0b S0 VDD NW g45p1svt m=1 l=45n w=215n
Mmp2 n0 S0 n4 NW g45p1svt m=1 l=45n w=310n
Mmp1 n4 A VDD NW g45p1svt m=1 l=45n w=310n
.ENDS

.SUBCKT MX2X6 A B NW S0 VDD VSS Y
*.PININFO A:I B:I NW:I S0:I VDD:I VSS:I Y:O
Mmn3 n5 B VSS VSS g45n1svt m=1 l=45n w=205n
Mmn4 n0 S0 n5 VSS g45n1svt m=1 l=45n w=205n
Mmn0 S0b S0 VSS VSS g45n1svt m=1 l=45n w=145n
Mmn1 n3 A VSS VSS g45n1svt m=1 l=45n w=205n
Mmn5 Y n0 VSS VSS g45n1svt m=1 l=45n w=1.55u
Mmn2 n0 S0b n3 VSS g45n1svt m=1 l=45n w=205n
Mmp4 n0 S0b n6 NW g45p1svt m=1 l=45n w=310n
Mmp3 n6 B VDD NW g45p1svt m=1 l=45n w=310n
Mmp5 Y n0 VDD NW g45p1svt m=1 l=45n w=2.35u
Mmp0 S0b S0 VDD NW g45p1svt m=1 l=45n w=215n
Mmp2 n0 S0 n4 NW g45p1svt m=1 l=45n w=310n
Mmp1 n4 A VDD NW g45p1svt m=1 l=45n w=310n
.ENDS

.SUBCKT MX2X8 A B NW S0 VDD VSS Y
*.PININFO A:I B:I NW:I S0:I VDD:I VSS:I Y:O
Mmn3 n5 B VSS VSS g45n1svt m=1 l=45n w=205n
Mmn4 n0 S0 n5 VSS g45n1svt m=1 l=45n w=205n
Mmn0 S0b S0 VSS VSS g45n1svt m=1 l=45n w=145n
Mmn1 n3 A VSS VSS g45n1svt m=1 l=45n w=205n
Mmn5 Y n0 VSS VSS g45n1svt m=1 l=45n w=2.065u
Mmn2 n0 S0b n3 VSS g45n1svt m=1 l=45n w=205n
Mmp4 n0 S0b n6 NW g45p1svt m=1 l=45n w=310n
Mmp3 n6 B VDD NW g45p1svt m=1 l=45n w=310n
Mmp5 Y n0 VDD NW g45p1svt m=1 l=45n w=3.115u
Mmp0 S0b S0 VDD NW g45p1svt m=1 l=45n w=215n
Mmp2 n0 S0 n4 NW g45p1svt m=1 l=45n w=310n
Mmp1 n4 A VDD NW g45p1svt m=1 l=45n w=310n
.ENDS

.SUBCKT MX2XL A B NW S0 VDD VSS Y
*.PININFO A:I B:I NW:I S0:I VDD:I VSS:I Y:O
Mmn3 n5 B VSS VSS g45n1svt m=1 l=45n w=145n
Mmn4 n0 S0 n5 VSS g45n1svt m=1 l=45n w=145n
Mmn0 S0b S0 VSS VSS g45n1svt m=1 l=45n w=145n
Mmn1 n3 A VSS VSS g45n1svt m=1 l=45n w=145n
Mmn5 Y n0 VSS VSS g45n1svt m=1 l=45n w=145n
Mmn2 n0 S0b n3 VSS g45n1svt m=1 l=45n w=145n
Mmp4 n0 S0b n6 NW g45p1svt m=1 l=45n w=215n
Mmp3 n6 B VDD NW g45p1svt m=1 l=45n w=215n
Mmp5 Y n0 VDD NW g45p1svt m=1 l=45n w=215n
Mmp0 S0b S0 VDD NW g45p1svt m=1 l=45n w=215n
Mmp2 n0 S0 n4 NW g45p1svt m=1 l=45n w=215n
Mmp1 n4 A VDD NW g45p1svt m=1 l=45n w=215n
.ENDS

.SUBCKT MX3X1 A B C NW S0 S1 VDD VSS Y
*.PININFO A:I B:I C:I NW:I S0:I S1:I VDD:I VSS:I Y:O
Mmn7 net245 C VSS VSS g45n1svt m=1 l=45n w=145n
Mmn8 n1 S1 net245 VSS g45n1svt m=1 l=45n w=145n
Mmn4 net234 B VSS VSS g45n1svt m=1 l=45n w=145n
Mmn5 n0 S0 net234 VSS g45n1svt m=1 l=45n w=145n
Mmn3 n0 S0b net229 VSS g45n1svt m=1 l=45n w=145n
Mmn2 net229 A VSS VSS g45n1svt m=1 l=45n w=145n
Mmn9 Y n1 VSS VSS g45n1svt m=1 l=45n w=260n
Mmn0 S0b S0 VSS VSS g45n1svt m=1 l=45n w=145n
Mmn1 S1b S1 VSS VSS g45n1svt m=1 l=45n w=145n
Mmn6 n1 S1b n0 VSS g45n1svt m=1 l=45n w=145n
Mmp8 n1 S1b net202 NW g45p1svt m=1 l=45n w=215n
Mmp7 net202 C VDD NW g45p1svt m=1 l=45n w=215n
Mmp5 n0 S0b net190 NW g45p1svt m=1 l=45n w=215n
Mmp4 net190 B VDD NW g45p1svt m=1 l=45n w=215n
Mmp3 n0 S0 net189 NW g45p1svt m=1 l=45n w=215n
Mmp2 net189 A VDD NW g45p1svt m=1 l=45n w=215n
Mmp9 Y n1 VDD NW g45p1svt m=1 l=45n w=390n
Mmp1 S1b S1 VDD NW g45p1svt m=1 l=45n w=215n
Mmp6 n0 S1 n1 NW g45p1svt m=1 l=45n w=215n
Mmp0 S0b S0 VDD NW g45p1svt m=1 l=45n w=215n
.ENDS

.SUBCKT MX3X2 A B C NW S0 S1 VDD VSS Y
*.PININFO A:I B:I C:I NW:I S0:I S1:I VDD:I VSS:I Y:O
Mmn7 net245 C VSS VSS g45n1svt m=1 l=45n w=145n
Mmn8 n1 S1 net245 VSS g45n1svt m=1 l=45n w=145n
Mmn4 net234 B VSS VSS g45n1svt m=1 l=45n w=145n
Mmn5 n0 S0 net234 VSS g45n1svt m=1 l=45n w=145n
Mmn3 n0 S0b net229 VSS g45n1svt m=1 l=45n w=145n
Mmn2 net229 A VSS VSS g45n1svt m=1 l=45n w=145n
Mmn9 Y n1 VSS VSS g45n1svt m=1 l=45n w=520n
Mmn0 S0b S0 VSS VSS g45n1svt m=1 l=45n w=145n
Mmn1 S1b S1 VSS VSS g45n1svt m=1 l=45n w=145n
Mmn6 n1 S1b n0 VSS g45n1svt m=1 l=45n w=145n
Mmp8 n1 S1b net202 NW g45p1svt m=1 l=45n w=215n
Mmp7 net202 C VDD NW g45p1svt m=1 l=45n w=215n
Mmp5 n0 S0b net190 NW g45p1svt m=1 l=45n w=215n
Mmp4 net190 B VDD NW g45p1svt m=1 l=45n w=215n
Mmp3 n0 S0 net189 NW g45p1svt m=1 l=45n w=215n
Mmp2 net189 A VDD NW g45p1svt m=1 l=45n w=215n
Mmp9 Y n1 VDD NW g45p1svt m=1 l=45n w=780n
Mmp1 S1b S1 VDD NW g45p1svt m=1 l=45n w=215n
Mmp6 n0 S1 n1 NW g45p1svt m=1 l=45n w=215n
Mmp0 S0b S0 VDD NW g45p1svt m=1 l=45n w=215n
.ENDS

.SUBCKT MX3X4 A B C NW S0 S1 VDD VSS Y
*.PININFO A:I B:I C:I NW:I S0:I S1:I VDD:I VSS:I Y:O
Mmn7 net245 C VSS VSS g45n1svt m=1 l=45n w=260n
Mmn8 n1 S1 net245 VSS g45n1svt m=1 l=45n w=260n
Mmn4 net234 B VSS VSS g45n1svt m=1 l=45n w=145n
Mmn5 n0 S0 net234 VSS g45n1svt m=1 l=45n w=145n
Mmn3 n0 S0b net229 VSS g45n1svt m=1 l=45n w=145n
Mmn2 net229 A VSS VSS g45n1svt m=1 l=45n w=145n
Mmn9 Y n1 VSS VSS g45n1svt m=1 l=45n w=1.04u
Mmn0 S0b S0 VSS VSS g45n1svt m=1 l=45n w=145n
Mmn1 S1b S1 VSS VSS g45n1svt m=1 l=45n w=145n
Mmn6 n1 S1b n0 VSS g45n1svt m=1 l=45n w=260n
Mmp8 n1 S1b net202 NW g45p1svt m=1 l=45n w=390n
Mmp7 net202 C VDD NW g45p1svt m=1 l=45n w=390n
Mmp5 n0 S0b net190 NW g45p1svt m=1 l=45n w=215n
Mmp4 net190 B VDD NW g45p1svt m=1 l=45n w=215n
Mmp3 n0 S0 net189 NW g45p1svt m=1 l=45n w=215n
Mmp2 net189 A VDD NW g45p1svt m=1 l=45n w=215n
Mmp9 Y n1 VDD NW g45p1svt m=1 l=45n w=1.56u
Mmp1 S1b S1 VDD NW g45p1svt m=1 l=45n w=215n
Mmp6 n0 S1 n1 NW g45p1svt m=1 l=45n w=390n
Mmp0 S0b S0 VDD NW g45p1svt m=1 l=45n w=215n
.ENDS

.SUBCKT MX3XL A B C NW S0 S1 VDD VSS Y
*.PININFO A:I B:I C:I NW:I S0:I S1:I VDD:I VSS:I Y:O
Mmn7 net245 C VSS VSS g45n1svt m=1 l=45n w=145n
Mmn8 n1 S1 net245 VSS g45n1svt m=1 l=45n w=145n
Mmn4 net234 B VSS VSS g45n1svt m=1 l=45n w=145n
Mmn5 n0 S0 net234 VSS g45n1svt m=1 l=45n w=145n
Mmn3 n0 S0b net229 VSS g45n1svt m=1 l=45n w=145n
Mmn2 net229 A VSS VSS g45n1svt m=1 l=45n w=145n
Mmn9 Y n1 VSS VSS g45n1svt m=1 l=45n w=145n
Mmn0 S0b S0 VSS VSS g45n1svt m=1 l=45n w=145n
Mmn1 S1b S1 VSS VSS g45n1svt m=1 l=45n w=145n
Mmn6 n1 S1b n0 VSS g45n1svt m=1 l=45n w=145n
Mmp8 n1 S1b net202 NW g45p1svt m=1 l=45n w=215n
Mmp7 net202 C VDD NW g45p1svt m=1 l=45n w=215n
Mmp5 n0 S0b net190 NW g45p1svt m=1 l=45n w=215n
Mmp4 net190 B VDD NW g45p1svt m=1 l=45n w=215n
Mmp3 n0 S0 net189 NW g45p1svt m=1 l=45n w=215n
Mmp2 net189 A VDD NW g45p1svt m=1 l=45n w=215n
Mmp9 Y n1 VDD NW g45p1svt m=1 l=45n w=215n
Mmp1 S1b S1 VDD NW g45p1svt m=1 l=45n w=215n
Mmp6 n0 S1 n1 NW g45p1svt m=1 l=45n w=215n
Mmp0 S0b S0 VDD NW g45p1svt m=1 l=45n w=215n
.ENDS

.SUBCKT MX4X1 A B C D NW S0 S1 VDD VSS Y
*.PININFO A:I B:I C:I D:I NW:I S0:I S1:I VDD:I VSS:I Y:O
Mmn9 n1 S0 n9 VSS g45n1svt m=1 l=45n w=145n
Mmn6 n7 C VSS VSS g45n1svt m=1 l=45n w=145n
Mmn7 n1 S0b n7 VSS g45n1svt m=1 l=45n w=145n
Mmn4 n5 B VSS VSS g45n1svt m=1 l=45n w=145n
Mmn5 n0 S0 n5 VSS g45n1svt m=1 l=45n w=145n
Mmn3 n0 S0b n3 VSS g45n1svt m=1 l=45n w=145n
Mmn2 n3 A VSS VSS g45n1svt m=1 l=45n w=145n
Mmn12 Y n2 VSS VSS g45n1svt m=1 l=45n w=260n
Mmn1 S1b S1 VSS VSS g45n1svt m=1 l=45n w=145n
Mmn11 n2 S1 n1 VSS g45n1svt m=1 l=45n w=145n
Mmn8 n9 D VSS VSS g45n1svt m=1 l=45n w=145n
Mmn10 n2 S1b n0 VSS g45n1svt m=1 l=45n w=145n
Mmn0 S0b S0 VSS VSS g45n1svt m=1 l=45n w=145n
Mmp9 n1 S0b n10 NW g45p1svt m=1 l=45n w=215n
Mmp8 n10 D VDD NW g45p1svt m=1 l=45n w=215n
Mmp7 n1 S0 n8 NW g45p1svt m=1 l=45n w=215n
Mmp6 n8 C VDD NW g45p1svt m=1 l=45n w=215n
Mmp5 n0 S0b n6 NW g45p1svt m=1 l=45n w=215n
Mmp4 n6 B VDD NW g45p1svt m=1 l=45n w=215n
Mmp3 n0 S0 n4 NW g45p1svt m=1 l=45n w=215n
Mmp2 n4 A VDD NW g45p1svt m=1 l=45n w=215n
Mmp12 Y n2 VDD NW g45p1svt m=1 l=45n w=390n
Mmp0 S0b S0 VDD NW g45p1svt m=1 l=45n w=215n
Mmp10 n2 S1 n0 NW g45p1svt m=1 l=45n w=215n
Mmp11 n1 S1b n2 NW g45p1svt m=1 l=45n w=215n
Mmp1 S1b S1 VDD NW g45p1svt m=1 l=45n w=215n
.ENDS

.SUBCKT MX4X2 A B C D NW S0 S1 VDD VSS Y
*.PININFO A:I B:I C:I D:I NW:I S0:I S1:I VDD:I VSS:I Y:O
Mmn9 n1 S0 n9 VSS g45n1svt m=1 l=45n w=145n
Mmn6 n7 C VSS VSS g45n1svt m=1 l=45n w=145n
Mmn7 n1 S0b n7 VSS g45n1svt m=1 l=45n w=145n
Mmn4 n5 B VSS VSS g45n1svt m=1 l=45n w=145n
Mmn5 n0 S0 n5 VSS g45n1svt m=1 l=45n w=145n
Mmn3 n0 S0b n3 VSS g45n1svt m=1 l=45n w=145n
Mmn2 n3 A VSS VSS g45n1svt m=1 l=45n w=145n
Mmn12 Y n2 VSS VSS g45n1svt m=1 l=45n w=520n
Mmn1 S1b S1 VSS VSS g45n1svt m=1 l=45n w=145n
Mmn11 n2 S1 n1 VSS g45n1svt m=1 l=45n w=145n
Mmn8 n9 D VSS VSS g45n1svt m=1 l=45n w=145n
Mmn10 n2 S1b n0 VSS g45n1svt m=1 l=45n w=145n
Mmn0 S0b S0 VSS VSS g45n1svt m=1 l=45n w=145n
Mmp9 n1 S0b n10 NW g45p1svt m=1 l=45n w=215n
Mmp8 n10 D VDD NW g45p1svt m=1 l=45n w=215n
Mmp7 n1 S0 n8 NW g45p1svt m=1 l=45n w=215n
Mmp6 n8 C VDD NW g45p1svt m=1 l=45n w=215n
Mmp5 n0 S0b n6 NW g45p1svt m=1 l=45n w=215n
Mmp4 n6 B VDD NW g45p1svt m=1 l=45n w=215n
Mmp3 n0 S0 n4 NW g45p1svt m=1 l=45n w=215n
Mmp2 n4 A VDD NW g45p1svt m=1 l=45n w=215n
Mmp12 Y n2 VDD NW g45p1svt m=1 l=45n w=780n
Mmp0 S0b S0 VDD NW g45p1svt m=1 l=45n w=215n
Mmp10 n2 S1 n0 NW g45p1svt m=1 l=45n w=215n
Mmp11 n1 S1b n2 NW g45p1svt m=1 l=45n w=215n
Mmp1 S1b S1 VDD NW g45p1svt m=1 l=45n w=215n
.ENDS

.SUBCKT MX4X4 A B C D NW S0 S1 VDD VSS Y
*.PININFO A:I B:I C:I D:I NW:I S0:I S1:I VDD:I VSS:I Y:O
Mmn9 n1 S0 n9 VSS g45n1svt m=1 l=45n w=145n
Mmn6 n7 C VSS VSS g45n1svt m=1 l=45n w=145n
Mmn7 n1 S0b n7 VSS g45n1svt m=1 l=45n w=145n
Mmn4 n5 B VSS VSS g45n1svt m=1 l=45n w=145n
Mmn5 n0 S0 n5 VSS g45n1svt m=1 l=45n w=145n
Mmn3 n0 S0b n3 VSS g45n1svt m=1 l=45n w=145n
Mmn2 n3 A VSS VSS g45n1svt m=1 l=45n w=145n
Mmn12 Y n2 VSS VSS g45n1svt m=1 l=45n w=1.04u
Mmn1 S1b S1 VSS VSS g45n1svt m=1 l=45n w=145n
Mmn11 n2 S1 n1 VSS g45n1svt m=1 l=45n w=260n
Mmn8 n9 D VSS VSS g45n1svt m=1 l=45n w=145n
Mmn10 n2 S1b n0 VSS g45n1svt m=1 l=45n w=260n
Mmn0 S0b S0 VSS VSS g45n1svt m=1 l=45n w=145n
Mmp9 n1 S0b n10 NW g45p1svt m=1 l=45n w=215n
Mmp8 n10 D VDD NW g45p1svt m=1 l=45n w=215n
Mmp7 n1 S0 n8 NW g45p1svt m=1 l=45n w=215n
Mmp6 n8 C VDD NW g45p1svt m=1 l=45n w=215n
Mmp5 n0 S0b n6 NW g45p1svt m=1 l=45n w=215n
Mmp4 n6 B VDD NW g45p1svt m=1 l=45n w=215n
Mmp3 n0 S0 n4 NW g45p1svt m=1 l=45n w=215n
Mmp2 n4 A VDD NW g45p1svt m=1 l=45n w=215n
Mmp12 Y n2 VDD NW g45p1svt m=1 l=45n w=1.56u
Mmp0 S0b S0 VDD NW g45p1svt m=1 l=45n w=215n
Mmp10 n2 S1 n0 NW g45p1svt m=1 l=45n w=390n
Mmp11 n1 S1b n2 NW g45p1svt m=1 l=45n w=390n
Mmp1 S1b S1 VDD NW g45p1svt m=1 l=45n w=215n
.ENDS

.SUBCKT MX4XL A B C D NW S0 S1 VDD VSS Y
*.PININFO A:I B:I C:I D:I NW:I S0:I S1:I VDD:I VSS:I Y:O
Mmn9 n1 S0 n9 VSS g45n1svt m=1 l=45n w=145n
Mmn6 n7 C VSS VSS g45n1svt m=1 l=45n w=145n
Mmn7 n1 S0b n7 VSS g45n1svt m=1 l=45n w=145n
Mmn4 n5 B VSS VSS g45n1svt m=1 l=45n w=145n
Mmn5 n0 S0 n5 VSS g45n1svt m=1 l=45n w=145n
Mmn3 n0 S0b n3 VSS g45n1svt m=1 l=45n w=145n
Mmn2 n3 A VSS VSS g45n1svt m=1 l=45n w=145n
Mmn12 Y n2 VSS VSS g45n1svt m=1 l=45n w=145n
Mmn1 S1b S1 VSS VSS g45n1svt m=1 l=45n w=145n
Mmn11 n2 S1 n1 VSS g45n1svt m=1 l=45n w=145n
Mmn8 n9 D VSS VSS g45n1svt m=1 l=45n w=145n
Mmn10 n2 S1b n0 VSS g45n1svt m=1 l=45n w=145n
Mmn0 S0b S0 VSS VSS g45n1svt m=1 l=45n w=145n
Mmp9 n1 S0b n10 NW g45p1svt m=1 l=45n w=215n
Mmp8 n10 D VDD NW g45p1svt m=1 l=45n w=215n
Mmp7 n1 S0 n8 NW g45p1svt m=1 l=45n w=215n
Mmp6 n8 C VDD NW g45p1svt m=1 l=45n w=215n
Mmp5 n0 S0b n6 NW g45p1svt m=1 l=45n w=215n
Mmp4 n6 B VDD NW g45p1svt m=1 l=45n w=215n
Mmp3 n0 S0 n4 NW g45p1svt m=1 l=45n w=215n
Mmp2 n4 A VDD NW g45p1svt m=1 l=45n w=215n
Mmp12 Y n2 VDD NW g45p1svt m=1 l=45n w=215n
Mmp0 S0b S0 VDD NW g45p1svt m=1 l=45n w=215n
Mmp10 n2 S1 n0 NW g45p1svt m=1 l=45n w=215n
Mmp11 n1 S1b n2 NW g45p1svt m=1 l=45n w=215n
Mmp1 S1b S1 VDD NW g45p1svt m=1 l=45n w=215n
.ENDS

.SUBCKT MXI2X1 A B NW S0 VDD VSS Y
*.PININFO A:I B:I NW:I S0:I VDD:I VSS:I Y:O
Mmn3 n5 B VSS VSS g45n1svt m=1 l=45n w=260n
Mmn4 Y S0 n5 VSS g45n1svt m=1 l=45n w=260n
Mmn2 Y S0b n3 VSS g45n1svt m=1 l=45n w=260n
Mmn1 n3 A VSS VSS g45n1svt m=1 l=45n w=260n
Mmn0 S0b S0 VSS VSS g45n1svt m=1 l=45n w=145n
Mmp4 Y S0b n6 NW g45p1svt m=1 l=45n w=390n
Mmp3 n6 B VDD NW g45p1svt m=1 l=45n w=390n
Mmp2 Y S0 n4 NW g45p1svt m=1 l=45n w=390n
Mmp1 n4 A VDD NW g45p1svt m=1 l=45n w=390n
Mmp0 S0b S0 VDD NW g45p1svt m=1 l=45n w=215n
.ENDS

.SUBCKT MXI2X2 A B NW S0 VDD VSS Y
*.PININFO A:I B:I NW:I S0:I VDD:I VSS:I Y:O
Mmn3 n5 B VSS VSS g45n1svt m=1 l=45n w=145n
Mmn4 n0 S0 n5 VSS g45n1svt m=1 l=45n w=145n
Mmn2 n0 S0b n3 VSS g45n1svt m=1 l=45n w=145n
Mmn1 n3 A VSS VSS g45n1svt m=1 l=45n w=145n
Mmn5 n1 n0 VSS VSS g45n1svt m=1 l=45n w=145n
Mmn6 Y n1 VSS VSS g45n1svt m=1 l=45n w=520n
Mmn0 S0b S0 VSS VSS g45n1svt m=1 l=45n w=145n
Mmp4 n0 S0b n6 NW g45p1svt m=1 l=45n w=215n
Mmp3 n6 B VDD NW g45p1svt m=1 l=45n w=215n
Mmp2 n0 S0 n4 NW g45p1svt m=1 l=45n w=215n
Mmp1 n4 A VDD NW g45p1svt m=1 l=45n w=215n
Mmp6 Y n1 VDD NW g45p1svt m=1 l=45n w=780n
Mmp5 n1 n0 VDD NW g45p1svt m=1 l=45n w=215n
Mmp0 S0b S0 VDD NW g45p1svt m=1 l=45n w=215n
.ENDS

.SUBCKT MXI2X4 A B NW S0 VDD VSS Y
*.PININFO A:I B:I NW:I S0:I VDD:I VSS:I Y:O
Mmn3 n5 B VSS VSS g45n1svt m=1 l=45n w=145n
Mmn4 n0 S0 n5 VSS g45n1svt m=1 l=45n w=145n
Mmn2 n0 S0b n3 VSS g45n1svt m=1 l=45n w=145n
Mmn1 n3 A VSS VSS g45n1svt m=1 l=45n w=145n
Mmn5 n1 n0 VSS VSS g45n1svt m=1 l=45n w=260n
Mmn6 Y n1 VSS VSS g45n1svt m=1 l=45n w=1.04u
Mmn0 S0b S0 VSS VSS g45n1svt m=1 l=45n w=145n
Mmp4 n0 S0b n6 NW g45p1svt m=1 l=45n w=215n
Mmp3 n6 B VDD NW g45p1svt m=1 l=45n w=215n
Mmp2 n0 S0 n4 NW g45p1svt m=1 l=45n w=215n
Mmp1 n4 A VDD NW g45p1svt m=1 l=45n w=215n
Mmp6 Y n1 VDD NW g45p1svt m=1 l=45n w=1.56u
Mmp5 n1 n0 VDD NW g45p1svt m=1 l=45n w=390n
Mmp0 S0b S0 VDD NW g45p1svt m=1 l=45n w=215n
.ENDS

.SUBCKT MXI2X6 A B NW S0 VDD VSS Y
*.PININFO A:I B:I NW:I S0:I VDD:I VSS:I Y:O
Mmn3 n5 B VSS VSS g45n1svt m=1 l=45n w=145n
Mmn4 n0 S0 n5 VSS g45n1svt m=1 l=45n w=145n
Mmn2 n0 S0b n3 VSS g45n1svt m=1 l=45n w=145n
Mmn1 n3 A VSS VSS g45n1svt m=1 l=45n w=145n
Mmn5 n1 n0 VSS VSS g45n1svt m=1 l=45n w=520n
Mmn6 Y n1 VSS VSS g45n1svt m=1 l=45n w=1.55u
Mmn0 S0b S0 VSS VSS g45n1svt m=1 l=45n w=145n
Mmp4 n0 S0b n6 NW g45p1svt m=1 l=45n w=215n
Mmp3 n6 B VDD NW g45p1svt m=1 l=45n w=215n
Mmp2 n0 S0 n4 NW g45p1svt m=1 l=45n w=215n
Mmp1 n4 A VDD NW g45p1svt m=1 l=45n w=215n
Mmp6 Y n1 VDD NW g45p1svt m=1 l=45n w=2.35u
Mmp5 n1 n0 VDD NW g45p1svt m=1 l=45n w=780n
Mmp0 S0b S0 VDD NW g45p1svt m=1 l=45n w=215n
.ENDS

.SUBCKT MXI2X8 A B NW S0 VDD VSS Y
*.PININFO A:I B:I NW:I S0:I VDD:I VSS:I Y:O
Mmn3 n5 B VSS VSS g45n1svt m=1 l=45n w=145n
Mmn4 n0 S0 n5 VSS g45n1svt m=1 l=45n w=145n
Mmn2 n0 S0b n3 VSS g45n1svt m=1 l=45n w=145n
Mmn1 n3 A VSS VSS g45n1svt m=1 l=45n w=145n
Mmn5 n1 n0 VSS VSS g45n1svt m=1 l=45n w=520n
Mmn6 Y n1 VSS VSS g45n1svt m=1 l=45n w=2.065u
Mmn0 S0b S0 VSS VSS g45n1svt m=1 l=45n w=145n
Mmp4 n0 S0b n6 NW g45p1svt m=1 l=45n w=215n
Mmp3 n6 B VDD NW g45p1svt m=1 l=45n w=215n
Mmp2 n0 S0 n4 NW g45p1svt m=1 l=45n w=215n
Mmp1 n4 A VDD NW g45p1svt m=1 l=45n w=215n
Mmp6 Y n1 VDD NW g45p1svt m=1 l=45n w=3.115u
Mmp5 n1 n0 VDD NW g45p1svt m=1 l=45n w=780n
Mmp0 S0b S0 VDD NW g45p1svt m=1 l=45n w=215n
.ENDS

.SUBCKT MXI2XL A B NW S0 VDD VSS Y
*.PININFO A:I B:I NW:I S0:I VDD:I VSS:I Y:O
Mmn3 n5 B VSS VSS g45n1svt m=1 l=45n w=145n
Mmn4 Y S0 n5 VSS g45n1svt m=1 l=45n w=145n
Mmn2 Y S0b n3 VSS g45n1svt m=1 l=45n w=145n
Mmn1 n3 A VSS VSS g45n1svt m=1 l=45n w=145n
Mmn0 S0b S0 VSS VSS g45n1svt m=1 l=45n w=145n
Mmp4 Y S0b n6 NW g45p1svt m=1 l=45n w=215n
Mmp3 n6 B VDD NW g45p1svt m=1 l=45n w=215n
Mmp2 Y S0 n4 NW g45p1svt m=1 l=45n w=215n
Mmp1 n4 A VDD NW g45p1svt m=1 l=45n w=215n
Mmp0 S0b S0 VDD NW g45p1svt m=1 l=45n w=215n
.ENDS

.SUBCKT MXI3X1 A B C NW S0 S1 VDD VSS Y
*.PININFO A:I B:I C:I NW:I S0:I S1:I VDD:I VSS:I Y:O
Mmn4 n4 B VSS VSS g45n1svt m=1 l=45n w=145n
Mmn5 n0 S0 n4 VSS g45n1svt m=1 l=45n w=145n
Mmn3 n0 S0b n2 VSS g45n1svt m=1 l=45n w=145n
Mmn2 n2 A VSS VSS g45n1svt m=1 l=45n w=145n
Mmn11 Y n1 VSS VSS g45n1svt m=1 l=45n w=260n
Mmn10 n1 S1 n8 VSS g45n1svt m=1 l=45n w=145n
Mmn9 n8 Cp VSS VSS g45n1svt m=1 l=45n w=145n
Mmn8 n1 S1b n6 VSS g45n1svt m=1 l=45n w=145n
Mmn7 n6 n0 VSS VSS g45n1svt m=1 l=45n w=145n
Mmn6 Cp C VSS VSS g45n1svt m=1 l=45n w=145n
Mmn0 S0b S0 VSS VSS g45n1svt m=1 l=45n w=145n
Mmn1 S1b S1 VSS VSS g45n1svt m=1 l=45n w=145n
Mmp5 n0 S0b n5 NW g45p1svt m=1 l=45n w=215n
Mmp4 n5 B VDD NW g45p1svt m=1 l=45n w=215n
Mmp3 n0 S0 n3 NW g45p1svt m=1 l=45n w=215n
Mmp2 n3 A VDD NW g45p1svt m=1 l=45n w=215n
Mmp8 n1 S1 n7 NW g45p1svt m=1 l=45n w=215n
Mmp7 n7 n0 VDD NW g45p1svt m=1 l=45n w=215n
Mmp11 Y n1 VDD NW g45p1svt m=1 l=45n w=390n
Mmp9 n9 Cp VDD NW g45p1svt m=1 l=45n w=215n
Mmp10 n1 S1b n9 NW g45p1svt m=1 l=45n w=215n
Mmp6 Cp C VDD NW g45p1svt m=1 l=45n w=215n
Mmp1 S1b S1 VDD NW g45p1svt m=1 l=45n w=215n
Mmp0 S0b S0 VDD NW g45p1svt m=1 l=45n w=215n
.ENDS

.SUBCKT MXI3X2 A B C NW S0 S1 VDD VSS Y
*.PININFO A:I B:I C:I NW:I S0:I S1:I VDD:I VSS:I Y:O
Mmn4 n4 B VSS VSS g45n1svt m=1 l=45n w=145n
Mmn5 n0 S0 n4 VSS g45n1svt m=1 l=45n w=145n
Mmn3 n0 S0b n2 VSS g45n1svt m=1 l=45n w=145n
Mmn2 n2 A VSS VSS g45n1svt m=1 l=45n w=145n
Mmn11 Y n1 VSS VSS g45n1svt m=1 l=45n w=520n
Mmn10 n1 S1 n8 VSS g45n1svt m=1 l=45n w=145n
Mmn9 n8 Cp VSS VSS g45n1svt m=1 l=45n w=145n
Mmn8 n1 S1b n6 VSS g45n1svt m=1 l=45n w=145n
Mmn7 n6 n0 VSS VSS g45n1svt m=1 l=45n w=145n
Mmn6 Cp C VSS VSS g45n1svt m=1 l=45n w=145n
Mmn0 S0b S0 VSS VSS g45n1svt m=1 l=45n w=145n
Mmn1 S1b S1 VSS VSS g45n1svt m=1 l=45n w=145n
Mmp5 n0 S0b n5 NW g45p1svt m=1 l=45n w=215n
Mmp4 n5 B VDD NW g45p1svt m=1 l=45n w=215n
Mmp3 n0 S0 n3 NW g45p1svt m=1 l=45n w=215n
Mmp2 n3 A VDD NW g45p1svt m=1 l=45n w=215n
Mmp8 n1 S1 n7 NW g45p1svt m=1 l=45n w=215n
Mmp7 n7 n0 VDD NW g45p1svt m=1 l=45n w=215n
Mmp11 Y n1 VDD NW g45p1svt m=1 l=45n w=780n
Mmp9 n9 Cp VDD NW g45p1svt m=1 l=45n w=215n
Mmp10 n1 S1b n9 NW g45p1svt m=1 l=45n w=215n
Mmp6 Cp C VDD NW g45p1svt m=1 l=45n w=215n
Mmp1 S1b S1 VDD NW g45p1svt m=1 l=45n w=215n
Mmp0 S0b S0 VDD NW g45p1svt m=1 l=45n w=215n
.ENDS

.SUBCKT MXI3X4 A B C NW S0 S1 VDD VSS Y
*.PININFO A:I B:I C:I NW:I S0:I S1:I VDD:I VSS:I Y:O
Mmn4 n4 B VSS VSS g45n1svt m=1 l=45n w=145n
Mmn5 n0 S0 n4 VSS g45n1svt m=1 l=45n w=145n
Mmn3 n0 S0b n2 VSS g45n1svt m=1 l=45n w=145n
Mmn2 n2 A VSS VSS g45n1svt m=1 l=45n w=145n
Mmn11 Y n1 VSS VSS g45n1svt m=1 l=45n w=1.04u
Mmn10 n1 S1 n8 VSS g45n1svt m=1 l=45n w=205n
Mmn9 n8 Cp VSS VSS g45n1svt m=1 l=45n w=205n
Mmn8 n1 S1b n6 VSS g45n1svt m=1 l=45n w=205n
Mmn7 n6 n0 VSS VSS g45n1svt m=1 l=45n w=205n
Mmn6 Cp C VSS VSS g45n1svt m=1 l=45n w=145n
Mmn0 S0b S0 VSS VSS g45n1svt m=1 l=45n w=145n
Mmn1 S1b S1 VSS VSS g45n1svt m=1 l=45n w=145n
Mmp5 n0 S0b n5 NW g45p1svt m=1 l=45n w=215n
Mmp4 n5 B VDD NW g45p1svt m=1 l=45n w=215n
Mmp3 n0 S0 n3 NW g45p1svt m=1 l=45n w=215n
Mmp2 n3 A VDD NW g45p1svt m=1 l=45n w=215n
Mmp8 n1 S1 n7 NW g45p1svt m=1 l=45n w=310n
Mmp7 n7 n0 VDD NW g45p1svt m=1 l=45n w=310n
Mmp11 Y n1 VDD NW g45p1svt m=1 l=45n w=1.56u
Mmp9 n9 Cp VDD NW g45p1svt m=1 l=45n w=310n
Mmp10 n1 S1b n9 NW g45p1svt m=1 l=45n w=310n
Mmp6 Cp C VDD NW g45p1svt m=1 l=45n w=215n
Mmp1 S1b S1 VDD NW g45p1svt m=1 l=45n w=215n
Mmp0 S0b S0 VDD NW g45p1svt m=1 l=45n w=215n
.ENDS

.SUBCKT MXI3XL A B C NW S0 S1 VDD VSS Y
*.PININFO A:I B:I C:I NW:I S0:I S1:I VDD:I VSS:I Y:O
Mmn4 n4 B VSS VSS g45n1svt m=1 l=45n w=145n
Mmn5 n0 S0 n4 VSS g45n1svt m=1 l=45n w=145n
Mmn3 n0 S0b n2 VSS g45n1svt m=1 l=45n w=145n
Mmn2 n2 A VSS VSS g45n1svt m=1 l=45n w=145n
Mmn11 Y n1 VSS VSS g45n1svt m=1 l=45n w=145n
Mmn10 n1 S1 n8 VSS g45n1svt m=1 l=45n w=145n
Mmn9 n8 Cp VSS VSS g45n1svt m=1 l=45n w=145n
Mmn8 n1 S1b n6 VSS g45n1svt m=1 l=45n w=145n
Mmn7 n6 n0 VSS VSS g45n1svt m=1 l=45n w=145n
Mmn6 Cp C VSS VSS g45n1svt m=1 l=45n w=145n
Mmn0 S0b S0 VSS VSS g45n1svt m=1 l=45n w=145n
Mmn1 S1b S1 VSS VSS g45n1svt m=1 l=45n w=145n
Mmp5 n0 S0b n5 NW g45p1svt m=1 l=45n w=215n
Mmp4 n5 B VDD NW g45p1svt m=1 l=45n w=215n
Mmp3 n0 S0 n3 NW g45p1svt m=1 l=45n w=215n
Mmp2 n3 A VDD NW g45p1svt m=1 l=45n w=215n
Mmp8 n1 S1 n7 NW g45p1svt m=1 l=45n w=215n
Mmp7 n7 n0 VDD NW g45p1svt m=1 l=45n w=215n
Mmp11 Y n1 VDD NW g45p1svt m=1 l=45n w=215n
Mmp9 n9 Cp VDD NW g45p1svt m=1 l=45n w=215n
Mmp10 n1 S1b n9 NW g45p1svt m=1 l=45n w=215n
Mmp6 Cp C VDD NW g45p1svt m=1 l=45n w=215n
Mmp1 S1b S1 VDD NW g45p1svt m=1 l=45n w=215n
Mmp0 S0b S0 VDD NW g45p1svt m=1 l=45n w=215n
.ENDS

.SUBCKT MXI4X1 A B C D NW S0 S1 VDD VSS Y
*.PININFO A:I B:I C:I D:I NW:I S0:I S1:I VDD:I VSS:I Y:O
Mmn8 net377 D VSS VSS g45n1svt m=1 l=45n w=145n
Mmn9 n1 S0 net377 VSS g45n1svt m=1 l=45n w=145n
Mmn6 net369 C VSS VSS g45n1svt m=1 l=45n w=145n
Mmn7 n1 S0b net369 VSS g45n1svt m=1 l=45n w=145n
Mmn4 net361 B VSS VSS g45n1svt m=1 l=45n w=145n
Mmn5 n0 S0 net361 VSS g45n1svt m=1 l=45n w=145n
Mmn3 n0 S0b net349 VSS g45n1svt m=1 l=45n w=145n
Mmn2 net349 A VSS VSS g45n1svt m=1 l=45n w=145n
Mmn12 net345 n1 VSS VSS g45n1svt m=1 l=45n w=145n
Mmn13 n2 S1 net345 VSS g45n1svt m=1 l=45n w=145n
Mmn11 n2 S1b net329 VSS g45n1svt m=1 l=45n w=145n
Mmn1 S1b S1 VSS VSS g45n1svt m=1 l=45n w=145n
Mmn10 net329 n0 VSS VSS g45n1svt m=1 l=45n w=145n
Mmn14 Y n2 VSS VSS g45n1svt m=1 l=45n w=260n
Mmn0 S0b S0 VSS VSS g45n1svt m=1 l=45n w=145n
Mmp9 n1 S0b net320 NW g45p1svt m=1 l=45n w=215n
Mmp8 net320 D VDD NW g45p1svt m=1 l=45n w=215n
Mmp7 n1 S0 net312 NW g45p1svt m=1 l=45n w=215n
Mmp6 net312 C VDD NW g45p1svt m=1 l=45n w=215n
Mmp5 n0 S0b net304 NW g45p1svt m=1 l=45n w=215n
Mmp4 net304 B VDD NW g45p1svt m=1 l=45n w=215n
Mmp3 n0 S0 net296 NW g45p1svt m=1 l=45n w=215n
Mmp2 net296 A VDD NW g45p1svt m=1 l=45n w=215n
Mmp12 net284 n1 VDD NW g45p1svt m=1 l=45n w=215n
Mmp13 n2 S1b net284 NW g45p1svt m=1 l=45n w=215n
Mmp11 n2 S1 net280 NW g45p1svt m=1 l=45n w=215n
Mmp10 net280 n0 VDD NW g45p1svt m=1 l=45n w=215n
Mmp0 S0b S0 VDD NW g45p1svt m=1 l=45n w=215n
Mmp14 Y n2 VDD NW g45p1svt m=1 l=45n w=390n
Mmp1 S1b S1 VDD NW g45p1svt m=1 l=45n w=215n
.ENDS

.SUBCKT MXI4X2 A B C D NW S0 S1 VDD VSS Y
*.PININFO A:I B:I C:I D:I NW:I S0:I S1:I VDD:I VSS:I Y:O
Mmn8 net377 D VSS VSS g45n1svt m=1 l=45n w=145n
Mmn9 n1 S0 net377 VSS g45n1svt m=1 l=45n w=145n
Mmn6 net369 C VSS VSS g45n1svt m=1 l=45n w=145n
Mmn7 n1 S0b net369 VSS g45n1svt m=1 l=45n w=145n
Mmn4 net361 B VSS VSS g45n1svt m=1 l=45n w=145n
Mmn5 n0 S0 net361 VSS g45n1svt m=1 l=45n w=145n
Mmn3 n0 S0b net349 VSS g45n1svt m=1 l=45n w=145n
Mmn2 net349 A VSS VSS g45n1svt m=1 l=45n w=145n
Mmn12 net345 n1 VSS VSS g45n1svt m=1 l=45n w=145n
Mmn13 n2 S1 net345 VSS g45n1svt m=1 l=45n w=145n
Mmn11 n2 S1b net329 VSS g45n1svt m=1 l=45n w=145n
Mmn1 S1b S1 VSS VSS g45n1svt m=1 l=45n w=145n
Mmn10 net329 n0 VSS VSS g45n1svt m=1 l=45n w=145n
Mmn14 Y n2 VSS VSS g45n1svt m=1 l=45n w=520n
Mmn0 S0b S0 VSS VSS g45n1svt m=1 l=45n w=145n
Mmp9 n1 S0b net320 NW g45p1svt m=1 l=45n w=215n
Mmp8 net320 D VDD NW g45p1svt m=1 l=45n w=215n
Mmp7 n1 S0 net312 NW g45p1svt m=1 l=45n w=215n
Mmp6 net312 C VDD NW g45p1svt m=1 l=45n w=215n
Mmp5 n0 S0b net304 NW g45p1svt m=1 l=45n w=215n
Mmp4 net304 B VDD NW g45p1svt m=1 l=45n w=215n
Mmp3 n0 S0 net296 NW g45p1svt m=1 l=45n w=215n
Mmp2 net296 A VDD NW g45p1svt m=1 l=45n w=215n
Mmp12 net284 n1 VDD NW g45p1svt m=1 l=45n w=215n
Mmp13 n2 S1b net284 NW g45p1svt m=1 l=45n w=215n
Mmp11 n2 S1 net280 NW g45p1svt m=1 l=45n w=215n
Mmp10 net280 n0 VDD NW g45p1svt m=1 l=45n w=215n
Mmp0 S0b S0 VDD NW g45p1svt m=1 l=45n w=215n
Mmp14 Y n2 VDD NW g45p1svt m=1 l=45n w=780n
Mmp1 S1b S1 VDD NW g45p1svt m=1 l=45n w=215n
.ENDS

.SUBCKT MXI4X4 A B C D NW S0 S1 VDD VSS Y
*.PININFO A:I B:I C:I D:I NW:I S0:I S1:I VDD:I VSS:I Y:O
Mmn8 net377 D VSS VSS g45n1svt m=1 l=45n w=145n
Mmn9 n1 S0 net377 VSS g45n1svt m=1 l=45n w=145n
Mmn6 net369 C VSS VSS g45n1svt m=1 l=45n w=145n
Mmn7 n1 S0b net369 VSS g45n1svt m=1 l=45n w=145n
Mmn4 net361 B VSS VSS g45n1svt m=1 l=45n w=145n
Mmn5 n0 S0 net361 VSS g45n1svt m=1 l=45n w=145n
Mmn3 n0 S0b net349 VSS g45n1svt m=1 l=45n w=145n
Mmn2 net349 A VSS VSS g45n1svt m=1 l=45n w=145n
Mmn12 net345 n1 VSS VSS g45n1svt m=1 l=45n w=205n
Mmn13 n2 S1 net345 VSS g45n1svt m=1 l=45n w=205n
Mmn11 n2 S1b net329 VSS g45n1svt m=1 l=45n w=205n
Mmn1 S1b S1 VSS VSS g45n1svt m=1 l=45n w=145n
Mmn10 net329 n0 VSS VSS g45n1svt m=1 l=45n w=205n
Mmn14 Y n2 VSS VSS g45n1svt m=1 l=45n w=1.04u
Mmn0 S0b S0 VSS VSS g45n1svt m=1 l=45n w=145n
Mmp9 n1 S0b net320 NW g45p1svt m=1 l=45n w=215n
Mmp8 net320 D VDD NW g45p1svt m=1 l=45n w=215n
Mmp7 n1 S0 net312 NW g45p1svt m=1 l=45n w=215n
Mmp6 net312 C VDD NW g45p1svt m=1 l=45n w=215n
Mmp5 n0 S0b net304 NW g45p1svt m=1 l=45n w=215n
Mmp4 net304 B VDD NW g45p1svt m=1 l=45n w=215n
Mmp3 n0 S0 net296 NW g45p1svt m=1 l=45n w=215n
Mmp2 net296 A VDD NW g45p1svt m=1 l=45n w=215n
Mmp12 net284 n1 VDD NW g45p1svt m=1 l=45n w=310n
Mmp13 n2 S1b net284 NW g45p1svt m=1 l=45n w=310n
Mmp11 n2 S1 net280 NW g45p1svt m=1 l=45n w=310n
Mmp10 net280 n0 VDD NW g45p1svt m=1 l=45n w=310n
Mmp0 S0b S0 VDD NW g45p1svt m=1 l=45n w=215n
Mmp14 Y n2 VDD NW g45p1svt m=1 l=45n w=1.56u
Mmp1 S1b S1 VDD NW g45p1svt m=1 l=45n w=215n
.ENDS

.SUBCKT MXI4XL A B C D NW S0 S1 VDD VSS Y
*.PININFO A:I B:I C:I D:I NW:I S0:I S1:I VDD:I VSS:I Y:O
Mmn8 net377 D VSS VSS g45n1svt m=1 l=45n w=145n
Mmn9 n1 S0 net377 VSS g45n1svt m=1 l=45n w=145n
Mmn6 net369 C VSS VSS g45n1svt m=1 l=45n w=145n
Mmn7 n1 S0b net369 VSS g45n1svt m=1 l=45n w=145n
Mmn4 net361 B VSS VSS g45n1svt m=1 l=45n w=145n
Mmn5 n0 S0 net361 VSS g45n1svt m=1 l=45n w=145n
Mmn3 n0 S0b net349 VSS g45n1svt m=1 l=45n w=145n
Mmn2 net349 A VSS VSS g45n1svt m=1 l=45n w=145n
Mmn12 net345 n1 VSS VSS g45n1svt m=1 l=45n w=145n
Mmn13 n2 S1 net345 VSS g45n1svt m=1 l=45n w=145n
Mmn11 n2 S1b net329 VSS g45n1svt m=1 l=45n w=145n
Mmn1 S1b S1 VSS VSS g45n1svt m=1 l=45n w=145n
Mmn10 net329 n0 VSS VSS g45n1svt m=1 l=45n w=145n
Mmn14 Y n2 VSS VSS g45n1svt m=1 l=45n w=145n
Mmn0 S0b S0 VSS VSS g45n1svt m=1 l=45n w=145n
Mmp9 n1 S0b net320 NW g45p1svt m=1 l=45n w=215n
Mmp8 net320 D VDD NW g45p1svt m=1 l=45n w=215n
Mmp7 n1 S0 net312 NW g45p1svt m=1 l=45n w=215n
Mmp6 net312 C VDD NW g45p1svt m=1 l=45n w=215n
Mmp5 n0 S0b net304 NW g45p1svt m=1 l=45n w=215n
Mmp4 net304 B VDD NW g45p1svt m=1 l=45n w=215n
Mmp3 n0 S0 net296 NW g45p1svt m=1 l=45n w=215n
Mmp2 net296 A VDD NW g45p1svt m=1 l=45n w=215n
Mmp12 net284 n1 VDD NW g45p1svt m=1 l=45n w=215n
Mmp13 n2 S1b net284 NW g45p1svt m=1 l=45n w=215n
Mmp11 n2 S1 net280 NW g45p1svt m=1 l=45n w=215n
Mmp10 net280 n0 VDD NW g45p1svt m=1 l=45n w=215n
Mmp0 S0b S0 VDD NW g45p1svt m=1 l=45n w=215n
Mmp14 Y n2 VDD NW g45p1svt m=1 l=45n w=215n
Mmp1 S1b S1 VDD NW g45p1svt m=1 l=45n w=215n
.ENDS

.SUBCKT NAND2BX1 AN B NW VDD VSS Y
*.PININFO AN:I B:I NW:I VDD:I VSS:I Y:O
Mmn2 Y B n1 VSS g45n1svt m=1 l=45n w=260n
Mmn0 n0 AN VSS VSS g45n1svt m=1 l=45n w=145n
Mmn1 n1 n0 VSS VSS g45n1svt m=1 l=45n w=260n
Mmp1 Y n0 VDD NW g45p1svt m=1 l=45n w=390n
Mmp2 Y B VDD NW g45p1svt m=1 l=45n w=390n
Mmp0 n0 AN VDD NW g45p1svt m=1 l=45n w=215n
.ENDS

.SUBCKT NAND2BX2 AN B NW VDD VSS Y
*.PININFO AN:I B:I NW:I VDD:I VSS:I Y:O
Mmn2 Y B n1 VSS g45n1svt m=1 l=45n w=520n
Mmn0 n0 AN VSS VSS g45n1svt m=1 l=45n w=145n
Mmn1 n1 n0 VSS VSS g45n1svt m=1 l=45n w=520n
Mmp1 Y n0 VDD NW g45p1svt m=1 l=45n w=780n
Mmp2 Y B VDD NW g45p1svt m=1 l=45n w=780n
Mmp0 n0 AN VDD NW g45p1svt m=1 l=45n w=215n
.ENDS

.SUBCKT NAND2BX4 AN B NW VDD VSS Y
*.PININFO AN:I B:I NW:I VDD:I VSS:I Y:O
Mmn2 Y B n1 VSS g45n1svt m=1 l=45n w=1.04u
Mmn0 n0 AN VSS VSS g45n1svt m=1 l=45n w=260n
Mmn1 n1 n0 VSS VSS g45n1svt m=1 l=45n w=1.04u
Mmp1 Y n0 VDD NW g45p1svt m=1 l=45n w=1.56u
Mmp2 Y B VDD NW g45p1svt m=1 l=45n w=1.56u
Mmp0 n0 AN VDD NW g45p1svt m=1 l=45n w=390n
.ENDS

.SUBCKT NAND2BXL AN B NW VDD VSS Y
*.PININFO AN:I B:I NW:I VDD:I VSS:I Y:O
Mmn2 Y B n1 VSS g45n1svt m=1 l=45n w=145n
Mmn0 n0 AN VSS VSS g45n1svt m=1 l=45n w=145n
Mmn1 n1 n0 VSS VSS g45n1svt m=1 l=45n w=145n
Mmp1 Y n0 VDD NW g45p1svt m=1 l=45n w=215n
Mmp2 Y B VDD NW g45p1svt m=1 l=45n w=215n
Mmp0 n0 AN VDD NW g45p1svt m=1 l=45n w=215n
.ENDS

.SUBCKT NAND2X1 A B NW VDD VSS Y
*.PININFO A:I B:I NW:I VDD:I VSS:I Y:O
Mmn1 Y B n0 VSS g45n1svt m=1 l=45n w=260n
Mmn0 n0 A VSS VSS g45n1svt m=1 l=45n w=260n
Mmp1 Y B VDD NW g45p1svt m=1 l=45n w=390n
Mmp0 Y A VDD NW g45p1svt m=1 l=45n w=390n
.ENDS

.SUBCKT NAND2X2 A B NW VDD VSS Y
*.PININFO A:I B:I NW:I VDD:I VSS:I Y:O
Mmn1 Y B n0 VSS g45n1svt m=1 l=45n w=520n
Mmn0 n0 A VSS VSS g45n1svt m=1 l=45n w=520n
Mmp1 Y B VDD NW g45p1svt m=1 l=45n w=780n
Mmp0 Y A VDD NW g45p1svt m=1 l=45n w=780n
.ENDS

.SUBCKT NAND2X4 A B NW VDD VSS Y
*.PININFO A:I B:I NW:I VDD:I VSS:I Y:O
Mmn1 Y B n0 VSS g45n1svt m=1 l=45n w=1.04u
Mmn0 n0 A VSS VSS g45n1svt m=1 l=45n w=1.04u
Mmp1 Y B VDD NW g45p1svt m=1 l=45n w=1.56u
Mmp0 Y A VDD NW g45p1svt m=1 l=45n w=1.56u
.ENDS

.SUBCKT NAND2X6 A B NW VDD VSS Y
*.PININFO A:I B:I NW:I VDD:I VSS:I Y:O
Mmn1 Y B n0 VSS g45n1svt m=1 l=45n w=1.55u
Mmn0 n0 A VSS VSS g45n1svt m=1 l=45n w=1.55u
Mmp1 Y B VDD NW g45p1svt m=1 l=45n w=2.34u
Mmp0 Y A VDD NW g45p1svt m=1 l=45n w=2.34u
.ENDS

.SUBCKT NAND2X8 A B NW VDD VSS Y
*.PININFO A:I B:I NW:I VDD:I VSS:I Y:O
Mmn1 Y B n0 VSS g45n1svt m=1 l=45n w=2.065u
Mmn0 n0 A VSS VSS g45n1svt m=1 l=45n w=2.065u
Mmp1 Y B VDD NW g45p1svt m=1 l=45n w=3.115u
Mmp0 Y A VDD NW g45p1svt m=1 l=45n w=3.115u
.ENDS

.SUBCKT NAND2XL A B NW VDD VSS Y
*.PININFO A:I B:I NW:I VDD:I VSS:I Y:O
Mmn1 Y B n0 VSS g45n1svt m=1 l=45n w=145n
Mmn0 n0 A VSS VSS g45n1svt m=1 l=45n w=145n
Mmp1 Y B VDD NW g45p1svt m=1 l=45n w=215n
Mmp0 Y A VDD NW g45p1svt m=1 l=45n w=215n
.ENDS

.SUBCKT NAND3BX1 AN B C NW VDD VSS Y
*.PININFO AN:I B:I C:I NW:I VDD:I VSS:I Y:O
Mmn3 Y C n1 VSS g45n1svt m=1 l=45n w=260n
Mmn0 n0 AN VSS VSS g45n1svt m=1 l=45n w=145n
Mmn2 n1 B n2 VSS g45n1svt m=1 l=45n w=260n
Mmn1 n2 n0 VSS VSS g45n1svt m=1 l=45n w=260n
Mmp1 Y n0 VDD NW g45p1svt m=1 l=45n w=390n
Mmp3 Y C VDD NW g45p1svt m=1 l=45n w=390n
Mmp0 n0 AN VDD NW g45p1svt m=1 l=45n w=215n
Mmp2 Y B VDD NW g45p1svt m=1 l=45n w=390n
.ENDS

.SUBCKT NAND3BX2 AN B C NW VDD VSS Y
*.PININFO AN:I B:I C:I NW:I VDD:I VSS:I Y:O
Mmn3 Y C n1 VSS g45n1svt m=1 l=45n w=520n
Mmn0 n0 AN VSS VSS g45n1svt m=1 l=45n w=145n
Mmn2 n1 B n2 VSS g45n1svt m=1 l=45n w=520n
Mmn1 n2 n0 VSS VSS g45n1svt m=1 l=45n w=520n
Mmp1 Y n0 VDD NW g45p1svt m=1 l=45n w=780n
Mmp3 Y C VDD NW g45p1svt m=1 l=45n w=780n
Mmp0 n0 AN VDD NW g45p1svt m=1 l=45n w=215n
Mmp2 Y B VDD NW g45p1svt m=1 l=45n w=780n
.ENDS

.SUBCKT NAND3BX4 AN B C NW VDD VSS Y
*.PININFO AN:I B:I C:I NW:I VDD:I VSS:I Y:O
Mmn3 Y C n1 VSS g45n1svt m=1 l=45n w=1.04u
Mmn0 n0 AN VSS VSS g45n1svt m=1 l=45n w=260n
Mmn2 n1 B n2 VSS g45n1svt m=1 l=45n w=1.04u
Mmn1 n2 n0 VSS VSS g45n1svt m=1 l=45n w=1.04u
Mmp1 Y n0 VDD NW g45p1svt m=1 l=45n w=1.56u
Mmp3 Y C VDD NW g45p1svt m=1 l=45n w=1.56u
Mmp0 n0 AN VDD NW g45p1svt m=1 l=45n w=390n
Mmp2 Y B VDD NW g45p1svt m=1 l=45n w=1.56u
.ENDS

.SUBCKT NAND3BXL AN B C NW VDD VSS Y
*.PININFO AN:I B:I C:I NW:I VDD:I VSS:I Y:O
Mmn3 Y C n1 VSS g45n1svt m=1 l=45n w=145n
Mmn0 n0 AN VSS VSS g45n1svt m=1 l=45n w=145n
Mmn2 n1 B n2 VSS g45n1svt m=1 l=45n w=145n
Mmn1 n2 n0 VSS VSS g45n1svt m=1 l=45n w=145n
Mmp1 Y n0 VDD NW g45p1svt m=1 l=45n w=215n
Mmp3 Y C VDD NW g45p1svt m=1 l=45n w=215n
Mmp0 n0 AN VDD NW g45p1svt m=1 l=45n w=215n
Mmp2 Y B VDD NW g45p1svt m=1 l=45n w=215n
.ENDS

.SUBCKT NAND3X1 A B C NW VDD VSS Y
*.PININFO A:I B:I C:I NW:I VDD:I VSS:I Y:O
Mmn1 n0 B n1 VSS g45n1svt m=1 l=45n w=260n
Mmn2 Y C n0 VSS g45n1svt m=1 l=45n w=260n
Mmn0 n1 A VSS VSS g45n1svt m=1 l=45n w=260n
Mmp0 Y A VDD NW g45p1svt m=1 l=45n w=390n
Mmp1 Y B VDD NW g45p1svt m=1 l=45n w=390n
Mmp2 Y C VDD NW g45p1svt m=1 l=45n w=390n
.ENDS

.SUBCKT NAND3X2 A B C NW VDD VSS Y
*.PININFO A:I B:I C:I NW:I VDD:I VSS:I Y:O
Mmn1 n0 B n1 VSS g45n1svt m=1 l=45n w=520n
Mmn2 Y C n0 VSS g45n1svt m=1 l=45n w=520n
Mmn0 n1 A VSS VSS g45n1svt m=1 l=45n w=520n
Mmp0 Y A VDD NW g45p1svt m=1 l=45n w=780n
Mmp1 Y B VDD NW g45p1svt m=1 l=45n w=780n
Mmp2 Y C VDD NW g45p1svt m=1 l=45n w=780n
.ENDS

.SUBCKT NAND3X4 A B C NW VDD VSS Y
*.PININFO A:I B:I C:I NW:I VDD:I VSS:I Y:O
Mmn1 n0 B n1 VSS g45n1svt m=1 l=45n w=1.04u
Mmn2 Y C n0 VSS g45n1svt m=1 l=45n w=1.04u
Mmn0 n1 A VSS VSS g45n1svt m=1 l=45n w=1.04u
Mmp0 Y A VDD NW g45p1svt m=1 l=45n w=1.56u
Mmp1 Y B VDD NW g45p1svt m=1 l=45n w=1.56u
Mmp2 Y C VDD NW g45p1svt m=1 l=45n w=1.56u
.ENDS

.SUBCKT NAND3X6 A B C NW VDD VSS Y
*.PININFO A:I B:I C:I NW:I VDD:I VSS:I Y:O
Mmn1 n0 B n1 VSS g45n1svt m=1 l=45n w=1.55u
Mmn2 Y C n0 VSS g45n1svt m=1 l=45n w=1.55u
Mmn0 n1 A VSS VSS g45n1svt m=1 l=45n w=1.55u
Mmp0 Y A VDD NW g45p1svt m=1 l=45n w=2.34u
Mmp1 Y B VDD NW g45p1svt m=1 l=45n w=2.34u
Mmp2 Y C VDD NW g45p1svt m=1 l=45n w=2.34u
.ENDS

.SUBCKT NAND3X8 A B C NW VDD VSS Y
*.PININFO A:I B:I C:I NW:I VDD:I VSS:I Y:O
Mmn1 n0 B n1 VSS g45n1svt m=1 l=45n w=2.065u
Mmn2 Y C n0 VSS g45n1svt m=1 l=45n w=2.065u
Mmn0 n1 A VSS VSS g45n1svt m=1 l=45n w=2.065u
Mmp0 Y A VDD NW g45p1svt m=1 l=45n w=3.115u
Mmp1 Y B VDD NW g45p1svt m=1 l=45n w=3.115u
Mmp2 Y C VDD NW g45p1svt m=1 l=45n w=3.115u
.ENDS

.SUBCKT NAND3XL A B C NW VDD VSS Y
*.PININFO A:I B:I C:I NW:I VDD:I VSS:I Y:O
Mmn1 n0 B n1 VSS g45n1svt m=1 l=45n w=145n
Mmn2 Y C n0 VSS g45n1svt m=1 l=45n w=145n
Mmn0 n1 A VSS VSS g45n1svt m=1 l=45n w=145n
Mmp0 Y A VDD NW g45p1svt m=1 l=45n w=215n
Mmp1 Y B VDD NW g45p1svt m=1 l=45n w=215n
Mmp2 Y C VDD NW g45p1svt m=1 l=45n w=215n
.ENDS

.SUBCKT NAND4BBX1 AN BN C D NW VDD VSS Y
*.PININFO AN:I BN:I C:I D:I NW:I VDD:I VSS:I Y:O
Mmn1 n1 BN VSS VSS g45n1svt m=1 l=45n w=145n
Mmn2 n4 n0 VSS VSS g45n1svt m=1 l=45n w=260n
Mmn4 n2 C n3 VSS g45n1svt m=1 l=45n w=260n
Mmn5 Y D n2 VSS g45n1svt m=1 l=45n w=260n
Mmn0 n0 AN VSS VSS g45n1svt m=1 l=45n w=145n
Mmn3 n3 n1 n4 VSS g45n1svt m=1 l=45n w=260n
Mmp2 Y n0 VDD NW g45p1svt m=1 l=45n w=390n
Mmp0 n0 AN VDD NW g45p1svt m=1 l=45n w=215n
Mmp5 Y D VDD NW g45p1svt m=1 l=45n w=390n
Mmp4 Y C VDD NW g45p1svt m=1 l=45n w=390n
Mmp1 n1 BN VDD NW g45p1svt m=1 l=45n w=215n
Mmp3 Y n1 VDD NW g45p1svt m=1 l=45n w=390n
.ENDS

.SUBCKT NAND4BBX2 AN BN C D NW VDD VSS Y
*.PININFO AN:I BN:I C:I D:I NW:I VDD:I VSS:I Y:O
Mmn1 n1 BN VSS VSS g45n1svt m=1 l=45n w=145n
Mmn2 n4 n0 VSS VSS g45n1svt m=1 l=45n w=520n
Mmn4 n2 C n3 VSS g45n1svt m=1 l=45n w=520n
Mmn5 Y D n2 VSS g45n1svt m=1 l=45n w=520n
Mmn0 n0 AN VSS VSS g45n1svt m=1 l=45n w=145n
Mmn3 n3 n1 n4 VSS g45n1svt m=1 l=45n w=520n
Mmp2 Y n0 VDD NW g45p1svt m=1 l=45n w=780n
Mmp0 n0 AN VDD NW g45p1svt m=1 l=45n w=215n
Mmp5 Y D VDD NW g45p1svt m=1 l=45n w=780n
Mmp4 Y C VDD NW g45p1svt m=1 l=45n w=780n
Mmp1 n1 BN VDD NW g45p1svt m=1 l=45n w=215n
Mmp3 Y n1 VDD NW g45p1svt m=1 l=45n w=780n
.ENDS

.SUBCKT NAND4BBX4 AN BN C D NW VDD VSS Y
*.PININFO AN:I BN:I C:I D:I NW:I VDD:I VSS:I Y:O
Mmn1 n1 BN VSS VSS g45n1svt m=1 l=45n w=260n
Mmn2 n4 n0 VSS VSS g45n1svt m=1 l=45n w=1.04u
Mmn4 n2 C n3 VSS g45n1svt m=1 l=45n w=1.04u
Mmn5 Y D n2 VSS g45n1svt m=1 l=45n w=1.04u
Mmn0 n0 AN VSS VSS g45n1svt m=1 l=45n w=260n
Mmn3 n3 n1 n4 VSS g45n1svt m=1 l=45n w=1.04u
Mmp2 Y n0 VDD NW g45p1svt m=1 l=45n w=1.56u
Mmp0 n0 AN VDD NW g45p1svt m=1 l=45n w=390n
Mmp5 Y D VDD NW g45p1svt m=1 l=45n w=1.56u
Mmp4 Y C VDD NW g45p1svt m=1 l=45n w=1.56u
Mmp1 n1 BN VDD NW g45p1svt m=1 l=45n w=390n
Mmp3 Y n1 VDD NW g45p1svt m=1 l=45n w=1.56u
.ENDS

.SUBCKT NAND4BBXL AN BN C D NW VDD VSS Y
*.PININFO AN:I BN:I C:I D:I NW:I VDD:I VSS:I Y:O
Mmn1 n1 BN VSS VSS g45n1svt m=1 l=45n w=145n
Mmn2 n4 n0 VSS VSS g45n1svt m=1 l=45n w=145n
Mmn4 n2 C n3 VSS g45n1svt m=1 l=45n w=145n
Mmn5 Y D n2 VSS g45n1svt m=1 l=45n w=145n
Mmn0 n0 AN VSS VSS g45n1svt m=1 l=45n w=145n
Mmn3 n3 n1 n4 VSS g45n1svt m=1 l=45n w=145n
Mmp2 Y n0 VDD NW g45p1svt m=1 l=45n w=215n
Mmp0 n0 AN VDD NW g45p1svt m=1 l=45n w=215n
Mmp5 Y D VDD NW g45p1svt m=1 l=45n w=215n
Mmp4 Y C VDD NW g45p1svt m=1 l=45n w=215n
Mmp1 n1 BN VDD NW g45p1svt m=1 l=45n w=215n
Mmp3 Y n1 VDD NW g45p1svt m=1 l=45n w=215n
.ENDS

.SUBCKT NAND4BX1 AN B C D NW VDD VSS Y
*.PININFO AN:I B:I C:I D:I NW:I VDD:I VSS:I Y:O
Mmn4 Y D net130 VSS g45n1svt m=1 l=45n w=260n
Mmn2 net126 B net122 VSS g45n1svt m=1 l=45n w=260n
Mmn1 net122 net118 VSS VSS g45n1svt m=1 l=45n w=260n
Mmn0 net118 AN VSS VSS g45n1svt m=1 l=45n w=145n
Mmn3 net130 C net126 VSS g45n1svt m=1 l=45n w=260n
Mmp4 Y D VDD NW g45p1svt m=1 l=45n w=390n
Mmp1 Y net118 VDD NW g45p1svt m=1 l=45n w=390n
Mmp2 Y B VDD NW g45p1svt m=1 l=45n w=390n
Mmp0 net118 AN VDD NW g45p1svt m=1 l=45n w=215n
Mmp3 Y C VDD NW g45p1svt m=1 l=45n w=390n
.ENDS

.SUBCKT NAND4BX2 AN B C D NW VDD VSS Y
*.PININFO AN:I B:I C:I D:I NW:I VDD:I VSS:I Y:O
Mmn4 Y D net130 VSS g45n1svt m=1 l=45n w=520n
Mmn2 net126 B net122 VSS g45n1svt m=1 l=45n w=520n
Mmn1 net122 net118 VSS VSS g45n1svt m=1 l=45n w=520n
Mmn0 net118 AN VSS VSS g45n1svt m=1 l=45n w=145n
Mmn3 net130 C net126 VSS g45n1svt m=1 l=45n w=520n
Mmp4 Y D VDD NW g45p1svt m=1 l=45n w=780n
Mmp1 Y net118 VDD NW g45p1svt m=1 l=45n w=780n
Mmp2 Y B VDD NW g45p1svt m=1 l=45n w=780n
Mmp0 net118 AN VDD NW g45p1svt m=1 l=45n w=215n
Mmp3 Y C VDD NW g45p1svt m=1 l=45n w=780n
.ENDS

.SUBCKT NAND4BX4 AN B C D NW VDD VSS Y
*.PININFO AN:I B:I C:I D:I NW:I VDD:I VSS:I Y:O
Mmn4 Y D net130 VSS g45n1svt m=1 l=45n w=1.04u
Mmn2 net126 B net122 VSS g45n1svt m=1 l=45n w=1.04u
Mmn1 net122 net118 VSS VSS g45n1svt m=1 l=45n w=1.04u
Mmn0 net118 AN VSS VSS g45n1svt m=1 l=45n w=260n
Mmn3 net130 C net126 VSS g45n1svt m=1 l=45n w=1.04u
Mmp4 Y D VDD NW g45p1svt m=1 l=45n w=1.56u
Mmp1 Y net118 VDD NW g45p1svt m=1 l=45n w=1.56u
Mmp2 Y B VDD NW g45p1svt m=1 l=45n w=1.56u
Mmp0 net118 AN VDD NW g45p1svt m=1 l=45n w=390n
Mmp3 Y C VDD NW g45p1svt m=1 l=45n w=1.56u
.ENDS

.SUBCKT NAND4BXL AN B C D NW VDD VSS Y
*.PININFO AN:I B:I C:I D:I NW:I VDD:I VSS:I Y:O
Mmn4 Y D net130 VSS g45n1svt m=1 l=45n w=145n
Mmn2 net126 B net122 VSS g45n1svt m=1 l=45n w=145n
Mmn1 net122 net118 VSS VSS g45n1svt m=1 l=45n w=145n
Mmn0 net118 AN VSS VSS g45n1svt m=1 l=45n w=145n
Mmn3 net130 C net126 VSS g45n1svt m=1 l=45n w=145n
Mmp4 Y D VDD NW g45p1svt m=1 l=45n w=215n
Mmp1 Y net118 VDD NW g45p1svt m=1 l=45n w=215n
Mmp2 Y B VDD NW g45p1svt m=1 l=45n w=215n
Mmp0 net118 AN VDD NW g45p1svt m=1 l=45n w=215n
Mmp3 Y C VDD NW g45p1svt m=1 l=45n w=215n
.ENDS

.SUBCKT NAND4X1 A B C D NW VDD VSS Y
*.PININFO A:I B:I C:I D:I NW:I VDD:I VSS:I Y:O
Mmn1 n1 B n2 VSS g45n1svt m=1 l=45n w=260n
Mmn3 Y D n0 VSS g45n1svt m=1 l=45n w=260n
Mmn2 n0 C n1 VSS g45n1svt m=1 l=45n w=260n
Mmn0 n2 A VSS VSS g45n1svt m=1 l=45n w=260n
Mmp3 Y D VDD NW g45p1svt m=1 l=45n w=390n
Mmp2 Y C VDD NW g45p1svt m=1 l=45n w=390n
Mmp1 Y B VDD NW g45p1svt m=1 l=45n w=390n
Mmp0 Y A VDD NW g45p1svt m=1 l=45n w=390n
.ENDS

.SUBCKT NAND4X2 A B C D NW VDD VSS Y
*.PININFO A:I B:I C:I D:I NW:I VDD:I VSS:I Y:O
Mmn1 n1 B n2 VSS g45n1svt m=1 l=45n w=520n
Mmn3 Y D n0 VSS g45n1svt m=1 l=45n w=520n
Mmn2 n0 C n1 VSS g45n1svt m=1 l=45n w=520n
Mmn0 n2 A VSS VSS g45n1svt m=1 l=45n w=520n
Mmp3 Y D VDD NW g45p1svt m=1 l=45n w=780n
Mmp2 Y C VDD NW g45p1svt m=1 l=45n w=780n
Mmp1 Y B VDD NW g45p1svt m=1 l=45n w=780n
Mmp0 Y A VDD NW g45p1svt m=1 l=45n w=780n
.ENDS

.SUBCKT NAND4X4 A B C D NW VDD VSS Y
*.PININFO A:I B:I C:I D:I NW:I VDD:I VSS:I Y:O
Mmn1 n1 B n2 VSS g45n1svt m=1 l=45n w=1.04u
Mmn3 Y D n0 VSS g45n1svt m=1 l=45n w=1.04u
Mmn2 n0 C n1 VSS g45n1svt m=1 l=45n w=1.04u
Mmn0 n2 A VSS VSS g45n1svt m=1 l=45n w=1.04u
Mmp3 Y D VDD NW g45p1svt m=1 l=45n w=1.56u
Mmp2 Y C VDD NW g45p1svt m=1 l=45n w=1.56u
Mmp1 Y B VDD NW g45p1svt m=1 l=45n w=1.56u
Mmp0 Y A VDD NW g45p1svt m=1 l=45n w=1.56u
.ENDS

.SUBCKT NAND4X6 A B C D NW VDD VSS Y
*.PININFO A:I B:I C:I D:I NW:I VDD:I VSS:I Y:O
Mmn1 n1 B n2 VSS g45n1svt m=1 l=45n w=1.55u
Mmn3 Y D n0 VSS g45n1svt m=1 l=45n w=1.55u
Mmn2 n0 C n1 VSS g45n1svt m=1 l=45n w=1.55u
Mmn0 n2 A VSS VSS g45n1svt m=1 l=45n w=1.55u
Mmp3 Y D VDD NW g45p1svt m=1 l=45n w=2.35u
Mmp2 Y C VDD NW g45p1svt m=1 l=45n w=2.35u
Mmp1 Y B VDD NW g45p1svt m=1 l=45n w=2.35u
Mmp0 Y A VDD NW g45p1svt m=1 l=45n w=2.35u
.ENDS

.SUBCKT NAND4X8 A B C D NW VDD VSS Y
*.PININFO A:I B:I C:I D:I NW:I VDD:I VSS:I Y:O
Mmn1 n1 B n2 VSS g45n1svt m=1 l=45n w=2.065u
Mmn3 Y D n0 VSS g45n1svt m=1 l=45n w=2.065u
Mmn2 n0 C n1 VSS g45n1svt m=1 l=45n w=2.065u
Mmn0 n2 A VSS VSS g45n1svt m=1 l=45n w=2.065u
Mmp3 Y D VDD NW g45p1svt m=1 l=45n w=3.115u
Mmp2 Y C VDD NW g45p1svt m=1 l=45n w=3.115u
Mmp1 Y B VDD NW g45p1svt m=1 l=45n w=3.115u
Mmp0 Y A VDD NW g45p1svt m=1 l=45n w=3.115u
.ENDS

.SUBCKT NAND4XL A B C D NW VDD VSS Y
*.PININFO A:I B:I C:I D:I NW:I VDD:I VSS:I Y:O
Mmn1 n1 B n2 VSS g45n1svt m=1 l=45n w=145n
Mmn3 Y D n0 VSS g45n1svt m=1 l=45n w=145n
Mmn2 n0 C n1 VSS g45n1svt m=1 l=45n w=145n
Mmn0 n2 A VSS VSS g45n1svt m=1 l=45n w=145n
Mmp3 Y D VDD NW g45p1svt m=1 l=45n w=215n
Mmp2 Y C VDD NW g45p1svt m=1 l=45n w=215n
Mmp1 Y B VDD NW g45p1svt m=1 l=45n w=215n
Mmp0 Y A VDD NW g45p1svt m=1 l=45n w=215n
.ENDS

.SUBCKT NOR2BX1 AN B NW VDD VSS Y
*.PININFO AN:I B:I NW:I VDD:I VSS:I Y:O
Mmn1 Y net76 VSS VSS g45n1svt m=1 l=45n w=260n
Mmn2 Y B VSS VSS g45n1svt m=1 l=45n w=260n
Mmn0 net76 AN VSS VSS g45n1svt m=1 l=45n w=145n
Mmp2 Y B net59 NW g45p1svt m=1 l=45n w=390n
Mmp1 net59 net76 VDD NW g45p1svt m=1 l=45n w=390n
Mmp0 net76 AN VDD NW g45p1svt m=1 l=45n w=215n
.ENDS

.SUBCKT NOR2BX2 AN B NW VDD VSS Y
*.PININFO AN:I B:I NW:I VDD:I VSS:I Y:O
Mmn1 Y net76 VSS VSS g45n1svt m=1 l=45n w=520n
Mmn2 Y B VSS VSS g45n1svt m=1 l=45n w=520n
Mmn0 net76 AN VSS VSS g45n1svt m=1 l=45n w=145n
Mmp2 Y B net59 NW g45p1svt m=1 l=45n w=780n
Mmp1 net59 net76 VDD NW g45p1svt m=1 l=45n w=780n
Mmp0 net76 AN VDD NW g45p1svt m=1 l=45n w=215n
.ENDS

.SUBCKT NOR2BX4 AN B NW VDD VSS Y
*.PININFO AN:I B:I NW:I VDD:I VSS:I Y:O
Mmn1 Y net76 VSS VSS g45n1svt m=1 l=45n w=1.04u
Mmn2 Y B VSS VSS g45n1svt m=1 l=45n w=1.04u
Mmn0 net76 AN VSS VSS g45n1svt m=1 l=45n w=145n
Mmp2 Y B net59 NW g45p1svt m=1 l=45n w=1.56u
Mmp1 net59 net76 VDD NW g45p1svt m=1 l=45n w=1.56u
Mmp0 net76 AN VDD NW g45p1svt m=1 l=45n w=215n
.ENDS

.SUBCKT NOR2BXL AN B NW VDD VSS Y
*.PININFO AN:I B:I NW:I VDD:I VSS:I Y:O
Mmn1 Y net76 VSS VSS g45n1svt m=1 l=45n w=145n
Mmn2 Y B VSS VSS g45n1svt m=1 l=45n w=145n
Mmn0 net76 AN VSS VSS g45n1svt m=1 l=45n w=145n
Mmp2 Y B net59 NW g45p1svt m=1 l=45n w=215n
Mmp1 net59 net76 VDD NW g45p1svt m=1 l=45n w=215n
Mmp0 net76 AN VDD NW g45p1svt m=1 l=45n w=215n
.ENDS

.SUBCKT NOR2X1 A B NW VDD VSS Y
*.PININFO A:I B:I NW:I VDD:I VSS:I Y:O
Mmn1 Y B VSS VSS g45n1svt m=1 l=45n w=260n
Mmn0 Y A VSS VSS g45n1svt m=1 l=45n w=260n
Mmp1 Y B net41 NW g45p1svt m=1 l=45n w=390n
Mmp0 net41 A VDD NW g45p1svt m=1 l=45n w=390n
.ENDS

.SUBCKT NOR2X2 A B NW VDD VSS Y
*.PININFO A:I B:I NW:I VDD:I VSS:I Y:O
Mmn1 Y B VSS VSS g45n1svt m=1 l=45n w=520n
Mmn0 Y A VSS VSS g45n1svt m=1 l=45n w=520n
Mmp1 Y B net41 NW g45p1svt m=1 l=45n w=780n
Mmp0 net41 A VDD NW g45p1svt m=1 l=45n w=780n
.ENDS

.SUBCKT NOR2X4 A B NW VDD VSS Y
*.PININFO A:I B:I NW:I VDD:I VSS:I Y:O
Mmn1 Y B VSS VSS g45n1svt m=1 l=45n w=1.04u
Mmn0 Y A VSS VSS g45n1svt m=1 l=45n w=1.04u
Mmp1 Y B net41 NW g45p1svt m=1 l=45n w=1.56u
Mmp0 net41 A VDD NW g45p1svt m=1 l=45n w=1.56u
.ENDS

.SUBCKT NOR2X6 A B NW VDD VSS Y
*.PININFO A:I B:I NW:I VDD:I VSS:I Y:O
Mmn1 Y B VSS VSS g45n1svt m=1 l=45n w=1.55u
Mmn0 Y A VSS VSS g45n1svt m=1 l=45n w=1.55u
Mmp1 Y B net41 NW g45p1svt m=1 l=45n w=2.34u
Mmp0 net41 A VDD NW g45p1svt m=1 l=45n w=2.34u
.ENDS

.SUBCKT NOR2X8 A B NW VDD VSS Y
*.PININFO A:I B:I NW:I VDD:I VSS:I Y:O
Mmn1 Y B VSS VSS g45n1svt m=1 l=45n w=2.065u
Mmn0 Y A VSS VSS g45n1svt m=1 l=45n w=2.065u
Mmp1 Y B net41 NW g45p1svt m=1 l=45n w=3.115u
Mmp0 net41 A VDD NW g45p1svt m=1 l=45n w=3.115u
.ENDS

.SUBCKT NOR2XL A B NW VDD VSS Y
*.PININFO A:I B:I NW:I VDD:I VSS:I Y:O
Mmn1 Y B VSS VSS g45n1svt m=1 l=45n w=145n
Mmn0 Y A VSS VSS g45n1svt m=1 l=45n w=145n
Mmp1 Y B net41 NW g45p1svt m=1 l=45n w=215n
Mmp0 net41 A VDD NW g45p1svt m=1 l=45n w=215n
.ENDS

.SUBCKT NOR3BX1 AN B C NW VDD VSS Y
*.PININFO AN:I B:I C:I NW:I VDD:I VSS:I Y:O
Mmn1 Y net91 VSS VSS g45n1svt m=1 l=45n w=260n
Mmn3 Y C VSS VSS g45n1svt m=1 l=45n w=260n
Mmn0 net91 AN VSS VSS g45n1svt m=1 l=45n w=145n
Mmn2 Y B VSS VSS g45n1svt m=1 l=45n w=260n
Mmp3 Y C net90 NW g45p1svt m=1 l=45n w=390n
Mmp0 net91 AN VDD NW g45p1svt m=1 l=45n w=215n
Mmp1 net86 net91 VDD NW g45p1svt m=1 l=45n w=390n
Mmp2 net90 B net86 NW g45p1svt m=1 l=45n w=390n
.ENDS

.SUBCKT NOR3BX2 AN B C NW VDD VSS Y
*.PININFO AN:I B:I C:I NW:I VDD:I VSS:I Y:O
Mmn1 Y net91 VSS VSS g45n1svt m=1 l=45n w=520n
Mmn3 Y C VSS VSS g45n1svt m=1 l=45n w=520n
Mmn0 net91 AN VSS VSS g45n1svt m=1 l=45n w=145n
Mmn2 Y B VSS VSS g45n1svt m=1 l=45n w=520n
Mmp3 Y C net90 NW g45p1svt m=1 l=45n w=780n
Mmp0 net91 AN VDD NW g45p1svt m=1 l=45n w=215n
Mmp1 net86 net91 VDD NW g45p1svt m=1 l=45n w=780n
Mmp2 net90 B net86 NW g45p1svt m=1 l=45n w=780n
.ENDS

.SUBCKT NOR3BX4 AN B C NW VDD VSS Y
*.PININFO AN:I B:I C:I NW:I VDD:I VSS:I Y:O
Mmn1 Y net91 VSS VSS g45n1svt m=1 l=45n w=1.04u
Mmn3 Y C VSS VSS g45n1svt m=1 l=45n w=1.04u
Mmn0 net91 AN VSS VSS g45n1svt m=1 l=45n w=260n
Mmn2 Y B VSS VSS g45n1svt m=1 l=45n w=1.04u
Mmp3 Y C net90 NW g45p1svt m=1 l=45n w=1.56u
Mmp0 net91 AN VDD NW g45p1svt m=1 l=45n w=390n
Mmp1 net86 net91 VDD NW g45p1svt m=1 l=45n w=1.56u
Mmp2 net90 B net86 NW g45p1svt m=1 l=45n w=1.56u
.ENDS

.SUBCKT NOR3BXL AN B C NW VDD VSS Y
*.PININFO AN:I B:I C:I NW:I VDD:I VSS:I Y:O
Mmn1 Y net91 VSS VSS g45n1svt m=1 l=45n w=145n
Mmn3 Y C VSS VSS g45n1svt m=1 l=45n w=145n
Mmn0 net91 AN VSS VSS g45n1svt m=1 l=45n w=145n
Mmn2 Y B VSS VSS g45n1svt m=1 l=45n w=145n
Mmp3 Y C net90 NW g45p1svt m=1 l=45n w=215n
Mmp0 net91 AN VDD NW g45p1svt m=1 l=45n w=215n
Mmp1 net86 net91 VDD NW g45p1svt m=1 l=45n w=215n
Mmp2 net90 B net86 NW g45p1svt m=1 l=45n w=215n
.ENDS

.SUBCKT NOR3X1 A B C NW VDD VSS Y
*.PININFO A:I B:I C:I NW:I VDD:I VSS:I Y:O
Mmn0 Y A VSS VSS g45n1svt m=1 l=45n w=260n
Mmn1 Y B VSS VSS g45n1svt m=1 l=45n w=260n
Mmn2 Y C VSS VSS g45n1svt m=1 l=45n w=260n
Mmp1 n1 B n0 NW g45p1svt m=1 l=45n w=390n
Mmp2 Y C n1 NW g45p1svt m=1 l=45n w=390n
Mmp0 n0 A VDD NW g45p1svt m=1 l=45n w=390n
.ENDS

.SUBCKT NOR3X2 A B C NW VDD VSS Y
*.PININFO A:I B:I C:I NW:I VDD:I VSS:I Y:O
Mmn0 Y A VSS VSS g45n1svt m=1 l=45n w=520n
Mmn1 Y B VSS VSS g45n1svt m=1 l=45n w=520n
Mmn2 Y C VSS VSS g45n1svt m=1 l=45n w=520n
Mmp1 n1 B n0 NW g45p1svt m=1 l=45n w=780n
Mmp2 Y C n1 NW g45p1svt m=1 l=45n w=780n
Mmp0 n0 A VDD NW g45p1svt m=1 l=45n w=780n
.ENDS

.SUBCKT NOR3X4 A B C NW VDD VSS Y
*.PININFO A:I B:I C:I NW:I VDD:I VSS:I Y:O
Mmn0 Y A VSS VSS g45n1svt m=1 l=45n w=1.04u
Mmn1 Y B VSS VSS g45n1svt m=1 l=45n w=1.04u
Mmn2 Y C VSS VSS g45n1svt m=1 l=45n w=1.04u
Mmp1 n1 B n0 NW g45p1svt m=1 l=45n w=1.56u
Mmp2 Y C n1 NW g45p1svt m=1 l=45n w=1.56u
Mmp0 n0 A VDD NW g45p1svt m=1 l=45n w=1.56u
.ENDS

.SUBCKT NOR3X6 A B C NW VDD VSS Y
*.PININFO A:I B:I C:I NW:I VDD:I VSS:I Y:O
Mmn0 Y A VSS VSS g45n1svt m=1 l=45n w=1.55u
Mmn1 Y B VSS VSS g45n1svt m=1 l=45n w=1.55u
Mmn2 Y C VSS VSS g45n1svt m=1 l=45n w=1.55u
Mmp1 n1 B n0 NW g45p1svt m=1 l=45n w=2.34u
Mmp2 Y C n1 NW g45p1svt m=1 l=45n w=2.34u
Mmp0 n0 A VDD NW g45p1svt m=1 l=45n w=2.34u
.ENDS

.SUBCKT NOR3X8 A B C NW VDD VSS Y
*.PININFO A:I B:I C:I NW:I VDD:I VSS:I Y:O
Mmn0 Y A VSS VSS g45n1svt m=1 l=45n w=2.065u
Mmn1 Y B VSS VSS g45n1svt m=1 l=45n w=2.065u
Mmn2 Y C VSS VSS g45n1svt m=1 l=45n w=2.065u
Mmp1 n1 B n0 NW g45p1svt m=1 l=45n w=3.115u
Mmp2 Y C n1 NW g45p1svt m=1 l=45n w=3.115u
Mmp0 n0 A VDD NW g45p1svt m=1 l=45n w=3.115u
.ENDS

.SUBCKT NOR3XL A B C NW VDD VSS Y
*.PININFO A:I B:I C:I NW:I VDD:I VSS:I Y:O
Mmn0 Y A VSS VSS g45n1svt m=1 l=45n w=145n
Mmn1 Y B VSS VSS g45n1svt m=1 l=45n w=145n
Mmn2 Y C VSS VSS g45n1svt m=1 l=45n w=145n
Mmp1 n1 B n0 NW g45p1svt m=1 l=45n w=215n
Mmp2 Y C n1 NW g45p1svt m=1 l=45n w=215n
Mmp0 n0 A VDD NW g45p1svt m=1 l=45n w=215n
.ENDS

.SUBCKT NOR4BBX1 AN BN C D NW VDD VSS Y
*.PININFO AN:I BN:I C:I D:I NW:I VDD:I VSS:I Y:O
Mmn2 Y n0 VSS VSS g45n1svt m=1 l=45n w=260n
Mmn1 n1 BN VSS VSS g45n1svt m=1 l=45n w=145n
Mmn3 Y n1 VSS VSS g45n1svt m=1 l=45n w=260n
Mmn5 Y D VSS VSS g45n1svt m=1 l=45n w=260n
Mmn4 Y C VSS VSS g45n1svt m=1 l=45n w=260n
Mmn0 n0 AN VSS VSS g45n1svt m=1 l=45n w=145n
Mmp0 n0 AN VDD NW g45p1svt m=1 l=45n w=215n
Mmp5 Y D n4 NW g45p1svt m=1 l=45n w=390n
Mmp4 n4 C n3 NW g45p1svt m=1 l=45n w=390n
Mmp1 n1 BN VDD NW g45p1svt m=1 l=45n w=215n
Mmp3 n3 n1 n2 NW g45p1svt m=1 l=45n w=390n
Mmp2 n2 n0 VDD NW g45p1svt m=1 l=45n w=390n
.ENDS

.SUBCKT NOR4BBX2 AN BN C D NW VDD VSS Y
*.PININFO AN:I BN:I C:I D:I NW:I VDD:I VSS:I Y:O
Mmn2 Y n0 VSS VSS g45n1svt m=1 l=45n w=520n
Mmn1 n1 BN VSS VSS g45n1svt m=1 l=45n w=145n
Mmn3 Y n1 VSS VSS g45n1svt m=1 l=45n w=520n
Mmn5 Y D VSS VSS g45n1svt m=1 l=45n w=520n
Mmn4 Y C VSS VSS g45n1svt m=1 l=45n w=520n
Mmn0 n0 AN VSS VSS g45n1svt m=1 l=45n w=145n
Mmp0 n0 AN VDD NW g45p1svt m=1 l=45n w=215n
Mmp5 Y D n4 NW g45p1svt m=1 l=45n w=780n
Mmp4 n4 C n3 NW g45p1svt m=1 l=45n w=780n
Mmp1 n1 BN VDD NW g45p1svt m=1 l=45n w=215n
Mmp3 n3 n1 n2 NW g45p1svt m=1 l=45n w=780n
Mmp2 n2 n0 VDD NW g45p1svt m=1 l=45n w=780n
.ENDS

.SUBCKT NOR4BBX4 AN BN C D NW VDD VSS Y
*.PININFO AN:I BN:I C:I D:I NW:I VDD:I VSS:I Y:O
Mmn2 Y n0 VSS VSS g45n1svt m=1 l=45n w=1.04u
Mmn1 n1 BN VSS VSS g45n1svt m=1 l=45n w=260n
Mmn3 Y n1 VSS VSS g45n1svt m=1 l=45n w=1.04u
Mmn5 Y D VSS VSS g45n1svt m=1 l=45n w=1.04u
Mmn4 Y C VSS VSS g45n1svt m=1 l=45n w=1.04u
Mmn0 n0 AN VSS VSS g45n1svt m=1 l=45n w=260n
Mmp0 n0 AN VDD NW g45p1svt m=1 l=45n w=390n
Mmp5 Y D n4 NW g45p1svt m=1 l=45n w=1.56u
Mmp4 n4 C n3 NW g45p1svt m=1 l=45n w=1.56u
Mmp1 n1 BN VDD NW g45p1svt m=1 l=45n w=390n
Mmp3 n3 n1 n2 NW g45p1svt m=1 l=45n w=1.56u
Mmp2 n2 n0 VDD NW g45p1svt m=1 l=45n w=1.56u
.ENDS

.SUBCKT NOR4BBXL AN BN C D NW VDD VSS Y
*.PININFO AN:I BN:I C:I D:I NW:I VDD:I VSS:I Y:O
Mmn2 Y n0 VSS VSS g45n1svt m=1 l=45n w=145n
Mmn1 n1 BN VSS VSS g45n1svt m=1 l=45n w=145n
Mmn3 Y n1 VSS VSS g45n1svt m=1 l=45n w=145n
Mmn5 Y D VSS VSS g45n1svt m=1 l=45n w=145n
Mmn4 Y C VSS VSS g45n1svt m=1 l=45n w=145n
Mmn0 n0 AN VSS VSS g45n1svt m=1 l=45n w=145n
Mmp0 n0 AN VDD NW g45p1svt m=1 l=45n w=215n
Mmp5 Y D n4 NW g45p1svt m=1 l=45n w=215n
Mmp4 n4 C n3 NW g45p1svt m=1 l=45n w=215n
Mmp1 n1 BN VDD NW g45p1svt m=1 l=45n w=215n
Mmp3 n3 n1 n2 NW g45p1svt m=1 l=45n w=215n
Mmp2 n2 n0 VDD NW g45p1svt m=1 l=45n w=215n
.ENDS

.SUBCKT NOR4BX1 AN B C D NW VDD VSS Y
*.PININFO AN:I B:I C:I D:I NW:I VDD:I VSS:I Y:O
Mmn4 Y D VSS VSS g45n1svt m=1 l=45n w=260n
Mmn1 Y n0 VSS VSS g45n1svt m=1 l=45n w=260n
Mmn3 Y C VSS VSS g45n1svt m=1 l=45n w=260n
Mmn0 n0 AN VSS VSS g45n1svt m=1 l=45n w=145n
Mmn2 Y B VSS VSS g45n1svt m=1 l=45n w=260n
Mmp4 Y D n3 NW g45p1svt m=1 l=45n w=390n
Mmp0 n0 AN VDD NW g45p1svt m=1 l=45n w=215n
Mmp3 n3 C n2 NW g45p1svt m=1 l=45n w=390n
Mmp2 n2 B n1 NW g45p1svt m=1 l=45n w=390n
Mmp1 n1 n0 VDD NW g45p1svt m=1 l=45n w=390n
.ENDS

.SUBCKT NOR4BX2 AN B C D NW VDD VSS Y
*.PININFO AN:I B:I C:I D:I NW:I VDD:I VSS:I Y:O
Mmn4 Y D VSS VSS g45n1svt m=1 l=45n w=520n
Mmn1 Y n0 VSS VSS g45n1svt m=1 l=45n w=520n
Mmn3 Y C VSS VSS g45n1svt m=1 l=45n w=520n
Mmn0 n0 AN VSS VSS g45n1svt m=1 l=45n w=145n
Mmn2 Y B VSS VSS g45n1svt m=1 l=45n w=520n
Mmp4 Y D n3 NW g45p1svt m=1 l=45n w=780n
Mmp0 n0 AN VDD NW g45p1svt m=1 l=45n w=215n
Mmp3 n3 C n2 NW g45p1svt m=1 l=45n w=780n
Mmp2 n2 B n1 NW g45p1svt m=1 l=45n w=780n
Mmp1 n1 n0 VDD NW g45p1svt m=1 l=45n w=780n
.ENDS

.SUBCKT NOR4BX4 AN B C D NW VDD VSS Y
*.PININFO AN:I B:I C:I D:I NW:I VDD:I VSS:I Y:O
Mmn4 Y D VSS VSS g45n1svt m=1 l=45n w=1.04u
Mmn1 Y n0 VSS VSS g45n1svt m=1 l=45n w=1.04u
Mmn3 Y C VSS VSS g45n1svt m=1 l=45n w=1.04u
Mmn0 n0 AN VSS VSS g45n1svt m=1 l=45n w=260n
Mmn2 Y B VSS VSS g45n1svt m=1 l=45n w=1.04u
Mmp4 Y D n3 NW g45p1svt m=1 l=45n w=1.56u
Mmp0 n0 AN VDD NW g45p1svt m=1 l=45n w=390n
Mmp3 n3 C n2 NW g45p1svt m=1 l=45n w=1.56u
Mmp2 n2 B n1 NW g45p1svt m=1 l=45n w=1.56u
Mmp1 n1 n0 VDD NW g45p1svt m=1 l=45n w=1.56u
.ENDS

.SUBCKT NOR4BXL AN B C D NW VDD VSS Y
*.PININFO AN:I B:I C:I D:I NW:I VDD:I VSS:I Y:O
Mmn4 Y D VSS VSS g45n1svt m=1 l=45n w=145n
Mmn1 Y n0 VSS VSS g45n1svt m=1 l=45n w=145n
Mmn3 Y C VSS VSS g45n1svt m=1 l=45n w=145n
Mmn0 n0 AN VSS VSS g45n1svt m=1 l=45n w=145n
Mmn2 Y B VSS VSS g45n1svt m=1 l=45n w=145n
Mmp4 Y D n3 NW g45p1svt m=1 l=45n w=215n
Mmp0 n0 AN VDD NW g45p1svt m=1 l=45n w=215n
Mmp3 n3 C n2 NW g45p1svt m=1 l=45n w=215n
Mmp2 n2 B n1 NW g45p1svt m=1 l=45n w=215n
Mmp1 n1 n0 VDD NW g45p1svt m=1 l=45n w=215n
.ENDS

.SUBCKT NOR4X1 A B C D NW VDD VSS Y
*.PININFO A:I B:I C:I D:I NW:I VDD:I VSS:I Y:O
Mmn2 Y C VSS VSS g45n1svt m=1 l=45n w=260n
Mmn3 Y D VSS VSS g45n1svt m=1 l=45n w=260n
Mmn0 Y A VSS VSS g45n1svt m=1 l=45n w=260n
Mmn1 Y B VSS VSS g45n1svt m=1 l=45n w=260n
Mmp1 n1 B n0 NW g45p1svt m=1 l=45n w=390n
Mmp3 Y D n2 NW g45p1svt m=1 l=45n w=390n
Mmp2 n2 C n1 NW g45p1svt m=1 l=45n w=390n
Mmp0 n0 A VDD NW g45p1svt m=1 l=45n w=390n
.ENDS

.SUBCKT NOR4X2 A B C D NW VDD VSS Y
*.PININFO A:I B:I C:I D:I NW:I VDD:I VSS:I Y:O
Mmn2 Y C VSS VSS g45n1svt m=1 l=45n w=520n
Mmn3 Y D VSS VSS g45n1svt m=1 l=45n w=520n
Mmn0 Y A VSS VSS g45n1svt m=1 l=45n w=520n
Mmn1 Y B VSS VSS g45n1svt m=1 l=45n w=520n
Mmp1 n1 B n0 NW g45p1svt m=1 l=45n w=780n
Mmp3 Y D n2 NW g45p1svt m=1 l=45n w=780n
Mmp2 n2 C n1 NW g45p1svt m=1 l=45n w=780n
Mmp0 n0 A VDD NW g45p1svt m=1 l=45n w=780n
.ENDS

.SUBCKT NOR4X4 A B C D NW VDD VSS Y
*.PININFO A:I B:I C:I D:I NW:I VDD:I VSS:I Y:O
Mmn2 Y C VSS VSS g45n1svt m=1 l=45n w=1.04u
Mmn3 Y D VSS VSS g45n1svt m=1 l=45n w=1.04u
Mmn0 Y A VSS VSS g45n1svt m=1 l=45n w=1.04u
Mmn1 Y B VSS VSS g45n1svt m=1 l=45n w=1.04u
Mmp1 n1 B n0 NW g45p1svt m=1 l=45n w=1.56u
Mmp3 Y D n2 NW g45p1svt m=1 l=45n w=1.56u
Mmp2 n2 C n1 NW g45p1svt m=1 l=45n w=1.56u
Mmp0 n0 A VDD NW g45p1svt m=1 l=45n w=1.56u
.ENDS

.SUBCKT NOR4X6 A B C D NW VDD VSS Y
*.PININFO A:I B:I C:I D:I NW:I VDD:I VSS:I Y:O
Mmn2 Y C VSS VSS g45n1svt m=1 l=45n w=1.55u
Mmn3 Y D VSS VSS g45n1svt m=1 l=45n w=1.55u
Mmn0 Y A VSS VSS g45n1svt m=1 l=45n w=1.55u
Mmn1 Y B VSS VSS g45n1svt m=1 l=45n w=1.55u
Mmp1 n1 B n0 NW g45p1svt m=1 l=45n w=2.35u
Mmp3 Y D n2 NW g45p1svt m=1 l=45n w=2.35u
Mmp2 n2 C n1 NW g45p1svt m=1 l=45n w=2.35u
Mmp0 n0 A VDD NW g45p1svt m=1 l=45n w=2.35u
.ENDS

.SUBCKT NOR4X8 A B C D NW VDD VSS Y
*.PININFO A:I B:I C:I D:I NW:I VDD:I VSS:I Y:O
Mmn2 Y C VSS VSS g45n1svt m=1 l=45n w=2.065u
Mmn3 Y D VSS VSS g45n1svt m=1 l=45n w=2.065u
Mmn0 Y A VSS VSS g45n1svt m=1 l=45n w=2.065u
Mmn1 Y B VSS VSS g45n1svt m=1 l=45n w=2.065u
Mmp1 n1 B n0 NW g45p1svt m=1 l=45n w=3.115u
Mmp3 Y D n2 NW g45p1svt m=1 l=45n w=3.115u
Mmp2 n2 C n1 NW g45p1svt m=1 l=45n w=3.115u
Mmp0 n0 A VDD NW g45p1svt m=1 l=45n w=3.115u
.ENDS

.SUBCKT NOR4XL A B C D NW VDD VSS Y
*.PININFO A:I B:I C:I D:I NW:I VDD:I VSS:I Y:O
Mmn2 Y C VSS VSS g45n1svt m=1 l=45n w=145n
Mmn3 Y D VSS VSS g45n1svt m=1 l=45n w=145n
Mmn0 Y A VSS VSS g45n1svt m=1 l=45n w=145n
Mmn1 Y B VSS VSS g45n1svt m=1 l=45n w=145n
Mmp1 n1 B n0 NW g45p1svt m=1 l=45n w=215n
Mmp3 Y D n2 NW g45p1svt m=1 l=45n w=215n
Mmp2 n2 C n1 NW g45p1svt m=1 l=45n w=215n
Mmp0 n0 A VDD NW g45p1svt m=1 l=45n w=215n
.ENDS

.SUBCKT OA21X1 A0 A1 B0 NW VDD VSS Y
*.PININFO A0:I A1:I B0:I NW:I VDD:I VSS:I Y:O
Mmn1 net107 A1 VSS VSS g45n1svt m=1 l=45n w=145n
Mmn0 net107 A0 VSS VSS g45n1svt m=1 l=45n w=145n
Mmn3 Y net95 VSS VSS g45n1svt m=1 l=45n w=260n
Mmn2 net95 B0 net107 VSS g45n1svt m=1 l=45n w=145n
Mmp1 net95 A1 net98 NW g45p1svt m=1 l=45n w=215n
Mmp0 net98 A0 VDD NW g45p1svt m=1 l=45n w=215n
Mmp3 Y net95 VDD NW g45p1svt m=1 l=45n w=390n
Mmp2 net95 B0 VDD NW g45p1svt m=1 l=45n w=215n
.ENDS

.SUBCKT OA21X2 A0 A1 B0 NW VDD VSS Y
*.PININFO A0:I A1:I B0:I NW:I VDD:I VSS:I Y:O
Mmn1 net107 A1 VSS VSS g45n1svt m=1 l=45n w=145n
Mmn0 net107 A0 VSS VSS g45n1svt m=1 l=45n w=145n
Mmn3 Y net95 VSS VSS g45n1svt m=1 l=45n w=520n
Mmn2 net95 B0 net107 VSS g45n1svt m=1 l=45n w=145n
Mmp1 net95 A1 net98 NW g45p1svt m=1 l=45n w=215n
Mmp0 net98 A0 VDD NW g45p1svt m=1 l=45n w=215n
Mmp3 Y net95 VDD NW g45p1svt m=1 l=45n w=780n
Mmp2 net95 B0 VDD NW g45p1svt m=1 l=45n w=215n
.ENDS

.SUBCKT OA21X4 A0 A1 B0 NW VDD VSS Y
*.PININFO A0:I A1:I B0:I NW:I VDD:I VSS:I Y:O
Mmn1 net107 A1 VSS VSS g45n1svt m=1 l=45n w=260n
Mmn0 net107 A0 VSS VSS g45n1svt m=1 l=45n w=260n
Mmn3 Y net95 VSS VSS g45n1svt m=1 l=45n w=1.04u
Mmn2 net95 B0 net107 VSS g45n1svt m=1 l=45n w=260n
Mmp1 net95 A1 net98 NW g45p1svt m=1 l=45n w=390n
Mmp0 net98 A0 VDD NW g45p1svt m=1 l=45n w=390n
Mmp3 Y net95 VDD NW g45p1svt m=1 l=45n w=1.56u
Mmp2 net95 B0 VDD NW g45p1svt m=1 l=45n w=390n
.ENDS

.SUBCKT OA21XL A0 A1 B0 NW VDD VSS Y
*.PININFO A0:I A1:I B0:I NW:I VDD:I VSS:I Y:O
Mmn1 net107 A1 VSS VSS g45n1svt m=1 l=45n w=145n
Mmn0 net107 A0 VSS VSS g45n1svt m=1 l=45n w=145n
Mmn3 Y net95 VSS VSS g45n1svt m=1 l=45n w=145n
Mmn2 net95 B0 net107 VSS g45n1svt m=1 l=45n w=145n
Mmp1 net95 A1 net98 NW g45p1svt m=1 l=45n w=215n
Mmp0 net98 A0 VDD NW g45p1svt m=1 l=45n w=215n
Mmp3 Y net95 VDD NW g45p1svt m=1 l=45n w=215n
Mmp2 net95 B0 VDD NW g45p1svt m=1 l=45n w=215n
.ENDS

.SUBCKT OA22X1 A0 A1 B0 B1 NW VDD VSS Y
*.PININFO A0:I A1:I B0:I B1:I NW:I VDD:I VSS:I Y:O
Mmn3 net128 B1 net124 VSS g45n1svt m=1 l=45n w=145n
Mmn2 net128 B0 net124 VSS g45n1svt m=1 l=45n w=145n
Mmn1 net124 A1 VSS VSS g45n1svt m=1 l=45n w=145n
Mmn0 net124 A0 VSS VSS g45n1svt m=1 l=45n w=145n
Mmn4 Y net128 VSS VSS g45n1svt m=1 l=45n w=260n
Mmp3 net128 B1 net115 NW g45p1svt m=1 l=45n w=215n
Mmp2 net115 B0 VDD NW g45p1svt m=1 l=45n w=215n
Mmp1 net128 A1 net119 NW g45p1svt m=1 l=45n w=215n
Mmp0 net119 A0 VDD NW g45p1svt m=1 l=45n w=215n
Mmp4 Y net128 VDD NW g45p1svt m=1 l=45n w=390n
.ENDS

.SUBCKT OA22X2 A0 A1 B0 B1 NW VDD VSS Y
*.PININFO A0:I A1:I B0:I B1:I NW:I VDD:I VSS:I Y:O
Mmn3 net128 B1 net124 VSS g45n1svt m=1 l=45n w=145n
Mmn2 net128 B0 net124 VSS g45n1svt m=1 l=45n w=145n
Mmn1 net124 A1 VSS VSS g45n1svt m=1 l=45n w=145n
Mmn0 net124 A0 VSS VSS g45n1svt m=1 l=45n w=145n
Mmn4 Y net128 VSS VSS g45n1svt m=1 l=45n w=520n
Mmp3 net128 B1 net115 NW g45p1svt m=1 l=45n w=215n
Mmp2 net115 B0 VDD NW g45p1svt m=1 l=45n w=215n
Mmp1 net128 A1 net119 NW g45p1svt m=1 l=45n w=215n
Mmp0 net119 A0 VDD NW g45p1svt m=1 l=45n w=215n
Mmp4 Y net128 VDD NW g45p1svt m=1 l=45n w=780n
.ENDS

.SUBCKT OA22X4 A0 A1 B0 B1 NW VDD VSS Y
*.PININFO A0:I A1:I B0:I B1:I NW:I VDD:I VSS:I Y:O
Mmn3 net128 B1 net124 VSS g45n1svt m=1 l=45n w=260n
Mmn2 net128 B0 net124 VSS g45n1svt m=1 l=45n w=260n
Mmn1 net124 A1 VSS VSS g45n1svt m=1 l=45n w=260n
Mmn0 net124 A0 VSS VSS g45n1svt m=1 l=45n w=260n
Mmn4 Y net128 VSS VSS g45n1svt m=1 l=45n w=1.04u
Mmp3 net128 B1 net115 NW g45p1svt m=1 l=45n w=390n
Mmp2 net115 B0 VDD NW g45p1svt m=1 l=45n w=390n
Mmp1 net128 A1 net119 NW g45p1svt m=1 l=45n w=390n
Mmp0 net119 A0 VDD NW g45p1svt m=1 l=45n w=390n
Mmp4 Y net128 VDD NW g45p1svt m=1 l=45n w=1.56u
.ENDS

.SUBCKT OA22XL A0 A1 B0 B1 NW VDD VSS Y
*.PININFO A0:I A1:I B0:I B1:I NW:I VDD:I VSS:I Y:O
Mmn3 net128 B1 net124 VSS g45n1svt m=1 l=45n w=145n
Mmn2 net128 B0 net124 VSS g45n1svt m=1 l=45n w=145n
Mmn1 net124 A1 VSS VSS g45n1svt m=1 l=45n w=145n
Mmn0 net124 A0 VSS VSS g45n1svt m=1 l=45n w=145n
Mmn4 Y net128 VSS VSS g45n1svt m=1 l=45n w=145n
Mmp3 net128 B1 net115 NW g45p1svt m=1 l=45n w=215n
Mmp2 net115 B0 VDD NW g45p1svt m=1 l=45n w=215n
Mmp1 net128 A1 net119 NW g45p1svt m=1 l=45n w=215n
Mmp0 net119 A0 VDD NW g45p1svt m=1 l=45n w=215n
Mmp4 Y net128 VDD NW g45p1svt m=1 l=45n w=215n
.ENDS

.SUBCKT OAI211X1 A0 A1 B0 C0 NW VDD VSS Y
*.PININFO A0:I A1:I B0:I C0:I NW:I VDD:I VSS:I Y:O
Mmn1 n0 A1 VSS VSS g45n1svt m=1 l=45n w=260n
Mmn0 n0 A0 VSS VSS g45n1svt m=1 l=45n w=260n
Mmn2 n1 B0 n0 VSS g45n1svt m=1 l=45n w=260n
Mmn3 Y C0 n1 VSS g45n1svt m=1 l=45n w=260n
Mmp1 Y A1 n2 NW g45p1svt m=1 l=45n w=390n
Mmp0 n2 A0 VDD NW g45p1svt m=1 l=45n w=390n
Mmp3 Y C0 VDD NW g45p1svt m=1 l=45n w=390n
Mmp2 Y B0 VDD NW g45p1svt m=1 l=45n w=390n
.ENDS

.SUBCKT OAI211X2 A0 A1 B0 C0 NW VDD VSS Y
*.PININFO A0:I A1:I B0:I C0:I NW:I VDD:I VSS:I Y:O
Mmn1 n0 A1 VSS VSS g45n1svt m=1 l=45n w=520n
Mmn0 n0 A0 VSS VSS g45n1svt m=1 l=45n w=520n
Mmn2 n1 B0 n0 VSS g45n1svt m=1 l=45n w=520n
Mmn3 Y C0 n1 VSS g45n1svt m=1 l=45n w=520n
Mmp1 Y A1 n2 NW g45p1svt m=1 l=45n w=780n
Mmp0 n2 A0 VDD NW g45p1svt m=1 l=45n w=780n
Mmp3 Y C0 VDD NW g45p1svt m=1 l=45n w=780n
Mmp2 Y B0 VDD NW g45p1svt m=1 l=45n w=780n
.ENDS

.SUBCKT OAI211X4 A0 A1 B0 C0 NW VDD VSS Y
*.PININFO A0:I A1:I B0:I C0:I NW:I VDD:I VSS:I Y:O
Mmn1 n0 A1 VSS VSS g45n1svt m=1 l=45n w=1.04u
Mmn0 n0 A0 VSS VSS g45n1svt m=1 l=45n w=1.04u
Mmn2 n1 B0 n0 VSS g45n1svt m=1 l=45n w=1.04u
Mmn3 Y C0 n1 VSS g45n1svt m=1 l=45n w=1.04u
Mmp1 Y A1 n2 NW g45p1svt m=1 l=45n w=1.56u
Mmp0 n2 A0 VDD NW g45p1svt m=1 l=45n w=1.56u
Mmp3 Y C0 VDD NW g45p1svt m=1 l=45n w=1.56u
Mmp2 Y B0 VDD NW g45p1svt m=1 l=45n w=1.56u
.ENDS

.SUBCKT OAI211XL A0 A1 B0 C0 NW VDD VSS Y
*.PININFO A0:I A1:I B0:I C0:I NW:I VDD:I VSS:I Y:O
Mmn1 n0 A1 VSS VSS g45n1svt m=1 l=45n w=145n
Mmn0 n0 A0 VSS VSS g45n1svt m=1 l=45n w=145n
Mmn2 n1 B0 n0 VSS g45n1svt m=1 l=45n w=145n
Mmn3 Y C0 n1 VSS g45n1svt m=1 l=45n w=145n
Mmp1 Y A1 n2 NW g45p1svt m=1 l=45n w=215n
Mmp0 n2 A0 VDD NW g45p1svt m=1 l=45n w=215n
Mmp3 Y C0 VDD NW g45p1svt m=1 l=45n w=215n
Mmp2 Y B0 VDD NW g45p1svt m=1 l=45n w=215n
.ENDS

.SUBCKT OAI21X1 A0 A1 B0 NW VDD VSS Y
*.PININFO A0:I A1:I B0:I NW:I VDD:I VSS:I Y:O
Mmn2 Y B0 n0 VSS g45n1svt m=1 l=45n w=260n
Mmn1 n0 A1 VSS VSS g45n1svt m=1 l=45n w=260n
Mmn0 n0 A0 VSS VSS g45n1svt m=1 l=45n w=260n
Mmp0 n1 A0 VDD NW g45p1svt m=1 l=45n w=390n
Mmp2 Y B0 VDD NW g45p1svt m=1 l=45n w=390n
Mmp1 Y A1 n1 NW g45p1svt m=1 l=45n w=390n
.ENDS

.SUBCKT OAI21X2 A0 A1 B0 NW VDD VSS Y
*.PININFO A0:I A1:I B0:I NW:I VDD:I VSS:I Y:O
Mmn2 Y B0 n0 VSS g45n1svt m=1 l=45n w=520n
Mmn1 n0 A1 VSS VSS g45n1svt m=1 l=45n w=520n
Mmn0 n0 A0 VSS VSS g45n1svt m=1 l=45n w=520n
Mmp0 n1 A0 VDD NW g45p1svt m=1 l=45n w=780n
Mmp2 Y B0 VDD NW g45p1svt m=1 l=45n w=780n
Mmp1 Y A1 n1 NW g45p1svt m=1 l=45n w=780n
.ENDS

.SUBCKT OAI21X4 A0 A1 B0 NW VDD VSS Y
*.PININFO A0:I A1:I B0:I NW:I VDD:I VSS:I Y:O
Mmn2 Y B0 n0 VSS g45n1svt m=1 l=45n w=1.04u
Mmn1 n0 A1 VSS VSS g45n1svt m=1 l=45n w=1.04u
Mmn0 n0 A0 VSS VSS g45n1svt m=1 l=45n w=1.04u
Mmp0 n1 A0 VDD NW g45p1svt m=1 l=45n w=1.56u
Mmp2 Y B0 VDD NW g45p1svt m=1 l=45n w=1.56u
Mmp1 Y A1 n1 NW g45p1svt m=1 l=45n w=1.56u
.ENDS

.SUBCKT OAI21XL A0 A1 B0 NW VDD VSS Y
*.PININFO A0:I A1:I B0:I NW:I VDD:I VSS:I Y:O
Mmn2 Y B0 n0 VSS g45n1svt m=1 l=45n w=145n
Mmn1 n0 A1 VSS VSS g45n1svt m=1 l=45n w=145n
Mmn0 n0 A0 VSS VSS g45n1svt m=1 l=45n w=145n
Mmp0 n1 A0 VDD NW g45p1svt m=1 l=45n w=215n
Mmp2 Y B0 VDD NW g45p1svt m=1 l=45n w=215n
Mmp1 Y A1 n1 NW g45p1svt m=1 l=45n w=215n
.ENDS

.SUBCKT OAI221X1 A0 A1 B0 B1 C0 NW VDD VSS Y
*.PININFO A0:I A1:I B0:I B1:I C0:I NW:I VDD:I VSS:I Y:O
Mmn4 Y C0 net132 VSS g45n1svt m=1 l=45n w=260n
Mmn0 net128 A0 VSS VSS g45n1svt m=1 l=45n w=260n
Mmn1 net128 A1 VSS VSS g45n1svt m=1 l=45n w=260n
Mmn2 net132 B0 net128 VSS g45n1svt m=1 l=45n w=260n
Mmn3 net132 B1 net128 VSS g45n1svt m=1 l=45n w=260n
Mmp3 Y B1 net123 NW g45p1svt m=1 l=45n w=390n
Mmp0 net115 A0 VDD NW g45p1svt m=1 l=45n w=390n
Mmp1 Y A1 net115 NW g45p1svt m=1 l=45n w=390n
Mmp2 net123 B0 VDD NW g45p1svt m=1 l=45n w=390n
Mmp4 Y C0 VDD NW g45p1svt m=1 l=45n w=390n
.ENDS

.SUBCKT OAI221X2 A0 A1 B0 B1 C0 NW VDD VSS Y
*.PININFO A0:I A1:I B0:I B1:I C0:I NW:I VDD:I VSS:I Y:O
Mmn4 Y C0 net132 VSS g45n1svt m=1 l=45n w=520n
Mmn0 net128 A0 VSS VSS g45n1svt m=1 l=45n w=520n
Mmn1 net128 A1 VSS VSS g45n1svt m=1 l=45n w=520n
Mmn2 net132 B0 net128 VSS g45n1svt m=1 l=45n w=520n
Mmn3 net132 B1 net128 VSS g45n1svt m=1 l=45n w=520n
Mmp3 Y B1 net123 NW g45p1svt m=1 l=45n w=780n
Mmp0 net115 A0 VDD NW g45p1svt m=1 l=45n w=780n
Mmp1 Y A1 net115 NW g45p1svt m=1 l=45n w=780n
Mmp2 net123 B0 VDD NW g45p1svt m=1 l=45n w=780n
Mmp4 Y C0 VDD NW g45p1svt m=1 l=45n w=780n
.ENDS

.SUBCKT OAI221X4 A0 A1 B0 B1 C0 NW VDD VSS Y
*.PININFO A0:I A1:I B0:I B1:I C0:I NW:I VDD:I VSS:I Y:O
Mmn4 Y C0 net132 VSS g45n1svt m=1 l=45n w=1.04u
Mmn0 net128 A0 VSS VSS g45n1svt m=1 l=45n w=1.04u
Mmn1 net128 A1 VSS VSS g45n1svt m=1 l=45n w=1.04u
Mmn2 net132 B0 net128 VSS g45n1svt m=1 l=45n w=1.04u
Mmn3 net132 B1 net128 VSS g45n1svt m=1 l=45n w=1.04u
Mmp3 Y B1 net123 NW g45p1svt m=1 l=45n w=1.56u
Mmp0 net115 A0 VDD NW g45p1svt m=1 l=45n w=1.56u
Mmp1 Y A1 net115 NW g45p1svt m=1 l=45n w=1.56u
Mmp2 net123 B0 VDD NW g45p1svt m=1 l=45n w=1.56u
Mmp4 Y C0 VDD NW g45p1svt m=1 l=45n w=1.56u
.ENDS

.SUBCKT OAI221XL A0 A1 B0 B1 C0 NW VDD VSS Y
*.PININFO A0:I A1:I B0:I B1:I C0:I NW:I VDD:I VSS:I Y:O
Mmn4 Y C0 net132 VSS g45n1svt m=1 l=45n w=145n
Mmn0 net128 A0 VSS VSS g45n1svt m=1 l=45n w=145n
Mmn1 net128 A1 VSS VSS g45n1svt m=1 l=45n w=145n
Mmn2 net132 B0 net128 VSS g45n1svt m=1 l=45n w=145n
Mmn3 net132 B1 net128 VSS g45n1svt m=1 l=45n w=145n
Mmp3 Y B1 net123 NW g45p1svt m=1 l=45n w=215n
Mmp0 net115 A0 VDD NW g45p1svt m=1 l=45n w=215n
Mmp1 Y A1 net115 NW g45p1svt m=1 l=45n w=215n
Mmp2 net123 B0 VDD NW g45p1svt m=1 l=45n w=215n
Mmp4 Y C0 VDD NW g45p1svt m=1 l=45n w=215n
.ENDS

.SUBCKT OAI222X1 A0 A1 B0 B1 C0 C1 NW VDD VSS Y
*.PININFO A0:I A1:I B0:I B1:I C0:I C1:I NW:I VDD:I VSS:I Y:O
Mmn5 Y C1 n0 VSS g45n1svt m=1 l=45n w=260n
Mmn4 Y C0 n0 VSS g45n1svt m=1 l=45n w=260n
Mmn3 n0 B1 n1 VSS g45n1svt m=1 l=45n w=260n
Mmn2 n0 B0 n1 VSS g45n1svt m=1 l=45n w=260n
Mmn0 n1 A0 VSS VSS g45n1svt m=1 l=45n w=260n
Mmn1 n1 A1 VSS VSS g45n1svt m=1 l=45n w=260n
Mmp5 Y C1 n4 NW g45p1svt m=1 l=45n w=390n
Mmp4 n4 C0 VDD NW g45p1svt m=1 l=45n w=390n
Mmp3 Y B1 n3 NW g45p1svt m=1 l=45n w=390n
Mmp2 n3 B0 VDD NW g45p1svt m=1 l=45n w=390n
Mmp1 Y A1 n2 NW g45p1svt m=1 l=45n w=390n
Mmp0 n2 A0 VDD NW g45p1svt m=1 l=45n w=390n
.ENDS

.SUBCKT OAI222X2 A0 A1 B0 B1 C0 C1 NW VDD VSS Y
*.PININFO A0:I A1:I B0:I B1:I C0:I C1:I NW:I VDD:I VSS:I Y:O
Mmn5 Y C1 n0 VSS g45n1svt m=1 l=45n w=520n
Mmn4 Y C0 n0 VSS g45n1svt m=1 l=45n w=520n
Mmn3 n0 B1 n1 VSS g45n1svt m=1 l=45n w=520n
Mmn2 n0 B0 n1 VSS g45n1svt m=1 l=45n w=520n
Mmn0 n1 A0 VSS VSS g45n1svt m=1 l=45n w=520n
Mmn1 n1 A1 VSS VSS g45n1svt m=1 l=45n w=520n
Mmp5 Y C1 n4 NW g45p1svt m=1 l=45n w=780n
Mmp4 n4 C0 VDD NW g45p1svt m=1 l=45n w=780n
Mmp3 Y B1 n3 NW g45p1svt m=1 l=45n w=780n
Mmp2 n3 B0 VDD NW g45p1svt m=1 l=45n w=780n
Mmp1 Y A1 n2 NW g45p1svt m=1 l=45n w=780n
Mmp0 n2 A0 VDD NW g45p1svt m=1 l=45n w=780n
.ENDS

.SUBCKT OAI222X4 A0 A1 B0 B1 C0 C1 NW VDD VSS Y
*.PININFO A0:I A1:I B0:I B1:I C0:I C1:I NW:I VDD:I VSS:I Y:O
Mmn5 Y C1 n0 VSS g45n1svt m=1 l=45n w=1.04u
Mmn4 Y C0 n0 VSS g45n1svt m=1 l=45n w=1.04u
Mmn3 n0 B1 n1 VSS g45n1svt m=1 l=45n w=1.04u
Mmn2 n0 B0 n1 VSS g45n1svt m=1 l=45n w=1.04u
Mmn0 n1 A0 VSS VSS g45n1svt m=1 l=45n w=1.04u
Mmn1 n1 A1 VSS VSS g45n1svt m=1 l=45n w=1.04u
Mmp5 Y C1 n4 NW g45p1svt m=1 l=45n w=1.56u
Mmp4 n4 C0 VDD NW g45p1svt m=1 l=45n w=1.56u
Mmp3 Y B1 n3 NW g45p1svt m=1 l=45n w=1.56u
Mmp2 n3 B0 VDD NW g45p1svt m=1 l=45n w=1.56u
Mmp1 Y A1 n2 NW g45p1svt m=1 l=45n w=1.56u
Mmp0 n2 A0 VDD NW g45p1svt m=1 l=45n w=1.56u
.ENDS

.SUBCKT OAI222XL A0 A1 B0 B1 C0 C1 NW VDD VSS Y
*.PININFO A0:I A1:I B0:I B1:I C0:I C1:I NW:I VDD:I VSS:I Y:O
Mmn5 Y C1 n0 VSS g45n1svt m=1 l=45n w=145n
Mmn4 Y C0 n0 VSS g45n1svt m=1 l=45n w=145n
Mmn3 n0 B1 n1 VSS g45n1svt m=1 l=45n w=145n
Mmn2 n0 B0 n1 VSS g45n1svt m=1 l=45n w=145n
Mmn0 n1 A0 VSS VSS g45n1svt m=1 l=45n w=145n
Mmn1 n1 A1 VSS VSS g45n1svt m=1 l=45n w=145n
Mmp5 Y C1 n4 NW g45p1svt m=1 l=45n w=215n
Mmp4 n4 C0 VDD NW g45p1svt m=1 l=45n w=215n
Mmp3 Y B1 n3 NW g45p1svt m=1 l=45n w=215n
Mmp2 n3 B0 VDD NW g45p1svt m=1 l=45n w=215n
Mmp1 Y A1 n2 NW g45p1svt m=1 l=45n w=215n
Mmp0 n2 A0 VDD NW g45p1svt m=1 l=45n w=215n
.ENDS

.SUBCKT OAI22X1 A0 A1 B0 B1 NW VDD VSS Y
*.PININFO A0:I A1:I B0:I B1:I NW:I VDD:I VSS:I Y:O
Mmn0 net102 A0 VSS VSS g45n1svt m=1 l=45n w=260n
Mmn3 Y B1 net102 VSS g45n1svt m=1 l=45n w=260n
Mmn1 net102 A1 VSS VSS g45n1svt m=1 l=45n w=260n
Mmn2 Y B0 net102 VSS g45n1svt m=1 l=45n w=260n
Mmp3 Y B1 net85 NW g45p1svt m=1 l=45n w=390n
Mmp1 Y A1 net93 NW g45p1svt m=1 l=45n w=390n
Mmp0 net93 A0 VDD NW g45p1svt m=1 l=45n w=390n
Mmp2 net85 B0 VDD NW g45p1svt m=1 l=45n w=390n
.ENDS

.SUBCKT OAI22X2 A0 A1 B0 B1 NW VDD VSS Y
*.PININFO A0:I A1:I B0:I B1:I NW:I VDD:I VSS:I Y:O
Mmn0 net102 A0 VSS VSS g45n1svt m=1 l=45n w=520n
Mmn3 Y B1 net102 VSS g45n1svt m=1 l=45n w=520n
Mmn1 net102 A1 VSS VSS g45n1svt m=1 l=45n w=520n
Mmn2 Y B0 net102 VSS g45n1svt m=1 l=45n w=520n
Mmp3 Y B1 net85 NW g45p1svt m=1 l=45n w=780n
Mmp1 Y A1 net93 NW g45p1svt m=1 l=45n w=780n
Mmp0 net93 A0 VDD NW g45p1svt m=1 l=45n w=780n
Mmp2 net85 B0 VDD NW g45p1svt m=1 l=45n w=780n
.ENDS

.SUBCKT OAI22X4 A0 A1 B0 B1 NW VDD VSS Y
*.PININFO A0:I A1:I B0:I B1:I NW:I VDD:I VSS:I Y:O
Mmn0 net102 A0 VSS VSS g45n1svt m=1 l=45n w=1.04u
Mmn3 Y B1 net102 VSS g45n1svt m=1 l=45n w=1.04u
Mmn1 net102 A1 VSS VSS g45n1svt m=1 l=45n w=1.04u
Mmn2 Y B0 net102 VSS g45n1svt m=1 l=45n w=1.04u
Mmp3 Y B1 net85 NW g45p1svt m=1 l=45n w=1.56u
Mmp1 Y A1 net93 NW g45p1svt m=1 l=45n w=1.56u
Mmp0 net93 A0 VDD NW g45p1svt m=1 l=45n w=1.56u
Mmp2 net85 B0 VDD NW g45p1svt m=1 l=45n w=1.56u
.ENDS

.SUBCKT OAI22XL A0 A1 B0 B1 NW VDD VSS Y
*.PININFO A0:I A1:I B0:I B1:I NW:I VDD:I VSS:I Y:O
Mmn0 net102 A0 VSS VSS g45n1svt m=1 l=45n w=145n
Mmn3 Y B1 net102 VSS g45n1svt m=1 l=45n w=145n
Mmn1 net102 A1 VSS VSS g45n1svt m=1 l=45n w=145n
Mmn2 Y B0 net102 VSS g45n1svt m=1 l=45n w=145n
Mmp3 Y B1 net85 NW g45p1svt m=1 l=45n w=215n
Mmp1 Y A1 net93 NW g45p1svt m=1 l=45n w=215n
Mmp0 net93 A0 VDD NW g45p1svt m=1 l=45n w=215n
Mmp2 net85 B0 VDD NW g45p1svt m=1 l=45n w=215n
.ENDS

.SUBCKT OAI2BB1X1 A0N A1N B0 NW VDD VSS Y
*.PININFO A0N:I A1N:I B0:I NW:I VDD:I VSS:I Y:O
Mmn3 Y n0 n2 VSS g45n1svt m=1 l=45n w=260n
Mmn2 n2 B0 VSS VSS g45n1svt m=1 l=45n w=260n
Mmn0 n1 A0N VSS VSS g45n1svt m=1 l=45n w=145n
Mmn1 n0 A1N n1 VSS g45n1svt m=1 l=45n w=145n
Mmp2 Y B0 VDD NW g45p1svt m=1 l=45n w=390n
Mmp1 n0 A1N VDD NW g45p1svt m=1 l=45n w=215n
Mmp0 n0 A0N VDD NW g45p1svt m=1 l=45n w=215n
Mmp3 Y n0 VDD NW g45p1svt m=1 l=45n w=390n
.ENDS

.SUBCKT OAI2BB1X2 A0N A1N B0 NW VDD VSS Y
*.PININFO A0N:I A1N:I B0:I NW:I VDD:I VSS:I Y:O
Mmn3 Y n0 n2 VSS g45n1svt m=1 l=45n w=520n
Mmn2 n2 B0 VSS VSS g45n1svt m=1 l=45n w=520n
Mmn0 n1 A0N VSS VSS g45n1svt m=1 l=45n w=145n
Mmn1 n0 A1N n1 VSS g45n1svt m=1 l=45n w=145n
Mmp2 Y B0 VDD NW g45p1svt m=1 l=45n w=780n
Mmp1 n0 A1N VDD NW g45p1svt m=1 l=45n w=215n
Mmp0 n0 A0N VDD NW g45p1svt m=1 l=45n w=215n
Mmp3 Y n0 VDD NW g45p1svt m=1 l=45n w=780n
.ENDS

.SUBCKT OAI2BB1X4 A0N A1N B0 NW VDD VSS Y
*.PININFO A0N:I A1N:I B0:I NW:I VDD:I VSS:I Y:O
Mmn3 Y n0 n2 VSS g45n1svt m=1 l=45n w=1.04u
Mmn2 n2 B0 VSS VSS g45n1svt m=1 l=45n w=1.04u
Mmn0 n1 A0N VSS VSS g45n1svt m=1 l=45n w=260n
Mmn1 n0 A1N n1 VSS g45n1svt m=1 l=45n w=260n
Mmp2 Y B0 VDD NW g45p1svt m=1 l=45n w=1.56u
Mmp1 n0 A1N VDD NW g45p1svt m=1 l=45n w=390n
Mmp0 n0 A0N VDD NW g45p1svt m=1 l=45n w=390n
Mmp3 Y n0 VDD NW g45p1svt m=1 l=45n w=1.56u
.ENDS

.SUBCKT OAI2BB1XL A0N A1N B0 NW VDD VSS Y
*.PININFO A0N:I A1N:I B0:I NW:I VDD:I VSS:I Y:O
Mmn3 Y n0 n2 VSS g45n1svt m=1 l=45n w=145n
Mmn2 n2 B0 VSS VSS g45n1svt m=1 l=45n w=145n
Mmn0 n1 A0N VSS VSS g45n1svt m=1 l=45n w=145n
Mmn1 n0 A1N n1 VSS g45n1svt m=1 l=45n w=145n
Mmp2 Y B0 VDD NW g45p1svt m=1 l=45n w=215n
Mmp1 n0 A1N VDD NW g45p1svt m=1 l=45n w=215n
Mmp0 n0 A0N VDD NW g45p1svt m=1 l=45n w=215n
Mmp3 Y n0 VDD NW g45p1svt m=1 l=45n w=215n
.ENDS

.SUBCKT OAI2BB2X1 A0N A1N B0 B1 NW VDD VSS Y
*.PININFO A0N:I A1N:I B0:I B1:I NW:I VDD:I VSS:I Y:O
Mmn5 Y B1 n4 VSS g45n1svt m=1 l=45n w=260n
Mmn4 Y B0 n4 VSS g45n1svt m=1 l=45n w=260n
Mmn2 n4 n0 VSS VSS g45n1svt m=1 l=45n w=260n
Mmn0 n0 A0N VSS VSS g45n1svt m=1 l=45n w=145n
Mmn1 n1 A1N VSS VSS g45n1svt m=1 l=45n w=145n
Mmn3 n4 n1 VSS VSS g45n1svt m=1 l=45n w=260n
Mmp5 Y B1 n3 NW g45p1svt m=1 l=45n w=390n
Mmp4 n3 B0 VDD NW g45p1svt m=1 l=45n w=390n
Mmp0 n0 A0N VDD NW g45p1svt m=1 l=45n w=215n
Mmp2 n2 n0 VDD NW g45p1svt m=1 l=45n w=390n
Mmp1 n1 A1N VDD NW g45p1svt m=1 l=45n w=215n
Mmp3 Y n1 n2 NW g45p1svt m=1 l=45n w=390n
.ENDS

.SUBCKT OAI2BB2X2 A0N A1N B0 B1 NW VDD VSS Y
*.PININFO A0N:I A1N:I B0:I B1:I NW:I VDD:I VSS:I Y:O
Mmn5 Y B1 n4 VSS g45n1svt m=1 l=45n w=520n
Mmn4 Y B0 n4 VSS g45n1svt m=1 l=45n w=520n
Mmn2 n4 n0 VSS VSS g45n1svt m=1 l=45n w=520n
Mmn0 n0 A0N VSS VSS g45n1svt m=1 l=45n w=145n
Mmn1 n1 A1N VSS VSS g45n1svt m=1 l=45n w=145n
Mmn3 n4 n1 VSS VSS g45n1svt m=1 l=45n w=520n
Mmp5 Y B1 n3 NW g45p1svt m=1 l=45n w=780n
Mmp4 n3 B0 VDD NW g45p1svt m=1 l=45n w=780n
Mmp0 n0 A0N VDD NW g45p1svt m=1 l=45n w=215n
Mmp2 n2 n0 VDD NW g45p1svt m=1 l=45n w=780n
Mmp1 n1 A1N VDD NW g45p1svt m=1 l=45n w=215n
Mmp3 Y n1 n2 NW g45p1svt m=1 l=45n w=780n
.ENDS

.SUBCKT OAI2BB2X4 A0N A1N B0 B1 NW VDD VSS Y
*.PININFO A0N:I A1N:I B0:I B1:I NW:I VDD:I VSS:I Y:O
Mmn5 Y B1 n4 VSS g45n1svt m=1 l=45n w=1.04u
Mmn4 Y B0 n4 VSS g45n1svt m=1 l=45n w=1.04u
Mmn2 n4 n0 VSS VSS g45n1svt m=1 l=45n w=1.04u
Mmn0 n0 A0N VSS VSS g45n1svt m=1 l=45n w=260n
Mmn1 n1 A1N VSS VSS g45n1svt m=1 l=45n w=260n
Mmn3 n4 n1 VSS VSS g45n1svt m=1 l=45n w=1.04u
Mmp5 Y B1 n3 NW g45p1svt m=1 l=45n w=1.56u
Mmp4 n3 B0 VDD NW g45p1svt m=1 l=45n w=1.56u
Mmp0 n0 A0N VDD NW g45p1svt m=1 l=45n w=390n
Mmp2 n2 n0 VDD NW g45p1svt m=1 l=45n w=1.56u
Mmp1 n1 A1N VDD NW g45p1svt m=1 l=45n w=390n
Mmp3 Y n1 n2 NW g45p1svt m=1 l=45n w=1.56u
.ENDS

.SUBCKT OAI2BB2XL A0N A1N B0 B1 NW VDD VSS Y
*.PININFO A0N:I A1N:I B0:I B1:I NW:I VDD:I VSS:I Y:O
Mmn5 Y B1 n4 VSS g45n1svt m=1 l=45n w=145n
Mmn4 Y B0 n4 VSS g45n1svt m=1 l=45n w=145n
Mmn2 n4 n0 VSS VSS g45n1svt m=1 l=45n w=145n
Mmn0 n0 A0N VSS VSS g45n1svt m=1 l=45n w=145n
Mmn1 n1 A1N VSS VSS g45n1svt m=1 l=45n w=145n
Mmn3 n4 n1 VSS VSS g45n1svt m=1 l=45n w=145n
Mmp5 Y B1 n3 NW g45p1svt m=1 l=45n w=215n
Mmp4 n3 B0 VDD NW g45p1svt m=1 l=45n w=215n
Mmp0 n0 A0N VDD NW g45p1svt m=1 l=45n w=215n
Mmp2 n2 n0 VDD NW g45p1svt m=1 l=45n w=215n
Mmp1 n1 A1N VDD NW g45p1svt m=1 l=45n w=215n
Mmp3 Y n1 n2 NW g45p1svt m=1 l=45n w=215n
.ENDS

.SUBCKT OAI31X1 A0 A1 A2 B0 NW VDD VSS Y
*.PININFO A0:I A1:I A2:I B0:I NW:I VDD:I VSS:I Y:O
Mmn3 Y B0 n0 VSS g45n1svt m=1 l=45n w=260n
Mmn0 n0 A0 VSS VSS g45n1svt m=1 l=45n w=260n
Mmn2 n0 A2 VSS VSS g45n1svt m=1 l=45n w=260n
Mmn1 n0 A1 VSS VSS g45n1svt m=1 l=45n w=260n
Mmp2 Y A2 n2 NW g45p1svt m=1 l=45n w=390n
Mmp1 n2 A1 n1 NW g45p1svt m=1 l=45n w=390n
Mmp3 Y B0 VDD NW g45p1svt m=1 l=45n w=390n
Mmp0 n1 A0 VDD NW g45p1svt m=1 l=45n w=390n
.ENDS

.SUBCKT OAI31X2 A0 A1 A2 B0 NW VDD VSS Y
*.PININFO A0:I A1:I A2:I B0:I NW:I VDD:I VSS:I Y:O
Mmn3 Y B0 n0 VSS g45n1svt m=1 l=45n w=520n
Mmn0 n0 A0 VSS VSS g45n1svt m=1 l=45n w=520n
Mmn2 n0 A2 VSS VSS g45n1svt m=1 l=45n w=520n
Mmn1 n0 A1 VSS VSS g45n1svt m=1 l=45n w=520n
Mmp2 Y A2 n2 NW g45p1svt m=1 l=45n w=780n
Mmp1 n2 A1 n1 NW g45p1svt m=1 l=45n w=780n
Mmp3 Y B0 VDD NW g45p1svt m=1 l=45n w=780n
Mmp0 n1 A0 VDD NW g45p1svt m=1 l=45n w=780n
.ENDS

.SUBCKT OAI31X4 A0 A1 A2 B0 NW VDD VSS Y
*.PININFO A0:I A1:I A2:I B0:I NW:I VDD:I VSS:I Y:O
Mmn3 Y B0 n0 VSS g45n1svt m=1 l=45n w=1.04u
Mmn0 n0 A0 VSS VSS g45n1svt m=1 l=45n w=1.04u
Mmn2 n0 A2 VSS VSS g45n1svt m=1 l=45n w=1.04u
Mmn1 n0 A1 VSS VSS g45n1svt m=1 l=45n w=1.04u
Mmp2 Y A2 n2 NW g45p1svt m=1 l=45n w=1.56u
Mmp1 n2 A1 n1 NW g45p1svt m=1 l=45n w=1.56u
Mmp3 Y B0 VDD NW g45p1svt m=1 l=45n w=1.56u
Mmp0 n1 A0 VDD NW g45p1svt m=1 l=45n w=1.56u
.ENDS

.SUBCKT OAI31XL A0 A1 A2 B0 NW VDD VSS Y
*.PININFO A0:I A1:I A2:I B0:I NW:I VDD:I VSS:I Y:O
Mmn3 Y B0 n0 VSS g45n1svt m=1 l=45n w=145n
Mmn0 n0 A0 VSS VSS g45n1svt m=1 l=45n w=145n
Mmn2 n0 A2 VSS VSS g45n1svt m=1 l=45n w=145n
Mmn1 n0 A1 VSS VSS g45n1svt m=1 l=45n w=145n
Mmp2 Y A2 n2 NW g45p1svt m=1 l=45n w=215n
Mmp1 n2 A1 n1 NW g45p1svt m=1 l=45n w=215n
Mmp3 Y B0 VDD NW g45p1svt m=1 l=45n w=215n
Mmp0 n1 A0 VDD NW g45p1svt m=1 l=45n w=215n
.ENDS

.SUBCKT OAI32X1 A0 A1 A2 B0 B1 NW VDD VSS Y
*.PININFO A0:I A1:I A2:I B0:I B1:I NW:I VDD:I VSS:I Y:O
Mmn3 Y B0 n0 VSS g45n1svt m=1 l=45n w=260n
Mmn4 Y B1 n0 VSS g45n1svt m=1 l=45n w=260n
Mmn2 n0 A2 VSS VSS g45n1svt m=1 l=45n w=260n
Mmn0 n0 A0 VSS VSS g45n1svt m=1 l=45n w=260n
Mmn1 n0 A1 VSS VSS g45n1svt m=1 l=45n w=260n
Mmp2 Y A2 n2 NW g45p1svt m=1 l=45n w=390n
Mmp3 n4 B0 VDD NW g45p1svt m=1 l=45n w=390n
Mmp0 n1 A0 VDD NW g45p1svt m=1 l=45n w=390n
Mmp4 Y B1 n4 NW g45p1svt m=1 l=45n w=390n
Mmp1 n2 A1 n1 NW g45p1svt m=1 l=45n w=390n
.ENDS

.SUBCKT OAI32X2 A0 A1 A2 B0 B1 NW VDD VSS Y
*.PININFO A0:I A1:I A2:I B0:I B1:I NW:I VDD:I VSS:I Y:O
Mmn3 Y B0 n0 VSS g45n1svt m=1 l=45n w=520n
Mmn4 Y B1 n0 VSS g45n1svt m=1 l=45n w=520n
Mmn2 n0 A2 VSS VSS g45n1svt m=1 l=45n w=520n
Mmn0 n0 A0 VSS VSS g45n1svt m=1 l=45n w=520n
Mmn1 n0 A1 VSS VSS g45n1svt m=1 l=45n w=520n
Mmp2 Y A2 n2 NW g45p1svt m=1 l=45n w=780n
Mmp3 n4 B0 VDD NW g45p1svt m=1 l=45n w=780n
Mmp0 n1 A0 VDD NW g45p1svt m=1 l=45n w=780n
Mmp4 Y B1 n4 NW g45p1svt m=1 l=45n w=780n
Mmp1 n2 A1 n1 NW g45p1svt m=1 l=45n w=780n
.ENDS

.SUBCKT OAI32X4 A0 A1 A2 B0 B1 NW VDD VSS Y
*.PININFO A0:I A1:I A2:I B0:I B1:I NW:I VDD:I VSS:I Y:O
Mmn3 Y B0 n0 VSS g45n1svt m=1 l=45n w=1.04u
Mmn4 Y B1 n0 VSS g45n1svt m=1 l=45n w=1.04u
Mmn2 n0 A2 VSS VSS g45n1svt m=1 l=45n w=1.04u
Mmn0 n0 A0 VSS VSS g45n1svt m=1 l=45n w=1.04u
Mmn1 n0 A1 VSS VSS g45n1svt m=1 l=45n w=1.04u
Mmp2 Y A2 n2 NW g45p1svt m=1 l=45n w=1.56u
Mmp3 n4 B0 VDD NW g45p1svt m=1 l=45n w=1.56u
Mmp0 n1 A0 VDD NW g45p1svt m=1 l=45n w=1.56u
Mmp4 Y B1 n4 NW g45p1svt m=1 l=45n w=1.56u
Mmp1 n2 A1 n1 NW g45p1svt m=1 l=45n w=1.56u
.ENDS

.SUBCKT OAI32XL A0 A1 A2 B0 B1 NW VDD VSS Y
*.PININFO A0:I A1:I A2:I B0:I B1:I NW:I VDD:I VSS:I Y:O
Mmn3 Y B0 n0 VSS g45n1svt m=1 l=45n w=145n
Mmn4 Y B1 n0 VSS g45n1svt m=1 l=45n w=145n
Mmn2 n0 A2 VSS VSS g45n1svt m=1 l=45n w=145n
Mmn0 n0 A0 VSS VSS g45n1svt m=1 l=45n w=145n
Mmn1 n0 A1 VSS VSS g45n1svt m=1 l=45n w=145n
Mmp2 Y A2 n2 NW g45p1svt m=1 l=45n w=215n
Mmp3 n4 B0 VDD NW g45p1svt m=1 l=45n w=215n
Mmp0 n1 A0 VDD NW g45p1svt m=1 l=45n w=215n
Mmp4 Y B1 n4 NW g45p1svt m=1 l=45n w=215n
Mmp1 n2 A1 n1 NW g45p1svt m=1 l=45n w=215n
.ENDS

.SUBCKT OAI33X1 A0 A1 A2 B0 B1 B2 NW VDD VSS Y
*.PININFO A0:I A1:I A2:I B0:I B1:I B2:I NW:I VDD:I VSS:I Y:O
Mmn0 no A0 VSS VSS g45n1svt m=1 l=45n w=260n
Mmn4 Y B0 no VSS g45n1svt m=1 l=45n w=260n
Mmn3 Y B1 no VSS g45n1svt m=1 l=45n w=260n
Mmn1 no A1 VSS VSS g45n1svt m=1 l=45n w=260n
Mmn2 no A2 VSS VSS g45n1svt m=1 l=45n w=260n
Mmn5 Y B2 no VSS g45n1svt m=1 l=45n w=260n
Mmp1 n2 A1 n1 NW g45p1svt m=1 l=45n w=390n
Mmp4 n4 B0 n3 NW g45p1svt m=1 l=45n w=390n
Mmp3 n3 B1 VDD NW g45p1svt m=1 l=45n w=390n
Mmp5 Y B2 n4 NW g45p1svt m=1 l=45n w=390n
Mmp0 n1 A0 VDD NW g45p1svt m=1 l=45n w=390n
Mmp2 Y A2 n2 NW g45p1svt m=1 l=45n w=390n
.ENDS

.SUBCKT OAI33X2 A0 A1 A2 B0 B1 B2 NW VDD VSS Y
*.PININFO A0:I A1:I A2:I B0:I B1:I B2:I NW:I VDD:I VSS:I Y:O
Mmn0 n0 A0 VSS VSS g45n1svt m=1 l=45n w=520n
Mmn4 Y B0 n0 VSS g45n1svt m=1 l=45n w=520n
Mmn3 Y B1 n0 VSS g45n1svt m=1 l=45n w=520n
Mmn1 n0 A1 VSS VSS g45n1svt m=1 l=45n w=520n
Mmn2 n0 A2 VSS VSS g45n1svt m=1 l=45n w=520n
Mmn5 Y B2 n0 VSS g45n1svt m=1 l=45n w=520n
Mmp1 n2 A1 n1 NW g45p1svt m=1 l=45n w=790n
Mmp4 n4 B0 n3 NW g45p1svt m=1 l=45n w=790n
Mmp3 n3 B1 VDD NW g45p1svt m=1 l=45n w=790n
Mmp5 Y B2 n4 NW g45p1svt m=1 l=45n w=790n
Mmp0 n1 A0 VDD NW g45p1svt m=1 l=45n w=790n
Mmp2 Y A2 n2 NW g45p1svt m=1 l=45n w=790n
.ENDS

.SUBCKT OAI33X4 A0 A1 A2 B0 B1 B2 NW VDD VSS Y
*.PININFO A0:I A1:I A2:I B0:I B1:I B2:I NW:I VDD:I VSS:I Y:O
Mmn0 no A0 VSS VSS g45n1svt m=1 l=45n w=1.04u
Mmn4 Y B0 no VSS g45n1svt m=1 l=45n w=1.04u
Mmn3 Y B1 no VSS g45n1svt m=1 l=45n w=1.04u
Mmn1 no A1 VSS VSS g45n1svt m=1 l=45n w=1.04u
Mmn2 no A2 VSS VSS g45n1svt m=1 l=45n w=1.04u
Mmn5 Y B2 no VSS g45n1svt m=1 l=45n w=1.04u
Mmp1 n2 A1 n1 NW g45p1svt m=1 l=45n w=1.56u
Mmp4 n4 B0 n3 NW g45p1svt m=1 l=45n w=1.56u
Mmp3 n3 B1 VDD NW g45p1svt m=1 l=45n w=1.56u
Mmp5 Y B2 n4 NW g45p1svt m=1 l=45n w=1.56u
Mmp0 n1 A0 VDD NW g45p1svt m=1 l=45n w=1.56u
Mmp2 Y A2 n2 NW g45p1svt m=1 l=45n w=1.56u
.ENDS

.SUBCKT OAI33XL A0 A1 A2 B0 B1 B2 NW VDD VSS Y
*.PININFO A0:I A1:I A2:I B0:I B1:I B2:I NW:I VDD:I VSS:I Y:O
Mmn0 no A0 VSS VSS g45n1svt m=1 l=45n w=145n
Mmn4 Y B0 no VSS g45n1svt m=1 l=45n w=145n
Mmn3 Y B1 no VSS g45n1svt m=1 l=45n w=145n
Mmn1 no A1 VSS VSS g45n1svt m=1 l=45n w=145n
Mmn2 no A2 VSS VSS g45n1svt m=1 l=45n w=145n
Mmn5 Y B2 no VSS g45n1svt m=1 l=45n w=145n
Mmp1 n2 A1 n1 NW g45p1svt m=1 l=45n w=215n
Mmp4 n4 B0 n3 NW g45p1svt m=1 l=45n w=215n
Mmp3 n3 B1 VDD NW g45p1svt m=1 l=45n w=215n
Mmp5 Y B2 n4 NW g45p1svt m=1 l=45n w=215n
Mmp0 n1 A0 VDD NW g45p1svt m=1 l=45n w=215n
Mmp2 Y A2 n2 NW g45p1svt m=1 l=45n w=215n
.ENDS

.SUBCKT OR2X1 A B NW VDD VSS Y
*.PININFO A:I B:I NW:I VDD:I VSS:I Y:O
Mmn2 Y n0 VSS VSS g45n1svt m=1 l=45n w=260n
Mmn0 n0 A VSS VSS g45n1svt m=1 l=45n w=145n
Mmn1 n0 B VSS VSS g45n1svt m=1 l=45n w=145n
Mmp1 n0 B n1 NW g45p1svt m=1 l=45n w=215n
Mmp2 Y n0 VDD NW g45p1svt m=1 l=45n w=390n
Mmp0 n1 A VDD NW g45p1svt m=1 l=45n w=215n
.ENDS

.SUBCKT OR2X2 A B NW VDD VSS Y
*.PININFO A:I B:I NW:I VDD:I VSS:I Y:O
Mmn2 Y n0 VSS VSS g45n1svt m=1 l=45n w=520n
Mmn0 n0 A VSS VSS g45n1svt m=1 l=45n w=145n
Mmn1 n0 B VSS VSS g45n1svt m=1 l=45n w=145n
Mmp1 n0 B n1 NW g45p1svt m=1 l=45n w=215n
Mmp2 Y n0 VDD NW g45p1svt m=1 l=45n w=780n
Mmp0 n1 A VDD NW g45p1svt m=1 l=45n w=215n
.ENDS

.SUBCKT OR2X4 A B NW VDD VSS Y
*.PININFO A:I B:I NW:I VDD:I VSS:I Y:O
Mmn2 Y n0 VSS VSS g45n1svt m=1 l=45n w=1.04u
Mmn0 n0 A VSS VSS g45n1svt m=1 l=45n w=260n
Mmn1 n0 B VSS VSS g45n1svt m=1 l=45n w=260n
Mmp1 n0 B n1 NW g45p1svt m=1 l=45n w=390n
Mmp2 Y n0 VDD NW g45p1svt m=1 l=45n w=1.56u
Mmp0 n1 A VDD NW g45p1svt m=1 l=45n w=390n
.ENDS

.SUBCKT OR2X6 A B NW VDD VSS Y
*.PININFO A:I B:I NW:I VDD:I VSS:I Y:O
Mmn2 Y n0 VSS VSS g45n1svt m=1 l=45n w=1.55u
Mmn0 n0 A VSS VSS g45n1svt m=1 l=45n w=520n
Mmn1 n0 B VSS VSS g45n1svt m=1 l=45n w=520n
Mmp1 n0 B n1 NW g45p1svt m=1 l=45n w=780n
Mmp2 Y n0 VDD NW g45p1svt m=1 l=45n w=2.35u
Mmp0 n1 A VDD NW g45p1svt m=1 l=45n w=780n
.ENDS

.SUBCKT OR2X8 A B NW VDD VSS Y
*.PININFO A:I B:I NW:I VDD:I VSS:I Y:O
Mmn2 Y n0 VSS VSS g45n1svt m=1 l=45n w=2.1u
Mmn0 n0 A VSS VSS g45n1svt m=1 l=45n w=520n
Mmn1 n0 B VSS VSS g45n1svt m=1 l=45n w=520n
Mmp1 n0 B n1 NW g45p1svt m=1 l=45n w=780n
Mmp2 Y n0 VDD NW g45p1svt m=1 l=45n w=3.15u
Mmp0 n1 A VDD NW g45p1svt m=1 l=45n w=780n
.ENDS

.SUBCKT OR2XL A B NW VDD VSS Y
*.PININFO A:I B:I NW:I VDD:I VSS:I Y:O
Mmn2 Y n0 VSS VSS g45n1svt m=1 l=45n w=145n
Mmn0 n0 A VSS VSS g45n1svt m=1 l=45n w=145n
Mmn1 n0 B VSS VSS g45n1svt m=1 l=45n w=145n
Mmp1 n0 B n1 NW g45p1svt m=1 l=45n w=215n
Mmp2 Y n0 VDD NW g45p1svt m=1 l=45n w=215n
Mmp0 n1 A VDD NW g45p1svt m=1 l=45n w=215n
.ENDS

.SUBCKT OR3X1 A B C NW VDD VSS Y
*.PININFO A:I B:I C:I NW:I VDD:I VSS:I Y:O
Mmn3 Y n0 VSS VSS g45n1svt m=1 l=45n w=260n
Mmn0 n0 A VSS VSS g45n1svt m=1 l=45n w=145n
Mmn1 n0 B VSS VSS g45n1svt m=1 l=45n w=145n
Mmn2 n0 C VSS VSS g45n1svt m=1 l=45n w=145n
Mmp3 Y n0 VDD NW g45p1svt m=1 l=45n w=390n
Mmp1 n2 B n1 NW g45p1svt m=1 l=45n w=215n
Mmp2 n0 C n2 NW g45p1svt m=1 l=45n w=215n
Mmp0 n1 A VDD NW g45p1svt m=1 l=45n w=215n
.ENDS

.SUBCKT OR3X2 A B C NW VDD VSS Y
*.PININFO A:I B:I C:I NW:I VDD:I VSS:I Y:O
Mmn3 Y n0 VSS VSS g45n1svt m=1 l=45n w=520n
Mmn0 n0 A VSS VSS g45n1svt m=1 l=45n w=145n
Mmn1 n0 B VSS VSS g45n1svt m=1 l=45n w=145n
Mmn2 n0 C VSS VSS g45n1svt m=1 l=45n w=145n
Mmp3 Y n0 VDD NW g45p1svt m=1 l=45n w=780n
Mmp1 n2 B n1 NW g45p1svt m=1 l=45n w=215n
Mmp2 n0 C n2 NW g45p1svt m=1 l=45n w=215n
Mmp0 n1 A VDD NW g45p1svt m=1 l=45n w=215n
.ENDS

.SUBCKT OR3X4 A B C NW VDD VSS Y
*.PININFO A:I B:I C:I NW:I VDD:I VSS:I Y:O
Mmn3 Y n0 VSS VSS g45n1svt m=1 l=45n w=1.04u
Mmn0 n0 A VSS VSS g45n1svt m=1 l=45n w=260n
Mmn1 n0 B VSS VSS g45n1svt m=1 l=45n w=260n
Mmn2 n0 C VSS VSS g45n1svt m=1 l=45n w=260n
Mmp3 Y n0 VDD NW g45p1svt m=1 l=45n w=1.56u
Mmp1 n2 B n1 NW g45p1svt m=1 l=45n w=390n
Mmp2 n0 C n2 NW g45p1svt m=1 l=45n w=390n
Mmp0 n1 A VDD NW g45p1svt m=1 l=45n w=390n
.ENDS

.SUBCKT OR3X6 A B C NW VDD VSS Y
*.PININFO A:I B:I C:I NW:I VDD:I VSS:I Y:O
Mmn3 Y n0 VSS VSS g45n1svt m=1 l=45n w=1.55u
Mmn0 n0 A VSS VSS g45n1svt m=1 l=45n w=520n
Mmn1 n0 B VSS VSS g45n1svt m=1 l=45n w=520n
Mmn2 n0 C VSS VSS g45n1svt m=1 l=45n w=520n
Mmp3 Y n0 VDD NW g45p1svt m=1 l=45n w=2.35u
Mmp1 n2 B n1 NW g45p1svt m=1 l=45n w=780n
Mmp2 n0 C n2 NW g45p1svt m=1 l=45n w=780n
Mmp0 n1 A VDD NW g45p1svt m=1 l=45n w=780n
.ENDS

.SUBCKT OR3X8 A B C NW VDD VSS Y
*.PININFO A:I B:I C:I NW:I VDD:I VSS:I Y:O
Mmn3 Y n0 VSS VSS g45n1svt m=1 l=45n w=2.065u
Mmn0 n0 A VSS VSS g45n1svt m=1 l=45n w=520n
Mmn1 n0 B VSS VSS g45n1svt m=1 l=45n w=520n
Mmn2 n0 C VSS VSS g45n1svt m=1 l=45n w=520n
Mmp3 Y n0 VDD NW g45p1svt m=1 l=45n w=3.115u
Mmp1 n2 B n1 NW g45p1svt m=1 l=45n w=780n
Mmp2 n0 C n2 NW g45p1svt m=1 l=45n w=780n
Mmp0 n1 A VDD NW g45p1svt m=1 l=45n w=780n
.ENDS

.SUBCKT OR3XL A B C NW VDD VSS Y
*.PININFO A:I B:I C:I NW:I VDD:I VSS:I Y:O
Mmn3 Y n0 VSS VSS g45n1svt m=1 l=45n w=145n
Mmn0 n0 A VSS VSS g45n1svt m=1 l=45n w=145n
Mmn1 n0 B VSS VSS g45n1svt m=1 l=45n w=145n
Mmn2 n0 C VSS VSS g45n1svt m=1 l=45n w=145n
Mmp3 Y n0 VDD NW g45p1svt m=1 l=45n w=215n
Mmp1 n2 B n1 NW g45p1svt m=1 l=45n w=215n
Mmp2 n0 C n2 NW g45p1svt m=1 l=45n w=215n
Mmp0 n1 A VDD NW g45p1svt m=1 l=45n w=215n
.ENDS

.SUBCKT OR4X1 A B C D NW VDD VSS Y
*.PININFO A:I B:I C:I D:I NW:I VDD:I VSS:I Y:O
Mmn4 Y n0 VSS VSS g45n1svt m=1 l=45n w=260n
Mmn3 n0 D VSS VSS g45n1svt m=1 l=45n w=145n
Mmn0 n0 A VSS VSS g45n1svt m=1 l=45n w=145n
Mmn2 n0 C VSS VSS g45n1svt m=1 l=45n w=145n
Mmn1 n0 B VSS VSS g45n1svt m=1 l=45n w=145n
Mmp4 Y n0 VDD NW g45p1svt m=1 l=45n w=390n
Mmp0 n1 A VDD NW g45p1svt m=1 l=45n w=215n
Mmp3 n0 D n3 NW g45p1svt m=1 l=45n w=215n
Mmp1 n2 B n1 NW g45p1svt m=1 l=45n w=215n
Mmp2 n3 C n2 NW g45p1svt m=1 l=45n w=215n
.ENDS

.SUBCKT OR4X2 A B C D NW VDD VSS Y
*.PININFO A:I B:I C:I D:I NW:I VDD:I VSS:I Y:O
Mmn4 Y n0 VSS VSS g45n1svt m=1 l=45n w=520n
Mmn3 n0 D VSS VSS g45n1svt m=1 l=45n w=145n
Mmn0 n0 A VSS VSS g45n1svt m=1 l=45n w=145n
Mmn2 n0 C VSS VSS g45n1svt m=1 l=45n w=145n
Mmn1 n0 B VSS VSS g45n1svt m=1 l=45n w=145n
Mmp4 Y n0 VDD NW g45p1svt m=1 l=45n w=780n
Mmp0 n1 A VDD NW g45p1svt m=1 l=45n w=215n
Mmp3 n0 D n3 NW g45p1svt m=1 l=45n w=215n
Mmp1 n2 B n1 NW g45p1svt m=1 l=45n w=215n
Mmp2 n3 C n2 NW g45p1svt m=1 l=45n w=215n
.ENDS

.SUBCKT OR4X4 A B C D NW VDD VSS Y
*.PININFO A:I B:I C:I D:I NW:I VDD:I VSS:I Y:O
Mmn4 Y n0 VSS VSS g45n1svt m=1 l=45n w=1.04u
Mmn3 n0 D VSS VSS g45n1svt m=1 l=45n w=260n
Mmn0 n0 A VSS VSS g45n1svt m=1 l=45n w=260n
Mmn2 n0 C VSS VSS g45n1svt m=1 l=45n w=260n
Mmn1 n0 B VSS VSS g45n1svt m=1 l=45n w=260n
Mmp4 Y n0 VDD NW g45p1svt m=1 l=45n w=1.56u
Mmp0 n1 A VDD NW g45p1svt m=1 l=45n w=390n
Mmp3 n0 D n3 NW g45p1svt m=1 l=45n w=390n
Mmp1 n2 B n1 NW g45p1svt m=1 l=45n w=390n
Mmp2 n3 C n2 NW g45p1svt m=1 l=45n w=390n
.ENDS

.SUBCKT OR4X6 A B C D NW VDD VSS Y
*.PININFO A:I B:I C:I D:I NW:I VDD:I VSS:I Y:O
Mmn4 Y n0 VSS VSS g45n1svt m=1 l=45n w=1.55u
Mmn3 n0 D VSS VSS g45n1svt m=1 l=45n w=520n
Mmn0 n0 A VSS VSS g45n1svt m=1 l=45n w=520n
Mmn2 n0 C VSS VSS g45n1svt m=1 l=45n w=520n
Mmn1 n0 B VSS VSS g45n1svt m=1 l=45n w=520n
Mmp4 Y n0 VDD NW g45p1svt m=1 l=45n w=2.35u
Mmp0 n1 A VDD NW g45p1svt m=1 l=45n w=780n
Mmp3 n0 D n3 NW g45p1svt m=1 l=45n w=780n
Mmp1 n2 B n1 NW g45p1svt m=1 l=45n w=780n
Mmp2 n3 C n2 NW g45p1svt m=1 l=45n w=780n
.ENDS

.SUBCKT OR4X8 A B C D NW VDD VSS Y
*.PININFO A:I B:I C:I D:I NW:I VDD:I VSS:I Y:O
Mmn4 Y n0 VSS VSS g45n1svt m=1 l=45n w=2.065u
Mmn3 n0 D VSS VSS g45n1svt m=1 l=45n w=520n
Mmn0 n0 A VSS VSS g45n1svt m=1 l=45n w=520n
Mmn2 n0 C VSS VSS g45n1svt m=1 l=45n w=520n
Mmn1 n0 B VSS VSS g45n1svt m=1 l=45n w=520n
Mmp4 Y n0 VDD NW g45p1svt m=1 l=45n w=3.115u
Mmp0 n1 A VDD NW g45p1svt m=1 l=45n w=780n
Mmp3 n0 D n3 NW g45p1svt m=1 l=45n w=780n
Mmp1 n2 B n1 NW g45p1svt m=1 l=45n w=780n
Mmp2 n3 C n2 NW g45p1svt m=1 l=45n w=780n
.ENDS

.SUBCKT OR4XL A B C D NW VDD VSS Y
*.PININFO A:I B:I C:I D:I NW:I VDD:I VSS:I Y:O
Mmn4 Y n0 VSS VSS g45n1svt m=1 l=45n w=145n
Mmn3 n0 D VSS VSS g45n1svt m=1 l=45n w=145n
Mmn0 n0 A VSS VSS g45n1svt m=1 l=45n w=145n
Mmn2 n0 C VSS VSS g45n1svt m=1 l=45n w=145n
Mmn1 n0 B VSS VSS g45n1svt m=1 l=45n w=145n
Mmp4 Y n0 VDD NW g45p1svt m=1 l=45n w=215n
Mmp0 n1 A VDD NW g45p1svt m=1 l=45n w=215n
Mmp3 n0 D n3 NW g45p1svt m=1 l=45n w=215n
Mmp1 n2 B n1 NW g45p1svt m=1 l=45n w=215n
Mmp2 n3 C n2 NW g45p1svt m=1 l=45n w=215n
.ENDS

.SUBCKT SDFFHQX1 CK D NW Q SE SI VDD VSS
*.PININFO CK:I D:I NW:I SE:I SI:I VDD:I VSS:I Q:O
Mmn13 net411 SI VSS VSS g45n1svt m=1 l=45n w=260n
Mmn14 Db SE net411 VSS g45n1svt m=1 l=45n w=260n
Mmn12 Db SEb net399 VSS g45n1svt m=1 l=45n w=260n
Mmn11 net399 D VSS VSS g45n1svt m=1 l=45n w=260n
Mmn55 Q qbint VSS VSS g45n1svt m=1 l=45n w=260n
Mmn50 net391 qbint VSS VSS g45n1svt m=1 l=45n w=205n
Mmn10 SEb SE VSS VSS g45n1svt m=1 l=45n w=145n
Mmn40 mout CKbb n30 VSS g45n1svt m=1 l=45n w=205n
Mmn35 net378 mout VSS VSS g45n1svt m=1 l=45n w=205n
Mmn36 n20 CKbb net378 VSS g45n1svt m=1 l=45n w=205n
Mmn20 CKb CK VSS VSS g45n1svt m=1 l=45n w=145n
Mmn51 n30 CKb net391 VSS g45n1svt m=1 l=45n w=205n
Mmn21 CKbb CKb VSS VSS g45n1svt m=1 l=45n w=145n
Mmn45 qbint n30 VSS VSS g45n1svt m=1 l=45n w=205n
Mmn25 n20 CKb Db VSS g45n1svt m=1 l=45n w=205n
Mmn30 mout n20 VSS VSS g45n1svt m=1 l=45n w=205n
Mmp14 Db SEb net350 NW g45p1svt m=1 l=45n w=390n
Mmp13 net350 SI VDD NW g45p1svt m=1 l=45n w=390n
Mmp12 Db SE net342 NW g45p1svt m=1 l=45n w=390n
Mmp11 net342 D VDD NW g45p1svt m=1 l=45n w=390n
Mmp51 n30 CKbb net334 NW g45p1svt m=1 l=45n w=310n
Mmp50 net334 qbint VDD NW g45p1svt m=1 l=45n w=310n
Mmp55 Q qbint VDD NW g45p1svt m=1 l=45n w=390n
Mmp35 net319 mout VDD NW g45p1svt m=1 l=45n w=310n
Mmp25 Db CKbb n20 NW g45p1svt m=1 l=45n w=310n
Mmp21 CKbb CKb VDD NW g45p1svt m=1 l=45n w=215n
Mmp30 mout n20 VDD NW g45p1svt m=1 l=45n w=310n
Mmp36 n20 CKb net319 NW g45p1svt m=1 l=45n w=310n
Mmp40 n30 CKb mout NW g45p1svt m=1 l=45n w=310n
Mmp10 SEb SE VDD NW g45p1svt m=1 l=45n w=215n
Mmp45 qbint n30 VDD NW g45p1svt m=1 l=45n w=310n
Mmp20 CKb CK VDD NW g45p1svt m=1 l=45n w=215n
.ENDS

.SUBCKT SDFFHQX2 CK D NW Q SE SI VDD VSS
*.PININFO CK:I D:I NW:I SE:I SI:I VDD:I VSS:I Q:O
Mmn13 net411 SI VSS VSS g45n1svt m=1 l=45n w=260n
Mmn14 Db SE net411 VSS g45n1svt m=1 l=45n w=260n
Mmn12 Db SEb net399 VSS g45n1svt m=1 l=45n w=260n
Mmn11 net399 D VSS VSS g45n1svt m=1 l=45n w=260n
Mmn55 Q qbint VSS VSS g45n1svt m=1 l=45n w=520n
Mmn50 net391 qbint VSS VSS g45n1svt m=1 l=45n w=205n
Mmn10 SEb SE VSS VSS g45n1svt m=1 l=45n w=145n
Mmn40 mout CKbb n30 VSS g45n1svt m=1 l=45n w=205n
Mmn35 net378 mout VSS VSS g45n1svt m=1 l=45n w=205n
Mmn36 n20 CKbb net378 VSS g45n1svt m=1 l=45n w=205n
Mmn20 CKb CK VSS VSS g45n1svt m=1 l=45n w=145n
Mmn51 n30 CKb net391 VSS g45n1svt m=1 l=45n w=205n
Mmn21 CKbb CKb VSS VSS g45n1svt m=1 l=45n w=145n
Mmn45 qbint n30 VSS VSS g45n1svt m=1 l=45n w=205n
Mmn25 n20 CKb Db VSS g45n1svt m=1 l=45n w=205n
Mmn30 mout n20 VSS VSS g45n1svt m=1 l=45n w=205n
Mmp14 Db SEb net350 NW g45p1svt m=1 l=45n w=390n
Mmp13 net350 SI VDD NW g45p1svt m=1 l=45n w=390n
Mmp12 Db SE net342 NW g45p1svt m=1 l=45n w=390n
Mmp11 net342 D VDD NW g45p1svt m=1 l=45n w=390n
Mmp51 n30 CKbb net334 NW g45p1svt m=1 l=45n w=310n
Mmp50 net334 qbint VDD NW g45p1svt m=1 l=45n w=310n
Mmp55 Q qbint VDD NW g45p1svt m=1 l=45n w=780n
Mmp35 net319 mout VDD NW g45p1svt m=1 l=45n w=310n
Mmp25 Db CKbb n20 NW g45p1svt m=1 l=45n w=310n
Mmp21 CKbb CKb VDD NW g45p1svt m=1 l=45n w=215n
Mmp30 mout n20 VDD NW g45p1svt m=1 l=45n w=310n
Mmp36 n20 CKb net319 NW g45p1svt m=1 l=45n w=310n
Mmp40 n30 CKb mout NW g45p1svt m=1 l=45n w=310n
Mmp10 SEb SE VDD NW g45p1svt m=1 l=45n w=215n
Mmp45 qbint n30 VDD NW g45p1svt m=1 l=45n w=310n
Mmp20 CKb CK VDD NW g45p1svt m=1 l=45n w=215n
.ENDS

.SUBCKT SDFFHQX4 CK D NW Q SE SI VDD VSS
*.PININFO CK:I D:I NW:I SE:I SI:I VDD:I VSS:I Q:O
Mmn13 net411 SI VSS VSS g45n1svt m=1 l=45n w=260n
Mmn14 Db SE net411 VSS g45n1svt m=1 l=45n w=260n
Mmn12 Db SEb net399 VSS g45n1svt m=1 l=45n w=260n
Mmn11 net399 D VSS VSS g45n1svt m=1 l=45n w=260n
Mmn55 Q qbint VSS VSS g45n1svt m=1 l=45n w=1.04u
Mmn50 net391 qbint VSS VSS g45n1svt m=1 l=45n w=205n
Mmn10 SEb SE VSS VSS g45n1svt m=1 l=45n w=145n
Mmn40 mout CKbb n30 VSS g45n1svt m=1 l=45n w=205n
Mmn35 net378 mout VSS VSS g45n1svt m=1 l=45n w=205n
Mmn36 n20 CKbb net378 VSS g45n1svt m=1 l=45n w=205n
Mmn20 CKb CK VSS VSS g45n1svt m=1 l=45n w=145n
Mmn51 n30 CKb net391 VSS g45n1svt m=1 l=45n w=205n
Mmn21 CKbb CKb VSS VSS g45n1svt m=1 l=45n w=145n
Mmn45 qbint n30 VSS VSS g45n1svt m=1 l=45n w=410n
Mmn25 n20 CKb Db VSS g45n1svt m=1 l=45n w=205n
Mmn30 mout n20 VSS VSS g45n1svt m=1 l=45n w=205n
Mmp14 Db SEb net350 NW g45p1svt m=1 l=45n w=390n
Mmp13 net350 SI VDD NW g45p1svt m=1 l=45n w=390n
Mmp12 Db SE net342 NW g45p1svt m=1 l=45n w=390n
Mmp11 net342 D VDD NW g45p1svt m=1 l=45n w=390n
Mmp51 n30 CKbb net334 NW g45p1svt m=1 l=45n w=310n
Mmp50 net334 qbint VDD NW g45p1svt m=1 l=45n w=310n
Mmp55 Q qbint VDD NW g45p1svt m=1 l=45n w=1.56u
Mmp35 net319 mout VDD NW g45p1svt m=1 l=45n w=310n
Mmp25 Db CKbb n20 NW g45p1svt m=1 l=45n w=310n
Mmp21 CKbb CKb VDD NW g45p1svt m=1 l=45n w=215n
Mmp30 mout n20 VDD NW g45p1svt m=1 l=45n w=310n
Mmp36 n20 CKb net319 NW g45p1svt m=1 l=45n w=310n
Mmp40 n30 CKb mout NW g45p1svt m=1 l=45n w=310n
Mmp10 SEb SE VDD NW g45p1svt m=1 l=45n w=215n
Mmp45 qbint n30 VDD NW g45p1svt m=1 l=45n w=620n
Mmp20 CKb CK VDD NW g45p1svt m=1 l=45n w=215n
.ENDS

.SUBCKT SDFFHQX8 CK D NW Q SE SI VDD VSS
*.PININFO CK:I D:I NW:I SE:I SI:I VDD:I VSS:I Q:O
Mmn13 net411 SI VSS VSS g45n1svt m=1 l=45n w=260n
Mmn14 Db SE net411 VSS g45n1svt m=1 l=45n w=260n
Mmn12 Db SEb net399 VSS g45n1svt m=1 l=45n w=260n
Mmn11 net399 D VSS VSS g45n1svt m=1 l=45n w=260n
Mmn55 Q qbint VSS VSS g45n1svt m=1 l=45n w=2.065u
Mmn50 net391 qbint VSS VSS g45n1svt m=1 l=45n w=205n
Mmn10 SEb SE VSS VSS g45n1svt m=1 l=45n w=145n
Mmn40 mout CKbb n30 VSS g45n1svt m=1 l=45n w=205n
Mmn35 net378 mout VSS VSS g45n1svt m=1 l=45n w=205n
Mmn36 n20 CKbb net378 VSS g45n1svt m=1 l=45n w=205n
Mmn20 CKb CK VSS VSS g45n1svt m=1 l=45n w=145n
Mmn51 n30 CKb net391 VSS g45n1svt m=1 l=45n w=205n
Mmn21 CKbb CKb VSS VSS g45n1svt m=1 l=45n w=145n
Mmn45 qbint n30 VSS VSS g45n1svt m=1 l=45n w=780n
Mmn25 n20 CKb Db VSS g45n1svt m=1 l=45n w=205n
Mmn30 mout n20 VSS VSS g45n1svt m=1 l=45n w=205n
Mmp14 Db SEb net350 NW g45p1svt m=1 l=45n w=390n
Mmp13 net350 SI VDD NW g45p1svt m=1 l=45n w=390n
Mmp12 Db SE net342 NW g45p1svt m=1 l=45n w=390n
Mmp11 net342 D VDD NW g45p1svt m=1 l=45n w=390n
Mmp51 n30 CKbb net334 NW g45p1svt m=1 l=45n w=310n
Mmp50 net334 qbint VDD NW g45p1svt m=1 l=45n w=310n
Mmp55 Q qbint VDD NW g45p1svt m=1 l=45n w=3.115u
Mmp35 net319 mout VDD NW g45p1svt m=1 l=45n w=310n
Mmp25 Db CKbb n20 NW g45p1svt m=1 l=45n w=310n
Mmp21 CKbb CKb VDD NW g45p1svt m=1 l=45n w=215n
Mmp30 mout n20 VDD NW g45p1svt m=1 l=45n w=310n
Mmp36 n20 CKb net319 NW g45p1svt m=1 l=45n w=310n
Mmp40 n30 CKb mout NW g45p1svt m=1 l=45n w=310n
Mmp10 SEb SE VDD NW g45p1svt m=1 l=45n w=215n
Mmp45 qbint n30 VDD NW g45p1svt m=1 l=45n w=1.17u
Mmp20 CKb CK VDD NW g45p1svt m=1 l=45n w=215n
.ENDS

.SUBCKT SDFFNSRX1 CKN D NW Q QN RN SE SI SN VDD VSS
*.PININFO CKN:I D:I NW:I RN:I SE:I SI:I SN:I VDD:I VSS:I Q:O QN:O
Mmn13 net538 SI VSS VSS g45n1svt m=1 l=45n w=145n
Mmn14 Db SE net538 VSS g45n1svt m=1 l=45n w=145n
Mmn12 Db SEb net546 VSS g45n1svt m=1 l=45n w=145n
Mmn11 net546 D VSS VSS g45n1svt m=1 l=45n w=145n
Mmn57 QN qint VSS VSS g45n1svt m=1 l=45n w=260n
Mmn55 Q qbint VSS VSS g45n1svt m=1 l=45n w=260n
Mmn36 n20 CKNb net582 VSS g45n1svt m=1 l=45n w=145n
Mmn35 net582 mout VSS VSS g45n1svt m=1 l=45n w=145n
Mmn22 RNb RN VSS VSS g45n1svt m=1 l=45n w=145n
Mmn20 CKNb CKN VSS VSS g45n1svt m=1 l=45n w=145n
Mmn10 SEb SE VSS VSS g45n1svt m=1 l=45n w=145n
Mmn31 mout RNb net521 VSS g45n1svt m=1 l=45n w=145n
Mmn51 net0363 RNb net498 VSS g45n1svt m=1 l=45n w=145n
Mmn25 Db CKNbb n20 VSS g45n1svt m=1 l=45n w=145n
Mmn30 net521 SN VSS VSS g45n1svt m=1 l=45n w=145n
Mmn21 CKNbb CKNb VSS VSS g45n1svt m=1 l=45n w=145n
Mmn45 qbint n35 VSS VSS g45n1svt m=1 l=45n w=145n
Mmn50 net498 SN VSS VSS g45n1svt m=1 l=45n w=145n
Mmn32 mout n20 net521 VSS g45n1svt m=1 l=45n w=145n
Mmn56 qint qbint VSS VSS g45n1svt m=1 l=45n w=145n
Mmn53 n35 CKNbb net0363 VSS g45n1svt m=1 l=45n w=145n
Mmn52 net0363 qbint net498 VSS g45n1svt m=1 l=45n w=145n
Mmn40 mout CKNb n35 VSS g45n1svt m=1 l=45n w=145n
Mmp14 Db SEb net453 NW g45p1svt m=1 l=45n w=215n
Mmp13 net453 SI VDD NW g45p1svt m=1 l=45n w=215n
Mmp12 Db SE net461 NW g45p1svt m=1 l=45n w=215n
Mmp11 net461 D VDD NW g45p1svt m=1 l=45n w=215n
Mmp52 net566 qbint net414 NW g45p1svt m=1 l=45n w=215n
Mmp51 net414 RNb VDD NW g45p1svt m=1 l=45n w=215n
Mmp57 QN qint VDD NW g45p1svt m=1 l=45n w=390n
Mmp55 Q qbint VDD NW g45p1svt m=1 l=45n w=390n
Mmp36 n20 CKNbb net486 NW g45p1svt m=1 l=45n w=215n
Mmp35 net486 mout VDD NW g45p1svt m=1 l=45n w=215n
Mmp32 mout n20 net478 NW g45p1svt m=1 l=45n w=215n
Mmp31 net478 RNb VDD NW g45p1svt m=1 l=45n w=215n
Mmp22 RNb RN VDD NW g45p1svt m=1 l=45n w=215n
Mmp20 CKNb CKN VDD NW g45p1svt m=1 l=45n w=215n
Mmp53 n35 CKNb net566 NW g45p1svt m=1 l=45n w=215n
Mmp56 qint qbint VDD NW g45p1svt m=1 l=45n w=215n
Mmp21 CKNbb CKNb VDD NW g45p1svt m=1 l=45n w=215n
Mmp25 n20 CKNb Db NW g45p1svt m=1 l=45n w=215n
Mmp50 net566 SN VDD NW g45p1svt m=1 l=45n w=215n
Mmp10 SEb SE VDD NW g45p1svt m=1 l=45n w=215n
Mmp45 qbint n35 VDD NW g45p1svt m=1 l=45n w=215n
Mmp40 n35 CKNbb mout NW g45p1svt m=1 l=45n w=215n
Mmp30 mout SN VDD NW g45p1svt m=1 l=45n w=215n
.ENDS

.SUBCKT SDFFNSRX2 CKN D NW Q QN RN SE SI SN VDD VSS
*.PININFO CKN:I D:I NW:I RN:I SE:I SI:I SN:I VDD:I VSS:I Q:O QN:O
Mmn13 net538 SI VSS VSS g45n1svt m=1 l=45n w=145n
Mmn14 Db SE net538 VSS g45n1svt m=1 l=45n w=145n
Mmn12 Db SEb net546 VSS g45n1svt m=1 l=45n w=145n
Mmn11 net546 D VSS VSS g45n1svt m=1 l=45n w=145n
Mmn57 QN qint VSS VSS g45n1svt m=1 l=45n w=520n
Mmn55 Q qbint VSS VSS g45n1svt m=1 l=45n w=520n
Mmn36 n20 CKNb net582 VSS g45n1svt m=1 l=45n w=145n
Mmn35 net582 mout VSS VSS g45n1svt m=1 l=45n w=145n
Mmn22 RNb RN VSS VSS g45n1svt m=1 l=45n w=145n
Mmn20 CKNb CKN VSS VSS g45n1svt m=1 l=45n w=145n
Mmn10 SEb SE VSS VSS g45n1svt m=1 l=45n w=145n
Mmn31 mout RNb net521 VSS g45n1svt m=1 l=45n w=145n
Mmn51 net0363 RNb net498 VSS g45n1svt m=1 l=45n w=145n
Mmn25 Db CKNbb n20 VSS g45n1svt m=1 l=45n w=145n
Mmn30 net521 SN VSS VSS g45n1svt m=1 l=45n w=145n
Mmn21 CKNbb CKNb VSS VSS g45n1svt m=1 l=45n w=145n
Mmn45 qbint n35 VSS VSS g45n1svt m=1 l=45n w=205n
Mmn50 net498 SN VSS VSS g45n1svt m=1 l=45n w=145n
Mmn32 mout n20 net521 VSS g45n1svt m=1 l=45n w=145n
Mmn56 qint qbint VSS VSS g45n1svt m=1 l=45n w=145n
Mmn53 n35 CKNbb net0363 VSS g45n1svt m=1 l=45n w=145n
Mmn52 net0363 qbint net498 VSS g45n1svt m=1 l=45n w=145n
Mmn40 mout CKNb n35 VSS g45n1svt m=1 l=45n w=145n
Mmp14 Db SEb net453 NW g45p1svt m=1 l=45n w=215n
Mmp13 net453 SI VDD NW g45p1svt m=1 l=45n w=215n
Mmp12 Db SE net461 NW g45p1svt m=1 l=45n w=215n
Mmp11 net461 D VDD NW g45p1svt m=1 l=45n w=215n
Mmp52 net566 qbint net414 NW g45p1svt m=1 l=45n w=215n
Mmp51 net414 RNb VDD NW g45p1svt m=1 l=45n w=215n
Mmp57 QN qint VDD NW g45p1svt m=1 l=45n w=780n
Mmp55 Q qbint VDD NW g45p1svt m=1 l=45n w=780n
Mmp36 n20 CKNbb net486 NW g45p1svt m=1 l=45n w=215n
Mmp35 net486 mout VDD NW g45p1svt m=1 l=45n w=215n
Mmp32 mout n20 net478 NW g45p1svt m=1 l=45n w=215n
Mmp31 net478 RNb VDD NW g45p1svt m=1 l=45n w=215n
Mmp22 RNb RN VDD NW g45p1svt m=1 l=45n w=215n
Mmp20 CKNb CKN VDD NW g45p1svt m=1 l=45n w=215n
Mmp53 n35 CKNb net566 NW g45p1svt m=1 l=45n w=215n
Mmp56 qint qbint VDD NW g45p1svt m=1 l=45n w=215n
Mmp21 CKNbb CKNb VDD NW g45p1svt m=1 l=45n w=215n
Mmp25 n20 CKNb Db NW g45p1svt m=1 l=45n w=215n
Mmp50 net566 SN VDD NW g45p1svt m=1 l=45n w=215n
Mmp10 SEb SE VDD NW g45p1svt m=1 l=45n w=215n
Mmp45 qbint n35 VDD NW g45p1svt m=1 l=45n w=310n
Mmp40 n35 CKNbb mout NW g45p1svt m=1 l=45n w=215n
Mmp30 mout SN VDD NW g45p1svt m=1 l=45n w=215n
.ENDS

.SUBCKT SDFFNSRX4 CKN D NW Q QN RN SE SI SN VDD VSS
*.PININFO CKN:I D:I NW:I RN:I SE:I SI:I SN:I VDD:I VSS:I Q:O QN:O
Mmn13 net538 SI VSS VSS g45n1svt m=1 l=45n w=145n
Mmn14 Db SE net538 VSS g45n1svt m=1 l=45n w=145n
Mmn12 Db SEb net546 VSS g45n1svt m=1 l=45n w=145n
Mmn11 net546 D VSS VSS g45n1svt m=1 l=45n w=145n
Mmn57 QN qint VSS VSS g45n1svt m=1 l=45n w=1.04u
Mmn55 Q qbint VSS VSS g45n1svt m=1 l=45n w=1.04u
Mmn36 n20 CKNb net582 VSS g45n1svt m=1 l=45n w=145n
Mmn35 net582 mout VSS VSS g45n1svt m=1 l=45n w=145n
Mmn22 RNb RN VSS VSS g45n1svt m=1 l=45n w=145n
Mmn20 CKNb CKN VSS VSS g45n1svt m=1 l=45n w=145n
Mmn10 SEb SE VSS VSS g45n1svt m=1 l=45n w=145n
Mmn31 mout RNb net521 VSS g45n1svt m=1 l=45n w=145n
Mmn51 net0363 RNb net498 VSS g45n1svt m=1 l=45n w=145n
Mmn25 Db CKNbb n20 VSS g45n1svt m=1 l=45n w=145n
Mmn30 net521 SN VSS VSS g45n1svt m=1 l=45n w=145n
Mmn21 CKNbb CKNb VSS VSS g45n1svt m=1 l=45n w=145n
Mmn45 qbint n35 VSS VSS g45n1svt m=1 l=45n w=410n
Mmn50 net498 SN VSS VSS g45n1svt m=1 l=45n w=145n
Mmn32 mout n20 net521 VSS g45n1svt m=1 l=45n w=145n
Mmn56 qint qbint VSS VSS g45n1svt m=1 l=45n w=260n
Mmn53 n35 CKNbb net0363 VSS g45n1svt m=1 l=45n w=145n
Mmn52 net0363 qbint net498 VSS g45n1svt m=1 l=45n w=145n
Mmn40 mout CKNb n35 VSS g45n1svt m=1 l=45n w=145n
Mmp14 Db SEb net453 NW g45p1svt m=1 l=45n w=215n
Mmp13 net453 SI VDD NW g45p1svt m=1 l=45n w=215n
Mmp12 Db SE net461 NW g45p1svt m=1 l=45n w=215n
Mmp11 net461 D VDD NW g45p1svt m=1 l=45n w=215n
Mmp52 net566 qbint net414 NW g45p1svt m=1 l=45n w=215n
Mmp51 net414 RNb VDD NW g45p1svt m=1 l=45n w=215n
Mmp57 QN qint VDD NW g45p1svt m=1 l=45n w=1.56u
Mmp55 Q qbint VDD NW g45p1svt m=1 l=45n w=1.56u
Mmp36 n20 CKNbb net486 NW g45p1svt m=1 l=45n w=215n
Mmp35 net486 mout VDD NW g45p1svt m=1 l=45n w=215n
Mmp32 mout n20 net478 NW g45p1svt m=1 l=45n w=215n
Mmp31 net478 RNb VDD NW g45p1svt m=1 l=45n w=215n
Mmp22 RNb RN VDD NW g45p1svt m=1 l=45n w=215n
Mmp20 CKNb CKN VDD NW g45p1svt m=1 l=45n w=215n
Mmp53 n35 CKNb net566 NW g45p1svt m=1 l=45n w=215n
Mmp56 qint qbint VDD NW g45p1svt m=1 l=45n w=390n
Mmp21 CKNbb CKNb VDD NW g45p1svt m=1 l=45n w=215n
Mmp25 n20 CKNb Db NW g45p1svt m=1 l=45n w=215n
Mmp50 net566 SN VDD NW g45p1svt m=1 l=45n w=215n
Mmp10 SEb SE VDD NW g45p1svt m=1 l=45n w=215n
Mmp45 qbint n35 VDD NW g45p1svt m=1 l=45n w=620n
Mmp40 n35 CKNbb mout NW g45p1svt m=1 l=45n w=215n
Mmp30 mout SN VDD NW g45p1svt m=1 l=45n w=215n
.ENDS

.SUBCKT SDFFNSRXL CKN D NW Q QN RN SE SI SN VDD VSS
*.PININFO CKN:I D:I NW:I RN:I SE:I SI:I SN:I VDD:I VSS:I Q:O QN:O
Mmn13 net538 SI VSS VSS g45n1svt m=1 l=45n w=145n
Mmn14 Db SE net538 VSS g45n1svt m=1 l=45n w=145n
Mmn12 Db SEb net546 VSS g45n1svt m=1 l=45n w=145n
Mmn11 net546 D VSS VSS g45n1svt m=1 l=45n w=145n
Mmn57 QN qint VSS VSS g45n1svt m=1 l=45n w=145n
Mmn55 Q qbint VSS VSS g45n1svt m=1 l=45n w=145n
Mmn36 n20 CKNb net582 VSS g45n1svt m=1 l=45n w=145n
Mmn35 net582 mout VSS VSS g45n1svt m=1 l=45n w=145n
Mmn22 RNb RN VSS VSS g45n1svt m=1 l=45n w=145n
Mmn20 CKNb CKN VSS VSS g45n1svt m=1 l=45n w=145n
Mmn10 SEb SE VSS VSS g45n1svt m=1 l=45n w=145n
Mmn31 mout RNb net521 VSS g45n1svt m=1 l=45n w=145n
Mmn51 net0363 RNb net498 VSS g45n1svt m=1 l=45n w=145n
Mmn25 Db CKNbb n20 VSS g45n1svt m=1 l=45n w=145n
Mmn30 net521 SN VSS VSS g45n1svt m=1 l=45n w=145n
Mmn21 CKNbb CKNb VSS VSS g45n1svt m=1 l=45n w=145n
Mmn45 qbint n35 VSS VSS g45n1svt m=1 l=45n w=145n
Mmn50 net498 SN VSS VSS g45n1svt m=1 l=45n w=145n
Mmn32 mout n20 net521 VSS g45n1svt m=1 l=45n w=145n
Mmn56 qint qbint VSS VSS g45n1svt m=1 l=45n w=145n
Mmn53 n35 CKNbb net0363 VSS g45n1svt m=1 l=45n w=145n
Mmn52 net0363 qbint net498 VSS g45n1svt m=1 l=45n w=145n
Mmn40 mout CKNb n35 VSS g45n1svt m=1 l=45n w=145n
Mmp14 Db SEb net453 NW g45p1svt m=1 l=45n w=215n
Mmp13 net453 SI VDD NW g45p1svt m=1 l=45n w=215n
Mmp12 Db SE net461 NW g45p1svt m=1 l=45n w=215n
Mmp11 net461 D VDD NW g45p1svt m=1 l=45n w=215n
Mmp52 net566 qbint net414 NW g45p1svt m=1 l=45n w=215n
Mmp51 net414 RNb VDD NW g45p1svt m=1 l=45n w=215n
Mmp57 QN qint VDD NW g45p1svt m=1 l=45n w=215n
Mmp55 Q qbint VDD NW g45p1svt m=1 l=45n w=215n
Mmp36 n20 CKNbb net486 NW g45p1svt m=1 l=45n w=215n
Mmp35 net486 mout VDD NW g45p1svt m=1 l=45n w=215n
Mmp32 mout n20 net478 NW g45p1svt m=1 l=45n w=215n
Mmp31 net478 RNb VDD NW g45p1svt m=1 l=45n w=215n
Mmp22 RNb RN VDD NW g45p1svt m=1 l=45n w=215n
Mmp20 CKNb CKN VDD NW g45p1svt m=1 l=45n w=215n
Mmp53 n35 CKNb net566 NW g45p1svt m=1 l=45n w=215n
Mmp56 qint qbint VDD NW g45p1svt m=1 l=45n w=215n
Mmp21 CKNbb CKNb VDD NW g45p1svt m=1 l=45n w=215n
Mmp25 n20 CKNb Db NW g45p1svt m=1 l=45n w=215n
Mmp50 net566 SN VDD NW g45p1svt m=1 l=45n w=215n
Mmp10 SEb SE VDD NW g45p1svt m=1 l=45n w=215n
Mmp45 qbint n35 VDD NW g45p1svt m=1 l=45n w=215n
Mmp40 n35 CKNbb mout NW g45p1svt m=1 l=45n w=215n
Mmp30 mout SN VDD NW g45p1svt m=1 l=45n w=215n
.ENDS

.SUBCKT SDFFQX1 CK D NW Q SE SI VDD VSS
*.PININFO CK:I D:I NW:I SE:I SI:I VDD:I VSS:I Q:O
Mmn13 n3 SI VSS VSS g45n1svt m=1 l=45n w=145n
Mmn14 Db SE n3 VSS g45n1svt m=1 l=45n w=145n
Mmn12 Db SEb n1 VSS g45n1svt m=1 l=45n w=145n
Mmn11 n1 D VSS VSS g45n1svt m=1 l=45n w=145n
Mmn55 Q qbint VSS VSS g45n1svt m=1 l=45n w=260n
Mmn50 n7 qbint VSS VSS g45n1svt m=1 l=45n w=145n
Mmn10 SEb SE VSS VSS g45n1svt m=1 l=45n w=145n
Mmn40 mout CKbb n30 VSS g45n1svt m=1 l=45n w=145n
Mmn35 n20 CKbb n5 VSS g45n1svt m=1 l=45n w=145n
Mmn36 n5 mout VSS VSS g45n1svt m=1 l=45n w=145n
Mmn20 CKb CK VSS VSS g45n1svt m=1 l=45n w=145n
Mmn51 n30 CKb n7 VSS g45n1svt m=1 l=45n w=145n
Mmn21 CKbb CKb VSS VSS g45n1svt m=1 l=45n w=145n
Mmn45 qbint n30 VSS VSS g45n1svt m=1 l=45n w=145n
Mmn25 Db CKb n20 VSS g45n1svt m=1 l=45n w=145n
Mmn30 mout n20 VSS VSS g45n1svt m=1 l=45n w=145n
Mmp14 Db SEb n4 NW g45p1svt m=1 l=45n w=215n
Mmp13 n4 SI VDD NW g45p1svt m=1 l=45n w=215n
Mmp12 Db SE n2 NW g45p1svt m=1 l=45n w=215n
Mmp11 n2 D VDD NW g45p1svt m=1 l=45n w=215n
Mmp51 n30 CKbb n8 NW g45p1svt m=1 l=45n w=215n
Mmp50 n8 qbint VDD NW g45p1svt m=1 l=45n w=215n
Mmp55 Q qbint VDD NW g45p1svt m=1 l=45n w=390n
Mmp35 n6 mout VDD NW g45p1svt m=1 l=45n w=215n
Mmp25 n20 CKbb Db NW g45p1svt m=1 l=45n w=215n
Mmp21 CKbb CKb VDD NW g45p1svt m=1 l=45n w=215n
Mmp30 mout n20 VDD NW g45p1svt m=1 l=45n w=215n
Mmp36 n20 CKb n6 NW g45p1svt m=1 l=45n w=215n
Mmp40 n30 CKb mout NW g45p1svt m=1 l=45n w=215n
Mmp10 SEb SE VDD NW g45p1svt m=1 l=45n w=215n
Mmp45 qbint n30 VDD NW g45p1svt m=1 l=45n w=215n
Mmp20 CKb CK VDD NW g45p1svt m=1 l=45n w=215n
.ENDS

.SUBCKT SDFFQX2 CK D NW Q SE SI VDD VSS
*.PININFO CK:I D:I NW:I SE:I SI:I VDD:I VSS:I Q:O
Mmn13 n3 SI VSS VSS g45n1svt m=1 l=45n w=145n
Mmn14 Db SE n3 VSS g45n1svt m=1 l=45n w=145n
Mmn12 Db SEb n1 VSS g45n1svt m=1 l=45n w=145n
Mmn11 n1 D VSS VSS g45n1svt m=1 l=45n w=145n
Mmn55 Q qbint VSS VSS g45n1svt m=1 l=45n w=520n
Mmn50 n7 qbint VSS VSS g45n1svt m=1 l=45n w=145n
Mmn10 SEb SE VSS VSS g45n1svt m=1 l=45n w=145n
Mmn40 mout CKbb n30 VSS g45n1svt m=1 l=45n w=145n
Mmn35 n20 CKbb n5 VSS g45n1svt m=1 l=45n w=145n
Mmn36 n5 mout VSS VSS g45n1svt m=1 l=45n w=145n
Mmn20 CKb CK VSS VSS g45n1svt m=1 l=45n w=145n
Mmn51 n30 CKb n7 VSS g45n1svt m=1 l=45n w=145n
Mmn21 CKbb CKb VSS VSS g45n1svt m=1 l=45n w=145n
Mmn45 qbint n30 VSS VSS g45n1svt m=1 l=45n w=205n
Mmn25 Db CKb n20 VSS g45n1svt m=1 l=45n w=145n
Mmn30 mout n20 VSS VSS g45n1svt m=1 l=45n w=145n
Mmp14 Db SEb n4 NW g45p1svt m=1 l=45n w=215n
Mmp13 n4 SI VDD NW g45p1svt m=1 l=45n w=215n
Mmp12 Db SE n2 NW g45p1svt m=1 l=45n w=215n
Mmp11 n2 D VDD NW g45p1svt m=1 l=45n w=215n
Mmp51 n30 CKbb n8 NW g45p1svt m=1 l=45n w=215n
Mmp50 n8 qbint VDD NW g45p1svt m=1 l=45n w=215n
Mmp55 Q qbint VDD NW g45p1svt m=1 l=45n w=780n
Mmp35 n6 mout VDD NW g45p1svt m=1 l=45n w=215n
Mmp25 n20 CKbb Db NW g45p1svt m=1 l=45n w=215n
Mmp21 CKbb CKb VDD NW g45p1svt m=1 l=45n w=215n
Mmp30 mout n20 VDD NW g45p1svt m=1 l=45n w=215n
Mmp36 n20 CKb n6 NW g45p1svt m=1 l=45n w=215n
Mmp40 n30 CKb mout NW g45p1svt m=1 l=45n w=215n
Mmp10 SEb SE VDD NW g45p1svt m=1 l=45n w=215n
Mmp45 qbint n30 VDD NW g45p1svt m=1 l=45n w=310n
Mmp20 CKb CK VDD NW g45p1svt m=1 l=45n w=215n
.ENDS

.SUBCKT SDFFQX4 CK D NW Q SE SI VDD VSS
*.PININFO CK:I D:I NW:I SE:I SI:I VDD:I VSS:I Q:O
Mmn13 n3 SI VSS VSS g45n1svt m=1 l=45n w=145n
Mmn14 Db SE n3 VSS g45n1svt m=1 l=45n w=145n
Mmn12 Db SEb n1 VSS g45n1svt m=1 l=45n w=145n
Mmn11 n1 D VSS VSS g45n1svt m=1 l=45n w=145n
Mmn55 Q qbint VSS VSS g45n1svt m=1 l=45n w=1.04u
Mmn50 n7 qbint VSS VSS g45n1svt m=1 l=45n w=145n
Mmn10 SEb SE VSS VSS g45n1svt m=1 l=45n w=145n
Mmn40 mout CKbb n30 VSS g45n1svt m=1 l=45n w=145n
Mmn35 n20 CKbb n5 VSS g45n1svt m=1 l=45n w=145n
Mmn36 n5 mout VSS VSS g45n1svt m=1 l=45n w=145n
Mmn20 CKb CK VSS VSS g45n1svt m=1 l=45n w=145n
Mmn51 n30 CKb n7 VSS g45n1svt m=1 l=45n w=145n
Mmn21 CKbb CKb VSS VSS g45n1svt m=1 l=45n w=145n
Mmn45 qbint n30 VSS VSS g45n1svt m=1 l=45n w=410n
Mmn25 Db CKb n20 VSS g45n1svt m=1 l=45n w=145n
Mmn30 mout n20 VSS VSS g45n1svt m=1 l=45n w=145n
Mmp14 Db SEb n4 NW g45p1svt m=1 l=45n w=215n
Mmp13 n4 SI VDD NW g45p1svt m=1 l=45n w=215n
Mmp12 Db SE n2 NW g45p1svt m=1 l=45n w=215n
Mmp11 n2 D VDD NW g45p1svt m=1 l=45n w=215n
Mmp51 n30 CKbb n8 NW g45p1svt m=1 l=45n w=215n
Mmp50 n8 qbint VDD NW g45p1svt m=1 l=45n w=215n
Mmp55 Q qbint VDD NW g45p1svt m=1 l=45n w=1.56u
Mmp35 n6 mout VDD NW g45p1svt m=1 l=45n w=215n
Mmp25 n20 CKbb Db NW g45p1svt m=1 l=45n w=215n
Mmp21 CKbb CKb VDD NW g45p1svt m=1 l=45n w=215n
Mmp30 mout n20 VDD NW g45p1svt m=1 l=45n w=215n
Mmp36 n20 CKb n6 NW g45p1svt m=1 l=45n w=215n
Mmp40 n30 CKb mout NW g45p1svt m=1 l=45n w=215n
Mmp10 SEb SE VDD NW g45p1svt m=1 l=45n w=215n
Mmp45 qbint n30 VDD NW g45p1svt m=1 l=45n w=620n
Mmp20 CKb CK VDD NW g45p1svt m=1 l=45n w=215n
.ENDS

.SUBCKT SDFFQXL CK D NW Q SE SI VDD VSS
*.PININFO CK:I D:I NW:I SE:I SI:I VDD:I VSS:I Q:O
Mmn13 n3 SI VSS VSS g45n1svt m=1 l=45n w=145n
Mmn14 Db SE n3 VSS g45n1svt m=1 l=45n w=145n
Mmn12 Db SEb n1 VSS g45n1svt m=1 l=45n w=145n
Mmn11 n1 D VSS VSS g45n1svt m=1 l=45n w=145n
Mmn55 Q qbint VSS VSS g45n1svt m=1 l=45n w=145n
Mmn50 n7 qbint VSS VSS g45n1svt m=1 l=45n w=145n
Mmn10 SEb SE VSS VSS g45n1svt m=1 l=45n w=145n
Mmn40 mout CKbb n30 VSS g45n1svt m=1 l=45n w=145n
Mmn35 n20 CKbb n5 VSS g45n1svt m=1 l=45n w=145n
Mmn36 n5 mout VSS VSS g45n1svt m=1 l=45n w=145n
Mmn20 CKb CK VSS VSS g45n1svt m=1 l=45n w=145n
Mmn51 n30 CKb n7 VSS g45n1svt m=1 l=45n w=145n
Mmn21 CKbb CKb VSS VSS g45n1svt m=1 l=45n w=145n
Mmn45 qbint n30 VSS VSS g45n1svt m=1 l=45n w=145n
Mmn25 Db CKb n20 VSS g45n1svt m=1 l=45n w=145n
Mmn30 mout n20 VSS VSS g45n1svt m=1 l=45n w=145n
Mmp14 Db SEb n4 NW g45p1svt m=1 l=45n w=215n
Mmp13 n4 SI VDD NW g45p1svt m=1 l=45n w=215n
Mmp12 Db SE n2 NW g45p1svt m=1 l=45n w=215n
Mmp11 n2 D VDD NW g45p1svt m=1 l=45n w=215n
Mmp51 n30 CKbb n8 NW g45p1svt m=1 l=45n w=215n
Mmp50 n8 qbint VDD NW g45p1svt m=1 l=45n w=215n
Mmp55 Q qbint VDD NW g45p1svt m=1 l=45n w=215n
Mmp35 n6 mout VDD NW g45p1svt m=1 l=45n w=215n
Mmp25 n20 CKbb Db NW g45p1svt m=1 l=45n w=215n
Mmp21 CKbb CKb VDD NW g45p1svt m=1 l=45n w=215n
Mmp30 mout n20 VDD NW g45p1svt m=1 l=45n w=215n
Mmp36 n20 CKb n6 NW g45p1svt m=1 l=45n w=215n
Mmp40 n30 CKb mout NW g45p1svt m=1 l=45n w=215n
Mmp10 SEb SE VDD NW g45p1svt m=1 l=45n w=215n
Mmp45 qbint n30 VDD NW g45p1svt m=1 l=45n w=215n
Mmp20 CKb CK VDD NW g45p1svt m=1 l=45n w=215n
.ENDS

.SUBCKT SDFFRHQX1 CK D NW Q RN SE SI VDD VSS
*.PININFO CK:I D:I NW:I RN:I SE:I SI:I VDD:I VSS:I Q:O
Mmn36 net422 mout net426 VSS g45n1svt m=1 l=45n w=205n
Mmn35 net426 RN VSS VSS g45n1svt m=1 l=45n w=205n
Mmn37 n20 CKbb net422 VSS g45n1svt m=1 l=45n w=205n
Mmn13 net442 SI VSS VSS g45n1svt m=1 l=45n w=260n
Mmn14 Db SE net442 VSS g45n1svt m=1 l=45n w=260n
Mmn12 Db SEb net450 VSS g45n1svt m=1 l=45n w=260n
Mmn11 net450 D VSS VSS g45n1svt m=1 l=45n w=260n
Mmn55 Q qbint VSS VSS g45n1svt m=1 l=45n w=260n
Mmn45 net337 RN VSS VSS g45n1svt m=1 l=45n w=205n
Mmn46 qbint n30 net337 VSS g45n1svt m=1 l=45n w=205n
Mmn51 n30 CKb net405 VSS g45n1svt m=1 l=45n w=205n
Mmn50 net405 qbint VSS VSS g45n1svt m=1 l=45n w=205n
Mmn20 CKb CK VSS VSS g45n1svt m=1 l=45n w=145n
Mmn40 n30 CKbb mout VSS g45n1svt m=1 l=45n w=205n
Mmn30 mout n20 VSS VSS g45n1svt m=1 l=45n w=205n
Mmn21 CKbb CKb VSS VSS g45n1svt m=1 l=45n w=145n
Mmn10 SEb SE VSS VSS g45n1svt m=1 l=45n w=145n
Mmn25 n20 CKb Db VSS g45n1svt m=1 l=45n w=205n
Mmp14 Db SEb net373 NW g45p1svt m=1 l=45n w=390n
Mmp13 net373 SI VDD NW g45p1svt m=1 l=45n w=390n
Mmp12 Db SE net381 NW g45p1svt m=1 l=45n w=390n
Mmp11 net381 D VDD NW g45p1svt m=1 l=45n w=390n
Mmp51 n30 CKbb net326 NW g45p1svt m=1 l=45n w=310n
Mmp50 net326 qbint VDD NW g45p1svt m=1 l=45n w=310n
Mmp55 Q qbint VDD NW g45p1svt m=1 l=45n w=390n
Mmp20 CKb CK VDD NW g45p1svt m=1 l=45n w=215n
Mmp46 qbint n30 VDD NW g45p1svt m=1 l=45n w=310n
Mmp45 VDD RN qbint NW g45p1svt m=1 l=45n w=310n
Mmp35 net349 RN VDD NW g45p1svt m=1 l=45n w=310n
Mmp36 net349 mout VDD NW g45p1svt m=1 l=45n w=310n
Mmp37 n20 CKb net349 NW g45p1svt m=1 l=45n w=310n
Mmp40 n30 CKb mout NW g45p1svt m=1 l=45n w=310n
Mmp30 mout n20 VDD NW g45p1svt m=1 l=45n w=310n
Mmp21 CKbb CKb VDD NW g45p1svt m=1 l=45n w=215n
Mmp25 n20 CKbb Db NW g45p1svt m=1 l=45n w=310n
Mmp10 SEb SE VDD NW g45p1svt m=1 l=45n w=215n
.ENDS

.SUBCKT SDFFRHQX2 CK D NW Q RN SE SI VDD VSS
*.PININFO CK:I D:I NW:I RN:I SE:I SI:I VDD:I VSS:I Q:O
Mmn36 net422 mout net426 VSS g45n1svt m=1 l=45n w=205n
Mmn35 net426 RN VSS VSS g45n1svt m=1 l=45n w=205n
Mmn37 n20 CKbb net422 VSS g45n1svt m=1 l=45n w=205n
Mmn13 net442 SI VSS VSS g45n1svt m=1 l=45n w=260n
Mmn14 Db SE net442 VSS g45n1svt m=1 l=45n w=260n
Mmn12 Db SEb net450 VSS g45n1svt m=1 l=45n w=260n
Mmn11 net450 D VSS VSS g45n1svt m=1 l=45n w=260n
Mmn55 Q qbint VSS VSS g45n1svt m=1 l=45n w=520n
Mmn45 net337 RN VSS VSS g45n1svt m=1 l=45n w=205n
Mmn46 qbint n30 net337 VSS g45n1svt m=1 l=45n w=205n
Mmn51 n30 CKb net405 VSS g45n1svt m=1 l=45n w=205n
Mmn50 net405 qbint VSS VSS g45n1svt m=1 l=45n w=205n
Mmn20 CKb CK VSS VSS g45n1svt m=1 l=45n w=145n
Mmn40 n30 CKbb mout VSS g45n1svt m=1 l=45n w=205n
Mmn30 mout n20 VSS VSS g45n1svt m=1 l=45n w=205n
Mmn21 CKbb CKb VSS VSS g45n1svt m=1 l=45n w=145n
Mmn10 SEb SE VSS VSS g45n1svt m=1 l=45n w=145n
Mmn25 n20 CKb Db VSS g45n1svt m=1 l=45n w=205n
Mmp14 Db SEb net373 NW g45p1svt m=1 l=45n w=390n
Mmp13 net373 SI VDD NW g45p1svt m=1 l=45n w=390n
Mmp12 Db SE net381 NW g45p1svt m=1 l=45n w=390n
Mmp11 net381 D VDD NW g45p1svt m=1 l=45n w=390n
Mmp51 n30 CKbb net326 NW g45p1svt m=1 l=45n w=310n
Mmp50 net326 qbint VDD NW g45p1svt m=1 l=45n w=310n
Mmp55 Q qbint VDD NW g45p1svt m=1 l=45n w=780n
Mmp20 CKb CK VDD NW g45p1svt m=1 l=45n w=215n
Mmp46 qbint n30 VDD NW g45p1svt m=1 l=45n w=310n
Mmp45 VDD RN qbint NW g45p1svt m=1 l=45n w=310n
Mmp35 net349 RN VDD NW g45p1svt m=1 l=45n w=310n
Mmp36 net349 mout VDD NW g45p1svt m=1 l=45n w=310n
Mmp37 n20 CKb net349 NW g45p1svt m=1 l=45n w=310n
Mmp40 n30 CKb mout NW g45p1svt m=1 l=45n w=310n
Mmp30 mout n20 VDD NW g45p1svt m=1 l=45n w=310n
Mmp21 CKbb CKb VDD NW g45p1svt m=1 l=45n w=215n
Mmp25 n20 CKbb Db NW g45p1svt m=1 l=45n w=310n
Mmp10 SEb SE VDD NW g45p1svt m=1 l=45n w=215n
.ENDS

.SUBCKT SDFFRHQX4 CK D NW Q RN SE SI VDD VSS
*.PININFO CK:I D:I NW:I RN:I SE:I SI:I VDD:I VSS:I Q:O
Mmn36 net422 mout net426 VSS g45n1svt m=1 l=45n w=205n
Mmn35 net426 RN VSS VSS g45n1svt m=1 l=45n w=205n
Mmn37 n20 CKbb net422 VSS g45n1svt m=1 l=45n w=205n
Mmn13 net442 SI VSS VSS g45n1svt m=1 l=45n w=260n
Mmn14 Db SE net442 VSS g45n1svt m=1 l=45n w=260n
Mmn12 Db SEb net450 VSS g45n1svt m=1 l=45n w=260n
Mmn11 net450 D VSS VSS g45n1svt m=1 l=45n w=260n
Mmn55 Q qbint VSS VSS g45n1svt m=1 l=45n w=1.04u
Mmn45 net337 RN VSS VSS g45n1svt m=1 l=45n w=410n
Mmn46 qbint n30 net337 VSS g45n1svt m=1 l=45n w=410n
Mmn51 n30 CKb net405 VSS g45n1svt m=1 l=45n w=205n
Mmn50 net405 qbint VSS VSS g45n1svt m=1 l=45n w=205n
Mmn20 CKb CK VSS VSS g45n1svt m=1 l=45n w=145n
Mmn40 n30 CKbb mout VSS g45n1svt m=1 l=45n w=205n
Mmn30 mout n20 VSS VSS g45n1svt m=1 l=45n w=205n
Mmn21 CKbb CKb VSS VSS g45n1svt m=1 l=45n w=145n
Mmn10 SEb SE VSS VSS g45n1svt m=1 l=45n w=145n
Mmn25 n20 CKb Db VSS g45n1svt m=1 l=45n w=205n
Mmp14 Db SEb net373 NW g45p1svt m=1 l=45n w=390n
Mmp13 net373 SI VDD NW g45p1svt m=1 l=45n w=390n
Mmp12 Db SE net381 NW g45p1svt m=1 l=45n w=390n
Mmp11 net381 D VDD NW g45p1svt m=1 l=45n w=390n
Mmp51 n30 CKbb net326 NW g45p1svt m=1 l=45n w=310n
Mmp50 net326 qbint VDD NW g45p1svt m=1 l=45n w=310n
Mmp55 Q qbint VDD NW g45p1svt m=1 l=45n w=1.56u
Mmp20 CKb CK VDD NW g45p1svt m=1 l=45n w=215n
Mmp46 qbint n30 VDD NW g45p1svt m=1 l=45n w=620n
Mmp45 VDD RN qbint NW g45p1svt m=1 l=45n w=620n
Mmp35 net349 RN VDD NW g45p1svt m=1 l=45n w=310n
Mmp36 net349 mout VDD NW g45p1svt m=1 l=45n w=310n
Mmp37 n20 CKb net349 NW g45p1svt m=1 l=45n w=310n
Mmp40 n30 CKb mout NW g45p1svt m=1 l=45n w=310n
Mmp30 mout n20 VDD NW g45p1svt m=1 l=45n w=310n
Mmp21 CKbb CKb VDD NW g45p1svt m=1 l=45n w=215n
Mmp25 n20 CKbb Db NW g45p1svt m=1 l=45n w=310n
Mmp10 SEb SE VDD NW g45p1svt m=1 l=45n w=215n
.ENDS

.SUBCKT SDFFRHQX8 CK D NW Q RN SE SI VDD VSS
*.PININFO CK:I D:I NW:I RN:I SE:I SI:I VDD:I VSS:I Q:O
Mmn36 net422 mout net426 VSS g45n1svt m=1 l=45n w=205n
Mmn35 net426 RN VSS VSS g45n1svt m=1 l=45n w=205n
Mmn37 n20 CKbb net422 VSS g45n1svt m=1 l=45n w=205n
Mmn13 net442 SI VSS VSS g45n1svt m=1 l=45n w=260n
Mmn14 Db SE net442 VSS g45n1svt m=1 l=45n w=260n
Mmn12 Db SEb net450 VSS g45n1svt m=1 l=45n w=260n
Mmn11 net450 D VSS VSS g45n1svt m=1 l=45n w=260n
Mmn55 Q qbint VSS VSS g45n1svt m=1 l=45n w=2.065u
Mmn45 net337 RN VSS VSS g45n1svt m=1 l=45n w=780n
Mmn46 qbint n30 net337 VSS g45n1svt m=1 l=45n w=780n
Mmn51 n30 CKb net405 VSS g45n1svt m=1 l=45n w=205n
Mmn50 net405 qbint VSS VSS g45n1svt m=1 l=45n w=205n
Mmn20 CKb CK VSS VSS g45n1svt m=1 l=45n w=145n
Mmn40 n30 CKbb mout VSS g45n1svt m=1 l=45n w=205n
Mmn30 mout n20 VSS VSS g45n1svt m=1 l=45n w=205n
Mmn21 CKbb CKb VSS VSS g45n1svt m=1 l=45n w=145n
Mmn10 SEb SE VSS VSS g45n1svt m=1 l=45n w=145n
Mmn25 n20 CKb Db VSS g45n1svt m=1 l=45n w=205n
Mmp14 Db SEb net373 NW g45p1svt m=1 l=45n w=390n
Mmp13 net373 SI VDD NW g45p1svt m=1 l=45n w=390n
Mmp12 Db SE net381 NW g45p1svt m=1 l=45n w=390n
Mmp11 net381 D VDD NW g45p1svt m=1 l=45n w=390n
Mmp51 n30 CKbb net326 NW g45p1svt m=1 l=45n w=310n
Mmp50 net326 qbint VDD NW g45p1svt m=1 l=45n w=310n
Mmp55 Q qbint VDD NW g45p1svt m=1 l=45n w=3.115u
Mmp20 CKb CK VDD NW g45p1svt m=1 l=45n w=215n
Mmp46 qbint n30 VDD NW g45p1svt m=1 l=45n w=1.17u
Mmp45 VDD RN qbint NW g45p1svt m=1 l=45n w=1.17u
Mmp35 net349 RN VDD NW g45p1svt m=1 l=45n w=310n
Mmp36 net349 mout VDD NW g45p1svt m=1 l=45n w=310n
Mmp37 n20 CKb net349 NW g45p1svt m=1 l=45n w=310n
Mmp40 n30 CKb mout NW g45p1svt m=1 l=45n w=310n
Mmp30 mout n20 VDD NW g45p1svt m=1 l=45n w=310n
Mmp21 CKbb CKb VDD NW g45p1svt m=1 l=45n w=215n
Mmp25 n20 CKbb Db NW g45p1svt m=1 l=45n w=310n
Mmp10 SEb SE VDD NW g45p1svt m=1 l=45n w=215n
.ENDS

.SUBCKT SDFFRX1 CK D NW Q QN RN SE SI VDD VSS
*.PININFO CK:I D:I NW:I RN:I SE:I SI:I VDD:I VSS:I Q:O QN:O
Mmn36 n5 mout n7 VSS g45n1svt m=1 l=45n w=145n
Mmn35 n7 RN VSS VSS g45n1svt m=1 l=45n w=145n
Mmn37 n20 Ckbb n5 VSS g45n1svt m=1 l=45n w=145n
Mmn13 n3 SI VSS VSS g45n1svt m=1 l=45n w=145n
Mmn14 Db SE n3 VSS g45n1svt m=1 l=45n w=145n
Mmn12 Db SEb n1 VSS g45n1svt m=1 l=45n w=145n
Mmn11 n1 D VSS VSS g45n1svt m=1 l=45n w=145n
Mmn57 QN qint VSS VSS g45n1svt m=1 l=45n w=260n
Mmn55 Q qbint VSS VSS g45n1svt m=1 l=45n w=260n
Mmn45 n9 RN VSS VSS g45n1svt m=1 l=45n w=145n
Mmn46 qbint n30 n9 VSS g45n1svt m=1 l=45n w=145n
Mmn51 n30 CKb n11 VSS g45n1svt m=1 l=45n w=145n
Mmn50 n11 qbint VSS VSS g45n1svt m=1 l=45n w=145n
Mmn20 CKb CK VSS VSS g45n1svt m=1 l=45n w=145n
Mmn56 qint qbint VSS VSS g45n1svt m=1 l=45n w=145n
Mmn40 mout Ckbb n30 VSS g45n1svt m=1 l=45n w=145n
Mmn30 mout n20 VSS VSS g45n1svt m=1 l=45n w=145n
Mmn21 Ckbb CKb VSS VSS g45n1svt m=1 l=45n w=145n
Mmn10 SEb SE VSS VSS g45n1svt m=1 l=45n w=145n
Mmn25 Db CKb n20 VSS g45n1svt m=1 l=45n w=145n
Mmp14 Db SEb n4 NW g45p1svt m=1 l=45n w=215n
Mmp13 n4 SI VDD NW g45p1svt m=1 l=45n w=215n
Mmp12 Db SE n2 NW g45p1svt m=1 l=45n w=215n
Mmp11 n2 D VDD NW g45p1svt m=1 l=45n w=215n
Mmp51 n30 Ckbb n8 NW g45p1svt m=1 l=45n w=215n
Mmp50 n8 qbint VDD NW g45p1svt m=1 l=45n w=215n
Mmp55 Q qbint VDD NW g45p1svt m=1 l=45n w=390n
Mmp20 CKb CK VDD NW g45p1svt m=1 l=45n w=215n
Mmp46 qbint n30 VDD NW g45p1svt m=1 l=45n w=215n
Mmp56 qint qbint VDD NW g45p1svt m=1 l=45n w=215n
Mmp45 qbint RN VDD NW g45p1svt m=1 l=45n w=215n
Mmp35 n6 RN VDD NW g45p1svt m=1 l=45n w=215n
Mmp36 n6 mout VDD NW g45p1svt m=1 l=45n w=215n
Mmp37 n20 CKb n6 NW g45p1svt m=1 l=45n w=215n
Mmp40 n30 CKb mout NW g45p1svt m=1 l=45n w=215n
Mmp30 mout n20 VDD NW g45p1svt m=1 l=45n w=215n
Mmp21 Ckbb CKb VDD NW g45p1svt m=1 l=45n w=215n
Mmp25 n20 Ckbb Db NW g45p1svt m=1 l=45n w=215n
Mmp10 SEb SE VDD NW g45p1svt m=1 l=45n w=215n
Mmp57 QN qint VDD NW g45p1svt m=1 l=45n w=390n
.ENDS

.SUBCKT SDFFRX2 CK D NW Q QN RN SE SI VDD VSS
*.PININFO CK:I D:I NW:I RN:I SE:I SI:I VDD:I VSS:I Q:O QN:O
Mmn36 n5 mout n7 VSS g45n1svt m=1 l=45n w=145n
Mmn35 n7 RN VSS VSS g45n1svt m=1 l=45n w=145n
Mmn37 n20 Ckbb n5 VSS g45n1svt m=1 l=45n w=145n
Mmn13 n3 SI VSS VSS g45n1svt m=1 l=45n w=145n
Mmn14 Db SE n3 VSS g45n1svt m=1 l=45n w=145n
Mmn12 Db SEb n1 VSS g45n1svt m=1 l=45n w=145n
Mmn11 n1 D VSS VSS g45n1svt m=1 l=45n w=145n
Mmn57 QN qint VSS VSS g45n1svt m=1 l=45n w=520n
Mmn55 Q qbint VSS VSS g45n1svt m=1 l=45n w=520n
Mmn45 n9 RN VSS VSS g45n1svt m=1 l=45n w=205n
Mmn46 qbint n30 n9 VSS g45n1svt m=1 l=45n w=205n
Mmn51 n30 CKb n11 VSS g45n1svt m=1 l=45n w=145n
Mmn50 n11 qbint VSS VSS g45n1svt m=1 l=45n w=145n
Mmn20 CKb CK VSS VSS g45n1svt m=1 l=45n w=145n
Mmn56 qint qbint VSS VSS g45n1svt m=1 l=45n w=145n
Mmn40 mout Ckbb n30 VSS g45n1svt m=1 l=45n w=145n
Mmn30 mout n20 VSS VSS g45n1svt m=1 l=45n w=145n
Mmn21 Ckbb CKb VSS VSS g45n1svt m=1 l=45n w=145n
Mmn10 SEb SE VSS VSS g45n1svt m=1 l=45n w=145n
Mmn25 Db CKb n20 VSS g45n1svt m=1 l=45n w=145n
Mmp14 Db SEb n4 NW g45p1svt m=1 l=45n w=215n
Mmp13 n4 SI VDD NW g45p1svt m=1 l=45n w=215n
Mmp12 Db SE n2 NW g45p1svt m=1 l=45n w=215n
Mmp11 n2 D VDD NW g45p1svt m=1 l=45n w=215n
Mmp51 n30 Ckbb n8 NW g45p1svt m=1 l=45n w=215n
Mmp50 n8 qbint VDD NW g45p1svt m=1 l=45n w=215n
Mmp55 Q qbint VDD NW g45p1svt m=1 l=45n w=780n
Mmp20 CKb CK VDD NW g45p1svt m=1 l=45n w=215n
Mmp46 qbint n30 VDD NW g45p1svt m=1 l=45n w=310n
Mmp56 qint qbint VDD NW g45p1svt m=1 l=45n w=215n
Mmp45 qbint RN VDD NW g45p1svt m=1 l=45n w=310n
Mmp35 n6 RN VDD NW g45p1svt m=1 l=45n w=215n
Mmp36 n6 mout VDD NW g45p1svt m=1 l=45n w=215n
Mmp37 n20 CKb n6 NW g45p1svt m=1 l=45n w=215n
Mmp40 n30 CKb mout NW g45p1svt m=1 l=45n w=215n
Mmp30 mout n20 VDD NW g45p1svt m=1 l=45n w=215n
Mmp21 Ckbb CKb VDD NW g45p1svt m=1 l=45n w=215n
Mmp25 n20 Ckbb Db NW g45p1svt m=1 l=45n w=215n
Mmp10 SEb SE VDD NW g45p1svt m=1 l=45n w=215n
Mmp57 QN qint VDD NW g45p1svt m=1 l=45n w=780n
.ENDS

.SUBCKT SDFFRX4 CK D NW Q QN RN SE SI VDD VSS
*.PININFO CK:I D:I NW:I RN:I SE:I SI:I VDD:I VSS:I Q:O QN:O
Mmn36 n5 mout n7 VSS g45n1svt m=1 l=45n w=145n
Mmn35 n7 RN VSS VSS g45n1svt m=1 l=45n w=145n
Mmn37 n20 Ckbb n5 VSS g45n1svt m=1 l=45n w=145n
Mmn13 n3 SI VSS VSS g45n1svt m=1 l=45n w=145n
Mmn14 Db SE n3 VSS g45n1svt m=1 l=45n w=145n
Mmn12 Db SEb n1 VSS g45n1svt m=1 l=45n w=145n
Mmn11 n1 D VSS VSS g45n1svt m=1 l=45n w=145n
Mmn57 QN qint VSS VSS g45n1svt m=1 l=45n w=1.04u
Mmn55 Q qbint VSS VSS g45n1svt m=1 l=45n w=1.04u
Mmn45 n9 RN VSS VSS g45n1svt m=1 l=45n w=410n
Mmn46 qbint n30 n9 VSS g45n1svt m=1 l=45n w=410n
Mmn51 n30 CKb n11 VSS g45n1svt m=1 l=45n w=145n
Mmn50 n11 qbint VSS VSS g45n1svt m=1 l=45n w=145n
Mmn20 CKb CK VSS VSS g45n1svt m=1 l=45n w=145n
Mmn56 qint qbint VSS VSS g45n1svt m=1 l=45n w=260n
Mmn40 mout Ckbb n30 VSS g45n1svt m=1 l=45n w=145n
Mmn30 mout n20 VSS VSS g45n1svt m=1 l=45n w=145n
Mmn21 Ckbb CKb VSS VSS g45n1svt m=1 l=45n w=145n
Mmn10 SEb SE VSS VSS g45n1svt m=1 l=45n w=145n
Mmn25 Db CKb n20 VSS g45n1svt m=1 l=45n w=145n
Mmp14 Db SEb n4 NW g45p1svt m=1 l=45n w=215n
Mmp13 n4 SI VDD NW g45p1svt m=1 l=45n w=215n
Mmp12 Db SE n2 NW g45p1svt m=1 l=45n w=215n
Mmp11 n2 D VDD NW g45p1svt m=1 l=45n w=215n
Mmp51 n30 Ckbb n8 NW g45p1svt m=1 l=45n w=215n
Mmp50 n8 qbint VDD NW g45p1svt m=1 l=45n w=215n
Mmp55 Q qbint VDD NW g45p1svt m=1 l=45n w=1.56u
Mmp20 CKb CK VDD NW g45p1svt m=1 l=45n w=215n
Mmp46 qbint n30 VDD NW g45p1svt m=1 l=45n w=620n
Mmp56 qint qbint VDD NW g45p1svt m=1 l=45n w=390n
Mmp45 qbint RN VDD NW g45p1svt m=1 l=45n w=620n
Mmp35 n6 RN VDD NW g45p1svt m=1 l=45n w=215n
Mmp36 n6 mout VDD NW g45p1svt m=1 l=45n w=215n
Mmp37 n20 CKb n6 NW g45p1svt m=1 l=45n w=215n
Mmp40 n30 CKb mout NW g45p1svt m=1 l=45n w=215n
Mmp30 mout n20 VDD NW g45p1svt m=1 l=45n w=215n
Mmp21 Ckbb CKb VDD NW g45p1svt m=1 l=45n w=215n
Mmp25 n20 Ckbb Db NW g45p1svt m=1 l=45n w=215n
Mmp10 SEb SE VDD NW g45p1svt m=1 l=45n w=215n
Mmp57 QN qint VDD NW g45p1svt m=1 l=45n w=1.56u
.ENDS

.SUBCKT SDFFRXL CK D NW Q QN RN SE SI VDD VSS
*.PININFO CK:I D:I NW:I RN:I SE:I SI:I VDD:I VSS:I Q:O QN:O
Mmn36 n5 mout n7 VSS g45n1svt m=1 l=45n w=145n
Mmn35 n7 RN VSS VSS g45n1svt m=1 l=45n w=145n
Mmn37 n20 Ckbb n5 VSS g45n1svt m=1 l=45n w=145n
Mmn13 n3 SI VSS VSS g45n1svt m=1 l=45n w=145n
Mmn14 Db SE n3 VSS g45n1svt m=1 l=45n w=145n
Mmn12 Db SEb n1 VSS g45n1svt m=1 l=45n w=145n
Mmn11 n1 D VSS VSS g45n1svt m=1 l=45n w=145n
Mmn57 QN qint VSS VSS g45n1svt m=1 l=45n w=145n
Mmn55 Q qbint VSS VSS g45n1svt m=1 l=45n w=145n
Mmn45 n9 RN VSS VSS g45n1svt m=1 l=45n w=145n
Mmn46 qbint n30 n9 VSS g45n1svt m=1 l=45n w=145n
Mmn51 n30 CKb n11 VSS g45n1svt m=1 l=45n w=145n
Mmn50 n11 qbint VSS VSS g45n1svt m=1 l=45n w=145n
Mmn20 CKb CK VSS VSS g45n1svt m=1 l=45n w=145n
Mmn56 qint qbint VSS VSS g45n1svt m=1 l=45n w=145n
Mmn40 mout Ckbb n30 VSS g45n1svt m=1 l=45n w=145n
Mmn30 mout n20 VSS VSS g45n1svt m=1 l=45n w=145n
Mmn21 Ckbb CKb VSS VSS g45n1svt m=1 l=45n w=145n
Mmn10 SEb SE VSS VSS g45n1svt m=1 l=45n w=145n
Mmn25 Db CKb n20 VSS g45n1svt m=1 l=45n w=145n
Mmp14 Db SEb n4 NW g45p1svt m=1 l=45n w=215n
Mmp13 n4 SI VDD NW g45p1svt m=1 l=45n w=215n
Mmp12 Db SE n2 NW g45p1svt m=1 l=45n w=215n
Mmp11 n2 D VDD NW g45p1svt m=1 l=45n w=215n
Mmp51 n30 Ckbb n8 NW g45p1svt m=1 l=45n w=215n
Mmp50 n8 qbint VDD NW g45p1svt m=1 l=45n w=215n
Mmp55 Q qbint VDD NW g45p1svt m=1 l=45n w=215n
Mmp20 CKb CK VDD NW g45p1svt m=1 l=45n w=215n
Mmp46 qbint n30 VDD NW g45p1svt m=1 l=45n w=215n
Mmp56 qint qbint VDD NW g45p1svt m=1 l=45n w=215n
Mmp45 qbint RN VDD NW g45p1svt m=1 l=45n w=215n
Mmp35 n6 RN VDD NW g45p1svt m=1 l=45n w=215n
Mmp36 n6 mout VDD NW g45p1svt m=1 l=45n w=215n
Mmp37 n20 CKb n6 NW g45p1svt m=1 l=45n w=215n
Mmp40 n30 CKb mout NW g45p1svt m=1 l=45n w=215n
Mmp30 mout n20 VDD NW g45p1svt m=1 l=45n w=215n
Mmp21 Ckbb CKb VDD NW g45p1svt m=1 l=45n w=215n
Mmp25 n20 Ckbb Db NW g45p1svt m=1 l=45n w=215n
Mmp10 SEb SE VDD NW g45p1svt m=1 l=45n w=215n
Mmp57 QN qint VDD NW g45p1svt m=1 l=45n w=215n
.ENDS

.SUBCKT SDFFSHQX1 CK D NW Q SE SI SN VDD VSS
*.PININFO CK:I D:I NW:I SE:I SI:I SN:I VDD:I VSS:I Q:O
Mmn51 net467 qbint net459 VSS g45n1svt m=1 l=45n w=205n
Mmn52 n30 CKb net467 VSS g45n1svt m=1 l=45n w=205n
Mmn50 net459 SN VSS VSS g45n1svt m=1 l=45n w=205n
Mmn13 net455 SI VSS VSS g45n1svt m=1 l=45n w=260n
Mmn14 Db SE net455 VSS g45n1svt m=1 l=45n w=260n
Mmn12 Db SEb net443 VSS g45n1svt m=1 l=45n w=260n
Mmn11 net443 D VSS VSS g45n1svt m=1 l=45n w=260n
Mmn55 Q qbint VSS VSS g45n1svt m=1 l=45n w=260n
Mmn30 net435 SN VSS VSS g45n1svt m=1 l=45n w=205n
Mmn31 mout n20 net435 VSS g45n1svt m=1 l=45n w=205n
Mmn35 net427 mout VSS VSS g45n1svt m=1 l=45n w=205n
Mmn36 n20 CKbb net427 VSS g45n1svt m=1 l=45n w=205n
Mmn20 CKb CK VSS VSS g45n1svt m=1 l=45n w=145n
Mmn10 SEb SE VSS VSS g45n1svt m=1 l=45n w=145n
Mmn25 n20 CKb Db VSS g45n1svt m=1 l=45n w=205n
Mmn40 n30 CKbb mout VSS g45n1svt m=1 l=45n w=205n
Mmn45 qbint n30 VSS VSS g45n1svt m=1 l=45n w=205n
Mmn21 CKbb CKb VSS VSS g45n1svt m=1 l=45n w=145n
Mmp14 Db SEb net398 NW g45p1svt m=1 l=45n w=390n
Mmp13 net398 SI VDD NW g45p1svt m=1 l=45n w=390n
Mmp12 Db SE net390 NW g45p1svt m=1 l=45n w=390n
Mmp11 net390 D VDD NW g45p1svt m=1 l=45n w=390n
Mmp55 Q qbint VDD NW g45p1svt m=1 l=45n w=390n
Mmp36 n20 CKb net378 NW g45p1svt m=1 l=45n w=310n
Mmp35 net378 mout VDD NW g45p1svt m=1 l=45n w=310n
Mmp20 CKb CK VDD NW g45p1svt m=1 l=45n w=215n
Mmp52 n30 CKbb net355 NW g45p1svt m=1 l=45n w=310n
Mmp51 net355 qbint VDD NW g45p1svt m=1 l=45n w=310n
Mmp50 net355 SN VDD NW g45p1svt m=1 l=45n w=310n
Mmp21 CKbb CKb VDD NW g45p1svt m=1 l=45n w=215n
Mmp31 mout n20 VDD NW g45p1svt m=1 l=45n w=310n
Mmp45 qbint n30 VDD NW g45p1svt m=1 l=45n w=310n
Mmp30 mout SN VDD NW g45p1svt m=1 l=45n w=310n
Mmp25 n20 CKbb Db NW g45p1svt m=1 l=45n w=310n
Mmp40 n30 CKb mout NW g45p1svt m=1 l=45n w=310n
Mmp10 SEb SE VDD NW g45p1svt m=1 l=45n w=215n
.ENDS

.SUBCKT SDFFSHQX2 CK D NW Q SE SI SN VDD VSS
*.PININFO CK:I D:I NW:I SE:I SI:I SN:I VDD:I VSS:I Q:O
Mmn51 net467 qbint net459 VSS g45n1svt m=1 l=45n w=205n
Mmn52 n30 CKb net467 VSS g45n1svt m=1 l=45n w=205n
Mmn50 net459 SN VSS VSS g45n1svt m=1 l=45n w=205n
Mmn13 net455 SI VSS VSS g45n1svt m=1 l=45n w=260n
Mmn14 Db SE net455 VSS g45n1svt m=1 l=45n w=260n
Mmn12 Db SEb net443 VSS g45n1svt m=1 l=45n w=260n
Mmn11 net443 D VSS VSS g45n1svt m=1 l=45n w=260n
Mmn55 Q qbint VSS VSS g45n1svt m=1 l=45n w=520n
Mmn30 net435 SN VSS VSS g45n1svt m=1 l=45n w=205n
Mmn31 mout n20 net435 VSS g45n1svt m=1 l=45n w=205n
Mmn35 net427 mout VSS VSS g45n1svt m=1 l=45n w=205n
Mmn36 n20 CKbb net427 VSS g45n1svt m=1 l=45n w=205n
Mmn20 CKb CK VSS VSS g45n1svt m=1 l=45n w=145n
Mmn10 SEb SE VSS VSS g45n1svt m=1 l=45n w=145n
Mmn25 n20 CKb Db VSS g45n1svt m=1 l=45n w=205n
Mmn40 n30 CKbb mout VSS g45n1svt m=1 l=45n w=205n
Mmn45 qbint n30 VSS VSS g45n1svt m=1 l=45n w=205n
Mmn21 CKbb CKb VSS VSS g45n1svt m=1 l=45n w=145n
Mmp14 Db SEb net398 NW g45p1svt m=1 l=45n w=390n
Mmp13 net398 SI VDD NW g45p1svt m=1 l=45n w=390n
Mmp12 Db SE net390 NW g45p1svt m=1 l=45n w=390n
Mmp11 net390 D VDD NW g45p1svt m=1 l=45n w=390n
Mmp55 Q qbint VDD NW g45p1svt m=1 l=45n w=780n
Mmp36 n20 CKb net378 NW g45p1svt m=1 l=45n w=310n
Mmp35 net378 mout VDD NW g45p1svt m=1 l=45n w=310n
Mmp20 CKb CK VDD NW g45p1svt m=1 l=45n w=215n
Mmp52 n30 CKbb net355 NW g45p1svt m=1 l=45n w=310n
Mmp51 net355 qbint VDD NW g45p1svt m=1 l=45n w=310n
Mmp50 net355 SN VDD NW g45p1svt m=1 l=45n w=310n
Mmp21 CKbb CKb VDD NW g45p1svt m=1 l=45n w=215n
Mmp31 mout n20 VDD NW g45p1svt m=1 l=45n w=310n
Mmp45 qbint n30 VDD NW g45p1svt m=1 l=45n w=310n
Mmp30 mout SN VDD NW g45p1svt m=1 l=45n w=310n
Mmp25 n20 CKbb Db NW g45p1svt m=1 l=45n w=310n
Mmp40 n30 CKb mout NW g45p1svt m=1 l=45n w=310n
Mmp10 SEb SE VDD NW g45p1svt m=1 l=45n w=215n
.ENDS

.SUBCKT SDFFSHQX4 CK D NW Q SE SI SN VDD VSS
*.PININFO CK:I D:I NW:I SE:I SI:I SN:I VDD:I VSS:I Q:O
Mmn51 net467 qbint net459 VSS g45n1svt m=1 l=45n w=205n
Mmn52 n30 CKb net467 VSS g45n1svt m=1 l=45n w=205n
Mmn50 net459 SN VSS VSS g45n1svt m=1 l=45n w=205n
Mmn13 net455 SI VSS VSS g45n1svt m=1 l=45n w=260n
Mmn14 Db SE net455 VSS g45n1svt m=1 l=45n w=260n
Mmn12 Db SEb net443 VSS g45n1svt m=1 l=45n w=260n
Mmn11 net443 D VSS VSS g45n1svt m=1 l=45n w=260n
Mmn55 Q qbint VSS VSS g45n1svt m=1 l=45n w=1.04u
Mmn30 net435 SN VSS VSS g45n1svt m=1 l=45n w=205n
Mmn31 mout n20 net435 VSS g45n1svt m=1 l=45n w=205n
Mmn35 net427 mout VSS VSS g45n1svt m=1 l=45n w=205n
Mmn36 n20 CKbb net427 VSS g45n1svt m=1 l=45n w=205n
Mmn20 CKb CK VSS VSS g45n1svt m=1 l=45n w=145n
Mmn10 SEb SE VSS VSS g45n1svt m=1 l=45n w=145n
Mmn25 n20 CKb Db VSS g45n1svt m=1 l=45n w=205n
Mmn40 n30 CKbb mout VSS g45n1svt m=1 l=45n w=205n
Mmn45 qbint n30 VSS VSS g45n1svt m=1 l=45n w=410n
Mmn21 CKbb CKb VSS VSS g45n1svt m=1 l=45n w=145n
Mmp14 Db SEb net398 NW g45p1svt m=1 l=45n w=390n
Mmp13 net398 SI VDD NW g45p1svt m=1 l=45n w=390n
Mmp12 Db SE net390 NW g45p1svt m=1 l=45n w=390n
Mmp11 net390 D VDD NW g45p1svt m=1 l=45n w=390n
Mmp55 Q qbint VDD NW g45p1svt m=1 l=45n w=1.56u
Mmp36 n20 CKb net378 NW g45p1svt m=1 l=45n w=310n
Mmp35 net378 mout VDD NW g45p1svt m=1 l=45n w=310n
Mmp20 CKb CK VDD NW g45p1svt m=1 l=45n w=215n
Mmp52 n30 CKbb net355 NW g45p1svt m=1 l=45n w=310n
Mmp51 net355 qbint VDD NW g45p1svt m=1 l=45n w=310n
Mmp50 net355 SN VDD NW g45p1svt m=1 l=45n w=310n
Mmp21 CKbb CKb VDD NW g45p1svt m=1 l=45n w=215n
Mmp31 mout n20 VDD NW g45p1svt m=1 l=45n w=310n
Mmp45 qbint n30 VDD NW g45p1svt m=1 l=45n w=620n
Mmp30 mout SN VDD NW g45p1svt m=1 l=45n w=310n
Mmp25 n20 CKbb Db NW g45p1svt m=1 l=45n w=310n
Mmp40 n30 CKb mout NW g45p1svt m=1 l=45n w=310n
Mmp10 SEb SE VDD NW g45p1svt m=1 l=45n w=215n
.ENDS

.SUBCKT SDFFSHQX8 CK D NW Q SE SI SN VDD VSS
*.PININFO CK:I D:I NW:I SE:I SI:I SN:I VDD:I VSS:I Q:O
Mmn51 net467 qbint net459 VSS g45n1svt m=1 l=45n w=205n
Mmn52 n30 CKb net467 VSS g45n1svt m=1 l=45n w=205n
Mmn50 net459 SN VSS VSS g45n1svt m=1 l=45n w=205n
Mmn13 net455 SI VSS VSS g45n1svt m=1 l=45n w=260n
Mmn14 Db SE net455 VSS g45n1svt m=1 l=45n w=260n
Mmn12 Db SEb net443 VSS g45n1svt m=1 l=45n w=260n
Mmn11 net443 D VSS VSS g45n1svt m=1 l=45n w=260n
Mmn55 Q qbint VSS VSS g45n1svt m=1 l=45n w=2.065u
Mmn30 net435 SN VSS VSS g45n1svt m=1 l=45n w=205n
Mmn31 mout n20 net435 VSS g45n1svt m=1 l=45n w=205n
Mmn35 net427 mout VSS VSS g45n1svt m=1 l=45n w=205n
Mmn36 n20 CKbb net427 VSS g45n1svt m=1 l=45n w=205n
Mmn20 CKb CK VSS VSS g45n1svt m=1 l=45n w=145n
Mmn10 SEb SE VSS VSS g45n1svt m=1 l=45n w=145n
Mmn25 n20 CKb Db VSS g45n1svt m=1 l=45n w=205n
Mmn40 n30 CKbb mout VSS g45n1svt m=1 l=45n w=205n
Mmn45 qbint n30 VSS VSS g45n1svt m=1 l=45n w=780n
Mmn21 CKbb CKb VSS VSS g45n1svt m=1 l=45n w=145n
Mmp14 Db SEb net398 NW g45p1svt m=1 l=45n w=390n
Mmp13 net398 SI VDD NW g45p1svt m=1 l=45n w=390n
Mmp12 Db SE net390 NW g45p1svt m=1 l=45n w=390n
Mmp11 net390 D VDD NW g45p1svt m=1 l=45n w=390n
Mmp55 Q qbint VDD NW g45p1svt m=1 l=45n w=3.115u
Mmp36 n20 CKb net378 NW g45p1svt m=1 l=45n w=310n
Mmp35 net378 mout VDD NW g45p1svt m=1 l=45n w=310n
Mmp20 CKb CK VDD NW g45p1svt m=1 l=45n w=215n
Mmp52 n30 CKbb net355 NW g45p1svt m=1 l=45n w=310n
Mmp51 net355 qbint VDD NW g45p1svt m=1 l=45n w=310n
Mmp50 net355 SN VDD NW g45p1svt m=1 l=45n w=310n
Mmp21 CKbb CKb VDD NW g45p1svt m=1 l=45n w=215n
Mmp31 mout n20 VDD NW g45p1svt m=1 l=45n w=310n
Mmp45 qbint n30 VDD NW g45p1svt m=1 l=45n w=1.17u
Mmp30 mout SN VDD NW g45p1svt m=1 l=45n w=310n
Mmp25 n20 CKbb Db NW g45p1svt m=1 l=45n w=310n
Mmp40 n30 CKb mout NW g45p1svt m=1 l=45n w=310n
Mmp10 SEb SE VDD NW g45p1svt m=1 l=45n w=215n
.ENDS

.SUBCKT SDFFSRHQX1 CK D NW Q RN SE SI SN VDD VSS
*.PININFO CK:I D:I NW:I RN:I SE:I SI:I SN:I VDD:I VSS:I Q:O
Mmn13 net534 SI VSS VSS g45n1svt m=1 l=45n w=260n
Mmn14 Db SE net534 VSS g45n1svt m=1 l=45n w=260n
Mmn12 Db SEb net522 VSS g45n1svt m=1 l=45n w=260n
Mmn11 net522 D VSS VSS g45n1svt m=1 l=45n w=260n
Mmn55 Q qbint VSS VSS g45n1svt m=1 l=45n w=260n
Mmn35 net514 mout VSS VSS g45n1svt m=1 l=45n w=205n
Mmn36 n20 CKbb net514 VSS g45n1svt m=1 l=45n w=205n
Mmn22 RNb RN VSS VSS g45n1svt m=1 l=45n w=145n
Mmn20 CKb CK VSS VSS g45n1svt m=1 l=45n w=145n
Mmn45 qbint n35 VSS VSS g45n1svt m=1 l=45n w=205n
Mmn52 net490 qbint net486 VSS g45n1svt m=1 l=45n w=205n
Mmn51 net490 RNb net486 VSS g45n1svt m=1 l=45n w=205n
Mmn50 net486 SN VSS VSS g45n1svt m=1 l=45n w=205n
Mmn53 n35 CKb net490 VSS g45n1svt m=1 l=45n w=205n
Mmn10 SEb SE VSS VSS g45n1svt m=1 l=45n w=145n
Mmn25 Db CKb n20 VSS g45n1svt m=1 l=45n w=205n
Mmn30 net469 SN VSS VSS g45n1svt m=1 l=45n w=205n
Mmn32 mout n20 net469 VSS g45n1svt m=1 l=45n w=205n
Mmn31 mout RNb net469 VSS g45n1svt m=1 l=45n w=205n
Mmn40 n35 CKbb mout VSS g45n1svt m=1 l=45n w=205n
Mmn21 CKbb CKb VSS VSS g45n1svt m=1 l=45n w=145n
Mmp14 Db SEb net453 NW g45p1svt m=1 l=45n w=390n
Mmp13 net453 SI VDD NW g45p1svt m=1 l=45n w=390n
Mmp12 Db SE net445 NW g45p1svt m=1 l=45n w=390n
Mmp11 net445 D VDD NW g45p1svt m=1 l=45n w=390n
Mmp52 net394 qbint net437 NW g45p1svt m=1 l=45n w=310n
Mmp51 net437 RNb VDD NW g45p1svt m=1 l=45n w=310n
Mmp55 Q qbint VDD NW g45p1svt m=1 l=45n w=390n
Mmp36 n20 CKb net425 NW g45p1svt m=1 l=45n w=310n
Mmp35 net425 mout VDD NW g45p1svt m=1 l=45n w=310n
Mmp32 mout n20 net417 NW g45p1svt m=1 l=45n w=310n
Mmp31 net417 RNb VDD NW g45p1svt m=1 l=45n w=310n
Mmp22 RNb RN VDD NW g45p1svt m=1 l=45n w=215n
Mmp20 CKb CK VDD NW g45p1svt m=1 l=45n w=215n
Mmp53 n35 CKbb net394 NW g45p1svt m=1 l=45n w=310n
Mmp50 net394 SN VDD NW g45p1svt m=1 l=45n w=310n
Mmp45 qbint n35 VDD NW g45p1svt m=1 l=45n w=310n
Mmp25 n20 CKbb Db NW g45p1svt m=1 l=45n w=310n
Mmp30 mout SN VDD NW g45p1svt m=1 l=45n w=310n
Mmp40 n35 CKb mout NW g45p1svt m=1 l=45n w=310n
Mmp21 CKbb CKb VDD NW g45p1svt m=1 l=45n w=215n
Mmp10 SEb SE VDD NW g45p1svt m=1 l=45n w=215n
.ENDS

.SUBCKT SDFFSRHQX2 CK D NW Q RN SE SI SN VDD VSS
*.PININFO CK:I D:I NW:I RN:I SE:I SI:I SN:I VDD:I VSS:I Q:O
Mmn13 net534 SI VSS VSS g45n1svt m=1 l=45n w=260n
Mmn14 Db SE net534 VSS g45n1svt m=1 l=45n w=260n
Mmn12 Db SEb net522 VSS g45n1svt m=1 l=45n w=260n
Mmn11 net522 D VSS VSS g45n1svt m=1 l=45n w=260n
Mmn55 Q qbint VSS VSS g45n1svt m=1 l=45n w=520n
Mmn35 net514 mout VSS VSS g45n1svt m=1 l=45n w=205n
Mmn36 n20 CKbb net514 VSS g45n1svt m=1 l=45n w=205n
Mmn22 RNb RN VSS VSS g45n1svt m=1 l=45n w=145n
Mmn20 CKb CK VSS VSS g45n1svt m=1 l=45n w=145n
Mmn45 qbint n35 VSS VSS g45n1svt m=1 l=45n w=205n
Mmn52 net490 qbint net486 VSS g45n1svt m=1 l=45n w=205n
Mmn51 net490 RNb net486 VSS g45n1svt m=1 l=45n w=205n
Mmn50 net486 SN VSS VSS g45n1svt m=1 l=45n w=205n
Mmn53 n35 CKb net490 VSS g45n1svt m=1 l=45n w=205n
Mmn10 SEb SE VSS VSS g45n1svt m=1 l=45n w=145n
Mmn25 Db CKb n20 VSS g45n1svt m=1 l=45n w=205n
Mmn30 net469 SN VSS VSS g45n1svt m=1 l=45n w=205n
Mmn32 mout n20 net469 VSS g45n1svt m=1 l=45n w=205n
Mmn31 mout RNb net469 VSS g45n1svt m=1 l=45n w=205n
Mmn40 n35 CKbb mout VSS g45n1svt m=1 l=45n w=205n
Mmn21 CKbb CKb VSS VSS g45n1svt m=1 l=45n w=145n
Mmp14 Db SEb net453 NW g45p1svt m=1 l=45n w=390n
Mmp13 net453 SI VDD NW g45p1svt m=1 l=45n w=390n
Mmp12 Db SE net445 NW g45p1svt m=1 l=45n w=390n
Mmp11 net445 D VDD NW g45p1svt m=1 l=45n w=390n
Mmp52 net394 qbint net437 NW g45p1svt m=1 l=45n w=310n
Mmp51 net437 RNb VDD NW g45p1svt m=1 l=45n w=310n
Mmp55 Q qbint VDD NW g45p1svt m=1 l=45n w=780n
Mmp36 n20 CKb net425 NW g45p1svt m=1 l=45n w=310n
Mmp35 net425 mout VDD NW g45p1svt m=1 l=45n w=310n
Mmp32 mout n20 net417 NW g45p1svt m=1 l=45n w=310n
Mmp31 net417 RNb VDD NW g45p1svt m=1 l=45n w=310n
Mmp22 RNb RN VDD NW g45p1svt m=1 l=45n w=215n
Mmp20 CKb CK VDD NW g45p1svt m=1 l=45n w=215n
Mmp53 n35 CKbb net394 NW g45p1svt m=1 l=45n w=310n
Mmp50 net394 SN VDD NW g45p1svt m=1 l=45n w=310n
Mmp45 qbint n35 VDD NW g45p1svt m=1 l=45n w=310n
Mmp25 n20 CKbb Db NW g45p1svt m=1 l=45n w=310n
Mmp30 mout SN VDD NW g45p1svt m=1 l=45n w=310n
Mmp40 n35 CKb mout NW g45p1svt m=1 l=45n w=310n
Mmp21 CKbb CKb VDD NW g45p1svt m=1 l=45n w=215n
Mmp10 SEb SE VDD NW g45p1svt m=1 l=45n w=215n
.ENDS

.SUBCKT SDFFSRHQX4 CK D NW Q RN SE SI SN VDD VSS
*.PININFO CK:I D:I NW:I RN:I SE:I SI:I SN:I VDD:I VSS:I Q:O
Mmn13 net534 SI VSS VSS g45n1svt m=1 l=45n w=260n
Mmn14 Db SE net534 VSS g45n1svt m=1 l=45n w=260n
Mmn12 Db SEb net522 VSS g45n1svt m=1 l=45n w=260n
Mmn11 net522 D VSS VSS g45n1svt m=1 l=45n w=260n
Mmn55 Q qbint VSS VSS g45n1svt m=1 l=45n w=1.04u
Mmn35 net514 mout VSS VSS g45n1svt m=1 l=45n w=205n
Mmn36 n20 CKbb net514 VSS g45n1svt m=1 l=45n w=205n
Mmn22 RNb RN VSS VSS g45n1svt m=1 l=45n w=145n
Mmn20 CKb CK VSS VSS g45n1svt m=1 l=45n w=145n
Mmn45 qbint n35 VSS VSS g45n1svt m=1 l=45n w=410n
Mmn52 net490 qbint net486 VSS g45n1svt m=1 l=45n w=205n
Mmn51 net490 RNb net486 VSS g45n1svt m=1 l=45n w=205n
Mmn50 net486 SN VSS VSS g45n1svt m=1 l=45n w=205n
Mmn53 n35 CKb net490 VSS g45n1svt m=1 l=45n w=205n
Mmn10 SEb SE VSS VSS g45n1svt m=1 l=45n w=145n
Mmn25 Db CKb n20 VSS g45n1svt m=1 l=45n w=205n
Mmn30 net469 SN VSS VSS g45n1svt m=1 l=45n w=205n
Mmn32 mout n20 net469 VSS g45n1svt m=1 l=45n w=205n
Mmn31 mout RNb net469 VSS g45n1svt m=1 l=45n w=205n
Mmn40 n35 CKbb mout VSS g45n1svt m=1 l=45n w=205n
Mmn21 CKbb CKb VSS VSS g45n1svt m=1 l=45n w=145n
Mmp14 Db SEb net453 NW g45p1svt m=1 l=45n w=390n
Mmp13 net453 SI VDD NW g45p1svt m=1 l=45n w=390n
Mmp12 Db SE net445 NW g45p1svt m=1 l=45n w=390n
Mmp11 net445 D VDD NW g45p1svt m=1 l=45n w=390n
Mmp52 net394 qbint net437 NW g45p1svt m=1 l=45n w=310n
Mmp51 net437 RNb VDD NW g45p1svt m=1 l=45n w=310n
Mmp55 Q qbint VDD NW g45p1svt m=1 l=45n w=1.56u
Mmp36 n20 CKb net425 NW g45p1svt m=1 l=45n w=310n
Mmp35 net425 mout VDD NW g45p1svt m=1 l=45n w=310n
Mmp32 mout n20 net417 NW g45p1svt m=1 l=45n w=310n
Mmp31 net417 RNb VDD NW g45p1svt m=1 l=45n w=310n
Mmp22 RNb RN VDD NW g45p1svt m=1 l=45n w=215n
Mmp20 CKb CK VDD NW g45p1svt m=1 l=45n w=215n
Mmp53 n35 CKbb net394 NW g45p1svt m=1 l=45n w=310n
Mmp50 net394 SN VDD NW g45p1svt m=1 l=45n w=310n
Mmp45 qbint n35 VDD NW g45p1svt m=1 l=45n w=620n
Mmp25 n20 CKbb Db NW g45p1svt m=1 l=45n w=310n
Mmp30 mout SN VDD NW g45p1svt m=1 l=45n w=310n
Mmp40 n35 CKb mout NW g45p1svt m=1 l=45n w=310n
Mmp21 CKbb CKb VDD NW g45p1svt m=1 l=45n w=215n
Mmp10 SEb SE VDD NW g45p1svt m=1 l=45n w=215n
.ENDS

.SUBCKT SDFFSRHQX8 CK D NW Q RN SE SI SN VDD VSS
*.PININFO CK:I D:I NW:I RN:I SE:I SI:I SN:I VDD:I VSS:I Q:O
Mmn13 net534 SI VSS VSS g45n1svt m=1 l=45n w=260n
Mmn14 Db SE net534 VSS g45n1svt m=1 l=45n w=260n
Mmn12 Db SEb net522 VSS g45n1svt m=1 l=45n w=260n
Mmn11 net522 D VSS VSS g45n1svt m=1 l=45n w=260n
Mmn55 Q qbint VSS VSS g45n1svt m=1 l=45n w=2.065u
Mmn35 net514 mout VSS VSS g45n1svt m=1 l=45n w=205n
Mmn36 n20 CKbb net514 VSS g45n1svt m=1 l=45n w=205n
Mmn22 RNb RN VSS VSS g45n1svt m=1 l=45n w=145n
Mmn20 CKb CK VSS VSS g45n1svt m=1 l=45n w=145n
Mmn45 qbint n35 VSS VSS g45n1svt m=1 l=45n w=780n
Mmn52 net490 qbint net486 VSS g45n1svt m=1 l=45n w=205n
Mmn51 net490 RNb net486 VSS g45n1svt m=1 l=45n w=205n
Mmn50 net486 SN VSS VSS g45n1svt m=1 l=45n w=205n
Mmn53 n35 CKb net490 VSS g45n1svt m=1 l=45n w=205n
Mmn10 SEb SE VSS VSS g45n1svt m=1 l=45n w=145n
Mmn25 Db CKb n20 VSS g45n1svt m=1 l=45n w=205n
Mmn30 net469 SN VSS VSS g45n1svt m=1 l=45n w=205n
Mmn32 mout n20 net469 VSS g45n1svt m=1 l=45n w=205n
Mmn31 mout RNb net469 VSS g45n1svt m=1 l=45n w=205n
Mmn40 n35 CKbb mout VSS g45n1svt m=1 l=45n w=205n
Mmn21 CKbb CKb VSS VSS g45n1svt m=1 l=45n w=145n
Mmp14 Db SEb net453 NW g45p1svt m=1 l=45n w=390n
Mmp13 net453 SI VDD NW g45p1svt m=1 l=45n w=390n
Mmp12 Db SE net445 NW g45p1svt m=1 l=45n w=390n
Mmp11 net445 D VDD NW g45p1svt m=1 l=45n w=390n
Mmp52 net394 qbint net437 NW g45p1svt m=1 l=45n w=310n
Mmp51 net437 RNb VDD NW g45p1svt m=1 l=45n w=310n
Mmp55 Q qbint VDD NW g45p1svt m=1 l=45n w=3.115u
Mmp36 n20 CKb net425 NW g45p1svt m=1 l=45n w=310n
Mmp35 net425 mout VDD NW g45p1svt m=1 l=45n w=310n
Mmp32 mout n20 net417 NW g45p1svt m=1 l=45n w=310n
Mmp31 net417 RNb VDD NW g45p1svt m=1 l=45n w=310n
Mmp22 RNb RN VDD NW g45p1svt m=1 l=45n w=215n
Mmp20 CKb CK VDD NW g45p1svt m=1 l=45n w=215n
Mmp53 n35 CKbb net394 NW g45p1svt m=1 l=45n w=310n
Mmp50 net394 SN VDD NW g45p1svt m=1 l=45n w=310n
Mmp45 qbint n35 VDD NW g45p1svt m=1 l=45n w=1.17u
Mmp25 n20 CKbb Db NW g45p1svt m=1 l=45n w=310n
Mmp30 mout SN VDD NW g45p1svt m=1 l=45n w=310n
Mmp40 n35 CKb mout NW g45p1svt m=1 l=45n w=310n
Mmp21 CKbb CKb VDD NW g45p1svt m=1 l=45n w=215n
Mmp10 SEb SE VDD NW g45p1svt m=1 l=45n w=215n
.ENDS

.SUBCKT SDFFSRX1 CK D NW Q QN RN SE SI SN VDD VSS
*.PININFO CK:I D:I NW:I RN:I SE:I SI:I SN:I VDD:I VSS:I Q:O QN:O
Mmn13 n2 SI VSS VSS g45n1svt m=1 l=45n w=145n
Mmn14 Db SE n2 VSS g45n1svt m=1 l=45n w=145n
Mmn12 Db SEb n0 VSS g45n1svt m=1 l=45n w=145n
Mmn11 n0 D VSS VSS g45n1svt m=1 l=45n w=145n
Mmn57 QN net573 VSS VSS g45n1svt m=1 l=45n w=260n
Mmn55 Q qbint VSS VSS g45n1svt m=1 l=45n w=260n
Mmn35 n6 mout VSS VSS g45n1svt m=1 l=45n w=145n
Mmn36 n20 CKbb n6 VSS g45n1svt m=1 l=45n w=145n
Mmn22 RNb RN VSS VSS g45n1svt m=1 l=45n w=145n
Mmn20 CKb CK VSS VSS g45n1svt m=1 l=45n w=145n
Mmn10 SEb SE VSS VSS g45n1svt m=1 l=45n w=145n
Mmn56 net573 qbint VSS VSS g45n1svt m=1 l=45n w=145n
Mmn25 Db CKb n20 VSS g45n1svt m=1 l=45n w=145n
Mmn32 mout n20 n4 VSS g45n1svt m=1 l=45n w=145n
Mmn53 n35 CKb n10 VSS g45n1svt m=1 l=45n w=145n
Mmn30 n4 SN VSS VSS g45n1svt m=1 l=45n w=145n
Mmn50 n8 SN VSS VSS g45n1svt m=1 l=45n w=145n
Mmn51 n10 RNb n8 VSS g45n1svt m=1 l=45n w=145n
Mmn40 n35 CKbb mout VSS g45n1svt m=1 l=45n w=145n
Mmn31 mout RNb n4 VSS g45n1svt m=1 l=45n w=145n
Mmn21 CKbb CKb VSS VSS g45n1svt m=1 l=45n w=145n
Mmn52 n10 qbint n8 VSS g45n1svt m=1 l=45n w=145n
Mmn45 qbint n35 VSS VSS g45n1svt m=1 l=45n w=145n
Mmp14 Db SEb n3 NW g45p1svt m=1 l=45n w=215n
Mmp13 n3 SI VDD NW g45p1svt m=1 l=45n w=215n
Mmp12 Db SE n1 NW g45p1svt m=1 l=45n w=215n
Mmp11 n1 D VDD NW g45p1svt m=1 l=45n w=215n
Mmp52 n11 qbint n9 NW g45p1svt m=1 l=45n w=215n
Mmp51 n9 RNb VDD NW g45p1svt m=1 l=45n w=215n
Mmp57 QN net573 VDD NW g45p1svt m=1 l=45n w=390n
Mmp55 Q qbint VDD NW g45p1svt m=1 l=45n w=390n
Mmp36 n20 CKb n7 NW g45p1svt m=1 l=45n w=215n
Mmp35 n7 mout VDD NW g45p1svt m=1 l=45n w=215n
Mmp32 mout n20 n5 NW g45p1svt m=1 l=45n w=215n
Mmp31 n5 RNb VDD NW g45p1svt m=1 l=45n w=215n
Mmp22 RNb RN VDD NW g45p1svt m=1 l=45n w=215n
Mmp20 CKb CK VDD NW g45p1svt m=1 l=45n w=215n
Mmp21 CKbb CKb VDD NW g45p1svt m=1 l=45n w=215n
Mmp45 qbint n35 VDD NW g45p1svt m=1 l=45n w=215n
Mmp30 mout SN VDD NW g45p1svt m=1 l=45n w=215n
Mmp25 n20 CKbb Db NW g45p1svt m=1 l=45n w=215n
Mmp56 net573 qbint VDD NW g45p1svt m=1 l=45n w=215n
Mmp40 n35 CKb mout NW g45p1svt m=1 l=45n w=215n
Mmp53 n35 CKbb n11 NW g45p1svt m=1 l=45n w=215n
Mmp50 n11 SN VDD NW g45p1svt m=1 l=45n w=215n
Mmp10 SEb SE VDD NW g45p1svt m=1 l=45n w=215n
.ENDS

.SUBCKT SDFFSRX2 CK D NW Q QN RN SE SI SN VDD VSS
*.PININFO CK:I D:I NW:I RN:I SE:I SI:I SN:I VDD:I VSS:I Q:O QN:O
Mmn13 n2 SI VSS VSS g45n1svt m=1 l=45n w=145n
Mmn14 Db SE n2 VSS g45n1svt m=1 l=45n w=145n
Mmn12 Db SEb n0 VSS g45n1svt m=1 l=45n w=145n
Mmn11 n0 D VSS VSS g45n1svt m=1 l=45n w=145n
Mmn57 QN net573 VSS VSS g45n1svt m=1 l=45n w=520n
Mmn55 Q qbint VSS VSS g45n1svt m=1 l=45n w=520n
Mmn35 n6 mout VSS VSS g45n1svt m=1 l=45n w=145n
Mmn36 n20 CKbb n6 VSS g45n1svt m=1 l=45n w=145n
Mmn22 RNb RN VSS VSS g45n1svt m=1 l=45n w=145n
Mmn20 CKb CK VSS VSS g45n1svt m=1 l=45n w=145n
Mmn10 SEb SE VSS VSS g45n1svt m=1 l=45n w=145n
Mmn56 net573 qbint VSS VSS g45n1svt m=1 l=45n w=145n
Mmn25 Db CKb n20 VSS g45n1svt m=1 l=45n w=145n
Mmn32 mout n20 n4 VSS g45n1svt m=1 l=45n w=145n
Mmn53 n35 CKb n10 VSS g45n1svt m=1 l=45n w=145n
Mmn30 n4 SN VSS VSS g45n1svt m=1 l=45n w=145n
Mmn50 n8 SN VSS VSS g45n1svt m=1 l=45n w=145n
Mmn51 n10 RNb n8 VSS g45n1svt m=1 l=45n w=145n
Mmn40 n35 CKbb mout VSS g45n1svt m=1 l=45n w=145n
Mmn31 mout RNb n4 VSS g45n1svt m=1 l=45n w=145n
Mmn21 CKbb CKb VSS VSS g45n1svt m=1 l=45n w=145n
Mmn52 n10 qbint n8 VSS g45n1svt m=1 l=45n w=145n
Mmn45 qbint n35 VSS VSS g45n1svt m=1 l=45n w=205n
Mmp14 Db SEb n3 NW g45p1svt m=1 l=45n w=215n
Mmp13 n3 SI VDD NW g45p1svt m=1 l=45n w=215n
Mmp12 Db SE n1 NW g45p1svt m=1 l=45n w=215n
Mmp11 n1 D VDD NW g45p1svt m=1 l=45n w=215n
Mmp52 n11 qbint n9 NW g45p1svt m=1 l=45n w=215n
Mmp51 n9 RNb VDD NW g45p1svt m=1 l=45n w=215n
Mmp57 QN net573 VDD NW g45p1svt m=1 l=45n w=780n
Mmp55 Q qbint VDD NW g45p1svt m=1 l=45n w=780n
Mmp36 n20 CKb n7 NW g45p1svt m=1 l=45n w=215n
Mmp35 n7 mout VDD NW g45p1svt m=1 l=45n w=215n
Mmp32 mout n20 n5 NW g45p1svt m=1 l=45n w=215n
Mmp31 n5 RNb VDD NW g45p1svt m=1 l=45n w=215n
Mmp22 RNb RN VDD NW g45p1svt m=1 l=45n w=215n
Mmp20 CKb CK VDD NW g45p1svt m=1 l=45n w=215n
Mmp21 CKbb CKb VDD NW g45p1svt m=1 l=45n w=215n
Mmp45 qbint n35 VDD NW g45p1svt m=1 l=45n w=310n
Mmp30 mout SN VDD NW g45p1svt m=1 l=45n w=215n
Mmp25 n20 CKbb Db NW g45p1svt m=1 l=45n w=215n
Mmp56 net573 qbint VDD NW g45p1svt m=1 l=45n w=215n
Mmp40 n35 CKb mout NW g45p1svt m=1 l=45n w=215n
Mmp53 n35 CKbb n11 NW g45p1svt m=1 l=45n w=215n
Mmp50 n11 SN VDD NW g45p1svt m=1 l=45n w=215n
Mmp10 SEb SE VDD NW g45p1svt m=1 l=45n w=215n
.ENDS

.SUBCKT SDFFSRX4 CK D NW Q QN RN SE SI SN VDD VSS
*.PININFO CK:I D:I NW:I RN:I SE:I SI:I SN:I VDD:I VSS:I Q:O QN:O
Mmn13 n2 SI VSS VSS g45n1svt m=1 l=45n w=145n
Mmn14 Db SE n2 VSS g45n1svt m=1 l=45n w=145n
Mmn12 Db SEb n0 VSS g45n1svt m=1 l=45n w=145n
Mmn11 n0 D VSS VSS g45n1svt m=1 l=45n w=145n
Mmn57 QN net573 VSS VSS g45n1svt m=1 l=45n w=1.04u
Mmn55 Q qbint VSS VSS g45n1svt m=1 l=45n w=1.04u
Mmn35 n6 mout VSS VSS g45n1svt m=1 l=45n w=145n
Mmn36 n20 CKbb n6 VSS g45n1svt m=1 l=45n w=145n
Mmn22 RNb RN VSS VSS g45n1svt m=1 l=45n w=145n
Mmn20 CKb CK VSS VSS g45n1svt m=1 l=45n w=145n
Mmn10 SEb SE VSS VSS g45n1svt m=1 l=45n w=145n
Mmn56 net573 qbint VSS VSS g45n1svt m=1 l=45n w=260n
Mmn25 Db CKb n20 VSS g45n1svt m=1 l=45n w=145n
Mmn32 mout n20 n4 VSS g45n1svt m=1 l=45n w=145n
Mmn53 n35 CKb n10 VSS g45n1svt m=1 l=45n w=145n
Mmn30 n4 SN VSS VSS g45n1svt m=1 l=45n w=145n
Mmn50 n8 SN VSS VSS g45n1svt m=1 l=45n w=145n
Mmn51 n10 RNb n8 VSS g45n1svt m=1 l=45n w=145n
Mmn40 n35 CKbb mout VSS g45n1svt m=1 l=45n w=145n
Mmn31 mout RNb n4 VSS g45n1svt m=1 l=45n w=145n
Mmn21 CKbb CKb VSS VSS g45n1svt m=1 l=45n w=145n
Mmn52 n10 qbint n8 VSS g45n1svt m=1 l=45n w=145n
Mmn45 qbint n35 VSS VSS g45n1svt m=1 l=45n w=410n
Mmp14 Db SEb n3 NW g45p1svt m=1 l=45n w=215n
Mmp13 n3 SI VDD NW g45p1svt m=1 l=45n w=215n
Mmp12 Db SE n1 NW g45p1svt m=1 l=45n w=215n
Mmp11 n1 D VDD NW g45p1svt m=1 l=45n w=215n
Mmp52 n11 qbint n9 NW g45p1svt m=1 l=45n w=215n
Mmp51 n9 RNb VDD NW g45p1svt m=1 l=45n w=215n
Mmp57 QN net573 VDD NW g45p1svt m=1 l=45n w=1.56u
Mmp55 Q qbint VDD NW g45p1svt m=1 l=45n w=1.56u
Mmp36 n20 CKb n7 NW g45p1svt m=1 l=45n w=215n
Mmp35 n7 mout VDD NW g45p1svt m=1 l=45n w=215n
Mmp32 mout n20 n5 NW g45p1svt m=1 l=45n w=215n
Mmp31 n5 RNb VDD NW g45p1svt m=1 l=45n w=215n
Mmp22 RNb RN VDD NW g45p1svt m=1 l=45n w=215n
Mmp20 CKb CK VDD NW g45p1svt m=1 l=45n w=215n
Mmp21 CKbb CKb VDD NW g45p1svt m=1 l=45n w=215n
Mmp45 qbint n35 VDD NW g45p1svt m=1 l=45n w=620n
Mmp30 mout SN VDD NW g45p1svt m=1 l=45n w=215n
Mmp25 n20 CKbb Db NW g45p1svt m=1 l=45n w=215n
Mmp56 net573 qbint VDD NW g45p1svt m=1 l=45n w=390n
Mmp40 n35 CKb mout NW g45p1svt m=1 l=45n w=215n
Mmp53 n35 CKbb n11 NW g45p1svt m=1 l=45n w=215n
Mmp50 n11 SN VDD NW g45p1svt m=1 l=45n w=215n
Mmp10 SEb SE VDD NW g45p1svt m=1 l=45n w=215n
.ENDS

.SUBCKT SDFFSRXL CK D NW Q QN RN SE SI SN VDD VSS
*.PININFO CK:I D:I NW:I RN:I SE:I SI:I SN:I VDD:I VSS:I Q:O QN:O
Mmn13 n2 SI VSS VSS g45n1svt m=1 l=45n w=145n
Mmn14 Db SE n2 VSS g45n1svt m=1 l=45n w=145n
Mmn12 Db SEb n0 VSS g45n1svt m=1 l=45n w=145n
Mmn11 n0 D VSS VSS g45n1svt m=1 l=45n w=145n
Mmn57 QN net573 VSS VSS g45n1svt m=1 l=45n w=145n
Mmn55 Q qbint VSS VSS g45n1svt m=1 l=45n w=145n
Mmn35 n6 mout VSS VSS g45n1svt m=1 l=45n w=145n
Mmn36 n20 CKbb n6 VSS g45n1svt m=1 l=45n w=145n
Mmn22 RNb RN VSS VSS g45n1svt m=1 l=45n w=145n
Mmn20 CKb CK VSS VSS g45n1svt m=1 l=45n w=145n
Mmn10 SEb SE VSS VSS g45n1svt m=1 l=45n w=145n
Mmn56 net573 qbint VSS VSS g45n1svt m=1 l=45n w=145n
Mmn25 Db CKb n20 VSS g45n1svt m=1 l=45n w=145n
Mmn32 mout n20 n4 VSS g45n1svt m=1 l=45n w=145n
Mmn53 n35 CKb n10 VSS g45n1svt m=1 l=45n w=145n
Mmn30 n4 SN VSS VSS g45n1svt m=1 l=45n w=145n
Mmn50 n8 SN VSS VSS g45n1svt m=1 l=45n w=145n
Mmn51 n10 RNb n8 VSS g45n1svt m=1 l=45n w=145n
Mmn40 n35 CKbb mout VSS g45n1svt m=1 l=45n w=145n
Mmn31 mout RNb n4 VSS g45n1svt m=1 l=45n w=145n
Mmn21 CKbb CKb VSS VSS g45n1svt m=1 l=45n w=145n
Mmn52 n10 qbint n8 VSS g45n1svt m=1 l=45n w=145n
Mmn45 qbint n35 VSS VSS g45n1svt m=1 l=45n w=145n
Mmp14 Db SEb n3 NW g45p1svt m=1 l=45n w=215n
Mmp13 n3 SI VDD NW g45p1svt m=1 l=45n w=215n
Mmp12 Db SE n1 NW g45p1svt m=1 l=45n w=215n
Mmp11 n1 D VDD NW g45p1svt m=1 l=45n w=215n
Mmp52 n11 qbint n9 NW g45p1svt m=1 l=45n w=215n
Mmp51 n9 RNb VDD NW g45p1svt m=1 l=45n w=215n
Mmp57 QN net573 VDD NW g45p1svt m=1 l=45n w=215n
Mmp55 Q qbint VDD NW g45p1svt m=1 l=45n w=215n
Mmp36 n20 CKb n7 NW g45p1svt m=1 l=45n w=215n
Mmp35 n7 mout VDD NW g45p1svt m=1 l=45n w=215n
Mmp32 mout n20 n5 NW g45p1svt m=1 l=45n w=215n
Mmp31 n5 RNb VDD NW g45p1svt m=1 l=45n w=215n
Mmp22 RNb RN VDD NW g45p1svt m=1 l=45n w=215n
Mmp20 CKb CK VDD NW g45p1svt m=1 l=45n w=215n
Mmp21 CKbb CKb VDD NW g45p1svt m=1 l=45n w=215n
Mmp45 qbint n35 VDD NW g45p1svt m=1 l=45n w=215n
Mmp30 mout SN VDD NW g45p1svt m=1 l=45n w=215n
Mmp25 n20 CKbb Db NW g45p1svt m=1 l=45n w=215n
Mmp56 net573 qbint VDD NW g45p1svt m=1 l=45n w=215n
Mmp40 n35 CKb mout NW g45p1svt m=1 l=45n w=215n
Mmp53 n35 CKbb n11 NW g45p1svt m=1 l=45n w=215n
Mmp50 n11 SN VDD NW g45p1svt m=1 l=45n w=215n
Mmp10 SEb SE VDD NW g45p1svt m=1 l=45n w=215n
.ENDS

.SUBCKT SDFFSX1 CK D NW Q QN SE SI SN VDD VSS
*.PININFO CK:I D:I NW:I SE:I SI:I SN:I VDD:I VSS:I Q:O QN:O
Mmn51 net518 qbint net521 VSS g45n1svt m=1 l=45n w=145n
Mmn52 n35 CKb net518 VSS g45n1svt m=1 l=45n w=145n
Mmn50 net521 SN VSS VSS g45n1svt m=1 l=45n w=145n
Mmn13 net506 SI VSS VSS g45n1svt m=1 l=45n w=145n
Mmn14 Db SE net506 VSS g45n1svt m=1 l=45n w=145n
Mmn12 Db SEb net494 VSS g45n1svt m=1 l=45n w=145n
Mmn11 net494 D VSS VSS g45n1svt m=1 l=45n w=145n
Mmn57 QN net492 VSS VSS g45n1svt m=1 l=45n w=260n
Mmn55 Q qbint VSS VSS g45n1svt m=1 l=45n w=260n
Mmn31 mout n20 net442 VSS g45n1svt m=1 l=45n w=145n
Mmn35 net478 mout VSS VSS g45n1svt m=1 l=45n w=145n
Mmn36 n20 CKbb net478 VSS g45n1svt m=1 l=45n w=145n
Mmn20 CKb CK VSS VSS g45n1svt m=1 l=45n w=145n
Mmn45 qbint n35 VSS VSS g45n1svt m=1 l=45n w=145n
Mmn56 net492 qbint VSS VSS g45n1svt m=1 l=45n w=145n
Mmn21 CKbb CKb VSS VSS g45n1svt m=1 l=45n w=145n
Mmn40 n35 CKbb mout VSS g45n1svt m=1 l=45n w=145n
Mmn10 SEb SE VSS VSS g45n1svt m=1 l=45n w=145n
Mmn25 Db CKb n20 VSS g45n1svt m=1 l=45n w=145n
Mmn30 net442 SN VSS VSS g45n1svt m=1 l=45n w=145n
Mmp14 Db SEb net441 NW g45p1svt m=1 l=45n w=215n
Mmp13 net441 SI VDD NW g45p1svt m=1 l=45n w=215n
Mmp12 Db SE net433 NW g45p1svt m=1 l=45n w=215n
Mmp11 net433 D VDD NW g45p1svt m=1 l=45n w=215n
Mmp57 QN net492 VDD NW g45p1svt m=1 l=45n w=390n
Mmp55 Q qbint VDD NW g45p1svt m=1 l=45n w=390n
Mmp36 n20 CKb net417 NW g45p1svt m=1 l=45n w=215n
Mmp35 net417 mout VDD NW g45p1svt m=1 l=45n w=215n
Mmp20 CKb CK VDD NW g45p1svt m=1 l=45n w=215n
Mmp52 n35 CKbb net405 NW g45p1svt m=1 l=45n w=215n
Mmp51 net405 qbint VDD NW g45p1svt m=1 l=45n w=215n
Mmp50 net405 SN VDD NW g45p1svt m=1 l=45n w=215n
Mmp45 qbint n35 VDD NW g45p1svt m=1 l=45n w=215n
Mmp56 net492 qbint VDD NW g45p1svt m=1 l=45n w=215n
Mmp21 CKbb CKb VDD NW g45p1svt m=1 l=45n w=215n
Mmp40 n35 CKb mout NW g45p1svt m=1 l=45n w=215n
Mmp30 mout SN VDD NW g45p1svt m=1 l=45n w=215n
Mmp31 mout n20 VDD NW g45p1svt m=1 l=45n w=215n
Mmp25 n20 CKbb Db NW g45p1svt m=1 l=45n w=215n
Mmp10 SEb SE VDD NW g45p1svt m=1 l=45n w=215n
.ENDS

.SUBCKT SDFFSX2 CK D NW Q QN SE SI SN VDD VSS
*.PININFO CK:I D:I NW:I SE:I SI:I SN:I VDD:I VSS:I Q:O QN:O
Mmn51 net518 qbint net521 VSS g45n1svt m=1 l=45n w=145n
Mmn52 n35 CKb net518 VSS g45n1svt m=1 l=45n w=145n
Mmn50 net521 SN VSS VSS g45n1svt m=1 l=45n w=145n
Mmn13 net506 SI VSS VSS g45n1svt m=1 l=45n w=145n
Mmn14 Db SE net506 VSS g45n1svt m=1 l=45n w=145n
Mmn12 Db SEb net494 VSS g45n1svt m=1 l=45n w=145n
Mmn11 net494 D VSS VSS g45n1svt m=1 l=45n w=145n
Mmn57 QN net492 VSS VSS g45n1svt m=1 l=45n w=520n
Mmn55 Q qbint VSS VSS g45n1svt m=1 l=45n w=520n
Mmn31 mout n20 net442 VSS g45n1svt m=1 l=45n w=145n
Mmn35 net478 mout VSS VSS g45n1svt m=1 l=45n w=145n
Mmn36 n20 CKbb net478 VSS g45n1svt m=1 l=45n w=145n
Mmn20 CKb CK VSS VSS g45n1svt m=1 l=45n w=145n
Mmn45 qbint n35 VSS VSS g45n1svt m=1 l=45n w=205n
Mmn56 net492 qbint VSS VSS g45n1svt m=1 l=45n w=145n
Mmn21 CKbb CKb VSS VSS g45n1svt m=1 l=45n w=145n
Mmn40 n35 CKbb mout VSS g45n1svt m=1 l=45n w=145n
Mmn10 SEb SE VSS VSS g45n1svt m=1 l=45n w=145n
Mmn25 Db CKb n20 VSS g45n1svt m=1 l=45n w=145n
Mmn30 net442 SN VSS VSS g45n1svt m=1 l=45n w=145n
Mmp14 Db SEb net441 NW g45p1svt m=1 l=45n w=215n
Mmp13 net441 SI VDD NW g45p1svt m=1 l=45n w=215n
Mmp12 Db SE net433 NW g45p1svt m=1 l=45n w=215n
Mmp11 net433 D VDD NW g45p1svt m=1 l=45n w=215n
Mmp57 QN net492 VDD NW g45p1svt m=1 l=45n w=780n
Mmp55 Q qbint VDD NW g45p1svt m=1 l=45n w=780n
Mmp36 n20 CKb net417 NW g45p1svt m=1 l=45n w=215n
Mmp35 net417 mout VDD NW g45p1svt m=1 l=45n w=215n
Mmp20 CKb CK VDD NW g45p1svt m=1 l=45n w=215n
Mmp52 n35 CKbb net405 NW g45p1svt m=1 l=45n w=215n
Mmp51 net405 qbint VDD NW g45p1svt m=1 l=45n w=215n
Mmp50 net405 SN VDD NW g45p1svt m=1 l=45n w=215n
Mmp45 qbint n35 VDD NW g45p1svt m=1 l=45n w=310n
Mmp56 net492 qbint VDD NW g45p1svt m=1 l=45n w=215n
Mmp21 CKbb CKb VDD NW g45p1svt m=1 l=45n w=215n
Mmp40 n35 CKb mout NW g45p1svt m=1 l=45n w=215n
Mmp30 mout SN VDD NW g45p1svt m=1 l=45n w=215n
Mmp31 mout n20 VDD NW g45p1svt m=1 l=45n w=215n
Mmp25 n20 CKbb Db NW g45p1svt m=1 l=45n w=215n
Mmp10 SEb SE VDD NW g45p1svt m=1 l=45n w=215n
.ENDS

.SUBCKT SDFFSX4 CK D NW Q QN SE SI SN VDD VSS
*.PININFO CK:I D:I NW:I SE:I SI:I SN:I VDD:I VSS:I Q:O QN:O
Mmn51 net518 qbint net521 VSS g45n1svt m=1 l=45n w=145n
Mmn52 n35 CKb net518 VSS g45n1svt m=1 l=45n w=145n
Mmn50 net521 SN VSS VSS g45n1svt m=1 l=45n w=145n
Mmn13 net506 SI VSS VSS g45n1svt m=1 l=45n w=145n
Mmn14 Db SE net506 VSS g45n1svt m=1 l=45n w=145n
Mmn12 Db SEb net494 VSS g45n1svt m=1 l=45n w=145n
Mmn11 net494 D VSS VSS g45n1svt m=1 l=45n w=145n
Mmn57 QN net492 VSS VSS g45n1svt m=1 l=45n w=1.04u
Mmn55 Q qbint VSS VSS g45n1svt m=1 l=45n w=1.04u
Mmn31 mout n20 net442 VSS g45n1svt m=1 l=45n w=145n
Mmn35 net478 mout VSS VSS g45n1svt m=1 l=45n w=145n
Mmn36 n20 CKbb net478 VSS g45n1svt m=1 l=45n w=145n
Mmn20 CKb CK VSS VSS g45n1svt m=1 l=45n w=145n
Mmn45 qbint n35 VSS VSS g45n1svt m=1 l=45n w=410n
Mmn56 net492 qbint VSS VSS g45n1svt m=1 l=45n w=260n
Mmn21 CKbb CKb VSS VSS g45n1svt m=1 l=45n w=145n
Mmn40 n35 CKbb mout VSS g45n1svt m=1 l=45n w=145n
Mmn10 SEb SE VSS VSS g45n1svt m=1 l=45n w=145n
Mmn25 Db CKb n20 VSS g45n1svt m=1 l=45n w=145n
Mmn30 net442 SN VSS VSS g45n1svt m=1 l=45n w=145n
Mmp14 Db SEb net441 NW g45p1svt m=1 l=45n w=215n
Mmp13 net441 SI VDD NW g45p1svt m=1 l=45n w=215n
Mmp12 Db SE net433 NW g45p1svt m=1 l=45n w=215n
Mmp11 net433 D VDD NW g45p1svt m=1 l=45n w=215n
Mmp57 QN net492 VDD NW g45p1svt m=1 l=45n w=1.56u
Mmp55 Q qbint VDD NW g45p1svt m=1 l=45n w=1.56u
Mmp36 n20 CKb net417 NW g45p1svt m=1 l=45n w=215n
Mmp35 net417 mout VDD NW g45p1svt m=1 l=45n w=215n
Mmp20 CKb CK VDD NW g45p1svt m=1 l=45n w=215n
Mmp52 n35 CKbb net405 NW g45p1svt m=1 l=45n w=215n
Mmp51 net405 qbint VDD NW g45p1svt m=1 l=45n w=215n
Mmp50 net405 SN VDD NW g45p1svt m=1 l=45n w=215n
Mmp45 qbint n35 VDD NW g45p1svt m=1 l=45n w=620n
Mmp56 net492 qbint VDD NW g45p1svt m=1 l=45n w=390n
Mmp21 CKbb CKb VDD NW g45p1svt m=1 l=45n w=215n
Mmp40 n35 CKb mout NW g45p1svt m=1 l=45n w=215n
Mmp30 mout SN VDD NW g45p1svt m=1 l=45n w=215n
Mmp31 mout n20 VDD NW g45p1svt m=1 l=45n w=215n
Mmp25 n20 CKbb Db NW g45p1svt m=1 l=45n w=215n
Mmp10 SEb SE VDD NW g45p1svt m=1 l=45n w=215n
.ENDS

.SUBCKT SDFFSXL CK D NW Q QN SE SI SN VDD VSS
*.PININFO CK:I D:I NW:I SE:I SI:I SN:I VDD:I VSS:I Q:O QN:O
Mmn51 net518 qbint net521 VSS g45n1svt m=1 l=45n w=145n
Mmn52 n35 CKb net518 VSS g45n1svt m=1 l=45n w=145n
Mmn50 net521 SN VSS VSS g45n1svt m=1 l=45n w=145n
Mmn13 net506 SI VSS VSS g45n1svt m=1 l=45n w=145n
Mmn14 Db SE net506 VSS g45n1svt m=1 l=45n w=145n
Mmn12 Db SEb net494 VSS g45n1svt m=1 l=45n w=145n
Mmn11 net494 D VSS VSS g45n1svt m=1 l=45n w=145n
Mmn57 QN net492 VSS VSS g45n1svt m=1 l=45n w=145n
Mmn55 Q qbint VSS VSS g45n1svt m=1 l=45n w=145n
Mmn31 mout n20 net442 VSS g45n1svt m=1 l=45n w=145n
Mmn35 net478 mout VSS VSS g45n1svt m=1 l=45n w=145n
Mmn36 n20 CKbb net478 VSS g45n1svt m=1 l=45n w=145n
Mmn20 CKb CK VSS VSS g45n1svt m=1 l=45n w=145n
Mmn45 qbint n35 VSS VSS g45n1svt m=1 l=45n w=145n
Mmn56 net492 qbint VSS VSS g45n1svt m=1 l=45n w=145n
Mmn21 CKbb CKb VSS VSS g45n1svt m=1 l=45n w=145n
Mmn40 n35 CKbb mout VSS g45n1svt m=1 l=45n w=145n
Mmn10 SEb SE VSS VSS g45n1svt m=1 l=45n w=145n
Mmn25 Db CKb n20 VSS g45n1svt m=1 l=45n w=145n
Mmn30 net442 SN VSS VSS g45n1svt m=1 l=45n w=145n
Mmp14 Db SEb net441 NW g45p1svt m=1 l=45n w=215n
Mmp13 net441 SI VDD NW g45p1svt m=1 l=45n w=215n
Mmp12 Db SE net433 NW g45p1svt m=1 l=45n w=215n
Mmp11 net433 D VDD NW g45p1svt m=1 l=45n w=215n
Mmp57 QN net492 VDD NW g45p1svt m=1 l=45n w=215n
Mmp55 Q qbint VDD NW g45p1svt m=1 l=45n w=215n
Mmp36 n20 CKb net417 NW g45p1svt m=1 l=45n w=215n
Mmp35 net417 mout VDD NW g45p1svt m=1 l=45n w=215n
Mmp20 CKb CK VDD NW g45p1svt m=1 l=45n w=215n
Mmp52 n35 CKbb net405 NW g45p1svt m=1 l=45n w=215n
Mmp51 net405 qbint VDD NW g45p1svt m=1 l=45n w=215n
Mmp50 net405 SN VDD NW g45p1svt m=1 l=45n w=215n
Mmp45 qbint n35 VDD NW g45p1svt m=1 l=45n w=215n
Mmp56 net492 qbint VDD NW g45p1svt m=1 l=45n w=215n
Mmp21 CKbb CKb VDD NW g45p1svt m=1 l=45n w=215n
Mmp40 n35 CKb mout NW g45p1svt m=1 l=45n w=215n
Mmp30 mout SN VDD NW g45p1svt m=1 l=45n w=215n
Mmp31 mout n20 VDD NW g45p1svt m=1 l=45n w=215n
Mmp25 n20 CKbb Db NW g45p1svt m=1 l=45n w=215n
Mmp10 SEb SE VDD NW g45p1svt m=1 l=45n w=215n
.ENDS

.SUBCKT SDFFTRX1 CK D NW Q QN RN SE SI VDD VSS
*.PININFO CK:I D:I NW:I RN:I SE:I SI:I VDD:I VSS:I Q:O QN:O
Mmn12 net484 SI VSS VSS g45n1svt m=1 l=45n w=145n
Mmn13 Dbp SE net484 VSS g45n1svt m=1 l=45n w=145n
Mmn0 net476 RN VSS VSS g45n1svt m=1 l=45n w=145n
Mmn1 Db D net476 VSS g45n1svt m=1 l=45n w=145n
Mmn57 QN net436 VSS VSS g45n1svt m=1 l=45n w=260n
Mmn55 Q qbint VSS VSS g45n1svt m=1 l=45n w=260n
Mmn50 net460 qbint VSS VSS g45n1svt m=1 l=45n w=145n
Mmn51 n30 CKb net460 VSS g45n1svt m=1 l=45n w=145n
Mmn35 net452 mout VSS VSS g45n1svt m=1 l=45n w=145n
Mmn36 n20 CKbb net452 VSS g45n1svt m=1 l=45n w=145n
Mmn20 CKb CK VSS VSS g45n1svt m=1 l=45n w=145n
Mmn45 qbint n30 VSS VSS g45n1svt m=1 l=45n w=145n
Mmn56 net436 qbint VSS VSS g45n1svt m=1 l=45n w=145n
Mmn11 Db SEb Dbp VSS g45n1svt m=1 l=45n w=145n
Mmn21 CKbb CKb VSS VSS g45n1svt m=1 l=45n w=145n
Mmn30 mout n20 VSS VSS g45n1svt m=1 l=45n w=145n
Mmn10 SEb SE VSS VSS g45n1svt m=1 l=45n w=145n
Mmn25 Dbp CKb n20 VSS g45n1svt m=1 l=45n w=145n
Mmn40 n30 CKbb mout VSS g45n1svt m=1 l=45n w=145n
Mmp13 Dbp SEb net411 NW g45p1svt m=1 l=45n w=215n
Mmp12 net411 SI VDD NW g45p1svt m=1 l=45n w=215n
Mmp1 Db D VDD NW g45p1svt m=1 l=45n w=215n
Mmp0 Db RN VDD NW g45p1svt m=1 l=45n w=215n
Mmp51 n30 CKbb net395 NW g45p1svt m=1 l=45n w=215n
Mmp50 net395 qbint VDD NW g45p1svt m=1 l=45n w=215n
Mmp57 QN net436 VDD NW g45p1svt m=1 l=45n w=390n
Mmp55 Q qbint VDD NW g45p1svt m=1 l=45n w=390n
Mmp35 net375 mout VDD NW g45p1svt m=1 l=45n w=215n
Mmp36 n20 CKb net375 NW g45p1svt m=1 l=45n w=215n
Mmp20 CKb CK VDD NW g45p1svt m=1 l=45n w=215n
Mmp45 qbint n30 VDD NW g45p1svt m=1 l=45n w=215n
Mmp56 net436 qbint VDD NW g45p1svt m=1 l=45n w=215n
Mmp25 n20 CKbb Dbp NW g45p1svt m=1 l=45n w=215n
Mmp11 Dbp SE Db NW g45p1svt m=1 l=45n w=215n
Mmp10 SEb SE VDD NW g45p1svt m=1 l=45n w=215n
Mmp21 CKbb CKb VDD NW g45p1svt m=1 l=45n w=215n
Mmp30 mout n20 VDD NW g45p1svt m=1 l=45n w=215n
Mmp40 n30 CKb mout NW g45p1svt m=1 l=45n w=215n
.ENDS

.SUBCKT SDFFTRX2 CK D NW Q QN RN SE SI VDD VSS
*.PININFO CK:I D:I NW:I RN:I SE:I SI:I VDD:I VSS:I Q:O QN:O
Mmn12 net484 SI VSS VSS g45n1svt m=1 l=45n w=145n
Mmn13 Dbp SE net484 VSS g45n1svt m=1 l=45n w=145n
Mmn0 net476 RN VSS VSS g45n1svt m=1 l=45n w=145n
Mmn1 Db D net476 VSS g45n1svt m=1 l=45n w=145n
Mmn57 QN net436 VSS VSS g45n1svt m=1 l=45n w=520n
Mmn55 Q qbint VSS VSS g45n1svt m=1 l=45n w=520n
Mmn50 net460 qbint VSS VSS g45n1svt m=1 l=45n w=145n
Mmn51 n30 CKb net460 VSS g45n1svt m=1 l=45n w=145n
Mmn35 net452 mout VSS VSS g45n1svt m=1 l=45n w=145n
Mmn36 n20 CKbb net452 VSS g45n1svt m=1 l=45n w=145n
Mmn20 CKb CK VSS VSS g45n1svt m=1 l=45n w=145n
Mmn45 qbint n30 VSS VSS g45n1svt m=1 l=45n w=205n
Mmn56 net436 qbint VSS VSS g45n1svt m=1 l=45n w=145n
Mmn11 Db SEb Dbp VSS g45n1svt m=1 l=45n w=145n
Mmn21 CKbb CKb VSS VSS g45n1svt m=1 l=45n w=145n
Mmn30 mout n20 VSS VSS g45n1svt m=1 l=45n w=145n
Mmn10 SEb SE VSS VSS g45n1svt m=1 l=45n w=145n
Mmn25 Dbp CKb n20 VSS g45n1svt m=1 l=45n w=145n
Mmn40 n30 CKbb mout VSS g45n1svt m=1 l=45n w=145n
Mmp13 Dbp SEb net411 NW g45p1svt m=1 l=45n w=215n
Mmp12 net411 SI VDD NW g45p1svt m=1 l=45n w=215n
Mmp1 Db D VDD NW g45p1svt m=1 l=45n w=215n
Mmp0 Db RN VDD NW g45p1svt m=1 l=45n w=215n
Mmp51 n30 CKbb net395 NW g45p1svt m=1 l=45n w=215n
Mmp50 net395 qbint VDD NW g45p1svt m=1 l=45n w=215n
Mmp57 QN net436 VDD NW g45p1svt m=1 l=45n w=780n
Mmp55 Q qbint VDD NW g45p1svt m=1 l=45n w=780n
Mmp35 net375 mout VDD NW g45p1svt m=1 l=45n w=215n
Mmp36 n20 CKb net375 NW g45p1svt m=1 l=45n w=215n
Mmp20 CKb CK VDD NW g45p1svt m=1 l=45n w=215n
Mmp45 qbint n30 VDD NW g45p1svt m=1 l=45n w=310n
Mmp56 net436 qbint VDD NW g45p1svt m=1 l=45n w=215n
Mmp25 n20 CKbb Dbp NW g45p1svt m=1 l=45n w=215n
Mmp11 Dbp SE Db NW g45p1svt m=1 l=45n w=215n
Mmp10 SEb SE VDD NW g45p1svt m=1 l=45n w=215n
Mmp21 CKbb CKb VDD NW g45p1svt m=1 l=45n w=215n
Mmp30 mout n20 VDD NW g45p1svt m=1 l=45n w=215n
Mmp40 n30 CKb mout NW g45p1svt m=1 l=45n w=215n
.ENDS

.SUBCKT SDFFTRX4 CK D NW Q QN RN SE SI VDD VSS
*.PININFO CK:I D:I NW:I RN:I SE:I SI:I VDD:I VSS:I Q:O QN:O
Mmn12 net484 SI VSS VSS g45n1svt m=1 l=45n w=145n
Mmn13 Dbp SE net484 VSS g45n1svt m=1 l=45n w=145n
Mmn0 net476 RN VSS VSS g45n1svt m=1 l=45n w=145n
Mmn1 Db D net476 VSS g45n1svt m=1 l=45n w=145n
Mmn57 QN net436 VSS VSS g45n1svt m=1 l=45n w=1.04u
Mmn55 Q qbint VSS VSS g45n1svt m=1 l=45n w=1.04u
Mmn50 net460 qbint VSS VSS g45n1svt m=1 l=45n w=145n
Mmn51 n30 CKb net460 VSS g45n1svt m=1 l=45n w=145n
Mmn35 net452 mout VSS VSS g45n1svt m=1 l=45n w=145n
Mmn36 n20 CKbb net452 VSS g45n1svt m=1 l=45n w=145n
Mmn20 CKb CK VSS VSS g45n1svt m=1 l=45n w=145n
Mmn45 qbint n30 VSS VSS g45n1svt m=1 l=45n w=410n
Mmn56 net436 qbint VSS VSS g45n1svt m=1 l=45n w=260n
Mmn11 Db SEb Dbp VSS g45n1svt m=1 l=45n w=145n
Mmn21 CKbb CKb VSS VSS g45n1svt m=1 l=45n w=145n
Mmn30 mout n20 VSS VSS g45n1svt m=1 l=45n w=145n
Mmn10 SEb SE VSS VSS g45n1svt m=1 l=45n w=145n
Mmn25 Dbp CKb n20 VSS g45n1svt m=1 l=45n w=145n
Mmn40 n30 CKbb mout VSS g45n1svt m=1 l=45n w=145n
Mmp13 Dbp SEb net411 NW g45p1svt m=1 l=45n w=215n
Mmp12 net411 SI VDD NW g45p1svt m=1 l=45n w=215n
Mmp1 Db D VDD NW g45p1svt m=1 l=45n w=215n
Mmp0 Db RN VDD NW g45p1svt m=1 l=45n w=215n
Mmp51 n30 CKbb net395 NW g45p1svt m=1 l=45n w=215n
Mmp50 net395 qbint VDD NW g45p1svt m=1 l=45n w=215n
Mmp57 QN net436 VDD NW g45p1svt m=1 l=45n w=1.56u
Mmp55 Q qbint VDD NW g45p1svt m=1 l=45n w=1.56u
Mmp35 net375 mout VDD NW g45p1svt m=1 l=45n w=215n
Mmp36 n20 CKb net375 NW g45p1svt m=1 l=45n w=215n
Mmp20 CKb CK VDD NW g45p1svt m=1 l=45n w=215n
Mmp45 qbint n30 VDD NW g45p1svt m=1 l=45n w=620n
Mmp56 net436 qbint VDD NW g45p1svt m=1 l=45n w=390n
Mmp25 n20 CKbb Dbp NW g45p1svt m=1 l=45n w=215n
Mmp11 Dbp SE Db NW g45p1svt m=1 l=45n w=215n
Mmp10 SEb SE VDD NW g45p1svt m=1 l=45n w=215n
Mmp21 CKbb CKb VDD NW g45p1svt m=1 l=45n w=215n
Mmp30 mout n20 VDD NW g45p1svt m=1 l=45n w=215n
Mmp40 n30 CKb mout NW g45p1svt m=1 l=45n w=215n
.ENDS

.SUBCKT SDFFTRXL CK D NW Q QN RN SE SI VDD VSS
*.PININFO CK:I D:I NW:I RN:I SE:I SI:I VDD:I VSS:I Q:O QN:O
Mmn12 net484 SI VSS VSS g45n1svt m=1 l=45n w=145n
Mmn13 Dbp SE net484 VSS g45n1svt m=1 l=45n w=145n
Mmn0 net476 RN VSS VSS g45n1svt m=1 l=45n w=145n
Mmn1 Db D net476 VSS g45n1svt m=1 l=45n w=145n
Mmn57 QN net436 VSS VSS g45n1svt m=1 l=45n w=145n
Mmn55 Q qbint VSS VSS g45n1svt m=1 l=45n w=145n
Mmn50 net460 qbint VSS VSS g45n1svt m=1 l=45n w=145n
Mmn51 n30 CKb net460 VSS g45n1svt m=1 l=45n w=145n
Mmn35 net452 mout VSS VSS g45n1svt m=1 l=45n w=145n
Mmn36 n20 CKbb net452 VSS g45n1svt m=1 l=45n w=145n
Mmn20 CKb CK VSS VSS g45n1svt m=1 l=45n w=145n
Mmn45 qbint n30 VSS VSS g45n1svt m=1 l=45n w=145n
Mmn56 net436 qbint VSS VSS g45n1svt m=1 l=45n w=145n
Mmn11 Db SEb Dbp VSS g45n1svt m=1 l=45n w=145n
Mmn21 CKbb CKb VSS VSS g45n1svt m=1 l=45n w=145n
Mmn30 mout n20 VSS VSS g45n1svt m=1 l=45n w=145n
Mmn10 SEb SE VSS VSS g45n1svt m=1 l=45n w=145n
Mmn25 Dbp CKb n20 VSS g45n1svt m=1 l=45n w=145n
Mmn40 n30 CKbb mout VSS g45n1svt m=1 l=45n w=145n
Mmp13 Dbp SEb net411 NW g45p1svt m=1 l=45n w=215n
Mmp12 net411 SI VDD NW g45p1svt m=1 l=45n w=215n
Mmp1 Db D VDD NW g45p1svt m=1 l=45n w=215n
Mmp0 Db RN VDD NW g45p1svt m=1 l=45n w=215n
Mmp51 n30 CKbb net395 NW g45p1svt m=1 l=45n w=215n
Mmp50 net395 qbint VDD NW g45p1svt m=1 l=45n w=215n
Mmp57 QN net436 VDD NW g45p1svt m=1 l=45n w=215n
Mmp55 Q qbint VDD NW g45p1svt m=1 l=45n w=215n
Mmp35 net375 mout VDD NW g45p1svt m=1 l=45n w=215n
Mmp36 n20 CKb net375 NW g45p1svt m=1 l=45n w=215n
Mmp20 CKb CK VDD NW g45p1svt m=1 l=45n w=215n
Mmp45 qbint n30 VDD NW g45p1svt m=1 l=45n w=215n
Mmp56 net436 qbint VDD NW g45p1svt m=1 l=45n w=215n
Mmp25 n20 CKbb Dbp NW g45p1svt m=1 l=45n w=215n
Mmp11 Dbp SE Db NW g45p1svt m=1 l=45n w=215n
Mmp10 SEb SE VDD NW g45p1svt m=1 l=45n w=215n
Mmp21 CKbb CKb VDD NW g45p1svt m=1 l=45n w=215n
Mmp30 mout n20 VDD NW g45p1svt m=1 l=45n w=215n
Mmp40 n30 CKb mout NW g45p1svt m=1 l=45n w=215n
.ENDS

.SUBCKT SDFFX1 CK D NW Q QN SE SI VDD VSS
*.PININFO CK:I D:I NW:I SE:I SI:I VDD:I VSS:I Q:O QN:O
Mmn13 net461 SI VSS VSS g45n1svt m=1 l=45n w=145n
Mmn14 Db SE net461 VSS g45n1svt m=1 l=45n w=145n
Mmn12 Db SEb net449 VSS g45n1svt m=1 l=45n w=145n
Mmn11 net449 D VSS VSS g45n1svt m=1 l=45n w=145n
Mmn57 QN net367 VSS VSS g45n1svt m=1 l=45n w=260n
Mmn55 Q qbint VSS VSS g45n1svt m=1 l=45n w=260n
Mmn50 net436 qbint VSS VSS g45n1svt m=1 l=45n w=145n
Mmn51 n30 CKb net436 VSS g45n1svt m=1 l=45n w=145n
Mmn35 net429 mout VSS VSS g45n1svt m=1 l=45n w=145n
Mmn36 n20 CKbb net429 VSS g45n1svt m=1 l=45n w=145n
Mmn20 CKb CK VSS VSS g45n1svt m=1 l=45n w=145n
Mmn45 qbint n30 VSS VSS g45n1svt m=1 l=45n w=145n
Mmn56 net367 qbint VSS VSS g45n1svt m=1 l=45n w=145n
Mmn21 CKbb CKb VSS VSS g45n1svt m=1 l=45n w=145n
Mmn40 n30 CKbb mout VSS g45n1svt m=1 l=45n w=145n
Mmn30 mout n20 VSS VSS g45n1svt m=1 l=45n w=145n
Mmn10 SEb SE VSS VSS g45n1svt m=1 l=45n w=145n
Mmn25 n20 CKb Db VSS g45n1svt m=1 l=45n w=145n
Mmp14 Db SEb net392 NW g45p1svt m=1 l=45n w=215n
Mmp13 net392 SI VDD NW g45p1svt m=1 l=45n w=215n
Mmp12 Db SE net384 NW g45p1svt m=1 l=45n w=215n
Mmp11 net384 D VDD NW g45p1svt m=1 l=45n w=215n
Mmp51 n30 CKbb net376 NW g45p1svt m=1 l=45n w=215n
Mmp50 net376 qbint VDD NW g45p1svt m=1 l=45n w=215n
Mmp57 QN net367 VDD NW g45p1svt m=1 l=45n w=390n
Mmp55 Q qbint VDD NW g45p1svt m=1 l=45n w=390n
Mmp35 net356 mout VDD NW g45p1svt m=1 l=45n w=215n
Mmp36 n20 CKb net356 NW g45p1svt m=1 l=45n w=215n
Mmp20 CKb CK VDD NW g45p1svt m=1 l=45n w=215n
Mmp45 qbint n30 VDD NW g45p1svt m=1 l=45n w=215n
Mmp56 net367 qbint VDD NW g45p1svt m=1 l=45n w=215n
Mmp21 CKbb CKb VDD NW g45p1svt m=1 l=45n w=215n
Mmp40 n30 CKb mout NW g45p1svt m=1 l=45n w=215n
Mmp30 mout n20 VDD NW g45p1svt m=1 l=45n w=215n
Mmp25 n20 CKbb Db NW g45p1svt m=1 l=45n w=215n
Mmp10 SEb SE VDD NW g45p1svt m=1 l=45n w=215n
.ENDS

.SUBCKT SDFFX2 CK D NW Q QN SE SI VDD VSS
*.PININFO CK:I D:I NW:I SE:I SI:I VDD:I VSS:I Q:O QN:O
Mmn13 net461 SI VSS VSS g45n1svt m=1 l=45n w=145n
Mmn14 Db SE net461 VSS g45n1svt m=1 l=45n w=145n
Mmn12 Db SEb net449 VSS g45n1svt m=1 l=45n w=145n
Mmn11 net449 D VSS VSS g45n1svt m=1 l=45n w=145n
Mmn57 QN net367 VSS VSS g45n1svt m=1 l=45n w=520n
Mmn55 Q qbint VSS VSS g45n1svt m=1 l=45n w=520n
Mmn50 net436 qbint VSS VSS g45n1svt m=1 l=45n w=145n
Mmn51 n30 CKb net436 VSS g45n1svt m=1 l=45n w=145n
Mmn35 net429 mout VSS VSS g45n1svt m=1 l=45n w=145n
Mmn36 n20 CKbb net429 VSS g45n1svt m=1 l=45n w=145n
Mmn20 CKb CK VSS VSS g45n1svt m=1 l=45n w=145n
Mmn45 qbint n30 VSS VSS g45n1svt m=1 l=45n w=205n
Mmn56 net367 qbint VSS VSS g45n1svt m=1 l=45n w=145n
Mmn21 CKbb CKb VSS VSS g45n1svt m=1 l=45n w=145n
Mmn40 n30 CKbb mout VSS g45n1svt m=1 l=45n w=145n
Mmn30 mout n20 VSS VSS g45n1svt m=1 l=45n w=145n
Mmn10 SEb SE VSS VSS g45n1svt m=1 l=45n w=145n
Mmn25 n20 CKb Db VSS g45n1svt m=1 l=45n w=145n
Mmp14 Db SEb net392 NW g45p1svt m=1 l=45n w=215n
Mmp13 net392 SI VDD NW g45p1svt m=1 l=45n w=215n
Mmp12 Db SE net384 NW g45p1svt m=1 l=45n w=215n
Mmp11 net384 D VDD NW g45p1svt m=1 l=45n w=215n
Mmp51 n30 CKbb net376 NW g45p1svt m=1 l=45n w=215n
Mmp50 net376 qbint VDD NW g45p1svt m=1 l=45n w=215n
Mmp57 QN net367 VDD NW g45p1svt m=1 l=45n w=780n
Mmp55 Q qbint VDD NW g45p1svt m=1 l=45n w=780n
Mmp35 net356 mout VDD NW g45p1svt m=1 l=45n w=215n
Mmp36 n20 CKb net356 NW g45p1svt m=1 l=45n w=215n
Mmp20 CKb CK VDD NW g45p1svt m=1 l=45n w=215n
Mmp45 qbint n30 VDD NW g45p1svt m=1 l=45n w=310n
Mmp56 net367 qbint VDD NW g45p1svt m=1 l=45n w=215n
Mmp21 CKbb CKb VDD NW g45p1svt m=1 l=45n w=215n
Mmp40 n30 CKb mout NW g45p1svt m=1 l=45n w=215n
Mmp30 mout n20 VDD NW g45p1svt m=1 l=45n w=215n
Mmp25 n20 CKbb Db NW g45p1svt m=1 l=45n w=215n
Mmp10 SEb SE VDD NW g45p1svt m=1 l=45n w=215n
.ENDS

.SUBCKT SDFFX4 CK D NW Q QN SE SI VDD VSS
*.PININFO CK:I D:I NW:I SE:I SI:I VDD:I VSS:I Q:O QN:O
Mmn13 net461 SI VSS VSS g45n1svt m=1 l=45n w=145n
Mmn14 Db SE net461 VSS g45n1svt m=1 l=45n w=145n
Mmn12 Db SEb net449 VSS g45n1svt m=1 l=45n w=145n
Mmn11 net449 D VSS VSS g45n1svt m=1 l=45n w=145n
Mmn57 QN net367 VSS VSS g45n1svt m=1 l=45n w=1.04u
Mmn55 Q qbint VSS VSS g45n1svt m=1 l=45n w=1.04u
Mmn50 net436 qbint VSS VSS g45n1svt m=1 l=45n w=145n
Mmn51 n30 CKb net436 VSS g45n1svt m=1 l=45n w=145n
Mmn35 net429 mout VSS VSS g45n1svt m=1 l=45n w=145n
Mmn36 n20 CKbb net429 VSS g45n1svt m=1 l=45n w=145n
Mmn20 CKb CK VSS VSS g45n1svt m=1 l=45n w=145n
Mmn45 qbint n30 VSS VSS g45n1svt m=1 l=45n w=410n
Mmn56 net367 qbint VSS VSS g45n1svt m=1 l=45n w=260n
Mmn21 CKbb CKb VSS VSS g45n1svt m=1 l=45n w=145n
Mmn40 n30 CKbb mout VSS g45n1svt m=1 l=45n w=145n
Mmn30 mout n20 VSS VSS g45n1svt m=1 l=45n w=145n
Mmn10 SEb SE VSS VSS g45n1svt m=1 l=45n w=145n
Mmn25 n20 CKb Db VSS g45n1svt m=1 l=45n w=145n
Mmp14 Db SEb net392 NW g45p1svt m=1 l=45n w=215n
Mmp13 net392 SI VDD NW g45p1svt m=1 l=45n w=215n
Mmp12 Db SE net384 NW g45p1svt m=1 l=45n w=215n
Mmp11 net384 D VDD NW g45p1svt m=1 l=45n w=215n
Mmp51 n30 CKbb net376 NW g45p1svt m=1 l=45n w=215n
Mmp50 net376 qbint VDD NW g45p1svt m=1 l=45n w=215n
Mmp57 QN net367 VDD NW g45p1svt m=1 l=45n w=1.56u
Mmp55 Q qbint VDD NW g45p1svt m=1 l=45n w=1.56u
Mmp35 net356 mout VDD NW g45p1svt m=1 l=45n w=215n
Mmp36 n20 CKb net356 NW g45p1svt m=1 l=45n w=215n
Mmp20 CKb CK VDD NW g45p1svt m=1 l=45n w=215n
Mmp45 qbint n30 VDD NW g45p1svt m=1 l=45n w=620n
Mmp56 net367 qbint VDD NW g45p1svt m=1 l=45n w=390n
Mmp21 CKbb CKb VDD NW g45p1svt m=1 l=45n w=215n
Mmp40 n30 CKb mout NW g45p1svt m=1 l=45n w=215n
Mmp30 mout n20 VDD NW g45p1svt m=1 l=45n w=215n
Mmp25 n20 CKbb Db NW g45p1svt m=1 l=45n w=215n
Mmp10 SEb SE VDD NW g45p1svt m=1 l=45n w=215n
.ENDS

.SUBCKT SDFFXL CK D NW Q QN SE SI VDD VSS
*.PININFO CK:I D:I NW:I SE:I SI:I VDD:I VSS:I Q:O QN:O
Mmn13 net461 SI VSS VSS g45n1svt m=1 l=45n w=145n
Mmn14 Db SE net461 VSS g45n1svt m=1 l=45n w=145n
Mmn12 Db SEb net449 VSS g45n1svt m=1 l=45n w=145n
Mmn11 net449 D VSS VSS g45n1svt m=1 l=45n w=145n
Mmn57 QN net367 VSS VSS g45n1svt m=1 l=45n w=145n
Mmn55 Q qbint VSS VSS g45n1svt m=1 l=45n w=145n
Mmn50 net436 qbint VSS VSS g45n1svt m=1 l=45n w=145n
Mmn51 n30 CKb net436 VSS g45n1svt m=1 l=45n w=145n
Mmn35 net429 mout VSS VSS g45n1svt m=1 l=45n w=145n
Mmn36 n20 CKbb net429 VSS g45n1svt m=1 l=45n w=145n
Mmn20 CKb CK VSS VSS g45n1svt m=1 l=45n w=145n
Mmn45 qbint n30 VSS VSS g45n1svt m=1 l=45n w=145n
Mmn56 net367 qbint VSS VSS g45n1svt m=1 l=45n w=145n
Mmn21 CKbb CKb VSS VSS g45n1svt m=1 l=45n w=145n
Mmn40 n30 CKbb mout VSS g45n1svt m=1 l=45n w=145n
Mmn30 mout n20 VSS VSS g45n1svt m=1 l=45n w=145n
Mmn10 SEb SE VSS VSS g45n1svt m=1 l=45n w=145n
Mmn25 n20 CKb Db VSS g45n1svt m=1 l=45n w=145n
Mmp14 Db SEb net392 NW g45p1svt m=1 l=45n w=215n
Mmp13 net392 SI VDD NW g45p1svt m=1 l=45n w=215n
Mmp12 Db SE net384 NW g45p1svt m=1 l=45n w=215n
Mmp11 net384 D VDD NW g45p1svt m=1 l=45n w=215n
Mmp51 n30 CKbb net376 NW g45p1svt m=1 l=45n w=215n
Mmp50 net376 qbint VDD NW g45p1svt m=1 l=45n w=215n
Mmp57 QN net367 VDD NW g45p1svt m=1 l=45n w=215n
Mmp55 Q qbint VDD NW g45p1svt m=1 l=45n w=215n
Mmp35 net356 mout VDD NW g45p1svt m=1 l=45n w=215n
Mmp36 n20 CKb net356 NW g45p1svt m=1 l=45n w=215n
Mmp20 CKb CK VDD NW g45p1svt m=1 l=45n w=215n
Mmp45 qbint n30 VDD NW g45p1svt m=1 l=45n w=215n
Mmp56 net367 qbint VDD NW g45p1svt m=1 l=45n w=215n
Mmp21 CKbb CKb VDD NW g45p1svt m=1 l=45n w=215n
Mmp40 n30 CKb mout NW g45p1svt m=1 l=45n w=215n
Mmp30 mout n20 VDD NW g45p1svt m=1 l=45n w=215n
Mmp25 n20 CKbb Db NW g45p1svt m=1 l=45n w=215n
Mmp10 SEb SE VDD NW g45p1svt m=1 l=45n w=215n
.ENDS

.SUBCKT SEDFFHQX1 CK D E NW Q SE SI VDD VSS
*.PININFO CK:I D:I E:I NW:I SE:I SI:I VDD:I VSS:I Q:O
Mmn4 Db E net526 VSS g45n1svt m=1 l=45n w=260n
Mmn3 net526 D VSS VSS g45n1svt m=1 l=45n w=260n
Mmn13 Dbp SE net518 VSS g45n1svt m=1 l=45n w=260n
Mmn12 net518 SI VSS VSS g45n1svt m=1 l=45n w=260n
Mmn55 Q qbint VSS VSS g45n1svt m=1 l=45n w=260n
Mmn50 net509 qbint VSS VSS g45n1svt m=1 l=45n w=205n
Mmn51 n30 CKb net509 VSS g45n1svt m=1 l=45n w=205n
Mmn35 net501 mout VSS VSS g45n1svt m=1 l=45n w=205n
Mmn36 n20 Ckbb net501 VSS g45n1svt m=1 l=45n w=205n
Mmn1 net494 qint VSS VSS g45n1svt m=1 l=45n w=260n
Mmn2 Db Eb net494 VSS g45n1svt m=1 l=45n w=260n
Mmn45 qbint n30 VSS VSS g45n1svt m=1 l=45n w=205n
Mmn56 qint qbint VSS VSS g45n1svt m=1 l=45n w=205n
Mmn21 Ckbb CKb VSS VSS g45n1svt m=1 l=45n w=145n
Mmn40 n30 Ckbb mout VSS g45n1svt m=1 l=45n w=205n
Mmn30 mout n20 VSS VSS g45n1svt m=1 l=45n w=205n
Mmn10 SEb SE VSS VSS g45n1svt m=1 l=45n w=145n
Mmn0 Eb E VSS VSS g45n1svt m=1 l=45n w=145n
Mmn25 n20 CKb Dbp VSS g45n1svt m=1 l=45n w=205n
Mmn20 CKb CK VSS VSS g45n1svt m=1 l=45n w=145n
Mmn11 Db SEb Dbp VSS g45n1svt m=1 l=45n w=260n
Mmp4 Db Eb net449 NW g45p1svt m=1 l=45n w=390n
Mmp3 net449 D VDD NW g45p1svt m=1 l=45n w=390n
Mmp13 Dbp SEb net441 NW g45p1svt m=1 l=45n w=390n
Mmp12 net441 SI VDD NW g45p1svt m=1 l=45n w=390n
Mmp51 n30 Ckbb net426 NW g45p1svt m=1 l=45n w=310n
Mmp50 net426 qbint VDD NW g45p1svt m=1 l=45n w=310n
Mmp55 Q qbint VDD NW g45p1svt m=1 l=45n w=390n
Mmp35 net417 mout VDD NW g45p1svt m=1 l=45n w=310n
Mmp36 n20 CKb net417 NW g45p1svt m=1 l=45n w=310n
Mmp20 CKb CK VDD NW g45p1svt m=1 l=45n w=215n
Mmp1 net405 qint VDD NW g45p1svt m=1 l=45n w=390n
Mmp2 Db E net405 NW g45p1svt m=1 l=45n w=390n
Mmp45 qbint n30 VDD NW g45p1svt m=1 l=45n w=310n
Mmp56 qint qbint VDD NW g45p1svt m=1 l=45n w=310n
Mmp21 Ckbb CKb VDD NW g45p1svt m=1 l=45n w=215n
Mmp40 n30 CKb mout NW g45p1svt m=1 l=45n w=310n
Mmp30 mout n20 VDD NW g45p1svt m=1 l=45n w=310n
Mmp11 Db SE Dbp NW g45p1svt m=1 l=45n w=390n
Mmp10 SEb SE VDD NW g45p1svt m=1 l=45n w=215n
Mmp0 Eb E VDD NW g45p1svt m=1 l=45n w=215n
Mmp25 n20 Ckbb Dbp NW g45p1svt m=1 l=45n w=310n
.ENDS

.SUBCKT SEDFFHQX2 CK D E NW Q SE SI VDD VSS
*.PININFO CK:I D:I E:I NW:I SE:I SI:I VDD:I VSS:I Q:O
Mmn4 Db E net526 VSS g45n1svt m=1 l=45n w=260n
Mmn3 net526 D VSS VSS g45n1svt m=1 l=45n w=260n
Mmn13 Dbp SE net518 VSS g45n1svt m=1 l=45n w=260n
Mmn12 net518 SI VSS VSS g45n1svt m=1 l=45n w=260n
Mmn55 Q qbint VSS VSS g45n1svt m=1 l=45n w=520n
Mmn50 net509 qbint VSS VSS g45n1svt m=1 l=45n w=205n
Mmn51 n30 CKb net509 VSS g45n1svt m=1 l=45n w=205n
Mmn35 net501 mout VSS VSS g45n1svt m=1 l=45n w=205n
Mmn36 n20 Ckbb net501 VSS g45n1svt m=1 l=45n w=205n
Mmn1 net494 qint VSS VSS g45n1svt m=1 l=45n w=260n
Mmn2 Db Eb net494 VSS g45n1svt m=1 l=45n w=260n
Mmn45 qbint n30 VSS VSS g45n1svt m=1 l=45n w=260n
Mmn56 qint qbint VSS VSS g45n1svt m=1 l=45n w=205n
Mmn21 Ckbb CKb VSS VSS g45n1svt m=1 l=45n w=145n
Mmn40 n30 Ckbb mout VSS g45n1svt m=1 l=45n w=205n
Mmn30 mout n20 VSS VSS g45n1svt m=1 l=45n w=205n
Mmn10 SEb SE VSS VSS g45n1svt m=1 l=45n w=145n
Mmn0 Eb E VSS VSS g45n1svt m=1 l=45n w=145n
Mmn25 n20 CKb Dbp VSS g45n1svt m=1 l=45n w=205n
Mmn20 CKb CK VSS VSS g45n1svt m=1 l=45n w=145n
Mmn11 Db SEb Dbp VSS g45n1svt m=1 l=45n w=260n
Mmp4 Db Eb net449 NW g45p1svt m=1 l=45n w=390n
Mmp3 net449 D VDD NW g45p1svt m=1 l=45n w=390n
Mmp13 Dbp SEb net441 NW g45p1svt m=1 l=45n w=390n
Mmp12 net441 SI VDD NW g45p1svt m=1 l=45n w=390n
Mmp51 n30 Ckbb net426 NW g45p1svt m=1 l=45n w=310n
Mmp50 net426 qbint VDD NW g45p1svt m=1 l=45n w=310n
Mmp55 Q qbint VDD NW g45p1svt m=1 l=45n w=780n
Mmp35 net417 mout VDD NW g45p1svt m=1 l=45n w=310n
Mmp36 n20 CKb net417 NW g45p1svt m=1 l=45n w=310n
Mmp20 CKb CK VDD NW g45p1svt m=1 l=45n w=215n
Mmp1 net405 qint VDD NW g45p1svt m=1 l=45n w=390n
Mmp2 Db E net405 NW g45p1svt m=1 l=45n w=390n
Mmp45 qbint n30 VDD NW g45p1svt m=1 l=45n w=390n
Mmp56 qint qbint VDD NW g45p1svt m=1 l=45n w=310n
Mmp21 Ckbb CKb VDD NW g45p1svt m=1 l=45n w=215n
Mmp40 n30 CKb mout NW g45p1svt m=1 l=45n w=310n
Mmp30 mout n20 VDD NW g45p1svt m=1 l=45n w=310n
Mmp11 Db SE Dbp NW g45p1svt m=1 l=45n w=390n
Mmp10 SEb SE VDD NW g45p1svt m=1 l=45n w=215n
Mmp0 Eb E VDD NW g45p1svt m=1 l=45n w=215n
Mmp25 n20 Ckbb Dbp NW g45p1svt m=1 l=45n w=310n
.ENDS

.SUBCKT SEDFFHQX4 CK D E NW Q SE SI VDD VSS
*.PININFO CK:I D:I E:I NW:I SE:I SI:I VDD:I VSS:I Q:O
Mmn4 Db E net526 VSS g45n1svt m=1 l=45n w=260n
Mmn3 net526 D VSS VSS g45n1svt m=1 l=45n w=260n
Mmn13 Dbp SE net518 VSS g45n1svt m=1 l=45n w=260n
Mmn12 net518 SI VSS VSS g45n1svt m=1 l=45n w=260n
Mmn55 Q qbint VSS VSS g45n1svt m=1 l=45n w=1.04u
Mmn50 net509 qbint VSS VSS g45n1svt m=1 l=45n w=205n
Mmn51 n30 CKb net509 VSS g45n1svt m=1 l=45n w=205n
Mmn35 net501 mout VSS VSS g45n1svt m=1 l=45n w=205n
Mmn36 n20 Ckbb net501 VSS g45n1svt m=1 l=45n w=205n
Mmn1 net494 qint VSS VSS g45n1svt m=1 l=45n w=260n
Mmn2 Db Eb net494 VSS g45n1svt m=1 l=45n w=260n
Mmn45 qbint n30 VSS VSS g45n1svt m=1 l=45n w=410n
Mmn56 qint qbint VSS VSS g45n1svt m=1 l=45n w=260n
Mmn21 Ckbb CKb VSS VSS g45n1svt m=1 l=45n w=145n
Mmn40 n30 Ckbb mout VSS g45n1svt m=1 l=45n w=205n
Mmn30 mout n20 VSS VSS g45n1svt m=1 l=45n w=205n
Mmn10 SEb SE VSS VSS g45n1svt m=1 l=45n w=145n
Mmn0 Eb E VSS VSS g45n1svt m=1 l=45n w=145n
Mmn25 n20 CKb Dbp VSS g45n1svt m=1 l=45n w=205n
Mmn20 CKb CK VSS VSS g45n1svt m=1 l=45n w=145n
Mmn11 Db SEb Dbp VSS g45n1svt m=1 l=45n w=260n
Mmp4 Db Eb net449 NW g45p1svt m=1 l=45n w=390n
Mmp3 net449 D VDD NW g45p1svt m=1 l=45n w=390n
Mmp13 Dbp SEb net441 NW g45p1svt m=1 l=45n w=390n
Mmp12 net441 SI VDD NW g45p1svt m=1 l=45n w=390n
Mmp51 n30 Ckbb net426 NW g45p1svt m=1 l=45n w=310n
Mmp50 net426 qbint VDD NW g45p1svt m=1 l=45n w=310n
Mmp55 Q qbint VDD NW g45p1svt m=1 l=45n w=1.56u
Mmp35 net417 mout VDD NW g45p1svt m=1 l=45n w=310n
Mmp36 n20 CKb net417 NW g45p1svt m=1 l=45n w=310n
Mmp20 CKb CK VDD NW g45p1svt m=1 l=45n w=215n
Mmp1 net405 qint VDD NW g45p1svt m=1 l=45n w=390n
Mmp2 Db E net405 NW g45p1svt m=1 l=45n w=390n
Mmp45 qbint n30 VDD NW g45p1svt m=1 l=45n w=620n
Mmp56 qint qbint VDD NW g45p1svt m=1 l=45n w=390n
Mmp21 Ckbb CKb VDD NW g45p1svt m=1 l=45n w=215n
Mmp40 n30 CKb mout NW g45p1svt m=1 l=45n w=310n
Mmp30 mout n20 VDD NW g45p1svt m=1 l=45n w=310n
Mmp11 Db SE Dbp NW g45p1svt m=1 l=45n w=390n
Mmp10 SEb SE VDD NW g45p1svt m=1 l=45n w=215n
Mmp0 Eb E VDD NW g45p1svt m=1 l=45n w=215n
Mmp25 n20 Ckbb Dbp NW g45p1svt m=1 l=45n w=310n
.ENDS

.SUBCKT SEDFFHQX8 CK D E NW Q SE SI VDD VSS
*.PININFO CK:I D:I E:I NW:I SE:I SI:I VDD:I VSS:I Q:O
Mmn4 Db E net526 VSS g45n1svt m=1 l=45n w=260n
Mmn3 net526 D VSS VSS g45n1svt m=1 l=45n w=260n
Mmn13 Dbp SE net518 VSS g45n1svt m=1 l=45n w=260n
Mmn12 net518 SI VSS VSS g45n1svt m=1 l=45n w=260n
Mmn55 Q qbint VSS VSS g45n1svt m=1 l=45n w=2.065u
Mmn50 net509 qbint VSS VSS g45n1svt m=1 l=45n w=205n
Mmn51 n30 CKb net509 VSS g45n1svt m=1 l=45n w=205n
Mmn35 net501 mout VSS VSS g45n1svt m=1 l=45n w=205n
Mmn36 n20 Ckbb net501 VSS g45n1svt m=1 l=45n w=205n
Mmn1 net494 qint VSS VSS g45n1svt m=1 l=45n w=260n
Mmn2 Db Eb net494 VSS g45n1svt m=1 l=45n w=260n
Mmn45 qbint n30 VSS VSS g45n1svt m=1 l=45n w=780n
Mmn56 qint qbint VSS VSS g45n1svt m=1 l=45n w=520n
Mmn21 Ckbb CKb VSS VSS g45n1svt m=1 l=45n w=145n
Mmn40 n30 Ckbb mout VSS g45n1svt m=1 l=45n w=205n
Mmn30 mout n20 VSS VSS g45n1svt m=1 l=45n w=205n
Mmn10 SEb SE VSS VSS g45n1svt m=1 l=45n w=145n
Mmn0 Eb E VSS VSS g45n1svt m=1 l=45n w=145n
Mmn25 n20 CKb Dbp VSS g45n1svt m=1 l=45n w=205n
Mmn20 CKb CK VSS VSS g45n1svt m=1 l=45n w=145n
Mmn11 Db SEb Dbp VSS g45n1svt m=1 l=45n w=260n
Mmp4 Db Eb net449 NW g45p1svt m=1 l=45n w=390n
Mmp3 net449 D VDD NW g45p1svt m=1 l=45n w=390n
Mmp13 Dbp SEb net441 NW g45p1svt m=1 l=45n w=390n
Mmp12 net441 SI VDD NW g45p1svt m=1 l=45n w=390n
Mmp51 n30 Ckbb net426 NW g45p1svt m=1 l=45n w=310n
Mmp50 net426 qbint VDD NW g45p1svt m=1 l=45n w=310n
Mmp55 Q qbint VDD NW g45p1svt m=1 l=45n w=3.115u
Mmp35 net417 mout VDD NW g45p1svt m=1 l=45n w=310n
Mmp36 n20 CKb net417 NW g45p1svt m=1 l=45n w=310n
Mmp20 CKb CK VDD NW g45p1svt m=1 l=45n w=215n
Mmp1 net405 qint VDD NW g45p1svt m=1 l=45n w=390n
Mmp2 Db E net405 NW g45p1svt m=1 l=45n w=390n
Mmp45 qbint n30 VDD NW g45p1svt m=1 l=45n w=1.17u
Mmp56 qint qbint VDD NW g45p1svt m=1 l=45n w=780n
Mmp21 Ckbb CKb VDD NW g45p1svt m=1 l=45n w=215n
Mmp40 n30 CKb mout NW g45p1svt m=1 l=45n w=310n
Mmp30 mout n20 VDD NW g45p1svt m=1 l=45n w=310n
Mmp11 Db SE Dbp NW g45p1svt m=1 l=45n w=390n
Mmp10 SEb SE VDD NW g45p1svt m=1 l=45n w=215n
Mmp0 Eb E VDD NW g45p1svt m=1 l=45n w=215n
Mmp25 n20 Ckbb Dbp NW g45p1svt m=1 l=45n w=310n
.ENDS

.SUBCKT SEDFFTRX1 CK D E NW Q QN RN SE SI VDD VSS
*.PININFO CK:I D:I E:I NW:I RN:I SE:I SI:I VDD:I VSS:I Q:O QN:O
Mmn14 Dpb SE net658 VSS g45n1svt m=1 l=45n w=145n
Mmn13 net658 SI VSS VSS g45n1svt m=1 l=45n w=145n
Mmn12 Dpb SEb net650 VSS g45n1svt m=1 l=45n w=145n
Mmn11 net650 Dp VSS VSS g45n1svt m=1 l=45n w=145n
Mmn1 Db D VSS VSS g45n1svt m=1 l=45n w=145n
Mmn7 Dp Db net638 VSS g45n1svt m=1 l=45n w=145n
Mmn6 net638 E VSS VSS g45n1svt m=1 l=45n w=145n
Mmn4 net634 Eb VSS VSS g45n1svt m=1 l=45n w=145n
Mmn5 Dp qbint net634 VSS g45n1svt m=1 l=45n w=145n
Mmn57 QN net582 VSS VSS g45n1svt m=1 l=45n w=260n
Mmn55 Q qbint VSS VSS g45n1svt m=1 l=45n w=260n
Mmn50 net618 qbint VSS VSS g45n1svt m=1 l=45n w=145n
Mmn51 n30 CKb net618 VSS g45n1svt m=1 l=45n w=145n
Mmn36 n20 CKbb net606 VSS g45n1svt m=1 l=45n w=145n
Mmn35 net606 mout VSS VSS g45n1svt m=1 l=45n w=145n
Mmn20 CKb CK VSS VSS g45n1svt m=1 l=45n w=145n
Mmn2 RNb RN VSS VSS g45n1svt m=1 l=45n w=145n
Mmn10 SEb SE VSS VSS g45n1svt m=1 l=45n w=145n
Mmn0 Eb E VSS VSS g45n1svt m=1 l=45n w=145n
Mmn3 Dp RNb VSS VSS g45n1svt m=1 l=45n w=145n
Mmn56 net582 qbint VSS VSS g45n1svt m=1 l=45n w=145n
Mmn45 qbint n30 VSS VSS g45n1svt m=1 l=45n w=145n
Mmn30 mout n20 VSS VSS g45n1svt m=1 l=45n w=145n
Mmn25 n20 CKb Dpb VSS g45n1svt m=1 l=45n w=145n
Mmn40 n30 CKbb mout VSS g45n1svt m=1 l=45n w=145n
Mmn21 CKbb CKb VSS VSS g45n1svt m=1 l=45n w=145n
Mmp13 net557 SI VDD NW g45p1svt m=1 l=45n w=215n
Mmp14 Dpb SEb net557 NW g45p1svt m=1 l=45n w=215n
Mmp11 net549 Dp VDD NW g45p1svt m=1 l=45n w=215n
Mmp12 Dpb SE net549 NW g45p1svt m=1 l=45n w=215n
Mmp1 Db D VDD NW g45p1svt m=1 l=45n w=215n
Mmp57 QN net582 VDD NW g45p1svt m=1 l=45n w=390n
Mmp55 Q qbint VDD NW g45p1svt m=1 l=45n w=390n
Mmp50 net529 qbint VDD NW g45p1svt m=1 l=45n w=215n
Mmp51 n30 CKbb net529 NW g45p1svt m=1 l=45n w=215n
Mmp35 net521 mout VDD NW g45p1svt m=1 l=45n w=215n
Mmp36 n20 CKb net521 NW g45p1svt m=1 l=45n w=215n
Mmp20 CKb CK VDD NW g45p1svt m=1 l=45n w=215n
Mmp2 RNb RN VDD NW g45p1svt m=1 l=45n w=215n
Mmp7 Dp Db net505 NW g45p1svt m=1 l=45n w=215n
Mmp6 Dp E net505 NW g45p1svt m=1 l=45n w=215n
Mmp10 SEb SE VDD NW g45p1svt m=1 l=45n w=215n
Mmp0 Eb E VDD NW g45p1svt m=1 l=45n w=215n
Mmp4 net505 Eb net493 NW g45p1svt m=1 l=45n w=215n
Mmp5 net505 qbint net493 NW g45p1svt m=1 l=45n w=215n
Mmp3 net493 RNb VDD NW g45p1svt m=1 l=45n w=215n
Mmp56 net582 qbint VDD NW g45p1svt m=1 l=45n w=215n
Mmp45 qbint n30 VDD NW g45p1svt m=1 l=45n w=215n
Mmp30 mout n20 VDD NW g45p1svt m=1 l=45n w=215n
Mmp40 n30 CKb mout NW g45p1svt m=1 l=45n w=215n
Mmp21 CKbb CKb VDD NW g45p1svt m=1 l=45n w=215n
Mmp25 n20 CKbb Dpb NW g45p1svt m=1 l=45n w=215n
.ENDS

.SUBCKT SEDFFTRX2 CK D E NW Q QN RN SE SI VDD VSS
*.PININFO CK:I D:I E:I NW:I RN:I SE:I SI:I VDD:I VSS:I Q:O QN:O
Mmn14 Dpb SE net658 VSS g45n1svt m=1 l=45n w=145n
Mmn13 net658 SI VSS VSS g45n1svt m=1 l=45n w=145n
Mmn12 Dpb SEb net650 VSS g45n1svt m=1 l=45n w=145n
Mmn11 net650 Dp VSS VSS g45n1svt m=1 l=45n w=145n
Mmn1 Db D VSS VSS g45n1svt m=1 l=45n w=145n
Mmn7 Dp Db net638 VSS g45n1svt m=1 l=45n w=145n
Mmn6 net638 E VSS VSS g45n1svt m=1 l=45n w=145n
Mmn4 net634 Eb VSS VSS g45n1svt m=1 l=45n w=145n
Mmn5 Dp qbint net634 VSS g45n1svt m=1 l=45n w=145n
Mmn57 QN net582 VSS VSS g45n1svt m=1 l=45n w=520n
Mmn55 Q qbint VSS VSS g45n1svt m=1 l=45n w=520n
Mmn50 net618 qbint VSS VSS g45n1svt m=1 l=45n w=145n
Mmn51 n30 CKb net618 VSS g45n1svt m=1 l=45n w=145n
Mmn36 n20 CKbb net606 VSS g45n1svt m=1 l=45n w=145n
Mmn35 net606 mout VSS VSS g45n1svt m=1 l=45n w=145n
Mmn20 CKb CK VSS VSS g45n1svt m=1 l=45n w=145n
Mmn2 RNb RN VSS VSS g45n1svt m=1 l=45n w=145n
Mmn10 SEb SE VSS VSS g45n1svt m=1 l=45n w=145n
Mmn0 Eb E VSS VSS g45n1svt m=1 l=45n w=145n
Mmn3 Dp RNb VSS VSS g45n1svt m=1 l=45n w=145n
Mmn56 net582 qbint VSS VSS g45n1svt m=1 l=45n w=145n
Mmn45 qbint n30 VSS VSS g45n1svt m=1 l=45n w=205n
Mmn30 mout n20 VSS VSS g45n1svt m=1 l=45n w=145n
Mmn25 n20 CKb Dpb VSS g45n1svt m=1 l=45n w=145n
Mmn40 n30 CKbb mout VSS g45n1svt m=1 l=45n w=145n
Mmn21 CKbb CKb VSS VSS g45n1svt m=1 l=45n w=145n
Mmp13 net557 SI VDD NW g45p1svt m=1 l=45n w=215n
Mmp14 Dpb SEb net557 NW g45p1svt m=1 l=45n w=215n
Mmp11 net549 Dp VDD NW g45p1svt m=1 l=45n w=215n
Mmp12 Dpb SE net549 NW g45p1svt m=1 l=45n w=215n
Mmp1 Db D VDD NW g45p1svt m=1 l=45n w=215n
Mmp57 QN net582 VDD NW g45p1svt m=1 l=45n w=780n
Mmp55 Q qbint VDD NW g45p1svt m=1 l=45n w=780n
Mmp50 net529 qbint VDD NW g45p1svt m=1 l=45n w=215n
Mmp51 n30 CKbb net529 NW g45p1svt m=1 l=45n w=215n
Mmp35 net521 mout VDD NW g45p1svt m=1 l=45n w=215n
Mmp36 n20 CKb net521 NW g45p1svt m=1 l=45n w=215n
Mmp20 CKb CK VDD NW g45p1svt m=1 l=45n w=215n
Mmp2 RNb RN VDD NW g45p1svt m=1 l=45n w=215n
Mmp7 Dp Db net505 NW g45p1svt m=1 l=45n w=215n
Mmp6 Dp E net505 NW g45p1svt m=1 l=45n w=215n
Mmp10 SEb SE VDD NW g45p1svt m=1 l=45n w=215n
Mmp0 Eb E VDD NW g45p1svt m=1 l=45n w=215n
Mmp4 net505 Eb net493 NW g45p1svt m=1 l=45n w=215n
Mmp5 net505 qbint net493 NW g45p1svt m=1 l=45n w=215n
Mmp3 net493 RNb VDD NW g45p1svt m=1 l=45n w=215n
Mmp56 net582 qbint VDD NW g45p1svt m=1 l=45n w=215n
Mmp45 qbint n30 VDD NW g45p1svt m=1 l=45n w=310n
Mmp30 mout n20 VDD NW g45p1svt m=1 l=45n w=215n
Mmp40 n30 CKb mout NW g45p1svt m=1 l=45n w=215n
Mmp21 CKbb CKb VDD NW g45p1svt m=1 l=45n w=215n
Mmp25 n20 CKbb Dpb NW g45p1svt m=1 l=45n w=215n
.ENDS

.SUBCKT SEDFFTRX4 CK D E NW Q QN RN SE SI VDD VSS
*.PININFO CK:I D:I E:I NW:I RN:I SE:I SI:I VDD:I VSS:I Q:O QN:O
Mmn14 Dpb SE net658 VSS g45n1svt m=1 l=45n w=145n
Mmn13 net658 SI VSS VSS g45n1svt m=1 l=45n w=145n
Mmn12 Dpb SEb net650 VSS g45n1svt m=1 l=45n w=145n
Mmn11 net650 Dp VSS VSS g45n1svt m=1 l=45n w=145n
Mmn1 Db D VSS VSS g45n1svt m=1 l=45n w=145n
Mmn7 Dp Db net638 VSS g45n1svt m=1 l=45n w=145n
Mmn6 net638 E VSS VSS g45n1svt m=1 l=45n w=145n
Mmn4 net634 Eb VSS VSS g45n1svt m=1 l=45n w=145n
Mmn5 Dp qbint net634 VSS g45n1svt m=1 l=45n w=145n
Mmn57 QN net582 VSS VSS g45n1svt m=1 l=45n w=1.04u
Mmn55 Q qbint VSS VSS g45n1svt m=1 l=45n w=1.04u
Mmn50 net618 qbint VSS VSS g45n1svt m=1 l=45n w=145n
Mmn51 n30 CKb net618 VSS g45n1svt m=1 l=45n w=145n
Mmn36 n20 CKbb net606 VSS g45n1svt m=1 l=45n w=145n
Mmn35 net606 mout VSS VSS g45n1svt m=1 l=45n w=145n
Mmn20 CKb CK VSS VSS g45n1svt m=1 l=45n w=145n
Mmn2 RNb RN VSS VSS g45n1svt m=1 l=45n w=145n
Mmn10 SEb SE VSS VSS g45n1svt m=1 l=45n w=145n
Mmn0 Eb E VSS VSS g45n1svt m=1 l=45n w=145n
Mmn3 Dp RNb VSS VSS g45n1svt m=1 l=45n w=145n
Mmn56 net582 qbint VSS VSS g45n1svt m=1 l=45n w=260n
Mmn45 qbint n30 VSS VSS g45n1svt m=1 l=45n w=410n
Mmn30 mout n20 VSS VSS g45n1svt m=1 l=45n w=145n
Mmn25 n20 CKb Dpb VSS g45n1svt m=1 l=45n w=145n
Mmn40 n30 CKbb mout VSS g45n1svt m=1 l=45n w=145n
Mmn21 CKbb CKb VSS VSS g45n1svt m=1 l=45n w=145n
Mmp13 net557 SI VDD NW g45p1svt m=1 l=45n w=215n
Mmp14 Dpb SEb net557 NW g45p1svt m=1 l=45n w=215n
Mmp11 net549 Dp VDD NW g45p1svt m=1 l=45n w=215n
Mmp12 Dpb SE net549 NW g45p1svt m=1 l=45n w=215n
Mmp1 Db D VDD NW g45p1svt m=1 l=45n w=215n
Mmp57 QN net582 VDD NW g45p1svt m=1 l=45n w=1.56u
Mmp55 Q qbint VDD NW g45p1svt m=1 l=45n w=1.56u
Mmp50 net529 qbint VDD NW g45p1svt m=1 l=45n w=215n
Mmp51 n30 CKbb net529 NW g45p1svt m=1 l=45n w=215n
Mmp35 net521 mout VDD NW g45p1svt m=1 l=45n w=215n
Mmp36 n20 CKb net521 NW g45p1svt m=1 l=45n w=215n
Mmp20 CKb CK VDD NW g45p1svt m=1 l=45n w=215n
Mmp2 RNb RN VDD NW g45p1svt m=1 l=45n w=215n
Mmp7 Dp Db net505 NW g45p1svt m=1 l=45n w=215n
Mmp6 Dp E net505 NW g45p1svt m=1 l=45n w=215n
Mmp10 SEb SE VDD NW g45p1svt m=1 l=45n w=215n
Mmp0 Eb E VDD NW g45p1svt m=1 l=45n w=215n
Mmp4 net505 Eb net493 NW g45p1svt m=1 l=45n w=215n
Mmp5 net505 qbint net493 NW g45p1svt m=1 l=45n w=215n
Mmp3 net493 RNb VDD NW g45p1svt m=1 l=45n w=215n
Mmp56 net582 qbint VDD NW g45p1svt m=1 l=45n w=390n
Mmp45 qbint n30 VDD NW g45p1svt m=1 l=45n w=620n
Mmp30 mout n20 VDD NW g45p1svt m=1 l=45n w=215n
Mmp40 n30 CKb mout NW g45p1svt m=1 l=45n w=215n
Mmp21 CKbb CKb VDD NW g45p1svt m=1 l=45n w=215n
Mmp25 n20 CKbb Dpb NW g45p1svt m=1 l=45n w=215n
.ENDS

.SUBCKT SEDFFTRXL CK D E NW Q QN RN SE SI VDD VSS
*.PININFO CK:I D:I E:I NW:I RN:I SE:I SI:I VDD:I VSS:I Q:O QN:O
Mmn14 Dpb SE net658 VSS g45n1svt m=1 l=45n w=145n
Mmn13 net658 SI VSS VSS g45n1svt m=1 l=45n w=145n
Mmn12 Dpb SEb net650 VSS g45n1svt m=1 l=45n w=145n
Mmn11 net650 Dp VSS VSS g45n1svt m=1 l=45n w=145n
Mmn1 Db D VSS VSS g45n1svt m=1 l=45n w=145n
Mmn7 Dp Db net638 VSS g45n1svt m=1 l=45n w=145n
Mmn6 net638 E VSS VSS g45n1svt m=1 l=45n w=145n
Mmn4 net634 Eb VSS VSS g45n1svt m=1 l=45n w=145n
Mmn5 Dp qbint net634 VSS g45n1svt m=1 l=45n w=145n
Mmn57 QN net582 VSS VSS g45n1svt m=1 l=45n w=145n
Mmn55 Q qbint VSS VSS g45n1svt m=1 l=45n w=145n
Mmn50 net618 qbint VSS VSS g45n1svt m=1 l=45n w=145n
Mmn51 n30 CKb net618 VSS g45n1svt m=1 l=45n w=145n
Mmn36 n20 CKbb net606 VSS g45n1svt m=1 l=45n w=145n
Mmn35 net606 mout VSS VSS g45n1svt m=1 l=45n w=145n
Mmn20 CKb CK VSS VSS g45n1svt m=1 l=45n w=145n
Mmn2 RNb RN VSS VSS g45n1svt m=1 l=45n w=145n
Mmn10 SEb SE VSS VSS g45n1svt m=1 l=45n w=145n
Mmn0 Eb E VSS VSS g45n1svt m=1 l=45n w=145n
Mmn3 Dp RNb VSS VSS g45n1svt m=1 l=45n w=145n
Mmn56 net582 qbint VSS VSS g45n1svt m=1 l=45n w=145n
Mmn45 qbint n30 VSS VSS g45n1svt m=1 l=45n w=145n
Mmn30 mout n20 VSS VSS g45n1svt m=1 l=45n w=145n
Mmn25 n20 CKb Dpb VSS g45n1svt m=1 l=45n w=145n
Mmn40 n30 CKbb mout VSS g45n1svt m=1 l=45n w=145n
Mmn21 CKbb CKb VSS VSS g45n1svt m=1 l=45n w=145n
Mmp13 net557 SI VDD NW g45p1svt m=1 l=45n w=215n
Mmp14 Dpb SEb net557 NW g45p1svt m=1 l=45n w=215n
Mmp11 net549 Dp VDD NW g45p1svt m=1 l=45n w=215n
Mmp12 Dpb SE net549 NW g45p1svt m=1 l=45n w=215n
Mmp1 Db D VDD NW g45p1svt m=1 l=45n w=215n
Mmp57 QN net582 VDD NW g45p1svt m=1 l=45n w=215n
Mmp55 Q qbint VDD NW g45p1svt m=1 l=45n w=215n
Mmp50 net529 qbint VDD NW g45p1svt m=1 l=45n w=215n
Mmp51 n30 CKbb net529 NW g45p1svt m=1 l=45n w=215n
Mmp35 net521 mout VDD NW g45p1svt m=1 l=45n w=215n
Mmp36 n20 CKb net521 NW g45p1svt m=1 l=45n w=215n
Mmp20 CKb CK VDD NW g45p1svt m=1 l=45n w=215n
Mmp2 RNb RN VDD NW g45p1svt m=1 l=45n w=215n
Mmp7 Dp Db net505 NW g45p1svt m=1 l=45n w=215n
Mmp6 Dp E net505 NW g45p1svt m=1 l=45n w=215n
Mmp10 SEb SE VDD NW g45p1svt m=1 l=45n w=215n
Mmp0 Eb E VDD NW g45p1svt m=1 l=45n w=215n
Mmp4 net505 Eb net493 NW g45p1svt m=1 l=45n w=215n
Mmp5 net505 qbint net493 NW g45p1svt m=1 l=45n w=215n
Mmp3 net493 RNb VDD NW g45p1svt m=1 l=45n w=215n
Mmp56 net582 qbint VDD NW g45p1svt m=1 l=45n w=215n
Mmp45 qbint n30 VDD NW g45p1svt m=1 l=45n w=215n
Mmp30 mout n20 VDD NW g45p1svt m=1 l=45n w=215n
Mmp40 n30 CKb mout NW g45p1svt m=1 l=45n w=215n
Mmp21 CKbb CKb VDD NW g45p1svt m=1 l=45n w=215n
Mmp25 n20 CKbb Dpb NW g45p1svt m=1 l=45n w=215n
.ENDS

.SUBCKT SEDFFX1 CK D E NW Q QN SE SI VDD VSS
*.PININFO CK:I D:I E:I NW:I SE:I SI:I VDD:I VSS:I Q:O QN:O
Mmn4 Db E net554 VSS g45n1svt m=1 l=45n w=145n
Mmn3 net554 D VSS VSS g45n1svt m=1 l=45n w=145n
Mmn13 Dbp SE net546 VSS g45n1svt m=1 l=45n w=145n
Mmn12 net546 SI VSS VSS g45n1svt m=1 l=45n w=145n
Mmn57 QN net502 VSS VSS g45n1svt m=1 l=45n w=260n
Mmn55 Q net536 VSS VSS g45n1svt m=1 l=45n w=260n
Mmn50 net534 net536 VSS VSS g45n1svt m=1 l=45n w=145n
Mmn51 n30 CKb net534 VSS g45n1svt m=1 l=45n w=145n
Mmn35 net526 mout VSS VSS g45n1svt m=1 l=45n w=145n
Mmn36 n20 CKbb net526 VSS g45n1svt m=1 l=45n w=145n
Mmn20 CKb CK VSS VSS g45n1svt m=1 l=45n w=145n
Mmn1 net514 net502 VSS VSS g45n1svt m=1 l=45n w=145n
Mmn2 Db Eb net514 VSS g45n1svt m=1 l=45n w=145n
Mmn45 net536 n30 VSS VSS g45n1svt m=1 l=45n w=145n
Mmn56 net502 net536 VSS VSS g45n1svt m=1 l=45n w=145n
Mmn21 CKbb CKb VSS VSS g45n1svt m=1 l=45n w=145n
Mmn40 mout CKbb n30 VSS g45n1svt m=1 l=45n w=145n
Mmn10 SEb SE VSS VSS g45n1svt m=1 l=45n w=145n
Mmn30 mout n20 VSS VSS g45n1svt m=1 l=45n w=145n
Mmn0 Eb E VSS VSS g45n1svt m=1 l=45n w=145n
Mmn25 Dbp CKb n20 VSS g45n1svt m=1 l=45n w=145n
Mmn11 Db SEb Dbp VSS g45n1svt m=1 l=45n w=145n
Mmp4 Db Eb net473 NW g45p1svt m=1 l=45n w=215n
Mmp3 net473 D VDD NW g45p1svt m=1 l=45n w=215n
Mmp13 Dbp SEb net465 NW g45p1svt m=1 l=45n w=215n
Mmp12 net465 SI VDD NW g45p1svt m=1 l=45n w=215n
Mmp51 n30 CKbb net457 NW g45p1svt m=1 l=45n w=215n
Mmp50 net457 net536 VDD NW g45p1svt m=1 l=45n w=215n
Mmp57 QN net502 VDD NW g45p1svt m=1 l=45n w=390n
Mmp55 Q net536 VDD NW g45p1svt m=1 l=45n w=390n
Mmp35 net437 mout VDD NW g45p1svt m=1 l=45n w=215n
Mmp36 n20 CKb net437 NW g45p1svt m=1 l=45n w=215n
Mmp20 CKb CK VDD NW g45p1svt m=1 l=45n w=215n
Mmp1 net425 net502 VDD NW g45p1svt m=1 l=45n w=215n
Mmp2 Db E net425 NW g45p1svt m=1 l=45n w=215n
Mmp45 net536 n30 VDD NW g45p1svt m=1 l=45n w=215n
Mmp56 net502 net536 VDD NW g45p1svt m=1 l=45n w=215n
Mmp21 CKbb CKb VDD NW g45p1svt m=1 l=45n w=215n
Mmp40 n30 CKb mout NW g45p1svt m=1 l=45n w=215n
Mmp30 mout n20 VDD NW g45p1svt m=1 l=45n w=215n
Mmp0 Eb E VDD NW g45p1svt m=1 l=45n w=215n
Mmp25 n20 CKbb Dbp NW g45p1svt m=1 l=45n w=215n
Mmp11 Dbp SE Db NW g45p1svt m=1 l=45n w=215n
Mmp10 SEb SE VDD NW g45p1svt m=1 l=45n w=215n
.ENDS

.SUBCKT SEDFFX2 CK D E NW Q QN SE SI VDD VSS
*.PININFO CK:I D:I E:I NW:I SE:I SI:I VDD:I VSS:I Q:O QN:O
Mmn4 Db E net554 VSS g45n1svt m=1 l=45n w=145n
Mmn3 net554 D VSS VSS g45n1svt m=1 l=45n w=145n
Mmn13 Dbp SE net546 VSS g45n1svt m=1 l=45n w=145n
Mmn12 net546 SI VSS VSS g45n1svt m=1 l=45n w=145n
Mmn57 QN net502 VSS VSS g45n1svt m=1 l=45n w=520n
Mmn55 Q net536 VSS VSS g45n1svt m=1 l=45n w=520n
Mmn50 net534 net536 VSS VSS g45n1svt m=1 l=45n w=145n
Mmn51 n30 CKb net534 VSS g45n1svt m=1 l=45n w=145n
Mmn35 net526 mout VSS VSS g45n1svt m=1 l=45n w=145n
Mmn36 n20 CKbb net526 VSS g45n1svt m=1 l=45n w=145n
Mmn20 CKb CK VSS VSS g45n1svt m=1 l=45n w=145n
Mmn1 net514 net502 VSS VSS g45n1svt m=1 l=45n w=145n
Mmn2 Db Eb net514 VSS g45n1svt m=1 l=45n w=145n
Mmn45 net536 n30 VSS VSS g45n1svt m=1 l=45n w=205n
Mmn56 net502 net536 VSS VSS g45n1svt m=1 l=45n w=145n
Mmn21 CKbb CKb VSS VSS g45n1svt m=1 l=45n w=145n
Mmn40 mout CKbb n30 VSS g45n1svt m=1 l=45n w=145n
Mmn10 SEb SE VSS VSS g45n1svt m=1 l=45n w=145n
Mmn30 mout n20 VSS VSS g45n1svt m=1 l=45n w=145n
Mmn0 Eb E VSS VSS g45n1svt m=1 l=45n w=145n
Mmn25 Dbp CKb n20 VSS g45n1svt m=1 l=45n w=145n
Mmn11 Db SEb Dbp VSS g45n1svt m=1 l=45n w=145n
Mmp4 Db Eb net473 NW g45p1svt m=1 l=45n w=215n
Mmp3 net473 D VDD NW g45p1svt m=1 l=45n w=215n
Mmp13 Dbp SEb net465 NW g45p1svt m=1 l=45n w=215n
Mmp12 net465 SI VDD NW g45p1svt m=1 l=45n w=215n
Mmp51 n30 CKbb net457 NW g45p1svt m=1 l=45n w=215n
Mmp50 net457 net536 VDD NW g45p1svt m=1 l=45n w=215n
Mmp57 QN net502 VDD NW g45p1svt m=1 l=45n w=780n
Mmp55 Q net536 VDD NW g45p1svt m=1 l=45n w=780n
Mmp35 net437 mout VDD NW g45p1svt m=1 l=45n w=215n
Mmp36 n20 CKb net437 NW g45p1svt m=1 l=45n w=215n
Mmp20 CKb CK VDD NW g45p1svt m=1 l=45n w=215n
Mmp1 net425 net502 VDD NW g45p1svt m=1 l=45n w=215n
Mmp2 Db E net425 NW g45p1svt m=1 l=45n w=215n
Mmp45 net536 n30 VDD NW g45p1svt m=1 l=45n w=310n
Mmp56 net502 net536 VDD NW g45p1svt m=1 l=45n w=215n
Mmp21 CKbb CKb VDD NW g45p1svt m=1 l=45n w=215n
Mmp40 n30 CKb mout NW g45p1svt m=1 l=45n w=215n
Mmp30 mout n20 VDD NW g45p1svt m=1 l=45n w=215n
Mmp0 Eb E VDD NW g45p1svt m=1 l=45n w=215n
Mmp25 n20 CKbb Dbp NW g45p1svt m=1 l=45n w=215n
Mmp11 Dbp SE Db NW g45p1svt m=1 l=45n w=215n
Mmp10 SEb SE VDD NW g45p1svt m=1 l=45n w=215n
.ENDS

.SUBCKT SEDFFX4 CK D E NW Q QN SE SI VDD VSS
*.PININFO CK:I D:I E:I NW:I SE:I SI:I VDD:I VSS:I Q:O QN:O
Mmn4 Db E net554 VSS g45n1svt m=1 l=45n w=145n
Mmn3 net554 D VSS VSS g45n1svt m=1 l=45n w=145n
Mmn13 Dbp SE net546 VSS g45n1svt m=1 l=45n w=145n
Mmn12 net546 SI VSS VSS g45n1svt m=1 l=45n w=145n
Mmn57 QN net502 VSS VSS g45n1svt m=1 l=45n w=1.04u
Mmn55 Q net536 VSS VSS g45n1svt m=1 l=45n w=1.04u
Mmn50 net534 net536 VSS VSS g45n1svt m=1 l=45n w=145n
Mmn51 n30 CKb net534 VSS g45n1svt m=1 l=45n w=145n
Mmn35 net526 mout VSS VSS g45n1svt m=1 l=45n w=145n
Mmn36 n20 CKbb net526 VSS g45n1svt m=1 l=45n w=145n
Mmn20 CKb CK VSS VSS g45n1svt m=1 l=45n w=145n
Mmn1 net514 net502 VSS VSS g45n1svt m=1 l=45n w=145n
Mmn2 Db Eb net514 VSS g45n1svt m=1 l=45n w=145n
Mmn45 net536 n30 VSS VSS g45n1svt m=1 l=45n w=410n
Mmn56 net502 net536 VSS VSS g45n1svt m=1 l=45n w=260n
Mmn21 CKbb CKb VSS VSS g45n1svt m=1 l=45n w=145n
Mmn40 mout CKbb n30 VSS g45n1svt m=1 l=45n w=145n
Mmn10 SEb SE VSS VSS g45n1svt m=1 l=45n w=145n
Mmn30 mout n20 VSS VSS g45n1svt m=1 l=45n w=145n
Mmn0 Eb E VSS VSS g45n1svt m=1 l=45n w=145n
Mmn25 Dbp CKb n20 VSS g45n1svt m=1 l=45n w=145n
Mmn11 Db SEb Dbp VSS g45n1svt m=1 l=45n w=145n
Mmp4 Db Eb net473 NW g45p1svt m=1 l=45n w=215n
Mmp3 net473 D VDD NW g45p1svt m=1 l=45n w=215n
Mmp13 Dbp SEb net465 NW g45p1svt m=1 l=45n w=215n
Mmp12 net465 SI VDD NW g45p1svt m=1 l=45n w=215n
Mmp51 n30 CKbb net457 NW g45p1svt m=1 l=45n w=215n
Mmp50 net457 net536 VDD NW g45p1svt m=1 l=45n w=215n
Mmp57 QN net502 VDD NW g45p1svt m=1 l=45n w=1.56u
Mmp55 Q net536 VDD NW g45p1svt m=1 l=45n w=1.56u
Mmp35 net437 mout VDD NW g45p1svt m=1 l=45n w=215n
Mmp36 n20 CKb net437 NW g45p1svt m=1 l=45n w=215n
Mmp20 CKb CK VDD NW g45p1svt m=1 l=45n w=215n
Mmp1 net425 net502 VDD NW g45p1svt m=1 l=45n w=215n
Mmp2 Db E net425 NW g45p1svt m=1 l=45n w=215n
Mmp45 net536 n30 VDD NW g45p1svt m=1 l=45n w=620n
Mmp56 net502 net536 VDD NW g45p1svt m=1 l=45n w=390n
Mmp21 CKbb CKb VDD NW g45p1svt m=1 l=45n w=215n
Mmp40 n30 CKb mout NW g45p1svt m=1 l=45n w=215n
Mmp30 mout n20 VDD NW g45p1svt m=1 l=45n w=215n
Mmp0 Eb E VDD NW g45p1svt m=1 l=45n w=215n
Mmp25 n20 CKbb Dbp NW g45p1svt m=1 l=45n w=215n
Mmp11 Dbp SE Db NW g45p1svt m=1 l=45n w=215n
Mmp10 SEb SE VDD NW g45p1svt m=1 l=45n w=215n
.ENDS

.SUBCKT SEDFFXL CK D E NW Q QN SE SI VDD VSS
*.PININFO CK:I D:I E:I NW:I SE:I SI:I VDD:I VSS:I Q:O QN:O
Mmn4 Db E net554 VSS g45n1svt m=1 l=45n w=145n
Mmn3 net554 D VSS VSS g45n1svt m=1 l=45n w=145n
Mmn13 Dbp SE net546 VSS g45n1svt m=1 l=45n w=145n
Mmn12 net546 SI VSS VSS g45n1svt m=1 l=45n w=145n
Mmn57 QN net502 VSS VSS g45n1svt m=1 l=45n w=145n
Mmn55 Q net536 VSS VSS g45n1svt m=1 l=45n w=145n
Mmn50 net534 net536 VSS VSS g45n1svt m=1 l=45n w=145n
Mmn51 n30 CKb net534 VSS g45n1svt m=1 l=45n w=145n
Mmn35 net526 mout VSS VSS g45n1svt m=1 l=45n w=145n
Mmn36 n20 CKbb net526 VSS g45n1svt m=1 l=45n w=145n
Mmn20 CKb CK VSS VSS g45n1svt m=1 l=45n w=145n
Mmn1 net514 net502 VSS VSS g45n1svt m=1 l=45n w=145n
Mmn2 Db Eb net514 VSS g45n1svt m=1 l=45n w=145n
Mmn45 net536 n30 VSS VSS g45n1svt m=1 l=45n w=145n
Mmn56 net502 net536 VSS VSS g45n1svt m=1 l=45n w=145n
Mmn21 CKbb CKb VSS VSS g45n1svt m=1 l=45n w=145n
Mmn40 mout CKbb n30 VSS g45n1svt m=1 l=45n w=145n
Mmn10 SEb SE VSS VSS g45n1svt m=1 l=45n w=145n
Mmn30 mout n20 VSS VSS g45n1svt m=1 l=45n w=145n
Mmn0 Eb E VSS VSS g45n1svt m=1 l=45n w=145n
Mmn25 Dbp CKb n20 VSS g45n1svt m=1 l=45n w=145n
Mmn11 Db SEb Dbp VSS g45n1svt m=1 l=45n w=145n
Mmp4 Db Eb net473 NW g45p1svt m=1 l=45n w=215n
Mmp3 net473 D VDD NW g45p1svt m=1 l=45n w=215n
Mmp13 Dbp SEb net465 NW g45p1svt m=1 l=45n w=215n
Mmp12 net465 SI VDD NW g45p1svt m=1 l=45n w=215n
Mmp51 n30 CKbb net457 NW g45p1svt m=1 l=45n w=215n
Mmp50 net457 net536 VDD NW g45p1svt m=1 l=45n w=215n
Mmp57 QN net502 VDD NW g45p1svt m=1 l=45n w=215n
Mmp55 Q net536 VDD NW g45p1svt m=1 l=45n w=215n
Mmp35 net437 mout VDD NW g45p1svt m=1 l=45n w=215n
Mmp36 n20 CKb net437 NW g45p1svt m=1 l=45n w=215n
Mmp20 CKb CK VDD NW g45p1svt m=1 l=45n w=215n
Mmp1 net425 net502 VDD NW g45p1svt m=1 l=45n w=215n
Mmp2 Db E net425 NW g45p1svt m=1 l=45n w=215n
Mmp45 net536 n30 VDD NW g45p1svt m=1 l=45n w=215n
Mmp56 net502 net536 VDD NW g45p1svt m=1 l=45n w=215n
Mmp21 CKbb CKb VDD NW g45p1svt m=1 l=45n w=215n
Mmp40 n30 CKb mout NW g45p1svt m=1 l=45n w=215n
Mmp30 mout n20 VDD NW g45p1svt m=1 l=45n w=215n
Mmp0 Eb E VDD NW g45p1svt m=1 l=45n w=215n
Mmp25 n20 CKbb Dbp NW g45p1svt m=1 l=45n w=215n
Mmp11 Dbp SE Db NW g45p1svt m=1 l=45n w=215n
Mmp10 SEb SE VDD NW g45p1svt m=1 l=45n w=215n
.ENDS

.SUBCKT SMDFFHQX1 CK D0 D1 NW Q S0 SE SI VDD VSS
*.PININFO CK:I D0:I D1:I NW:I S0:I SE:I SI:I VDD:I VSS:I Q:O
Mmn3 net510 D1 VSS VSS g45n1svt m=1 l=45n w=260n
Mmn4 db S0 net510 VSS g45n1svt m=1 l=45n w=260n
Mmn2 db S0b net498 VSS g45n1svt m=1 l=45n w=260n
Mmn1 net498 D0 VSS VSS g45n1svt m=1 l=45n w=260n
Mmn13 dbp SE net490 VSS g45n1svt m=1 l=45n w=260n
Mmn12 net490 SI VSS VSS g45n1svt m=1 l=45n w=260n
Mmn55 Q qbint VSS VSS g45n1svt m=1 l=45n w=260n
Mmn50 net482 qbint VSS VSS g45n1svt m=1 l=45n w=205n
Mmn51 n30 CKb net482 VSS g45n1svt m=1 l=45n w=205n
Mmn35 net474 mout VSS VSS g45n1svt m=1 l=45n w=205n
Mmn36 n20 CKbb net474 VSS g45n1svt m=1 l=45n w=205n
Mmn20 CKb CK VSS VSS g45n1svt m=1 l=45n w=145n
Mmn45 qbint n30 VSS VSS g45n1svt m=1 l=45n w=205n
Mmn10 SEb SE VSS VSS g45n1svt m=1 l=45n w=145n
Mmn0 S0b S0 VSS VSS g45n1svt m=1 l=45n w=145n
Mmn11 db SEb dbp VSS g45n1svt m=1 l=45n w=260n
Mmn40 mout CKbb n30 VSS g45n1svt m=1 l=45n w=205n
Mmn25 dbp CKb n20 VSS g45n1svt m=1 l=45n w=205n
Mmn30 mout n20 VSS VSS g45n1svt m=1 l=45n w=205n
Mmn21 CKbb CKb VSS VSS g45n1svt m=1 l=45n w=145n
Mmp3 net429 D1 VDD NW g45p1svt m=1 l=45n w=390n
Mmp4 db S0b net429 NW g45p1svt m=1 l=45n w=390n
Mmp2 db S0 net425 NW g45p1svt m=1 l=45n w=390n
Mmp1 net425 D0 VDD NW g45p1svt m=1 l=45n w=390n
Mmp13 dbp SEb net417 NW g45p1svt m=1 l=45n w=390n
Mmp12 net417 SI VDD NW g45p1svt m=1 l=45n w=390n
Mmp51 n30 CKbb net409 NW g45p1svt m=1 l=45n w=310n
Mmp50 net409 qbint VDD NW g45p1svt m=1 l=45n w=310n
Mmp55 Q qbint VDD NW g45p1svt m=1 l=45n w=390n
Mmp35 net393 mout VDD NW g45p1svt m=1 l=45n w=310n
Mmp36 n20 CKb net393 NW g45p1svt m=1 l=45n w=310n
Mmp20 CKb CK VDD NW g45p1svt m=1 l=45n w=215n
Mmp45 qbint n30 VDD NW g45p1svt m=1 l=45n w=310n
Mmp0 S0b S0 VDD NW g45p1svt m=1 l=45n w=215n
Mmp40 n30 CKb mout NW g45p1svt m=1 l=45n w=310n
Mmp21 CKbb CKb VDD NW g45p1svt m=1 l=45n w=215n
Mmp30 mout n20 VDD NW g45p1svt m=1 l=45n w=310n
Mmp10 SEb SE VDD NW g45p1svt m=1 l=45n w=215n
Mmp11 dbp SE db NW g45p1svt m=1 l=45n w=390n
Mmp25 n20 CKbb dbp NW g45p1svt m=1 l=45n w=310n
.ENDS

.SUBCKT SMDFFHQX2 CK D0 D1 NW Q S0 SE SI VDD VSS
*.PININFO CK:I D0:I D1:I NW:I S0:I SE:I SI:I VDD:I VSS:I Q:O
Mmn3 net510 D1 VSS VSS g45n1svt m=1 l=45n w=260n
Mmn4 db S0 net510 VSS g45n1svt m=1 l=45n w=260n
Mmn2 db S0b net498 VSS g45n1svt m=1 l=45n w=260n
Mmn1 net498 D0 VSS VSS g45n1svt m=1 l=45n w=260n
Mmn13 dbp SE net490 VSS g45n1svt m=1 l=45n w=260n
Mmn12 net490 SI VSS VSS g45n1svt m=1 l=45n w=260n
Mmn55 Q qbint VSS VSS g45n1svt m=1 l=45n w=520n
Mmn50 net482 qbint VSS VSS g45n1svt m=1 l=45n w=205n
Mmn51 n30 CKb net482 VSS g45n1svt m=1 l=45n w=205n
Mmn35 net474 mout VSS VSS g45n1svt m=1 l=45n w=205n
Mmn36 n20 CKbb net474 VSS g45n1svt m=1 l=45n w=205n
Mmn20 CKb CK VSS VSS g45n1svt m=1 l=45n w=145n
Mmn45 qbint n30 VSS VSS g45n1svt m=1 l=45n w=260n
Mmn10 SEb SE VSS VSS g45n1svt m=1 l=45n w=145n
Mmn0 S0b S0 VSS VSS g45n1svt m=1 l=45n w=145n
Mmn11 db SEb dbp VSS g45n1svt m=1 l=45n w=260n
Mmn40 mout CKbb n30 VSS g45n1svt m=1 l=45n w=205n
Mmn25 dbp CKb n20 VSS g45n1svt m=1 l=45n w=205n
Mmn30 mout n20 VSS VSS g45n1svt m=1 l=45n w=205n
Mmn21 CKbb CKb VSS VSS g45n1svt m=1 l=45n w=145n
Mmp3 net429 D1 VDD NW g45p1svt m=1 l=45n w=390n
Mmp4 db S0b net429 NW g45p1svt m=1 l=45n w=390n
Mmp2 db S0 net425 NW g45p1svt m=1 l=45n w=390n
Mmp1 net425 D0 VDD NW g45p1svt m=1 l=45n w=390n
Mmp13 dbp SEb net417 NW g45p1svt m=1 l=45n w=390n
Mmp12 net417 SI VDD NW g45p1svt m=1 l=45n w=390n
Mmp51 n30 CKbb net409 NW g45p1svt m=1 l=45n w=310n
Mmp50 net409 qbint VDD NW g45p1svt m=1 l=45n w=310n
Mmp55 Q qbint VDD NW g45p1svt m=1 l=45n w=780n
Mmp35 net393 mout VDD NW g45p1svt m=1 l=45n w=310n
Mmp36 n20 CKb net393 NW g45p1svt m=1 l=45n w=310n
Mmp20 CKb CK VDD NW g45p1svt m=1 l=45n w=215n
Mmp45 qbint n30 VDD NW g45p1svt m=1 l=45n w=390n
Mmp0 S0b S0 VDD NW g45p1svt m=1 l=45n w=215n
Mmp40 n30 CKb mout NW g45p1svt m=1 l=45n w=310n
Mmp21 CKbb CKb VDD NW g45p1svt m=1 l=45n w=215n
Mmp30 mout n20 VDD NW g45p1svt m=1 l=45n w=310n
Mmp10 SEb SE VDD NW g45p1svt m=1 l=45n w=215n
Mmp11 dbp SE db NW g45p1svt m=1 l=45n w=390n
Mmp25 n20 CKbb dbp NW g45p1svt m=1 l=45n w=310n
.ENDS

.SUBCKT SMDFFHQX4 CK D0 D1 NW Q S0 SE SI VDD VSS
*.PININFO CK:I D0:I D1:I NW:I S0:I SE:I SI:I VDD:I VSS:I Q:O
Mmn3 net510 D1 VSS VSS g45n1svt m=1 l=45n w=260n
Mmn4 db S0 net510 VSS g45n1svt m=1 l=45n w=260n
Mmn2 db S0b net498 VSS g45n1svt m=1 l=45n w=260n
Mmn1 net498 D0 VSS VSS g45n1svt m=1 l=45n w=260n
Mmn13 dbp SE net490 VSS g45n1svt m=1 l=45n w=260n
Mmn12 net490 SI VSS VSS g45n1svt m=1 l=45n w=260n
Mmn55 Q qbint VSS VSS g45n1svt m=1 l=45n w=1.04u
Mmn50 net482 qbint VSS VSS g45n1svt m=1 l=45n w=205n
Mmn51 n30 CKb net482 VSS g45n1svt m=1 l=45n w=205n
Mmn35 net474 mout VSS VSS g45n1svt m=1 l=45n w=205n
Mmn36 n20 CKbb net474 VSS g45n1svt m=1 l=45n w=205n
Mmn20 CKb CK VSS VSS g45n1svt m=1 l=45n w=145n
Mmn45 qbint n30 VSS VSS g45n1svt m=1 l=45n w=410n
Mmn10 SEb SE VSS VSS g45n1svt m=1 l=45n w=145n
Mmn0 S0b S0 VSS VSS g45n1svt m=1 l=45n w=145n
Mmn11 db SEb dbp VSS g45n1svt m=1 l=45n w=260n
Mmn40 mout CKbb n30 VSS g45n1svt m=1 l=45n w=205n
Mmn25 dbp CKb n20 VSS g45n1svt m=1 l=45n w=205n
Mmn30 mout n20 VSS VSS g45n1svt m=1 l=45n w=205n
Mmn21 CKbb CKb VSS VSS g45n1svt m=1 l=45n w=145n
Mmp3 net429 D1 VDD NW g45p1svt m=1 l=45n w=390n
Mmp4 db S0b net429 NW g45p1svt m=1 l=45n w=390n
Mmp2 db S0 net425 NW g45p1svt m=1 l=45n w=390n
Mmp1 net425 D0 VDD NW g45p1svt m=1 l=45n w=390n
Mmp13 dbp SEb net417 NW g45p1svt m=1 l=45n w=390n
Mmp12 net417 SI VDD NW g45p1svt m=1 l=45n w=390n
Mmp51 n30 CKbb net409 NW g45p1svt m=1 l=45n w=310n
Mmp50 net409 qbint VDD NW g45p1svt m=1 l=45n w=310n
Mmp55 Q qbint VDD NW g45p1svt m=1 l=45n w=1.56u
Mmp35 net393 mout VDD NW g45p1svt m=1 l=45n w=310n
Mmp36 n20 CKb net393 NW g45p1svt m=1 l=45n w=310n
Mmp20 CKb CK VDD NW g45p1svt m=1 l=45n w=215n
Mmp45 qbint n30 VDD NW g45p1svt m=1 l=45n w=620n
Mmp0 S0b S0 VDD NW g45p1svt m=1 l=45n w=215n
Mmp40 n30 CKb mout NW g45p1svt m=1 l=45n w=310n
Mmp21 CKbb CKb VDD NW g45p1svt m=1 l=45n w=215n
Mmp30 mout n20 VDD NW g45p1svt m=1 l=45n w=310n
Mmp10 SEb SE VDD NW g45p1svt m=1 l=45n w=215n
Mmp11 dbp SE db NW g45p1svt m=1 l=45n w=390n
Mmp25 n20 CKbb dbp NW g45p1svt m=1 l=45n w=310n
.ENDS

.SUBCKT SMDFFHQX8 CK D0 D1 NW Q S0 SE SI VDD VSS
*.PININFO CK:I D0:I D1:I NW:I S0:I SE:I SI:I VDD:I VSS:I Q:O
Mmn3 net510 D1 VSS VSS g45n1svt m=1 l=45n w=260n
Mmn4 db S0 net510 VSS g45n1svt m=1 l=45n w=260n
Mmn2 db S0b net498 VSS g45n1svt m=1 l=45n w=260n
Mmn1 net498 D0 VSS VSS g45n1svt m=1 l=45n w=260n
Mmn13 dbp SE net490 VSS g45n1svt m=1 l=45n w=260n
Mmn12 net490 SI VSS VSS g45n1svt m=1 l=45n w=260n
Mmn55 Q qbint VSS VSS g45n1svt m=1 l=45n w=2.065u
Mmn50 net482 qbint VSS VSS g45n1svt m=1 l=45n w=205n
Mmn51 n30 CKb net482 VSS g45n1svt m=1 l=45n w=205n
Mmn35 net474 mout VSS VSS g45n1svt m=1 l=45n w=205n
Mmn36 n20 CKbb net474 VSS g45n1svt m=1 l=45n w=205n
Mmn20 CKb CK VSS VSS g45n1svt m=1 l=45n w=145n
Mmn45 qbint n30 VSS VSS g45n1svt m=1 l=45n w=780n
Mmn10 SEb SE VSS VSS g45n1svt m=1 l=45n w=145n
Mmn0 S0b S0 VSS VSS g45n1svt m=1 l=45n w=145n
Mmn11 db SEb dbp VSS g45n1svt m=1 l=45n w=260n
Mmn40 mout CKbb n30 VSS g45n1svt m=1 l=45n w=205n
Mmn25 dbp CKb n20 VSS g45n1svt m=1 l=45n w=205n
Mmn30 mout n20 VSS VSS g45n1svt m=1 l=45n w=205n
Mmn21 CKbb CKb VSS VSS g45n1svt m=1 l=45n w=145n
Mmp3 net429 D1 VDD NW g45p1svt m=1 l=45n w=390n
Mmp4 db S0b net429 NW g45p1svt m=1 l=45n w=390n
Mmp2 db S0 net425 NW g45p1svt m=1 l=45n w=390n
Mmp1 net425 D0 VDD NW g45p1svt m=1 l=45n w=390n
Mmp13 dbp SEb net417 NW g45p1svt m=1 l=45n w=390n
Mmp12 net417 SI VDD NW g45p1svt m=1 l=45n w=390n
Mmp51 n30 CKbb net409 NW g45p1svt m=1 l=45n w=310n
Mmp50 net409 qbint VDD NW g45p1svt m=1 l=45n w=310n
Mmp55 Q qbint VDD NW g45p1svt m=1 l=45n w=3.115u
Mmp35 net393 mout VDD NW g45p1svt m=1 l=45n w=310n
Mmp36 n20 CKb net393 NW g45p1svt m=1 l=45n w=310n
Mmp20 CKb CK VDD NW g45p1svt m=1 l=45n w=215n
Mmp45 qbint n30 VDD NW g45p1svt m=1 l=45n w=1.17u
Mmp0 S0b S0 VDD NW g45p1svt m=1 l=45n w=215n
Mmp40 n30 CKb mout NW g45p1svt m=1 l=45n w=310n
Mmp21 CKbb CKb VDD NW g45p1svt m=1 l=45n w=215n
Mmp30 mout n20 VDD NW g45p1svt m=1 l=45n w=310n
Mmp10 SEb SE VDD NW g45p1svt m=1 l=45n w=215n
Mmp11 dbp SE db NW g45p1svt m=1 l=45n w=390n
Mmp25 n20 CKbb dbp NW g45p1svt m=1 l=45n w=310n
.ENDS

.SUBCKT TBUFX12 A NW OE VDD VSS Y
*.PININFO A:I NW:I OE:I VDD:I VSS:I Y:O
Mmn5 Y non VSS VSS g45n1svt m=1 l=45n w=3.12u
Mmn3 net144 A VSS VSS g45n1svt m=1 l=45n w=770n
Mmn0 OEb OE VSS VSS g45n1svt m=1 l=45n w=260n
Mmn4 pon OE net144 VSS g45n1svt m=1 l=45n w=770n
Mmn2 non OEb VSS VSS g45n1svt m=1 l=45n w=770n
Mmn1 non A VSS VSS g45n1svt m=1 l=45n w=770n
Mmp2 non OEb net127 NW g45p1svt m=1 l=45n w=1.17u
Mmp1 net127 A VDD NW g45p1svt m=1 l=45n w=1.17u
Mmp5 Y pon VDD NW g45p1svt m=1 l=45n w=4.68u
Mmp3 pon A VDD NW g45p1svt m=1 l=45n w=1.17u
Mmp4 pon OE VDD NW g45p1svt m=1 l=45n w=1.17u
Mmp0 OEb OE VDD NW g45p1svt m=1 l=45n w=390n
.ENDS

.SUBCKT TBUFX16 A NW OE VDD VSS Y
*.PININFO A:I NW:I OE:I VDD:I VSS:I Y:O
Mmn5 Y non VSS VSS g45n1svt m=1 l=45n w=4.16u
Mmn3 net144 A VSS VSS g45n1svt m=1 l=45n w=1.025u
Mmn0 OEb OE VSS VSS g45n1svt m=1 l=45n w=260n
Mmn4 pon OE net144 VSS g45n1svt m=1 l=45n w=1.025u
Mmn2 non OEb VSS VSS g45n1svt m=1 l=45n w=1.025u
Mmn1 non A VSS VSS g45n1svt m=1 l=45n w=1.025u
Mmp2 non OEb net127 NW g45p1svt m=1 l=45n w=1.55u
Mmp1 net127 A VDD NW g45p1svt m=1 l=45n w=1.55u
Mmp5 Y pon VDD NW g45p1svt m=1 l=45n w=6.24u
Mmp3 pon A VDD NW g45p1svt m=1 l=45n w=1.55u
Mmp4 pon OE VDD NW g45p1svt m=1 l=45n w=1.55u
Mmp0 OEb OE VDD NW g45p1svt m=1 l=45n w=390n
.ENDS

.SUBCKT TBUFX1 A NW OE VDD VSS Y
*.PININFO A:I NW:I OE:I VDD:I VSS:I Y:O
Mmn5 Y non VSS VSS g45n1svt m=1 l=45n w=260n
Mmn3 net144 A VSS VSS g45n1svt m=1 l=45n w=145n
Mmn0 OEb OE VSS VSS g45n1svt m=1 l=45n w=145n
Mmn4 pon OE net144 VSS g45n1svt m=1 l=45n w=145n
Mmn2 non OEb VSS VSS g45n1svt m=1 l=45n w=145n
Mmn1 non A VSS VSS g45n1svt m=1 l=45n w=145n
Mmp2 non OEb net127 NW g45p1svt m=1 l=45n w=215n
Mmp1 net127 A VDD NW g45p1svt m=1 l=45n w=215n
Mmp5 Y pon VDD NW g45p1svt m=1 l=45n w=390n
Mmp3 pon A VDD NW g45p1svt m=1 l=45n w=215n
Mmp4 pon OE VDD NW g45p1svt m=1 l=45n w=215n
Mmp0 OEb OE VDD NW g45p1svt m=1 l=45n w=215n
.ENDS

.SUBCKT TBUFX20 A NW OE VDD VSS Y
*.PININFO A:I NW:I OE:I VDD:I VSS:I Y:O
Mmn5 Y non VSS VSS g45n1svt m=1 l=45n w=5.2u
Mmn3 net144 A VSS VSS g45n1svt m=1 l=45n w=1.29u
Mmn0 OEb OE VSS VSS g45n1svt m=1 l=45n w=520n
Mmn4 pon OE net144 VSS g45n1svt m=1 l=45n w=1.29u
Mmn2 non OEb VSS VSS g45n1svt m=1 l=45n w=1.29u
Mmn1 non A VSS VSS g45n1svt m=1 l=45n w=1.29u
Mmp2 non OEb net127 NW g45p1svt m=1 l=45n w=1.95u
Mmp1 net127 A VDD NW g45p1svt m=1 l=45n w=1.95u
Mmp5 Y pon VDD NW g45p1svt m=1 l=45n w=7.8u
Mmp3 pon A VDD NW g45p1svt m=1 l=45n w=1.95u
Mmp4 pon OE VDD NW g45p1svt m=1 l=45n w=1.95u
Mmp0 OEb OE VDD NW g45p1svt m=1 l=45n w=780n
.ENDS

.SUBCKT TBUFX2 A NW OE VDD VSS Y
*.PININFO A:I NW:I OE:I VDD:I VSS:I Y:O
Mmn5 Y non VSS VSS g45n1svt m=1 l=45n w=520n
Mmn3 net144 A VSS VSS g45n1svt m=1 l=45n w=145n
Mmn0 OEb OE VSS VSS g45n1svt m=1 l=45n w=145n
Mmn4 pon OE net144 VSS g45n1svt m=1 l=45n w=145n
Mmn2 non OEb VSS VSS g45n1svt m=1 l=45n w=145n
Mmn1 non A VSS VSS g45n1svt m=1 l=45n w=145n
Mmp2 non OEb net127 NW g45p1svt m=1 l=45n w=215n
Mmp1 net127 A VDD NW g45p1svt m=1 l=45n w=215n
Mmp5 Y pon VDD NW g45p1svt m=1 l=45n w=780n
Mmp3 pon A VDD NW g45p1svt m=1 l=45n w=215n
Mmp4 pon OE VDD NW g45p1svt m=1 l=45n w=215n
Mmp0 OEb OE VDD NW g45p1svt m=1 l=45n w=215n
.ENDS

.SUBCKT TBUFX3 A NW OE VDD VSS Y
*.PININFO A:I NW:I OE:I VDD:I VSS:I Y:O
Mmn5 Y non VSS VSS g45n1svt m=1 l=45n w=780n
Mmn3 net144 A VSS VSS g45n1svt m=1 l=45n w=260n
Mmn0 OEb OE VSS VSS g45n1svt m=1 l=45n w=145n
Mmn4 pon OE net144 VSS g45n1svt m=1 l=45n w=260n
Mmn2 non OEb VSS VSS g45n1svt m=1 l=45n w=260n
Mmn1 non A VSS VSS g45n1svt m=1 l=45n w=260n
Mmp2 non OEb net127 NW g45p1svt m=1 l=45n w=390n
Mmp1 net127 A VDD NW g45p1svt m=1 l=45n w=390n
Mmp5 Y pon VDD NW g45p1svt m=1 l=45n w=1.17u
Mmp3 pon A VDD NW g45p1svt m=1 l=45n w=390n
Mmp4 pon OE VDD NW g45p1svt m=1 l=45n w=390n
Mmp0 OEb OE VDD NW g45p1svt m=1 l=45n w=215n
.ENDS

.SUBCKT TBUFX4 A NW OE VDD VSS Y
*.PININFO A:I NW:I OE:I VDD:I VSS:I Y:O
Mmn5 Y non VSS VSS g45n1svt m=1 l=45n w=1.04u
Mmn3 net144 A VSS VSS g45n1svt m=1 l=45n w=260n
Mmn0 OEb OE VSS VSS g45n1svt m=1 l=45n w=145n
Mmn4 pon OE net144 VSS g45n1svt m=1 l=45n w=260n
Mmn2 non OEb VSS VSS g45n1svt m=1 l=45n w=260n
Mmn1 non A VSS VSS g45n1svt m=1 l=45n w=260n
Mmp2 non OEb net127 NW g45p1svt m=1 l=45n w=390n
Mmp1 net127 A VDD NW g45p1svt m=1 l=45n w=390n
Mmp5 Y pon VDD NW g45p1svt m=1 l=45n w=1.56u
Mmp3 pon A VDD NW g45p1svt m=1 l=45n w=390n
Mmp4 pon OE VDD NW g45p1svt m=1 l=45n w=390n
Mmp0 OEb OE VDD NW g45p1svt m=1 l=45n w=215n
.ENDS

.SUBCKT TBUFX6 A NW OE VDD VSS Y
*.PININFO A:I NW:I OE:I VDD:I VSS:I Y:O
Mmn5 Y non VSS VSS g45n1svt m=1 l=45n w=1.56u
Mmn3 net144 A VSS VSS g45n1svt m=1 l=45n w=515n
Mmn0 OEb OE VSS VSS g45n1svt m=1 l=45n w=145n
Mmn4 pon OE net144 VSS g45n1svt m=1 l=45n w=515n
Mmn2 non OEb VSS VSS g45n1svt m=1 l=45n w=515n
Mmn1 non A VSS VSS g45n1svt m=1 l=45n w=515n
Mmp2 non OEb net127 NW g45p1svt m=1 l=45n w=780n
Mmp1 net127 A VDD NW g45p1svt m=1 l=45n w=780n
Mmp5 Y pon VDD NW g45p1svt m=1 l=45n w=2.34u
Mmp3 pon A VDD NW g45p1svt m=1 l=45n w=780n
Mmp4 pon OE VDD NW g45p1svt m=1 l=45n w=780n
Mmp0 OEb OE VDD NW g45p1svt m=1 l=45n w=215n
.ENDS

.SUBCKT TBUFX8 A NW OE VDD VSS Y
*.PININFO A:I NW:I OE:I VDD:I VSS:I Y:O
Mmn5 Y non VSS VSS g45n1svt m=1 l=45n w=2.08u
Mmn3 net144 A VSS VSS g45n1svt m=1 l=45n w=515n
Mmn0 OEb OE VSS VSS g45n1svt m=1 l=45n w=145n
Mmn4 pon OE net144 VSS g45n1svt m=1 l=45n w=515n
Mmn2 non OEb VSS VSS g45n1svt m=1 l=45n w=515n
Mmn1 non A VSS VSS g45n1svt m=1 l=45n w=515n
Mmp2 non OEb net127 NW g45p1svt m=1 l=45n w=780n
Mmp1 net127 A VDD NW g45p1svt m=1 l=45n w=780n
Mmp5 Y pon VDD NW g45p1svt m=1 l=45n w=3.12u
Mmp3 pon A VDD NW g45p1svt m=1 l=45n w=780n
Mmp4 pon OE VDD NW g45p1svt m=1 l=45n w=780n
Mmp0 OEb OE VDD NW g45p1svt m=1 l=45n w=215n
.ENDS

.SUBCKT TBUFXL A NW OE VDD VSS Y
*.PININFO A:I NW:I OE:I VDD:I VSS:I Y:O
Mmn5 Y non VSS VSS g45n1svt m=1 l=45n w=145n
Mmn3 net144 A VSS VSS g45n1svt m=1 l=45n w=145n
Mmn0 OEb OE VSS VSS g45n1svt m=1 l=45n w=145n
Mmn4 pon OE net144 VSS g45n1svt m=1 l=45n w=145n
Mmn2 non OEb VSS VSS g45n1svt m=1 l=45n w=145n
Mmn1 non A VSS VSS g45n1svt m=1 l=45n w=145n
Mmp2 non OEb net127 NW g45p1svt m=1 l=45n w=215n
Mmp1 net127 A VDD NW g45p1svt m=1 l=45n w=215n
Mmp5 Y pon VDD NW g45p1svt m=1 l=45n w=215n
Mmp3 pon A VDD NW g45p1svt m=1 l=45n w=215n
Mmp4 pon OE VDD NW g45p1svt m=1 l=45n w=215n
Mmp0 OEb OE VDD NW g45p1svt m=1 l=45n w=215n
.ENDS

.SUBCKT TIEHI NW VDD VSS Y
*.PININFO NW:I VDD:I VSS:I Y:O
Mmp0 Y net25 VDD NW g45p1svt m=1 l=45n w=390n
Mmn0 net25 net25 VSS VSS g45n1svt m=1 l=45n w=260n
.ENDS

.SUBCKT TIELO NW VDD VSS Y
*.PININFO NW:I VDD:I VSS:I Y:O
Mmp0 net25 net25 VDD NW g45p1svt m=1 l=45n w=390n
Mmn0 Y net25 VSS VSS g45n1svt m=1 l=45n w=260n
.ENDS

.SUBCKT TLATNCAX12 CK E ECK NW VDD VSS
*.PININFO CK:I E:I NW:I VDD:I VSS:I ECK:O
Mmn5 net254 E VSS VSS g45n1svt m=1 l=45n w=145n
Mmn6 n0 CKb net254 VSS g45n1svt m=1 l=45n w=145n
Mmn22 ECK ECKb VSS VSS g45n1svt m=1 l=45n w=3.1u
Mmn21 ECKb CKbb net238 VSS g45n1svt m=1 l=45n w=780n
Mmn20 net238 Eint VSS VSS g45n1svt m=1 l=45n w=780n
Mmn16 n0 CKbb net230 VSS g45n1svt m=1 l=45n w=145n
Mmn15 net230 Eint VSS VSS g45n1svt m=1 l=45n w=145n
Mmn0 CKb CK VSS VSS g45n1svt m=1 l=45n w=145n
Mmn10 Eint n0 VSS VSS g45n1svt m=1 l=45n w=260n
Mmn1 CKbb CKb VSS VSS g45n1svt m=1 l=45n w=145n
Mmp6 n0 CKbb net217 NW g45p1svt m=1 l=45n w=215n
Mmp5 net217 E VDD NW g45p1svt m=1 l=45n w=215n
Mmp22 ECK ECKb VDD NW g45p1svt m=1 l=45n w=4.7u
Mmp16 n0 CKb net205 NW g45p1svt m=1 l=45n w=215n
Mmp15 net205 Eint VDD NW g45p1svt m=1 l=45n w=215n
Mmp0 CKb CK VDD NW g45p1svt m=1 l=45n w=215n
Mmp1 CKbb CKb VDD NW g45p1svt m=1 l=45n w=215n
Mmp20 ECKb Eint VDD NW g45p1svt m=1 l=45n w=1.17u
Mmp21 ECKb CKbb VDD NW g45p1svt m=1 l=45n w=1.17u
Mmp10 Eint n0 VDD NW g45p1svt m=1 l=45n w=390n
.ENDS

.SUBCKT TLATNCAX16 CK E ECK NW VDD VSS
*.PININFO CK:I E:I NW:I VDD:I VSS:I ECK:O
Mmn5 net254 E VSS VSS g45n1svt m=1 l=45n w=145n
Mmn6 n0 CKb net254 VSS g45n1svt m=1 l=45n w=145n
Mmn22 ECK ECKb VSS VSS g45n1svt m=1 l=45n w=4.13u
Mmn21 ECKb CKbb net238 VSS g45n1svt m=1 l=45n w=1.04u
Mmn20 net238 Eint VSS VSS g45n1svt m=1 l=45n w=1.04u
Mmn16 n0 CKbb net230 VSS g45n1svt m=1 l=45n w=145n
Mmn15 net230 Eint VSS VSS g45n1svt m=1 l=45n w=145n
Mmn0 CKb CK VSS VSS g45n1svt m=1 l=45n w=145n
Mmn10 Eint n0 VSS VSS g45n1svt m=1 l=45n w=410n
Mmn1 CKbb CKb VSS VSS g45n1svt m=1 l=45n w=145n
Mmp6 n0 CKbb net217 NW g45p1svt m=1 l=45n w=215n
Mmp5 net217 E VDD NW g45p1svt m=1 l=45n w=215n
Mmp22 ECK ECKb VDD NW g45p1svt m=1 l=45n w=6.23u
Mmp16 n0 CKb net205 NW g45p1svt m=1 l=45n w=215n
Mmp15 net205 Eint VDD NW g45p1svt m=1 l=45n w=215n
Mmp0 CKb CK VDD NW g45p1svt m=1 l=45n w=215n
Mmp1 CKbb CKb VDD NW g45p1svt m=1 l=45n w=215n
Mmp20 ECKb Eint VDD NW g45p1svt m=1 l=45n w=1.56u
Mmp21 ECKb CKbb VDD NW g45p1svt m=1 l=45n w=1.56u
Mmp10 Eint n0 VDD NW g45p1svt m=1 l=45n w=620n
.ENDS

.SUBCKT TLATNCAX20 CK E ECK NW VDD VSS
*.PININFO CK:I E:I NW:I VDD:I VSS:I ECK:O
Mmn5 net254 E VSS VSS g45n1svt m=1 l=45n w=145n
Mmn6 n0 CKb net254 VSS g45n1svt m=1 l=45n w=145n
Mmn22 ECK ECKb VSS VSS g45n1svt m=1 l=45n w=5.185u
Mmn21 ECKb CKbb net238 VSS g45n1svt m=1 l=45n w=1.3u
Mmn20 net238 Eint VSS VSS g45n1svt m=1 l=45n w=1.3u
Mmn16 n0 CKbb net230 VSS g45n1svt m=1 l=45n w=145n
Mmn15 net230 Eint VSS VSS g45n1svt m=1 l=45n w=145n
Mmn0 CKb CK VSS VSS g45n1svt m=1 l=45n w=145n
Mmn10 Eint n0 VSS VSS g45n1svt m=1 l=45n w=520n
Mmn1 CKbb CKb VSS VSS g45n1svt m=1 l=45n w=145n
Mmp6 n0 CKbb net217 NW g45p1svt m=1 l=45n w=215n
Mmp5 net217 E VDD NW g45p1svt m=1 l=45n w=215n
Mmp22 ECK ECKb VDD NW g45p1svt m=1 l=45n w=7.815u
Mmp16 n0 CKb net205 NW g45p1svt m=1 l=45n w=215n
Mmp15 net205 Eint VDD NW g45p1svt m=1 l=45n w=215n
Mmp0 CKb CK VDD NW g45p1svt m=1 l=45n w=215n
Mmp1 CKbb CKb VDD NW g45p1svt m=1 l=45n w=215n
Mmp20 ECKb Eint VDD NW g45p1svt m=1 l=45n w=1.95u
Mmp21 ECKb CKbb VDD NW g45p1svt m=1 l=45n w=1.95u
Mmp10 Eint n0 VDD NW g45p1svt m=1 l=45n w=780n
.ENDS

.SUBCKT TLATNCAX2 CK E ECK NW VDD VSS
*.PININFO CK:I E:I NW:I VDD:I VSS:I ECK:O
Mmn5 net254 E VSS VSS g45n1svt m=1 l=45n w=145n
Mmn6 n0 CKb net254 VSS g45n1svt m=1 l=45n w=145n
Mmn22 ECK ECKb VSS VSS g45n1svt m=1 l=45n w=520n
Mmn21 ECKb CKbb net238 VSS g45n1svt m=1 l=45n w=145n
Mmn20 net238 Eint VSS VSS g45n1svt m=1 l=45n w=145n
Mmn16 n0 CKbb net230 VSS g45n1svt m=1 l=45n w=145n
Mmn15 net230 Eint VSS VSS g45n1svt m=1 l=45n w=145n
Mmn0 CKb CK VSS VSS g45n1svt m=1 l=45n w=145n
Mmn10 Eint n0 VSS VSS g45n1svt m=1 l=45n w=145n
Mmn1 CKbb CKb VSS VSS g45n1svt m=1 l=45n w=145n
Mmp6 n0 CKbb net217 NW g45p1svt m=1 l=45n w=215n
Mmp5 net217 E VDD NW g45p1svt m=1 l=45n w=215n
Mmp22 ECK ECKb VDD NW g45p1svt m=1 l=45n w=780n
Mmp16 n0 CKb net205 NW g45p1svt m=1 l=45n w=215n
Mmp15 net205 Eint VDD NW g45p1svt m=1 l=45n w=215n
Mmp0 CKb CK VDD NW g45p1svt m=1 l=45n w=215n
Mmp1 CKbb CKb VDD NW g45p1svt m=1 l=45n w=215n
Mmp20 ECKb Eint VDD NW g45p1svt m=1 l=45n w=215n
Mmp21 ECKb CKbb VDD NW g45p1svt m=1 l=45n w=215n
Mmp10 Eint n0 VDD NW g45p1svt m=1 l=45n w=215n
.ENDS

.SUBCKT TLATNCAX3 CK E ECK NW VDD VSS
*.PININFO CK:I E:I NW:I VDD:I VSS:I ECK:O
Mmn5 net254 E VSS VSS g45n1svt m=1 l=45n w=145n
Mmn6 n0 CKb net254 VSS g45n1svt m=1 l=45n w=145n
Mmn22 ECK ECKb VSS VSS g45n1svt m=1 l=45n w=780n
Mmn21 ECKb CKbb net238 VSS g45n1svt m=1 l=45n w=260n
Mmn20 net238 Eint VSS VSS g45n1svt m=1 l=45n w=260n
Mmn16 n0 CKbb net230 VSS g45n1svt m=1 l=45n w=145n
Mmn15 net230 Eint VSS VSS g45n1svt m=1 l=45n w=145n
Mmn0 CKb CK VSS VSS g45n1svt m=1 l=45n w=145n
Mmn10 Eint n0 VSS VSS g45n1svt m=1 l=45n w=145n
Mmn1 CKbb CKb VSS VSS g45n1svt m=1 l=45n w=145n
Mmp6 n0 CKbb net217 NW g45p1svt m=1 l=45n w=215n
Mmp5 net217 E VDD NW g45p1svt m=1 l=45n w=215n
Mmp22 ECK ECKb VDD NW g45p1svt m=1 l=45n w=1.17u
Mmp16 n0 CKb net205 NW g45p1svt m=1 l=45n w=215n
Mmp15 net205 Eint VDD NW g45p1svt m=1 l=45n w=215n
Mmp0 CKb CK VDD NW g45p1svt m=1 l=45n w=215n
Mmp1 CKbb CKb VDD NW g45p1svt m=1 l=45n w=215n
Mmp20 ECKb Eint VDD NW g45p1svt m=1 l=45n w=390n
Mmp21 ECKb CKbb VDD NW g45p1svt m=1 l=45n w=390n
Mmp10 Eint n0 VDD NW g45p1svt m=1 l=45n w=215n
.ENDS

.SUBCKT TLATNCAX4 CK E ECK NW VDD VSS
*.PININFO CK:I E:I NW:I VDD:I VSS:I ECK:O
Mmn5 net254 E VSS VSS g45n1svt m=1 l=45n w=145n
Mmn6 n0 CKb net254 VSS g45n1svt m=1 l=45n w=145n
Mmn22 ECK ECKb VSS VSS g45n1svt m=1 l=45n w=1.04u
Mmn21 ECKb CKbb net238 VSS g45n1svt m=1 l=45n w=260n
Mmn20 net238 Eint VSS VSS g45n1svt m=1 l=45n w=260n
Mmn16 n0 CKbb net230 VSS g45n1svt m=1 l=45n w=145n
Mmn15 net230 Eint VSS VSS g45n1svt m=1 l=45n w=145n
Mmn0 CKb CK VSS VSS g45n1svt m=1 l=45n w=145n
Mmn10 Eint n0 VSS VSS g45n1svt m=1 l=45n w=145n
Mmn1 CKbb CKb VSS VSS g45n1svt m=1 l=45n w=145n
Mmp6 n0 CKbb net217 NW g45p1svt m=1 l=45n w=215n
Mmp5 net217 E VDD NW g45p1svt m=1 l=45n w=215n
Mmp22 ECK ECKb VDD NW g45p1svt m=1 l=45n w=1.56u
Mmp16 n0 CKb net205 NW g45p1svt m=1 l=45n w=215n
Mmp15 net205 Eint VDD NW g45p1svt m=1 l=45n w=215n
Mmp0 CKb CK VDD NW g45p1svt m=1 l=45n w=215n
Mmp1 CKbb CKb VDD NW g45p1svt m=1 l=45n w=215n
Mmp20 ECKb Eint VDD NW g45p1svt m=1 l=45n w=390n
Mmp21 ECKb CKbb VDD NW g45p1svt m=1 l=45n w=390n
Mmp10 Eint n0 VDD NW g45p1svt m=1 l=45n w=215n
.ENDS

.SUBCKT TLATNCAX6 CK E ECK NW VDD VSS
*.PININFO CK:I E:I NW:I VDD:I VSS:I ECK:O
Mmn5 net254 E VSS VSS g45n1svt m=1 l=45n w=145n
Mmn6 n0 CKb net254 VSS g45n1svt m=1 l=45n w=145n
Mmn22 ECK ECKb VSS VSS g45n1svt m=1 l=45n w=1.55u
Mmn21 ECKb CKbb net238 VSS g45n1svt m=1 l=45n w=520n
Mmn20 net238 Eint VSS VSS g45n1svt m=1 l=45n w=520n
Mmn16 n0 CKbb net230 VSS g45n1svt m=1 l=45n w=145n
Mmn15 net230 Eint VSS VSS g45n1svt m=1 l=45n w=145n
Mmn0 CKb CK VSS VSS g45n1svt m=1 l=45n w=145n
Mmn10 Eint n0 VSS VSS g45n1svt m=1 l=45n w=205n
Mmn1 CKbb CKb VSS VSS g45n1svt m=1 l=45n w=145n
Mmp6 n0 CKbb net217 NW g45p1svt m=1 l=45n w=215n
Mmp5 net217 E VDD NW g45p1svt m=1 l=45n w=215n
Mmp22 ECK ECKb VDD NW g45p1svt m=1 l=45n w=2.35u
Mmp16 n0 CKb net205 NW g45p1svt m=1 l=45n w=215n
Mmp15 net205 Eint VDD NW g45p1svt m=1 l=45n w=215n
Mmp0 CKb CK VDD NW g45p1svt m=1 l=45n w=215n
Mmp1 CKbb CKb VDD NW g45p1svt m=1 l=45n w=215n
Mmp20 ECKb Eint VDD NW g45p1svt m=1 l=45n w=780n
Mmp21 ECKb CKbb VDD NW g45p1svt m=1 l=45n w=780n
Mmp10 Eint n0 VDD NW g45p1svt m=1 l=45n w=310n
.ENDS

.SUBCKT TLATNCAX8 CK E ECK NW VDD VSS
*.PININFO CK:I E:I NW:I VDD:I VSS:I ECK:O
Mmn5 net254 E VSS VSS g45n1svt m=1 l=45n w=145n
Mmn6 n0 CKb net254 VSS g45n1svt m=1 l=45n w=145n
Mmn22 ECK ECKb VSS VSS g45n1svt m=1 l=45n w=2.065u
Mmn21 ECKb CKbb net238 VSS g45n1svt m=1 l=45n w=520n
Mmn20 net238 Eint VSS VSS g45n1svt m=1 l=45n w=520n
Mmn16 n0 CKbb net230 VSS g45n1svt m=1 l=45n w=145n
Mmn15 net230 Eint VSS VSS g45n1svt m=1 l=45n w=145n
Mmn0 CKb CK VSS VSS g45n1svt m=1 l=45n w=145n
Mmn10 Eint n0 VSS VSS g45n1svt m=1 l=45n w=205n
Mmn1 CKbb CKb VSS VSS g45n1svt m=1 l=45n w=145n
Mmp6 n0 CKbb net217 NW g45p1svt m=1 l=45n w=215n
Mmp5 net217 E VDD NW g45p1svt m=1 l=45n w=215n
Mmp22 ECK ECKb VDD NW g45p1svt m=1 l=45n w=3.115u
Mmp16 n0 CKb net205 NW g45p1svt m=1 l=45n w=215n
Mmp15 net205 Eint VDD NW g45p1svt m=1 l=45n w=215n
Mmp0 CKb CK VDD NW g45p1svt m=1 l=45n w=215n
Mmp1 CKbb CKb VDD NW g45p1svt m=1 l=45n w=215n
Mmp20 ECKb Eint VDD NW g45p1svt m=1 l=45n w=780n
Mmp21 ECKb CKbb VDD NW g45p1svt m=1 l=45n w=780n
Mmp10 Eint n0 VDD NW g45p1svt m=1 l=45n w=310n
.ENDS

.SUBCKT TLATNSRX1 D GN NW Q QN RN SN VDD VSS
*.PININFO D:I GN:I NW:I RN:I SN:I VDD:I VSS:I Q:O QN:O
Mmn5 net366 D VSS VSS g45n1svt m=1 l=45n w=145n
Mmn6 n5 GNb net366 VSS g45n1svt m=1 l=45n w=145n
Mmn17 n5 GNbb net354 VSS g45n1svt m=1 l=45n w=145n
Mmn16 net354 qint net350 VSS g45n1svt m=1 l=45n w=145n
Mmn15 net350 RN VSS VSS g45n1svt m=1 l=45n w=145n
Mmn11 qint n5 net342 VSS g45n1svt m=1 l=45n w=145n
Mmn10 net342 SN VSS VSS g45n1svt m=1 l=45n w=145n
Mmn21 Q qbint VSS VSS g45n1svt m=1 l=45n w=260n
Mmn0 GNbp GN VSS VSS g45n1svt m=1 l=45n w=145n
Mmn2 GNbb GNbp net326 VSS g45n1svt m=1 l=45n w=145n
Mmn1 net326 RN VSS VSS g45n1svt m=1 l=45n w=145n
Mmn3 GNb GNbb VSS VSS g45n1svt m=1 l=45n w=145n
Mmn20 qbint qint VSS VSS g45n1svt m=1 l=45n w=260n
Mmn22 QN qint VSS VSS g45n1svt m=1 l=45n w=260n
Mmp6 n5 GNbb net313 NW g45p1svt m=1 l=45n w=215n
Mmp5 net313 D VDD NW g45p1svt m=1 l=45n w=215n
Mmp10 qint SN VDD NW g45p1svt m=1 l=45n w=215n
Mmp22 QN qint VDD NW g45p1svt m=1 l=45n w=390n
Mmp21 Q qbint VDD NW g45p1svt m=1 l=45n w=390n
Mmp0 GNbp GN VDD NW g45p1svt m=1 l=45n w=215n
Mmp3 GNb GNbb VDD NW g45p1svt m=1 l=45n w=215n
Mmp17 n5 GNb net270 NW g45p1svt m=1 l=45n w=215n
Mmp2 GNbb GNbp VDD NW g45p1svt m=1 l=45n w=215n
Mmp16 net270 qint VDD NW g45p1svt m=1 l=45n w=215n
Mmp15 net270 RN VDD NW g45p1svt m=1 l=45n w=215n
Mmp20 qbint qint VDD NW g45p1svt m=1 l=45n w=390n
Mmp1 GNbb RN VDD NW g45p1svt m=1 l=45n w=215n
Mmp11 qint n5 VDD NW g45p1svt m=1 l=45n w=215n
.ENDS

.SUBCKT TLATNSRX2 D GN NW Q QN RN SN VDD VSS
*.PININFO D:I GN:I NW:I RN:I SN:I VDD:I VSS:I Q:O QN:O
Mmn5 net366 D VSS VSS g45n1svt m=1 l=45n w=145n
Mmn6 n5 GNb net366 VSS g45n1svt m=1 l=45n w=145n
Mmn17 n5 GNbb net354 VSS g45n1svt m=1 l=45n w=145n
Mmn16 net354 qint net350 VSS g45n1svt m=1 l=45n w=145n
Mmn15 net350 RN VSS VSS g45n1svt m=1 l=45n w=145n
Mmn11 qint n5 net342 VSS g45n1svt m=1 l=45n w=205n
Mmn10 net342 SN VSS VSS g45n1svt m=1 l=45n w=205n
Mmn21 Q qbint VSS VSS g45n1svt m=1 l=45n w=520n
Mmn0 GNbp GN VSS VSS g45n1svt m=1 l=45n w=145n
Mmn2 GNbb GNbp net326 VSS g45n1svt m=1 l=45n w=145n
Mmn1 net326 RN VSS VSS g45n1svt m=1 l=45n w=145n
Mmn3 GNb GNbb VSS VSS g45n1svt m=1 l=45n w=145n
Mmn20 qbint qint VSS VSS g45n1svt m=1 l=45n w=520n
Mmn22 QN qint VSS VSS g45n1svt m=1 l=45n w=520n
Mmp6 n5 GNbb net313 NW g45p1svt m=1 l=45n w=215n
Mmp5 net313 D VDD NW g45p1svt m=1 l=45n w=215n
Mmp10 qint SN VDD NW g45p1svt m=1 l=45n w=310n
Mmp22 QN qint VDD NW g45p1svt m=1 l=45n w=780n
Mmp21 Q qbint VDD NW g45p1svt m=1 l=45n w=780n
Mmp0 GNbp GN VDD NW g45p1svt m=1 l=45n w=215n
Mmp3 GNb GNbb VDD NW g45p1svt m=1 l=45n w=215n
Mmp17 n5 GNb net270 NW g45p1svt m=1 l=45n w=215n
Mmp2 GNbb GNbp VDD NW g45p1svt m=1 l=45n w=215n
Mmp16 net270 qint VDD NW g45p1svt m=1 l=45n w=215n
Mmp15 net270 RN VDD NW g45p1svt m=1 l=45n w=215n
Mmp20 qbint qint VDD NW g45p1svt m=1 l=45n w=780n
Mmp1 GNbb RN VDD NW g45p1svt m=1 l=45n w=215n
Mmp11 qint n5 VDD NW g45p1svt m=1 l=45n w=310n
.ENDS

.SUBCKT TLATNSRX4 D GN NW Q QN RN SN VDD VSS
*.PININFO D:I GN:I NW:I RN:I SN:I VDD:I VSS:I Q:O QN:O
Mmn5 net366 D VSS VSS g45n1svt m=1 l=45n w=145n
Mmn6 n5 GNb net366 VSS g45n1svt m=1 l=45n w=145n
Mmn17 n5 GNbb net354 VSS g45n1svt m=1 l=45n w=145n
Mmn16 net354 qint net350 VSS g45n1svt m=1 l=45n w=145n
Mmn15 net350 RN VSS VSS g45n1svt m=1 l=45n w=145n
Mmn11 qint n5 net342 VSS g45n1svt m=1 l=45n w=410n
Mmn10 net342 SN VSS VSS g45n1svt m=1 l=45n w=410n
Mmn21 Q qbint VSS VSS g45n1svt m=1 l=45n w=1.04u
Mmn0 GNbp GN VSS VSS g45n1svt m=1 l=45n w=145n
Mmn2 GNbb GNbp net326 VSS g45n1svt m=1 l=45n w=145n
Mmn1 net326 RN VSS VSS g45n1svt m=1 l=45n w=145n
Mmn3 GNb GNbb VSS VSS g45n1svt m=1 l=45n w=145n
Mmn20 qbint qint VSS VSS g45n1svt m=1 l=45n w=1.04u
Mmn22 QN qint VSS VSS g45n1svt m=1 l=45n w=1.04u
Mmp6 n5 GNbb net313 NW g45p1svt m=1 l=45n w=215n
Mmp5 net313 D VDD NW g45p1svt m=1 l=45n w=215n
Mmp10 qint SN VDD NW g45p1svt m=1 l=45n w=620n
Mmp22 QN qint VDD NW g45p1svt m=1 l=45n w=1.56u
Mmp21 Q qbint VDD NW g45p1svt m=1 l=45n w=1.56u
Mmp0 GNbp GN VDD NW g45p1svt m=1 l=45n w=215n
Mmp3 GNb GNbb VDD NW g45p1svt m=1 l=45n w=215n
Mmp17 n5 GNb net270 NW g45p1svt m=1 l=45n w=215n
Mmp2 GNbb GNbp VDD NW g45p1svt m=1 l=45n w=215n
Mmp16 net270 qint VDD NW g45p1svt m=1 l=45n w=215n
Mmp15 net270 RN VDD NW g45p1svt m=1 l=45n w=215n
Mmp20 qbint qint VDD NW g45p1svt m=1 l=45n w=1.56u
Mmp1 GNbb RN VDD NW g45p1svt m=1 l=45n w=215n
Mmp11 qint n5 VDD NW g45p1svt m=1 l=45n w=620n
.ENDS

.SUBCKT TLATNSRXL D GN NW Q QN RN SN VDD VSS
*.PININFO D:I GN:I NW:I RN:I SN:I VDD:I VSS:I Q:O QN:O
Mmn5 net366 D VSS VSS g45n1svt m=1 l=45n w=145n
Mmn6 n5 GNb net366 VSS g45n1svt m=1 l=45n w=145n
Mmn17 n5 GNbb net354 VSS g45n1svt m=1 l=45n w=145n
Mmn16 net354 qint net350 VSS g45n1svt m=1 l=45n w=145n
Mmn15 net350 RN VSS VSS g45n1svt m=1 l=45n w=145n
Mmn11 qint n5 net342 VSS g45n1svt m=1 l=45n w=145n
Mmn10 net342 SN VSS VSS g45n1svt m=1 l=45n w=145n
Mmn21 Q qbint VSS VSS g45n1svt m=1 l=45n w=145n
Mmn0 GNbp GN VSS VSS g45n1svt m=1 l=45n w=145n
Mmn2 GNbb GNbp net326 VSS g45n1svt m=1 l=45n w=145n
Mmn1 net326 RN VSS VSS g45n1svt m=1 l=45n w=145n
Mmn3 GNb GNbb VSS VSS g45n1svt m=1 l=45n w=145n
Mmn20 qbint qint VSS VSS g45n1svt m=1 l=45n w=145n
Mmn22 QN qint VSS VSS g45n1svt m=1 l=45n w=145n
Mmp6 n5 GNbb net313 NW g45p1svt m=1 l=45n w=215n
Mmp5 net313 D VDD NW g45p1svt m=1 l=45n w=215n
Mmp10 qint SN VDD NW g45p1svt m=1 l=45n w=215n
Mmp22 QN qint VDD NW g45p1svt m=1 l=45n w=215n
Mmp21 Q qbint VDD NW g45p1svt m=1 l=45n w=215n
Mmp0 GNbp GN VDD NW g45p1svt m=1 l=45n w=215n
Mmp3 GNb GNbb VDD NW g45p1svt m=1 l=45n w=215n
Mmp17 n5 GNb net270 NW g45p1svt m=1 l=45n w=215n
Mmp2 GNbb GNbp VDD NW g45p1svt m=1 l=45n w=215n
Mmp16 net270 qint VDD NW g45p1svt m=1 l=45n w=215n
Mmp15 net270 RN VDD NW g45p1svt m=1 l=45n w=215n
Mmp20 qbint qint VDD NW g45p1svt m=1 l=45n w=215n
Mmp1 GNbb RN VDD NW g45p1svt m=1 l=45n w=215n
Mmp11 qint n5 VDD NW g45p1svt m=1 l=45n w=215n
.ENDS

.SUBCKT TLATNTSCAX12 CK E ECK NW SE VDD VSS
*.PININFO CK:I E:I NW:I SE:I VDD:I VSS:I ECK:O
Mmn1 Eb E VSS VSS g45n1svt m=1 l=45n w=145n
Mmn0 Eb SE VSS VSS g45n1svt m=1 l=45n w=145n
Mmn22 ECK ECKb VSS VSS g45n1svt m=1 l=45n w=3.1u
Mmn21 ECKb CKbb net271 VSS g45n1svt m=1 l=45n w=780n
Mmn20 net271 Eint VSS VSS g45n1svt m=1 l=45n w=780n
Mmn16 n5 CKbb net263 VSS g45n1svt m=1 l=45n w=145n
Mmn15 net263 Eint VSS VSS g45n1svt m=1 l=45n w=145n
Mmn2 CKb CK VSS VSS g45n1svt m=1 l=45n w=145n
Mmn10 Eint n5 VSS VSS g45n1svt m=1 l=45n w=260n
Mmn5 Eb CKb n5 VSS g45n1svt m=1 l=45n w=145n
Mmn3 CKbb CKb VSS VSS g45n1svt m=1 l=45n w=145n
Mmp1 Eb E net246 NW g45p1svt m=1 l=45n w=215n
Mmp0 net246 SE VDD NW g45p1svt m=1 l=45n w=215n
Mmp22 ECK ECKb VDD NW g45p1svt m=1 l=45n w=4.7u
Mmp16 n5 CKb net234 NW g45p1svt m=1 l=45n w=215n
Mmp15 net234 Eint VDD NW g45p1svt m=1 l=45n w=215n
Mmp2 CKb CK VDD NW g45p1svt m=1 l=45n w=215n
Mmp10 Eint n5 VDD NW g45p1svt m=1 l=45n w=390n
Mmp3 CKbb CKb VDD NW g45p1svt m=1 l=45n w=215n
Mmp5 n5 CKbb Eb NW g45p1svt m=1 l=45n w=215n
Mmp21 ECKb CKbb VDD NW g45p1svt m=1 l=45n w=1.17u
Mmp20 ECKb Eint VDD NW g45p1svt m=1 l=45n w=1.17u
.ENDS

.SUBCKT TLATNTSCAX16 CK E ECK NW SE VDD VSS
*.PININFO CK:I E:I NW:I SE:I VDD:I VSS:I ECK:O
Mmn1 Eb E VSS VSS g45n1svt m=1 l=45n w=145n
Mmn0 Eb SE VSS VSS g45n1svt m=1 l=45n w=145n
Mmn22 ECK ECKb VSS VSS g45n1svt m=1 l=45n w=4.13u
Mmn21 ECKb CKbb net271 VSS g45n1svt m=1 l=45n w=1.04u
Mmn20 net271 Eint VSS VSS g45n1svt m=1 l=45n w=1.04u
Mmn16 n5 CKbb net263 VSS g45n1svt m=1 l=45n w=145n
Mmn15 net263 Eint VSS VSS g45n1svt m=1 l=45n w=145n
Mmn2 CKb CK VSS VSS g45n1svt m=1 l=45n w=145n
Mmn10 Eint n5 VSS VSS g45n1svt m=1 l=45n w=410n
Mmn5 Eb CKb n5 VSS g45n1svt m=1 l=45n w=145n
Mmn3 CKbb CKb VSS VSS g45n1svt m=1 l=45n w=145n
Mmp1 Eb E net246 NW g45p1svt m=1 l=45n w=215n
Mmp0 net246 SE VDD NW g45p1svt m=1 l=45n w=215n
Mmp22 ECK ECKb VDD NW g45p1svt m=1 l=45n w=6.23u
Mmp16 n5 CKb net234 NW g45p1svt m=1 l=45n w=215n
Mmp15 net234 Eint VDD NW g45p1svt m=1 l=45n w=215n
Mmp2 CKb CK VDD NW g45p1svt m=1 l=45n w=215n
Mmp10 Eint n5 VDD NW g45p1svt m=1 l=45n w=620n
Mmp3 CKbb CKb VDD NW g45p1svt m=1 l=45n w=215n
Mmp5 n5 CKbb Eb NW g45p1svt m=1 l=45n w=215n
Mmp21 ECKb CKbb VDD NW g45p1svt m=1 l=45n w=1.56u
Mmp20 ECKb Eint VDD NW g45p1svt m=1 l=45n w=1.56u
.ENDS

.SUBCKT TLATNTSCAX20 CK E ECK NW SE VDD VSS
*.PININFO CK:I E:I NW:I SE:I VDD:I VSS:I ECK:O
Mmn1 Eb E VSS VSS g45n1svt m=1 l=45n w=145n
Mmn0 Eb SE VSS VSS g45n1svt m=1 l=45n w=145n
Mmn22 ECK ECKb VSS VSS g45n1svt m=1 l=45n w=5.185u
Mmn21 ECKb CKbb net271 VSS g45n1svt m=1 l=45n w=1.3u
Mmn20 net271 Eint VSS VSS g45n1svt m=1 l=45n w=1.3u
Mmn16 n5 CKbb net263 VSS g45n1svt m=1 l=45n w=145n
Mmn15 net263 Eint VSS VSS g45n1svt m=1 l=45n w=145n
Mmn2 CKb CK VSS VSS g45n1svt m=1 l=45n w=145n
Mmn10 Eint n5 VSS VSS g45n1svt m=1 l=45n w=520n
Mmn5 Eb CKb n5 VSS g45n1svt m=1 l=45n w=145n
Mmn3 CKbb CKb VSS VSS g45n1svt m=1 l=45n w=145n
Mmp1 Eb E net246 NW g45p1svt m=1 l=45n w=215n
Mmp0 net246 SE VDD NW g45p1svt m=1 l=45n w=215n
Mmp22 ECK ECKb VDD NW g45p1svt m=1 l=45n w=7.815u
Mmp16 n5 CKb net234 NW g45p1svt m=1 l=45n w=215n
Mmp15 net234 Eint VDD NW g45p1svt m=1 l=45n w=215n
Mmp2 CKb CK VDD NW g45p1svt m=1 l=45n w=215n
Mmp10 Eint n5 VDD NW g45p1svt m=1 l=45n w=780n
Mmp3 CKbb CKb VDD NW g45p1svt m=1 l=45n w=215n
Mmp5 n5 CKbb Eb NW g45p1svt m=1 l=45n w=215n
Mmp21 ECKb CKbb VDD NW g45p1svt m=1 l=45n w=1.95u
Mmp20 ECKb Eint VDD NW g45p1svt m=1 l=45n w=1.95u
.ENDS

.SUBCKT TLATNTSCAX2 CK E ECK NW SE VDD VSS
*.PININFO CK:I E:I NW:I SE:I VDD:I VSS:I ECK:O
Mmn1 Eb E VSS VSS g45n1svt m=1 l=45n w=145n
Mmn0 Eb SE VSS VSS g45n1svt m=1 l=45n w=145n
Mmn22 ECK ECKb VSS VSS g45n1svt m=1 l=45n w=520n
Mmn21 ECKb CKbb net271 VSS g45n1svt m=1 l=45n w=145n
Mmn20 net271 Eint VSS VSS g45n1svt m=1 l=45n w=145n
Mmn16 n5 CKbb net263 VSS g45n1svt m=1 l=45n w=145n
Mmn15 net263 Eint VSS VSS g45n1svt m=1 l=45n w=145n
Mmn2 CKb CK VSS VSS g45n1svt m=1 l=45n w=145n
Mmn10 Eint n5 VSS VSS g45n1svt m=1 l=45n w=145n
Mmn5 Eb CKb n5 VSS g45n1svt m=1 l=45n w=145n
Mmn3 CKbb CKb VSS VSS g45n1svt m=1 l=45n w=145n
Mmp1 Eb E net246 NW g45p1svt m=1 l=45n w=215n
Mmp0 net246 SE VDD NW g45p1svt m=1 l=45n w=215n
Mmp22 ECK ECKb VDD NW g45p1svt m=1 l=45n w=780n
Mmp16 n5 CKb net234 NW g45p1svt m=1 l=45n w=215n
Mmp15 net234 Eint VDD NW g45p1svt m=1 l=45n w=215n
Mmp2 CKb CK VDD NW g45p1svt m=1 l=45n w=215n
Mmp10 Eint n5 VDD NW g45p1svt m=1 l=45n w=215n
Mmp3 CKbb CKb VDD NW g45p1svt m=1 l=45n w=215n
Mmp5 n5 CKbb Eb NW g45p1svt m=1 l=45n w=215n
Mmp21 ECKb CKbb VDD NW g45p1svt m=1 l=45n w=215n
Mmp20 ECKb Eint VDD NW g45p1svt m=1 l=45n w=215n
.ENDS

.SUBCKT TLATNTSCAX3 CK E ECK NW SE VDD VSS
*.PININFO CK:I E:I NW:I SE:I VDD:I VSS:I ECK:O
Mmn1 Eb E VSS VSS g45n1svt m=1 l=45n w=145n
Mmn0 Eb SE VSS VSS g45n1svt m=1 l=45n w=145n
Mmn22 ECK ECKb VSS VSS g45n1svt m=1 l=45n w=780n
Mmn21 ECKb CKbb net271 VSS g45n1svt m=1 l=45n w=260n
Mmn20 net271 Eint VSS VSS g45n1svt m=1 l=45n w=260n
Mmn16 n5 CKbb net263 VSS g45n1svt m=1 l=45n w=145n
Mmn15 net263 Eint VSS VSS g45n1svt m=1 l=45n w=145n
Mmn2 CKb CK VSS VSS g45n1svt m=1 l=45n w=145n
Mmn10 Eint n5 VSS VSS g45n1svt m=1 l=45n w=145n
Mmn5 Eb CKb n5 VSS g45n1svt m=1 l=45n w=145n
Mmn3 CKbb CKb VSS VSS g45n1svt m=1 l=45n w=145n
Mmp1 Eb E net246 NW g45p1svt m=1 l=45n w=215n
Mmp0 net246 SE VDD NW g45p1svt m=1 l=45n w=215n
Mmp22 ECK ECKb VDD NW g45p1svt m=1 l=45n w=1.17u
Mmp16 n5 CKb net234 NW g45p1svt m=1 l=45n w=215n
Mmp15 net234 Eint VDD NW g45p1svt m=1 l=45n w=215n
Mmp2 CKb CK VDD NW g45p1svt m=1 l=45n w=215n
Mmp10 Eint n5 VDD NW g45p1svt m=1 l=45n w=215n
Mmp3 CKbb CKb VDD NW g45p1svt m=1 l=45n w=215n
Mmp5 n5 CKbb Eb NW g45p1svt m=1 l=45n w=215n
Mmp21 ECKb CKbb VDD NW g45p1svt m=1 l=45n w=390n
Mmp20 ECKb Eint VDD NW g45p1svt m=1 l=45n w=390n
.ENDS

.SUBCKT TLATNTSCAX4 CK E ECK NW SE VDD VSS
*.PININFO CK:I E:I NW:I SE:I VDD:I VSS:I ECK:O
Mmn1 Eb E VSS VSS g45n1svt m=1 l=45n w=145n
Mmn0 Eb SE VSS VSS g45n1svt m=1 l=45n w=145n
Mmn22 ECK ECKb VSS VSS g45n1svt m=1 l=45n w=1.04u
Mmn21 ECKb CKbb net271 VSS g45n1svt m=1 l=45n w=260n
Mmn20 net271 Eint VSS VSS g45n1svt m=1 l=45n w=260n
Mmn16 n5 CKbb net263 VSS g45n1svt m=1 l=45n w=145n
Mmn15 net263 Eint VSS VSS g45n1svt m=1 l=45n w=145n
Mmn2 CKb CK VSS VSS g45n1svt m=1 l=45n w=145n
Mmn10 Eint n5 VSS VSS g45n1svt m=1 l=45n w=145n
Mmn5 Eb CKb n5 VSS g45n1svt m=1 l=45n w=145n
Mmn3 CKbb CKb VSS VSS g45n1svt m=1 l=45n w=145n
Mmp1 Eb E net246 NW g45p1svt m=1 l=45n w=215n
Mmp0 net246 SE VDD NW g45p1svt m=1 l=45n w=215n
Mmp22 ECK ECKb VDD NW g45p1svt m=1 l=45n w=1.56u
Mmp16 n5 CKb net234 NW g45p1svt m=1 l=45n w=215n
Mmp15 net234 Eint VDD NW g45p1svt m=1 l=45n w=215n
Mmp2 CKb CK VDD NW g45p1svt m=1 l=45n w=215n
Mmp10 Eint n5 VDD NW g45p1svt m=1 l=45n w=215n
Mmp3 CKbb CKb VDD NW g45p1svt m=1 l=45n w=215n
Mmp5 n5 CKbb Eb NW g45p1svt m=1 l=45n w=215n
Mmp21 ECKb CKbb VDD NW g45p1svt m=1 l=45n w=390n
Mmp20 ECKb Eint VDD NW g45p1svt m=1 l=45n w=390n
.ENDS

.SUBCKT TLATNTSCAX6 CK E ECK NW SE VDD VSS
*.PININFO CK:I E:I NW:I SE:I VDD:I VSS:I ECK:O
Mmn1 Eb E VSS VSS g45n1svt m=1 l=45n w=145n
Mmn0 Eb SE VSS VSS g45n1svt m=1 l=45n w=145n
Mmn22 ECK ECKb VSS VSS g45n1svt m=1 l=45n w=1.55u
Mmn21 ECKb CKbb net271 VSS g45n1svt m=1 l=45n w=520n
Mmn20 net271 Eint VSS VSS g45n1svt m=1 l=45n w=520n
Mmn16 n5 CKbb net263 VSS g45n1svt m=1 l=45n w=145n
Mmn15 net263 Eint VSS VSS g45n1svt m=1 l=45n w=145n
Mmn2 CKb CK VSS VSS g45n1svt m=1 l=45n w=145n
Mmn10 Eint n5 VSS VSS g45n1svt m=1 l=45n w=205n
Mmn5 Eb CKb n5 VSS g45n1svt m=1 l=45n w=145n
Mmn3 CKbb CKb VSS VSS g45n1svt m=1 l=45n w=145n
Mmp1 Eb E net246 NW g45p1svt m=1 l=45n w=215n
Mmp0 net246 SE VDD NW g45p1svt m=1 l=45n w=215n
Mmp22 ECK ECKb VDD NW g45p1svt m=1 l=45n w=2.35u
Mmp16 n5 CKb net234 NW g45p1svt m=1 l=45n w=215n
Mmp15 net234 Eint VDD NW g45p1svt m=1 l=45n w=215n
Mmp2 CKb CK VDD NW g45p1svt m=1 l=45n w=215n
Mmp10 Eint n5 VDD NW g45p1svt m=1 l=45n w=310n
Mmp3 CKbb CKb VDD NW g45p1svt m=1 l=45n w=215n
Mmp5 n5 CKbb Eb NW g45p1svt m=1 l=45n w=215n
Mmp21 ECKb CKbb VDD NW g45p1svt m=1 l=45n w=780n
Mmp20 ECKb Eint VDD NW g45p1svt m=1 l=45n w=780n
.ENDS

.SUBCKT TLATNTSCAX8 CK E ECK NW SE VDD VSS
*.PININFO CK:I E:I NW:I SE:I VDD:I VSS:I ECK:O
Mmn1 Eb E VSS VSS g45n1svt m=1 l=45n w=145n
Mmn0 Eb SE VSS VSS g45n1svt m=1 l=45n w=145n
Mmn22 ECK ECKb VSS VSS g45n1svt m=1 l=45n w=2.065u
Mmn21 ECKb CKbb net271 VSS g45n1svt m=1 l=45n w=520n
Mmn20 net271 Eint VSS VSS g45n1svt m=1 l=45n w=520n
Mmn16 n5 CKbb net263 VSS g45n1svt m=1 l=45n w=145n
Mmn15 net263 Eint VSS VSS g45n1svt m=1 l=45n w=145n
Mmn2 CKb CK VSS VSS g45n1svt m=1 l=45n w=145n
Mmn10 Eint n5 VSS VSS g45n1svt m=1 l=45n w=205n
Mmn5 Eb CKb n5 VSS g45n1svt m=1 l=45n w=145n
Mmn3 CKbb CKb VSS VSS g45n1svt m=1 l=45n w=145n
Mmp1 Eb E net246 NW g45p1svt m=1 l=45n w=215n
Mmp0 net246 SE VDD NW g45p1svt m=1 l=45n w=215n
Mmp22 ECK ECKb VDD NW g45p1svt m=1 l=45n w=3.115u
Mmp16 n5 CKb net234 NW g45p1svt m=1 l=45n w=215n
Mmp15 net234 Eint VDD NW g45p1svt m=1 l=45n w=215n
Mmp2 CKb CK VDD NW g45p1svt m=1 l=45n w=215n
Mmp10 Eint n5 VDD NW g45p1svt m=1 l=45n w=310n
Mmp3 CKbb CKb VDD NW g45p1svt m=1 l=45n w=215n
Mmp5 n5 CKbb Eb NW g45p1svt m=1 l=45n w=215n
Mmp21 ECKb CKbb VDD NW g45p1svt m=1 l=45n w=780n
Mmp20 ECKb Eint VDD NW g45p1svt m=1 l=45n w=780n
.ENDS

.SUBCKT TLATNX1 D GN NW Q QN VDD VSS
*.PININFO D:I GN:I NW:I VDD:I VSS:I Q:O QN:O
Mmn5 net257 D VSS VSS g45n1svt m=1 l=45n w=145n
Mmn6 n0 GNb net257 VSS g45n1svt m=1 l=45n w=145n
Mmn16 n0 GNbb net245 VSS g45n1svt m=1 l=45n w=145n
Mmn15 net245 Qint VSS VSS g45n1svt m=1 l=45n w=145n
Mmn22 QN Qint VSS VSS g45n1svt m=1 l=45n w=260n
Mmn21 Q Qbint VSS VSS g45n1svt m=1 l=45n w=260n
Mmn0 GNb GN VSS VSS g45n1svt m=1 l=45n w=145n
Mmn1 GNbb GNb VSS VSS g45n1svt m=1 l=45n w=145n
Mmn10 Qint n0 VSS VSS g45n1svt m=1 l=45n w=145n
Mmn20 Qbint Qint VSS VSS g45n1svt m=1 l=45n w=260n
Mmp6 n0 GNbb net220 NW g45p1svt m=1 l=45n w=215n
Mmp5 net220 D VDD NW g45p1svt m=1 l=45n w=215n
Mmp16 n0 GNb net212 NW g45p1svt m=1 l=45n w=215n
Mmp15 net212 Qint VDD NW g45p1svt m=1 l=45n w=215n
Mmp22 QN Qint VDD NW g45p1svt m=1 l=45n w=390n
Mmp21 Q Qbint VDD NW g45p1svt m=1 l=45n w=390n
Mmp0 GNb GN VDD NW g45p1svt m=1 l=45n w=215n
Mmp1 GNbb GNb VDD NW g45p1svt m=1 l=45n w=215n
Mmp10 Qint n0 VDD NW g45p1svt m=1 l=45n w=215n
Mmp20 Qbint Qint VDD NW g45p1svt m=1 l=45n w=390n
.ENDS

.SUBCKT TLATNX2 D GN NW Q QN VDD VSS
*.PININFO D:I GN:I NW:I VDD:I VSS:I Q:O QN:O
Mmn5 net257 D VSS VSS g45n1svt m=1 l=45n w=145n
Mmn6 n0 GNb net257 VSS g45n1svt m=1 l=45n w=145n
Mmn16 n0 GNbb net245 VSS g45n1svt m=1 l=45n w=145n
Mmn15 net245 Qint VSS VSS g45n1svt m=1 l=45n w=145n
Mmn22 QN Qint VSS VSS g45n1svt m=1 l=45n w=520n
Mmn21 Q Qbint VSS VSS g45n1svt m=1 l=45n w=520n
Mmn0 GNb GN VSS VSS g45n1svt m=1 l=45n w=145n
Mmn1 GNbb GNb VSS VSS g45n1svt m=1 l=45n w=145n
Mmn10 Qint n0 VSS VSS g45n1svt m=1 l=45n w=205n
Mmn20 Qbint Qint VSS VSS g45n1svt m=1 l=45n w=520n
Mmp6 n0 GNbb net220 NW g45p1svt m=1 l=45n w=215n
Mmp5 net220 D VDD NW g45p1svt m=1 l=45n w=215n
Mmp16 n0 GNb net212 NW g45p1svt m=1 l=45n w=215n
Mmp15 net212 Qint VDD NW g45p1svt m=1 l=45n w=215n
Mmp22 QN Qint VDD NW g45p1svt m=1 l=45n w=780n
Mmp21 Q Qbint VDD NW g45p1svt m=1 l=45n w=780n
Mmp0 GNb GN VDD NW g45p1svt m=1 l=45n w=215n
Mmp1 GNbb GNb VDD NW g45p1svt m=1 l=45n w=215n
Mmp10 Qint n0 VDD NW g45p1svt m=1 l=45n w=310n
Mmp20 Qbint Qint VDD NW g45p1svt m=1 l=45n w=780n
.ENDS

.SUBCKT TLATNX4 D GN NW Q QN VDD VSS
*.PININFO D:I GN:I NW:I VDD:I VSS:I Q:O QN:O
Mmn5 net257 D VSS VSS g45n1svt m=1 l=45n w=145n
Mmn6 n0 GNb net257 VSS g45n1svt m=1 l=45n w=145n
Mmn16 n0 GNbb net245 VSS g45n1svt m=1 l=45n w=145n
Mmn15 net245 Qint VSS VSS g45n1svt m=1 l=45n w=145n
Mmn22 QN Qint VSS VSS g45n1svt m=1 l=45n w=1.04u
Mmn21 Q Qbint VSS VSS g45n1svt m=1 l=45n w=1.04u
Mmn0 GNb GN VSS VSS g45n1svt m=1 l=45n w=145n
Mmn1 GNbb GNb VSS VSS g45n1svt m=1 l=45n w=145n
Mmn10 Qint n0 VSS VSS g45n1svt m=1 l=45n w=410n
Mmn20 Qbint Qint VSS VSS g45n1svt m=1 l=45n w=1.04u
Mmp6 n0 GNbb net220 NW g45p1svt m=1 l=45n w=215n
Mmp5 net220 D VDD NW g45p1svt m=1 l=45n w=215n
Mmp16 n0 GNb net212 NW g45p1svt m=1 l=45n w=215n
Mmp15 net212 Qint VDD NW g45p1svt m=1 l=45n w=215n
Mmp22 QN Qint VDD NW g45p1svt m=1 l=45n w=1.56u
Mmp21 Q Qbint VDD NW g45p1svt m=1 l=45n w=1.56u
Mmp0 GNb GN VDD NW g45p1svt m=1 l=45n w=215n
Mmp1 GNbb GNb VDD NW g45p1svt m=1 l=45n w=215n
Mmp10 Qint n0 VDD NW g45p1svt m=1 l=45n w=620n
Mmp20 Qbint Qint VDD NW g45p1svt m=1 l=45n w=1.56u
.ENDS

.SUBCKT TLATNXL D GN NW Q QN VDD VSS
*.PININFO D:I GN:I NW:I VDD:I VSS:I Q:O QN:O
Mmn5 net257 D VSS VSS g45n1svt m=1 l=45n w=145n
Mmn6 n0 GNb net257 VSS g45n1svt m=1 l=45n w=145n
Mmn16 n0 GNbb net245 VSS g45n1svt m=1 l=45n w=145n
Mmn15 net245 Qint VSS VSS g45n1svt m=1 l=45n w=145n
Mmn22 QN Qint VSS VSS g45n1svt m=1 l=45n w=145n
Mmn21 Q Qbint VSS VSS g45n1svt m=1 l=45n w=145n
Mmn0 GNb GN VSS VSS g45n1svt m=1 l=45n w=145n
Mmn1 GNbb GNb VSS VSS g45n1svt m=1 l=45n w=145n
Mmn10 Qint n0 VSS VSS g45n1svt m=1 l=45n w=145n
Mmn20 Qbint Qint VSS VSS g45n1svt m=1 l=45n w=145n
Mmp6 n0 GNbb net220 NW g45p1svt m=1 l=45n w=215n
Mmp5 net220 D VDD NW g45p1svt m=1 l=45n w=215n
Mmp16 n0 GNb net212 NW g45p1svt m=1 l=45n w=215n
Mmp15 net212 Qint VDD NW g45p1svt m=1 l=45n w=215n
Mmp22 QN Qint VDD NW g45p1svt m=1 l=45n w=215n
Mmp21 Q Qbint VDD NW g45p1svt m=1 l=45n w=215n
Mmp0 GNb GN VDD NW g45p1svt m=1 l=45n w=215n
Mmp1 GNbb GNb VDD NW g45p1svt m=1 l=45n w=215n
Mmp10 Qint n0 VDD NW g45p1svt m=1 l=45n w=215n
Mmp20 Qbint Qint VDD NW g45p1svt m=1 l=45n w=215n
.ENDS

.SUBCKT TLATSRX1 D G NW Q QN RN SN VDD VSS
*.PININFO D:I G:I NW:I RN:I SN:I VDD:I VSS:I Q:O QN:O
Mmn5 net191 D VSS VSS g45n1svt m=1 l=45n w=145n
Mmn6 n5 Gbb net191 VSS g45n1svt m=1 l=45n w=145n
Mmn10 net183 SN VSS VSS g45n1svt m=1 l=45n w=145n
Mmn11 Qint n5 net183 VSS g45n1svt m=1 l=45n w=145n
Mmn17 n5 Gb net171 VSS g45n1svt m=1 l=45n w=145n
Mmn16 net171 Qint net167 VSS g45n1svt m=1 l=45n w=145n
Mmn15 net167 RN VSS VSS g45n1svt m=1 l=45n w=145n
Mmn1 Gb G net159 VSS g45n1svt m=1 l=45n w=145n
Mmn0 net159 RN VSS VSS g45n1svt m=1 l=45n w=145n
Mmn22 QN Qint VSS VSS g45n1svt m=1 l=45n w=260n
Mmn21 Q Qbint VSS VSS g45n1svt m=1 l=45n w=260n
Mmn2 Gbb Gb VSS VSS g45n1svt m=1 l=45n w=145n
Mmn20 Qbint Qint VSS VSS g45n1svt m=1 l=45n w=260n
Mmp6 n5 Gb net142 NW g45p1svt m=1 l=45n w=215n
Mmp5 net142 D VDD NW g45p1svt m=1 l=45n w=215n
Mmp10 Qint SN VDD NW g45p1svt m=1 l=45n w=215n
Mmp1 Gb G VDD NW g45p1svt m=1 l=45n w=215n
Mmp22 QN Qint VDD NW g45p1svt m=1 l=45n w=390n
Mmp21 Q Qbint VDD NW g45p1svt m=1 l=45n w=390n
Mmp2 Gbb Gb VDD NW g45p1svt m=1 l=45n w=215n
Mmp17 n5 Gbb net103 NW g45p1svt m=1 l=45n w=215n
Mmp16 net103 Qint VDD NW g45p1svt m=1 l=45n w=215n
Mmp15 net103 RN VDD NW g45p1svt m=1 l=45n w=215n
Mmp0 Gb RN VDD NW g45p1svt m=1 l=45n w=215n
Mmp20 Qbint Qint VDD NW g45p1svt m=1 l=45n w=390n
Mmp11 Qint n5 VDD NW g45p1svt m=1 l=45n w=215n
.ENDS

.SUBCKT TLATSRX2 D G NW Q QN RN SN VDD VSS
*.PININFO D:I G:I NW:I RN:I SN:I VDD:I VSS:I Q:O QN:O
Mmn5 net191 D VSS VSS g45n1svt m=1 l=45n w=145n
Mmn6 n5 Gbb net191 VSS g45n1svt m=1 l=45n w=145n
Mmn10 net183 SN VSS VSS g45n1svt m=1 l=45n w=205n
Mmn11 Qint n5 net183 VSS g45n1svt m=1 l=45n w=205n
Mmn17 n5 Gb net171 VSS g45n1svt m=1 l=45n w=145n
Mmn16 net171 Qint net167 VSS g45n1svt m=1 l=45n w=145n
Mmn15 net167 RN VSS VSS g45n1svt m=1 l=45n w=145n
Mmn1 Gb G net159 VSS g45n1svt m=1 l=45n w=145n
Mmn0 net159 RN VSS VSS g45n1svt m=1 l=45n w=145n
Mmn22 QN Qint VSS VSS g45n1svt m=1 l=45n w=520n
Mmn21 Q Qbint VSS VSS g45n1svt m=1 l=45n w=520n
Mmn2 Gbb Gb VSS VSS g45n1svt m=1 l=45n w=145n
Mmn20 Qbint Qint VSS VSS g45n1svt m=1 l=45n w=520n
Mmp6 n5 Gb net142 NW g45p1svt m=1 l=45n w=215n
Mmp5 net142 D VDD NW g45p1svt m=1 l=45n w=215n
Mmp10 Qint SN VDD NW g45p1svt m=1 l=45n w=310n
Mmp1 Gb G VDD NW g45p1svt m=1 l=45n w=215n
Mmp22 QN Qint VDD NW g45p1svt m=1 l=45n w=780n
Mmp21 Q Qbint VDD NW g45p1svt m=1 l=45n w=780n
Mmp2 Gbb Gb VDD NW g45p1svt m=1 l=45n w=215n
Mmp17 n5 Gbb net103 NW g45p1svt m=1 l=45n w=215n
Mmp16 net103 Qint VDD NW g45p1svt m=1 l=45n w=215n
Mmp15 net103 RN VDD NW g45p1svt m=1 l=45n w=215n
Mmp0 Gb RN VDD NW g45p1svt m=1 l=45n w=215n
Mmp20 Qbint Qint VDD NW g45p1svt m=1 l=45n w=780n
Mmp11 Qint n5 VDD NW g45p1svt m=1 l=45n w=310n
.ENDS

.SUBCKT TLATSRX4 D G NW Q QN RN SN VDD VSS
*.PININFO D:I G:I NW:I RN:I SN:I VDD:I VSS:I Q:O QN:O
Mmn5 net191 D VSS VSS g45n1svt m=1 l=45n w=145n
Mmn6 n5 Gbb net191 VSS g45n1svt m=1 l=45n w=145n
Mmn10 net183 SN VSS VSS g45n1svt m=1 l=45n w=410n
Mmn11 Qint n5 net183 VSS g45n1svt m=1 l=45n w=410n
Mmn17 n5 Gb net171 VSS g45n1svt m=1 l=45n w=145n
Mmn16 net171 Qint net167 VSS g45n1svt m=1 l=45n w=145n
Mmn15 net167 RN VSS VSS g45n1svt m=1 l=45n w=145n
Mmn1 Gb G net159 VSS g45n1svt m=1 l=45n w=145n
Mmn0 net159 RN VSS VSS g45n1svt m=1 l=45n w=145n
Mmn22 QN Qint VSS VSS g45n1svt m=1 l=45n w=1.04u
Mmn21 Q Qbint VSS VSS g45n1svt m=1 l=45n w=1.04u
Mmn2 Gbb Gb VSS VSS g45n1svt m=1 l=45n w=145n
Mmn20 Qbint Qint VSS VSS g45n1svt m=1 l=45n w=1.04u
Mmp6 n5 Gb net142 NW g45p1svt m=1 l=45n w=215n
Mmp5 net142 D VDD NW g45p1svt m=1 l=45n w=215n
Mmp10 Qint SN VDD NW g45p1svt m=1 l=45n w=620n
Mmp1 Gb G VDD NW g45p1svt m=1 l=45n w=215n
Mmp22 QN Qint VDD NW g45p1svt m=1 l=45n w=1.56u
Mmp21 Q Qbint VDD NW g45p1svt m=1 l=45n w=1.56u
Mmp2 Gbb Gb VDD NW g45p1svt m=1 l=45n w=215n
Mmp17 n5 Gbb net103 NW g45p1svt m=1 l=45n w=215n
Mmp16 net103 Qint VDD NW g45p1svt m=1 l=45n w=215n
Mmp15 net103 RN VDD NW g45p1svt m=1 l=45n w=215n
Mmp0 Gb RN VDD NW g45p1svt m=1 l=45n w=215n
Mmp20 Qbint Qint VDD NW g45p1svt m=1 l=45n w=1.56u
Mmp11 Qint n5 VDD NW g45p1svt m=1 l=45n w=620n
.ENDS

.SUBCKT TLATSRXL D G NW Q QN RN SN VDD VSS
*.PININFO D:I G:I NW:I RN:I SN:I VDD:I VSS:I Q:O QN:O
Mmn5 net191 D VSS VSS g45n1svt m=1 l=45n w=145n
Mmn6 n5 Gbb net191 VSS g45n1svt m=1 l=45n w=145n
Mmn10 net183 SN VSS VSS g45n1svt m=1 l=45n w=145n
Mmn11 Qint n5 net183 VSS g45n1svt m=1 l=45n w=145n
Mmn17 n5 Gb net171 VSS g45n1svt m=1 l=45n w=145n
Mmn16 net171 Qint net167 VSS g45n1svt m=1 l=45n w=145n
Mmn15 net167 RN VSS VSS g45n1svt m=1 l=45n w=145n
Mmn1 Gb G net159 VSS g45n1svt m=1 l=45n w=145n
Mmn0 net159 RN VSS VSS g45n1svt m=1 l=45n w=145n
Mmn22 QN Qint VSS VSS g45n1svt m=1 l=45n w=145n
Mmn21 Q Qbint VSS VSS g45n1svt m=1 l=45n w=145n
Mmn2 Gbb Gb VSS VSS g45n1svt m=1 l=45n w=145n
Mmn20 Qbint Qint VSS VSS g45n1svt m=1 l=45n w=145n
Mmp6 n5 Gb net142 NW g45p1svt m=1 l=45n w=215n
Mmp5 net142 D VDD NW g45p1svt m=1 l=45n w=215n
Mmp10 Qint SN VDD NW g45p1svt m=1 l=45n w=215n
Mmp1 Gb G VDD NW g45p1svt m=1 l=45n w=215n
Mmp22 QN Qint VDD NW g45p1svt m=1 l=45n w=215n
Mmp21 Q Qbint VDD NW g45p1svt m=1 l=45n w=215n
Mmp2 Gbb Gb VDD NW g45p1svt m=1 l=45n w=215n
Mmp17 n5 Gbb net103 NW g45p1svt m=1 l=45n w=215n
Mmp16 net103 Qint VDD NW g45p1svt m=1 l=45n w=215n
Mmp15 net103 RN VDD NW g45p1svt m=1 l=45n w=215n
Mmp0 Gb RN VDD NW g45p1svt m=1 l=45n w=215n
Mmp20 Qbint Qint VDD NW g45p1svt m=1 l=45n w=215n
Mmp11 Qint n5 VDD NW g45p1svt m=1 l=45n w=215n
.ENDS

.SUBCKT TLATX1 D G NW Q QN VDD VSS
*.PININFO D:I G:I NW:I VDD:I VSS:I Q:O QN:O
Mmn5 net257 D VSS VSS g45n1svt m=1 l=45n w=145n
Mmn6 n0 Gbb net257 VSS g45n1svt m=1 l=45n w=145n
Mmn16 n0 Gb net245 VSS g45n1svt m=1 l=45n w=145n
Mmn15 net245 Qint VSS VSS g45n1svt m=1 l=45n w=145n
Mmn22 QN Qint VSS VSS g45n1svt m=1 l=45n w=260n
Mmn21 Q Qbint VSS VSS g45n1svt m=1 l=45n w=260n
Mmn0 Gb G VSS VSS g45n1svt m=1 l=45n w=145n
Mmn10 Qint n0 VSS VSS g45n1svt m=1 l=45n w=145n
Mmn20 Qbint Qint VSS VSS g45n1svt m=1 l=45n w=260n
Mmn1 Gbb Gb VSS VSS g45n1svt m=1 l=45n w=145n
Mmp6 n0 Gb net220 NW g45p1svt m=1 l=45n w=215n
Mmp5 net220 D VDD NW g45p1svt m=1 l=45n w=215n
Mmp16 n0 Gbb net212 NW g45p1svt m=1 l=45n w=215n
Mmp15 net212 Qint VDD NW g45p1svt m=1 l=45n w=215n
Mmp22 QN Qint VDD NW g45p1svt m=1 l=45n w=390n
Mmp21 Q Qbint VDD NW g45p1svt m=1 l=45n w=390n
Mmp0 Gb G VDD NW g45p1svt m=1 l=45n w=215n
Mmp1 Gbb Gb VDD NW g45p1svt m=1 l=45n w=215n
Mmp10 Qint n0 VDD NW g45p1svt m=1 l=45n w=215n
Mmp20 Qbint Qint VDD NW g45p1svt m=1 l=45n w=390n
.ENDS

.SUBCKT TLATX2 D G NW Q QN VDD VSS
*.PININFO D:I G:I NW:I VDD:I VSS:I Q:O QN:O
Mmn5 net257 D VSS VSS g45n1svt m=1 l=45n w=145n
Mmn6 n0 Gbb net257 VSS g45n1svt m=1 l=45n w=145n
Mmn16 n0 Gb net245 VSS g45n1svt m=1 l=45n w=145n
Mmn15 net245 Qint VSS VSS g45n1svt m=1 l=45n w=145n
Mmn22 QN Qint VSS VSS g45n1svt m=1 l=45n w=520n
Mmn21 Q Qbint VSS VSS g45n1svt m=1 l=45n w=520n
Mmn0 Gb G VSS VSS g45n1svt m=1 l=45n w=145n
Mmn10 Qint n0 VSS VSS g45n1svt m=1 l=45n w=205n
Mmn20 Qbint Qint VSS VSS g45n1svt m=1 l=45n w=520n
Mmn1 Gbb Gb VSS VSS g45n1svt m=1 l=45n w=145n
Mmp6 n0 Gb net220 NW g45p1svt m=1 l=45n w=215n
Mmp5 net220 D VDD NW g45p1svt m=1 l=45n w=215n
Mmp16 n0 Gbb net212 NW g45p1svt m=1 l=45n w=215n
Mmp15 net212 Qint VDD NW g45p1svt m=1 l=45n w=215n
Mmp22 QN Qint VDD NW g45p1svt m=1 l=45n w=780n
Mmp21 Q Qbint VDD NW g45p1svt m=1 l=45n w=780n
Mmp0 Gb G VDD NW g45p1svt m=1 l=45n w=215n
Mmp1 Gbb Gb VDD NW g45p1svt m=1 l=45n w=215n
Mmp10 Qint n0 VDD NW g45p1svt m=1 l=45n w=310n
Mmp20 Qbint Qint VDD NW g45p1svt m=1 l=45n w=780n
.ENDS

.SUBCKT TLATX4 D G NW Q QN VDD VSS
*.PININFO D:I G:I NW:I VDD:I VSS:I Q:O QN:O
Mmn5 net257 D VSS VSS g45n1svt m=1 l=45n w=145n
Mmn6 n0 Gbb net257 VSS g45n1svt m=1 l=45n w=145n
Mmn16 n0 Gb net245 VSS g45n1svt m=1 l=45n w=145n
Mmn15 net245 Qint VSS VSS g45n1svt m=1 l=45n w=145n
Mmn22 QN Qint VSS VSS g45n1svt m=1 l=45n w=1.04u
Mmn21 Q Qbint VSS VSS g45n1svt m=1 l=45n w=1.04u
Mmn0 Gb G VSS VSS g45n1svt m=1 l=45n w=145n
Mmn10 Qint n0 VSS VSS g45n1svt m=1 l=45n w=410n
Mmn20 Qbint Qint VSS VSS g45n1svt m=1 l=45n w=1.04u
Mmn1 Gbb Gb VSS VSS g45n1svt m=1 l=45n w=145n
Mmp6 n0 Gb net220 NW g45p1svt m=1 l=45n w=215n
Mmp5 net220 D VDD NW g45p1svt m=1 l=45n w=215n
Mmp16 n0 Gbb net212 NW g45p1svt m=1 l=45n w=215n
Mmp15 net212 Qint VDD NW g45p1svt m=1 l=45n w=215n
Mmp22 QN Qint VDD NW g45p1svt m=1 l=45n w=1.56u
Mmp21 Q Qbint VDD NW g45p1svt m=1 l=45n w=1.56u
Mmp0 Gb G VDD NW g45p1svt m=1 l=45n w=215n
Mmp1 Gbb Gb VDD NW g45p1svt m=1 l=45n w=215n
Mmp10 Qint n0 VDD NW g45p1svt m=1 l=45n w=620n
Mmp20 Qbint Qint VDD NW g45p1svt m=1 l=45n w=1.56u
.ENDS

.SUBCKT TLATXL D G NW Q QN VDD VSS
*.PININFO D:I G:I NW:I VDD:I VSS:I Q:O QN:O
Mmn5 net257 D VSS VSS g45n1svt m=1 l=45n w=145n
Mmn6 n0 Gbb net257 VSS g45n1svt m=1 l=45n w=145n
Mmn16 n0 Gb net245 VSS g45n1svt m=1 l=45n w=145n
Mmn15 net245 Qint VSS VSS g45n1svt m=1 l=45n w=145n
Mmn22 QN Qint VSS VSS g45n1svt m=1 l=45n w=145n
Mmn21 Q Qbint VSS VSS g45n1svt m=1 l=45n w=145n
Mmn0 Gb G VSS VSS g45n1svt m=1 l=45n w=145n
Mmn10 Qint n0 VSS VSS g45n1svt m=1 l=45n w=145n
Mmn20 Qbint Qint VSS VSS g45n1svt m=1 l=45n w=145n
Mmn1 Gbb Gb VSS VSS g45n1svt m=1 l=45n w=145n
Mmp6 n0 Gb net220 NW g45p1svt m=1 l=45n w=215n
Mmp5 net220 D VDD NW g45p1svt m=1 l=45n w=215n
Mmp16 n0 Gbb net212 NW g45p1svt m=1 l=45n w=215n
Mmp15 net212 Qint VDD NW g45p1svt m=1 l=45n w=215n
Mmp22 QN Qint VDD NW g45p1svt m=1 l=45n w=215n
Mmp21 Q Qbint VDD NW g45p1svt m=1 l=45n w=215n
Mmp0 Gb G VDD NW g45p1svt m=1 l=45n w=215n
Mmp1 Gbb Gb VDD NW g45p1svt m=1 l=45n w=215n
Mmp10 Qint n0 VDD NW g45p1svt m=1 l=45n w=215n
Mmp20 Qbint Qint VDD NW g45p1svt m=1 l=45n w=215n
.ENDS

.SUBCKT XNOR2X1 A B NW VDD VSS Y
*.PININFO A:I B:I NW:I VDD:I VSS:I Y:O
Mmn1 n2 B VSS VSS g45n1svt m=1 l=45n w=145n
Mmn2 net145 n1 VSS VSS g45n1svt m=1 l=45n w=145n
Mmn3 n0 n2 net145 VSS g45n1svt m=1 l=45n w=145n
Mmn5 Y n0 VSS VSS g45n1svt m=1 l=45n w=260n
Mmn0 n1 A VSS VSS g45n1svt m=1 l=45n w=145n
Mmn4 n0 B n1 VSS g45n1svt m=1 l=45n w=145n
Mmp0 n1 A VDD NW g45p1svt m=1 l=45n w=215n
Mmp4 n1 n2 n0 NW g45p1svt m=1 l=45n w=215n
Mmp2 net112 n1 VDD NW g45p1svt m=1 l=45n w=215n
Mmp1 n2 B VDD NW g45p1svt m=1 l=45n w=215n
Mmp3 n0 B net112 NW g45p1svt m=1 l=45n w=215n
Mmp5 Y n0 VDD NW g45p1svt m=1 l=45n w=390n
.ENDS

.SUBCKT XNOR2X2 A B NW VDD VSS Y
*.PININFO A:I B:I NW:I VDD:I VSS:I Y:O
Mmn1 n2 B VSS VSS g45n1svt m=1 l=45n w=145n
Mmn2 net145 n1 VSS VSS g45n1svt m=1 l=45n w=145n
Mmn3 n0 n2 net145 VSS g45n1svt m=1 l=45n w=145n
Mmn5 Y n0 VSS VSS g45n1svt m=1 l=45n w=520n
Mmn0 n1 A VSS VSS g45n1svt m=1 l=45n w=145n
Mmn4 n0 B n1 VSS g45n1svt m=1 l=45n w=145n
Mmp0 n1 A VDD NW g45p1svt m=1 l=45n w=215n
Mmp4 n1 n2 n0 NW g45p1svt m=1 l=45n w=215n
Mmp2 net112 n1 VDD NW g45p1svt m=1 l=45n w=215n
Mmp1 n2 B VDD NW g45p1svt m=1 l=45n w=215n
Mmp3 n0 B net112 NW g45p1svt m=1 l=45n w=215n
Mmp5 Y n0 VDD NW g45p1svt m=1 l=45n w=780n
.ENDS

.SUBCKT XNOR2X4 A B NW VDD VSS Y
*.PININFO A:I B:I NW:I VDD:I VSS:I Y:O
Mmn1 n2 B VSS VSS g45n1svt m=1 l=45n w=145n
Mmn2 net145 n1 VSS VSS g45n1svt m=1 l=45n w=260n
Mmn3 n0 n2 net145 VSS g45n1svt m=1 l=45n w=260n
Mmn5 Y n0 VSS VSS g45n1svt m=1 l=45n w=1.04u
Mmn0 n1 A VSS VSS g45n1svt m=1 l=45n w=145n
Mmn4 n0 B n1 VSS g45n1svt m=1 l=45n w=260n
Mmp0 n1 A VDD NW g45p1svt m=1 l=45n w=215n
Mmp4 n1 n2 n0 NW g45p1svt m=1 l=45n w=390n
Mmp2 net112 n1 VDD NW g45p1svt m=1 l=45n w=390n
Mmp1 n2 B VDD NW g45p1svt m=1 l=45n w=215n
Mmp3 n0 B net112 NW g45p1svt m=1 l=45n w=390n
Mmp5 Y n0 VDD NW g45p1svt m=1 l=45n w=1.56u
.ENDS

.SUBCKT XNOR2XL A B NW VDD VSS Y
*.PININFO A:I B:I NW:I VDD:I VSS:I Y:O
Mmn1 n2 B VSS VSS g45n1svt m=1 l=45n w=145n
Mmn2 net145 n1 VSS VSS g45n1svt m=1 l=45n w=145n
Mmn3 n0 n2 net145 VSS g45n1svt m=1 l=45n w=145n
Mmn5 Y n0 VSS VSS g45n1svt m=1 l=45n w=145n
Mmn0 n1 A VSS VSS g45n1svt m=1 l=45n w=145n
Mmn4 n0 B n1 VSS g45n1svt m=1 l=45n w=145n
Mmp0 n1 A VDD NW g45p1svt m=1 l=45n w=215n
Mmp4 n1 n2 n0 NW g45p1svt m=1 l=45n w=215n
Mmp2 net112 n1 VDD NW g45p1svt m=1 l=45n w=215n
Mmp1 n2 B VDD NW g45p1svt m=1 l=45n w=215n
Mmp3 n0 B net112 NW g45p1svt m=1 l=45n w=215n
Mmp5 Y n0 VDD NW g45p1svt m=1 l=45n w=215n
.ENDS

.SUBCKT XNOR3X1 A B C NW VDD VSS Y
*.PININFO A:I B:I C:I NW:I VDD:I VSS:I Y:O
Mmn8 Y n11 VSS VSS g45n1svt m=1 l=45n w=205n
Mmn10 n12 n61 n8 VSS g45n1svt m=1 l=45n w=205n
Mmn2 n9 n61 n62 VSS g45n1svt m=1 l=45n w=205n
Mmn1 n9 B n8 VSS g45n1svt m=1 l=45n w=190n
Mmn9 n8 n62 VSS VSS g45n1svt m=1 l=45n w=190n
Mmn11 n12 B n62 VSS g45n1svt m=1 l=45n w=205n
Mmn6 n11 C n9 VSS g45n1svt m=1 l=45n w=190n
Mmn5 n11 n60 n12 VSS g45n1svt m=1 l=45n w=190n
Mmn7 n60 C VSS VSS g45n1svt m=1 l=45n w=190n
Mmn4 n61 B VSS VSS g45n1svt m=1 l=45n w=190n
Mmn3 n62 A VSS VSS g45n1svt m=1 l=45n w=205n
Mmp8 Y n11 VDD NW g45p1svt m=1 l=45n w=390n
Mmp3 n62 A VDD NW g45p1svt m=1 l=45n w=390n
Mmp6 n9 n60 n11 NW g45p1svt m=1 l=45n w=310n
Mmp11 n62 n61 n12 NW g45p1svt m=1 l=45n w=390n
Mmp2 n62 B n9 NW g45p1svt m=1 l=45n w=390n
Mmp5 n12 C n11 NW g45p1svt m=1 l=45n w=310n
Mmp1 n8 n61 n9 NW g45p1svt m=1 l=45n w=310n
Mmp10 n8 B n12 NW g45p1svt m=1 l=45n w=310n
Mmp4 n61 B VDD NW g45p1svt m=1 l=45n w=310n
Mmp9 n8 n62 VDD NW g45p1svt m=1 l=45n w=310n
Mmp7 n60 C VDD NW g45p1svt m=1 l=45n w=310n
.ENDS

.SUBCKT XNOR3XL A B C NW VDD VSS Y
*.PININFO A:I B:I C:I NW:I VDD:I VSS:I Y:O
Mmn8 Y n11 VSS VSS g45n1svt m=1 l=45n w=205n
Mmn10 n12 n61 n8 VSS g45n1svt m=1 l=45n w=205n
Mmn2 n9 n61 n62 VSS g45n1svt m=1 l=45n w=190n
Mmn1 n9 B n8 VSS g45n1svt m=1 l=45n w=190n
Mmn9 n8 n62 VSS VSS g45n1svt m=1 l=45n w=190n
Mmn11 n12 B n62 VSS g45n1svt m=1 l=45n w=190n
Mmn6 n11 C n9 VSS g45n1svt m=1 l=45n w=190n
Mmn5 n11 n60 n12 VSS g45n1svt m=1 l=45n w=190n
Mmn7 n60 C VSS VSS g45n1svt m=1 l=45n w=190n
Mmn4 n61 B VSS VSS g45n1svt m=1 l=45n w=190n
Mmn3 n62 A VSS VSS g45n1svt m=1 l=45n w=205n
Mmp8 Y n11 VDD NW g45p1svt m=1 l=45n w=205n
Mmp3 n62 A VDD NW g45p1svt m=1 l=45n w=310n
Mmp6 n9 n60 n11 NW g45p1svt m=1 l=45n w=310n
Mmp11 n62 n61 n12 NW g45p1svt m=1 l=45n w=310n
Mmp2 n62 B n9 NW g45p1svt m=1 l=45n w=310n
Mmp5 n12 C n11 NW g45p1svt m=1 l=45n w=310n
Mmp1 n8 n61 n9 NW g45p1svt m=1 l=45n w=310n
Mmp10 n8 B n12 NW g45p1svt m=1 l=45n w=310n
Mmp4 n61 B VDD NW g45p1svt m=1 l=45n w=310n
Mmp9 n8 n62 VDD NW g45p1svt m=1 l=45n w=310n
Mmp7 n60 C VDD NW g45p1svt m=1 l=45n w=310n
.ENDS

.SUBCKT XOR2X1 A B NW VDD VSS Y
*.PININFO A:I B:I NW:I VDD:I VSS:I Y:O
Mmn1 n2 B VSS VSS g45n1svt m=1 l=45n w=145n
Mmn0 n1 A VSS VSS g45n1svt m=1 l=45n w=145n
Mmn5 Y n0 VSS VSS g45n1svt m=1 l=45n w=260n
Mmn3 n0 B net131 VSS g45n1svt m=1 l=45n w=145n
Mmn4 n0 n2 n1 VSS g45n1svt m=1 l=45n w=145n
Mmn2 net131 n1 VSS VSS g45n1svt m=1 l=45n w=145n
Mmp3 n0 n2 net130 NW g45p1svt m=1 l=45n w=215n
Mmp1 n2 B VDD NW g45p1svt m=1 l=45n w=215n
Mmp4 n1 B n0 NW g45p1svt m=1 l=45n w=215n
Mmp0 n1 A VDD NW g45p1svt m=1 l=45n w=215n
Mmp5 Y n0 VDD NW g45p1svt m=1 l=45n w=390n
Mmp2 net130 n1 VDD NW g45p1svt m=1 l=45n w=215n
.ENDS

.SUBCKT XOR2X2 A B NW VDD VSS Y
*.PININFO A:I B:I NW:I VDD:I VSS:I Y:O
Mmn1 n2 B VSS VSS g45n1svt m=1 l=45n w=145n
Mmn0 n1 A VSS VSS g45n1svt m=1 l=45n w=145n
Mmn5 Y n0 VSS VSS g45n1svt m=1 l=45n w=520n
Mmn3 n0 B net131 VSS g45n1svt m=1 l=45n w=145n
Mmn4 n0 n2 n1 VSS g45n1svt m=1 l=45n w=145n
Mmn2 net131 n1 VSS VSS g45n1svt m=1 l=45n w=145n
Mmp3 n0 n2 net130 NW g45p1svt m=1 l=45n w=215n
Mmp1 n2 B VDD NW g45p1svt m=1 l=45n w=215n
Mmp4 n1 B n0 NW g45p1svt m=1 l=45n w=215n
Mmp0 n1 A VDD NW g45p1svt m=1 l=45n w=215n
Mmp5 Y n0 VDD NW g45p1svt m=1 l=45n w=780n
Mmp2 net130 n1 VDD NW g45p1svt m=1 l=45n w=215n
.ENDS

.SUBCKT XOR2X4 A B NW VDD VSS Y
*.PININFO A:I B:I NW:I VDD:I VSS:I Y:O
Mmn1 n2 B VSS VSS g45n1svt m=1 l=45n w=145n
Mmn0 n1 A VSS VSS g45n1svt m=1 l=45n w=145n
Mmn5 Y n0 VSS VSS g45n1svt m=1 l=45n w=1.04u
Mmn3 n0 B net131 VSS g45n1svt m=1 l=45n w=260n
Mmn4 n0 n2 n1 VSS g45n1svt m=1 l=45n w=260n
Mmn2 net131 n1 VSS VSS g45n1svt m=1 l=45n w=260n
Mmp3 n0 n2 net130 NW g45p1svt m=1 l=45n w=390n
Mmp1 n2 B VDD NW g45p1svt m=1 l=45n w=215n
Mmp4 n1 B n0 NW g45p1svt m=1 l=45n w=390n
Mmp0 n1 A VDD NW g45p1svt m=1 l=45n w=215n
Mmp5 Y n0 VDD NW g45p1svt m=1 l=45n w=1.56u
Mmp2 net130 n1 VDD NW g45p1svt m=1 l=45n w=390n
.ENDS

.SUBCKT XOR2XL A B NW VDD VSS Y
*.PININFO A:I B:I NW:I VDD:I VSS:I Y:O
Mmn1 n2 B VSS VSS g45n1svt m=1 l=45n w=145n
Mmn0 n1 A VSS VSS g45n1svt m=1 l=45n w=145n
Mmn5 Y n0 VSS VSS g45n1svt m=1 l=45n w=145n
Mmn3 n0 B net131 VSS g45n1svt m=1 l=45n w=145n
Mmn4 n0 n2 n1 VSS g45n1svt m=1 l=45n w=145n
Mmn2 net131 n1 VSS VSS g45n1svt m=1 l=45n w=145n
Mmp3 n0 n2 net130 NW g45p1svt m=1 l=45n w=215n
Mmp1 n2 B VDD NW g45p1svt m=1 l=45n w=215n
Mmp4 n1 B n0 NW g45p1svt m=1 l=45n w=215n
Mmp0 n1 A VDD NW g45p1svt m=1 l=45n w=215n
Mmp5 Y n0 VDD NW g45p1svt m=1 l=45n w=215n
Mmp2 net130 n1 VDD NW g45p1svt m=1 l=45n w=215n
.ENDS

.SUBCKT XOR3X1 A B C NW VDD VSS Y
*.PININFO A:I B:I C:I NW:I VDD:I VSS:I Y:O
Mmn3 n56 n60 n50 VSS g45n1svt m=1 l=45n w=190n
Mmn10 n62 A VSS VSS g45n1svt m=1 l=45n w=205n
Mmn4 n44 C n50 VSS g45n1svt m=1 l=45n w=190n
Mmn8 n60 C VSS VSS g45n1svt m=1 l=45n w=190n
Mmn9 n61 B VSS VSS g45n1svt m=1 l=45n w=190n
Mmn6 n56 B n11 VSS g45n1svt m=1 l=45n w=190n
Mmn1 n62 B n44 VSS g45n1svt m=1 l=45n w=205n
Mmn2 n11 n61 n44 VSS g45n1svt m=1 l=45n w=190n
Mmn0 n11 n62 VSS VSS g45n1svt m=1 l=45n w=190n
Mmn5 n62 n61 n56 VSS g45n1svt m=1 l=45n w=205n
Mmn7 Y n50 VSS VSS g45n1svt m=1 l=45n w=205n
Mmp10 n62 A VDD NW g45p1svt m=1 l=45n w=390n
Mmp1 n44 n61 n62 NW g45p1svt m=1 l=45n w=390n
Mmp7 Y n50 VDD NW g45p1svt m=1 l=45n w=390n
Mmp2 n44 B n11 NW g45p1svt m=1 l=45n w=310n
Mmp9 n61 B VDD NW g45p1svt m=1 l=45n w=310n
Mmp3 n50 C n56 NW g45p1svt m=1 l=45n w=310n
Mmp8 n60 C VDD NW g45p1svt m=1 l=45n w=310n
Mmp4 n50 n60 n44 NW g45p1svt m=1 l=45n w=310n
Mmp0 n11 n62 VDD NW g45p1svt m=1 l=45n w=310n
Mmp6 n11 n61 n56 NW g45p1svt m=1 l=45n w=310n
Mmp5 n56 B n62 NW g45p1svt m=1 l=45n w=390n
.ENDS

.SUBCKT XOR3XL A B C NW VDD VSS Y
*.PININFO A:I B:I C:I NW:I VDD:I VSS:I Y:O
Mmn3 n56 n60 n50 VSS g45n1svt m=1 l=45n w=190n
Mmn10 n62 A VSS VSS g45n1svt m=1 l=45n w=190n
Mmn4 n44 C n50 VSS g45n1svt m=1 l=45n w=190n
Mmn8 n60 C VSS VSS g45n1svt m=1 l=45n w=190n
Mmn9 n61 B VSS VSS g45n1svt m=1 l=45n w=190n
Mmn6 n56 B n11 VSS g45n1svt m=1 l=45n w=190n
Mmn1 n62 B n44 VSS g45n1svt m=1 l=45n w=190n
Mmn2 n11 n61 n44 VSS g45n1svt m=1 l=45n w=190n
Mmn0 n11 n62 VSS VSS g45n1svt m=1 l=45n w=190n
Mmn5 n62 n61 n56 VSS g45n1svt m=1 l=45n w=190n
Mmn7 Y n50 VSS VSS g45n1svt m=1 l=45n w=190n
Mmp10 n62 A VDD NW g45p1svt m=1 l=45n w=310n
Mmp1 n44 n61 n62 NW g45p1svt m=1 l=45n w=310n
Mmp7 Y n50 VDD NW g45p1svt m=1 l=45n w=205n
Mmp2 n44 B n11 NW g45p1svt m=1 l=45n w=310n
Mmp9 n61 B VDD NW g45p1svt m=1 l=45n w=310n
Mmp3 n50 C n56 NW g45p1svt m=1 l=45n w=310n
Mmp8 n60 C VDD NW g45p1svt m=1 l=45n w=310n
Mmp4 n50 n60 n44 NW g45p1svt m=1 l=45n w=310n
Mmp0 n11 n62 VDD NW g45p1svt m=1 l=45n w=310n
Mmp6 n11 n61 n56 NW g45p1svt m=1 l=45n w=310n
Mmp5 n56 B n62 NW g45p1svt m=1 l=45n w=310n
.ENDS
