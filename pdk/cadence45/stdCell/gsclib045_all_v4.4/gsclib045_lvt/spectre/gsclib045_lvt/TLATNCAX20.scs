// gsclib045_lvt/TLATNCAX20/schematic

simulator lang=spectre

subckt TLATNCAX20 CK E ECK VDD VSS
mp6 (n0 CKbb net217 VDD) g45p1lvt w=(215n) l=45n nf=1 m=(1)
mp5 (net217 E VDD VDD) g45p1lvt w=(215n) l=45n nf=1 m=(1)
mp22 (ECK ECKb VDD VDD) g45p1lvt w=(7.815u) l=45n nf=1 m=(1)
mp16 (n0 CKb net205 VDD) g45p1lvt w=(215n) l=45n nf=1 m=(1)
mp15 (net205 Eint VDD VDD) g45p1lvt w=(215n) l=45n nf=1 m=(1)
mp0 (CKb CK VDD VDD) g45p1lvt w=(215n) l=45n nf=1 m=(1)
mp1 (CKbb CKb VDD VDD) g45p1lvt w=(215n) l=45n nf=1 m=(1)
mp20 (ECKb Eint VDD VDD) g45p1lvt w=(1.95u) l=45n nf=1 m=(1)
mp21 (ECKb CKbb VDD VDD) g45p1lvt w=(1.95u) l=45n nf=1 m=(1)
mp10 (Eint n0 VDD VDD) g45p1lvt w=(780n) l=45n nf=1 m=(1)
mn5 (net254 E VSS VSS) g45n1lvt w=(145n) l=45n nf=1 m=(1)
mn6 (n0 CKb net254 VSS) g45n1lvt w=(145n) l=45n nf=1 m=(1)
mn22 (ECK ECKb VSS VSS) g45n1lvt w=(5.185u) l=45n nf=1 m=(1)
mn21 (ECKb CKbb net238 VSS) g45n1lvt w=(1.3u) l=45n nf=1 m=(1)
mn20 (net238 Eint VSS VSS) g45n1lvt w=(1.3u) l=45n nf=1 m=(1)
mn16 (n0 CKbb net230 VSS) g45n1lvt w=(145n) l=45n nf=1 m=(1)
mn15 (net230 Eint VSS VSS) g45n1lvt w=(145n) l=45n nf=1 m=(1)
mn0 (CKb CK VSS VSS) g45n1lvt w=(145n) l=45n nf=1 m=(1)
mn10 (Eint n0 VSS VSS) g45n1lvt w=(520n) l=45n nf=1 m=(1)
mn1 (CKbb CKb VSS VSS) g45n1lvt w=(145n) l=45n nf=1 m=(1)
ends TLATNCAX20
