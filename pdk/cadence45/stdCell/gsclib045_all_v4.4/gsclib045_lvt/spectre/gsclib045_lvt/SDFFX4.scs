// gsclib045_lvt/SDFFX4/schematic

simulator lang=spectre

subckt SDFFX4 CK D Q QN SE SI VDD VSS
mp14 (Db SEb net392 VDD) g45p1lvt w=(215n) l=45n nf=1 m=(1)
mp13 (net392 SI VDD VDD) g45p1lvt w=(215n) l=45n nf=1 m=(1)
mp12 (Db SE net384 VDD) g45p1lvt w=(215n) l=45n nf=1 m=(1)
mp11 (net384 D VDD VDD) g45p1lvt w=(215n) l=45n nf=1 m=(1)
mp51 (n30 CKbb net376 VDD) g45p1lvt w=(215n) l=45n nf=1 m=(1)
mp50 (net376 qbint VDD VDD) g45p1lvt w=(215n) l=45n nf=1 m=(1)
mp57 (QN net367 VDD VDD) g45p1lvt w=(1.56u) l=45n nf=1 m=(1)
mp55 (Q qbint VDD VDD) g45p1lvt w=(1.56u) l=45n nf=1 m=(1)
mp35 (net356 mout VDD VDD) g45p1lvt w=(215n) l=45n nf=1 m=(1)
mp36 (n20 CKb net356 VDD) g45p1lvt w=(215n) l=45n nf=1 m=(1)
mp20 (CKb CK VDD VDD) g45p1lvt w=(215n) l=45n nf=1 m=(1)
mp45 (qbint n30 VDD VDD) g45p1lvt w=(620n) l=45n nf=1 m=(1)
mp56 (net367 qbint VDD VDD) g45p1lvt w=(390n) l=45n nf=1 m=(1)
mp21 (CKbb CKb VDD VDD) g45p1lvt w=(215n) l=45n nf=1 m=(1)
mp40 (n30 CKb mout VDD) g45p1lvt w=(215n) l=45n nf=1 m=(1)
mp30 (mout n20 VDD VDD) g45p1lvt w=(215n) l=45n nf=1 m=(1)
mp25 (n20 CKbb Db VDD) g45p1lvt w=(215n) l=45n nf=1 m=(1)
mp10 (SEb SE VDD VDD) g45p1lvt w=(215n) l=45n nf=1 m=(1)
mn13 (net461 SI VSS VSS) g45n1lvt w=(145n) l=45n nf=1 m=(1)
mn14 (Db SE net461 VSS) g45n1lvt w=(145n) l=45n nf=1 m=(1)
mn12 (Db SEb net449 VSS) g45n1lvt w=(145n) l=45n nf=1 m=(1)
mn11 (net449 D VSS VSS) g45n1lvt w=(145n) l=45n nf=1 m=(1)
mn57 (QN net367 VSS VSS) g45n1lvt w=(1.04u) l=45n nf=1 m=(1)
mn55 (Q qbint VSS VSS) g45n1lvt w=(1.04u) l=45n nf=1 m=(1)
mn50 (net436 qbint VSS VSS) g45n1lvt w=(145n) l=45n nf=1 m=(1)
mn51 (n30 CKb net436 VSS) g45n1lvt w=(145n) l=45n nf=1 m=(1)
mn35 (net429 mout VSS VSS) g45n1lvt w=(145n) l=45n nf=1 m=(1)
mn36 (n20 CKbb net429 VSS) g45n1lvt w=(145n) l=45n nf=1 m=(1)
mn20 (CKb CK VSS VSS) g45n1lvt w=(145n) l=45n nf=1 m=(1)
mn45 (qbint n30 VSS VSS) g45n1lvt w=(410n) l=45n nf=1 m=(1)
mn56 (net367 qbint VSS VSS) g45n1lvt w=(260n) l=45n nf=1 m=(1)
mn21 (CKbb CKb VSS VSS) g45n1lvt w=(145n) l=45n nf=1 m=(1)
mn40 (n30 CKbb mout VSS) g45n1lvt w=(145n) l=45n nf=1 m=(1)
mn30 (mout n20 VSS VSS) g45n1lvt w=(145n) l=45n nf=1 m=(1)
mn10 (SEb SE VSS VSS) g45n1lvt w=(145n) l=45n nf=1 m=(1)
mn25 (n20 CKb Db VSS) g45n1lvt w=(145n) l=45n nf=1 m=(1)
ends SDFFX4
