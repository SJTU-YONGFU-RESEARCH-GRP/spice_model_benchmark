// gsclib045_lvt/ADDFHX4/schematic

simulator lang=spectre

subckt ADDFHX4 A B CI CO S VDD VSS
mp2 (n3 A VDD VDD) g45p1lvt w=(390n) l=45n nf=1 m=(1)
mp3 (n3 B VDD VDD) g45p1lvt w=(390n) l=45n nf=1 m=(1)
mp4 (COb CI n3 VDD) g45p1lvt w=(390n) l=45n nf=1 m=(1)
mp5 (n5 A VDD VDD) g45p1lvt w=(390n) l=45n nf=1 m=(1)
mp6 (n5 B VDD VDD) g45p1lvt w=(390n) l=45n nf=1 m=(1)
mp7 (n5 CI VDD VDD) g45p1lvt w=(390n) l=45n nf=1 m=(1)
mp8 (Sb COb n5 VDD) g45p1lvt w=(390n) l=45n nf=1 m=(1)
mp0 (n1 A VDD VDD) g45p1lvt w=(390n) l=45n nf=1 m=(1)
mp1 (COb B n1 VDD) g45p1lvt w=(390n) l=45n nf=1 m=(1)
mp12 (CO COb VDD VDD) g45p1lvt w=(1.56u) l=45n nf=1 m=(1)
mp13 (S Sb VDD VDD) g45p1lvt w=(1.56u) l=45n nf=1 m=(1)
mp11 (Sb CI n9 VDD) g45p1lvt w=(390n) l=45n nf=1 m=(1)
mp10 (n9 B n8 VDD) g45p1lvt w=(390n) l=45n nf=1 m=(1)
mp9 (n8 A VDD VDD) g45p1lvt w=(390n) l=45n nf=1 m=(1)
mn5 (n4 A VSS VSS) g45n1lvt w=(260n) l=45n nf=1 m=(1)
mn6 (n4 B VSS VSS) g45n1lvt w=(260n) l=45n nf=1 m=(1)
mn4 (COb CI n2 VSS) g45n1lvt w=(260n) l=45n nf=1 m=(1)
mn3 (n2 B VSS VSS) g45n1lvt w=(260n) l=45n nf=1 m=(1)
mn2 (n2 A VSS VSS) g45n1lvt w=(260n) l=45n nf=1 m=(1)
mn7 (n4 CI VSS VSS) g45n1lvt w=(260n) l=45n nf=1 m=(1)
mn8 (Sb COb n4 VSS) g45n1lvt w=(260n) l=45n nf=1 m=(1)
mn0 (n0 A VSS VSS) g45n1lvt w=(260n) l=45n nf=1 m=(1)
mn1 (COb B n0 VSS) g45n1lvt w=(260n) l=45n nf=1 m=(1)
mn12 (CO COb VSS VSS) g45n1lvt w=(1.04u) l=45n nf=1 m=(1)
mn13 (S Sb VSS VSS) g45n1lvt w=(1.04u) l=45n nf=1 m=(1)
mn11 (Sb CI n7 VSS) g45n1lvt w=(260n) l=45n nf=1 m=(1)
mn10 (n7 B n6 VSS) g45n1lvt w=(260n) l=45n nf=1 m=(1)
mn9 (n6 A VSS VSS) g45n1lvt w=(260n) l=45n nf=1 m=(1)
ends ADDFHX4
