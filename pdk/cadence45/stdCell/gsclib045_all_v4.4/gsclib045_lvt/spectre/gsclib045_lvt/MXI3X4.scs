// gsclib045_lvt/MXI3X4/schematic

simulator lang=spectre

subckt MXI3X4 A B C S0 S1 Y VDD VSS
mp5 (n0 S0b n5 VDD) g45p1lvt w=(215n) l=45n nf=1 m=(1)
mp4 (n5 B VDD VDD) g45p1lvt w=(215n) l=45n nf=1 m=(1)
mp3 (n0 S0 n3 VDD) g45p1lvt w=(215n) l=45n nf=1 m=(1)
mp2 (n3 A VDD VDD) g45p1lvt w=(215n) l=45n nf=1 m=(1)
mp8 (n1 S1 n7 VDD) g45p1lvt w=(310n) l=45n nf=1 m=(1)
mp7 (n7 n0 VDD VDD) g45p1lvt w=(310n) l=45n nf=1 m=(1)
mp11 (Y n1 VDD VDD) g45p1lvt w=(1.56u) l=45n nf=1 m=(1)
mp9 (n9 Cp VDD VDD) g45p1lvt w=(310n) l=45n nf=1 m=(1)
mp10 (n1 S1b n9 VDD) g45p1lvt w=(310n) l=45n nf=1 m=(1)
mp6 (Cp C VDD VDD) g45p1lvt w=(215n) l=45n nf=1 m=(1)
mp1 (S1b S1 VDD VDD) g45p1lvt w=(215n) l=45n nf=1 m=(1)
mp0 (S0b S0 VDD VDD) g45p1lvt w=(215n) l=45n nf=1 m=(1)
mn4 (n4 B VSS VSS) g45n1lvt w=(145n) l=45n nf=1 m=(1)
mn5 (n0 S0 n4 VSS) g45n1lvt w=(145n) l=45n nf=1 m=(1)
mn3 (n0 S0b n2 VSS) g45n1lvt w=(145n) l=45n nf=1 m=(1)
mn2 (n2 A VSS VSS) g45n1lvt w=(145n) l=45n nf=1 m=(1)
mn11 (Y n1 VSS VSS) g45n1lvt w=(1.04u) l=45n nf=1 m=(1)
mn10 (n1 S1 n8 VSS) g45n1lvt w=(205n) l=45n nf=1 m=(1)
mn9 (n8 Cp VSS VSS) g45n1lvt w=(205n) l=45n nf=1 m=(1)
mn8 (n1 S1b n6 VSS) g45n1lvt w=(205n) l=45n nf=1 m=(1)
mn7 (n6 n0 VSS VSS) g45n1lvt w=(205n) l=45n nf=1 m=(1)
mn6 (Cp C VSS VSS) g45n1lvt w=(145n) l=45n nf=1 m=(1)
mn0 (S0b S0 VSS VSS) g45n1lvt w=(145n) l=45n nf=1 m=(1)
mn1 (S1b S1 VSS VSS) g45n1lvt w=(145n) l=45n nf=1 m=(1)
ends MXI3X4
