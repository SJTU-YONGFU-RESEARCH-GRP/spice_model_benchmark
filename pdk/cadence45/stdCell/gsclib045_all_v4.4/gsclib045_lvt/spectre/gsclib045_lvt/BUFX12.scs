// gsclib045_lvt/BUFX12/schematic

simulator lang=spectre

subckt BUFX12 A Y VDD VSS
mp1 (Y n0 VDD VDD) g45p1lvt w=(4.7u) l=45n nf=1 m=(1)
mp0 (n0 A VDD VDD) g45p1lvt w=(1.17u) l=45n nf=1 m=(1)
mn1 (VSS n0 Y VSS) g45n1lvt w=(3.1u) l=45n nf=1 m=(1)
mn0 (VSS A n0 VSS) g45n1lvt w=(780n) l=45n nf=1 m=(1)
ends BUFX12
