// gsclib045_lvt/NAND2X1/schematic

simulator lang=spectre

subckt NAND2X1 A B Y VSS VDD
mp1 (Y B VDD VDD) g45p1lvt w=(390n) l=45n nf=1 m=(1)
mp0 (Y A VDD VDD) g45p1lvt w=(390n) l=45n nf=1 m=(1)
mn1 (Y B n0 VSS) g45n1lvt w=(260n) l=45n nf=1 m=(1)
mn0 (n0 A VSS VSS) g45n1lvt w=(260n) l=45n nf=1 m=(1)
ends NAND2X1
