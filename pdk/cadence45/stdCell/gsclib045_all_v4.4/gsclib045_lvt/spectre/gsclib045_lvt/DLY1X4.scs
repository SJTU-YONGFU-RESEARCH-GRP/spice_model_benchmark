// gsclib045_lvt/DLY1X4/schematic

simulator lang=spectre

subckt DLY1X4 A Y VSS VDD
mp2 (n1 VSS n5 VDD) g45p1lvt w=(215n) l=45n nf=1 m=(1)
mp1 (n5 n0 VDD VDD) g45p1lvt w=(215n) l=45n nf=1 m=(1)
mp4 (Y n2 VDD VDD) g45p1lvt w=(1.56u) l=45n nf=1 m=(1)
mp0 (n0 A VDD VDD) g45p1lvt w=(215n) l=45n nf=1 m=(1)
mp3 (n2 n1 VDD VDD) g45p1lvt w=(390n) l=45n nf=1 m=(1)
mn2 (n1 VDD n4 VSS) g45n1lvt w=(145n) l=45n nf=1 m=(1)
mn1 (n4 n0 VSS VSS) g45n1lvt w=(145n) l=45n nf=1 m=(1)
mn4 (Y n2 VSS VSS) g45n1lvt w=(1.04u) l=45n nf=1 m=(1)
mn0 (n0 A VSS VSS) g45n1lvt w=(145n) l=45n nf=1 m=(1)
mn3 (n2 n1 VSS VSS) g45n1lvt w=(260n) l=45n nf=1 m=(1)
ends DLY1X4
