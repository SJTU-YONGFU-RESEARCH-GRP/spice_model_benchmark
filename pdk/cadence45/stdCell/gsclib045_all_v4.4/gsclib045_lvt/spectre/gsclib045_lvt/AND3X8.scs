// gsclib045_lvt/AND3X8/schematic

simulator lang=spectre

subckt AND3X8 A B C Y VSS VDD
mp1 (net95 B VDD VDD) g45p1lvt w=(780n) l=45n nf=1 m=(1)
mp2 (net95 C VDD VDD) g45p1lvt w=(780n) l=45n nf=1 m=(1)
mp0 (net95 A VDD VDD) g45p1lvt w=(780n) l=45n nf=1 m=(1)
mp3 (Y net95 VDD VDD) g45p1lvt w=(3.115u) l=45n nf=1 m=(1)
mn3 (Y net95 VSS VSS) g45n1lvt w=(2.065u) l=45n nf=1 m=(1)
mn1 (net107 B net103 VSS) g45n1lvt w=(520n) l=45n nf=1 m=(1)
mn0 (net103 A VSS VSS) g45n1lvt w=(520n) l=45n nf=1 m=(1)
mn2 (net95 C net107 VSS) g45n1lvt w=(520n) l=45n nf=1 m=(1)
ends AND3X8
