// gsclib045_lvt/AOI22X4/schematic

simulator lang=spectre

subckt AOI22X4 A0 A1 B0 B1 Y VSS VDD
mp3 (Y B1 net89 VDD) g45p1lvt w=(1.56u) l=45n nf=1 m=(1)
mp0 (net89 A0 VDD VDD) g45p1lvt w=(1.56u) l=45n nf=1 m=(1)
mp1 (net89 A1 VDD VDD) g45p1lvt w=(1.56u) l=45n nf=1 m=(1)
mp2 (Y B0 net89 VDD) g45p1lvt w=(1.56u) l=45n nf=1 m=(1)
mn3 (Y B1 net102 VSS) g45n1lvt w=(1.04u) l=45n nf=1 m=(1)
mn0 (net98 A0 VSS VSS) g45n1lvt w=(1.04u) l=45n nf=1 m=(1)
mn2 (net102 B0 VSS VSS) g45n1lvt w=(1.04u) l=45n nf=1 m=(1)
mn1 (Y A1 net98 VSS) g45n1lvt w=(1.04u) l=45n nf=1 m=(1)
ends AOI22X4
