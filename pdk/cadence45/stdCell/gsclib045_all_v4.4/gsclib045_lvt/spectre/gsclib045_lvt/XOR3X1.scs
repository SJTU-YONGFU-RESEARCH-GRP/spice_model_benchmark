// gsclib045_lvt/XOR3X1/schematic

simulator lang=spectre

subckt XOR3X1 A B C Y VDD VSS
mp10 (n62 A VDD VDD) g45p1lvt w=(390n) l=45n nf=1 m=(1)
mp1 (n44 n61 n62 VDD) g45p1lvt w=(390n) l=45n nf=1 m=(1)
mp7 (Y n50 VDD VDD) g45p1lvt w=(390n) l=45n nf=1 m=(1)
mp2 (n44 B n11 VDD) g45p1lvt w=(310n) l=45n nf=1 m=(1)
mp9 (n61 B VDD VDD) g45p1lvt w=(310n) l=45n nf=1 m=(1)
mp3 (n50 C n56 VDD) g45p1lvt w=(310n) l=45n nf=1 m=(1)
mp8 (n60 C VDD VDD) g45p1lvt w=(310n) l=45n nf=1 m=(1)
mp4 (n50 n60 n44 VDD) g45p1lvt w=(310n) l=45n nf=1 m=(1)
mp0 (n11 n62 VDD VDD) g45p1lvt w=(310n) l=45n nf=1 m=(1)
mp6 (n11 n61 n56 VDD) g45p1lvt w=(310n) l=45n nf=1 m=(1)
mp5 (n56 B n62 VDD) g45p1lvt w=(390n) l=45n nf=1 m=(1)
mn3 (n56 n60 n50 VSS) g45n1lvt w=(190n) l=45n nf=1 m=(1)
mn10 (n62 A VSS VSS) g45n1lvt w=(205n) l=45n nf=1 m=(1)
mn4 (n44 C n50 VSS) g45n1lvt w=(190n) l=45n nf=1 m=(1)
mn8 (n60 C VSS VSS) g45n1lvt w=(190n) l=45n nf=1 m=(1)
mn9 (n61 B VSS VSS) g45n1lvt w=(190n) l=45n nf=1 m=(1)
mn6 (n56 B n11 VSS) g45n1lvt w=(190n) l=45n nf=1 m=(1)
mn1 (n62 B n44 VSS) g45n1lvt w=(205n) l=45n nf=1 m=(1)
mn2 (n11 n61 n44 VSS) g45n1lvt w=(190n) l=45n nf=1 m=(1)
mn0 (n11 n62 VSS VSS) g45n1lvt w=(190n) l=45n nf=1 m=(1)
mn5 (n62 n61 n56 VSS) g45n1lvt w=(205n) l=45n nf=1 m=(1)
mn7 (Y n50 VSS VSS) g45n1lvt w=(205n) l=45n nf=1 m=(1)
ends XOR3X1
