// gsclib045_lvt/DLY2X4/schematic

simulator lang=spectre

subckt DLY2X4 A Y VDD VSS
mp6 (n3 VSS n11 VDD) g45p1lvt w=(215n) l=45n nf=1 m=(1)
mp5 (n11 n2 VDD VDD) g45p1lvt w=(215n) l=45n nf=1 m=(1)
mp8 (Y n4 VDD VDD) g45p1lvt w=(1.56u) l=45n nf=1 m=(1)
mp4 (n2 VSS n9 VDD) g45p1lvt w=(215n) l=45n nf=1 m=(1)
mp3 (n9 n1 VDD VDD) g45p1lvt w=(215n) l=45n nf=1 m=(1)
mp2 (n1 VSS n7 VDD) g45p1lvt w=(215n) l=45n nf=1 m=(1)
mp1 (n7 n0 VDD VDD) g45p1lvt w=(215n) l=45n nf=1 m=(1)
mp7 (n4 n3 VDD VDD) g45p1lvt w=(390n) l=45n nf=1 m=(1)
mp0 (n0 A VDD VDD) g45p1lvt w=(215n) l=45n nf=1 m=(1)
mn6 (n3 VDD n10 VSS) g45n1lvt w=(145n) l=45n nf=1 m=(1)
mn5 (n10 n2 VSS VSS) g45n1lvt w=(145n) l=45n nf=1 m=(1)
mn8 (Y n4 VSS VSS) g45n1lvt w=(1.04u) l=45n nf=1 m=(1)
mn4 (n2 VDD n8 VSS) g45n1lvt w=(145n) l=45n nf=1 m=(1)
mn3 (n8 n1 VSS VSS) g45n1lvt w=(145n) l=45n nf=1 m=(1)
mn2 (n1 VDD n6 VSS) g45n1lvt w=(145n) l=45n nf=1 m=(1)
mn1 (n6 n0 VSS VSS) g45n1lvt w=(145n) l=45n nf=1 m=(1)
mn7 (n4 n3 VSS VSS) g45n1lvt w=(260n) l=45n nf=1 m=(1)
mn0 (n0 A VSS VSS) g45n1lvt w=(145n) l=45n nf=1 m=(1)
ends DLY2X4
