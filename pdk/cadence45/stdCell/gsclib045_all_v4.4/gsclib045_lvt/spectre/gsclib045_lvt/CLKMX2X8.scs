// gsclib045_lvt/CLKMX2X8/schematic

simulator lang=spectre

subckt CLKMX2X8 A B S0 Y VDD VSS
mp4 (n0 S0b net115 VDD) g45p1lvt w=(310n) l=45n nf=1 m=(1)
mp3 (net115 B VDD VDD) g45p1lvt w=(310n) l=45n nf=1 m=(1)
mp5 (Y n0 VDD VDD) g45p1lvt w=(3.115u) l=45n nf=1 m=(1)
mp2 (n0 S0 net123 VDD) g45p1lvt w=(310n) l=45n nf=1 m=(1)
mp0 (S0b S0 VDD VDD) g45p1lvt w=(215n) l=45n nf=1 m=(1)
mp1 (net123 A VDD VDD) g45p1lvt w=(310n) l=45n nf=1 m=(1)
mn3 (net140 B VSS VSS) g45n1lvt w=(205n) l=45n nf=1 m=(1)
mn0 (S0b S0 VSS VSS) g45n1lvt w=(145n) l=45n nf=1 m=(1)
mn2 (n0 S0b net148 VSS) g45n1lvt w=(205n) l=45n nf=1 m=(1)
mn1 (net148 A VSS VSS) g45n1lvt w=(205n) l=45n nf=1 m=(1)
mn5 (Y n0 VSS VSS) g45n1lvt w=(2.065u) l=45n nf=1 m=(1)
mn4 (n0 S0 net140 VSS) g45n1lvt w=(205n) l=45n nf=1 m=(1)
ends CLKMX2X8
