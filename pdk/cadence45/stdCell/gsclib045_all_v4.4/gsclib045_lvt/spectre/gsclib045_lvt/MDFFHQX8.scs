// gsclib045_lvt/MDFFHQX8/schematic

simulator lang=spectre

subckt MDFFHQX8 CK D0 D1 Q S0 VDD VSS
mp14 (D0b S0b n13 VDD) g45p1lvt w=(390n) l=45n nf=1 m=(1)
mp13 (n13 D1 VDD VDD) g45p1lvt w=(390n) l=45n nf=1 m=(1)
mp12 (D0b S0 n11 VDD) g45p1lvt w=(390n) l=45n nf=1 m=(1)
mp11 (n11 D0 VDD VDD) g45p1lvt w=(390n) l=45n nf=1 m=(1)
mp51 (n30 CKbb n36 VDD) g45p1lvt w=(310n) l=45n nf=1 m=(1)
mp50 (n36 qbint VDD VDD) g45p1lvt w=(310n) l=45n nf=1 m=(1)
mp55 (Q qbint VDD VDD) g45p1lvt w=(3.115u) l=45n nf=1 m=(1)
mp35 (n26 mout VDD VDD) g45p1lvt w=(310n) l=45n nf=1 m=(1)
mp36 (n20 CKb n26 VDD) g45p1lvt w=(310n) l=45n nf=1 m=(1)
mp25 (n20 CKbb D0b VDD) g45p1lvt w=(310n) l=45n nf=1 m=(1)
mp21 (CKbb CKb VDD VDD) g45p1lvt w=(215n) l=45n nf=1 m=(1)
mp30 (mout n20 VDD VDD) g45p1lvt w=(310n) l=45n nf=1 m=(1)
mp40 (n30 CKb mout VDD) g45p1lvt w=(310n) l=45n nf=1 m=(1)
mp10 (S0b S0 VDD VDD) g45p1lvt w=(215n) l=45n nf=1 m=(1)
mp45 (qbint n30 VDD VDD) g45p1lvt w=(1.17u) l=45n nf=1 m=(1)
mp20 (CKb CK VDD VDD) g45p1lvt w=(215n) l=45n nf=1 m=(1)
mn13 (n12 D1 VSS VSS) g45n1lvt w=(260n) l=45n nf=1 m=(1)
mn14 (D0b S0 n12 VSS) g45n1lvt w=(260n) l=45n nf=1 m=(1)
mn12 (D0b S0b n10 VSS) g45n1lvt w=(260n) l=45n nf=1 m=(1)
mn11 (n10 D0 VSS VSS) g45n1lvt w=(260n) l=45n nf=1 m=(1)
mn55 (Q qbint VSS VSS) g45n1lvt w=(2.065u) l=45n nf=1 m=(1)
mn50 (n35 qbint VSS VSS) g45n1lvt w=(205n) l=45n nf=1 m=(1)
mn51 (n30 CKb n35 VSS) g45n1lvt w=(205n) l=45n nf=1 m=(1)
mn10 (S0b S0 VSS VSS) g45n1lvt w=(145n) l=45n nf=1 m=(1)
mn40 (mout CKbb n30 VSS) g45n1lvt w=(205n) l=45n nf=1 m=(1)
mn35 (n25 mout VSS VSS) g45n1lvt w=(205n) l=45n nf=1 m=(1)
mn36 (n20 CKbb n25 VSS) g45n1lvt w=(205n) l=45n nf=1 m=(1)
mn21 (CKbb CKb VSS VSS) g45n1lvt w=(145n) l=45n nf=1 m=(1)
mn45 (qbint n30 VSS VSS) g45n1lvt w=(780n) l=45n nf=1 m=(1)
mn25 (D0b CKb n20 VSS) g45n1lvt w=(205n) l=45n nf=1 m=(1)
mn30 (mout n20 VSS VSS) g45n1lvt w=(205n) l=45n nf=1 m=(1)
mn20 (CKb CK VSS VSS) g45n1lvt w=(145n) l=45n nf=1 m=(1)
ends MDFFHQX8
