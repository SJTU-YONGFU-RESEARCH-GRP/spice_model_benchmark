// gsclib045_lvt/SEDFFTRX4/schematic

simulator lang=spectre

subckt SEDFFTRX4 CK D E Q QN RN SE SI VDD VSS
mp13 (net557 SI VDD VDD) g45p1lvt w=(215n) l=45n nf=1 m=(1)
mp14 (Dpb SEb net557 VDD) g45p1lvt w=(215n) l=45n nf=1 m=(1)
mp11 (net549 Dp VDD VDD) g45p1lvt w=(215n) l=45n nf=1 m=(1)
mp12 (Dpb SE net549 VDD) g45p1lvt w=(215n) l=45n nf=1 m=(1)
mp1 (Db D VDD VDD) g45p1lvt w=(215n) l=45n nf=1 m=(1)
mp57 (QN net582 VDD VDD) g45p1lvt w=(1.56u) l=45n nf=1 m=(1)
mp55 (Q qbint VDD VDD) g45p1lvt w=(1.56u) l=45n nf=1 m=(1)
mp50 (net529 qbint VDD VDD) g45p1lvt w=(215n) l=45n nf=1 m=(1)
mp51 (n30 CKbb net529 VDD) g45p1lvt w=(215n) l=45n nf=1 m=(1)
mp35 (net521 mout VDD VDD) g45p1lvt w=(215n) l=45n nf=1 m=(1)
mp36 (n20 CKb net521 VDD) g45p1lvt w=(215n) l=45n nf=1 m=(1)
mp20 (CKb CK VDD VDD) g45p1lvt w=(215n) l=45n nf=1 m=(1)
mp2 (RNb RN VDD VDD) g45p1lvt w=(215n) l=45n nf=1 m=(1)
mp7 (Dp Db net505 VDD) g45p1lvt w=(215n) l=45n nf=1 m=(1)
mp6 (Dp E net505 VDD) g45p1lvt w=(215n) l=45n nf=1 m=(1)
mp10 (SEb SE VDD VDD) g45p1lvt w=(215n) l=45n nf=1 m=(1)
mp0 (Eb E VDD VDD) g45p1lvt w=(215n) l=45n nf=1 m=(1)
mp4 (net505 Eb net493 VDD) g45p1lvt w=(215n) l=45n nf=1 m=(1)
mp5 (net505 qbint net493 VDD) g45p1lvt w=(215n) l=45n nf=1 m=(1)
mp3 (net493 RNb VDD VDD) g45p1lvt w=(215n) l=45n nf=1 m=(1)
mp56 (net582 qbint VDD VDD) g45p1lvt w=(390n) l=45n nf=1 m=(1)
mp45 (qbint n30 VDD VDD) g45p1lvt w=(620n) l=45n nf=1 m=(1)
mp30 (mout n20 VDD VDD) g45p1lvt w=(215n) l=45n nf=1 m=(1)
mp40 (n30 CKb mout VDD) g45p1lvt w=(215n) l=45n nf=1 m=(1)
mp21 (CKbb CKb VDD VDD) g45p1lvt w=(215n) l=45n nf=1 m=(1)
mp25 (n20 CKbb Dpb VDD) g45p1lvt w=(215n) l=45n nf=1 m=(1)
mn14 (Dpb SE net658 VSS) g45n1lvt w=(145n) l=45n nf=1 m=(1)
mn13 (net658 SI VSS VSS) g45n1lvt w=(145n) l=45n nf=1 m=(1)
mn12 (Dpb SEb net650 VSS) g45n1lvt w=(145n) l=45n nf=1 m=(1)
mn11 (net650 Dp VSS VSS) g45n1lvt w=(145n) l=45n nf=1 m=(1)
mn1 (Db D VSS VSS) g45n1lvt w=(145n) l=45n nf=1 m=(1)
mn7 (Dp Db net638 VSS) g45n1lvt w=(145n) l=45n nf=1 m=(1)
mn6 (net638 E VSS VSS) g45n1lvt w=(145n) l=45n nf=1 m=(1)
mn4 (net634 Eb VSS VSS) g45n1lvt w=(145n) l=45n nf=1 m=(1)
mn5 (Dp qbint net634 VSS) g45n1lvt w=(145n) l=45n nf=1 m=(1)
mn57 (QN net582 VSS VSS) g45n1lvt w=(1.04u) l=45n nf=1 m=(1)
mn55 (Q qbint VSS VSS) g45n1lvt w=(1.04u) l=45n nf=1 m=(1)
mn50 (net618 qbint VSS VSS) g45n1lvt w=(145n) l=45n nf=1 m=(1)
mn51 (n30 CKb net618 VSS) g45n1lvt w=(145n) l=45n nf=1 m=(1)
mn36 (n20 CKbb net606 VSS) g45n1lvt w=(145n) l=45n nf=1 m=(1)
mn35 (net606 mout VSS VSS) g45n1lvt w=(145n) l=45n nf=1 m=(1)
mn20 (CKb CK VSS VSS) g45n1lvt w=(145n) l=45n nf=1 m=(1)
mn2 (RNb RN VSS VSS) g45n1lvt w=(145n) l=45n nf=1 m=(1)
mn10 (SEb SE VSS VSS) g45n1lvt w=(145n) l=45n nf=1 m=(1)
mn0 (Eb E VSS VSS) g45n1lvt w=(145n) l=45n nf=1 m=(1)
mn3 (Dp RNb VSS VSS) g45n1lvt w=(145n) l=45n nf=1 m=(1)
mn56 (net582 qbint VSS VSS) g45n1lvt w=(260n) l=45n nf=1 m=(1)
mn45 (qbint n30 VSS VSS) g45n1lvt w=(410n) l=45n nf=1 m=(1)
mn30 (mout n20 VSS VSS) g45n1lvt w=(145n) l=45n nf=1 m=(1)
mn25 (n20 CKb Dpb VSS) g45n1lvt w=(145n) l=45n nf=1 m=(1)
mn40 (n30 CKbb mout VSS) g45n1lvt w=(145n) l=45n nf=1 m=(1)
mn21 (CKbb CKb VSS VSS) g45n1lvt w=(145n) l=45n nf=1 m=(1)
ends SEDFFTRX4
