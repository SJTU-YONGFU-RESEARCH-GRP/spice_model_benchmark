// gsclib045_lvt/OAI221X4/schematic

simulator lang=spectre

subckt OAI221X4 A0 A1 B0 B1 C0 Y VSS VDD
mp3 (Y B1 net123 VDD) g45p1lvt w=(1.56u) l=45n nf=1 m=(1)
mp0 (net115 A0 VDD VDD) g45p1lvt w=(1.56u) l=45n nf=1 m=(1)
mp1 (Y A1 net115 VDD) g45p1lvt w=(1.56u) l=45n nf=1 m=(1)
mp2 (net123 B0 VDD VDD) g45p1lvt w=(1.56u) l=45n nf=1 m=(1)
mp4 (Y C0 VDD VDD) g45p1lvt w=(1.56u) l=45n nf=1 m=(1)
mn4 (Y C0 net132 VSS) g45n1lvt w=(1.04u) l=45n nf=1 m=(1)
mn0 (net128 A0 VSS VSS) g45n1lvt w=(1.04u) l=45n nf=1 m=(1)
mn1 (net128 A1 VSS VSS) g45n1lvt w=(1.04u) l=45n nf=1 m=(1)
mn2 (net132 B0 net128 VSS) g45n1lvt w=(1.04u) l=45n nf=1 m=(1)
mn3 (net132 B1 net128 VSS) g45n1lvt w=(1.04u) l=45n nf=1 m=(1)
ends OAI221X4
