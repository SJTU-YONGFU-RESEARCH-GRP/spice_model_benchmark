// gsclib045_lvt/AND3X1/schematic

simulator lang=spectre

subckt AND3X1 A B C Y VSS VDD
mp1 (net086 B VDD VDD) g45p1lvt w=(215n) l=45n nf=1 m=(1)
mp2 (net086 C VDD VDD) g45p1lvt w=(215n) l=45n nf=1 m=(1)
mp0 (net086 A VDD VDD) g45p1lvt w=(215n) l=45n nf=1 m=(1)
mp3 (Y net086 VDD VDD) g45p1lvt w=(390n) l=45n nf=1 m=(1)
mn3 (Y net086 VSS VSS) g45n1lvt w=(260n) l=45n nf=1 m=(1)
mn1 (net0106 B net0102 VSS) g45n1lvt w=(145n) l=45n nf=1 m=(1)
mn0 (net0102 A VSS VSS) g45n1lvt w=(145n) l=45n nf=1 m=(1)
mn2 (net086 C net0106 VSS) g45n1lvt w=(145n) l=45n nf=1 m=(1)
ends AND3X1
