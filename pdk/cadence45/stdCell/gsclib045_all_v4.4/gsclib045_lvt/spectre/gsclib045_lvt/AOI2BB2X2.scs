// gsclib045_lvt/AOI2BB2X2/schematic

simulator lang=spectre

subckt AOI2BB2X2 A0N A1N B0 B1 Y VSS VDD
mp5 (Y B1 n4 VDD) g45p1lvt w=(780n) l=45n nf=1 m=(1)
mp4 (Y B0 n4 VDD) g45p1lvt w=(780n) l=45n nf=1 m=(1)
mp2 (n4 n0 VDD VDD) g45p1lvt w=(780n) l=45n nf=1 m=(1)
mp0 (n0 A0N VDD VDD) g45p1lvt w=(215n) l=45n nf=1 m=(1)
mp1 (n1 A1N VDD VDD) g45p1lvt w=(215n) l=45n nf=1 m=(1)
mp3 (n4 n1 VDD VDD) g45p1lvt w=(780n) l=45n nf=1 m=(1)
mn5 (n3 B1 VSS VSS) g45n1lvt w=(520n) l=45n nf=1 m=(1)
mn4 (Y B0 n3 VSS) g45n1lvt w=(520n) l=45n nf=1 m=(1)
mn3 (Y n1 n2 VSS) g45n1lvt w=(520n) l=45n nf=1 m=(1)
mn2 (n2 n0 VSS VSS) g45n1lvt w=(520n) l=45n nf=1 m=(1)
mn0 (n0 A0N VSS VSS) g45n1lvt w=(145n) l=45n nf=1 m=(1)
mn1 (n1 A1N VSS VSS) g45n1lvt w=(145n) l=45n nf=1 m=(1)
ends AOI2BB2X2
