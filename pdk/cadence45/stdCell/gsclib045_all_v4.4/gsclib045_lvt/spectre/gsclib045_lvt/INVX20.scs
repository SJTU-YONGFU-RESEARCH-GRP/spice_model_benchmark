// Generated for: spectre (Apr 19 14:34:31 2013 )
// Library name: gsclib045_lvt
// Cell name: INVX20
// View name: schematic

simulator lang=spectre

subckt INVX20 A Y VDD VSS
mp0 (Y A VDD VDD) g45p1lvt w=(7.82u) l=45n nf=1 as=1.0948p ad=1.0948p \
        ps=15.92u pd=15.92u nrd=17.9028m nrs=17.9028m sa=140n sb=140n \
        sd=160n sca=45.04644 scb=0.05038 scc=0.00572 m=(1)
mn0 (Y A VSS VSS) g45n1lvt w=(5.185u) l=45n nf=1 as=725.9f ad=725.9f \
        ps=10.65u pd=10.65u nrd=27.001m nrs=27.001m sa=140n sb=140n \
        sd=160n sca=47.17159 scb=0.05152 scc=0.00593 m=(1)
ends INVX20
// End of subcircuit definition.
