// gsclib045_lvt/AOI2BB2XL/schematic

simulator lang=spectre

subckt AOI2BB2XL A0N A1N B0 B1 Y VDD VSS
mp5 (Y B1 net124 VDD) g45p1lvt w=(215n) l=45n nf=1 m=(1)
mp4 (Y B0 net124 VDD) g45p1lvt w=(215n) l=45n nf=1 m=(1)
mp2 (net124 net146 VDD VDD) g45p1lvt w=(215n) l=45n nf=1 m=(1)
mp0 (net146 A0N VDD VDD) g45p1lvt w=(215n) l=45n nf=1 m=(1)
mp1 (net164 A1N VDD VDD) g45p1lvt w=(215n) l=45n nf=1 m=(1)
mp3 (net124 net164 VDD VDD) g45p1lvt w=(215n) l=45n nf=1 m=(1)
mn5 (net156 B1 VSS VSS) g45n1lvt w=(145n) l=45n nf=1 m=(1)
mn4 (Y B0 net156 VSS) g45n1lvt w=(145n) l=45n nf=1 m=(1)
mn3 (Y net164 net144 VSS) g45n1lvt w=(145n) l=45n nf=1 m=(1)
mn2 (net144 net146 VSS VSS) g45n1lvt w=(145n) l=45n nf=1 m=(1)
mn0 (net146 A0N VSS VSS) g45n1lvt w=(145n) l=45n nf=1 m=(1)
mn1 (net164 A1N VSS VSS) g45n1lvt w=(145n) l=45n nf=1 m=(1)
ends AOI2BB2XL
