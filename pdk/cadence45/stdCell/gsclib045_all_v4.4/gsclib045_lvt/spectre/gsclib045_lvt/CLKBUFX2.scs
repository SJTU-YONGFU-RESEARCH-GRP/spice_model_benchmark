// gsclib045_lvt/CLKBUFX2/schematic

simulator lang=spectre

subckt CLKBUFX2 A Y VDD VSS
mp1 (Y net44 VDD VDD) g45p1lvt w=(780n) l=45n nf=1 m=(1)
mp0 (net44 A VDD VDD) g45p1lvt w=(215n) l=45n nf=1 m=(1)
mn1 (Y net44 VSS VSS) g45n1lvt w=(520n) l=45n nf=1 m=(1)
mn0 (net44 A VSS VSS) g45n1lvt w=(145n) l=45n nf=1 m=(1)
ends CLKBUFX2
