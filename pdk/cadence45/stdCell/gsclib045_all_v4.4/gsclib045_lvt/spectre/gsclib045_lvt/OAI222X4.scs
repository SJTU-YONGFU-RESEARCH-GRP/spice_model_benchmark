// gsclib045_lvt/OAI222X4/schematic

simulator lang=spectre

subckt OAI222X4 A0 A1 B0 B1 C0 C1 Y VSS VDD
mp5 (Y C1 n4 VDD) g45p1lvt w=(1.56u) l=45n nf=1 m=(1)
mp4 (n4 C0 VDD VDD) g45p1lvt w=(1.56u) l=45n nf=1 m=(1)
mp3 (Y B1 n3 VDD) g45p1lvt w=(1.56u) l=45n nf=1 m=(1)
mp2 (n3 B0 VDD VDD) g45p1lvt w=(1.56u) l=45n nf=1 m=(1)
mp1 (Y A1 n2 VDD) g45p1lvt w=(1.56u) l=45n nf=1 m=(1)
mp0 (n2 A0 VDD VDD) g45p1lvt w=(1.56u) l=45n nf=1 m=(1)
mn5 (Y C1 n0 VSS) g45n1lvt w=(1.04u) l=45n nf=1 m=(1)
mn4 (Y C0 n0 VSS) g45n1lvt w=(1.04u) l=45n nf=1 m=(1)
mn3 (n0 B1 n1 VSS) g45n1lvt w=(1.04u) l=45n nf=1 m=(1)
mn2 (n0 B0 n1 VSS) g45n1lvt w=(1.04u) l=45n nf=1 m=(1)
mn0 (n1 A0 VSS VSS) g45n1lvt w=(1.04u) l=45n nf=1 m=(1)
mn1 (n1 A1 VSS VSS) g45n1lvt w=(1.04u) l=45n nf=1 m=(1)
ends OAI222X4
