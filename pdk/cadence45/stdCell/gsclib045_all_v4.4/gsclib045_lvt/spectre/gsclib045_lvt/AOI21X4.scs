// gsclib045_lvt/AOI21X4/schematic

simulator lang=spectre

subckt AOI21X4 A0 A1 B0 Y VDD VSS
mp2 (Y B0 net70 VDD) g45p1lvt w=(1.56u) l=45n nf=1 m=(1)
mp1 (net70 A1 VDD VDD) g45p1lvt w=(1.56u) l=45n nf=1 m=(1)
mp0 (net70 A0 VDD VDD) g45p1lvt w=(1.56u) l=45n nf=1 m=(1)
mn2 (Y B0 VSS VSS) g45n1lvt w=(1.04u) l=45n nf=1 m=(1)
mn0 (net82 A0 VSS VSS) g45n1lvt w=(1.04u) l=45n nf=1 m=(1)
mn1 (Y A1 net82 VSS) g45n1lvt w=(1.04u) l=45n nf=1 m=(1)
ends AOI21X4
