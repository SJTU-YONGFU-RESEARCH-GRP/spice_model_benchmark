// gsclib045_lvt/CLKAND2X12/schematic

simulator lang=spectre

subckt CLKAND2X12 A B Y VDD VSS
mp1 (net61 B VDD VDD) g45p1lvt w=(1.175u) l=45n nf=1 m=(1)
mp0 (net61 A VDD VDD) g45p1lvt w=(1.175u) l=45n nf=1 m=(1)
mp2 (Y net61 VDD VDD) g45p1lvt w=(4.7u) l=45n nf=1 m=(1)
mn2 (Y net61 VSS VSS) g45n1lvt w=(3.1u) l=45n nf=1 m=(1)
mn0 (net69 A VSS VSS) g45n1lvt w=(1.55u) l=45n nf=1 m=(1)
mn1 (net61 B net69 VSS) g45n1lvt w=(1.55u) l=45n nf=1 m=(1)
ends CLKAND2X12
