// gsclib045_lvt/NAND2X8/schematic

simulator lang=spectre

subckt NAND2X8 A B Y VDD VSS
mp1 (Y B VDD VDD) g45p1lvt w=(3.115u) l=45n nf=1 m=(1)
mp0 (Y A VDD VDD) g45p1lvt w=(3.115u) l=45n nf=1 m=(1)
mn1 (Y B n0 VSS) g45n1lvt w=(2.065u) l=45n nf=1 m=(1)
mn0 (n0 A VSS VSS) g45n1lvt w=(2.065u) l=45n nf=1 m=(1)
ends NAND2X8
