// gsclib045_lvt/AOI31X1/schematic

simulator lang=spectre

subckt AOI31X1 A0 A1 A2 B0 Y VSS VDD
mp2 (net81 A2 VDD VDD) g45p1lvt w=(390n) l=45n nf=1 m=(1)
mp3 (Y B0 net81 VDD) g45p1lvt w=(390n) l=45n nf=1 m=(1)
mp1 (net81 A1 VDD VDD) g45p1lvt w=(390n) l=45n nf=1 m=(1)
mp0 (net81 A0 VDD VDD) g45p1lvt w=(390n) l=45n nf=1 m=(1)
mn3 (Y B0 VSS VSS) g45n1lvt w=(260n) l=45n nf=1 m=(1)
mn1 (net97 A1 net93 VSS) g45n1lvt w=(260n) l=45n nf=1 m=(1)
mn2 (Y A2 net97 VSS) g45n1lvt w=(260n) l=45n nf=1 m=(1)
mn0 (net93 A0 VSS VSS) g45n1lvt w=(260n) l=45n nf=1 m=(1)
ends AOI31X1
