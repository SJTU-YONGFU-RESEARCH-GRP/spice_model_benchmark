// Generated for: spectre (May  1 09:16:14 2013 )
// Library name: gsclib045_lvt
// Cell name: MXI2X8
// View name: extracted

simulator lang=spectre

subckt MXI2X8 A B S0 VDD VSS Y
mp0 (\10\:S0b \1\:S0 \19\:VDD VDD) g45p1lvt w=(2.15e-07) l=4.5e-08 nf=1 \
        as=3.44e-14 ad=3.01e-14 ps=7.5e-07 pd=7.1e-07 nrd=1.16667 \
        nrs=1.16667 sa=1.4e-07 sb=2e-06 sd=160n sca=14.9313 scb=0.0137374 \
        scc=0.000173804 m=(1)
mp1 (n4 \1\:A \19\:VDD VDD) g45p1lvt w=(2.15e-07) l=4.5e-08 nf=1 \
        as=3.44e-14 ad=3.762e-14 ps=7.5e-07 pd=7.8e-07 nrd=1.16667 \
        nrs=1.16667 sa=3.45e-07 sb=2e-06 sd=160n sca=11.7616 \
        scb=0.00852924 scc=7.50663e-05 m=(1)
mp2 (\7\:n0 \6\:S0 n4 VDD) g45p1lvt w=(2.15e-07) l=4.5e-08 nf=1 \
        as=3.762e-14 ad=3.655e-14 ps=7.8e-07 pd=7.7e-07 nrd=1.16667 \
        nrs=1.16667 sa=5.65e-07 sb=2e-06 sd=160n sca=10.5874 \
        scb=0.00747601 scc=7.25996e-05 m=(1)
mp4 (\7\:n0 \3\:S0b n6 VDD) g45p1lvt w=(2.15e-07) l=4.5e-08 nf=1 \
        as=4.73e-14 ad=3.655e-14 ps=8.7e-07 pd=7.7e-07 nrd=1.16667 \
        nrs=1.16667 sa=7.8e-07 sb=2e-06 sd=160n sca=10.1345 scb=0.00732736 \
        scc=7.25592e-05 m=(1)
mp3 (n6 \1\:B \1\:VDD VDD) g45p1lvt w=(2.15e-07) l=4.5e-08 nf=1 \
        as=7.18e-14 ad=4.73e-14 ps=1.22e-06 pd=8.7e-07 nrd=1.16667 \
        nrs=1.16667 sa=1.045e-06 sb=2e-06 sd=160n sca=10.1345 \
        scb=0.00732736 scc=7.25592e-05 m=(1)
C1 (S0 VSS) capacitor c=9.9353e-17
C2 (Y VSS) capacitor c=4.75477e-16
C3 (VDD VSS) capacitor c=2.21755e-16
C4 (A VSS) capacitor c=6.08266e-17
C5 (S0b VSS) capacitor c=4.85138e-17
C6 (n0 VSS) capacitor c=2.02097e-16
C7 (n5 VSS) capacitor c=5.73861e-18
C8 (n1 VSS) capacitor c=4.00666e-16
C9 (n6 VSS) capacitor c=6.10308e-18
C10 (\1\:B VSS) capacitor c=4.77173e-17
C11 (\3\:S0b VSS) capacitor c=4.45148e-17
C12 (\6\:S0 VSS) capacitor c=4.46984e-17
C13 (\1\:A VSS) capacitor c=6.05572e-17
C14 (\1\:S0 VSS) capacitor c=3.37217e-17
C15 (\3\:B VSS) capacitor c=4.71729e-17
C16 (\4\:S0 VSS) capacitor c=5.88773e-17
C17 (\3\:A VSS) capacitor c=4.77193e-17
C18 (\3\:S0 VSS) capacitor c=5.95161e-17
C19 (\9\:n1 VSS) capacitor c=1.79325e-17
C20 (\2\:B VSS) capacitor c=5.04386e-17
C21 (\4\:S0b VSS) capacitor c=4.19511e-17
C22 (\5\:S0 VSS) capacitor c=8.4611e-17
C23 (\2\:S0b VSS) capacitor c=4.49556e-17
C24 (\2\:A VSS) capacitor c=6.19038e-17
C25 (\2\:S0 VSS) capacitor c=5.44423e-17
C26 (\1\:VDD VSS) capacitor c=3.82076e-16
C27 (\27\:n1 VSS) capacitor c=9.17053e-17
C28 (\7\:n0 VSS) capacitor c=9.63503e-17
C29 (\19\:VDD VSS) capacitor c=3.81592e-17
C30 (\10\:S0b VSS) capacitor c=8.85201e-17
C31 (\3\:VDD VSS) capacitor c=5.1227e-17
C32 (\25\:n1 VSS) capacitor c=3.78545e-17
C33 (\10\:n0 VSS) capacitor c=4.20241e-17
C34 (\8\:S0b VSS) capacitor c=3.19633e-17
C35 (\4\:A VSS) capacitor c=5.68875e-17
C36 (\7\:S0 VSS) capacitor c=8.78803e-17
C37 (\5\:S0b VSS) capacitor c=6.56721e-17
C38 (\6\:S0b VSS) capacitor c=1.14789e-16
C39 (\7\:S0b VSS) capacitor c=8.60401e-17
C40 (\4\:B VSS) capacitor c=1.04842e-16
C41 (\9\:n0 VSS) capacitor c=1.42642e-16
C42 (\12\:n0 VSS) capacitor c=4.72608e-17
C43 (\23\:n1 VSS) capacitor c=2.27074e-17
C44 (\24\:n1 VSS) capacitor c=5.46801e-17
C45 (\10\:VDD VSS) capacitor c=2.40327e-17
Rk8 (\4\:B B) resistor r=0.002995 c=0
Rk3 (\8\:S0 S0) resistor r=0.002702 c=0
Rk2 (\7\:S0 \8\:S0) resistor r=0.4715 c=0
Rk32 (\1\:VDD \9\:VDD) resistor r=0.1126 c=0
Rk34 (\10\:VDD VDD) resistor r=0.18 c=0
Rk33 (\9\:VDD \10\:VDD) resistor r=0.3707 c=0
Rk39 (\10\:VDD \20\:VDD) resistor r=0.2141 c=0
Rk1 (\4\:A A) resistor r=0.04728 c=0
Rk45 (\1\:VSS \9\:VSS) resistor r=0.08251 c=0
Rk47 (\10\:VSS VSS) resistor r=0.18 c=0
Rk46 (\9\:VSS \10\:VSS) resistor r=0.3707 c=0
Rk52 (\10\:VSS \20\:VSS) resistor r=0.2008 c=0
Rk4 (\5\:S0b \6\:S0b) resistor r=0.3979 c=0
Rk5 (\6\:S0b \7\:S0b) resistor r=0.5535 c=0
Rk6 (\7\:S0b \9\:S0b) resistor r=0.2007 c=0
Rk7 (\7\:S0b \11\:S0b) resistor r=0.6499 c=0
Rk9 (\8\:n0 \9\:n0) resistor r=0.7092 c=0
Rk10 (\9\:n0 \11\:n0) resistor r=0.3288 c=0
Rk11 (\9\:n0 \12\:n0) resistor r=0.2772 c=0
Rk12 (\23\:n1 \24\:n1) resistor r=0.1007 c=0
Rk13 (\24\:n1 \26\:n1) resistor r=0.2117 c=0
Rk14 (\24\:n1 \28\:n1) resistor r=0.4765 c=0
Rl9 (\1\:B \2\:B) resistor r=125.692 c=0
Rl10 (\2\:B \3\:B) resistor r=156.461 c=0
Rl7 (\5\:S0 \6\:S0) resistor r=92.1028 c=0
Rl6 (\4\:S0 \5\:S0) resistor r=221.131 c=0
Rl1 (\1\:S0 \2\:S0) resistor r=48.7687 c=0
Rl2 (\2\:S0 \3\:S0) resistor r=233.384 c=0
Rl3 (\1\:A \2\:A) resistor r=181.461 c=0
Rl4 (\2\:A \3\:A) resistor r=100.692 c=0
Rl8 (\3\:S0b \4\:S0b) resistor r=56.461 c=0
Rl5 (S0b \2\:S0b) resistor r=85.3072 c=0
Rl23 (n1 \9\:n1) resistor r=9.5287 c=0
Rz8 (\1\:VDD \3\:VDD) resistor r=12.5 c=0
Rz9 (\9\:VDD \3\:VDD) resistor r=6.25 c=0
Rz15 (\20\:VSS \19\:VSS) resistor r=75 c=0
Rz1 (\8\:S0b \9\:S0b) resistor r=75 c=0
Rz2 (\11\:n0 \10\:n0) resistor r=75 c=0
Rz3 (\26\:n1 \25\:n1) resistor r=75 c=0
Ry13 (\20\:VDD \19\:VDD) resistor r=62 c=0
Ry14 (\1\:VSS \3\:VSS) resistor r=10.3333 c=0
Ry15 (\9\:VSS \3\:VSS) resistor r=5.1667 c=0
Ry1 (\10\:S0b \11\:S0b) resistor r=62 c=0
Ry2 (\8\:n0 \7\:n0) resistor r=62 c=0
Ry3 (\28\:n1 \27\:n1) resistor r=20.6667 c=0
Rx6 (\2\:B \4\:B) resistor r=45 c=0
Rx2 (\5\:S0 \7\:S0) resistor r=45 c=0
Rx3 (\2\:S0 \8\:S0) resistor r=45 c=0
Rx1 (\2\:A \4\:A) resistor r=45 c=0
Rx4 (\4\:S0b \5\:S0b) resistor r=45 c=0
Rx5 (\2\:S0b \6\:S0b) resistor r=45 c=0
Rx7 (\12\:n0 n0) resistor r=45 c=0
Rx8 (\23\:n1 \9\:n1) resistor r=45 c=0
mn0 (\8\:S0b \3\:S0 \19\:VSS VSS) g45n1lvt w=(1.45e-07) l=4.5e-08 nf=1 \
        as=2.32e-14 ad=2.03e-14 ps=6.1e-07 pd=5.7e-07 nrd=1.16667 \
        nrs=1.16667 sa=1.4e-07 sb=2e-06 sd=160n sca=7.18188 scb=0.00417289 \
        scc=4.04165e-05 m=(1)
mn1 (n3 \3\:A \19\:VSS VSS) g45n1lvt w=(1.45e-07) l=4.5e-08 nf=1 \
        as=2.32e-14 ad=2.247e-14 ps=6.1e-07 pd=6e-07 nrd=1.16667 \
        nrs=1.16667 sa=3.45e-07 sb=2e-06 sd=160n sca=7.18188 \
        scb=0.00417289 scc=4.04165e-05 m=(1)
mn2 (\10\:n0 S0b n3 VSS) g45n1lvt w=(1.45e-07) l=4.5e-08 nf=1 \
        as=2.247e-14 ad=2.32e-14 ps=6e-07 pd=6.1e-07 nrd=1.16667 \
        nrs=1.16667 sa=5.45e-07 sb=2e-06 sd=160n sca=7.18188 \
        scb=0.00417289 scc=4.04165e-05 m=(1)
mn4 (\10\:n0 \4\:S0 n5 VSS) g45n1lvt w=(1.45e-07) l=4.5e-08 nf=1 \
        as=3.625e-14 ad=2.32e-14 ps=7.9e-07 pd=6.1e-07 nrd=1.16667 \
        nrs=1.16667 sa=7.5e-07 sb=2e-06 sd=160n sca=7.18188 scb=0.00417289 \
        scc=4.04165e-05 m=(1)
mn3 (n5 \3\:B \1\:VSS VSS) g45n1lvt w=(1.45e-07) l=4.5e-08 nf=1 \
        as=4.34e-14 ad=3.625e-14 ps=9.6e-07 pd=7.9e-07 nrd=1.16667 \
        nrs=1.16667 sa=1.045e-06 sb=2e-06 sd=160n sca=7.18188 \
        scb=0.00417289 scc=4.04165e-05 m=(1)
mn5 (\25\:n1 n0 \1\:VSS VSS) g45n1lvt w=(2.6e-07) l=4.5e-08 nf=1 \
        as=5.075e-14 ad=4.16e-14 ps=9.85e-07 pd=8.4e-07 nrd=1.16667 \
        nrs=1.16667 sa=7.74808e-07 sb=1.83e-06 sd=160n sca=8.81533 \
        scb=0.00706435 scc=0.000179997 m=(2)
mn6_1__rcx (Y n1 \1\:VSS VSS) g45n1lvt w=(2.95e-07) l=4.5e-08 nf=1 \
        as=4.876e-14 ad=4.636e-14 ps=9.2429e-07 pd=9.0429e-07 nrd=1.16667 \
        nrs=1.16667 sa=1.10017e-06 sb=1.37e-06 sd=160n sca=8.43155 \
        scb=0.00645789 scc=0.000159377 m=(7)
mp5_1__rcx (\27\:n1 n0 \1\:VDD VDD) g45p1lvt w=(3.9e-07) l=4.5e-08 nf=1 \
        as=7.96e-14 ad=6.24e-14 ps=1.265e-06 pd=1.1e-06 nrd=1.16667 \
        nrs=1.16667 sa=7.85e-07 sb=1.83e-06 sd=160n sca=12.7076 \
        scb=0.0112318 scc=0.000478212 m=(2)
mp6_1__rcx (Y n1 \1\:VDD VDD) g45p1lvt w=(4.45e-07) l=4.5e-08 nf=1 \
        as=7.351e-14 ad=6.993e-14 ps=1.22429e-06 pd=1.20429e-06 \
        nrd=1.16667 nrs=1.16667 sa=1.10348e-06 sb=1.37e-06 sd=160n \
        sca=15.1493 scb=0.013431 scc=0.000976912 m=(7)
ends MXI2X8
// End of subcircuit definition.
