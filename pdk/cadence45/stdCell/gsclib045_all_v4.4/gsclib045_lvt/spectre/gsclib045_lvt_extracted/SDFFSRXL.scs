// Generated for: spectre (May  1 09:15:08 2013 )
// Library name: gsclib045_lvt
// Cell name: SDFFSRXL
// View name: extracted

simulator lang=spectre

subckt SDFFSRXL CK D Q QN RN SE SI SN VDD VSS
mp57 (\1\:QN net573 \29\:VDD VDD) g45p1lvt w=(2.15e-07) l=4.5e-08 nf=1 \
        as=3.44e-14 ad=3.01e-14 ps=7.5e-07 pd=7.1e-07 nrd=1.16667 \
        nrs=1.16667 sa=1.4e-07 sb=3.45e-07 sd=160n sca=49.954 \
        scb=0.0336165 scc=0.00594928 m=(1)
mp56 (\4\:net573 \6\:qbint \29\:VDD VDD) g45p1lvt w=(2.15e-07) l=4.5e-08 \
        nf=1 as=3.44e-14 ad=3.01e-14 ps=7.5e-07 pd=7.1e-07 nrd=1.16667 \
        nrs=1.16667 sa=3.45e-07 sb=1.4e-07 sd=160n sca=47.2218 \
        scb=0.0292973 scc=0.00588575 m=(1)
mp55 (\1\:Q qbint \26\:VDD VDD) g45p1lvt w=(2.15e-07) l=4.5e-08 nf=1 \
        as=3.44e-14 ad=4.3e-14 ps=7.5e-07 pd=8.3e-07 nrd=1.16667 \
        nrs=1.16667 sa=2e-07 sb=3.45e-07 sd=160n sca=10.9013 \
        scb=0.00874909 scc=0.000160703 m=(1)
mp22 (\10\:RNb \3\:RN \26\:VDD VDD) g45p1lvt w=(2.15e-07) l=4.5e-08 nf=1 \
        as=3.44e-14 ad=3.01e-14 ps=7.5e-07 pd=7.1e-07 nrd=1.16667 \
        nrs=1.16667 sa=4.05e-07 sb=1.4e-07 sd=160n sca=10.9013 \
        scb=0.00874909 scc=0.000160703 m=(1)
mp45 (\15\:qbint n35 \23\:VDD VDD) g45p1lvt w=(2.15e-07) l=4.5e-08 nf=1 \
        as=9.89e-14 ad=3.01e-14 ps=1.73e-06 pd=7.1e-07 nrd=1.16667 \
        nrs=1.16667 sa=1.4e-07 sb=8.4e-07 sd=160n sca=19.7413 scb=0.019281 \
        scc=0.00179464 m=(1)
mp50 (\3\:n11 \1\:SN \23\:VDD VDD) g45p1lvt w=(2.15e-07) l=4.5e-08 nf=1 \
        as=9.89e-14 ad=3.44e-14 ps=1.73e-06 pd=7.5e-07 nrd=1.16667 \
        nrs=1.16667 sa=4.05e-07 sb=5.75e-07 sd=160n sca=19.7413 \
        scb=0.019281 scc=0.00179464 m=(1)
mp52 (\3\:n11 \7\:qbint n9 VDD) g45p1lvt w=(2.15e-07) l=4.5e-08 nf=1 \
        as=1.29e-14 ad=3.44e-14 ps=5.5e-07 pd=7.5e-07 nrd=1.16667 \
        nrs=1.16667 sa=6.1e-07 sb=3.7e-07 sd=160n sca=19.7413 scb=0.019281 \
        scc=0.00179464 m=(1)
mp51 (n9 \2\:RNb \20\:VDD VDD) g45p1lvt w=(2.15e-07) l=4.5e-08 nf=1 \
        as=1.0857e-13 ad=1.29e-14 ps=1.82e-06 pd=5.5e-07 nrd=1.16667 \
        nrs=1.16667 sa=7.15e-07 sb=2.65e-07 sd=160n sca=19.7413 \
        scb=0.019281 scc=0.00179464 m=(1)
mp53 (\8\:n35 \5\:CKbb n11 VDD) g45p1lvt w=(2.15e-07) l=4.5e-08 nf=1 \
        as=6.987e-14 ad=3.762e-14 ps=1.08e-06 pd=7.8e-07 nrd=1.16667 \
        nrs=1.16667 sa=3.25e-07 sb=3.6e-07 sd=160n sca=19.7413 \
        scb=0.019281 scc=0.00179464 m=(1)
mp40 (\8\:n35 \5\:CKb \8\:mout VDD) g45p1lvt w=(2.15e-07) l=4.5e-08 nf=1 \
        as=3.01e-14 ad=3.762e-14 ps=7.1e-07 pd=7.8e-07 nrd=1.16667 \
        nrs=1.16667 sa=5.45e-07 sb=1.4e-07 sd=160n sca=19.7413 \
        scb=0.019281 scc=0.00179464 m=(1)
mp31 (n5 \4\:RNb \17\:VDD VDD) g45p1lvt w=(2.15e-07) l=4.5e-08 nf=1 \
        as=1.0383e-13 ad=3.977e-14 ps=2.11e-06 pd=8e-07 nrd=1.16667 \
        nrs=1.16667 sa=3.45e-07 sb=1.03558e-06 sd=160n sca=19.0975 \
        scb=0.0187686 scc=0.00166224 m=(1)
mp32 (\10\:mout \4\:n20 n5 VDD) g45p1lvt w=(2.15e-07) l=4.5e-08 nf=1 \
        as=3.977e-14 ad=3.44e-14 ps=8e-07 pd=7.5e-07 nrd=1.16667 \
        nrs=1.16667 sa=5.75e-07 sb=8.05581e-07 sd=160n sca=19.0975 \
        scb=0.0187686 scc=0.00166224 m=(1)
mp30 (\10\:mout \4\:SN \15\:VDD VDD) g45p1lvt w=(2.15e-07) l=4.5e-08 \
        nf=1 as=9.55e-14 ad=3.44e-14 ps=1.72e-06 pd=7.5e-07 nrd=1.16667 \
        nrs=1.16667 sa=7.8e-07 sb=6.00581e-07 sd=160n sca=19.0975 \
        scb=0.0187686 scc=0.00166224 m=(1)
mp35 (n7 mout \15\:VDD VDD) g45p1lvt w=(2.15e-07) l=4.5e-08 nf=1 \
        as=9.55e-14 ad=1.29e-14 ps=1.72e-06 pd=5.5e-07 nrd=1.16667 \
        nrs=1.16667 sa=8.82209e-07 sb=4.5e-07 sd=160n sca=15.2551 \
        scb=0.0150251 scc=0.000885438 m=(1)
mp36 (\9\:n20 \6\:CKb n7 VDD) g45p1lvt w=(2.15e-07) l=4.5e-08 nf=1 \
        as=1.29e-14 ad=3.44e-14 ps=5.5e-07 pd=7.5e-07 nrd=1.16667 \
        nrs=1.16667 sa=9.87209e-07 sb=3.45e-07 sd=160n sca=15.2551 \
        scb=0.0150251 scc=0.000885438 m=(1)
mp25 (\9\:n20 \6\:CKbb \8\:Db VDD) g45p1lvt w=(2.15e-07) l=4.5e-08 nf=1 \
        as=3.01e-14 ad=3.44e-14 ps=7.1e-07 pd=7.5e-07 nrd=1.16667 \
        nrs=1.16667 sa=1.19221e-06 sb=1.4e-07 sd=160n sca=15.2551 \
        scb=0.0150251 scc=0.000885438 m=(1)
mp21 (\7\:CKbb \8\:CKb \13\:VDD VDD) g45p1lvt w=(2.15e-07) l=4.5e-08 \
        nf=1 as=6.835e-14 ad=3.01e-14 ps=1.3e-06 pd=7.1e-07 nrd=1.16667 \
        nrs=1.16667 sa=1.4e-07 sb=1.7e-07 sd=160n sca=24.8095 \
        scb=0.0224988 scc=0.00280688 m=(1)
mp20 (\21\:CKb \1\:CK \11\:VDD VDD) g45p1lvt w=(2.15e-07) l=4.5e-08 nf=1 \
        as=3.44e-14 ad=3.01e-14 ps=7.5e-07 pd=7.1e-07 nrd=1.16667 \
        nrs=1.16667 sa=1.4e-07 sb=1.155e-06 sd=160n sca=10.6366 \
        scb=0.00827102 scc=0.000128406 m=(1)
mp11 (n1 \1\:D \11\:VDD VDD) g45p1lvt w=(2.15e-07) l=4.5e-08 nf=1 \
        as=3.44e-14 ad=4.515e-14 ps=7.5e-07 pd=8.5e-07 nrd=1.16667 \
        nrs=1.16667 sa=3.45e-07 sb=9.5e-07 sd=160n sca=10.6366 \
        scb=0.00827102 scc=0.000128406 m=(1)
mp12 (\6\:Db \1\:SE n1 VDD) g45p1lvt w=(2.15e-07) l=4.5e-08 nf=1 \
        as=4.515e-14 ad=3.655e-14 ps=8.5e-07 pd=7.7e-07 nrd=1.16667 \
        nrs=1.16667 sa=6e-07 sb=6.95e-07 sd=160n sca=10.8061 \
        scb=0.00831024 scc=0.000128411 m=(1)
mp14 (\6\:Db SEb n3 VDD) g45p1lvt w=(2.15e-07) l=4.5e-08 nf=1 \
        as=1.935e-14 ad=3.655e-14 ps=6.1e-07 pd=7.7e-07 nrd=1.16667 \
        nrs=1.16667 sa=8.15e-07 sb=4.8e-07 sd=160n sca=11.5709 \
        scb=0.00874068 scc=0.000128764 m=(1)
mp13 (n3 \1\:SI \9\:VDD VDD) g45p1lvt w=(2.15e-07) l=4.5e-08 nf=1 \
        as=3.44e-14 ad=1.935e-14 ps=7.5e-07 pd=6.1e-07 nrd=1.16667 \
        nrs=1.16667 sa=9.5e-07 sb=3.45e-07 sd=160n sca=12.5323 \
        scb=0.0098256 scc=0.000132754 m=(1)
mp10 (\4\:SEb \5\:SE \9\:VDD VDD) g45p1lvt w=(2.15e-07) l=4.5e-08 nf=1 \
        as=3.44e-14 ad=3.01e-14 ps=7.5e-07 pd=7.1e-07 nrd=1.16667 \
        nrs=1.16667 sa=1.155e-06 sb=1.4e-07 sd=160n sca=16.3619 \
        scb=0.0163088 scc=0.000299525 m=(1)
C1 (QN VSS) capacitor c=1.78862e-17
C2 (CK VSS) capacitor c=6.76016e-17
C3 (SN VSS) capacitor c=3.01394e-16
C4 (SI VSS) capacitor c=9.05018e-17
C5 (VDD VSS) capacitor c=5.18142e-16
C6 (RN VSS) capacitor c=1.34753e-16
C7 (D VSS) capacitor c=3.0396e-17
C8 (Q VSS) capacitor c=4.6388e-17
C9 (net573 VSS) capacitor c=3.02467e-17
C10 (qbint VSS) capacitor c=4.6896e-17
C11 (RNb VSS) capacitor c=5.32295e-17
C12 (n35 VSS) capacitor c=4.42777e-17
C13 (n8 VSS) capacitor c=9.43719e-17
C14 (n10 VSS) capacitor c=7.13756e-17
C15 (CKb VSS) capacitor c=4.45034e-17
C16 (mout VSS) capacitor c=6.38945e-17
C17 (CKbb VSS) capacitor c=4.15633e-17
C18 (n4 VSS) capacitor c=7.06836e-17
C19 (n20 VSS) capacitor c=2.58566e-17
C20 (Db VSS) capacitor c=5.38274e-17
C21 (n0 VSS) capacitor c=5.49257e-18
C22 (SEb VSS) capacitor c=4.48508e-17
C23 (n11 VSS) capacitor c=1.17713e-16
C24 (n9 VSS) capacitor c=1.57439e-18
C25 (n5 VSS) capacitor c=2.74777e-18
C26 (n1 VSS) capacitor c=5.46877e-18
C27 (\5\:SE VSS) capacitor c=5.13366e-17
C28 (\1\:SI VSS) capacitor c=6.08635e-17
C29 (\1\:SE VSS) capacitor c=4.46046e-17
C30 (\1\:D VSS) capacitor c=4.4469e-17
C31 (\1\:CK VSS) capacitor c=2.64647e-17
C32 (\8\:CKb VSS) capacitor c=2.2591e-17
C33 (\6\:CKbb VSS) capacitor c=3.89638e-17
C34 (\6\:CKb VSS) capacitor c=6.99494e-17
C35 (\4\:SN VSS) capacitor c=5.25137e-17
C36 (\4\:n20 VSS) capacitor c=5.38014e-17
C37 (\4\:RNb VSS) capacitor c=6.67384e-17
C38 (\5\:CKb VSS) capacitor c=3.60709e-17
C39 (\5\:CKbb VSS) capacitor c=7.4193e-17
C40 (\2\:RNb VSS) capacitor c=8.82675e-17
C41 (\7\:qbint VSS) capacitor c=9.49651e-17
C42 (\1\:SN VSS) capacitor c=4.2763e-17
C43 (\3\:RN VSS) capacitor c=3.25423e-17
C44 (\6\:qbint VSS) capacitor c=2.70518e-17
C45 (\7\:SE VSS) capacitor c=2.76376e-17
C46 (\3\:SI VSS) capacitor c=6.83593e-17
C47 (\3\:SE VSS) capacitor c=6.73081e-17
C48 (\3\:SEb VSS) capacitor c=7.34901e-17
C49 (\3\:D VSS) capacitor c=4.19081e-17
C50 (\3\:CK VSS) capacitor c=4.82426e-17
C51 (\11\:CKb VSS) capacitor c=2.34647e-17
C52 (\10\:CKb VSS) capacitor c=5.45941e-17
C53 (\3\:CKbb VSS) capacitor c=1.63653e-16
C54 (\3\:mout VSS) capacitor c=6.71347e-17
C55 (\6\:SN VSS) capacitor c=7.34685e-17
C56 (\3\:n20 VSS) capacitor c=3.88531e-17
C57 (\6\:RNb VSS) capacitor c=4.90845e-17
C58 (\4\:CKbb VSS) capacitor c=1.06372e-16
C59 (\8\:qbint VSS) capacitor c=4.55797e-17
C60 (\3\:SN VSS) capacitor c=5.97268e-17
C61 (\3\:n35 VSS) capacitor c=3.27737e-17
C62 (\1\:RN VSS) capacitor c=4.45942e-17
C63 (\5\:qbint VSS) capacitor c=1.67095e-17
C64 (\4\:qbint VSS) capacitor c=3.52581e-17
C65 (\3\:net573 VSS) capacitor c=3.84588e-17
C66 (\6\:SE VSS) capacitor c=4.49727e-17
C67 (\2\:SI VSS) capacitor c=6.60001e-17
C68 (\4\:SE VSS) capacitor c=4.93053e-17
C69 (\2\:SEb VSS) capacitor c=7.54387e-17
C70 (\2\:SE VSS) capacitor c=4.54464e-17
C71 (\2\:D VSS) capacitor c=4.54149e-17
C72 (\2\:CK VSS) capacitor c=3.58351e-17
C73 (\9\:CKb VSS) capacitor c=4.4452e-17
C74 (\7\:CKb VSS) capacitor c=2.90574e-17
C75 (\2\:mout VSS) capacitor c=5.54167e-17
C76 (\5\:SN VSS) capacitor c=3.28352e-17
C77 (\3\:CKb VSS) capacitor c=3.79305e-17
C78 (\5\:RNb VSS) capacitor c=2.18917e-17
C79 (\4\:CKb VSS) capacitor c=3.64278e-17
C80 (\2\:CKb VSS) capacitor c=3.3476e-17
C81 (\3\:RNb VSS) capacitor c=2.53533e-17
C82 (\9\:qbint VSS) capacitor c=2.75482e-17
C83 (\2\:SN VSS) capacitor c=4.07021e-17
C84 (\2\:n35 VSS) capacitor c=2.7325e-17
C85 (\2\:RN VSS) capacitor c=3.70964e-17
C86 (\2\:qbint VSS) capacitor c=3.98325e-17
C87 (\2\:net573 VSS) capacitor c=2.82053e-17
C88 (\4\:SEb VSS) capacitor c=1.21994e-17
C89 (\9\:VDD VSS) capacitor c=3.34885e-17
C90 (\6\:Db VSS) capacitor c=9.24599e-17
C91 (\11\:VDD VSS) capacitor c=4.17829e-17
C92 (\21\:CKb VSS) capacitor c=6.99786e-17
C93 (\13\:VDD VSS) capacitor c=3.80007e-17
C94 (\7\:CKbb VSS) capacitor c=4.99911e-17
C95 (\8\:Db VSS) capacitor c=8.11227e-17
C96 (\9\:n20 VSS) capacitor c=4.57607e-17
C97 (\15\:VDD VSS) capacitor c=1.3735e-17
C98 (\10\:mout VSS) capacitor c=3.62816e-17
C99 (\17\:VDD VSS) capacitor c=2.41136e-17
C100 (\8\:mout VSS) capacitor c=7.27074e-17
C101 (\8\:n35 VSS) capacitor c=4.8242e-17
C102 (\20\:VDD VSS) capacitor c=2.4503e-17
C103 (\3\:n11 VSS) capacitor c=1.10446e-16
C104 (\23\:VDD VSS) capacitor c=1.24221e-17
C105 (\15\:qbint VSS) capacitor c=5.86906e-17
C106 (\10\:RNb VSS) capacitor c=3.25075e-17
C107 (\26\:VDD VSS) capacitor c=3.19539e-17
C108 (\1\:Q VSS) capacitor c=6.11596e-17
C109 (\4\:net573 VSS) capacitor c=3.0512e-17
C110 (\29\:VDD VSS) capacitor c=3.72838e-17
C111 (\1\:QN VSS) capacitor c=2.83577e-17
C112 (\1\:VDD VSS) capacitor c=1.09541e-16
C113 (\8\:SEb VSS) capacitor c=7.05458e-17
C114 (\14\:CKb VSS) capacitor c=4.60253e-17
C115 (\10\:CKbb VSS) capacitor c=6.00262e-17
C116 (\4\:Db VSS) capacitor c=1.75685e-16
C117 (\5\:n20 VSS) capacitor c=2.64333e-17
C118 (\12\:mout VSS) capacitor c=3.04683e-17
C119 (\3\:n4 VSS) capacitor c=7.69115e-17
C120 (\14\:mout VSS) capacitor c=4.4623e-17
C121 (\4\:n35 VSS) capacitor c=4.13101e-17
C122 (\3\:n8 VSS) capacitor c=8.17739e-17
C123 (\3\:n10 VSS) capacitor c=8.46242e-17
C124 (\12\:qbint VSS) capacitor c=4.98633e-17
C125 (\12\:RNb VSS) capacitor c=8.85207e-17
C126 (\3\:Q VSS) capacitor c=3.80042e-17
C127 (\8\:net573 VSS) capacitor c=3.17542e-17
C128 (\4\:QN VSS) capacitor c=2.07436e-17
C129 (\3\:qbint VSS) capacitor c=3.38382e-17
C130 (\2\:n20 VSS) capacitor c=2.46342e-17
C131 (\3\:QN VSS) capacitor c=3.49599e-17
C132 (\2\:CKbb VSS) capacitor c=4.35372e-17
C133 (\6\:net573 VSS) capacitor c=3.79287e-17
C134 (\7\:net573 VSS) capacitor c=3.00838e-17
C135 (\10\:qbint VSS) capacitor c=6.22136e-17
C136 (\11\:qbint VSS) capacitor c=9.92114e-17
C137 (\14\:qbint VSS) capacitor c=1.26251e-16
C138 (\6\:n35 VSS) capacitor c=1.71618e-16
C139 (\7\:n35 VSS) capacitor c=1.54363e-16
C140 (\12\:CKb VSS) capacitor c=1.13224e-16
C141 (\13\:CKb VSS) capacitor c=6.34978e-17
C142 (\7\:RNb VSS) capacitor c=1.44453e-16
C143 (\8\:RNb VSS) capacitor c=2.19415e-16
C144 (\9\:RNb VSS) capacitor c=1.07891e-16
C145 (\7\:SN VSS) capacitor c=2.61365e-16
C146 (\8\:SN VSS) capacitor c=2.99462e-17
C147 (\4\:mout VSS) capacitor c=4.49264e-17
C148 (\5\:mout VSS) capacitor c=4.93374e-17
C149 (\6\:mout VSS) capacitor c=5.97245e-17
C150 (\7\:mout VSS) capacitor c=5.55689e-17
C151 (\7\:n20 VSS) capacitor c=5.64323e-17
C152 (\8\:n20 VSS) capacitor c=8.54522e-17
C153 (\9\:CKbb VSS) capacitor c=4.54232e-17
C154 (\16\:CKb VSS) capacitor c=4.54004e-17
C155 (\17\:CKb VSS) capacitor c=1.23411e-16
C156 (\18\:CKb VSS) capacitor c=1.51904e-16
C157 (\19\:CKb VSS) capacitor c=1.51284e-16
C158 (\20\:CKb VSS) capacitor c=2.29076e-17
C159 (\23\:CKb VSS) capacitor c=1.92389e-17
C160 (\4\:CK VSS) capacitor c=5.09082e-17
C161 (\4\:D VSS) capacitor c=8.56648e-17
C162 (\3\:Db VSS) capacitor c=2.08452e-16
C163 (\8\:SE VSS) capacitor c=7.82859e-17
C164 (\9\:SE VSS) capacitor c=5.10941e-17
C165 (\10\:SE VSS) capacitor c=6.56771e-17
C166 (\6\:SEb VSS) capacitor c=7.98095e-17
C167 (\7\:SEb VSS) capacitor c=5.89282e-17
C168 (\3\:VDD VSS) capacitor c=2.15558e-17
C169 (\4\:VDD VSS) capacitor c=2.1004e-17
C170 (\6\:VDD VSS) capacitor c=2.57372e-17
C171 (\7\:VDD VSS) capacitor c=6.33097e-17
C172 (\19\:VDD VSS) capacitor c=3.56798e-17
C173 (\22\:VDD VSS) capacitor c=2.93587e-17
C174 (\28\:VDD VSS) capacitor c=1.17986e-17
Rk2 (\3\:QN QN) resistor r=0.02903 c=0
Rk1 (\2\:QN \3\:QN) resistor r=0.2 c=0
Rk3 (\3\:QN \5\:QN) resistor r=0.1282 c=0
Rk47 (\4\:CK CK) resistor r=0.1889 c=0
Rk55 (\8\:SE SE) resistor r=0.2644 c=0
Rk54 (\8\:SE \9\:SE) resistor r=0.3108 c=0
Rk56 (SE \10\:SE) resistor r=0.002257 c=0
Rk26 (\7\:SN SN) resistor r=1.978 c=0
Rk27 (SN \8\:SN) resistor r=0.09842 c=0
Rk53 (\4\:SI SI) resistor r=0.001898 c=0
Rk60 (\2\:VDD \3\:VDD) resistor r=0.1152 c=0
Rk61 (\3\:VDD \4\:VDD) resistor r=0.4209 c=0
Rk62 (\4\:VDD \5\:VDD) resistor r=0.1653 c=0
Rk63 (\5\:VDD \6\:VDD) resistor r=0.1929 c=0
Rk64 (\6\:VDD \7\:VDD) resistor r=0.5012 c=0
Rk65 (\7\:VDD \8\:VDD) resistor r=0.5101 c=0
Rk66 (\3\:VDD \10\:VDD) resistor r=0.251 c=0
Rk67 (\4\:VDD \12\:VDD) resistor r=0.2463 c=0
Rk68 (\6\:VDD \14\:VDD) resistor r=0.1999 c=0
Rk69 (\7\:VDD \16\:VDD) resistor r=0.07393 c=0
Rk70 (\8\:VDD \18\:VDD) resistor r=0.07147 c=0
Rk71 (\8\:VDD \19\:VDD) resistor r=0.4813 c=0
Rk72 (\19\:VDD \21\:VDD) resistor r=0.1026 c=0
Rk73 (\19\:VDD \22\:VDD) resistor r=0.3206 c=0
Rk74 (\22\:VDD \24\:VDD) resistor r=0.07393 c=0
Rk75 (\22\:VDD \25\:VDD) resistor r=0.4011 c=0
Rk76 (\25\:VDD \27\:VDD) resistor r=0.3119 c=0
Rk79 (\28\:VDD VDD) resistor r=0.1927 c=0
Rk77 (\25\:VDD \28\:VDD) resistor r=0.359 c=0
Rk78 (\28\:VDD \30\:VDD) resistor r=0.4181 c=0
Rk9 (\4\:RN RN) resistor r=0.003663 c=0
Rk48 (D \4\:D) resistor r=0.0781 c=0
Rk7 (\2\:Q Q) resistor r=0.3967 c=0
Rk8 (Q \4\:Q) resistor r=0.04807 c=0
Rk80 (\2\:VSS \3\:VSS) resistor r=0.1152 c=0
Rk81 (\3\:VSS \4\:VSS) resistor r=0.4059 c=0
Rk82 (\4\:VSS \5\:VSS) resistor r=0.1804 c=0
Rk83 (\5\:VSS \6\:VSS) resistor r=0.2095 c=0
Rk84 (\6\:VSS \7\:VSS) resistor r=0.4977 c=0
Rk85 (\7\:VSS \8\:VSS) resistor r=0.4938 c=0
Rk86 (\8\:VSS \9\:VSS) resistor r=0.8014 c=0
Rk87 (\9\:VSS \10\:VSS) resistor r=0.4001 c=0
Rk88 (\3\:VSS \12\:VSS) resistor r=0.2896 c=0
Rk89 (\4\:VSS \14\:VSS) resistor r=0.2196 c=0
Rk90 (\6\:VSS \16\:VSS) resistor r=0.04331 c=0
Rk91 (\7\:VSS \18\:VSS) resistor r=0.3557 c=0
Rk92 (\9\:VSS \20\:VSS) resistor r=0.04331 c=0
Rk94 (\21\:VSS VSS) resistor r=0.2077 c=0
Rk93 (\10\:VSS \21\:VSS) resistor r=0.3439 c=0
Rk95 (\10\:VSS \23\:VSS) resistor r=0.4377 c=0
Rk96 (\21\:VSS \25\:VSS) resistor r=0.07393 c=0
Rk4 (\5\:net573 \6\:net573) resistor r=0.1238 c=0
Rk5 (\6\:net573 \7\:net573) resistor r=0.1344 c=0
Rk6 (\6\:net573 \9\:net573) resistor r=0.1959 c=0
Rk10 (\10\:qbint \11\:qbint) resistor r=0.368 c=0
Rk11 (\11\:qbint \13\:qbint) resistor r=0.09138 c=0
Rk12 (\11\:qbint \14\:qbint) resistor r=0.8183 c=0
Rk13 (\13\:qbint \16\:qbint) resistor r=0.4607 c=0
Rk21 (\7\:RNb \8\:RNb) resistor r=1.0519 c=0
Rk22 (\8\:RNb \9\:RNb) resistor r=0.6756 c=0
Rk23 (\9\:RNb \11\:RNb) resistor r=0.07287 c=0
Rk24 (\9\:RNb \13\:RNb) resistor r=0.4963 c=0
Rk17 (\5\:n35 \6\:n35) resistor r=0.1803 c=0
Rk18 (\6\:n35 \7\:n35) resistor r=1.1324 c=0
Rk19 (\6\:n35 \9\:n35) resistor r=0.1634 c=0
Rk14 (\2\:n8 \4\:n8) resistor r=0.6111 c=0
Rk16 (\2\:n10 \4\:n10) resistor r=0.301 c=0
Rk20 (\12\:CKb \13\:CKb) resistor r=0.6571 c=0
Rk40 (\15\:CKb \16\:CKb) resistor r=0.3345 c=0
Rk41 (\16\:CKb \17\:CKb) resistor r=0.3365 c=0
Rk42 (\17\:CKb \18\:CKb) resistor r=0.6509 c=0
Rk43 (\18\:CKb \19\:CKb) resistor r=1.0248 c=0
Rk44 (\16\:CKb \20\:CKb) resistor r=0.08669 c=0
Rk45 (\17\:CKb \22\:CKb) resistor r=0.3751 c=0
Rk46 (\18\:CKb \23\:CKb) resistor r=0.02283 c=0
Rk28 (\4\:mout \5\:mout) resistor r=0.2592 c=0
Rk29 (\5\:mout \6\:mout) resistor r=0.2896 c=0
Rk30 (\6\:mout \7\:mout) resistor r=0.3064 c=0
Rk31 (\7\:mout \9\:mout) resistor r=0.3617 c=0
Rk32 (\5\:mout \11\:mout) resistor r=0.08669 c=0
Rk33 (\6\:mout \13\:mout) resistor r=0.1031 c=0
Rk34 (\7\:mout \15\:mout) resistor r=0.16 c=0
Rk38 (\8\:CKbb \9\:CKbb) resistor r=0.1237 c=0
Rk39 (\9\:CKbb \11\:CKbb) resistor r=0.183 c=0
Rk25 (\2\:n4 \4\:n4) resistor r=0.4889 c=0
Rk35 (\6\:n20 \7\:n20) resistor r=0.1311 c=0
Rk36 (\7\:n20 \8\:n20) resistor r=0.4162 c=0
Rk37 (\7\:n20 \10\:n20) resistor r=0.269 c=0
Rk49 (\2\:Db \3\:Db) resistor r=0.2394 c=0
Rk50 (\3\:Db \5\:Db) resistor r=1.2106 c=0
Rk51 (\3\:Db \7\:Db) resistor r=0.6628 c=0
Rk52 (\5\:Db \9\:Db) resistor r=0.4296 c=0
Rk57 (\5\:SEb \6\:SEb) resistor r=0.04795 c=0
Rk58 (\6\:SEb \7\:SEb) resistor r=0.3966 c=0
Rk59 (\6\:SEb \9\:SEb) resistor r=0.614 c=0
Rk15 (\2\:n11 \4\:n11) resistor r=0.4173 c=0
Rl39 (\1\:CK \2\:CK) resistor r=30.1196 c=0
Rl40 (\2\:CK \3\:CK) resistor r=134.41 c=0
Rl49 (\5\:SE \6\:SE) resistor r=176.156 c=0
Rl50 (\6\:SE \7\:SE) resistor r=28.079 c=0
Rl46 (\3\:SE \4\:SE) resistor r=26.098 c=0
Rl43 (\1\:SE \2\:SE) resistor r=67.9995 c=0
Rl27 (\4\:SN \6\:SN) resistor r=140.385 c=0
Rl26 (\4\:SN \5\:SN) resistor r=52.1723 c=0
Rl12 (\1\:SN \2\:SN) resistor r=33.3841 c=0
Rl13 (\2\:SN \3\:SN) resistor r=102.615 c=0
Rl47 (\1\:SI \2\:SI) resistor r=104.538 c=0
Rl48 (\2\:SI \3\:SI) resistor r=102.615 c=0
Rl9 (\2\:RN \3\:RN) resistor r=29.9451 c=0
Rl8 (\1\:RN \2\:RN) resistor r=128.846 c=0
Rl41 (\1\:D \2\:D) resistor r=91.5405 c=0
Rl42 (\2\:D \3\:D) resistor r=112.694 c=0
Rl1 (net573 \2\:net573) resistor r=35.7713 c=0
Rl2 (\2\:net573 \3\:net573) resistor r=80.0021 c=0
Rl14 (\7\:qbint \8\:qbint) resistor r=161.538 c=0
Rl15 (\8\:qbint \9\:qbint) resistor r=38.5707 c=0
Rl3 (qbint \2\:qbint) resistor r=122.872 c=0
Rl6 (\2\:qbint \5\:qbint) resistor r=24.4837 c=0
Rl7 (\3\:qbint \6\:qbint) resistor r=60.772 c=0
Rl5 (\3\:qbint \4\:qbint) resistor r=80.0028 c=0
Rl4 (\2\:qbint \3\:qbint) resistor r=175.837 c=0
Rl22 (\4\:RNb \6\:RNb) resistor r=140.385 c=0
Rl16 (RNb \2\:RNb) resistor r=264.95 c=0
Rl21 (\4\:RNb \5\:RNb) resistor r=111.052 c=0
Rl17 (\2\:RNb \3\:RNb) resistor r=43.4636 c=0
Rl10 (n35 \2\:n35) resistor r=102.615 c=0
Rl11 (\2\:n35 \3\:n35) resistor r=33.3841 c=0
Rl36 (\8\:CKb \9\:CKb) resistor r=57.4874 c=0
Rl38 (\9\:CKb \11\:CKb) resistor r=42.2956 c=0
Rl37 (\9\:CKb \10\:CKb) resistor r=184.593 c=0
Rl30 (\6\:CKb \7\:CKb) resistor r=66.5405 c=0
Rl20 (\4\:CKb \5\:CKb) resistor r=49.5131 c=0
Rl19 (\3\:CKb \4\:CKb) resistor r=117.979 c=0
Rl18 (CKb \2\:CKb) resistor r=83.8482 c=0
Rl28 (mout \2\:mout) resistor r=55.6115 c=0
Rl29 (\2\:mout \3\:mout) resistor r=89.8988 c=0
Rl34 (\4\:CKbb \5\:CKbb) resistor r=152.977 c=0
Rl33 (\3\:CKbb \4\:CKbb) resistor r=705.335 c=0
Rl35 (\2\:CKbb \6\:CKbb) resistor r=55.0028 c=0
Rl32 (\2\:CKbb \3\:CKbb) resistor r=170.415 c=0
Rl31 (CKbb \2\:CKbb) resistor r=75.3733 c=0
Rl25 (\2\:n20 \4\:n20) resistor r=95.868 c=0
Rl24 (\2\:n20 \3\:n20) resistor r=36.2526 c=0
Rl23 (n20 \2\:n20) resistor r=2.0213 c=0
Rl44 (SEb \2\:SEb) resistor r=29.5379 c=0
Rl45 (\2\:SEb \3\:SEb) resistor r=227.18 c=0
Rz1 (\4\:QN \5\:QN) resistor r=75 c=0
Rz21 (\1\:VDD \2\:VDD) resistor r=37.5 c=0
Rz22 (\1\:VDD \5\:VDD) resistor r=6.25 c=0
Rz23 (\1\:VDD \8\:VDD) resistor r=6.25 c=0
Rz24 (\1\:VDD \25\:VDD) resistor r=6.25 c=0
Rz3 (\3\:Q \4\:Q) resistor r=75 c=0
Rz25 (\11\:VSS \12\:VSS) resistor r=75 c=0
Rz26 (\13\:VSS \14\:VSS) resistor r=75 c=0
Rz27 (\15\:VSS \16\:VSS) resistor r=75 c=0
Rz28 (\17\:VSS \18\:VSS) resistor r=75 c=0
Rz29 (\19\:VSS \20\:VSS) resistor r=75 c=0
Rz30 (\22\:VSS \23\:VSS) resistor r=75 c=0
Rz31 (\24\:VSS \25\:VSS) resistor r=75 c=0
Rz2 (\8\:net573 \9\:net573) resistor r=75 c=0
Rz4 (\12\:qbint \13\:qbint) resistor r=75 c=0
Rz10 (\12\:RNb \13\:RNb) resistor r=75 c=0
Rz9 (\4\:n35 \5\:n35) resistor r=75 c=0
Rz5 (n8 \2\:n8) resistor r=75 c=0
Rz6 (\3\:n8 \4\:n8) resistor r=75 c=0
Rz7 (n10 \2\:n10) resistor r=75 c=0
Rz8 (\3\:n10 \4\:n10) resistor r=75 c=0
Rz17 (\14\:CKb \15\:CKb) resistor r=75 c=0
Rz13 (\12\:mout \13\:mout) resistor r=75 c=0
Rz14 (\14\:mout \15\:mout) resistor r=75 c=0
Rz16 (\10\:CKbb \11\:CKbb) resistor r=75 c=0
Rz11 (n4 \2\:n4) resistor r=75 c=0
Rz12 (\3\:n4 \4\:n4) resistor r=75 c=0
Rz15 (\5\:n20 \6\:n20) resistor r=75 c=0
Rz18 (Db \2\:Db) resistor r=75 c=0
Rz19 (\4\:Db \5\:Db) resistor r=75 c=0
Rz20 (\8\:SEb \9\:SEb) resistor r=75 c=0
Ry1 (\1\:QN \2\:QN) resistor r=62 c=0
Ry17 (\9\:VDD \10\:VDD) resistor r=62 c=0
Ry18 (\11\:VDD \12\:VDD) resistor r=62 c=0
Ry19 (\13\:VDD \14\:VDD) resistor r=62 c=0
Ry20 (\15\:VDD \16\:VDD) resistor r=62 c=0
Ry21 (\17\:VDD \18\:VDD) resistor r=62 c=0
Ry22 (\20\:VDD \21\:VDD) resistor r=62 c=0
Ry23 (\23\:VDD \24\:VDD) resistor r=62 c=0
Ry24 (\26\:VDD \27\:VDD) resistor r=62 c=0
Ry25 (\29\:VDD \30\:VDD) resistor r=62 c=0
Ry3 (\1\:Q \2\:Q) resistor r=62 c=0
Ry26 (\1\:VSS \2\:VSS) resistor r=31 c=0
Ry27 (\1\:VSS \5\:VSS) resistor r=5.1667 c=0
Ry28 (\1\:VSS \8\:VSS) resistor r=5.1667 c=0
Ry29 (\1\:VSS \10\:VSS) resistor r=5.1667 c=0
Ry2 (\4\:net573 \5\:net573) resistor r=62 c=0
Ry4 (\15\:qbint \16\:qbint) resistor r=62 c=0
Ry8 (\10\:RNb \11\:RNb) resistor r=62 c=0
Ry7 (\8\:n35 \9\:n35) resistor r=62 c=0
Ry13 (\21\:CKb \22\:CKb) resistor r=62 c=0
Ry9 (\8\:mout \9\:mout) resistor r=62 c=0
Ry10 (\10\:mout \11\:mout) resistor r=62 c=0
Ry12 (\7\:CKbb \8\:CKbb) resistor r=62 c=0
Ry11 (\9\:n20 \10\:n20) resistor r=62 c=0
Ry14 (\6\:Db \7\:Db) resistor r=62 c=0
Ry15 (\8\:Db \9\:Db) resistor r=62 c=0
Ry16 (\4\:SEb \5\:SEb) resistor r=62 c=0
Ry5 (n11 \2\:n11) resistor r=62 c=0
Ry6 (\3\:n11 \4\:n11) resistor r=62 c=0
Rx18 (\2\:CK \4\:CK) resistor r=45 c=0
Rx21 (\4\:SE \8\:SE) resistor r=45 c=0
Rx22 (\2\:SE \9\:SE) resistor r=45 c=0
Rx23 (\6\:SE \10\:SE) resistor r=45 c=0
Rx10 (\5\:SN \7\:SN) resistor r=45 c=0
Rx11 (\2\:SN \8\:SN) resistor r=45 c=0
Rx20 (\2\:SI \4\:SI) resistor r=45 c=0
Rx2 (\2\:RN \4\:RN) resistor r=45 c=0
Rx19 (\2\:D \4\:D) resistor r=45 c=0
Rx1 (\2\:net573 \7\:net573) resistor r=45 c=0
Rx3 (\9\:qbint \10\:qbint) resistor r=45 c=0
Rx4 (\2\:qbint \14\:qbint) resistor r=45 c=0
Rx8 (\5\:RNb \7\:RNb) resistor r=45 c=0
Rx9 (\3\:RNb \8\:RNb) resistor r=45 c=0
Rx5 (\2\:n35 \7\:n35) resistor r=45 c=0
Rx6 (\4\:CKb \12\:CKb) resistor r=45 c=0
Rx7 (\2\:CKb \13\:CKb) resistor r=45 c=0
Rx15 (\3\:CKb \19\:CKb) resistor r=45 c=0
Rx16 (\9\:CKb \20\:CKb) resistor r=45 c=0
Rx17 (\7\:CKb \23\:CKb) resistor r=45 c=0
Rx12 (\2\:mout \4\:mout) resistor r=45 c=0
Rx14 (CKbb \9\:CKbb) resistor r=45 c=0
Rx13 (n20 \8\:n20) resistor r=45 c=0
Rx24 (\2\:SEb \7\:SEb) resistor r=45 c=0
mn57 (\4\:QN \3\:net573 \24\:VSS VSS) g45n1lvt w=(1.45e-07) l=4.5e-08 \
        nf=1 as=4.66e-14 ad=2.03e-14 ps=1.35e-06 pd=5.7e-07 nrd=1.16667 \
        nrs=1.16667 sa=1.4e-07 sb=3.45e-07 sd=160n sca=10.4914 \
        scb=0.00978575 scc=0.000300434 m=(1)
mn56 (\8\:net573 \4\:qbint \24\:VSS VSS) g45n1lvt w=(1.45e-07) l=4.5e-08 \
        nf=1 as=4.66e-14 ad=2.03e-14 ps=1.35e-06 pd=5.7e-07 nrd=1.16667 \
        nrs=1.16667 sa=3.45e-07 sb=1.4e-07 sd=160n sca=10.4914 \
        scb=0.00978575 scc=0.000300434 m=(1)
mn55 (\3\:Q \5\:qbint \22\:VSS VSS) g45n1lvt w=(1.45e-07) l=4.5e-08 nf=1 \
        as=3.117e-14 ad=2.102e-14 ps=7.2e-07 pd=5.8e-07 nrd=1.16667 \
        nrs=1.16667 sa=1.45e-07 sb=4.85e-07 sd=160n sca=23.279 \
        scb=0.0230742 scc=0.00267719 m=(1)
mn22 (\12\:RNb \1\:RN \22\:VSS VSS) g45n1lvt w=(1.45e-07) l=4.5e-08 nf=1 \
        as=3.117e-14 ad=3.262e-14 ps=7.2e-07 pd=7.4e-07 nrd=1.16667 \
        nrs=1.16667 sa=4.05e-07 sb=2.25e-07 sd=160n sca=23.279 \
        scb=0.0230742 scc=0.00267719 m=(1)
mn45 (\12\:qbint \3\:n35 \19\:VSS VSS) g45n1lvt w=(1.45e-07) l=4.5e-08 \
        nf=1 as=7.27e-14 ad=2.03e-14 ps=1.41e-06 pd=5.7e-07 nrd=1.16667 \
        nrs=1.16667 sa=1.4e-07 sb=1.045e-06 sd=160n sca=12.5912 \
        scb=0.0129007 scc=0.000589158 m=(1)
mn50 (n8 \3\:SN \19\:VSS VSS) g45n1lvt w=(1.45e-07) l=4.5e-08 nf=1 \
        as=7.27e-14 ad=2.32e-14 ps=1.41e-06 pd=6.1e-07 nrd=1.16667 \
        nrs=1.16667 sa=4.05e-07 sb=7.8e-07 sd=160n sca=12.5912 \
        scb=0.0129007 scc=0.000589158 m=(1)
mn52 (\3\:n10 \8\:qbint n8 VSS) g45n1lvt w=(1.45e-07) l=4.5e-08 nf=1 \
        as=2.32e-14 ad=5.437e-14 ps=6.1e-07 pd=1.04e-06 nrd=1.16667 \
        nrs=1.16667 sa=6.1e-07 sb=5.75e-07 sd=160n sca=12.5912 \
        scb=0.0129007 scc=0.000589158 m=(1)
mn51 (\3\:n10 RNb \3\:n8 VSS) g45n1lvt w=(1.45e-07) l=4.5e-08 nf=1 \
        as=2.247e-14 ad=5.437e-14 ps=6e-07 pd=1.04e-06 nrd=1.16667 \
        nrs=1.16667 sa=1.03e-06 sb=1.55e-07 sd=160n sca=12.5912 \
        scb=0.0129007 scc=0.000589158 m=(1)
mn53 (\4\:n35 CKb n10 VSS) g45n1lvt w=(1.45e-07) l=4.5e-08 nf=1 \
        as=2.03e-14 ad=2.32e-14 ps=5.7e-07 pd=6.1e-07 nrd=1.16667 \
        nrs=1.16667 sa=1.4e-07 sb=4.6e-07 sd=160n sca=23.279 scb=0.0230742 \
        scc=0.00267719 m=(1)
mn40 (\4\:n35 \4\:CKbb \14\:mout VSS) g45n1lvt w=(1.45e-07) l=4.5e-08 \
        nf=1 as=3.697e-14 ad=2.32e-14 ps=8e-07 pd=6.1e-07 nrd=1.16667 \
        nrs=1.16667 sa=3.45e-07 sb=2.55e-07 sd=160n sca=23.279 \
        scb=0.0230742 scc=0.00267719 m=(1)
mn31 (\12\:mout \6\:RNb \3\:n4 VSS) g45n1lvt w=(1.45e-07) l=4.5e-08 nf=1 \
        as=2.03e-14 ad=2.682e-14 ps=5.7e-07 pd=6.6e-07 nrd=1.16667 \
        nrs=1.16667 sa=1.4e-07 sb=1.135e-06 sd=160n sca=17.8702 \
        scb=0.0189183 scc=0.00156031 m=(1)
mn32 (\12\:mout \3\:n20 n4 VSS) g45n1lvt w=(1.45e-07) l=4.5e-08 nf=1 \
        as=2.32e-14 ad=2.682e-14 ps=6.1e-07 pd=6.6e-07 nrd=1.16667 \
        nrs=1.16667 sa=3.7e-07 sb=9.05e-07 sd=160n sca=17.8702 \
        scb=0.0189183 scc=0.00156031 m=(1)
mn30 (n4 \6\:SN \17\:VSS VSS) g45n1lvt w=(1.45e-07) l=4.5e-08 nf=1 \
        as=2.755e-14 ad=2.32e-14 ps=6.7e-07 pd=6.1e-07 nrd=1.16667 \
        nrs=1.16667 sa=5.75e-07 sb=7e-07 sd=160n sca=17.8702 scb=0.0189183 \
        scc=0.00156031 m=(1)
mn35 (n6 \3\:mout \17\:VSS VSS) g45n1lvt w=(1.45e-07) l=4.5e-08 nf=1 \
        as=2.755e-14 ad=8.7e-15 ps=6.7e-07 pd=4.1e-07 nrd=1.16667 \
        nrs=1.16667 sa=8.1e-07 sb=4.65e-07 sd=160n sca=17.8702 \
        scb=0.0189183 scc=0.00156031 m=(1)
mn36 (\5\:n20 \3\:CKbb n6 VSS) g45n1lvt w=(1.45e-07) l=4.5e-08 nf=1 \
        as=8.7e-15 ad=2.537e-14 ps=4.1e-07 pd=6.4e-07 nrd=1.16667 \
        nrs=1.16667 sa=9.15e-07 sb=3.6e-07 sd=160n sca=17.8702 \
        scb=0.0189183 scc=0.00156031 m=(1)
mn25 (\4\:Db \10\:CKb \5\:n20 VSS) g45n1lvt w=(1.45e-07) l=4.5e-08 nf=1 \
        as=2.537e-14 ad=2.03e-14 ps=6.4e-07 pd=5.7e-07 nrd=1.16667 \
        nrs=1.16667 sa=1.135e-06 sb=1.4e-07 sd=160n sca=17.8702 \
        scb=0.0189183 scc=0.00156031 m=(1)
mn21 (\10\:CKbb \11\:CKb \15\:VSS VSS) g45n1lvt w=(1.45e-07) l=4.5e-08 \
        nf=1 as=7.085e-14 ad=2.03e-14 ps=1.4e-06 pd=5.7e-07 nrd=1.16667 \
        nrs=1.16667 sa=1.4e-07 sb=1.7e-07 sd=160n sca=16.2011 \
        scb=0.0172667 scc=0.0012292 m=(1)
mn20 (\14\:CKb \3\:CK \13\:VSS VSS) g45n1lvt w=(1.45e-07) l=4.5e-08 nf=1 \
        as=4.855e-14 ad=3.987e-14 ps=1.13e-06 pd=8.4e-07 nrd=1.16667 \
        nrs=1.16667 sa=2.75e-07 sb=4.87931e-07 sd=160n sca=19.8813 \
        scb=0.0206549 scc=0.00197265 m=(1)
mn11 (n0 \3\:D \13\:VSS VSS) g45n1lvt w=(1.45e-07) l=4.5e-08 nf=1 \
        as=4.855e-14 ad=3.625e-14 ps=1.13e-06 pd=7.9e-07 nrd=1.16667 \
        nrs=1.16667 sa=3.01034e-07 sb=9.5e-07 sd=160n sca=11.4452 \
        scb=0.0112553 scc=0.00042156 m=(1)
mn12 (Db \3\:SEb n0 VSS) g45n1lvt w=(1.45e-07) l=4.5e-08 nf=1 \
        as=3.625e-14 ad=2.32e-14 ps=7.9e-07 pd=6.1e-07 nrd=1.16667 \
        nrs=1.16667 sa=5.96034e-07 sb=6.55e-07 sd=160n sca=11.4452 \
        scb=0.0112553 scc=0.00042156 m=(1)
mn14 (Db \3\:SE n2 VSS) g45n1lvt w=(1.45e-07) l=4.5e-08 nf=1 as=8.7e-15 \
        ad=2.32e-14 ps=4.1e-07 pd=6.1e-07 nrd=1.16667 nrs=1.16667 \
        sa=8.01034e-07 sb=4.5e-07 sd=160n sca=11.4452 scb=0.0112553 \
        scc=0.00042156 m=(1)
mn13 (n2 \3\:SI \11\:VSS VSS) g45n1lvt w=(1.45e-07) l=4.5e-08 nf=1 \
        as=2.32e-14 ad=8.7e-15 ps=6.1e-07 pd=4.1e-07 nrd=1.16667 \
        nrs=1.16667 sa=9.06034e-07 sb=3.45e-07 sd=160n sca=11.4452 \
        scb=0.0112553 scc=0.00042156 m=(1)
mn10 (\8\:SEb \7\:SE \11\:VSS VSS) g45n1lvt w=(1.45e-07) l=4.5e-08 nf=1 \
        as=2.32e-14 ad=2.03e-14 ps=6.1e-07 pd=5.7e-07 nrd=1.16667 \
        nrs=1.16667 sa=1.11103e-06 sb=1.4e-07 sd=160n sca=11.4452 \
        scb=0.0112553 scc=0.00042156 m=(1)
ends SDFFSRXL
// End of subcircuit definition.
