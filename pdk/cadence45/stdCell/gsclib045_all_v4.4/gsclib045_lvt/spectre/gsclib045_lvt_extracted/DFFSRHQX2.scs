// Generated for: spectre (May  1 09:13:56 2013 )
// Library name: gsclib045_lvt
// Cell name: DFFSRHQX2
// View name: extracted

simulator lang=spectre

subckt DFFSRHQX2 CK D Q RN SN VDD VSS
mp55 (\1\:Q qbint \12\:VDD VDD) g45p1lvt w=(3.9e-07) l=4.5e-08 nf=1 \
        as=5.842e-14 ad=7.41e-14 ps=1.095e-06 pd=1.16e-06 nrd=1.16667 \
        nrs=1.16667 sa=1.4e-07 sb=5.22179e-07 sd=160n sca=32.3479 \
        scb=0.0266211 scc=0.00309587 m=(2)
C1 (SN VSS) capacitor c=2.70976e-16
C2 (RN VSS) capacitor c=4.26641e-17
C3 (VDD VSS) capacitor c=4.09282e-16
C4 (CK VSS) capacitor c=3.82141e-17
C5 (D VSS) capacitor c=6.69247e-17
C6 (Q VSS) capacitor c=4.71701e-17
C7 (qbint VSS) capacitor c=1.51426e-16
C8 (n35 VSS) capacitor c=4.75777e-17
C9 (RNb VSS) capacitor c=5.0747e-17
C10 (n42 VSS) capacitor c=7.73019e-17
C11 (n40 VSS) capacitor c=9.46141e-17
C12 (CKb VSS) capacitor c=3.99809e-17
C13 (mout VSS) capacitor c=4.62333e-17
C14 (CKbb VSS) capacitor c=3.56021e-17
C15 (n25 VSS) capacitor c=7.45713e-17
C16 (n20 VSS) capacitor c=3.23802e-17
C17 (n30 VSS) capacitor c=5.489e-18
C18 (n21 VSS) capacitor c=1.51044e-18
C19 (n41 VSS) capacitor c=9.62584e-17
C20 (n43 VSS) capacitor c=3.29651e-18
C21 (n26 VSS) capacitor c=7.09526e-18
C22 (n31 VSS) capacitor c=1.2985e-17
C23 (n22 VSS) capacitor c=1.7513e-18
C24 (\1\:CK VSS) capacitor c=2.67269e-17
C25 (\9\:CKb VSS) capacitor c=6.18073e-17
C26 (\4\:D VSS) capacitor c=6.56728e-17
C27 (\5\:CKbb VSS) capacitor c=4.74637e-17
C28 (\5\:CKb VSS) capacitor c=4.39961e-17
C29 (\4\:SN VSS) capacitor c=7.51676e-17
C30 (\4\:n20 VSS) capacitor c=5.26603e-17
C31 (\2\:RNb VSS) capacitor c=1.14699e-16
C32 (\4\:RNb VSS) capacitor c=6.58119e-17
C33 (\9\:qbint VSS) capacitor c=1.2751e-16
C34 (\1\:SN VSS) capacitor c=4.10962e-17
C35 (\3\:RN VSS) capacitor c=2.90449e-17
C36 (\3\:CK VSS) capacitor c=2.04531e-17
C37 (\10\:CKb VSS) capacitor c=4.46647e-17
C38 (\3\:D VSS) capacitor c=5.27356e-17
C39 (\7\:CKb VSS) capacitor c=5.05185e-17
C40 (\7\:CKbb VSS) capacitor c=4.85904e-17
C41 (\4\:mout VSS) capacitor c=3.48398e-17
C42 (\6\:SN VSS) capacitor c=5.79028e-17
C43 (\3\:n20 VSS) capacitor c=3.49787e-17
C44 (\4\:CKbb VSS) capacitor c=3.98769e-17
C45 (\3\:CKb VSS) capacitor c=5.93051e-17
C46 (\5\:RNb VSS) capacitor c=4.92825e-17
C47 (\8\:qbint VSS) capacitor c=6.5796e-17
C48 (\3\:SN VSS) capacitor c=3.49316e-17
C49 (\1\:RN VSS) capacitor c=2.8176e-17
C50 (\3\:n35 VSS) capacitor c=3.49361e-17
C51 (\2\:CK VSS) capacitor c=1.64555e-17
C52 (\11\:CKb VSS) capacitor c=1.73344e-17
C53 (\1\:D VSS) capacitor c=2.34538e-17
C54 (\6\:CKbb VSS) capacitor c=6.61015e-17
C55 (\8\:CKb VSS) capacitor c=4.73122e-17
C56 (\6\:CKb VSS) capacitor c=2.6862e-17
C57 (\3\:mout VSS) capacitor c=2.93676e-17
C58 (\5\:SN VSS) capacitor c=2.20043e-17
C59 (\4\:CKb VSS) capacitor c=3.70844e-17
C60 (\3\:CKbb VSS) capacitor c=4.7289e-17
C61 (\2\:CKbb VSS) capacitor c=3.22088e-17
C62 (\3\:RNb VSS) capacitor c=9.51065e-17
C63 (\2\:SN VSS) capacitor c=2.96545e-17
C64 (\2\:RN VSS) capacitor c=2.57056e-17
C65 (\10\:qbint VSS) capacitor c=5.08637e-17
C66 (\2\:n35 VSS) capacitor c=3.28837e-17
C67 (\1\:VDD VSS) capacitor c=2.95941e-17
C68 (\12\:CKb VSS) capacitor c=6.36203e-17
C69 (\8\:CKbb VSS) capacitor c=1.42126e-17
C70 (\14\:VDD VSS) capacitor c=3.98209e-17
C71 (\6\:n20 VSS) capacitor c=1.56306e-16
C72 (\16\:VDD VSS) capacitor c=4.10692e-17
C73 (\12\:mout VSS) capacitor c=3.68629e-17
C74 (\18\:VDD VSS) capacitor c=4.48011e-17
C75 (\7\:mout VSS) capacitor c=1.68814e-16
C76 (\4\:n35 VSS) capacitor c=6.67491e-17
C77 (\20\:VDD VSS) capacitor c=3.97334e-17
C78 (\3\:n41 VSS) capacitor c=1.07463e-16
C79 (\22\:VDD VSS) capacitor c=6.12829e-17
C80 (\7\:RNb VSS) capacitor c=1.8214e-16
C81 (\12\:qbint VSS) capacitor c=7.91829e-17
C82 (\1\:Q VSS) capacitor c=5.27998e-17
C83 (\3\:VDD VSS) capacitor c=1.02389e-16
C84 (\14\:CKb VSS) capacitor c=7.52755e-17
C85 (\14\:CKbb VSS) capacitor c=6.25302e-17
C86 (\8\:n20 VSS) capacitor c=8.64051e-17
C87 (\14\:mout VSS) capacitor c=1.13143e-16
C88 (\3\:n25 VSS) capacitor c=8.85635e-17
C89 (\10\:mout VSS) capacitor c=2.79694e-17
C90 (\8\:n35 VSS) capacitor c=2.38705e-17
C91 (\3\:n40 VSS) capacitor c=1.36393e-16
C92 (\3\:n42 VSS) capacitor c=8.57924e-17
C93 (\9\:RNb VSS) capacitor c=8.19062e-17
C94 (\15\:qbint VSS) capacitor c=6.61964e-17
C95 (\3\:Q VSS) capacitor c=4.14873e-17
C96 (\2\:CKb VSS) capacitor c=5.38857e-17
C97 (\2\:n20 VSS) capacitor c=1.80203e-17
C98 (\2\:mout VSS) capacitor c=2.49478e-17
C99 (\2\:D VSS) capacitor c=4.50698e-17
C100 (\11\:qbint VSS) capacitor c=5.60563e-17
C101 (\14\:qbint VSS) capacitor c=6.37639e-17
C102 (\17\:qbint VSS) capacitor c=5.7878e-17
C103 (\4\:RN VSS) capacitor c=7.33045e-17
C104 (\6\:RNb VSS) capacitor c=1.39202e-16
C105 (\6\:n35 VSS) capacitor c=3.41388e-16
C106 (\7\:n35 VSS) capacitor c=2.6828e-16
C107 (\7\:SN VSS) capacitor c=2.83433e-16
C108 (\8\:SN VSS) capacitor c=2.94189e-17
C109 (\5\:mout VSS) capacitor c=3.53323e-17
C110 (\6\:mout VSS) capacitor c=1.2752e-16
C111 (\9\:mout VSS) capacitor c=7.43289e-17
C112 (\5\:n20 VSS) capacitor c=1.50398e-16
C113 (\5\:D VSS) capacitor c=4.10588e-17
C114 (\10\:CKbb VSS) capacitor c=7.07422e-17
C115 (\11\:CKbb VSS) capacitor c=2.21241e-16
C116 (\12\:CKbb VSS) capacitor c=3.74435e-16
C117 (\13\:CKbb VSS) capacitor c=7.82378e-17
C118 (\16\:CKbb VSS) capacitor c=2.51418e-17
C119 (\17\:CKbb VSS) capacitor c=8.25472e-17
C120 (\16\:CKb VSS) capacitor c=5.40596e-17
C121 (\17\:CKb VSS) capacitor c=8.30233e-17
C122 (\18\:CKb VSS) capacitor c=1.97719e-16
C123 (\19\:CKb VSS) capacitor c=1.99318e-16
C124 (\20\:CKb VSS) capacitor c=5.22398e-17
C125 (\21\:CKb VSS) capacitor c=5.46089e-17
C126 (\5\:CK VSS) capacitor c=7.76247e-17
C127 (\5\:VDD VSS) capacitor c=2.04721e-17
C128 (\6\:VDD VSS) capacitor c=3.8778e-17
C129 (\7\:VDD VSS) capacitor c=2.21456e-17
C130 (\9\:VDD VSS) capacitor c=7.68934e-17
C131 (\10\:VDD VSS) capacitor c=3.94136e-17
C132 (\12\:VDD VSS) capacitor c=1.53001e-16
Rk17 (\7\:SN SN) resistor r=2.2141 c=0
Rk18 (SN \8\:SN) resistor r=0.09879 c=0
Rk7 (RN \4\:RN) resistor r=0.1146 c=0
Rk63 (\2\:VSS \4\:VSS) resistor r=0.7521 c=0
Rk64 (\4\:VSS \5\:VSS) resistor r=0.07662 c=0
Rk65 (\5\:VSS \6\:VSS) resistor r=0.533 c=0
Rk66 (\6\:VSS \7\:VSS) resistor r=0.4413 c=0
Rk67 (\7\:VSS \8\:VSS) resistor r=1.0183 c=0
Rk68 (\8\:VSS \9\:VSS) resistor r=0.1854 c=0
Rk71 (\10\:VSS VSS) resistor r=0.0698 c=0
Rk69 (\9\:VSS \10\:VSS) resistor r=0.2758 c=0
Rk72 (\5\:VSS \13\:VSS) resistor r=0.04333 c=0
Rk73 (\6\:VSS \15\:VSS) resistor r=0.265 c=0
Rk74 (\8\:VSS \17\:VSS) resistor r=0.33 c=0
Rk45 (\2\:VDD \4\:VDD) resistor r=0.8097 c=0
Rk46 (\4\:VDD \5\:VDD) resistor r=0.09262 c=0
Rk47 (\5\:VDD \6\:VDD) resistor r=0.4737 c=0
Rk48 (\6\:VDD \7\:VDD) resistor r=0.3885 c=0
Rk49 (\7\:VDD \8\:VDD) resistor r=0.09764 c=0
Rk50 (\8\:VDD \9\:VDD) resistor r=0.632 c=0
Rk51 (\9\:VDD \10\:VDD) resistor r=0.4938 c=0
Rk52 (\10\:VDD \11\:VDD) resistor r=0.07757 c=0
Rk55 (\12\:VDD VDD) resistor r=0.0698 c=0
Rk53 (\11\:VDD \12\:VDD) resistor r=0.2532 c=0
Rk56 (\5\:VDD \15\:VDD) resistor r=0.3466 c=0
Rk57 (\6\:VDD \17\:VDD) resistor r=0.19 c=0
Rk58 (\7\:VDD \19\:VDD) resistor r=0.1923 c=0
Rk59 (\9\:VDD \21\:VDD) resistor r=0.19 c=0
Rk60 (\10\:VDD \23\:VDD) resistor r=0.1718 c=0
Rk44 (CK \5\:CK) resistor r=0.05712 c=0
Rk27 (\5\:D D) resistor r=0.1918 c=0
Rk1 (Q \2\:Q) resistor r=0.1207 c=0
Rk2 (\2\:Q \4\:Q) resistor r=0.3721 c=0
Rk3 (\11\:qbint \13\:qbint) resistor r=0.4038 c=0
Rk4 (\13\:qbint \14\:qbint) resistor r=0.2523 c=0
Rk5 (\14\:qbint \16\:qbint) resistor r=0.2897 c=0
Rk6 (\14\:qbint \17\:qbint) resistor r=0.3486 c=0
Rk13 (\5\:n35 \6\:n35) resistor r=0.2646 c=0
Rk14 (\6\:n35 \7\:n35) resistor r=2.2813 c=0
Rk15 (\6\:n35 \9\:n35) resistor r=0.09796 c=0
Rk8 (\6\:RNb \8\:RNb) resistor r=1.0653 c=0
Rk9 (\8\:RNb \10\:RNb) resistor r=0.3734 c=0
Rk10 (\2\:n42 \4\:n42) resistor r=0.3899 c=0
Rk12 (\2\:n40 \4\:n40) resistor r=0.7499 c=0
Rk35 (\13\:CKb \15\:CKb) resistor r=0.3039 c=0
Rk36 (\15\:CKb \16\:CKb) resistor r=0.3682 c=0
Rk37 (\16\:CKb \17\:CKb) resistor r=0.2592 c=0
Rk38 (\17\:CKb \18\:CKb) resistor r=0.5823 c=0
Rk39 (\18\:CKb \19\:CKb) resistor r=1.2197 c=0
Rk40 (\17\:CKb \20\:CKb) resistor r=0.2127 c=0
Rk41 (\18\:CKb \21\:CKb) resistor r=0.2339 c=0
Rk19 (\5\:mout \6\:mout) resistor r=0.1687 c=0
Rk20 (\6\:mout \8\:mout) resistor r=0.8668 c=0
Rk21 (\8\:mout \9\:mout) resistor r=0.2852 c=0
Rk22 (\9\:mout \11\:mout) resistor r=0.1572 c=0
Rk23 (\6\:mout \13\:mout) resistor r=0.08695 c=0
Rk24 (\9\:mout \15\:mout) resistor r=0.4786 c=0
Rk28 (\9\:CKbb \10\:CKbb) resistor r=0.04813 c=0
Rk29 (\10\:CKbb \11\:CKbb) resistor r=0.3166 c=0
Rk30 (\11\:CKbb \12\:CKbb) resistor r=2.069 c=0
Rk31 (\12\:CKbb \13\:CKbb) resistor r=0.4924 c=0
Rk32 (\10\:CKbb \15\:CKbb) resistor r=0.3959 c=0
Rk33 (\11\:CKbb \16\:CKbb) resistor r=0.06445 c=0
Rk34 (\12\:CKbb \17\:CKbb) resistor r=0.3648 c=0
Rk16 (\2\:n25 \4\:n25) resistor r=0.3596 c=0
Rk25 (\5\:n20 \7\:n20) resistor r=0.8727 c=0
Rk26 (\7\:n20 \9\:n20) resistor r=0.448 c=0
Rk11 (\2\:n41 \4\:n41) resistor r=0.5639 c=0
Rl28 (\4\:SN \6\:SN) resistor r=167.308 c=0
Rl27 (\4\:SN \5\:SN) resistor r=68.032 c=0
Rl11 (\1\:SN \2\:SN) resistor r=30.7692 c=0
Rl12 (\2\:SN \3\:SN) resistor r=78.022 c=0
Rl10 (\2\:RN \3\:RN) resistor r=46.985 c=0
Rl9 (\1\:RN \2\:RN) resistor r=64.6174 c=0
Rl41 (\1\:CK \2\:CK) resistor r=39.6174 c=0
Rl42 (\2\:CK \3\:CK) resistor r=24.2328 c=0
Rl38 (\2\:D \4\:D) resistor r=77.7258 c=0
Rl37 (\2\:D \3\:D) resistor r=81.5719 c=0
Rl36 (\1\:D \2\:D) resistor r=1.2334 c=0
Rl13 (\8\:qbint \9\:qbint) resistor r=149.566 c=0
Rl14 (\10\:qbint \9\:qbint) resistor r=392.285 c=0
Rl7 (n35 \2\:n35) resistor r=74.2328 c=0
Rl8 (\2\:n35 \3\:n35) resistor r=24.2328 c=0
Rl20 (RNb \2\:RNb) resistor r=151.489 c=0
Rl23 (\4\:RNb \5\:RNb) resistor r=132.692 c=0
Rl21 (\2\:RNb \3\:RNb) resistor r=765.924 c=0
Rl22 (\3\:RNb \4\:RNb) resistor r=56.9251 c=0
Rl39 (\9\:CKb \10\:CKb) resistor r=164.95 c=0
Rl40 (\10\:CKb \11\:CKb) resistor r=29.5379 c=0
Rl33 (\7\:CKb \8\:CKb) resistor r=26.098 c=0
Rl32 (\5\:CKb \6\:CKb) resistor r=33.8482 c=0
Rl17 (CKb \2\:CKb) resistor r=30.4507 c=0
Rl18 (\2\:CKb \3\:CKb) resistor r=139.928 c=0
Rl19 (\2\:CKb \4\:CKb) resistor r=154.421 c=0
Rl29 (mout \2\:mout) resistor r=47.3105 c=0
Rl31 (\2\:mout \4\:mout) resistor r=116.541 c=0
Rl30 (\2\:mout \3\:mout) resistor r=34.9887 c=0
Rl34 (\5\:CKbb \6\:CKbb) resistor r=24.7951 c=0
Rl35 (\6\:CKbb \7\:CKbb) resistor r=155.312 c=0
Rl16 (\3\:CKbb \4\:CKbb) resistor r=31.0981 c=0
Rl15 (CKbb \2\:CKbb) resistor r=29.4849 c=0
Rl26 (\2\:n20 \4\:n20) resistor r=45.3874 c=0
Rl25 (\2\:n20 \3\:n20) resistor r=76.1566 c=0
Rl24 (n20 \2\:n20) resistor r=34.9887 c=0
Rz19 (\2\:VSS \1\:VSS) resistor r=75 c=0
Rz20 (\13\:VSS \12\:VSS) resistor r=75 c=0
Rz21 (\15\:VSS \14\:VSS) resistor r=75 c=0
Rz22 (\17\:VSS \16\:VSS) resistor r=75 c=0
Rz16 (\4\:VDD \3\:VDD) resistor r=8.3333 c=0
Rz17 (\8\:VDD \3\:VDD) resistor r=6.25 c=0
Rz18 (\11\:VDD \3\:VDD) resistor r=6.25 c=0
Rz1 (\4\:Q \3\:Q) resistor r=75 c=0
Rz2 (\16\:qbint \15\:qbint) resistor r=75 c=0
Rz8 (\8\:n35 \9\:n35) resistor r=75 c=0
Rz3 (\9\:RNb \10\:RNb) resistor r=75 c=0
Rz4 (n42 \2\:n42) resistor r=75 c=0
Rz5 (\3\:n42 \4\:n42) resistor r=75 c=0
Rz6 (n40 \2\:n40) resistor r=75 c=0
Rz7 (\3\:n40 \4\:n40) resistor r=75 c=0
Rz15 (\14\:CKb \15\:CKb) resistor r=75 c=0
Rz11 (\10\:mout \11\:mout) resistor r=75 c=0
Rz12 (\14\:mout \15\:mout) resistor r=75 c=0
Rz14 (\14\:CKbb \15\:CKbb) resistor r=75 c=0
Rz9 (n25 \2\:n25) resistor r=75 c=0
Rz10 (\3\:n25 \4\:n25) resistor r=75 c=0
Rz13 (\8\:n20 \9\:n20) resistor r=75 c=0
Ry20 (\4\:VSS \3\:VSS) resistor r=6.8889 c=0
Ry21 (\7\:VSS \3\:VSS) resistor r=5.1667 c=0
Ry22 (\9\:VSS \3\:VSS) resistor r=5.1667 c=0
Ry12 (\2\:VDD \1\:VDD) resistor r=62 c=0
Ry13 (\15\:VDD \14\:VDD) resistor r=62 c=0
Ry14 (\17\:VDD \16\:VDD) resistor r=62 c=0
Ry15 (\19\:VDD \18\:VDD) resistor r=62 c=0
Ry16 (\21\:VDD \20\:VDD) resistor r=62 c=0
Ry17 (\23\:VDD \22\:VDD) resistor r=62 c=0
Ry1 (\2\:Q \1\:Q) resistor r=20.6667 c=0
Ry2 (\13\:qbint \12\:qbint) resistor r=62 c=0
Ry6 (\4\:n35 \5\:n35) resistor r=62 c=0
Ry3 (\7\:RNb \8\:RNb) resistor r=62 c=0
Ry11 (\12\:CKb \13\:CKb) resistor r=62 c=0
Ry7 (\7\:mout \8\:mout) resistor r=62 c=0
Ry8 (\12\:mout \13\:mout) resistor r=62 c=0
Ry10 (\8\:CKbb \9\:CKbb) resistor r=62 c=0
Ry9 (\6\:n20 \7\:n20) resistor r=62 c=0
Ry4 (n41 \2\:n41) resistor r=62 c=0
Ry5 (\3\:n41 \4\:n41) resistor r=62 c=0
Rx6 (\5\:SN \7\:SN) resistor r=45 c=0
Rx7 (\2\:SN \8\:SN) resistor r=45 c=0
Rx3 (\2\:RN \4\:RN) resistor r=45 c=0
Rx18 (\2\:CK \5\:CK) resistor r=45 c=0
Rx10 (\1\:D \5\:D) resistor r=45 c=0
Rx1 (\11\:qbint \10\:qbint) resistor r=45 c=0
Rx2 (\17\:qbint qbint) resistor r=45 c=0
Rx5 (\2\:n35 \7\:n35) resistor r=45 c=0
Rx4 (\3\:RNb \6\:RNb) resistor r=45 c=0
Rx14 (\11\:CKb \16\:CKb) resistor r=45 c=0
Rx15 (\4\:CKb \19\:CKb) resistor r=45 c=0
Rx16 (\8\:CKb \20\:CKb) resistor r=45 c=0
Rx17 (\6\:CKb \21\:CKb) resistor r=45 c=0
Rx8 (\3\:mout \5\:mout) resistor r=45 c=0
Rx11 (\2\:CKbb \13\:CKbb) resistor r=45 c=0
Rx12 (\6\:CKbb \16\:CKbb) resistor r=45 c=0
Rx13 (\3\:CKbb \17\:CKbb) resistor r=45 c=0
Rx9 (n20 \5\:n20) resistor r=45 c=0
mn55_1__rcx (\3\:Q qbint \10\:VSS VSS) g45n1lvt w=(2.6e-07) l=4.5e-08 \
        nf=1 as=3.94e-14 ad=4.16e-14 ps=8.4e-07 pd=8.4e-07 nrd=1.16667 \
        nrs=1.16667 sa=1.4e-07 sb=5.88846e-07 sd=160n sca=17.5885 \
        scb=0.0172826 scc=0.00162584 m=(2)
mn45 (\15\:qbint \3\:n35 \10\:VSS VSS) g45n1lvt w=(2.05e-07) l=4.5e-08 \
        nf=1 as=4.24e-14 ad=4.818e-14 ps=8.8e-07 pd=8.8e-07 nrd=1.16667 \
        nrs=1.16667 sa=5.7e-07 sb=2.35e-07 sd=160n sca=19.867 \
        scb=0.0198061 scc=0.00201945 m=(1)
mn50 (\3\:n42 \3\:SN \16\:VSS VSS) g45n1lvt w=(2.05e-07) l=4.5e-08 nf=1 \
        as=6.278e-14 ad=3.28e-14 ps=1.16e-06 pd=7.3e-07 nrd=1.16667 \
        nrs=1.16667 sa=4.37073e-07 sb=5.5e-07 sd=160n sca=19.1238 \
        scb=0.0192529 scc=0.0018715 m=(1)
mn52 (\3\:n40 \8\:qbint \3\:n42 VSS) g45n1lvt w=(2.05e-07) l=4.5e-08 nf=1 \
        as=3.28e-14 ad=3.28e-14 ps=7.3e-07 pd=7.3e-07 nrd=1.16667 \
        nrs=1.16667 sa=6.42073e-07 sb=3.45e-07 sd=160n sca=19.1238 \
        scb=0.0192529 scc=0.0018715 m=(1)
mn51 (\3\:n40 \5\:RNb n42 VSS) g45n1lvt w=(2.05e-07) l=4.5e-08 nf=1 \
        as=2.87e-14 ad=3.28e-14 ps=6.9e-07 pd=7.3e-07 nrd=1.16667 \
        nrs=1.16667 sa=8.47073e-07 sb=1.4e-07 sd=160n sca=19.1238 \
        scb=0.0192529 scc=0.0018715 m=(1)
mn53 (\8\:n35 \3\:CKb n40 VSS) g45n1lvt w=(2.05e-07) l=4.5e-08 nf=1 \
        as=2.87e-14 ad=3.28e-14 ps=6.9e-07 pd=7.3e-07 nrd=1.16667 \
        nrs=1.16667 sa=1.4e-07 sb=3.45e-07 sd=160n sca=11.535 \
        scb=0.0112489 scc=0.00047927 m=(1)
mn40 (\8\:n35 \4\:CKbb \10\:mout VSS) g45n1lvt w=(2.05e-07) l=4.5e-08 \
        nf=1 as=2.87e-14 ad=3.28e-14 ps=6.9e-07 pd=7.3e-07 nrd=1.16667 \
        nrs=1.16667 sa=3.45e-07 sb=1.4e-07 sd=160n sca=11.535 \
        scb=0.0112489 scc=0.00047927 m=(1)
mn31 (\14\:mout RNb \3\:n25 VSS) g45n1lvt w=(2.05e-07) l=4.5e-08 nf=1 \
        as=3.177e-14 ad=6.047e-14 ps=7.2e-07 pd=1e-06 nrd=1.16667 \
        nrs=1.16667 sa=1.55e-07 sb=1.85854e-06 sd=160n sca=11.814 \
        scb=0.0116374 scc=0.000520744 m=(1)
mn32 (\14\:mout \3\:n20 n25 VSS) g45n1lvt w=(2.05e-07) l=4.5e-08 nf=1 \
        as=4.92e-14 ad=6.047e-14 ps=8.9e-07 pd=1e-06 nrd=1.16667 \
        nrs=1.16667 sa=4.95e-07 sb=1.57122e-06 sd=160n sca=11.814 \
        scb=0.0116374 scc=0.000520744 m=(1)
mn30 (n25 \6\:SN \14\:VSS VSS) g45n1lvt w=(2.05e-07) l=4.5e-08 nf=1 \
        as=4.92e-14 ad=4.92e-14 ps=8.9e-07 pd=8.9e-07 nrd=1.16667 \
        nrs=1.16667 sa=7.8e-07 sb=1.28622e-06 sd=160n sca=11.814 \
        scb=0.0116374 scc=0.000520744 m=(1)
mn35 (n30 \4\:mout \14\:VSS VSS) g45n1lvt w=(2.05e-07) l=4.5e-08 nf=1 \
        as=4.92e-14 ad=6.662e-14 ps=8.9e-07 pd=1.06e-06 nrd=1.16667 \
        nrs=1.16667 sa=1.065e-06 sb=1.00122e-06 sd=160n sca=11.814 \
        scb=0.0116374 scc=0.000520744 m=(1)
mn36 (\8\:n20 \7\:CKbb n30 VSS) g45n1lvt w=(2.05e-07) l=4.5e-08 nf=1 \
        as=6.662e-14 ad=3.28e-14 ps=1.06e-06 pd=7.3e-07 nrd=1.16667 \
        nrs=1.16667 sa=1.435e-06 sb=6.3122e-07 sd=160n sca=11.814 \
        scb=0.0116374 scc=0.000520744 m=(1)
mn26 (\8\:n20 \7\:CKb n21 VSS) g45n1lvt w=(2.05e-07) l=4.5e-08 nf=1 \
        as=2.05e-14 ad=3.28e-14 ps=6.1e-07 pd=7.3e-07 nrd=1.16667 \
        nrs=1.16667 sa=1.64e-06 sb=4.2622e-07 sd=160n sca=11.814 \
        scb=0.0116374 scc=0.000520744 m=(1)
mn25 (n21 \3\:D \12\:VSS VSS) g45n1lvt w=(2.05e-07) l=4.5e-08 nf=1 \
        as=8.475e-14 ad=2.05e-14 ps=1.72e-06 pd=6.1e-07 nrd=1.16667 \
        nrs=1.16667 sa=1.785e-06 sb=2.8122e-07 sd=160n sca=11.814 \
        scb=0.0116374 scc=0.000520744 m=(1)
mn22 (\9\:RNb \1\:RN \16\:VSS VSS) g45n1lvt w=(1.45e-07) l=4.5e-08 nf=1 \
        as=6.278e-14 ad=2.03e-14 ps=1.16e-06 pd=5.7e-07 nrd=1.16667 \
        nrs=1.16667 sa=1.4e-07 sb=9.7e-07 sd=160n sca=22.3376 \
        scb=0.0224607 scc=0.00248252 m=(1)
mn21 (\14\:CKbb \10\:CKb \12\:VSS VSS) g45n1lvt w=(1.45e-07) l=4.5e-08 \
        nf=1 as=8.475e-14 ad=3.263e-14 ps=1.72e-06 pd=7.4e-07 nrd=1.16667 \
        nrs=1.16667 sa=8.86207e-07 sb=2.25e-07 sd=160n sca=23.279 \
        scb=0.0230742 scc=0.00267719 m=(1)
mn20 (\14\:CKb \3\:CK \1\:VSS VSS) g45n1lvt w=(1.45e-07) l=4.5e-08 nf=1 \
        as=2.61e-14 ad=3.407e-14 ps=6.5e-07 pd=7.6e-07 nrd=1.16667 \
        nrs=1.16667 sa=2.35e-07 sb=1.8e-07 sd=160n sca=23.279 \
        scb=0.0230742 scc=0.00267719 m=(1)
mp45 (\12\:qbint n35 \12\:VDD VDD) g45p1lvt w=(3.1e-07) l=4.5e-08 nf=1 \
        as=6.225e-14 ad=3.58e-14 ps=1.13e-06 pd=9e-07 nrd=1.16667 \
        nrs=1.16667 sa=5.95e-07 sb=1.15484e-07 sd=160n sca=16.8189 \
        scb=0.0155179 scc=0.00118078 m=(1)
mp50 (\3\:n41 \1\:SN \22\:VDD VDD) g45p1lvt w=(3.1e-07) l=4.5e-08 nf=1 \
        as=1.102e-13 ad=6.045e-14 ps=2.44e-06 pd=1.01e-06 nrd=1.16667 \
        nrs=1.16667 sa=1.91129e-07 sb=4.86452e-07 sd=160n sca=15.5687 \
        scb=0.0146164 scc=0.00101158 m=(1)
mp52 (n43 \9\:qbint \3\:n41 VDD) g45p1lvt w=(3.1e-07) l=4.5e-08 nf=1 \
        as=6.045e-14 ad=2.17e-14 ps=1.01e-06 pd=7.6e-07 nrd=1.16667 \
        nrs=1.16667 sa=4.31129e-07 sb=2.46452e-07 sd=160n sca=15.5687 \
        scb=0.0146164 scc=0.00101158 m=(1)
mp51 (n43 \4\:RNb \20\:VDD VDD) g45p1lvt w=(3.1e-07) l=4.5e-08 nf=1 \
        as=5.755e-14 ad=2.17e-14 ps=1.49e-06 pd=7.6e-07 nrd=1.16667 \
        nrs=1.16667 sa=5.46129e-07 sb=1.31452e-07 sd=160n sca=15.5687 \
        scb=0.0146164 scc=0.00101158 m=(1)
mp53 (\4\:n35 CKbb n41 VDD) g45p1lvt w=(3.1e-07) l=4.5e-08 nf=1 \
        as=5.8e-14 ad=6.045e-14 ps=1.12e-06 pd=1.01e-06 nrd=1.16667 \
        nrs=1.16667 sa=1.87097e-07 sb=4.95e-07 sd=160n sca=35.6995 \
        scb=0.0234062 scc=0.00420468 m=(1)
mp40 (\4\:n35 CKb \7\:mout VDD) g45p1lvt w=(3.1e-07) l=4.5e-08 nf=1 \
        as=7.905e-14 ad=6.045e-14 ps=1.13e-06 pd=1.01e-06 nrd=1.16667 \
        nrs=1.16667 sa=4.27097e-07 sb=2.55e-07 sd=160n sca=35.6995 \
        scb=0.0234062 scc=0.00420468 m=(1)
mp31 (n26 \2\:RNb \18\:VDD VDD) g45p1lvt w=(3.1e-07) l=4.5e-08 nf=1 \
        as=8.15e-14 ad=5.58e-14 ps=1.44e-06 pd=9.8e-07 nrd=1.16667 \
        nrs=1.16667 sa=1.7e-07 sb=1.30419e-06 sd=160n sca=35.6995 \
        scb=0.0234062 scc=0.00420468 m=(1)
mp32 (\12\:mout \4\:n20 n26 VDD) g45p1lvt w=(3.1e-07) l=4.5e-08 nf=1 \
        as=5.58e-14 ad=7e-14 ps=9.8e-07 pd=1.32e-06 nrd=1.16667 \
        nrs=1.16667 sa=3.95e-07 sb=1.07919e-06 sd=160n sca=35.6995 \
        scb=0.0234062 scc=0.00420468 m=(1)
mp30 (\12\:mout \4\:SN \16\:VDD VDD) g45p1lvt w=(3.1e-07) l=4.5e-08 nf=1 \
        as=9e-14 ad=7e-14 ps=1.36e-06 pd=1.32e-06 nrd=1.16667 nrs=1.16667 \
        sa=4.74194e-07 sb=1.26774e-06 sd=160n sca=14.8314 scb=0.0138806 \
        scc=0.000865287 m=(1)
mp35 (n31 mout \16\:VDD VDD) g45p1lvt w=(3.1e-07) l=4.5e-08 nf=1 \
        as=9e-14 ad=7.13e-14 ps=1.36e-06 pd=1.08e-06 nrd=1.16667 \
        nrs=1.16667 sa=7.59194e-07 sb=9.82742e-07 sd=160n sca=14.8314 \
        scb=0.0138806 scc=0.000865287 m=(1)
mp36 (\6\:n20 \5\:CKb n31 VDD) g45p1lvt w=(3.1e-07) l=4.5e-08 nf=1 \
        as=7.13e-14 ad=7.42e-14 ps=1.08e-06 pd=1.11e-06 nrd=1.16667 \
        nrs=1.16667 sa=1.03419e-06 sb=7.07742e-07 sd=160n sca=14.8314 \
        scb=0.0138806 scc=0.000865287 m=(1)
mp26 (\6\:n20 \5\:CKbb n22 VDD) g45p1lvt w=(3.1e-07) l=4.5e-08 nf=1 \
        as=3.565e-14 ad=7.42e-14 ps=8.5e-07 pd=1.11e-06 nrd=1.16667 \
        nrs=1.16667 sa=1.29621e-06 sb=4.29919e-07 sd=160n sca=14.4984 \
        scb=0.0135284 scc=0.000799873 m=(1)
mp25 (n22 \4\:D \14\:VDD VDD) g45p1lvt w=(3.1e-07) l=4.5e-08 nf=1 \
        as=4.39e-14 ad=3.565e-14 ps=9.4e-07 pd=8.5e-07 nrd=1.16667 \
        nrs=1.16667 sa=1.45621e-06 sb=2.69919e-07 sd=160n sca=14.4984 \
        scb=0.0135284 scc=0.000799873 m=(1)
mp22 (\7\:RNb \3\:RN \22\:VDD VDD) g45p1lvt w=(2.15e-07) l=4.5e-08 nf=1 \
        as=1.102e-13 ad=2.87e-14 ps=2.44e-06 pd=7.5e-07 nrd=1.16667 \
        nrs=1.16667 sa=1.33488e-07 sb=3.48837e-07 sd=160n sca=19.7413 \
        scb=0.019281 scc=0.00179464 m=(1)
mp21 (\8\:CKbb \9\:CKb \14\:VDD VDD) g45p1lvt w=(2.15e-07) l=4.5e-08 \
        nf=1 as=4.39e-14 ad=3.01e-14 ps=9.4e-07 pd=7.1e-07 nrd=1.16667 \
        nrs=1.16667 sa=1.83605e-06 sb=1.4e-07 sd=160n sca=16.4667 \
        scb=0.0163489 scc=0.00112485 m=(1)
mp20 (\12\:CKb \1\:CK \1\:VDD VDD) g45p1lvt w=(2.15e-07) l=4.5e-08 nf=1 \
        as=3.87e-14 ad=5.052e-14 ps=7.9e-07 pd=9e-07 nrd=1.16667 \
        nrs=1.16667 sa=2.35e-07 sb=1.8e-07 sd=160n sca=53.9205 \
        scb=0.0402944 scc=0.00632464 m=(1)
ends DFFSRHQX2
// End of subcircuit definition.
