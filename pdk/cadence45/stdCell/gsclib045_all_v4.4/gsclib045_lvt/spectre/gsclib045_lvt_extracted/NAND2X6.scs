// Generated for: spectre (May  1 09:16:35 2013 )
// Library name: gsclib045_lvt
// Cell name: NAND2X6
// View name: extracted

simulator lang=spectre

subckt NAND2X6 A B VDD VSS Y
mp0_1__rcx (\1\:Y \2\:A VDD VDD) g45p1lvt w=(3.9e-07) l=4.5e-08 nf=1 \
        as=5.98e-14 ad=6.305e-14 ps=1.08667e-06 pd=1.10333e-06 nrd=1.16667 \
        nrs=1.16667 sa=1.4e-07 sb=2e-06 sd=160n sca=32.0426 scb=0.0350053 \
        scc=0.00300251 m=(6)
mp1_1__rcx (\1\:Y B VDD VDD) g45p1lvt w=(3.9e-07) l=4.5e-08 nf=1 \
        as=6.24e-14 ad=6.305e-14 ps=1.1e-06 pd=1.10333e-06 nrd=1.16667 \
        nrs=1.16667 sa=3.45e-07 sb=2e-06 sd=160n sca=22.0088 scb=0.0203326 \
        scc=0.00163789 m=(6)
C1 (A VSS) capacitor c=1.09831e-17
C2 (Y VSS) capacitor c=8.65689e-17
C3 (VDD VSS) capacitor c=6.06685e-16
C4 (B VSS) capacitor c=8.13246e-16
C5 (6 VSS) capacitor c=5.30371e-18
C6 (7 VSS) capacitor c=2.54934e-18
C7 (8 VSS) capacitor c=8.5648e-18
C8 (9 VSS) capacitor c=1.82949e-18
C9 (10 VSS) capacitor c=1.79953e-18
C10 (\16\:B VSS) capacitor c=6.98908e-17
C11 (\11\:A VSS) capacitor c=5.43052e-17
C12 (\15\:A VSS) capacitor c=5.29641e-17
C13 (\8\:B VSS) capacitor c=6.35861e-17
C14 (\12\:B VSS) capacitor c=2.68954e-17
C15 (\4\:A VSS) capacitor c=2.42979e-17
C16 (\8\:A VSS) capacitor c=4.34053e-17
C17 (\1\:B VSS) capacitor c=4.74912e-17
C18 (\5\:B VSS) capacitor c=5.812e-17
C19 (\1\:A VSS) capacitor c=5.49718e-17
C20 (\2\:A VSS) capacitor c=9.57084e-16
C21 (\1\:Y VSS) capacitor c=6.75947e-16
C22 (\12\:Y VSS) capacitor c=1.7196e-17
C23 (\28\:Y VSS) capacitor c=2.32985e-17
C24 (\30\:Y VSS) capacitor c=1.16692e-16
C25 (\11\:Y VSS) capacitor c=1.1812e-16
C26 (\27\:Y VSS) capacitor c=1.17947e-16
Rk45 (\2\:VSS \3\:VSS) resistor r=0.4104 c=0
Rk46 (\3\:VSS \4\:VSS) resistor r=0.29 c=0
Rk47 (\4\:VSS \5\:VSS) resistor r=0.1469 c=0
Rk49 (\6\:VSS VSS) resistor r=0.04974 c=0
Rk48 (\5\:VSS \6\:VSS) resistor r=0.3525 c=0
Rk50 (\3\:VSS \8\:VSS) resistor r=0.1262 c=0
Rk51 (\5\:VSS \10\:VSS) resistor r=0.1262 c=0
Rk52 (\6\:VSS \12\:VSS) resistor r=0.2827 c=0
Rk8 (\2\:A A) resistor r=0.01242 c=0
Rk16 (\1\:Y Y) resistor r=0.1688 c=0
Rk17 (Y \11\:Y) resistor r=0.6436 c=0
Rk18 (\11\:Y \13\:Y) resistor r=0.04664 c=0
Rk28 (\11\:Y \27\:Y) resistor r=0.5467 c=0
Rk29 (\27\:Y \29\:Y) resistor r=0.04664 c=0
Rk30 (\27\:Y \31\:Y) resistor r=0.7599 c=0
Rl20 (\2\:A \11\:A) resistor r=34.6466 c=0
Rl23 (\2\:A \15\:A) resistor r=34.3295 c=0
Rl9 (\2\:A \4\:A) resistor r=34.0954 c=0
Rl12 (\2\:A \8\:A) resistor r=34.7148 c=0
Rl1 (\2\:A \1\:A) resistor r=26.9231 c=0
Rl27 (B \16\:B) resistor r=76.7373 c=0
Rl15 (B \8\:B) resistor r=91.0296 c=0
Rl18 (B \12\:B) resistor r=75.8974 c=0
Rl3 (B \1\:B) resistor r=80.7323 c=0
Rl6 (B \5\:B) resistor r=81.9857 c=0
Rz6 (\7\:VSS \8\:VSS) resistor r=37.5 c=0
Rz7 (\9\:VSS \10\:VSS) resistor r=37.5 c=0
Rz8 (\11\:VSS \12\:VSS) resistor r=37.5 c=0
Rz1 (\13\:Y \12\:Y) resistor r=37.5 c=0
Rz2 (\29\:Y \28\:Y) resistor r=37.5 c=0
Rz3 (\31\:Y \30\:Y) resistor r=37.5 c=0
Ry20 (\1\:VSS \2\:VSS) resistor r=31 c=0
Ry21 (\1\:VSS \4\:VSS) resistor r=5.1667 c=0
mn0_1__rcx (6 \1\:A \11\:VSS VSS) g45n1lvt w=(3.1e-07) l=4.5e-08 nf=1 \
        as=4.34e-14 ad=1.86e-14 ps=9e-07 pd=7.4e-07 nrd=1.16667 \
        nrs=1.16667 sa=1.4e-07 sb=1.855e-06 sd=160n sca=12.1492 \
        scb=0.0116051 scc=0.000678556 m=(1)
mn1_1__rcx (\30\:Y \5\:B 6 VSS) g45n1lvt w=(3.1e-07) l=4.5e-08 nf=1 \
        as=1.86e-14 ad=5.89e-14 ps=7.4e-07 pd=1e-06 nrd=1.16667 \
        nrs=1.16667 sa=2.45e-07 sb=1.75e-06 sd=160n sca=12.1492 \
        scb=0.0116051 scc=0.000678556 m=(1)
mn1_2__rcx (\30\:Y \1\:B 7 VSS) g45n1lvt w=(3.1e-07) l=4.5e-08 nf=1 \
        as=2.635e-14 ad=5.89e-14 ps=7.9e-07 pd=1e-06 nrd=1.16667 \
        nrs=1.16667 sa=4.8e-07 sb=1.515e-06 sd=160n sca=12.1492 \
        scb=0.0116051 scc=0.000678556 m=(1)
mn0_2__rcx (7 \8\:A \9\:VSS VSS) g45n1lvt w=(3.1e-07) l=4.5e-08 nf=1 \
        as=8.26e-14 ad=2.635e-14 ps=1.3e-06 pd=7.9e-07 nrd=1.16667 \
        nrs=1.16667 sa=6.1e-07 sb=1.385e-06 sd=160n sca=12.1492 \
        scb=0.0116051 scc=0.000678556 m=(1)
mn0_3__rcx (8 \4\:A \9\:VSS VSS) g45n1lvt w=(3.1e-07) l=4.5e-08 nf=1 \
        as=8.26e-14 ad=7.905e-14 ps=1.3e-06 pd=1.13e-06 nrd=1.16667 \
        nrs=1.16667 sa=8.75e-07 sb=1.12e-06 sd=160n sca=12.1492 \
        scb=0.0116051 scc=0.000678556 m=(1)
mn1_3__rcx (\28\:Y \12\:B 8 VSS) g45n1lvt w=(3.1e-07) l=4.5e-08 nf=1 \
        as=7.905e-14 ad=4.96e-14 ps=1.13e-06 pd=9.4e-07 nrd=1.16667 \
        nrs=1.16667 sa=1.175e-06 sb=8.2e-07 sd=160n sca=12.1492 \
        scb=0.0116051 scc=0.000678556 m=(1)
mn1_4__rcx (\28\:Y \8\:B 9 VSS) g45n1lvt w=(3.1e-07) l=4.5e-08 nf=1 \
        as=1.86e-14 ad=4.96e-14 ps=7.4e-07 pd=9.4e-07 nrd=1.16667 \
        nrs=1.16667 sa=1.38e-06 sb=6.15e-07 sd=160n sca=12.1492 \
        scb=0.0116051 scc=0.000678556 m=(1)
mn0_4__rcx (9 \15\:A \7\:VSS VSS) g45n1lvt w=(3.1e-07) l=4.5e-08 nf=1 \
        as=8.26e-14 ad=1.86e-14 ps=1.3e-06 pd=7.4e-07 nrd=1.16667 \
        nrs=1.16667 sa=1.485e-06 sb=5.1e-07 sd=160n sca=12.1492 \
        scb=0.0116051 scc=0.000678556 m=(1)
mn0 (10 \11\:A \7\:VSS VSS) g45n1lvt w=(3.1e-07) l=4.5e-08 nf=1 \
        as=8.26e-14 ad=1.86e-14 ps=1.3e-06 pd=7.4e-07 nrd=1.16667 \
        nrs=1.16667 sa=1.75e-06 sb=2.45e-07 sd=160n sca=12.1492 \
        scb=0.0116051 scc=0.000678556 m=(1)
mn1 (\12\:Y \16\:B 10 VSS) g45n1lvt w=(3.1e-07) l=4.5e-08 nf=1 \
        as=1.86e-14 ad=4.34e-14 ps=7.4e-07 pd=9e-07 nrd=1.16667 \
        nrs=1.16667 sa=1.855e-06 sb=1.4e-07 sd=160n sca=12.1492 \
        scb=0.0116051 scc=0.000678556 m=(1)
ends NAND2X6
// End of subcircuit definition.
