// Generated for: spectre (May  1 09:18:00 2013 )
// Library name: gsclib045_lvt
// Cell name: OAI21X2
// View name: extracted

simulator lang=spectre

subckt OAI21X2 A0 A1 B0 VDD VSS Y
mp0_1__rcx (1 \1\:A0 \9\:VDD VDD) g45p1lvt w=(3.9e-07) l=4.5e-08 nf=1 \
        as=5.85e-14 ad=3.315e-14 ps=1.08e-06 pd=9.5e-07 nrd=1.16667 \
        nrs=1.16667 sa=1.5e-07 sb=1.025e-06 sd=160n sca=14.3979 \
        scb=0.0128198 scc=0.000254146 m=(1)
mp1_1__rcx (\6\:Y \6\:A1 1 VDD) g45p1lvt w=(3.9e-07) l=4.5e-08 nf=1 \
        as=3.315e-14 ad=6.24e-14 ps=9.5e-07 pd=1.1e-06 nrd=1.16667 \
        nrs=1.16667 sa=2.8e-07 sb=8.95e-07 sd=160n sca=12.9324 \
        scb=0.0106401 scc=0.000233941 m=(1)
mp1 (\6\:Y \1\:A1 4 VDD) g45p1lvt w=(3.9e-07) l=4.5e-08 nf=1 as=2.34e-14 \
        ad=6.24e-14 ps=9e-07 pd=1.1e-06 nrd=1.16667 nrs=1.16667 \
        sa=4.85e-07 sb=6.9e-07 sd=160n sca=11.8564 scb=0.00969513 \
        scc=0.0002319 m=(1)
mp0 (4 \6\:A0 \1\:VDD VDD) g45p1lvt w=(3.9e-07) l=4.5e-08 nf=1 \
        as=7.605e-14 ad=2.34e-14 ps=1.17e-06 pd=9e-07 nrd=1.16667 \
        nrs=1.16667 sa=5.9e-07 sb=5.85e-07 sd=160n sca=11.6462 \
        scb=0.00959597 scc=0.000231862 m=(1)
mp2 (\4\:Y \1\:B0 \1\:VDD VDD) g45p1lvt w=(3.9e-07) l=4.5e-08 nf=1 \
        as=6.532e-14 ad=6.24e-14 ps=1.115e-06 pd=1.1e-06 nrd=1.16667 \
        nrs=1.16667 sa=8.3e-07 sb=3.45e-07 sd=160n sca=12.2699 \
        scb=0.00996585 scc=0.000232152 m=(2)
C1 (B0 VSS) capacitor c=1.55439e-17
C2 (Y VSS) capacitor c=2.91841e-17
C3 (A0 VSS) capacitor c=3.25037e-16
C4 (A1 VSS) capacitor c=5.61425e-17
C5 (VDD VSS) capacitor c=1.05692e-16
C6 (n0 VSS) capacitor c=9.16589e-17
C7 (1 VSS) capacitor c=3.4798e-18
C8 (4 VSS) capacitor c=1.86068e-18
C9 (\6\:A0 VSS) capacitor c=8.4418e-17
C10 (\1\:A1 VSS) capacitor c=6.20032e-17
C11 (\6\:A1 VSS) capacitor c=4.29888e-17
C12 (\1\:A0 VSS) capacitor c=6.6294e-17
C13 (\1\:B0 VSS) capacitor c=1.56504e-16
C14 (\1\:VDD VSS) capacitor c=9.78645e-17
C15 (\4\:Y VSS) capacitor c=8.50857e-17
C16 (\6\:Y VSS) capacitor c=9.70182e-17
C17 (\9\:VDD VSS) capacitor c=5.18611e-17
C18 (\1\:Y VSS) capacitor c=4.18405e-17
C19 (\2\:A1 VSS) capacitor c=1.43298e-16
C20 (\7\:A1 VSS) capacitor c=6.37633e-17
C21 (\3\:Y VSS) capacitor c=4.59532e-17
C22 (\8\:B0 VSS) capacitor c=8.22814e-17
C23 (\2\:n0 VSS) capacitor c=1.70771e-16
C24 (\5\:VDD VSS) capacitor c=2.2763e-17
C25 (\6\:VDD VSS) capacitor c=1.29027e-17
Rk10 (B0 \8\:B0) resistor r=0.02037 c=0
Rk6 (\3\:Y Y) resistor r=0.1105 c=0
Rk4 (\2\:Y \3\:Y) resistor r=0.2433 c=0
Rk5 (\3\:Y \5\:Y) resistor r=0.2361 c=0
Rk7 (\5\:Y \7\:Y) resistor r=0.3796 c=0
Rk8 (\7\:Y \8\:Y) resistor r=0.1523 c=0
Rk9 (\5\:Y \9\:Y) resistor r=0.1555 c=0
Rk1 (\7\:A1 A1) resistor r=0.192 c=0
Rk22 (\1\:VSS VSS) resistor r=0.1843 c=0
Rk15 (\1\:VDD \5\:VDD) resistor r=0.04224 c=0
Rk17 (\6\:VDD VDD) resistor r=0.1144 c=0
Rk16 (\5\:VDD \6\:VDD) resistor r=0.2844 c=0
Rk19 (\6\:VDD \10\:VDD) resistor r=0.2616 c=0
Rl9 (A0 \6\:A0) resistor r=78.6412 c=0
Rl1 (A0 \1\:A0) resistor r=96.1538 c=0
Rl3 (\2\:A1 \1\:A1) resistor r=47.3105 c=0
Rl7 (\2\:A1 \6\:A1) resistor r=24.2328 c=0
Rz1 (\2\:Y \1\:Y) resistor r=75 c=0
Rz2 (\2\:n0 n0) resistor r=75 c=0
Ry1 (\5\:Y \4\:Y) resistor r=62 c=0
Ry2 (\7\:Y \6\:Y) resistor r=62 c=0
Ry3 (\8\:Y \6\:Y) resistor r=62 c=0
Ry4 (\9\:Y \4\:Y) resistor r=62 c=0
Ry7 (\10\:VDD \9\:VDD) resistor r=20.6667 c=0
Rx4 (\8\:B0 \1\:B0) resistor r=45 c=0
Rx1 (\7\:A1 \2\:A1) resistor r=45 c=0
mn1 (n0 \2\:A1 \1\:VSS VSS) g45n1lvt w=(2.6e-07) l=4.5e-08 nf=1 \
        as=4.16e-14 ad=4.16e-14 ps=8.4e-07 pd=8.4e-07 nrd=1.16667 \
        nrs=1.16667 sa=3.45e-07 sb=1.025e-06 sd=160n sca=17.5885 \
        scb=0.0172826 scc=0.00162584 m=(2)
mn0 (\2\:n0 A0 \1\:VSS VSS) g45n1lvt w=(2.6e-07) l=4.5e-08 nf=1 \
        as=4.16e-14 ad=4.745e-14 ps=8.4e-07 pd=8.85e-07 nrd=1.16667 \
        nrs=1.16667 sa=1.4e-07 sb=1.23e-06 sd=160n sca=17.5885 \
        scb=0.0172826 scc=0.00162584 m=(2)
mn2 (\1\:Y \1\:B0 \2\:n0 VSS) g45n1lvt w=(2.6e-07) l=4.5e-08 nf=1 \
        as=4.745e-14 ad=4.16e-14 ps=8.85e-07 pd=8.4e-07 nrd=1.16667 \
        nrs=1.16667 sa=1.025e-06 sb=3.45e-07 sd=160n sca=17.5885 \
        scb=0.0172826 scc=0.00162584 m=(2)
ends OAI21X2
// End of subcircuit definition.
