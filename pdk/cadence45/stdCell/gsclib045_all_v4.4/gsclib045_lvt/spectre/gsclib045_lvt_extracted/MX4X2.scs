// Generated for: spectre (May  1 09:16:06 2013 )
// Library name: gsclib045_lvt
// Cell name: MX4X2
// View name: extracted

simulator lang=spectre

subckt MX4X2 A B C D S0 S1 VDD VSS Y
mp10 (\9\:n2 \4\:S1 \4\:n0 VDD) g45p1lvt w=(2.15e-07) l=4.5e-08 nf=1 \
        as=4.085e-14 ad=3.44e-14 ps=8.1e-07 pd=7.5e-07 nrd=1.16667 \
        nrs=1.16667 sa=1.9e-07 sb=3.45e-07 sd=160n sca=44.5479 \
        scb=0.0294091 scc=0.00553812 m=(1)
mp11 (\5\:n1 \5\:S1b \9\:n2 VDD) g45p1lvt w=(2.15e-07) l=4.5e-08 nf=1 \
        as=3.44e-14 ad=3.01e-14 ps=7.5e-07 pd=7.1e-07 nrd=1.16667 \
        nrs=1.16667 sa=3.95e-07 sb=1.4e-07 sd=160n sca=43.2688 \
        scb=0.0280932 scc=0.00553387 m=(1)
mp1 (\8\:S1b \1\:S1 \6\:VDD VDD) g45p1lvt w=(2.15e-07) l=4.5e-08 nf=1 \
        as=1.093e-13 ad=3.01e-14 ps=2.21e-06 pd=7.1e-07 nrd=1.16667 \
        nrs=1.16667 sa=1.4e-07 sb=6.6e-07 sd=160n sca=42.6522 \
        scb=0.0278545 scc=0.00553378 m=(1)
mp2 (n4 \1\:A \6\:VDD VDD) g45p1lvt w=(2.15e-07) l=4.5e-08 nf=1 \
        as=1.0353e-13 ad=4.73e-14 ps=1.7e-06 pd=8.7e-07 nrd=1.16667 \
        nrs=1.16667 sa=6.12674e-07 sb=2e-06 sd=160n sca=10.9013 \
        scb=0.00874909 scc=0.000160703 m=(1)
mp3 (\6\:n0 \1\:S0 n4 VDD) g45p1lvt w=(2.15e-07) l=4.5e-08 nf=1 \
        as=4.73e-14 ad=4.515e-14 ps=8.7e-07 pd=8.5e-07 nrd=1.16667 \
        nrs=1.16667 sa=8.77674e-07 sb=2e-06 sd=160n sca=10.9013 \
        scb=0.00874909 scc=0.000160703 m=(1)
mp5 (\6\:n0 S0b n6 VDD) g45p1lvt w=(2.15e-07) l=4.5e-08 nf=1 as=4.408e-14 \
        ad=4.515e-14 ps=8.4e-07 pd=8.5e-07 nrd=1.16667 nrs=1.16667 \
        sa=1.13267e-06 sb=2e-06 sd=160n sca=10.9013 scb=0.00874909 \
        scc=0.000160703 m=(1)
mp4 (n6 \3\:B \11\:VDD VDD) g45p1lvt w=(2.15e-07) l=4.5e-08 nf=1 \
        as=1.1745e-13 ad=4.408e-14 ps=1.77e-06 pd=8.4e-07 nrd=1.16667 \
        nrs=1.16667 sa=1.38267e-06 sb=1.86e-06 sd=160n sca=10.9013 \
        scb=0.00874909 scc=0.000160703 m=(1)
mp6 (n8 \1\:C \11\:VDD VDD) g45p1lvt w=(2.15e-07) l=4.5e-08 nf=1 \
        as=1.1745e-13 ad=3.763e-14 ps=1.77e-06 pd=7.8e-07 nrd=1.16667 \
        nrs=1.16667 sa=1.81767e-06 sb=1.425e-06 sd=160n sca=10.9013 \
        scb=0.00874909 scc=0.000160703 m=(1)
mp7 (\7\:n1 \8\:S0 n8 VDD) g45p1lvt w=(2.15e-07) l=4.5e-08 nf=1 \
        as=3.763e-14 ad=9.783e-14 ps=7.8e-07 pd=1.34e-06 nrd=1.16667 \
        nrs=1.16667 sa=1.93349e-06 sb=1.205e-06 sd=160n sca=10.9013 \
        scb=0.00874909 scc=0.000160703 m=(1)
mp9 (\7\:n1 \6\:S0b n10 VDD) g45p1lvt w=(2.15e-07) l=4.5e-08 nf=1 \
        as=1.505e-14 ad=9.783e-14 ps=5.7e-07 pd=1.34e-06 nrd=1.16667 \
        nrs=1.16667 sa=2e-06 sb=7.05e-07 sd=160n sca=11.0244 \
        scb=0.00877578 scc=0.000160706 m=(1)
mp8 (n10 \1\:D \9\:VDD VDD) g45p1lvt w=(2.15e-07) l=4.5e-08 nf=1 \
        as=8.708e-14 ad=1.505e-14 ps=1.24e-06 pd=5.7e-07 nrd=1.16667 \
        nrs=1.16667 sa=2e-06 sb=5.9e-07 sd=160n sca=11.3376 scb=0.00888972 \
        scc=0.00016074 m=(1)
mp0 (\8\:S0b \9\:S0 \9\:VDD VDD) g45p1lvt w=(2.15e-07) l=4.5e-08 nf=1 \
        as=8.708e-14 ad=3.01e-14 ps=1.24e-06 pd=7.1e-07 nrd=1.16667 \
        nrs=1.16667 sa=2e-06 sb=1.4e-07 sd=160n sca=16.2936 scb=0.0162078 \
        scc=0.00030445 m=(1)
C1 (S1 VSS) capacitor c=3.03135e-17
C2 (C VSS) capacitor c=5.89194e-17
C3 (S0 VSS) capacitor c=5.05854e-17
C4 (VDD VSS) capacitor c=3.64229e-16
C5 (B VSS) capacitor c=5.35605e-17
C6 (D VSS) capacitor c=7.52301e-17
C7 (A VSS) capacitor c=4.53854e-17
C8 (Y VSS) capacitor c=4.17646e-17
C9 (n2 VSS) capacitor c=1.66162e-16
C10 (S1b VSS) capacitor c=3.27637e-17
C11 (n0 VSS) capacitor c=1.38309e-16
C12 (n1 VSS) capacitor c=3.5461e-16
C13 (n3 VSS) capacitor c=7.21662e-18
C14 (S0b VSS) capacitor c=2.59494e-17
C15 (n5 VSS) capacitor c=4.71508e-19
C16 (n7 VSS) capacitor c=1.02499e-17
C17 (n4 VSS) capacitor c=8.22888e-18
C18 (n6 VSS) capacitor c=5.22066e-18
C19 (n10 VSS) capacitor c=1.44701e-19
C20 (\9\:S0 VSS) capacitor c=3.72407e-17
C21 (\1\:D VSS) capacitor c=6.17538e-17
C22 (\6\:S0b VSS) capacitor c=5.12034e-17
C23 (\8\:S0 VSS) capacitor c=3.77279e-17
C24 (\1\:C VSS) capacitor c=3.72744e-17
C25 (\3\:B VSS) capacitor c=3.00478e-17
C26 (\1\:S0 VSS) capacitor c=3.64099e-17
C27 (\1\:A VSS) capacitor c=4.9018e-17
C28 (\1\:S1 VSS) capacitor c=4.18059e-17
C29 (\5\:S1b VSS) capacitor c=3.46653e-17
C30 (\4\:S1 VSS) capacitor c=6.02821e-17
C31 (\11\:S0 VSS) capacitor c=1.95059e-17
C32 (\3\:D VSS) capacitor c=4.02086e-17
C33 (\5\:S0 VSS) capacitor c=3.20619e-17
C34 (\4\:S0b VSS) capacitor c=4.05942e-17
C35 (\3\:C VSS) capacitor c=4.02775e-17
C36 (\1\:B VSS) capacitor c=8.20868e-17
C37 (\3\:S0 VSS) capacitor c=6.58262e-17
C38 (\3\:S0b VSS) capacitor c=5.39876e-17
C39 (\3\:A VSS) capacitor c=2.84391e-17
C40 (\5\:S1 VSS) capacitor c=2.38565e-17
C41 (\6\:S1 VSS) capacitor c=2.28106e-17
C42 (\10\:S0 VSS) capacitor c=2.88049e-17
C43 (\2\:D VSS) capacitor c=4.59045e-17
C44 (\7\:S0b VSS) capacitor c=3.46285e-17
C45 (\6\:S0 VSS) capacitor c=6.65703e-17
C46 (\5\:S0b VSS) capacitor c=3.80151e-17
C47 (\7\:S0 VSS) capacitor c=6.40273e-17
C48 (\2\:C VSS) capacitor c=4.69178e-17
C49 (\2\:B VSS) capacitor c=4.41742e-17
C50 (\4\:S0 VSS) capacitor c=4.14976e-17
C51 (\2\:S0b VSS) capacitor c=4.7716e-17
C52 (\2\:S0 VSS) capacitor c=3.16081e-17
C53 (\2\:A VSS) capacitor c=3.29075e-17
C54 (\2\:S1 VSS) capacitor c=5.61893e-17
C55 (\3\:S1b VSS) capacitor c=4.4254e-17
C56 (\4\:S1b VSS) capacitor c=4.82849e-17
C57 (\2\:S1b VSS) capacitor c=2.34723e-17
C58 (\8\:S0b VSS) capacitor c=8.8745e-18
C59 (\9\:VDD VSS) capacitor c=4.33854e-17
C60 (\7\:n1 VSS) capacitor c=1.17298e-16
C61 (\11\:VDD VSS) capacitor c=3.24796e-17
C62 (\6\:n0 VSS) capacitor c=3.2839e-17
C63 (\1\:Y VSS) capacitor c=7.1067e-17
C64 (\8\:S1b VSS) capacitor c=5.80819e-17
C65 (\5\:n1 VSS) capacitor c=8.90701e-17
C66 (\9\:n2 VSS) capacitor c=1.88379e-16
C67 (\4\:n0 VSS) capacitor c=2.18826e-16
C68 (\1\:VDD VSS) capacitor c=8.62528e-17
C69 (\14\:S0b VSS) capacitor c=5.73979e-17
C70 (\3\:Y VSS) capacitor c=3.32595e-17
C71 (\11\:S1b VSS) capacitor c=6.33625e-17
C72 (\3\:n1 VSS) capacitor c=3.41271e-16
C73 (\11\:n2 VSS) capacitor c=9.15842e-17
C74 (\8\:n0 VSS) capacitor c=6.20326e-17
C75 (\3\:S1 VSS) capacitor c=5.68542e-17
C76 (\6\:S1b VSS) capacitor c=1.47833e-16
C77 (\7\:S1b VSS) capacitor c=1.1811e-16
C78 (\10\:S1b VSS) capacitor c=5.73696e-17
C79 (\7\:S1 VSS) capacitor c=7.88409e-17
C80 (\8\:n2 VSS) capacitor c=1.49059e-16
C81 (\4\:A VSS) capacitor c=5.1485e-17
C82 (\3\:n0 VSS) capacitor c=2.81283e-16
C83 (\4\:B VSS) capacitor c=5.65839e-17
C84 (\4\:C VSS) capacitor c=2.45936e-17
C85 (\12\:S0 VSS) capacitor c=8.24824e-17
C86 (\13\:S0 VSS) capacitor c=9.20341e-17
C87 (\14\:S0 VSS) capacitor c=6.9139e-17
C88 (\4\:D VSS) capacitor c=4.4904e-17
C89 (\15\:S0 VSS) capacitor c=6.35834e-17
C90 (\16\:S0 VSS) capacitor c=7.79906e-17
C91 (\10\:S0b VSS) capacitor c=7.45014e-17
C92 (\11\:S0b VSS) capacitor c=1.07957e-16
C93 (\12\:S0b VSS) capacitor c=1.75561e-16
C94 (\13\:S0b VSS) capacitor c=1.33944e-16
C95 (\16\:S0b VSS) capacitor c=2.47153e-17
C96 (\17\:S0b VSS) capacitor c=9.53017e-17
C97 (\3\:VDD VSS) capacitor c=2.72385e-17
C98 (\5\:VDD VSS) capacitor c=4.12621e-17
C99 (\6\:VDD VSS) capacitor c=1.05216e-16
Rk4 (S1 \7\:S1) resistor r=0.01942 c=0
Rk15 (\4\:C C) resistor r=0.09804 c=0
Rk16 (\12\:S0 \13\:S0) resistor r=0.5455 c=0
Rk17 (\13\:S0 \14\:S0) resistor r=0.4359 c=0
Rk22 (S0 \15\:S0) resistor r=0.143 c=0
Rk23 (\15\:S0 \16\:S0) resistor r=0.4525 c=0
Rk31 (\2\:VDD \3\:VDD) resistor r=0.2932 c=0
Rk32 (\3\:VDD \4\:VDD) resistor r=0.3584 c=0
Rk33 (\4\:VDD \5\:VDD) resistor r=0.2622 c=0
Rk34 (\5\:VDD \6\:VDD) resistor r=0.6056 c=0
Rk37 (\8\:VDD VDD) resistor r=0.5515 c=0
Rk36 (\6\:VDD \8\:VDD) resistor r=0.1117 c=0
Rk38 (\3\:VDD \10\:VDD) resistor r=0.2729 c=0
Rk39 (\5\:VDD \12\:VDD) resistor r=0.04331 c=0
Rk14 (B \4\:B) resistor r=0.01225 c=0
Rk21 (D \4\:D) resistor r=0.01986 c=0
Rk9 (\4\:A A) resistor r=0.1913 c=0
Rk7 (\2\:Y Y) resistor r=0.1971 c=0
Rk8 (Y \4\:Y) resistor r=0.1065 c=0
Rk42 (\2\:VSS \3\:VSS) resistor r=0.3083 c=0
Rk43 (\3\:VSS \4\:VSS) resistor r=0.3434 c=0
Rk44 (\4\:VSS \5\:VSS) resistor r=0.2155 c=0
Rk45 (\5\:VSS \6\:VSS) resistor r=0.5664 c=0
Rk48 (\8\:VSS VSS) resistor r=0.5515 c=0
Rk47 (\6\:VSS \8\:VSS) resistor r=0.09009 c=0
Rk49 (\3\:VSS \10\:VSS) resistor r=0.2831 c=0
Rk50 (\5\:VSS \12\:VSS) resistor r=0.2007 c=0
Rk5 (\8\:n2 \10\:n2) resistor r=1.0286 c=0
Rk6 (\10\:n2 \12\:n2) resistor r=0.4267 c=0
Rk1 (\6\:S1b \7\:S1b) resistor r=0.8716 c=0
Rk2 (\9\:S1b \10\:S1b) resistor r=0.1566 c=0
Rk3 (\10\:S1b \12\:S1b) resistor r=0.1913 c=0
Rk10 (\2\:n0 \3\:n0) resistor r=0.8572 c=0
Rk11 (\3\:n0 \5\:n0) resistor r=1.6974 c=0
Rk12 (\3\:n0 \7\:n0) resistor r=0.1728 c=0
Rk13 (\5\:n0 \9\:n0) resistor r=0.4869 c=0
Rk18 (\2\:n1 \4\:n1) resistor r=2.6238 c=0
Rk19 (\4\:n1 \6\:n1) resistor r=0.4302 c=0
Rk20 (\2\:n1 \8\:n1) resistor r=0.6204 c=0
Rk24 (\9\:S0b \10\:S0b) resistor r=0.04795 c=0
Rk25 (\10\:S0b \11\:S0b) resistor r=0.5069 c=0
Rk26 (\11\:S0b \12\:S0b) resistor r=0.4962 c=0
Rk27 (\12\:S0b \13\:S0b) resistor r=0.9893 c=0
Rk28 (\10\:S0b \15\:S0b) resistor r=0.5141 c=0
Rk29 (\11\:S0b \16\:S0b) resistor r=0.1247 c=0
Rk30 (\12\:S0b \17\:S0b) resistor r=0.5379 c=0
Rl4 (\1\:S1 \2\:S1) resistor r=72.3097 c=0
Rl7 (\2\:S1 \5\:S1) resistor r=37.6944 c=0
Rl6 (\3\:S1 \4\:S1) resistor r=124.611 c=0
Rl8 (\3\:S1 \6\:S1) resistor r=30.4507 c=0
Rl5 (\2\:S1 \3\:S1) resistor r=211.505 c=0
Rl23 (\1\:C \2\:C) resistor r=77.6148 c=0
Rl24 (\2\:C \3\:C) resistor r=123.769 c=0
Rl32 (\9\:S0 \10\:S0) resistor r=171.846 c=0
Rl33 (\10\:S0 \11\:S0) resistor r=29.5379 c=0
Rl27 (\5\:S0 \6\:S0) resistor r=26.1559 c=0
Rl29 (\7\:S0 \8\:S0) resistor r=116.54 c=0
Rl28 (\6\:S0 \7\:S0) resistor r=201.031 c=0
Rl20 (\3\:S0 \4\:S0) resistor r=39.1533 c=0
Rl17 (\1\:S0 \2\:S0) resistor r=71.8456 c=0
Rl22 (\2\:B \3\:B) resistor r=29.9451 c=0
Rl21 (\1\:B \2\:B) resistor r=173.077 c=0
Rl30 (\1\:D \2\:D) resistor r=112.23 c=0
Rl31 (\2\:D \3\:D) resistor r=89.1533 c=0
Rl15 (\1\:A \2\:A) resistor r=148.769 c=0
Rl16 (\2\:A \3\:A) resistor r=52.6149 c=0
Rl3 (\4\:S1b \5\:S1b) resistor r=26.1559 c=0
Rl2 (\3\:S1b \4\:S1b) resistor r=92.2733 c=0
Rl1 (S1b \2\:S1b) resistor r=29.5379 c=0
Rl26 (\6\:S0b \7\:S0b) resistor r=29.5379 c=0
Rl25 (\4\:S0b \5\:S0b) resistor r=39.1533 c=0
Rl18 (S0b \2\:S0b) resistor r=24.2328 c=0
Rl19 (\2\:S0b \3\:S0b) resistor r=172.68 c=0
Rz9 (\2\:VDD \1\:VDD) resistor r=75 c=0
Rz10 (\4\:VDD \1\:VDD) resistor r=6.25 c=0
Rz11 (\8\:VDD \1\:VDD) resistor r=6.25 c=0
Rz3 (\4\:Y \3\:Y) resistor r=75 c=0
Rz12 (\10\:VSS \9\:VSS) resistor r=75 c=0
Rz13 (\12\:VSS \11\:VSS) resistor r=75 c=0
Rz2 (\12\:n2 \11\:n2) resistor r=75 c=0
Rz1 (\11\:S1b \12\:S1b) resistor r=75 c=0
Rz4 (n0 \2\:n0) resistor r=75 c=0
Rz5 (\8\:n0 \9\:n0) resistor r=75 c=0
Rz6 (n1 \2\:n1) resistor r=75 c=0
Rz7 (\3\:n1 \4\:n1) resistor r=75 c=0
Rz8 (\14\:S0b \15\:S0b) resistor r=75 c=0
Ry9 (\10\:VDD \9\:VDD) resistor r=62 c=0
Ry10 (\12\:VDD \11\:VDD) resistor r=62 c=0
Ry3 (\2\:Y \1\:Y) resistor r=62 c=0
Ry13 (\2\:VSS \1\:VSS) resistor r=62 c=0
Ry14 (\4\:VSS \1\:VSS) resistor r=5.1667 c=0
Ry15 (\8\:VSS \1\:VSS) resistor r=5.1667 c=0
Ry2 (\10\:n2 \9\:n2) resistor r=62 c=0
Ry1 (\8\:S1b \9\:S1b) resistor r=62 c=0
Ry4 (\4\:n0 \5\:n0) resistor r=62 c=0
Ry5 (\6\:n0 \7\:n0) resistor r=62 c=0
Ry6 (\5\:n1 \6\:n1) resistor r=62 c=0
Ry7 (\7\:n1 \8\:n1) resistor r=62 c=0
Ry8 (\8\:S0b \9\:S0b) resistor r=62 c=0
Rx4 (\2\:S1 \7\:S1) resistor r=45 c=0
Rx8 (\2\:C \4\:C) resistor r=45 c=0
Rx9 (\7\:S0 \12\:S0) resistor r=45 c=0
Rx10 (\4\:S0 \13\:S0) resistor r=45 c=0
Rx11 (\2\:S0 \14\:S0) resistor r=45 c=0
Rx13 (\10\:S0 \15\:S0) resistor r=45 c=0
Rx14 (\6\:S0 \16\:S0) resistor r=45 c=0
Rx7 (\2\:B \4\:B) resistor r=45 c=0
Rx12 (\2\:D \4\:D) resistor r=45 c=0
Rx6 (\2\:A \4\:A) resistor r=45 c=0
Rx5 (\8\:n2 n2) resistor r=45 c=0
Rx1 (\4\:S1b \6\:S1b) resistor r=45 c=0
Rx2 (\2\:S1b \7\:S1b) resistor r=45 c=0
Rx3 (\3\:S1b \10\:S1b) resistor r=45 c=0
Rx15 (\2\:S0b \13\:S0b) resistor r=45 c=0
Rx16 (\7\:S0b \16\:S0b) resistor r=45 c=0
Rx17 (\5\:S0b \17\:S0b) resistor r=45 c=0
mn10 (\11\:n2 S1b \8\:n0 VSS) g45n1lvt w=(1.45e-07) l=4.5e-08 nf=1 \
        as=2.465e-14 ad=3.553e-14 ps=6.3e-07 pd=7.8e-07 nrd=1.16667 \
        nrs=1.16667 sa=1.7e-07 sb=5.45e-07 sd=160n sca=11.9911 \
        scb=0.0120555 scc=0.000498628 m=(1)
mn11 (\11\:n2 \6\:S1 \3\:n1 VSS) g45n1lvt w=(1.45e-07) l=4.5e-08 nf=1 \
        as=3.698e-14 ad=3.553e-14 ps=8e-07 pd=7.8e-07 nrd=1.16667 \
        nrs=1.16667 sa=4.6e-07 sb=2.55e-07 sd=160n sca=11.9911 \
        scb=0.0120555 scc=0.000498628 m=(1)
mn1 (\11\:S1b \5\:S1 \6\:VSS VSS) g45n1lvt w=(1.45e-07) l=4.5e-08 nf=1 \
        as=1.0468e-13 ad=2.61e-14 ps=1.63e-06 pd=6.5e-07 nrd=1.16667 \
        nrs=1.16667 sa=1.8e-07 sb=2e-06 sd=160n sca=11.4452 scb=0.0112553 \
        scc=0.00042156 m=(1)
mn2 (n3 \3\:A \6\:VSS VSS) g45n1lvt w=(1.45e-07) l=4.5e-08 nf=1 \
        as=1.0335e-13 ad=6.815e-14 ps=1.58e-06 pd=1.23e-06 nrd=1.16667 \
        nrs=1.16667 sa=1.15e-06 sb=2e-06 sd=160n sca=11.4452 scb=0.0112553 \
        scc=0.00042156 m=(1)
mn3 (n0 \3\:S0b n3 VSS) g45n1lvt w=(1.45e-07) l=4.5e-08 nf=1 as=6.815e-14 \
        ad=2.32e-14 ps=1.23e-06 pd=6.1e-07 nrd=1.16667 nrs=1.16667 \
        sa=1.665e-06 sb=2e-06 sd=160n sca=11.4452 scb=0.0112553 \
        scc=0.00042156 m=(1)
mn5 (n0 \3\:S0 n5 VSS) g45n1lvt w=(1.45e-07) l=4.5e-08 nf=1 as=8.7e-15 \
        ad=2.32e-14 ps=4.1e-07 pd=6.1e-07 nrd=1.16667 nrs=1.16667 \
        sa=1.87e-06 sb=1.995e-06 sd=160n sca=11.4452 scb=0.0112553 \
        scc=0.00042156 m=(1)
mn4 (n5 \1\:B \11\:VSS VSS) g45n1lvt w=(1.45e-07) l=4.5e-08 nf=1 \
        as=6.418e-14 ad=8.7e-15 ps=1.22e-06 pd=4.1e-07 nrd=1.16667 \
        nrs=1.16667 sa=1.975e-06 sb=1.89e-06 sd=160n sca=11.4452 \
        scb=0.0112553 scc=0.00042156 m=(1)
mn6 (n7 \3\:C \11\:VSS VSS) g45n1lvt w=(1.45e-07) l=4.5e-08 nf=1 \
        as=6.418e-14 ad=5.148e-14 ps=1.22e-06 pd=1e-06 nrd=1.16667 \
        nrs=1.16667 sa=2e-06 sb=1.51e-06 sd=160n sca=11.4452 scb=0.0112553 \
        scc=0.00042156 m=(1)
mn7 (n1 \4\:S0b n7 VSS) g45n1lvt w=(1.45e-07) l=4.5e-08 nf=1 as=5.148e-14 \
        ad=3.045e-14 ps=1e-06 pd=7.1e-07 nrd=1.16667 nrs=1.16667 sa=2e-06 \
        sb=1.11e-06 sd=160n sca=11.4452 scb=0.0112553 scc=0.00042156 m=(1)
mn9 (n1 \5\:S0 n9 VSS) g45n1lvt w=(1.45e-07) l=4.5e-08 nf=1 as=1.958e-14 \
        ad=3.045e-14 ps=5.6e-07 pd=7.1e-07 nrd=1.16667 nrs=1.16667 \
        sa=2e-06 sb=8.55e-07 sd=160n sca=11.4452 scb=0.0112553 \
        scc=0.00042156 m=(1)
mn8 (n9 \3\:D \9\:VSS VSS) g45n1lvt w=(1.45e-07) l=4.5e-08 nf=1 \
        as=5.873e-14 ad=1.958e-14 ps=1.1e-06 pd=5.6e-07 nrd=1.16667 \
        nrs=1.16667 sa=2e-06 sb=6.75e-07 sd=160n sca=11.4452 scb=0.0112553 \
        scc=0.00042156 m=(1)
mn0 (\14\:S0b \11\:S0 \9\:VSS VSS) g45n1lvt w=(1.45e-07) l=4.5e-08 nf=1 \
        as=5.873e-14 ad=3.263e-14 ps=1.1e-06 pd=7.4e-07 nrd=1.16667 \
        nrs=1.16667 sa=2e-06 sb=2.25e-07 sd=160n sca=11.4452 scb=0.0112553 \
        scc=0.00042156 m=(1)
mn12_1__rcx (\3\:Y n2 \6\:VSS VSS) g45n1lvt w=(2.6e-07) l=4.5e-08 nf=1 \
        as=1.0401e-13 ad=4.16e-14 ps=1.605e-06 pd=8.4e-07 nrd=1.16667 \
        nrs=1.16667 sa=4.33462e-07 sb=1.32769e-06 sd=160n sca=9.50447 \
        scb=0.0081528 scc=0.00025289 m=(2)
mp12 (\1\:Y n2 \6\:VDD VDD) g45p1lvt w=(3.9e-07) l=4.5e-08 nf=1 \
        as=1.0641e-13 ad=6.24e-14 ps=1.955e-06 pd=1.1e-06 nrd=1.16667 \
        nrs=1.16667 sa=3.17756e-07 sb=1.00038e-06 sd=160n sca=28.7024 \
        scb=0.0198217 scc=0.00315848 m=(2)
ends MX4X2
// End of subcircuit definition.
