// Generated for: spectre (May  1 09:12:59 2013 )
// Library name: gsclib045_lvt
// Cell name: CLKINVX1
// View name: extracted

simulator lang=spectre

subckt CLKINVX1 A VDD VSS Y
mp0 (\1\:Y \1\:A \3\:VDD VDD) g45p1lvt w=(3.9e-07) l=4.5e-08 nf=1 \
        as=5.46e-14 ad=4.86e-14 ps=1.06e-06 pd=1.06e-06 nrd=1.16667 \
        nrs=1.16667 sa=1.4e-07 sb=1.24615e-07 sd=160n sca=47.9961 \
        scb=0.0439169 scc=0.00481722 m=(1)
C1 (Y VSS) capacitor c=4.98396e-17
C2 (VDD VSS) capacitor c=2.75467e-17
C3 (\1\:A VSS) capacitor c=2.93388e-17
C4 (\4\:A VSS) capacitor c=2.40696e-17
C5 (\3\:A VSS) capacitor c=1.55142e-17
C6 (\1\:Y VSS) capacitor c=4.02946e-17
C7 (\3\:VDD VSS) capacitor c=4.72871e-17
C8 (\2\:A VSS) capacitor c=9.53353e-18
C9 (\5\:A VSS) capacitor c=3.69186e-17
C10 (\7\:A VSS) capacitor c=3.88107e-17
Rk9 (VSS \4\:VSS) resistor r=0.3102 c=0
Rk1 (\5\:A \6\:A) resistor r=0.004811 c=0
Rk2 (A \7\:A) resistor r=0.004651 c=0
Rk3 (\5\:A \7\:A) resistor r=0.04303 c=0
Rk4 (\2\:Y Y) resistor r=0.2477 c=0
Rk5 (Y \4\:Y) resistor r=0.06047 c=0
Rk7 (VDD \4\:VDD) resistor r=0.3843 c=0
Rl1 (\1\:A \2\:A) resistor r=61.2526 c=0
Rl3 (\2\:A \4\:A) resistor r=34.3295 c=0
Rl2 (\2\:A \3\:A) resistor r=4.3144 c=0
Rz3 (\3\:VSS \4\:VSS) resistor r=37.5 c=0
Rz1 (\3\:Y \4\:Y) resistor r=75 c=0
Ry1 (\1\:Y \2\:Y) resistor r=31 c=0
Ry2 (\3\:VDD \4\:VDD) resistor r=20.6667 c=0
Rx1 (\3\:A \6\:A) resistor r=45 c=0
mn0 (\3\:Y \4\:A \3\:VSS VSS) g45n1lvt w=(2.6e-07) l=4.5e-08 nf=1 \
        as=3.64e-14 ad=3.08e-14 ps=8e-07 pd=8e-07 nrd=1.16667 nrs=1.16667 \
        sa=1.4e-07 sb=1.18462e-07 sd=160n sca=14.4034 scb=0.0144248 \
        scc=0.00102063 m=(1)
ends CLKINVX1
// End of subcircuit definition.
