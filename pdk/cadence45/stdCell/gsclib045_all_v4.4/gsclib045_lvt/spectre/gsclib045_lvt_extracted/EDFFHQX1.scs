// Generated for: spectre (May  1 09:14:17 2013 )
// Library name: gsclib045_lvt
// Cell name: EDFFHQX1
// View name: extracted

simulator lang=spectre

subckt EDFFHQX1 CK D E Q VDD VSS
mp20 (\12\:CKb \3\:CK \18\:VDD VDD) g45p1lvt w=(2.15e-07) l=4.5e-08 nf=1 \
        as=3.44e-14 ad=3.01e-14 ps=7.5e-07 pd=7.1e-07 nrd=1.16667 \
        nrs=1.16667 sa=1.4e-07 sb=3.45e-07 sd=160n sca=18.8664 \
        scb=0.0202043 scc=0.000597023 m=(1)
mp21 (\15\:CKbb \6\:CKb \18\:VDD VDD) g45p1lvt w=(2.15e-07) l=4.5e-08 \
        nf=1 as=3.44e-14 ad=3.01e-14 ps=7.5e-07 pd=7.1e-07 nrd=1.16667 \
        nrs=1.16667 sa=3.45e-07 sb=1.4e-07 sd=160n sca=12.8049 \
        scb=0.0100559 scc=8.95671e-05 m=(1)
mp0 (\6\:Eb \5\:E \10\:VDD VDD) g45p1lvt w=(2.15e-07) l=4.5e-08 nf=1 \
        as=6.535e-14 ad=3.01e-14 ps=1.16e-06 pd=7.1e-07 nrd=1.16667 \
        nrs=1.16667 sa=9.76395e-07 sb=1.4e-07 sd=160n sca=24.8073 \
        scb=0.0246729 scc=0.00213017 m=(1)
C1 (E VSS) capacitor c=3.69119e-17
C2 (Q VSS) capacitor c=2.81592e-17
C3 (D VSS) capacitor c=8.69786e-17
C4 (VDD VSS) capacitor c=3.14292e-16
C5 (CK VSS) capacitor c=1.16323e-16
C6 (CKb VSS) capacitor c=9.66399e-17
C7 (CKbb VSS) capacitor c=3.5695e-17
C8 (n20 VSS) capacitor c=5.41751e-17
C9 (Db VSS) capacitor c=1.11957e-16
C10 (net340 VSS) capacitor c=1.32881e-18
C11 (mout VSS) capacitor c=3.17058e-17
C12 (n30 VSS) capacitor c=6.78488e-17
C13 (net380 VSS) capacitor c=1.32746e-18
C14 (qbint VSS) capacitor c=3.84482e-17
C15 (Eb VSS) capacitor c=4.17502e-17
C16 (net333 VSS) capacitor c=4.74274e-19
C17 (net309 VSS) capacitor c=3.73929e-18
C18 (net317 VSS) capacitor c=6.19106e-18
C19 (net328 VSS) capacitor c=4.71904e-18
C20 (\5\:E VSS) capacitor c=4.8429e-17
C21 (\1\:D VSS) capacitor c=5.61257e-17
C22 (\1\:E VSS) capacitor c=5.38862e-17
C23 (\8\:qbint VSS) capacitor c=4.69843e-17
C24 (\7\:CKbb VSS) capacitor c=5.34177e-17
C25 (\2\:CKb VSS) capacitor c=1.09157e-16
C26 (\4\:mout VSS) capacitor c=4.75671e-17
C27 (\3\:CKb VSS) capacitor c=1.36672e-16
C28 (\6\:CKb VSS) capacitor c=5.86145e-17
C29 (\3\:CK VSS) capacitor c=3.554e-17
C30 (\7\:E VSS) capacitor c=3.09505e-17
C31 (\3\:D VSS) capacitor c=8.40174e-17
C32 (\3\:E VSS) capacitor c=6.65466e-17
C33 (\3\:Eb VSS) capacitor c=6.27889e-17
C34 (\4\:n30 VSS) capacitor c=2.23392e-17
C35 (\7\:qbint VSS) capacitor c=2.58382e-17
C36 (\5\:qbint VSS) capacitor c=4.65493e-17
C37 (\5\:CKbb VSS) capacitor c=3.17461e-17
C38 (\3\:n20 VSS) capacitor c=3.3877e-17
C39 (\3\:mout VSS) capacitor c=5.19861e-17
C40 (\3\:CKbb VSS) capacitor c=3.89703e-17
C41 (\7\:CKb VSS) capacitor c=2.3158e-17
C42 (\9\:CKb VSS) capacitor c=2.37109e-17
C43 (\1\:CK VSS) capacitor c=5.51986e-17
C44 (\6\:E VSS) capacitor c=3.26734e-17
C45 (\2\:D VSS) capacitor c=5.69982e-17
C46 (\2\:Eb VSS) capacitor c=5.86158e-17
C47 (\4\:E VSS) capacitor c=4.84224e-17
C48 (\2\:E VSS) capacitor c=3.29734e-17
C49 (\3\:n30 VSS) capacitor c=1.26163e-17
C50 (\6\:qbint VSS) capacitor c=3.20811e-17
C51 (\8\:CKbb VSS) capacitor c=5.20547e-17
C52 (\6\:CKbb VSS) capacitor c=2.84089e-17
C53 (\2\:n20 VSS) capacitor c=3.19936e-17
C54 (\4\:CKbb VSS) capacitor c=3.73524e-17
C55 (\2\:CKbb VSS) capacitor c=4.02879e-17
C56 (\8\:CKb VSS) capacitor c=1.88147e-17
C57 (\2\:CK VSS) capacitor c=5.47942e-17
C58 (\6\:Eb VSS) capacitor c=1.11447e-16
C59 (\10\:VDD VSS) capacitor c=3.0312e-17
C60 (\3\:Db VSS) capacitor c=3.21195e-16
C61 (\9\:qbint VSS) capacitor c=4.94456e-17
C62 (\12\:VDD VSS) capacitor c=3.72406e-17
C63 (\3\:Q VSS) capacitor c=4.24557e-17
C64 (\14\:VDD VSS) capacitor c=3.65603e-17
C65 (\9\:n30 VSS) capacitor c=8.27008e-17
C66 (\5\:mout VSS) capacitor c=4.31984e-17
C67 (\16\:VDD VSS) capacitor c=4.66436e-17
C68 (\4\:n20 VSS) capacitor c=3.40446e-17
C69 (\5\:Db VSS) capacitor c=3.02619e-16
C70 (\15\:CKbb VSS) capacitor c=6.99055e-17
C71 (\18\:VDD VSS) capacitor c=3.23209e-17
C72 (\12\:CKb VSS) capacitor c=7.27967e-17
C73 (\1\:VDD VSS) capacitor c=5.58182e-17
C74 (\4\:Eb VSS) capacitor c=8.31816e-17
C75 (\13\:qbint VSS) capacitor c=5.69645e-17
C76 (\1\:Q VSS) capacitor c=6.11352e-17
C77 (\7\:n30 VSS) capacitor c=5.79044e-17
C78 (\9\:mout VSS) capacitor c=5.89385e-17
C79 (\7\:n20 VSS) capacitor c=6.82836e-17
C80 (\7\:Db VSS) capacitor c=9.42314e-17
C81 (\13\:CKbb VSS) capacitor c=1.08664e-16
C82 (\14\:CKb VSS) capacitor c=1.99224e-17
C83 (\2\:mout VSS) capacitor c=2.83213e-17
C84 (\4\:CKb VSS) capacitor c=5.38255e-17
C85 (\5\:CKb VSS) capacitor c=4.30245e-17
C86 (\2\:qbint VSS) capacitor c=1.31329e-17
C87 (\3\:qbint VSS) capacitor c=6.70585e-18
C88 (\4\:qbint VSS) capacitor c=4.07691e-17
C89 (\2\:n30 VSS) capacitor c=3.4538e-17
C90 (\10\:CKb VSS) capacitor c=3.47116e-17
C91 (\11\:CKb VSS) capacitor c=7.9079e-17
C92 (\6\:n20 VSS) capacitor c=8.46973e-17
C93 (\9\:n20 VSS) capacitor c=8.89553e-17
C94 (\7\:mout VSS) capacitor c=4.78583e-17
C95 (\8\:mout VSS) capacitor c=6.24794e-17
C96 (\9\:CKbb VSS) capacitor c=6.28715e-17
C97 (\10\:CKbb VSS) capacitor c=1.27819e-16
C98 (\11\:CKbb VSS) capacitor c=1.10191e-16
C99 (\12\:CKbb VSS) capacitor c=7.52883e-17
C100 (\17\:CKbb VSS) capacitor c=5.34588e-17
C101 (\18\:CKbb VSS) capacitor c=6.74442e-17
C102 (\5\:n30 VSS) capacitor c=1.30373e-16
C103 (\6\:n30 VSS) capacitor c=1.38064e-16
C104 (\11\:qbint VSS) capacitor c=5.92846e-17
C105 (\12\:qbint VSS) capacitor c=4.91603e-17
C106 (\8\:E VSS) capacitor c=1.47695e-16
C107 (\9\:E VSS) capacitor c=1.15849e-16
C108 (\10\:E VSS) capacitor c=3.25895e-17
C109 (\11\:E VSS) capacitor c=3.99042e-17
C110 (\4\:D VSS) capacitor c=5.21404e-17
C111 (\8\:Eb VSS) capacitor c=7.76016e-17
C112 (\3\:VDD VSS) capacitor c=1.76492e-17
C113 (\5\:VDD VSS) capacitor c=1.12802e-17
C114 (\6\:VDD VSS) capacitor c=3.67754e-17
C115 (\7\:VDD VSS) capacitor c=4.13102e-17
C116 (\9\:VDD VSS) capacitor c=1.97058e-17
Rk29 (\8\:E \9\:E) resistor r=0.9065 c=0
Rk30 (\9\:E \10\:E) resistor r=0.08499 c=0
Rk32 (\11\:E E) resistor r=0.053 c=0
Rk31 (\9\:E \11\:E) resistor r=0.2237 c=0
Rk18 (\2\:Q Q) resistor r=0.1572 c=0
Rk19 (Q \4\:Q) resistor r=0.1049 c=0
Rk33 (D \4\:D) resistor r=0.03958 c=0
Rk36 (\2\:VSS \3\:VSS) resistor r=0.2054 c=0
Rk37 (\3\:VSS \4\:VSS) resistor r=0.446 c=0
Rk38 (\4\:VSS \5\:VSS) resistor r=0.06499 c=0
Rk39 (\5\:VSS \6\:VSS) resistor r=0.3606 c=0
Rk40 (\6\:VSS \7\:VSS) resistor r=0.5211 c=0
Rk41 (\7\:VSS \8\:VSS) resistor r=0.2555 c=0
Rk43 (\9\:VSS VSS) resistor r=0.1525 c=0
Rk42 (\8\:VSS \9\:VSS) resistor r=0.3984 c=0
Rk44 (\3\:VSS \11\:VSS) resistor r=0.3077 c=0
Rk45 (\5\:VSS \13\:VSS) resistor r=0.271 c=0
Rk46 (\6\:VSS \15\:VSS) resistor r=0.2827 c=0
Rk47 (\7\:VSS \17\:VSS) resistor r=0.1224 c=0
Rk48 (\9\:VSS \19\:VSS) resistor r=0.2529 c=0
Rk49 (\2\:VDD \3\:VDD) resistor r=0.2204 c=0
Rk50 (\3\:VDD \4\:VDD) resistor r=0.431 c=0
Rk51 (\4\:VDD \5\:VDD) resistor r=0.03741 c=0
Rk52 (\5\:VDD \6\:VDD) resistor r=0.3355 c=0
Rk53 (\6\:VDD \7\:VDD) resistor r=0.5737 c=0
Rk54 (\7\:VDD \8\:VDD) resistor r=0.2555 c=0
Rk56 (\9\:VDD VDD) resistor r=0.1324 c=0
Rk55 (\8\:VDD \9\:VDD) resistor r=0.4185 c=0
Rk57 (\3\:VDD \11\:VDD) resistor r=0.2503 c=0
Rk58 (\5\:VDD \13\:VDD) resistor r=0.1957 c=0
Rk59 (\6\:VDD \15\:VDD) resistor r=0.1957 c=0
Rk60 (\7\:VDD \17\:VDD) resistor r=0.2919 c=0
Rk61 (\9\:VDD \19\:VDD) resistor r=0.1966 c=0
Rk1 (\4\:CK CK) resistor r=0.002999 c=0
Rk2 (\10\:CKb \11\:CKb) resistor r=0.2077 c=0
Rk3 (\11\:CKb \13\:CKb) resistor r=0.6388 c=0
Rk4 (\11\:CKb \15\:CKb) resistor r=0.1003 c=0
Rk11 (\9\:CKbb \10\:CKbb) resistor r=0.2447 c=0
Rk12 (\10\:CKbb \11\:CKbb) resistor r=0.8878 c=0
Rk13 (\11\:CKbb \12\:CKbb) resistor r=0.2837 c=0
Rk14 (\12\:CKbb \14\:CKbb) resistor r=0.2845 c=0
Rk15 (\14\:CKbb \16\:CKbb) resistor r=0.6667 c=0
Rk16 (\11\:CKbb \17\:CKbb) resistor r=0.2247 c=0
Rk17 (\12\:CKbb \18\:CKbb) resistor r=0.3613 c=0
Rk5 (\5\:n20 \6\:n20) resistor r=0.1174 c=0
Rk6 (\6\:n20 \8\:n20) resistor r=0.2631 c=0
Rk7 (\6\:n20 \9\:n20) resistor r=0.5876 c=0
Rk26 (\2\:Db \4\:Db) resistor r=0.5934 c=0
Rk27 (\4\:Db \6\:Db) resistor r=2.4551 c=0
Rk28 (\6\:Db \8\:Db) resistor r=0.5402 c=0
Rk8 (\6\:mout \7\:mout) resistor r=0.1196 c=0
Rk9 (\7\:mout \8\:mout) resistor r=0.228 c=0
Rk10 (\7\:mout \10\:mout) resistor r=0.2628 c=0
Rk20 (\5\:n30 \6\:n30) resistor r=0.9078 c=0
Rk21 (\6\:n30 \8\:n30) resistor r=0.2329 c=0
Rk22 (\6\:n30 \10\:n30) resistor r=0.4348 c=0
Rk23 (\10\:qbint \11\:qbint) resistor r=0.2292 c=0
Rk24 (\11\:qbint \12\:qbint) resistor r=0.2451 c=0
Rk25 (\11\:qbint \14\:qbint) resistor r=0.2442 c=0
Rk34 (\5\:Eb \7\:Eb) resistor r=0.6874 c=0
Rk35 (\7\:Eb \8\:Eb) resistor r=0.484 c=0
Rl36 (\5\:E \6\:E) resistor r=95.3288 c=0
Rl37 (\6\:E \7\:E) resistor r=35.7134 c=0
Rl31 (\3\:E \4\:E) resistor r=28.079 c=0
Rl30 (\1\:E \2\:E) resistor r=46.5349 c=0
Rl34 (\1\:D \2\:D) resistor r=24.2328 c=0
Rl35 (\2\:D \3\:D) resistor r=101.156 c=0
Rl2 (\2\:CK \3\:CK) resistor r=58.7903 c=0
Rl1 (\1\:CK \2\:CK) resistor r=195.329 c=0
Rl12 (\2\:CKb \3\:CKb) resistor r=524.566 c=0
Rl11 (CKb \2\:CKb) resistor r=203.045 c=0
Rl18 (\8\:CKb \9\:CKb) resistor r=26.098 c=0
Rl13 (\3\:CKb \4\:CKb) resistor r=245.697 c=0
Rl16 (\4\:CKb \7\:CKb) resistor r=30.4507 c=0
Rl15 (\5\:CKb \6\:CKb) resistor r=206.36 c=0
Rl17 (\5\:CKb \8\:CKb) resistor r=12.0714 c=0
Rl14 (\4\:CKb \5\:CKb) resistor r=172.352 c=0
Rl19 (\7\:CKbb \8\:CKbb) resistor r=47.3097 c=0
Rl10 (\5\:CKbb \6\:CKbb) resistor r=48.7687 c=0
Rl4 (\3\:CKbb \4\:CKbb) resistor r=29.5379 c=0
Rl3 (CKbb \2\:CKbb) resistor r=46.417 c=0
Rl8 (n20 \2\:n20) resistor r=98.7687 c=0
Rl9 (\2\:n20 \3\:n20) resistor r=29.5379 c=0
Rl7 (\2\:mout \4\:mout) resistor r=45.868 c=0
Rl6 (\2\:mout \3\:mout) resistor r=99.7141 c=0
Rl5 (mout \2\:mout) resistor r=16.2873 c=0
Rl27 (n30 \2\:n30) resistor r=171.462 c=0
Rl29 (\2\:n30 \4\:n30) resistor r=23.7402 c=0
Rl28 (\2\:n30 \3\:n30) resistor r=5.1011 c=0
Rl20 (qbint \2\:qbint) resistor r=72.3105 c=0
Rl24 (\2\:qbint \6\:qbint) resistor r=104.219 c=0
Rl25 (\3\:qbint \7\:qbint) resistor r=35.772 c=0
Rl21 (\2\:qbint \3\:qbint) resistor r=17.6978 c=0
Rl26 (\4\:qbint \8\:qbint) resistor r=93.4643 c=0
Rl23 (\4\:qbint \5\:qbint) resistor r=68.03 c=0
Rl22 (\3\:qbint \4\:qbint) resistor r=87.8245 c=0
Rl32 (Eb \2\:Eb) resistor r=24.2328 c=0
Rl33 (\2\:Eb \3\:Eb) resistor r=135.217 c=0
Rz5 (\1\:Q \2\:Q) resistor r=75 c=0
Rz11 (\10\:VSS \11\:VSS) resistor r=75 c=0
Rz12 (\12\:VSS \13\:VSS) resistor r=75 c=0
Rz13 (\14\:VSS \15\:VSS) resistor r=75 c=0
Rz14 (\16\:VSS \17\:VSS) resistor r=75 c=0
Rz15 (\18\:VSS \19\:VSS) resistor r=75 c=0
Rz16 (\1\:VDD \2\:VDD) resistor r=75 c=0
Rz17 (\1\:VDD \4\:VDD) resistor r=6.25 c=0
Rz18 (\1\:VDD \8\:VDD) resistor r=6.25 c=0
Rz1 (\14\:CKb \15\:CKb) resistor r=75 c=0
Rz4 (\13\:CKbb \14\:CKbb) resistor r=75 c=0
Rz2 (\7\:n20 \8\:n20) resistor r=75 c=0
Rz8 (Db \2\:Db) resistor r=75 c=0
Rz9 (\7\:Db \8\:Db) resistor r=75 c=0
Rz3 (\9\:mout \10\:mout) resistor r=75 c=0
Rz6 (\7\:n30 \8\:n30) resistor r=75 c=0
Rz7 (\13\:qbint \14\:qbint) resistor r=75 c=0
Rz10 (\4\:Eb \5\:Eb) resistor r=75 c=0
Ry5 (\3\:Q \4\:Q) resistor r=62 c=0
Ry11 (\1\:VSS \2\:VSS) resistor r=62 c=0
Ry12 (\1\:VSS \4\:VSS) resistor r=5.1667 c=0
Ry13 (\1\:VSS \8\:VSS) resistor r=5.1667 c=0
Ry14 (\10\:VDD \11\:VDD) resistor r=62 c=0
Ry15 (\12\:VDD \13\:VDD) resistor r=62 c=0
Ry16 (\14\:VDD \15\:VDD) resistor r=62 c=0
Ry17 (\16\:VDD \17\:VDD) resistor r=62 c=0
Ry18 (\18\:VDD \19\:VDD) resistor r=62 c=0
Ry1 (\12\:CKb \13\:CKb) resistor r=62 c=0
Ry4 (\15\:CKbb \16\:CKbb) resistor r=62 c=0
Ry2 (\4\:n20 \5\:n20) resistor r=62 c=0
Ry8 (\3\:Db \4\:Db) resistor r=20.6667 c=0
Ry9 (\5\:Db \6\:Db) resistor r=31 c=0
Ry3 (\5\:mout \6\:mout) resistor r=62 c=0
Ry6 (\9\:n30 \10\:n30) resistor r=62 c=0
Ry7 (\9\:qbint \10\:qbint) resistor r=62 c=0
Ry10 (\6\:Eb \7\:Eb) resistor r=62 c=0
Rx11 (\2\:E \8\:E) resistor r=45 c=0
Rx12 (\4\:E \10\:E) resistor r=45 c=0
Rx13 (\6\:E \11\:E) resistor r=45 c=0
Rx14 (\2\:D \4\:D) resistor r=45 c=0
Rx1 (\2\:CK \4\:CK) resistor r=45 c=0
Rx2 (\8\:CKb \10\:CKb) resistor r=45 c=0
Rx5 (\8\:CKbb \9\:CKbb) resistor r=45 c=0
Rx6 (\6\:CKbb \10\:CKbb) resistor r=45 c=0
Rx7 (\4\:CKbb \17\:CKbb) resistor r=45 c=0
Rx8 (\2\:CKbb \18\:CKbb) resistor r=45 c=0
Rx3 (\2\:n20 \9\:n20) resistor r=45 c=0
Rx4 (mout \8\:mout) resistor r=45 c=0
Rx9 (\3\:n30 \5\:n30) resistor r=45 c=0
Rx10 (\6\:qbint \12\:qbint) resistor r=45 c=0
Rx15 (\2\:Eb \8\:Eb) resistor r=45 c=0
mn20 (\14\:CKb \1\:CK \18\:VSS VSS) g45n1lvt w=(1.45e-07) l=4.5e-08 nf=1 \
        as=2.32e-14 ad=2.03e-14 ps=6.1e-07 pd=5.7e-07 nrd=1.16667 \
        nrs=1.16667 sa=1.4e-07 sb=4.05e-07 sd=160n sca=9.16682 \
        scb=0.00760686 scc=0.000164708 m=(1)
mn21 (\13\:CKbb \9\:CKb \18\:VSS VSS) g45n1lvt w=(1.45e-07) l=4.5e-08 \
        nf=1 as=2.32e-14 ad=2.9e-14 ps=6.1e-07 pd=6.9e-07 nrd=1.16667 \
        nrs=1.16667 sa=3.45e-07 sb=2e-07 sd=160n sca=9.16682 \
        scb=0.00760686 scc=0.000164708 m=(1)
mn0 (\4\:Eb \7\:E \10\:VSS VSS) g45n1lvt w=(1.45e-07) l=4.5e-08 nf=1 \
        as=3.905e-14 ad=2.03e-14 ps=9e-07 pd=5.7e-07 nrd=1.16667 \
        nrs=1.16667 sa=1.16e-06 sb=1.4e-07 sd=160n sca=11.7118 \
        scb=0.0116498 scc=0.000458536 m=(1)
mn25 (\7\:n20 \7\:CKb \7\:Db VSS) g45n1lvt w=(2.05e-07) l=4.5e-08 nf=1 \
        as=2.87e-14 ad=8.098e-14 ps=6.9e-07 pd=1.2e-06 nrd=1.16667 \
        nrs=1.16667 sa=1.4e-07 sb=2e-06 sd=160n sca=13.4389 scb=0.0137383 \
        scc=0.000784938 m=(1)
mn36 (\7\:n20 \3\:CKbb net340 VSS) g45n1lvt w=(2.05e-07) l=4.5e-08 nf=1 \
        as=3.075e-14 ad=8.098e-14 ps=7.1e-07 pd=1.2e-06 nrd=1.16667 \
        nrs=1.16667 sa=5.8e-07 sb=1.755e-06 sd=160n sca=13.4389 \
        scb=0.0137383 scc=0.000784938 m=(1)
mn35 (net340 \3\:mout \16\:VSS VSS) g45n1lvt w=(2.05e-07) l=4.5e-08 nf=1 \
        as=7.945e-14 ad=3.075e-14 ps=1.38e-06 pd=7.1e-07 nrd=1.16667 \
        nrs=1.16667 sa=7.75e-07 sb=1.56e-06 sd=160n sca=13.4389 \
        scb=0.0137383 scc=0.000784938 m=(1)
mn30 (\9\:mout \3\:n20 \16\:VSS VSS) g45n1lvt w=(2.05e-07) l=4.5e-08 \
        nf=1 as=7.945e-14 ad=6.252e-14 ps=1.38e-06 pd=1.02e-06 nrd=1.16667 \
        nrs=1.16667 sa=1.07e-06 sb=1.265e-06 sd=160n sca=13.4389 \
        scb=0.0137383 scc=0.000784938 m=(1)
mn40 (\9\:mout \5\:CKbb \7\:n30 VSS) g45n1lvt w=(2.05e-07) l=4.5e-08 nf=1 \
        as=5.638e-14 ad=6.252e-14 ps=9.6e-07 pd=1.02e-06 nrd=1.16667 \
        nrs=1.16667 sa=1.42e-06 sb=9.15e-07 sd=160n sca=13.4389 \
        scb=0.0137383 scc=0.000784938 m=(1)
mn51 (\7\:n30 CKb net380 VSS) g45n1lvt w=(2.05e-07) l=4.5e-08 nf=1 \
        as=1.23e-14 ad=5.638e-14 ps=5.3e-07 pd=9.6e-07 nrd=1.16667 \
        nrs=1.16667 sa=1.74e-06 sb=5.95e-07 sd=160n sca=13.4389 \
        scb=0.0137383 scc=0.000784938 m=(1)
mn50 (net380 \5\:qbint \14\:VSS VSS) g45n1lvt w=(2.05e-07) l=4.5e-08 \
        nf=1 as=6.598e-14 ad=1.23e-14 ps=1.11e-06 pd=5.3e-07 nrd=1.16667 \
        nrs=1.16667 sa=1.845e-06 sb=4.9e-07 sd=160n sca=13.4389 \
        scb=0.0137383 scc=0.000784938 m=(1)
mn45 (\13\:qbint \4\:n30 \12\:VSS VSS) g45n1lvt w=(2.05e-07) l=4.5e-08 \
        nf=1 as=2.87e-14 ad=9.16e-14 ps=6.9e-07 pd=1.36e-06 nrd=1.16667 \
        nrs=1.16667 sa=1.4e-07 sb=1.07951e-06 sd=160n sca=11.814 \
        scb=0.0116374 scc=0.000520744 m=(1)
mn55 (\1\:Q \7\:qbint \14\:VSS VSS) g45n1lvt w=(2.6e-07) l=4.5e-08 nf=1 \
        as=6.598e-14 ad=3.9e-14 ps=1.11e-06 pd=8.2e-07 nrd=1.16667 \
        nrs=1.16667 sa=1.59808e-06 sb=1.5e-07 sd=160n sca=16.9678 \
        scb=0.0167861 scc=0.00150639 m=(1)
mn1 (\13\:qbint \3\:Eb Db VSS) g45n1lvt w=(2.6e-07) l=4.5e-08 nf=1 \
        as=4.42e-14 ad=9.16e-14 ps=8.6e-07 pd=1.36e-06 nrd=1.16667 \
        nrs=1.16667 sa=4.98173e-07 sb=5.73365e-07 sd=160n sca=10.79 \
        scb=0.0100512 scc=0.000418069 m=(1)
mn3 (Db \3\:E net333 VSS) g45n1lvt w=(2.6e-07) l=4.5e-08 nf=1 as=1.56e-14 \
        ad=4.42e-14 ps=6.4e-07 pd=8.6e-07 nrd=1.16667 nrs=1.16667 \
        sa=7.13173e-07 sb=3.58365e-07 sd=160n sca=10.79 scb=0.0100512 \
        scc=0.000418069 m=(1)
mn2 (net333 \3\:D \10\:VSS VSS) g45n1lvt w=(2.6e-07) l=4.5e-08 nf=1 \
        as=3.905e-14 ad=1.56e-14 ps=9e-07 pd=6.4e-07 nrd=1.16667 \
        nrs=1.16667 sa=8.18173e-07 sb=2.53365e-07 sd=160n sca=10.79 \
        scb=0.0100512 scc=0.000418069 m=(1)
mp25 (\4\:n20 CKbb \5\:Db VDD) g45p1lvt w=(3.1e-07) l=4.5e-08 nf=1 \
        as=4.34e-14 ad=4.96e-14 ps=9e-07 pd=9.4e-07 nrd=1.16667 \
        nrs=1.16667 sa=1.4e-07 sb=1.98e-06 sd=160n sca=15.5687 \
        scb=0.0146164 scc=0.00101158 m=(1)
mp36 (\4\:n20 \3\:CKb net309 VDD) g45p1lvt w=(3.1e-07) l=4.5e-08 nf=1 \
        as=5.58e-14 ad=4.96e-14 ps=9.8e-07 pd=9.4e-07 nrd=1.16667 \
        nrs=1.16667 sa=3.45e-07 sb=1.775e-06 sd=160n sca=15.5687 \
        scb=0.0146164 scc=0.00101158 m=(1)
mp35 (net309 \4\:mout \16\:VDD VDD) g45p1lvt w=(3.1e-07) l=4.5e-08 nf=1 \
        as=7.75e-14 ad=5.58e-14 ps=1.12e-06 pd=9.8e-07 nrd=1.16667 \
        nrs=1.16667 sa=5.7e-07 sb=1.55e-06 sd=160n sca=15.5687 \
        scb=0.0146164 scc=0.00101158 m=(1)
mp30 (\5\:mout n20 \16\:VDD VDD) g45p1lvt w=(3.1e-07) l=4.5e-08 nf=1 \
        as=7.75e-14 ad=1.364e-13 ps=1.12e-06 pd=1.5e-06 nrd=1.16667 \
        nrs=1.16667 sa=8.65e-07 sb=1.255e-06 sd=160n sca=15.5687 \
        scb=0.0146164 scc=0.00101158 m=(1)
mp40 (\5\:mout \2\:CKb \9\:n30 VDD) g45p1lvt w=(3.1e-07) l=4.5e-08 nf=1 \
        as=4.96e-14 ad=1.364e-13 ps=9.4e-07 pd=1.5e-06 nrd=1.16667 \
        nrs=1.16667 sa=1.35e-06 sb=7.7e-07 sd=160n sca=15.5687 \
        scb=0.0146164 scc=0.00101158 m=(1)
mp51 (\9\:n30 \7\:CKbb net317 VDD) g45p1lvt w=(3.1e-07) l=4.5e-08 nf=1 \
        as=3.565e-14 ad=4.96e-14 ps=8.5e-07 pd=9.4e-07 nrd=1.16667 \
        nrs=1.16667 sa=1.555e-06 sb=5.65e-07 sd=160n sca=15.5687 \
        scb=0.0146164 scc=0.00101158 m=(1)
mp50 (net317 \8\:qbint \14\:VDD VDD) g45p1lvt w=(3.1e-07) l=4.5e-08 nf=1 \
        as=8.78e-14 ad=3.565e-14 ps=1.32e-06 pd=8.5e-07 nrd=1.16667 \
        nrs=1.16667 sa=1.715e-06 sb=4.05e-07 sd=160n sca=15.5687 \
        scb=0.0146164 scc=0.00101158 m=(1)
mp45 (\9\:qbint n30 \12\:VDD VDD) g45p1lvt w=(3.1e-07) l=4.5e-08 nf=1 \
        as=6.17e-14 ad=7.01e-14 ps=1.11e-06 pd=1.16e-06 nrd=1.16667 \
        nrs=1.16667 sa=1.7e-07 sb=9.12339e-07 sd=160n sca=12.4967 \
        scb=0.0111079 scc=0.00042389 m=(1)
mp55 (\3\:Q qbint \14\:VDD VDD) g45p1lvt w=(3.9e-07) l=4.5e-08 nf=1 \
        as=8.78e-14 ad=5.46e-14 ps=1.32e-06 pd=1.06e-06 nrd=1.16667 \
        nrs=1.16667 sa=1.60872e-06 sb=1.4e-07 sd=160n sca=14.3987 \
        scb=0.0130081 scc=0.000814275 m=(1)
mp1 (\9\:qbint \1\:E \3\:Db VDD) g45p1lvt w=(3.9e-07) l=4.5e-08 nf=1 \
        as=8.19e-14 ad=7.01e-14 ps=1.2e-06 pd=1.16e-06 nrd=1.16667 \
        nrs=1.16667 sa=3.50641e-07 sb=7.04551e-07 sd=160n sca=16.2669 \
        scb=0.0145797 scc=0.00118861 m=(1)
mp3 (\3\:Db Eb net328 VDD) g45p1lvt w=(3.9e-07) l=4.5e-08 nf=1 \
        as=5.265e-14 ad=8.19e-14 ps=1.05e-06 pd=1.2e-06 nrd=1.16667 \
        nrs=1.16667 sa=6.05641e-07 sb=4.49551e-07 sd=160n sca=16.5949 \
        scb=0.0146729 scc=0.00118863 m=(1)
mp2 (net328 \1\:D \10\:VDD VDD) g45p1lvt w=(3.9e-07) l=4.5e-08 nf=1 \
        as=6.535e-14 ad=5.265e-14 ps=1.16e-06 pd=1.05e-06 nrd=1.16667 \
        nrs=1.16667 sa=7.85641e-07 sb=2.69551e-07 sd=160n sca=17.3384 \
        scb=0.0151709 scc=0.00118918 m=(1)
ends EDFFHQX1
// End of subcircuit definition.
