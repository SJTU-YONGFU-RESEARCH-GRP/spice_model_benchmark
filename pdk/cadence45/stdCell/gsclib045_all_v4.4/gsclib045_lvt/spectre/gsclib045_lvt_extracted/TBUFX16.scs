// Generated for: spectre (May  1 09:12:36 2013 )
// Library name: gsclib045_lvt
// Cell name: TBUFX16
// View name: extracted

simulator lang=spectre

subckt TBUFX16 A OE VDD VSS Y
mp2_1__rcx (\44\:non OEb 7 VDD) g45p1lvt w=(3.1e-07) l=4.5e-08 nf=1 \
        as=3.1e-14 ad=4.34e-14 ps=8.2e-07 pd=9e-07 nrd=1.16667 nrs=1.16667 \
        sa=1.4e-07 sb=2e-06 sd=160n sca=13.6224 scb=0.0125368 \
        scc=0.000630866 m=(1)
mp1_1__rcx (7 \21\:A \42\:VDD VDD) g45p1lvt w=(3.1e-07) l=4.5e-08 nf=1 \
        as=4.96e-14 ad=3.1e-14 ps=9.4e-07 pd=8.2e-07 nrd=1.16667 \
        nrs=1.16667 sa=2.85e-07 sb=2e-06 sd=160n sca=13.6224 scb=0.0125368 \
        scc=0.000630866 m=(1)
mp1_2__rcx (6 \16\:A \42\:VDD VDD) g45p1lvt w=(3.1e-07) l=4.5e-08 nf=1 \
        as=4.96e-14 ad=3.1e-14 ps=9.4e-07 pd=8.2e-07 nrd=1.16667 \
        nrs=1.16667 sa=4.9e-07 sb=2e-06 sd=160n sca=13.6224 scb=0.0125368 \
        scc=0.000630866 m=(1)
mp2_2__rcx (\54\:non \6\:OEb 6 VDD) g45p1lvt w=(3.1e-07) l=4.5e-08 nf=1 \
        as=3.1e-14 ad=4.96e-14 ps=8.2e-07 pd=9.4e-07 nrd=1.16667 \
        nrs=1.16667 sa=6.35e-07 sb=2e-06 sd=160n sca=13.6224 scb=0.0125368 \
        scc=0.000630866 m=(1)
mp2_3__rcx (\54\:non \4\:OEb 9 VDD) g45p1lvt w=(3.1e-07) l=4.5e-08 nf=1 \
        as=1.86e-14 ad=4.96e-14 ps=7.4e-07 pd=9.4e-07 nrd=1.16667 \
        nrs=1.16667 sa=8.4e-07 sb=2e-06 sd=160n sca=13.6224 scb=0.0125368 \
        scc=0.000630866 m=(1)
mp1_3__rcx (9 \28\:A \40\:VDD VDD) g45p1lvt w=(3.1e-07) l=4.5e-08 nf=1 \
        as=6.2e-14 ad=1.86e-14 ps=1.02e-06 pd=7.4e-07 nrd=1.16667 \
        nrs=1.16667 sa=9.45e-07 sb=2e-06 sd=160n sca=13.6224 scb=0.0125368 \
        scc=0.000630866 m=(1)
mp1_4__rcx (8 \23\:A \40\:VDD VDD) g45p1lvt w=(3.1e-07) l=4.5e-08 nf=1 \
        as=6.2e-14 ad=1.86e-14 ps=1.02e-06 pd=7.4e-07 nrd=1.16667 \
        nrs=1.16667 sa=1.19e-06 sb=2e-06 sd=160n sca=13.6224 scb=0.0125368 \
        scc=0.000630866 m=(1)
mp2_4__rcx (\52\:non \12\:OEb 8 VDD) g45p1lvt w=(3.1e-07) l=4.5e-08 nf=1 \
        as=1.86e-14 ad=6.2e-14 ps=7.4e-07 pd=1.02e-06 nrd=1.16667 \
        nrs=1.16667 sa=1.295e-06 sb=2e-06 sd=160n sca=13.6224 \
        scb=0.0125368 scc=0.000630866 m=(1)
mp2 (\52\:non \13\:OEb 10 VDD) g45p1lvt w=(3.1e-07) l=4.5e-08 nf=1 \
        as=1.86e-14 ad=6.2e-14 ps=7.4e-07 pd=1.02e-06 nrd=1.16667 \
        nrs=1.16667 sa=1.54e-06 sb=2e-06 sd=160n sca=13.6224 scb=0.0125368 \
        scc=0.000630866 m=(1)
mp1 (10 \31\:A \1\:VDD VDD) g45p1lvt w=(3.1e-07) l=4.5e-08 nf=1 \
        as=1.2115e-13 ad=1.86e-14 ps=1.51e-06 pd=7.4e-07 nrd=1.16667 \
        nrs=1.16667 sa=1.645e-06 sb=2e-06 sd=160n sca=13.6224 \
        scb=0.0125368 scc=0.000630866 m=(1)
mp4_1__rcx (\34\:pon \1\:OE \17\:VDD VDD) g45p1lvt w=(3.1e-07) l=4.5e-08 \
        nf=1 as=4.836e-14 ad=5.834e-14 ps=9.32e-07 pd=1.026e-06 \
        nrd=1.16667 nrs=1.16667 sa=1.4e-07 sb=1.99726e-06 sd=160n \
        sca=16.3045 scb=0.0159017 scc=0.000427021 m=(5)
mp3_1__rcx (\34\:pon \1\:A \17\:VDD VDD) g45p1lvt w=(3.1e-07) l=4.5e-08 \
        nf=1 as=9.056e-14 ad=5.834e-14 ps=1.476e-06 pd=1.026e-06 \
        nrd=1.16667 nrs=1.16667 sa=3.45e-07 sb=1.94105e-06 sd=160n \
        sca=13.5722 scb=0.0115826 scc=0.000363488 m=(5)
C1 (A VSS) capacitor c=2.02651e-17
C2 (OE VSS) capacitor c=3.44183e-17
C3 (VDD VSS) capacitor c=4.8705e-16
C4 (Y VSS) capacitor c=1.02194e-15
C5 (pon VSS) capacitor c=5.28942e-16
C6 (16 VSS) capacitor c=1.86268e-18
C7 (17 VSS) capacitor c=1.38687e-18
C8 (18 VSS) capacitor c=2.31144e-18
C9 (OEb VSS) capacitor c=5.13299e-17
C10 (non VSS) capacitor c=5.03265e-16
C11 (7 VSS) capacitor c=3.46041e-18
C12 (6 VSS) capacitor c=3.35142e-18
C13 (9 VSS) capacitor c=1.93954e-18
C14 (8 VSS) capacitor c=1.92628e-18
C15 (10 VSS) capacitor c=1.87512e-18
C16 (\31\:A VSS) capacitor c=8.57071e-17
C17 (\13\:OEb VSS) capacitor c=5.93512e-17
C18 (\12\:OEb VSS) capacitor c=5.87735e-17
C19 (\23\:A VSS) capacitor c=7.13621e-17
C20 (\28\:A VSS) capacitor c=7.21447e-17
C21 (\4\:OEb VSS) capacitor c=6.56905e-17
C22 (\6\:OEb VSS) capacitor c=4.27089e-17
C23 (\16\:A VSS) capacitor c=5.79105e-17
C24 (\21\:A VSS) capacitor c=3.77173e-17
C25 (\14\:OE VSS) capacitor c=7.68714e-17
C26 (\1\:A VSS) capacitor c=1.30428e-15
C27 (\1\:OE VSS) capacitor c=6.90195e-16
C28 (\20\:OE VSS) capacitor c=4.02348e-17
C29 (\15\:A VSS) capacitor c=2.82682e-17
C30 (\22\:OE VSS) capacitor c=2.78857e-17
C31 (\19\:OE VSS) capacitor c=4.48504e-17
C32 (\10\:A VSS) capacitor c=4.14348e-17
C33 (\12\:A VSS) capacitor c=2.57555e-17
C34 (\11\:OE VSS) capacitor c=2.99134e-17
C35 (\13\:OE VSS) capacitor c=2.40599e-17
C36 (\6\:A VSS) capacitor c=3.01097e-17
C37 (\3\:A VSS) capacitor c=3.29594e-17
C38 (\3\:OE VSS) capacitor c=3.36744e-17
C39 (\17\:non VSS) capacitor c=2.45771e-17
C40 (\18\:A VSS) capacitor c=6.35186e-16
C41 (\2\:OEb VSS) capacitor c=8.08835e-16
C42 (\1\:VDD VSS) capacitor c=7.18317e-16
C43 (\52\:non VSS) capacitor c=3.56732e-17
C44 (\40\:VDD VSS) capacitor c=4.62596e-17
C45 (\54\:non VSS) capacitor c=3.46368e-17
C46 (\42\:VDD VSS) capacitor c=4.80844e-17
C47 (\44\:non VSS) capacitor c=1.12305e-16
C48 (\21\:OEb VSS) capacitor c=2.97567e-17
C49 (\33\:non VSS) capacitor c=4.35118e-16
C50 (\19\:OEb VSS) capacitor c=6.92146e-17
C51 (\32\:pon VSS) capacitor c=8.22826e-17
C52 (\42\:pon VSS) capacitor c=8.35506e-17
C53 (\49\:pon VSS) capacitor c=8.35175e-17
C54 (\17\:A VSS) capacitor c=3.07866e-17
C55 (\18\:OEb VSS) capacitor c=4.98755e-17
C56 (\41\:non VSS) capacitor c=1.05209e-16
C57 (\42\:non VSS) capacitor c=1.25123e-16
C58 (\43\:non VSS) capacitor c=1.54977e-16
C59 (\34\:pon VSS) capacitor c=7.37879e-16
C60 (\37\:pon VSS) capacitor c=3.94173e-16
C61 (\14\:VDD VSS) capacitor c=2.82878e-17
C62 (\15\:VDD VSS) capacitor c=1.55741e-17
C63 (\17\:VDD VSS) capacitor c=2.64921e-16
Rk18 (\1\:A A) resistor r=0.003673 c=0
Rk14 (\1\:A \18\:A) resistor r=1.3948 c=0
Rk135 (\1\:VSS \41\:VSS) resistor r=0.3882 c=0
Rk136 (\41\:VSS \42\:VSS) resistor r=0.4108 c=0
Rk137 (\42\:VSS \43\:VSS) resistor r=0.2079 c=0
Rk139 (\44\:VSS VSS) resistor r=0.2753 c=0
Rk138 (\43\:VSS \44\:VSS) resistor r=0.2756 c=0
Rk142 (\41\:VSS \50\:VSS) resistor r=0.3411 c=0
Rk143 (\42\:VSS \52\:VSS) resistor r=0.3314 c=0
Rk144 (\44\:VSS \54\:VSS) resistor r=0.3236 c=0
Rk1 (OE \1\:OE) resistor r=0.03115 c=0
Rk82 (\1\:VDD \14\:VDD) resistor r=0.3506 c=0
Rk83 (\14\:VDD \15\:VDD) resistor r=0.3506 c=0
Rk84 (\15\:VDD \16\:VDD) resistor r=0.09758 c=0
Rk92 (\17\:VDD VDD) resistor r=0.08981 c=0
Rk85 (\16\:VDD \17\:VDD) resistor r=0.4962 c=0
Rk101 (\14\:VDD \41\:VDD) resistor r=0.2623 c=0
Rk102 (\15\:VDD \43\:VDD) resistor r=0.2623 c=0
Rk33 (\33\:pon \34\:pon) resistor r=0.4161 c=0
Rk35 (\34\:pon \37\:pon) resistor r=3.0493 c=0
Rk39 (\34\:pon \43\:pon) resistor r=0.362 c=0
Rk43 (\34\:pon \50\:pon) resistor r=0.7273 c=0
Rk6 (\2\:OEb \18\:OEb) resistor r=0.4155 c=0
Rk7 (\18\:OEb \20\:OEb) resistor r=0.2001 c=0
Rk8 (\18\:OEb \22\:OEb) resistor r=0.08288 c=0
Rk24 (\33\:non \41\:non) resistor r=0.2767 c=0
Rk25 (\41\:non \42\:non) resistor r=0.5185 c=0
Rk26 (\42\:non \43\:non) resistor r=0.5743 c=0
Rk27 (\43\:non \45\:non) resistor r=0.6502 c=0
Rk31 (\42\:non \53\:non) resistor r=0.07109 c=0
Rk32 (\43\:non \55\:non) resistor r=0.07109 c=0
Rl22 (\1\:A \15\:A) resistor r=35.989 c=0
Rl18 (\1\:A \10\:A) resistor r=55.0028 c=0
Rl20 (\1\:A \12\:A) resistor r=35.3463 c=0
Rl6 (\1\:A \6\:A) resistor r=86.3335 c=0
Rl4 (\1\:A \3\:A) resistor r=76.098 c=0
Rl54 (\18\:A \31\:A) resistor r=128.297 c=0
Rl43 (\18\:A \23\:A) resistor r=148.385 c=0
Rl47 (\18\:A \28\:A) resistor r=135.771 c=0
Rl33 (\17\:A \16\:A) resistor r=100.426 c=0
Rl37 (\17\:A \21\:A) resistor r=35.772 c=0
Rl34 (\17\:A \18\:A) resistor r=98.0022 c=0
Rl23 (\1\:OE \14\:OE) resistor r=263.027 c=0
Rl28 (\20\:OE \14\:OE) resistor r=92.3077 c=0
Rl30 (\1\:OE \22\:OE) resistor r=72.9851 c=0
Rl27 (\1\:OE \19\:OE) resistor r=53.079 c=0
Rl13 (\1\:OE \11\:OE) resistor r=30.0028 c=0
Rl15 (\1\:OE \13\:OE) resistor r=24.6815 c=0
Rl2 (\1\:OE \3\:OE) resistor r=29.5379 c=0
Rl51 (\2\:OEb \13\:OEb) resistor r=72.3105 c=0
Rl50 (\2\:OEb \12\:OEb) resistor r=71.8867 c=0
Rl39 (\2\:OEb \4\:OEb) resistor r=121.898 c=0
Rl40 (\2\:OEb \6\:OEb) resistor r=75.5053 c=0
Rl31 (\2\:OEb OEb) resistor r=70.9489 c=0
Rl70 (non \17\:non) resistor r=24.2107 c=0
Rz36 (\50\:VSS \49\:VSS) resistor r=75 c=0
Rz37 (\52\:VSS \51\:VSS) resistor r=75 c=0
Rz38 (\54\:VSS \53\:VSS) resistor r=75 c=0
Rz20 (\16\:VDD \1\:VDD) resistor r=6.25 c=0
Rz21 (\17\:VDD \1\:VDD) resistor r=6.25 c=0
Rz7 (\33\:pon \32\:pon) resistor r=75 c=0
Rz8 (\43\:pon \42\:pon) resistor r=75 c=0
Rz9 (\50\:pon \49\:pon) resistor r=75 c=0
Rz1 (\20\:OEb \19\:OEb) resistor r=75 c=0
Ry39 (\43\:VSS \1\:VSS) resistor r=5.1667 c=0
Ry28 (\41\:VDD \40\:VDD) resistor r=62 c=0
Ry29 (\43\:VDD \42\:VDD) resistor r=62 c=0
Ry1 (\22\:OEb \21\:OEb) resistor r=62 c=0
Ry2 (\45\:non \44\:non) resistor r=62 c=0
Ry3 (\53\:non \52\:non) resistor r=62 c=0
Ry4 (\55\:non \54\:non) resistor r=62 c=0
Rx16 (\37\:pon pon) resistor r=45 c=0
Rx15 (\41\:non \17\:non) resistor r=45 c=0
mn4_1__rcx (\49\:pon \3\:OE 14 VSS) g45n1lvt w=(2.05e-07) l=4.5e-08 nf=1 \
        as=2.46e-14 ad=2.87e-14 ps=6.5e-07 pd=6.9e-07 nrd=1.16667 \
        nrs=1.16667 sa=1.4e-07 sb=2e-06 sd=160n sca=19.867 scb=0.0198061 \
        scc=0.00201945 m=(1)
mn3_1__rcx (14 \3\:A \53\:VSS VSS) g45n1lvt w=(2.05e-07) l=4.5e-08 nf=1 \
        as=3.485e-14 ad=2.46e-14 ps=7.5e-07 pd=6.5e-07 nrd=1.16667 \
        nrs=1.16667 sa=3.05e-07 sb=2e-06 sd=160n sca=19.867 scb=0.0198061 \
        scc=0.00201945 m=(1)
mn3_2__rcx (15 \6\:A \53\:VSS VSS) g45n1lvt w=(2.05e-07) l=4.5e-08 nf=1 \
        as=3.485e-14 ad=4.92e-14 ps=7.5e-07 pd=8.9e-07 nrd=1.16667 \
        nrs=1.16667 sa=5.2e-07 sb=2e-06 sd=160n sca=19.867 scb=0.0198061 \
        scc=0.00201945 m=(1)
mn4_2__rcx (\42\:pon \13\:OE 15 VSS) g45n1lvt w=(2.05e-07) l=4.5e-08 nf=1 \
        as=4.92e-14 ad=6.15e-14 ps=8.9e-07 pd=1.01e-06 nrd=1.16667 \
        nrs=1.16667 sa=8.05e-07 sb=1.775e-06 sd=160n sca=19.867 \
        scb=0.0198061 scc=0.00201945 m=(1)
mn4_3__rcx (\42\:pon \11\:OE 16 VSS) g45n1lvt w=(2.05e-07) l=4.5e-08 nf=1 \
        as=2.153e-14 ad=6.15e-14 ps=6.2e-07 pd=1.01e-06 nrd=1.16667 \
        nrs=1.16667 sa=1.15e-06 sb=1.43e-06 sd=160n sca=19.867 \
        scb=0.0198061 scc=0.00201945 m=(1)
mn3_3__rcx (16 \12\:A \51\:VSS VSS) g45n1lvt w=(2.05e-07) l=4.5e-08 nf=1 \
        as=3.998e-14 ad=2.153e-14 ps=8e-07 pd=6.2e-07 nrd=1.16667 \
        nrs=1.16667 sa=1.3e-06 sb=1.28e-06 sd=160n sca=19.867 \
        scb=0.0198061 scc=0.00201945 m=(1)
mn3_4__rcx (17 \10\:A \51\:VSS VSS) g45n1lvt w=(2.05e-07) l=4.5e-08 nf=1 \
        as=3.998e-14 ad=1.23e-14 ps=8e-07 pd=5.3e-07 nrd=1.16667 \
        nrs=1.16667 sa=1.54e-06 sb=1.04e-06 sd=160n sca=19.867 \
        scb=0.0198061 scc=0.00201945 m=(1)
mn4_4__rcx (\32\:pon \19\:OE 17 VSS) g45n1lvt w=(2.05e-07) l=4.5e-08 nf=1 \
        as=1.23e-14 ad=3.998e-14 ps=5.3e-07 pd=8e-07 nrd=1.16667 \
        nrs=1.16667 sa=1.645e-06 sb=9.35e-07 sd=160n sca=19.867 \
        scb=0.0198061 scc=0.00201945 m=(1)
mn4 (\32\:pon \22\:OE 18 VSS) g45n1lvt w=(2.05e-07) l=4.5e-08 nf=1 \
        as=3.28e-14 ad=3.998e-14 ps=7.3e-07 pd=8e-07 nrd=1.16667 \
        nrs=1.16667 sa=1.885e-06 sb=6.95e-07 sd=160n sca=19.867 \
        scb=0.0198061 scc=0.00201945 m=(1)
mn3 (18 \15\:A \49\:VSS VSS) g45n1lvt w=(2.05e-07) l=4.5e-08 nf=1 \
        as=6.803e-14 ad=3.28e-14 ps=1.13e-06 pd=7.3e-07 nrd=1.16667 \
        nrs=1.16667 sa=2e-06 sb=4.9e-07 sd=160n sca=19.867 scb=0.0198061 \
        scc=0.00201945 m=(1)
mn2 (\33\:non \2\:OEb \1\:VSS VSS) g45n1lvt w=(2.05e-07) l=4.5e-08 nf=1 \
        as=3.198e-14 ad=3.444e-14 ps=7.22e-07 pd=7.46e-07 nrd=1.16667 \
        nrs=1.16667 sa=1.4e-07 sb=2e-06 sd=160n sca=7.14613 scb=0.0042077 \
        scc=4.68757e-05 m=(5)
mn1_1__rcx (\33\:non \18\:A \1\:VSS VSS) g45n1lvt w=(2.05e-07) l=4.5e-08 \
        nf=1 as=3.493e-14 ad=3.444e-14 ps=7.62e-07 pd=7.46e-07 nrd=1.16667 \
        nrs=1.16667 sa=3.45e-07 sb=2e-06 sd=160n sca=7.14613 scb=0.0042077 \
        scc=4.68757e-05 m=(5)
mn0 (\19\:OEb \20\:OE \49\:VSS VSS) g45n1lvt w=(2.6e-07) l=4.5e-08 nf=1 \
        as=6.803e-14 ad=3.64e-14 ps=1.13e-06 pd=8e-07 nrd=1.16667 \
        nrs=1.16667 sa=1.59808e-06 sb=1.4e-07 sd=160n sca=17.5885 \
        scb=0.0172826 scc=0.00162584 m=(1)
mn5_1__rcx (Y non \1\:VSS VSS) g45n1lvt w=(2.6e-07) l=4.5e-08 nf=1 \
        as=4.139e-14 ad=4.16e-14 ps=8.4063e-07 pd=8.4e-07 nrd=1.16667 \
        nrs=1.16667 sa=1.59808e-06 sb=2e-06 sd=160n sca=7.84363 \
        scb=0.00546499 scc=9.84911e-05 m=(16)
mp0 (\21\:OEb \14\:OE \17\:VDD VDD) g45p1lvt w=(3.9e-07) l=4.5e-08 nf=1 \
        as=5.76e-14 ad=1.2285e-13 ps=1.1e-06 pd=1.41e-06 nrd=1.16667 \
        nrs=1.16667 sa=1.24083e-06 sb=3.15e-07 sd=160n sca=30.5009 \
        scb=0.0202006 scc=0.00336097 m=(1)
mp5_1__rcx (Y pon \1\:VDD VDD) g45p1lvt w=(3.9e-07) l=4.5e-08 nf=1 \
        as=6.558e-14 ad=6.484e-14 ps=1.12313e-06 pd=1.1125e-06 nrd=1.16667 \
        nrs=1.16667 sa=1.61026e-06 sb=2e-06 sd=160n sca=12.8992 \
        scb=0.0114532 scc=0.000515529 m=(16)
ends TBUFX16
// End of subcircuit definition.
