// Generated for: spectre (May  1 09:18:24 2013 )
// Library name: gsclib045_lvt
// Cell name: OAI2BB2X4
// View name: extracted

simulator lang=spectre

subckt OAI2BB2X4 A0N A1N B0 B1 VDD VSS Y
mp1 (\19\:n1 \1\:A1N \21\:VDD VDD) g45p1lvt w=(3.9e-07) l=4.5e-08 nf=1 \
        as=6.24e-14 ad=5.46e-14 ps=1.1e-06 pd=1.06e-06 nrd=1.16667 \
        nrs=1.16667 sa=1.4e-07 sb=3.45e-07 sd=160n sca=19.8434 \
        scb=0.0211629 scc=0.00086948 m=(1)
mp0 (\18\:n0 \1\:A0N \21\:VDD VDD) g45p1lvt w=(3.9e-07) l=4.5e-08 nf=1 \
        as=6.24e-14 ad=5.46e-14 ps=1.1e-06 pd=1.06e-06 nrd=1.16667 \
        nrs=1.16667 sa=3.45e-07 sb=1.4e-07 sd=160n sca=15.6131 \
        scb=0.0139483 scc=0.000653233 m=(1)
mp2_1__rcx (6 n0 \19\:VDD VDD) g45p1lvt w=(3.9e-07) l=4.5e-08 nf=1 \
        as=5.46e-14 ad=2.34e-14 ps=1.06e-06 pd=9e-07 nrd=1.16667 \
        nrs=1.16667 sa=1.4e-07 sb=2e-06 sd=160n sca=16.2669 scb=0.0145797 \
        scc=0.00118861 m=(1)
mp3_1__rcx (\12\:Y \8\:n1 6 VDD) g45p1lvt w=(3.9e-07) l=4.5e-08 nf=1 \
        as=2.34e-14 ad=6.63e-14 ps=9e-07 pd=1.12e-06 nrd=1.16667 \
        nrs=1.16667 sa=2.45e-07 sb=2e-06 sd=160n sca=16.2669 scb=0.0145797 \
        scc=0.00118861 m=(1)
mp3_2__rcx (\12\:Y n1 7 VDD) g45p1lvt w=(3.9e-07) l=4.5e-08 nf=1 \
        as=2.34e-14 ad=6.63e-14 ps=9e-07 pd=1.12e-06 nrd=1.16667 \
        nrs=1.16667 sa=4.6e-07 sb=2e-06 sd=160n sca=16.2669 scb=0.0145797 \
        scc=0.00118861 m=(1)
mp2_2__rcx (7 \12\:n0 \17\:VDD VDD) g45p1lvt w=(3.9e-07) l=4.5e-08 nf=1 \
        as=1.215e-13 ad=2.34e-14 ps=1.77e-06 pd=9e-07 nrd=1.16667 \
        nrs=1.16667 sa=5.65e-07 sb=2e-06 sd=160n sca=16.2669 scb=0.0145797 \
        scc=0.00118861 m=(1)
mp2_3__rcx (9 \7\:n0 \17\:VDD VDD) g45p1lvt w=(3.9e-07) l=4.5e-08 nf=1 \
        as=1.215e-13 ad=3.51e-14 ps=1.77e-06 pd=9.6e-07 nrd=1.16667 \
        nrs=1.16667 sa=8.4e-07 sb=2e-06 sd=160n sca=16.2669 scb=0.0145797 \
        scc=0.00118861 m=(1)
mp3_3__rcx (\10\:Y \15\:n1 9 VDD) g45p1lvt w=(3.9e-07) l=4.5e-08 nf=1 \
        as=3.51e-14 ad=6.24e-14 ps=9.6e-07 pd=1.1e-06 nrd=1.16667 \
        nrs=1.16667 sa=9.75e-07 sb=2e-06 sd=160n sca=16.2669 scb=0.0145797 \
        scc=0.00118861 m=(1)
mp3 (\10\:Y \10\:n1 10 VDD) g45p1lvt w=(3.9e-07) l=4.5e-08 nf=1 \
        as=8.58e-14 ad=6.24e-14 ps=1.22e-06 pd=1.1e-06 nrd=1.16667 \
        nrs=1.16667 sa=1.18e-06 sb=2e-06 sd=160n sca=16.2669 scb=0.0145797 \
        scc=0.00118861 m=(1)
mp2 (10 \13\:n0 \15\:VDD VDD) g45p1lvt w=(3.9e-07) l=4.5e-08 nf=1 \
        as=1.176e-13 ad=8.58e-14 ps=1.75e-06 pd=1.22e-06 nrd=1.16667 \
        nrs=1.16667 sa=1.445e-06 sb=1.945e-06 sd=160n sca=16.2669 \
        scb=0.0145797 scc=0.00118861 m=(1)
mp4_1__rcx (11 \1\:B0 \15\:VDD VDD) g45p1lvt w=(3.9e-07) l=4.5e-08 nf=1 \
        as=1.176e-13 ad=5.655e-14 ps=1.75e-06 pd=1.07e-06 nrd=1.16667 \
        nrs=1.16667 sa=1.71e-06 sb=1.68e-06 sd=160n sca=16.2669 \
        scb=0.0145797 scc=0.00118861 m=(1)
mp5_1__rcx (\3\:Y \10\:B1 11 VDD) g45p1lvt w=(3.9e-07) l=4.5e-08 nf=1 \
        as=5.655e-14 ad=1.3455e-13 ps=1.07e-06 pd=1.47e-06 nrd=1.16667 \
        nrs=1.16667 sa=1.9e-06 sb=1.49e-06 sd=160n sca=16.2669 \
        scb=0.0145797 scc=0.00118861 m=(1)
mp5_2__rcx (\3\:Y \1\:B1 12 VDD) g45p1lvt w=(3.9e-07) l=4.5e-08 nf=1 \
        as=5.265e-14 ad=1.3455e-13 ps=1.05e-06 pd=1.47e-06 nrd=1.16667 \
        nrs=1.16667 sa=2e-06 sb=1.1e-06 sd=160n sca=16.2669 scb=0.0145797 \
        scc=0.00118861 m=(1)
mp4_2__rcx (12 \11\:B0 \13\:VDD VDD) g45p1lvt w=(3.9e-07) l=4.5e-08 nf=1 \
        as=1.176e-13 ad=5.265e-14 ps=1.75e-06 pd=1.05e-06 nrd=1.16667 \
        nrs=1.16667 sa=2e-06 sb=9.2e-07 sd=160n sca=16.2669 scb=0.0145797 \
        scc=0.00118861 m=(1)
mp4_3__rcx (13 \5\:B0 \13\:VDD VDD) g45p1lvt w=(3.9e-07) l=4.5e-08 nf=1 \
        as=1.176e-13 ad=5.07e-14 ps=1.75e-06 pd=1.04e-06 nrd=1.16667 \
        nrs=1.16667 sa=2e-06 sb=6.55e-07 sd=160n sca=16.4245 scb=0.0146155 \
        scc=0.00118862 m=(1)
mp5_3__rcx (\1\:Y \17\:B1 13 VDD) g45p1lvt w=(3.9e-07) l=4.5e-08 nf=1 \
        as=5.07e-14 ad=6.24e-14 ps=1.04e-06 pd=1.1e-06 nrd=1.16667 \
        nrs=1.16667 sa=2e-06 sb=4.8e-07 sd=160n sca=16.9872 scb=0.0148857 \
        scc=0.00118877 m=(1)
mp5 (\1\:Y \12\:B1 8 VDD) g45p1lvt w=(3.9e-07) l=4.5e-08 nf=1 as=2.34e-14 \
        ad=6.24e-14 ps=9e-07 pd=1.1e-06 nrd=1.16667 nrs=1.16667 sa=2e-06 \
        sb=2.75e-07 sd=160n sca=18.4199 scb=0.0164999 scc=0.00119548 m=(1)
mp4 (8 \14\:B0 \11\:VDD VDD) g45p1lvt w=(3.9e-07) l=4.5e-08 nf=1 \
        as=9.81e-14 ad=2.34e-14 ps=1.65e-06 pd=9e-07 nrd=1.16667 \
        nrs=1.16667 sa=2e-06 sb=1.7e-07 sd=160n sca=19.996 scb=0.0190983 \
        scc=0.00123425 m=(1)
C1 (Y VSS) capacitor c=4.11482e-17
C2 (VDD VSS) capacitor c=3.64434e-16
C3 (A0N VSS) capacitor c=5.98442e-17
C4 (B0 VSS) capacitor c=4.27057e-17
C5 (A1N VSS) capacitor c=9.22423e-17
C6 (n1 VSS) capacitor c=7.32797e-17
C7 (n0 VSS) capacitor c=9.50593e-17
C8 (n4 VSS) capacitor c=1.74343e-15
C9 (6 VSS) capacitor c=2.26562e-18
C10 (7 VSS) capacitor c=2.72975e-18
C11 (9 VSS) capacitor c=3.41961e-18
C12 (10 VSS) capacitor c=5.80348e-18
C13 (11 VSS) capacitor c=3.46881e-18
C14 (12 VSS) capacitor c=5.49378e-18
C15 (13 VSS) capacitor c=4.25442e-18
C16 (8 VSS) capacitor c=7.05326e-19
C17 (\14\:B0 VSS) capacitor c=6.41813e-17
C18 (\12\:B1 VSS) capacitor c=7.60743e-17
C19 (\17\:B1 VSS) capacitor c=4.28995e-17
C20 (\5\:B0 VSS) capacitor c=4.16039e-17
C21 (\11\:B0 VSS) capacitor c=3.91064e-17
C22 (\1\:B1 VSS) capacitor c=3.68188e-17
C23 (\10\:B1 VSS) capacitor c=3.67286e-17
C24 (\1\:B0 VSS) capacitor c=5.2395e-17
C25 (\13\:n0 VSS) capacitor c=4.62676e-17
C26 (\10\:n1 VSS) capacitor c=4.63857e-17
C27 (\15\:n1 VSS) capacitor c=5.85091e-17
C28 (\7\:n0 VSS) capacitor c=5.38929e-17
C29 (\12\:n0 VSS) capacitor c=6.3289e-17
C30 (\8\:n1 VSS) capacitor c=7.58404e-17
C31 (\1\:A0N VSS) capacitor c=4.95462e-17
C32 (\1\:A1N VSS) capacitor c=4.55796e-17
C33 (\3\:A0N VSS) capacitor c=4.34236e-17
C34 (\3\:A1N VSS) capacitor c=3.28954e-17
C35 (\3\:B1 VSS) capacitor c=3.70937e-16
C36 (\2\:n1 VSS) capacitor c=3.72092e-16
C37 (\6\:n1 VSS) capacitor c=2.14421e-17
C38 (\4\:n0 VSS) capacitor c=3.48178e-17
C39 (\2\:A0N VSS) capacitor c=3.81369e-17
C40 (\2\:A1N VSS) capacitor c=3.26536e-17
C41 (\11\:VDD VSS) capacitor c=2.73956e-17
C42 (\1\:Y VSS) capacitor c=1.06969e-16
C43 (\13\:VDD VSS) capacitor c=2.7002e-17
C44 (\3\:Y VSS) capacitor c=1.43623e-16
C45 (\15\:VDD VSS) capacitor c=3.51555e-17
C46 (\10\:Y VSS) capacitor c=1.01028e-16
C47 (\17\:VDD VSS) capacitor c=3.17601e-17
C48 (\12\:Y VSS) capacitor c=9.8001e-17
C49 (\19\:VDD VSS) capacitor c=4.83059e-17
C50 (\18\:n0 VSS) capacitor c=6.43729e-17
C51 (\21\:VDD VSS) capacitor c=3.90929e-17
C52 (\19\:n1 VSS) capacitor c=8.10263e-17
C53 (\1\:VDD VSS) capacitor c=5.41731e-17
C54 (\6\:Y VSS) capacitor c=4.04724e-16
C55 (\20\:n0 VSS) capacitor c=5.02323e-17
C56 (\17\:n1 VSS) capacitor c=2.03298e-16
C57 (\2\:n0 VSS) capacitor c=6.99585e-16
C58 (\2\:B0 VSS) capacitor c=5.80839e-16
C59 (\11\:B1 VSS) capacitor c=1.57164e-17
C60 (\2\:B1 VSS) capacitor c=1.1183e-17
C61 (\9\:B1 VSS) capacitor c=2.30627e-17
C62 (\4\:A1N VSS) capacitor c=4.09034e-17
C63 (\4\:A0N VSS) capacitor c=5.66469e-17
C64 (\17\:n0 VSS) capacitor c=8.25905e-17
C65 (\16\:n1 VSS) capacitor c=1.66522e-16
C66 (\18\:B1 VSS) capacitor c=1.07914e-16
C67 (\5\:Y VSS) capacitor c=1.08687e-16
C68 (\3\:VDD VSS) capacitor c=1.95869e-17
C69 (\4\:VDD VSS) capacitor c=2.32158e-17
C70 (\6\:VDD VSS) capacitor c=4.91448e-17
C71 (\7\:VDD VSS) capacitor c=4.42076e-17
C72 (\8\:VDD VSS) capacitor c=1.77376e-17
C73 (\10\:VDD VSS) capacitor c=2.45353e-17
Rk12 (\2\:Y \4\:Y) resistor r=0.6698 c=0
Rk16 (\5\:Y Y) resistor r=0.02575 c=0
Rk14 (\5\:Y \6\:Y) resistor r=0.6799 c=0
Rk13 (\4\:Y \5\:Y) resistor r=0.4471 c=0
Rk17 (Y \11\:Y) resistor r=0.2404 c=0
Rk18 (\11\:Y \13\:Y) resistor r=0.5364 c=0
Rk10 (\18\:B1 B1) resistor r=0.009408 c=0
Rk33 (\2\:VDD \3\:VDD) resistor r=0.1002 c=0
Rk34 (\3\:VDD \4\:VDD) resistor r=0.3762 c=0
Rk35 (\4\:VDD \5\:VDD) resistor r=0.1755 c=0
Rk36 (\5\:VDD \6\:VDD) resistor r=0.3227 c=0
Rk37 (\6\:VDD \7\:VDD) resistor r=0.4505 c=0
Rk38 (\7\:VDD \8\:VDD) resistor r=0.3209 c=0
Rk39 (\8\:VDD \9\:VDD) resistor r=0.1077 c=0
Rk41 (\10\:VDD VDD) resistor r=0.1577 c=0
Rk40 (\9\:VDD \10\:VDD) resistor r=0.3939 c=0
Rk42 (\3\:VDD \12\:VDD) resistor r=0.1035 c=0
Rk43 (\4\:VDD \14\:VDD) resistor r=0.1035 c=0
Rk44 (\6\:VDD \16\:VDD) resistor r=0.04337 c=0
Rk45 (\7\:VDD \18\:VDD) resistor r=0.1035 c=0
Rk46 (\8\:VDD \20\:VDD) resistor r=0.2596 c=0
Rk47 (\10\:VDD \22\:VDD) resistor r=0.2364 c=0
Rk2 (A0N \4\:A0N) resistor r=0.1808 c=0
Rk21 (B0 \2\:B0) resistor r=0.04362 c=0
Rk48 (\2\:VSS \3\:VSS) resistor r=0.6527 c=0
Rk49 (\3\:VSS \4\:VSS) resistor r=0.4557 c=0
Rk53 (\4\:VSS \8\:VSS) resistor r=0.1077 c=0
Rk55 (\9\:VSS VSS) resistor r=0.1401 c=0
Rk54 (\8\:VSS \9\:VSS) resistor r=0.4115 c=0
Rk60 (\9\:VSS \19\:VSS) resistor r=0.2323 c=0
Rk1 (A1N \4\:A1N) resistor r=0.06631 c=0
Rk5 (\16\:n1 \18\:n1) resistor r=1.2382 c=0
Rk6 (\18\:n1 \20\:n1) resistor r=0.6321 c=0
Rk3 (\17\:n0 \19\:n0) resistor r=0.4471 c=0
Rk4 (\17\:n0 \21\:n0) resistor r=0.2298 c=0
Rl51 (\3\:B1 \12\:B1) resistor r=120.387 c=0
Rl55 (\3\:B1 \17\:B1) resistor r=90.1797 c=0
Rl40 (\3\:B1 \8\:B1) resistor r=3.9152 c=0
Rl34 (\2\:B1 \1\:B1) resistor r=40.1923 c=0
Rl35 (\2\:B1 \3\:B1) resistor r=43.2713 c=0
Rl44 (\2\:B1 \11\:B1) resistor r=46.3175 c=0
Rl42 (\9\:B1 \10\:B1) resistor r=43.1761 c=0
Rl41 (\9\:B1 \8\:B1) resistor r=21.0032 c=0
Rl43 (\9\:B1 \11\:B1) resistor r=50.1411 c=0
Rl3 (\1\:A0N \2\:A0N) resistor r=91.0764 c=0
Rl4 (\2\:A0N \3\:A0N) resistor r=56.461 c=0
Rl57 (\2\:B0 \14\:B0) resistor r=24.7951 c=0
Rl45 (\2\:B0 \5\:B0) resistor r=55.7471 c=0
Rl50 (\2\:B0 \11\:B0) resistor r=34.3295 c=0
Rl31 (\2\:B0 \1\:B0) resistor r=37.477 c=0
Rl1 (\1\:A1N \2\:A1N) resistor r=87.6365 c=0
Rl2 (\2\:A1N \3\:A1N) resistor r=53.0211 c=0
Rl23 (\2\:n1 \10\:n1) resistor r=137.695 c=0
Rl27 (\2\:n1 \15\:n1) resistor r=110.513 c=0
Rl10 (\2\:n1 n1) resistor r=99.7951 c=0
Rl16 (\2\:n1 \8\:n1) resistor r=114.969 c=0
Rl14 (\2\:n1 \6\:n1) resistor r=9.3321 c=0
Rl28 (\2\:n0 \13\:n0) resistor r=37.3411 c=0
Rl18 (\2\:n0 \7\:n0) resistor r=69.2087 c=0
Rl22 (\2\:n0 \12\:n0) resistor r=28.079 c=0
Rl5 (\2\:n0 n0) resistor r=161.516 c=0
Rl7 (\2\:n0 \4\:n0) resistor r=158.53 c=0
Rz16 (\1\:VDD \2\:VDD) resistor r=75 c=0
Rz17 (\1\:VDD \5\:VDD) resistor r=6.25 c=0
Rz18 (\1\:VDD \9\:VDD) resistor r=6.25 c=0
Rz23 (\19\:VSS \18\:VSS) resistor r=75 c=0
Rz2 (\18\:n1 \17\:n1) resistor r=75 c=0
Rz1 (\21\:n0 \20\:n0) resistor r=75 c=0
Ry3 (\2\:Y \1\:Y) resistor r=62 c=0
Ry4 (\4\:Y \3\:Y) resistor r=62 c=0
Ry5 (\11\:Y \10\:Y) resistor r=62 c=0
Ry6 (\13\:Y \12\:Y) resistor r=62 c=0
Ry7 (\11\:VDD \12\:VDD) resistor r=62 c=0
Ry8 (\13\:VDD \14\:VDD) resistor r=62 c=0
Ry9 (\15\:VDD \16\:VDD) resistor r=62 c=0
Ry10 (\17\:VDD \18\:VDD) resistor r=62 c=0
Ry11 (\19\:VDD \20\:VDD) resistor r=62 c=0
Ry12 (\21\:VDD \22\:VDD) resistor r=62 c=0
Ry13 (\2\:VSS \1\:VSS) resistor r=62 c=0
Ry14 (\3\:VSS \1\:VSS) resistor r=5.1667 c=0
Ry15 (\8\:VSS \1\:VSS) resistor r=5.1667 c=0
Ry2 (\20\:n1 \19\:n1) resistor r=62 c=0
Ry1 (\19\:n0 \18\:n0) resistor r=62 c=0
Rx10 (\18\:B1 \8\:B1) resistor r=45 c=0
Rx2 (\2\:A0N \4\:A0N) resistor r=45 c=0
Rx1 (\2\:A1N \4\:A1N) resistor r=45 c=0
Rx4 (\16\:n1 \6\:n1) resistor r=45 c=0
Rx3 (\17\:n0 \4\:n0) resistor r=45 c=0
mn1 (\17\:n1 \3\:A1N \18\:VSS VSS) g45n1lvt w=(2.6e-07) l=4.5e-08 nf=1 \
        as=5.07e-14 ad=3.64e-14 ps=9.1e-07 pd=8e-07 nrd=1.16667 \
        nrs=1.16667 sa=1.4e-07 sb=4.6e-07 sd=160n sca=10.3222 \
        scb=0.00938145 scc=0.000353946 m=(1)
mn0 (\20\:n0 \3\:A0N \18\:VSS VSS) g45n1lvt w=(2.6e-07) l=4.5e-08 nf=1 \
        as=5.07e-14 ad=5.72e-14 ps=9.1e-07 pd=9.6e-07 nrd=1.16667 \
        nrs=1.16667 sa=3.8e-07 sb=2.2e-07 sd=160n sca=10.3222 \
        scb=0.00938145 scc=0.000353946 m=(1)
mn2_1__rcx (n4 \2\:n0 \4\:VSS VSS) g45n1lvt w=(2.6e-07) l=4.5e-08 nf=1 \
        as=6.078e-14 ad=4.323e-14 ps=1.04e-06 pd=8.525e-07 nrd=1.16667 \
        nrs=1.16667 sa=1.4e-07 sb=2e-06 sd=160n sca=9.14564 scb=0.00759168 \
        scc=0.000213449 m=(4)
mn3_1__rcx (n4 \2\:n1 \4\:VSS VSS) g45n1lvt w=(2.6e-07) l=4.5e-08 nf=1 \
        as=6.078e-14 ad=4.355e-14 ps=1.04e-06 pd=8.55e-07 nrd=1.16667 \
        nrs=1.16667 sa=4.9e-07 sb=2e-06 sd=160n sca=9.14564 scb=0.00759168 \
        scc=0.000213449 m=(4)
mn4_1__rcx (\6\:Y \2\:B0 n4 VSS) g45n1lvt w=(2.6e-07) l=4.5e-08 nf=1 \
        as=4.518e-14 ad=5.298e-14 ps=8.675e-07 pd=9.275e-07 nrd=1.16667 \
        nrs=1.16667 sa=2e-06 sb=1.78e-06 sd=160n sca=9.14564 \
        scb=0.00759168 scc=0.000213449 m=(4)
mn5_1__rcx (\6\:Y \3\:B1 n4 VSS) g45n1lvt w=(2.6e-07) l=4.5e-08 nf=1 \
        as=4.355e-14 ad=5.298e-14 ps=8.55e-07 pd=9.275e-07 nrd=1.16667 \
        nrs=1.16667 sa=2e-06 sb=1.575e-06 sd=160n sca=9.14564 \
        scb=0.00759168 scc=0.000213449 m=(4)
ends OAI2BB2X4
// End of subcircuit definition.
