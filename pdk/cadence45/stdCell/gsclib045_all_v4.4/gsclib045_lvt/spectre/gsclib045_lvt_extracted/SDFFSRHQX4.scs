// Generated for: spectre (May  1 09:15:02 2013 )
// Library name: gsclib045_lvt
// Cell name: SDFFSRHQX4
// View name: extracted

simulator lang=spectre

subckt SDFFSRHQX4 CK D Q RN SE SI SN VDD VSS
mp11 (net445 \1\:D \21\:VDD VDD) g45p1lvt w=(3.9e-07) l=4.5e-08 nf=1 \
        as=5.19e-14 ad=2.34e-14 ps=1.1e-06 pd=9e-07 nrd=1.16667 \
        nrs=1.16667 sa=2.35064e-07 sb=5.27308e-07 sd=160n sca=17.2385 \
        scb=0.0152696 scc=0.00137893 m=(1)
mp12 (\8\:Db \3\:SE net445 VDD) g45p1lvt w=(3.9e-07) l=4.5e-08 nf=1 \
        as=2.34e-14 ad=6.24e-14 ps=9e-07 pd=1.1e-06 nrd=1.16667 \
        nrs=1.16667 sa=3.40064e-07 sb=4.22308e-07 sd=160n sca=17.2385 \
        scb=0.0152696 scc=0.00137893 m=(1)
mp14 (\8\:Db \3\:SEb net453 VDD) g45p1lvt w=(3.9e-07) l=4.5e-08 nf=1 \
        as=2.34e-14 ad=6.24e-14 ps=9e-07 pd=1.1e-06 nrd=1.16667 \
        nrs=1.16667 sa=5.45064e-07 sb=2.17308e-07 sd=160n sca=17.2385 \
        scb=0.0152696 scc=0.00137893 m=(1)
mp13 (net453 \1\:SI \19\:VDD VDD) g45p1lvt w=(3.9e-07) l=4.5e-08 nf=1 \
        as=4.38e-14 ad=2.34e-14 ps=1.06e-06 pd=9e-07 nrd=1.16667 \
        nrs=1.16667 sa=6.50064e-07 sb=1.12308e-07 sd=160n sca=17.4322 \
        scb=0.015316 scc=0.00137893 m=(1)
mp55_1__rcx (Q qbint \14\:VDD VDD) g45p1lvt w=(3.9e-07) l=4.5e-08 nf=1 \
        as=5.925e-14 ad=6.24e-14 ps=1.09e-06 pd=1.1e-06 nrd=1.16667 \
        nrs=1.16667 sa=1.4e-07 sb=1.28949e-06 sd=160n sca=35.1619 \
        scb=0.02637 scc=0.00345369 m=(4)
C1 (RN VSS) capacitor c=5.9658e-17
C2 (D VSS) capacitor c=5.21983e-17
C3 (Q VSS) capacitor c=2.44956e-16
C4 (VDD VSS) capacitor c=5.07966e-16
C5 (CK VSS) capacitor c=4.25237e-17
C6 (SE VSS) capacitor c=1.03735e-16
C7 (SN VSS) capacitor c=2.35169e-16
C8 (SI VSS) capacitor c=9.87213e-17
C9 (qbint VSS) capacitor c=2.30768e-16
C10 (n35 VSS) capacitor c=1.55975e-17
C11 (RNb VSS) capacitor c=2.50169e-17
C12 (net490 VSS) capacitor c=8.661e-17
C13 (net486 VSS) capacitor c=1.46116e-16
C14 (CKb VSS) capacitor c=3.83318e-17
C15 (mout VSS) capacitor c=9.68847e-17
C16 (CKbb VSS) capacitor c=3.08044e-17
C17 (net469 VSS) capacitor c=5.5088e-17
C18 (n20 VSS) capacitor c=3.6203e-17
C19 (Db VSS) capacitor c=4.41009e-17
C20 (net522 VSS) capacitor c=1.37142e-18
C21 (SEb VSS) capacitor c=6.35501e-17
C22 (net534 VSS) capacitor c=1.71309e-18
C23 (net437 VSS) capacitor c=1.29793e-18
C24 (net394 VSS) capacitor c=9.60395e-17
C25 (net417 VSS) capacitor c=6.38365e-18
C26 (net425 VSS) capacitor c=1.44616e-18
C27 (net445 VSS) capacitor c=1.43883e-18
C28 (net453 VSS) capacitor c=1.71168e-18
C29 (\4\:SE VSS) capacitor c=3.01101e-17
C30 (\1\:SI VSS) capacitor c=7.2315e-17
C31 (\3\:SEb VSS) capacitor c=7.14067e-17
C32 (\3\:SE VSS) capacitor c=9.22986e-17
C33 (\1\:D VSS) capacitor c=1.03623e-16
C34 (\1\:CK VSS) capacitor c=7.09869e-17
C35 (\10\:CKb VSS) capacitor c=3.04452e-17
C36 (\8\:CKbb VSS) capacitor c=4.39317e-17
C37 (\5\:CKb VSS) capacitor c=6.16845e-17
C38 (\4\:mout VSS) capacitor c=6.981e-17
C39 (\6\:SN VSS) capacitor c=8.05155e-17
C40 (\3\:n20 VSS) capacitor c=6.22312e-17
C41 (\6\:RNb VSS) capacitor c=1.17424e-16
C42 (\3\:CKb VSS) capacitor c=4.36028e-17
C43 (\3\:CKbb VSS) capacitor c=5.17995e-17
C44 (\3\:SN VSS) capacitor c=5.02823e-17
C45 (\16\:qbint VSS) capacitor c=9.90159e-17
C46 (\2\:RNb VSS) capacitor c=5.04887e-17
C47 (\3\:RN VSS) capacitor c=3.19642e-17
C48 (\6\:SE VSS) capacitor c=2.19566e-17
C49 (\3\:SI VSS) capacitor c=7.50675e-17
C50 (\1\:SE VSS) capacitor c=5.77599e-17
C51 (\4\:D VSS) capacitor c=8.79536e-17
C52 (\3\:CK VSS) capacitor c=3.37617e-17
C53 (\7\:CKb VSS) capacitor c=2.83321e-17
C54 (\9\:CKb VSS) capacitor c=5.81915e-17
C55 (\9\:CKbb VSS) capacitor c=6.69271e-17
C56 (\5\:SN VSS) capacitor c=7.55788e-17
C57 (\4\:n20 VSS) capacitor c=3.39289e-17
C58 (\8\:RNb VSS) capacitor c=4.30186e-17
C59 (\1\:SN VSS) capacitor c=4.74138e-17
C60 (\13\:qbint VSS) capacitor c=2.99629e-17
C61 (\5\:RNb VSS) capacitor c=4.15857e-17
C62 (\1\:RN VSS) capacitor c=3.62308e-17
C63 (\5\:SE VSS) capacitor c=1.733e-17
C64 (\2\:SI VSS) capacitor c=5.23317e-17
C65 (\4\:SEb VSS) capacitor c=4.3037e-17
C66 (\2\:SE VSS) capacitor c=6.79669e-17
C67 (\2\:SEb VSS) capacitor c=4.57028e-17
C68 (\3\:D VSS) capacitor c=4.21819e-17
C69 (\2\:CK VSS) capacitor c=5.87438e-17
C70 (\8\:CKb VSS) capacitor c=5.33803e-17
C71 (\5\:CKbb VSS) capacitor c=4.59667e-17
C72 (\6\:CKb VSS) capacitor c=4.32095e-17
C73 (\7\:CKbb VSS) capacitor c=5.54029e-17
C74 (\3\:mout VSS) capacitor c=2.02168e-17
C75 (\7\:SN VSS) capacitor c=2.51954e-17
C76 (\4\:CKbb VSS) capacitor c=3.21302e-17
C77 (\4\:CKb VSS) capacitor c=3.89693e-17
C78 (\2\:CKb VSS) capacitor c=2.67405e-17
C79 (\7\:RNb VSS) capacitor c=7.88614e-17
C80 (\4\:SN VSS) capacitor c=2.13464e-17
C81 (\15\:qbint VSS) capacitor c=3.23783e-17
C82 (\4\:RNb VSS) capacitor c=3.12308e-17
C83 (\2\:RN VSS) capacitor c=3.87164e-17
C84 (\1\:VDD VSS) capacitor c=2.61559e-17
C85 (\9\:SEb VSS) capacitor c=1.00144e-16
C86 (\19\:VDD VSS) capacitor c=2.97754e-17
C87 (\8\:Db VSS) capacitor c=1.301e-16
C88 (\21\:VDD VSS) capacitor c=3.73005e-17
C89 (\11\:CKb VSS) capacitor c=7.7734e-17
C90 (\23\:VDD VSS) capacitor c=3.15869e-17
C91 (\13\:CKbb VSS) capacitor c=4.2242e-17
C92 (\6\:Db VSS) capacitor c=1.05231e-16
C93 (\7\:n20 VSS) capacitor c=9.79351e-17
C94 (\25\:VDD VSS) capacitor c=5.76041e-17
C95 (\6\:mout VSS) capacitor c=1.95453e-16
C96 (\27\:VDD VSS) capacitor c=5.34204e-17
C97 (\11\:mout VSS) capacitor c=3.55912e-17
C98 (\9\:n35 VSS) capacitor c=7.63216e-17
C99 (\29\:VDD VSS) capacitor c=3.07421e-17
C100 (\3\:net394 VSS) capacitor c=8.11713e-17
C101 (\31\:VDD VSS) capacitor c=2.01785e-17
C102 (\9\:RNb VSS) capacitor c=4.3815e-17
C103 (\23\:qbint VSS) capacitor c=8.4051e-17
C104 (\3\:VDD VSS) capacitor c=1.03934e-16
C105 (\5\:SEb VSS) capacitor c=1.13441e-16
C106 (\17\:CKb VSS) capacitor c=6.27908e-17
C107 (\15\:CKbb VSS) capacitor c=6.00087e-17
C108 (\4\:Db VSS) capacitor c=1.91528e-16
C109 (\9\:n20 VSS) capacitor c=3.61553e-17
C110 (\13\:mout VSS) capacitor c=1.46571e-16
C111 (\3\:net469 VSS) capacitor c=7.15713e-17
C112 (\9\:mout VSS) capacitor c=1.21388e-16
C113 (\13\:n35 VSS) capacitor c=6.66098e-17
C114 (\3\:net490 VSS) capacitor c=8.09597e-17
C115 (\3\:net486 VSS) capacitor c=1.24199e-16
C116 (\12\:RNb VSS) capacitor c=5.63118e-17
C117 (\21\:qbint VSS) capacitor c=2.20262e-17
C118 (\2\:n35 VSS) capacitor c=1.63969e-16
C119 (\3\:RNb VSS) capacitor c=4.98573e-17
C120 (\14\:qbint VSS) capacitor c=2.93639e-17
C121 (\2\:SN VSS) capacitor c=3.44043e-17
C122 (\2\:CKbb VSS) capacitor c=5.98244e-17
C123 (\2\:n20 VSS) capacitor c=2.5307e-17
C124 (\2\:mout VSS) capacitor c=5.22564e-17
C125 (\6\:CKbb VSS) capacitor c=3.01524e-17
C126 (\4\:RN VSS) capacitor c=5.71963e-17
C127 (\11\:RNb VSS) capacitor c=5.49087e-17
C128 (\2\:D VSS) capacitor c=3.43868e-17
C129 (\17\:qbint VSS) capacitor c=1.6209e-16
C130 (\18\:qbint VSS) capacitor c=1.31012e-16
C131 (\19\:qbint VSS) capacitor c=2.93919e-17
C132 (\20\:qbint VSS) capacitor c=2.83899e-17
C133 (\14\:RNb VSS) capacitor c=1.12889e-16
C134 (\15\:RNb VSS) capacitor c=7.91489e-17
C135 (\11\:n35 VSS) capacitor c=3.10506e-16
C136 (\12\:n35 VSS) capacitor c=2.35508e-16
C137 (\8\:SN VSS) capacitor c=2.26403e-16
C138 (\9\:SN VSS) capacitor c=3.35734e-17
C139 (\5\:mout VSS) capacitor c=5.95155e-17
C140 (\8\:mout VSS) capacitor c=1.48412e-16
C141 (\10\:CKbb VSS) capacitor c=2.19022e-16
C142 (\11\:CKbb VSS) capacitor c=1.93374e-16
C143 (\5\:n20 VSS) capacitor c=6.70997e-17
C144 (\6\:n20 VSS) capacitor c=9.50731e-17
C145 (\12\:CKbb VSS) capacitor c=6.06258e-17
C146 (\4\:CK VSS) capacitor c=6.73649e-17
C147 (\5\:D VSS) capacitor c=7.29229e-17
C148 (\13\:CKb VSS) capacitor c=1.42626e-16
C149 (\14\:CKb VSS) capacitor c=9.65274e-17
C150 (\15\:CKb VSS) capacitor c=3.06975e-16
C151 (\16\:CKb VSS) capacitor c=4.42883e-17
C152 (\19\:CKb VSS) capacitor c=3.64263e-16
C153 (\20\:CKb VSS) capacitor c=1.17428e-16
C154 (\3\:Db VSS) capacitor c=1.90959e-16
C155 (\4\:SI VSS) capacitor c=3.72149e-17
C156 (\7\:SEb VSS) capacitor c=1.51125e-16
C157 (\8\:SEb VSS) capacitor c=1.20847e-16
C158 (\7\:SE VSS) capacitor c=9.09822e-17
C159 (\8\:SE VSS) capacitor c=2.88355e-17
C160 (\5\:VDD VSS) capacitor c=1.37551e-17
C161 (\6\:VDD VSS) capacitor c=2.857e-17
C162 (\7\:VDD VSS) capacitor c=2.00591e-17
C163 (\9\:VDD VSS) capacitor c=4.19707e-17
C164 (\10\:VDD VSS) capacitor c=4.47821e-17
C165 (\12\:VDD VSS) capacitor c=4.95755e-17
C166 (\13\:VDD VSS) capacitor c=3.44118e-17
C167 (\14\:VDD VSS) capacitor c=2.76703e-16
Rk6 (RN \4\:RN) resistor r=0.09921 c=0
Rk36 (D \5\:D) resistor r=0.02137 c=0
Rk81 (\2\:VSS \4\:VSS) resistor r=0.6068 c=0
Rk82 (\4\:VSS \5\:VSS) resistor r=0.08259 c=0
Rk83 (\5\:VSS \6\:VSS) resistor r=0.3549 c=0
Rk84 (\6\:VSS \7\:VSS) resistor r=0.2611 c=0
Rk85 (\7\:VSS \8\:VSS) resistor r=0.2497 c=0
Rk86 (\8\:VSS \9\:VSS) resistor r=0.3134 c=0
Rk87 (\9\:VSS \10\:VSS) resistor r=0.8904 c=0
Rk88 (\10\:VSS \11\:VSS) resistor r=0.2808 c=0
Rk94 (\12\:VSS VSS) resistor r=0.07983 c=0
Rk89 (\11\:VSS \12\:VSS) resistor r=0.7622 c=0
Rk95 (\5\:VSS \18\:VSS) resistor r=0.2001 c=0
Rk96 (\6\:VSS \20\:VSS) resistor r=0.04333 c=0
Rk97 (\7\:VSS \22\:VSS) resistor r=0.04333 c=0
Rk98 (\9\:VSS \24\:VSS) resistor r=0.2403 c=0
Rk99 (\11\:VSS \26\:VSS) resistor r=0.07416 c=0
Rk54 (\2\:VDD \4\:VDD) resistor r=0.7242 c=0
Rk55 (\4\:VDD \5\:VDD) resistor r=0.03493 c=0
Rk56 (\5\:VDD \6\:VDD) resistor r=0.3107 c=0
Rk57 (\6\:VDD \7\:VDD) resistor r=0.4311 c=0
Rk58 (\7\:VDD \8\:VDD) resistor r=0.1754 c=0
Rk59 (\8\:VDD \9\:VDD) resistor r=0.356 c=0
Rk60 (\9\:VDD \10\:VDD) resistor r=0.5114 c=0
Rk61 (\10\:VDD \11\:VDD) resistor r=0.336 c=0
Rk62 (\11\:VDD \12\:VDD) resistor r=0.3752 c=0
Rk63 (\12\:VDD \13\:VDD) resistor r=0.3348 c=0
Rk69 (\14\:VDD VDD) resistor r=0.07983 c=0
Rk64 (\13\:VDD \14\:VDD) resistor r=0.3308 c=0
Rk70 (\5\:VDD \20\:VDD) resistor r=0.2585 c=0
Rk71 (\6\:VDD \22\:VDD) resistor r=0.2689 c=0
Rk72 (\7\:VDD \24\:VDD) resistor r=0.1847 c=0
Rk73 (\9\:VDD \26\:VDD) resistor r=0.2667 c=0
Rk74 (\10\:VDD \28\:VDD) resistor r=0.1733 c=0
Rk75 (\12\:VDD \30\:VDD) resistor r=0.04333 c=0
Rk76 (\13\:VDD \32\:VDD) resistor r=0.07416 c=0
Rk35 (CK \4\:CK) resistor r=0.1413 c=0
Rk52 (SE \7\:SE) resistor r=0.349 c=0
Rk53 (SE \8\:SE) resistor r=0.1576 c=0
Rk22 (\8\:SN SN) resistor r=1.7734 c=0
Rk23 (SN \9\:SN) resistor r=0.1145 c=0
Rk48 (\4\:SI SI) resistor r=0.05445 c=0
Rk9 (\17\:qbint \18\:qbint) resistor r=1.1772 c=0
Rk10 (\18\:qbint \19\:qbint) resistor r=0.1222 c=0
Rk11 (\19\:qbint \20\:qbint) resistor r=0.1635 c=0
Rk12 (\18\:qbint \22\:qbint) resistor r=0.0611 c=0
Rk13 (\19\:qbint \24\:qbint) resistor r=0.2933 c=0
Rk18 (\10\:n35 \11\:n35) resistor r=0.1916 c=0
Rk19 (\11\:n35 \12\:n35) resistor r=2.0548 c=0
Rk20 (\11\:n35 \14\:n35) resistor r=0.1632 c=0
Rk7 (\10\:RNb \11\:RNb) resistor r=0.1366 c=0
Rk8 (\11\:RNb \13\:RNb) resistor r=0.1548 c=0
Rk16 (\14\:RNb \15\:RNb) resistor r=0.6213 c=0
Rk15 (\2\:net490 \4\:net490) resistor r=0.5427 c=0
Rk14 (\2\:net486 \4\:net486) resistor r=0.8494 c=0
Rk37 (\12\:CKb \13\:CKb) resistor r=0.4982 c=0
Rk38 (\13\:CKb \14\:CKb) resistor r=0.3656 c=0
Rk39 (\13\:CKb \15\:CKb) resistor r=0.7856 c=0
Rk40 (\15\:CKb \16\:CKb) resistor r=0.1208 c=0
Rk41 (\14\:CKb \18\:CKb) resistor r=0.3804 c=0
Rk42 (\15\:CKb \19\:CKb) resistor r=1.8482 c=0
Rk43 (\19\:CKb \20\:CKb) resistor r=0.8559 c=0
Rk24 (\5\:mout \7\:mout) resistor r=0.2806 c=0
Rk25 (\7\:mout \8\:mout) resistor r=0.9773 c=0
Rk26 (\8\:mout \10\:mout) resistor r=0.3084 c=0
Rk27 (\8\:mout \12\:mout) resistor r=0.07562 c=0
Rk28 (\10\:mout \14\:mout) resistor r=0.7891 c=0
Rk29 (\10\:CKbb \11\:CKbb) resistor r=1.3392 c=0
Rk33 (\12\:CKbb \14\:CKbb) resistor r=0.1467 c=0
Rk34 (\12\:CKbb \16\:CKbb) resistor r=0.241 c=0
Rk21 (\2\:net469 \4\:net469) resistor r=0.3101 c=0
Rk30 (\5\:n20 \6\:n20) resistor r=0.4012 c=0
Rk31 (\6\:n20 \8\:n20) resistor r=0.4213 c=0
Rk32 (\6\:n20 \10\:n20) resistor r=0.09071 c=0
Rk44 (\2\:Db \3\:Db) resistor r=0.1866 c=0
Rk45 (\3\:Db \5\:Db) resistor r=0.9072 c=0
Rk46 (\5\:Db \7\:Db) resistor r=0.5864 c=0
Rk47 (\3\:Db \9\:Db) resistor r=0.9208 c=0
Rk49 (\6\:SEb \7\:SEb) resistor r=0.7847 c=0
Rk50 (\7\:SEb \8\:SEb) resistor r=0.3186 c=0
Rk51 (\8\:SEb \10\:SEb) resistor r=0.7019 c=0
Rk17 (\2\:net394 \4\:net394) resistor r=0.2992 c=0
Rl20 (\2\:RN \3\:RN) resistor r=26.3736 c=0
Rl19 (\1\:RN \2\:RN) resistor r=94.2308 c=0
Rl56 (\1\:D \2\:D) resistor r=86.5164 c=0
Rl58 (\2\:D \4\:D) resistor r=120.835 c=0
Rl57 (\2\:D \3\:D) resistor r=76.8484 c=0
Rl54 (\1\:CK \2\:CK) resistor r=200.257 c=0
Rl55 (\2\:CK \3\:CK) resistor r=100.692 c=0
Rl65 (\4\:SE \5\:SE) resistor r=69.9225 c=0
Rl66 (\5\:SE \6\:SE) resistor r=31.461 c=0
Rl61 (\2\:SE \3\:SE) resistor r=120.067 c=0
Rl60 (\1\:SE \2\:SE) resistor r=34.6154 c=0
Rl41 (\5\:SN \6\:SN) resistor r=193.796 c=0
Rl42 (\6\:SN \7\:SN) resistor r=24.2328 c=0
Rl29 (\2\:SN \3\:SN) resistor r=57.6702 c=0
Rl28 (\1\:SN \2\:SN) resistor r=145.835 c=0
Rl30 (\2\:SN \4\:SN) resistor r=44.1561 c=0
Rl63 (\1\:SI \2\:SI) resistor r=24.2328 c=0
Rl64 (\2\:SI \3\:SI) resistor r=119.952 c=0
Rl27 (\14\:qbint \16\:qbint) resistor r=95.7383 c=0
Rl25 (\14\:qbint \13\:qbint) resistor r=50.725 c=0
Rl26 (\14\:qbint \15\:qbint) resistor r=15.3358 c=0
Rl12 (\2\:n35 n35) resistor r=1.2713 c=0
Rl37 (\6\:RNb \8\:RNb) resistor r=119.231 c=0
Rl36 (\6\:RNb \7\:RNb) resistor r=718.744 c=0
Rl21 (RNb \2\:RNb) resistor r=24.2328 c=0
Rl22 (\2\:RNb \3\:RNb) resistor r=103.824 c=0
Rl24 (\3\:RNb \5\:RNb) resistor r=82.3738 c=0
Rl23 (\3\:RNb \4\:RNb) resistor r=115.31 c=0
Rl53 (\8\:CKb \10\:CKb) resistor r=78.1713 c=0
Rl51 (\7\:CKb \8\:CKb) resistor r=26.7711 c=0
Rl52 (\8\:CKb \9\:CKb) resistor r=188.381 c=0
Rl46 (\5\:CKb \6\:CKb) resistor r=24.2328 c=0
Rl32 (\3\:CKb \4\:CKb) resistor r=24.2328 c=0
Rl31 (CKb \2\:CKb) resistor r=34.0806 c=0
Rl45 (\2\:mout \4\:mout) resistor r=34.3295 c=0
Rl43 (mout \2\:mout) resistor r=172.357 c=0
Rl44 (\2\:mout \3\:mout) resistor r=4.3144 c=0
Rl50 (\7\:CKbb \9\:CKbb) resistor r=85.7713 c=0
Rl34 (\2\:CKbb \3\:CKbb) resistor r=128.39 c=0
Rl33 (CKbb \2\:CKbb) resistor r=38.143 c=0
Rl35 (\2\:CKbb \4\:CKbb) resistor r=150.332 c=0
Rl49 (\6\:CKbb \8\:CKbb) resistor r=82.3738 c=0
Rl47 (\5\:CKbb \6\:CKbb) resistor r=86.4638 c=0
Rl48 (\6\:CKbb \7\:CKbb) resistor r=74.5433 c=0
Rl39 (\2\:n20 \3\:n20) resistor r=88.1101 c=0
Rl40 (\2\:n20 \4\:n20) resistor r=30.5714 c=0
Rl38 (n20 \2\:n20) resistor r=68.8799 c=0
Rl62 (\3\:SEb \4\:SEb) resistor r=24.2328 c=0
Rl59 (SEb \2\:SEb) resistor r=31.9251 c=0
Rz24 (\2\:VSS \1\:VSS) resistor r=75 c=0
Rz25 (\18\:VSS \17\:VSS) resistor r=75 c=0
Rz26 (\20\:VSS \19\:VSS) resistor r=75 c=0
Rz27 (\22\:VSS \21\:VSS) resistor r=75 c=0
Rz28 (\24\:VSS \23\:VSS) resistor r=75 c=0
Rz29 (\26\:VSS \25\:VSS) resistor r=75 c=0
Rz20 (\4\:VDD \3\:VDD) resistor r=10.7143 c=0
Rz21 (\8\:VDD \3\:VDD) resistor r=6.25 c=0
Rz22 (\11\:VDD \3\:VDD) resistor r=6.25 c=0
Rz23 (\14\:VDD \3\:VDD) resistor r=6.25 c=0
Rz4 (\22\:qbint \21\:qbint) resistor r=75 c=0
Rz9 (\14\:n35 \13\:n35) resistor r=75 c=0
Rz3 (\12\:RNb \13\:RNb) resistor r=75 c=0
Rz7 (net490 \2\:net490) resistor r=75 c=0
Rz8 (\3\:net490 \4\:net490) resistor r=75 c=0
Rz5 (net486 \2\:net486) resistor r=75 c=0
Rz6 (\3\:net486 \4\:net486) resistor r=75 c=0
Rz16 (\17\:CKb \18\:CKb) resistor r=75 c=0
Rz12 (\9\:mout \10\:mout) resistor r=75 c=0
Rz13 (\13\:mout \14\:mout) resistor r=75 c=0
Rz15 (\15\:CKbb \16\:CKbb) resistor r=75 c=0
Rz10 (net469 \2\:net469) resistor r=75 c=0
Rz11 (\3\:net469 \4\:net469) resistor r=75 c=0
Rz14 (\9\:n20 \10\:n20) resistor r=75 c=0
Rz17 (Db \2\:Db) resistor r=75 c=0
Rz18 (\4\:Db \5\:Db) resistor r=75 c=0
Rz19 (\5\:SEb \6\:SEb) resistor r=75 c=0
Ry28 (\4\:VSS \3\:VSS) resistor r=8.8571 c=0
Ry29 (\8\:VSS \3\:VSS) resistor r=5.1667 c=0
Ry30 (\10\:VSS \3\:VSS) resistor r=5.1667 c=0
Ry31 (\12\:VSS \3\:VSS) resistor r=5.1667 c=0
Ry16 (\2\:VDD \1\:VDD) resistor r=62 c=0
Ry17 (\20\:VDD \19\:VDD) resistor r=62 c=0
Ry18 (\22\:VDD \21\:VDD) resistor r=62 c=0
Ry19 (\24\:VDD \23\:VDD) resistor r=62 c=0
Ry20 (\26\:VDD \25\:VDD) resistor r=62 c=0
Ry21 (\28\:VDD \27\:VDD) resistor r=62 c=0
Ry22 (\30\:VDD \29\:VDD) resistor r=62 c=0
Ry23 (\32\:VDD \31\:VDD) resistor r=62 c=0
Ry4 (\24\:qbint \23\:qbint) resistor r=31 c=0
Ry7 (\10\:n35 \9\:n35) resistor r=31 c=0
Ry3 (\9\:RNb \10\:RNb) resistor r=62 c=0
Ry12 (\11\:CKb \12\:CKb) resistor r=62 c=0
Ry8 (\6\:mout \7\:mout) resistor r=62 c=0
Ry9 (\11\:mout \12\:mout) resistor r=62 c=0
Ry11 (\13\:CKbb \14\:CKbb) resistor r=62 c=0
Ry10 (\7\:n20 \8\:n20) resistor r=62 c=0
Ry13 (\6\:Db \7\:Db) resistor r=62 c=0
Ry14 (\8\:Db \9\:Db) resistor r=62 c=0
Ry15 (\9\:SEb \10\:SEb) resistor r=62 c=0
Ry5 (net394 \2\:net394) resistor r=62 c=0
Ry6 (\3\:net394 \4\:net394) resistor r=62 c=0
Rx1 (\2\:RN \4\:RN) resistor r=45 c=0
Rx16 (\3\:D \5\:D) resistor r=45 c=0
Rx15 (\2\:CK \4\:CK) resistor r=45 c=0
Rx24 (\2\:SE \7\:SE) resistor r=45 c=0
Rx25 (\5\:SE \8\:SE) resistor r=45 c=0
Rx8 (\7\:SN \8\:SN) resistor r=45 c=0
Rx9 (\4\:SN \9\:SN) resistor r=45 c=0
Rx21 (\2\:SI \4\:SI) resistor r=45 c=0
Rx3 (\17\:qbint \15\:qbint) resistor r=45 c=0
Rx4 (\20\:qbint qbint) resistor r=45 c=0
Rx7 (\12\:n35 n35) resistor r=45 c=0
Rx2 (\4\:RNb \11\:RNb) resistor r=45 c=0
Rx5 (\7\:RNb \14\:RNb) resistor r=45 c=0
Rx6 (RNb \15\:RNb) resistor r=45 c=0
Rx17 (\8\:CKb \14\:CKb) resistor r=45 c=0
Rx18 (\6\:CKb \16\:CKb) resistor r=45 c=0
Rx19 (\4\:CKb \19\:CKb) resistor r=45 c=0
Rx20 (\2\:CKb \20\:CKb) resistor r=45 c=0
Rx10 (\3\:mout \5\:mout) resistor r=45 c=0
Rx11 (\7\:CKbb \10\:CKbb) resistor r=45 c=0
Rx12 (\4\:CKbb \11\:CKbb) resistor r=45 c=0
Rx14 (\5\:CKbb \12\:CKbb) resistor r=45 c=0
Rx13 (n20 \5\:n20) resistor r=45 c=0
Rx22 (\2\:SEb \7\:SEb) resistor r=45 c=0
Rx23 (\4\:SEb \8\:SEb) resistor r=45 c=0
mn11 (net522 \4\:D \19\:VSS VSS) g45n1lvt w=(2.6e-07) l=4.5e-08 nf=1 \
        as=7.415e-14 ad=1.56e-14 ps=1.85e-06 pd=6.4e-07 nrd=1.16667 \
        nrs=1.16667 sa=2.69231e-07 sb=6.45e-07 sd=160n sca=9.14564 \
        scb=0.00759168 scc=0.000213449 m=(1)
mn12 (Db SEb net522 VSS) g45n1lvt w=(2.6e-07) l=4.5e-08 nf=1 as=1.56e-14 \
        ad=6.5e-14 ps=6.4e-07 pd=1.02e-06 nrd=1.16667 nrs=1.16667 \
        sa=3.74231e-07 sb=5.4e-07 sd=160n sca=9.14564 scb=0.00759168 \
        scc=0.000213449 m=(1)
mn14 (Db \1\:SE net534 VSS) g45n1lvt w=(2.6e-07) l=4.5e-08 nf=1 \
        as=1.56e-14 ad=6.5e-14 ps=6.4e-07 pd=1.02e-06 nrd=1.16667 \
        nrs=1.16667 sa=6.69231e-07 sb=2.45e-07 sd=160n sca=9.14564 \
        scb=0.00759168 scc=0.000213449 m=(1)
mn13 (net534 \3\:SI \17\:VSS VSS) g45n1lvt w=(2.6e-07) l=4.5e-08 nf=1 \
        as=3.64e-14 ad=1.56e-14 ps=8e-07 pd=6.4e-07 nrd=1.16667 \
        nrs=1.16667 sa=7.74231e-07 sb=1.4e-07 sd=160n sca=9.14564 \
        scb=0.00759168 scc=0.000213449 m=(1)
mn55_1__rcx (Q qbint \12\:VSS VSS) g45n1lvt w=(2.6e-07) l=4.5e-08 nf=1 \
        as=3.947e-14 ad=4.16e-14 ps=8.3e-07 pd=8.4e-07 nrd=1.16667 \
        nrs=1.16667 sa=1.4e-07 sb=1.28173e-06 sd=160n sca=17.5885 \
        scb=0.0172826 scc=0.00162584 m=(4)
mn51 (\3\:net490 \5\:RNb \3\:net486 VSS) g45n1lvt w=(2.05e-07) l=4.5e-08 \
        nf=1 as=4.407e-14 ad=5.33e-14 ps=8.4e-07 pd=9.3e-07 nrd=1.16667 \
        nrs=1.16667 sa=2.15e-07 sb=6.3e-07 sd=160n sca=14.2182 \
        scb=0.0146528 scc=0.000922757 m=(1)
mn52 (\3\:net490 \13\:qbint net486 VSS) g45n1lvt w=(2.05e-07) l=4.5e-08 \
        nf=1 as=3.69e-14 ad=5.33e-14 ps=7.7e-07 pd=9.3e-07 nrd=1.16667 \
        nrs=1.16667 sa=5.2e-07 sb=3.25e-07 sd=160n sca=14.2182 \
        scb=0.0146528 scc=0.000922757 m=(1)
mn50 (net486 \1\:SN \25\:VSS VSS) g45n1lvt w=(2.05e-07) l=4.5e-08 nf=1 \
        as=5.835e-14 ad=3.69e-14 ps=1.62e-06 pd=7.7e-07 nrd=1.16667 \
        nrs=1.16667 sa=7.45e-07 sb=1e-07 sd=160n sca=14.2182 scb=0.0146528 \
        scc=0.000922757 m=(1)
mn53 (\13\:n35 CKb net490 VSS) g45n1lvt w=(2.05e-07) l=4.5e-08 nf=1 \
        as=4.21e-14 ad=3.997e-14 ps=9.7e-07 pd=8e-07 nrd=1.16667 \
        nrs=1.16667 sa=2.05366e-07 sb=5.25e-07 sd=160n sca=14.6414 \
        scb=0.0151256 scc=0.000999928 m=(1)
mn40 (\13\:n35 CKbb \9\:mout VSS) g45n1lvt w=(2.05e-07) l=4.5e-08 nf=1 \
        as=5.842e-14 ad=3.997e-14 ps=9.8e-07 pd=8e-07 nrd=1.16667 \
        nrs=1.16667 sa=4.45366e-07 sb=2.85e-07 sd=160n sca=14.6414 \
        scb=0.0151256 scc=0.000999928 m=(1)
mn31 (\13\:mout \8\:RNb \3\:net469 VSS) g45n1lvt w=(2.05e-07) l=4.5e-08 \
        nf=1 as=2.87e-14 ad=3.587e-14 ps=6.9e-07 pd=7.6e-07 nrd=1.16667 \
        nrs=1.16667 sa=1.4e-07 sb=1.02317e-06 sd=160n sca=12.7388 \
        scb=0.0128661 scc=0.000666764 m=(1)
mn32 (\13\:mout \4\:n20 net469 VSS) g45n1lvt w=(2.05e-07) l=4.5e-08 nf=1 \
        as=6.115e-14 ad=3.587e-14 ps=1.17e-06 pd=7.6e-07 nrd=1.16667 \
        nrs=1.16667 sa=3.6e-07 sb=8.03171e-07 sd=160n sca=12.7388 \
        scb=0.0128661 scc=0.000666764 m=(1)
mn30 (net469 \5\:SN \23\:VSS VSS) g45n1lvt w=(2.05e-07) l=4.5e-08 nf=1 \
        as=3.28e-14 ad=6.115e-14 ps=7.3e-07 pd=1.17e-06 nrd=1.16667 \
        nrs=1.16667 sa=5.80122e-07 sb=6.55e-07 sd=160n sca=10.1075 \
        scb=0.00913344 scc=0.000289639 m=(1)
mn35 (net514 mout \23\:VSS VSS) g45n1lvt w=(2.05e-07) l=4.5e-08 nf=1 \
        as=3.28e-14 ad=1.23e-14 ps=7.3e-07 pd=5.3e-07 nrd=1.16667 \
        nrs=1.16667 sa=7.85122e-07 sb=4.5e-07 sd=160n sca=10.1075 \
        scb=0.00913344 scc=0.000289639 m=(1)
mn36 (\9\:n20 \9\:CKbb net514 VSS) g45n1lvt w=(2.05e-07) l=4.5e-08 nf=1 \
        as=1.23e-14 ad=3.28e-14 ps=5.3e-07 pd=7.3e-07 nrd=1.16667 \
        nrs=1.16667 sa=8.90122e-07 sb=3.45e-07 sd=160n sca=10.1075 \
        scb=0.00913344 scc=0.000289639 m=(1)
mn25 (\4\:Db \9\:CKb \9\:n20 VSS) g45n1lvt w=(2.05e-07) l=4.5e-08 nf=1 \
        as=3.28e-14 ad=2.87e-14 ps=7.3e-07 pd=6.9e-07 nrd=1.16667 \
        nrs=1.16667 sa=1.09512e-06 sb=1.4e-07 sd=160n sca=10.1075 \
        scb=0.00913344 scc=0.000289639 m=(1)
mn45_1__rcx (\21\:qbint \2\:n35 \12\:VSS VSS) g45n1lvt w=(2.05e-07) \
        l=4.5e-08 nf=1 as=4.474e-14 ad=3.28e-14 ps=9.2e-07 pd=7.3e-07 \
        nrd=1.16667 nrs=1.16667 sa=9.6e-07 sb=6.1378e-07 sd=160n \
        sca=13.8179 scb=0.0141903 scc=0.000851218 m=(2)
mn22 (\12\:RNb \1\:RN \12\:VSS VSS) g45n1lvt w=(1.45e-07) l=4.5e-08 nf=1 \
        as=5.117e-14 ad=2.61e-14 ps=1e-06 pd=6.5e-07 nrd=1.16667 \
        nrs=1.16667 sa=1.505e-06 sb=1.8e-07 sd=160n sca=15.7071 \
        scb=0.0167369 scc=0.00113434 m=(1)
mn21 (\15\:CKbb \7\:CKb \21\:VSS VSS) g45n1lvt w=(1.45e-07) l=4.5e-08 \
        nf=1 as=5.152e-14 ad=3.045e-14 ps=1.49e-06 pd=7.1e-07 nrd=1.16667 \
        nrs=1.16667 sa=2.1e-07 sb=1.75e-07 sd=160n sca=13.6097 \
        scb=0.014254 scc=0.000755054 m=(1)
mn20 (\17\:CKb \3\:CK \19\:VSS VSS) g45n1lvt w=(1.45e-07) l=4.5e-08 nf=1 \
        as=7.415e-14 ad=2.03e-14 ps=1.85e-06 pd=5.7e-07 nrd=1.16667 \
        nrs=1.16667 sa=1.4e-07 sb=7.51724e-07 sd=160n sca=13.6097 \
        scb=0.014254 scc=0.000755054 m=(1)
mn10 (\5\:SEb \6\:SE \1\:VSS VSS) g45n1lvt w=(1.45e-07) l=4.5e-08 nf=1 \
        as=2.03e-14 ad=2.972e-14 ps=5.7e-07 pd=7e-07 nrd=1.16667 \
        nrs=1.16667 sa=2.05e-07 sb=1.4e-07 sd=160n sca=12.9138 \
        scb=0.0133404 scc=0.000640143 m=(1)
mp51 (net437 \2\:RNb \31\:VDD VDD) g45p1lvt w=(3.1e-07) l=4.5e-08 nf=1 \
        as=1.2055e-13 ad=1.86e-14 ps=1.79e-06 pd=7.4e-07 nrd=1.16667 \
        nrs=1.16667 sa=2.65e-07 sb=3.40565e-07 sd=160n sca=15.5687 \
        scb=0.0146164 scc=0.00101158 m=(1)
mp52 (\3\:net394 \16\:qbint net437 VDD) g45p1lvt w=(3.1e-07) l=4.5e-08 \
        nf=1 as=1.86e-14 ad=5.38e-14 ps=7.4e-07 pd=1.15e-06 nrd=1.16667 \
        nrs=1.16667 sa=3.7e-07 sb=2.35565e-07 sd=160n sca=15.5687 \
        scb=0.0146164 scc=0.00101158 m=(1)
mp50 (\3\:net394 \3\:SN \29\:VDD VDD) g45p1lvt w=(3.1e-07) l=4.5e-08 \
        nf=1 as=6.03e-14 ad=5.38e-14 ps=1.39e-06 pd=1.15e-06 nrd=1.16667 \
        nrs=1.16667 sa=4.14113e-07 sb=1.1129e-07 sd=160n sca=11.1346 \
        scb=0.00910425 scc=0.000198662 m=(1)
mp53 (\9\:n35 \3\:CKbb net394 VDD) g45p1lvt w=(3.1e-07) l=4.5e-08 nf=1 \
        as=8.835e-14 ad=5.58e-14 ps=1.19e-06 pd=9.8e-07 nrd=1.16667 \
        nrs=1.16667 sa=2.85e-07 sb=4.6e-07 sd=160n sca=19.1541 \
        scb=0.0174883 scc=0.00172295 m=(1)
mp40 (\9\:n35 \3\:CKb \11\:mout VDD) g45p1lvt w=(3.1e-07) l=4.5e-08 nf=1 \
        as=7.285e-14 ad=5.58e-14 ps=1.09e-06 pd=9.8e-07 nrd=1.16667 \
        nrs=1.16667 sa=5.1e-07 sb=2.35e-07 sd=160n sca=19.1541 \
        scb=0.0174883 scc=0.00172295 m=(1)
mp31 (net417 \6\:RNb \27\:VDD VDD) g45p1lvt w=(3.1e-07) l=4.5e-08 nf=1 \
        as=1.6975e-13 ad=4.805e-14 ps=2.04e-06 pd=9.3e-07 nrd=1.16667 \
        nrs=1.16667 sa=4.45e-07 sb=8.63065e-07 sd=160n sca=35.6995 \
        scb=0.0234062 scc=0.00420468 m=(1)
mp32 (\6\:mout \3\:n20 net417 VDD) g45p1lvt w=(3.1e-07) l=4.5e-08 nf=1 \
        as=4.805e-14 ad=4.96e-14 ps=9.3e-07 pd=9.4e-07 nrd=1.16667 \
        nrs=1.16667 sa=6.45e-07 sb=6.63065e-07 sd=160n sca=35.6995 \
        scb=0.0234062 scc=0.00420468 m=(1)
mp30 (\6\:mout \6\:SN \25\:VDD VDD) g45p1lvt w=(3.1e-07) l=4.5e-08 nf=1 \
        as=7.695e-14 ad=4.96e-14 ps=1.47e-06 pd=9.4e-07 nrd=1.16667 \
        nrs=1.16667 sa=8.5e-07 sb=4.58065e-07 sd=160n sca=35.6995 \
        scb=0.0234062 scc=0.00420468 m=(1)
mp35 (net425 \4\:mout \25\:VDD VDD) g45p1lvt w=(3.1e-07) l=4.5e-08 nf=1 \
        as=7.695e-14 ad=1.86e-14 ps=1.47e-06 pd=7.4e-07 nrd=1.16667 \
        nrs=1.16667 sa=6.29677e-07 sb=5.3e-07 sd=160n sca=12.3129 \
        scb=0.0108562 scc=0.00039161 m=(1)
mp36 (\7\:n20 \5\:CKb net425 VDD) g45p1lvt w=(3.1e-07) l=4.5e-08 nf=1 \
        as=1.86e-14 ad=7.44e-14 ps=7.4e-07 pd=1.1e-06 nrd=1.16667 \
        nrs=1.16667 sa=7.34677e-07 sb=4.25e-07 sd=160n sca=12.3129 \
        scb=0.0108562 scc=0.00039161 m=(1)
mp25 (\7\:n20 \8\:CKbb \6\:Db VDD) g45p1lvt w=(3.1e-07) l=4.5e-08 nf=1 \
        as=4.34e-14 ad=7.44e-14 ps=9e-07 pd=1.1e-06 nrd=1.16667 \
        nrs=1.16667 sa=1.01968e-06 sb=1.4e-07 sd=160n sca=12.3129 \
        scb=0.0108562 scc=0.00039161 m=(1)
mp45 (\23\:qbint \2\:n35 \14\:VDD VDD) g45p1lvt w=(3.1e-07) l=4.5e-08 \
        nf=1 as=8.093e-14 ad=4.96e-14 ps=1.42e-06 pd=9.4e-07 nrd=1.16667 \
        nrs=1.16667 sa=9.6e-07 sb=6.17742e-07 sd=160n sca=17.3904 \
        scb=0.0162056 scc=0.00137566 m=(2)
mp22 (\9\:RNb \3\:RN \14\:VDD VDD) g45p1lvt w=(2.15e-07) l=4.5e-08 nf=1 \
        as=1.0425e-13 ad=5.482e-14 ps=1.74e-06 pd=9.4e-07 nrd=1.16667 \
        nrs=1.16667 sa=1.43e-06 sb=2.55e-07 sd=160n sca=20.4333 \
        scb=0.0198015 scc=0.00193653 m=(1)
mp21 (\13\:CKbb \10\:CKb \23\:VDD VDD) g45p1lvt w=(2.15e-07) l=4.5e-08 \
        nf=1 as=7.495e-14 ad=3.01e-14 ps=1.41e-06 pd=7.1e-07 nrd=1.16667 \
        nrs=1.16667 sa=1.4e-07 sb=1.7e-07 sd=160n sca=31.508 scb=0.0252524 \
        scc=0.00399199 m=(1)
mp20 (\11\:CKb \1\:CK \21\:VDD VDD) g45p1lvt w=(2.15e-07) l=4.5e-08 nf=1 \
        as=5.19e-14 ad=3.01e-14 ps=1.1e-06 pd=7.1e-07 nrd=1.16667 \
        nrs=1.16667 sa=1.4e-07 sb=7.39535e-07 sd=160n sca=11.1138 \
        scb=0.00912362 scc=0.000187967 m=(1)
mp10 (\9\:SEb \4\:SE \1\:VDD VDD) g45p1lvt w=(2.15e-07) l=4.5e-08 nf=1 \
        as=3.01e-14 ad=7.525e-14 ps=7.1e-07 pd=1.13e-06 nrd=1.16667 \
        nrs=1.16667 sa=3.5e-07 sb=1.4e-07 sd=160n sca=59.4536 \
        scb=0.0473468 scc=0.00729053 m=(1)
ends SDFFSRHQX4
// End of subcircuit definition.
