// Generated for: spectre (May  1 09:12:54 2013 )
// Library name: gsclib045_lvt
// Cell name: CLKBUFX20
// View name: extracted

simulator lang=spectre

subckt CLKBUFX20 A VDD VSS Y
mp1_1__rcx (\1\:Y net44 \1\:VDD VDD) g45p1lvt w=(4.55e-07) l=4.5e-08 \
        nf=1 as=7.33e-14 ad=6.37e-14 ps=1.24e-06 pd=1.19e-06 nrd=1.16667 \
        nrs=1.16667 sa=1.4e-07 sb=2e-06 sd=160n sca=39.6635 scb=0.0369516 \
        scc=0.00411991 m=(1)
C1 (VDD VSS) capacitor c=1.58849e-16
C2 (A VSS) capacitor c=4.0659e-16
C3 (Y VSS) capacitor c=1.32273e-17
C4 (net44 VSS) capacitor c=1.45439e-15
C5 (\52\:net44 VSS) capacitor c=2.26735e-16
C6 (\1\:VDD VSS) capacitor c=8.8794e-16
C7 (\1\:Y VSS) capacitor c=1.06716e-15
C8 (\57\:net44 VSS) capacitor c=1.32282e-16
C9 (\11\:Y VSS) capacitor c=8.15041e-16
C10 (\56\:net44 VSS) capacitor c=2.24545e-17
Rk87 (\1\:VSS VSS) resistor r=0.1025 c=0
Rk74 (\1\:VDD VDD) resistor r=0.1025 c=0
Rk9 (\1\:Y Y) resistor r=0.1726 c=0
Rk10 (Y \11\:Y) resistor r=0.02804 c=0
Rk43 (\56\:net44 net44) resistor r=0.1404 c=0
Rk39 (\52\:net44 \56\:net44) resistor r=0.2212 c=0
Rk40 (\56\:net44 \57\:net44) resistor r=0.1372 c=0
mn1_1__rcx (\11\:Y net44 \1\:VSS VSS) g45n1lvt w=(3.05e-07) l=4.5e-08 \
        nf=1 as=4.864e-14 ad=4.844e-14 ps=9.3e-07 pd=9.2765e-07 \
        nrd=1.16667 nrs=1.16667 sa=1.4e-07 sb=2e-06 sd=160n sca=16.121 \
        scb=0.0155296 scc=0.00139557 m=(17)
mn0_1__rcx (\57\:net44 A \1\:VSS VSS) g45n1lvt w=(2.6e-07) l=4.5e-08 \
        nf=1 as=4.25e-14 ad=4.056e-14 ps=8.58e-07 pd=8.32e-07 nrd=1.16667 \
        nrs=1.16667 sa=2e-06 sb=9.6e-07 sd=160n sca=17.5885 scb=0.0172826 \
        scc=0.00162584 m=(5)
mp1_2__rcx (\1\:Y net44 \1\:VDD VDD) g45p1lvt w=(4.6e-07) l=4.5e-08 nf=1 \
        as=7.332e-14 ad=7.36e-14 ps=1.24e-06 pd=1.24e-06 nrd=1.16667 \
        nrs=1.16667 sa=3.42337e-07 sb=2e-06 sd=160n sca=30.979 \
        scb=0.0224787 scc=0.002898 m=(16)
mp0_1__rcx (\52\:net44 A \1\:VDD VDD) g45p1lvt w=(3.9e-07) l=4.5e-08 \
        nf=1 as=6.38e-14 ad=6.084e-14 ps=1.128e-06 pd=1.092e-06 \
        nrd=1.16667 nrs=1.16667 sa=2e-06 sb=9.6e-07 sd=160n sca=16.7336 \
        scb=0.0149207 scc=0.00128056 m=(5)
ends CLKBUFX20
// End of subcircuit definition.
