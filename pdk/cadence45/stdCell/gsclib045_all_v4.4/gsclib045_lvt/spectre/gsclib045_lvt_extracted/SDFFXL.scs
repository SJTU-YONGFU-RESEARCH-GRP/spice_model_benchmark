// Generated for: spectre (May  1 09:15:22 2013 )
// Library name: gsclib045_lvt
// Cell name: SDFFXL
// View name: extracted

simulator lang=spectre

subckt SDFFXL CK D Q QN SE SI VDD VSS
mp57 (\1\:QN \4\:net367 \20\:VDD VDD) g45p1lvt w=(2.15e-07) l=4.5e-08 \
        nf=1 as=3.44e-14 ad=3.548e-14 ps=7.5e-07 pd=7.6e-07 nrd=1.16667 \
        nrs=1.16667 sa=1.65e-07 sb=3.45e-07 sd=160n sca=49.5197 \
        scb=0.0328493 scc=0.0059298 m=(1)
mp56 (\5\:net367 \6\:qbint \20\:VDD VDD) g45p1lvt w=(2.15e-07) l=4.5e-08 \
        nf=1 as=3.44e-14 ad=3.01e-14 ps=7.5e-07 pd=7.1e-07 nrd=1.16667 \
        nrs=1.16667 sa=3.7e-07 sb=1.4e-07 sd=160n sca=47.0806 \
        scb=0.0291408 scc=0.00588526 m=(1)
mp55 (\3\:Q qbint \16\:VDD VDD) g45p1lvt w=(2.15e-07) l=4.5e-08 nf=1 \
        as=3.44e-14 ad=6.773e-14 ps=7.5e-07 pd=1.06e-06 nrd=1.16667 \
        nrs=1.16667 sa=3.15e-07 sb=3.45e-07 sd=160n sca=12.1244 \
        scb=0.0107968 scc=0.000332109 m=(1)
mp20 (\15\:CKb \1\:CK \16\:VDD VDD) g45p1lvt w=(2.15e-07) l=4.5e-08 nf=1 \
        as=3.44e-14 ad=3.01e-14 ps=7.5e-07 pd=7.1e-07 nrd=1.16667 \
        nrs=1.16667 sa=5.2e-07 sb=1.4e-07 sd=160n sca=12.1244 \
        scb=0.0107968 scc=0.000332109 m=(1)
mp45 (\15\:qbint n30 \13\:VDD VDD) g45p1lvt w=(2.15e-07) l=4.5e-08 nf=1 \
        as=8.99e-14 ad=3.01e-14 ps=1.58e-06 pd=7.1e-07 nrd=1.16667 \
        nrs=1.16667 sa=1.4e-07 sb=2e-06 sd=160n sca=13.4114 scb=0.012694 \
        scc=0.000544005 m=(1)
mp50 (net376 \7\:qbint \13\:VDD VDD) g45p1lvt w=(2.15e-07) l=4.5e-08 \
        nf=1 as=8.99e-14 ad=7.203e-14 ps=1.58e-06 pd=1.1e-06 nrd=1.16667 \
        nrs=1.16667 sa=4.05e-07 sb=1.74e-06 sd=160n sca=13.4114 \
        scb=0.012694 scc=0.000544005 m=(1)
mp51 (\4\:n30 \3\:CKbb net376 VDD) g45p1lvt w=(2.15e-07) l=4.5e-08 nf=1 \
        as=7.203e-14 ad=3.44e-14 ps=1.1e-06 pd=7.5e-07 nrd=1.16667 \
        nrs=1.16667 sa=7.85e-07 sb=1.36e-06 sd=160n sca=13.4114 \
        scb=0.012694 scc=0.000544005 m=(1)
mp40 (\4\:n30 \3\:CKb \8\:mout VDD) g45p1lvt w=(2.15e-07) l=4.5e-08 nf=1 \
        as=5.16e-14 ad=3.44e-14 ps=9.1e-07 pd=7.5e-07 nrd=1.16667 \
        nrs=1.16667 sa=9.9e-07 sb=1.155e-06 sd=160n sca=13.4114 \
        scb=0.012694 scc=0.000544005 m=(1)
mp30 (\8\:mout n20 \10\:VDD VDD) g45p1lvt w=(2.15e-07) l=4.5e-08 nf=1 \
        as=8.99e-14 ad=5.16e-14 ps=1.58e-06 pd=9.1e-07 nrd=1.16667 \
        nrs=1.16667 sa=1.275e-06 sb=8.7e-07 sd=160n sca=13.4114 \
        scb=0.012694 scc=0.000544005 m=(1)
mp35 (net356 mout \10\:VDD VDD) g45p1lvt w=(2.15e-07) l=4.5e-08 nf=1 \
        as=8.99e-14 ad=1.505e-14 ps=1.58e-06 pd=5.7e-07 nrd=1.16667 \
        nrs=1.16667 sa=1.54e-06 sb=6.05e-07 sd=160n sca=13.4114 \
        scb=0.012694 scc=0.000544005 m=(1)
mp36 (\4\:n20 \8\:CKb net356 VDD) g45p1lvt w=(2.15e-07) l=4.5e-08 nf=1 \
        as=1.505e-14 ad=4.73e-14 ps=5.7e-07 pd=8.7e-07 nrd=1.16667 \
        nrs=1.16667 sa=1.655e-06 sb=4.9e-07 sd=160n sca=13.4114 \
        scb=0.012694 scc=0.000544005 m=(1)
mp25 (\4\:n20 \7\:CKbb \5\:Db VDD) g45p1lvt w=(2.15e-07) l=4.5e-08 nf=1 \
        as=4.838e-14 ad=4.73e-14 ps=8.8e-07 pd=8.7e-07 nrd=1.16667 \
        nrs=1.16667 sa=1.92e-06 sb=2.25e-07 sd=160n sca=13.4114 \
        scb=0.012694 scc=0.000544005 m=(1)
mp21 (\9\:CKbb \9\:CKb \6\:VDD VDD) g45p1lvt w=(2.15e-07) l=4.5e-08 nf=1 \
        as=3.44e-14 ad=3.01e-14 ps=7.5e-07 pd=7.1e-07 nrd=1.16667 \
        nrs=1.16667 sa=1.4e-07 sb=1.195e-06 sd=160n sca=11.1138 \
        scb=0.00912362 scc=0.000187967 m=(1)
mp11 (net384 \3\:D \6\:VDD VDD) g45p1lvt w=(2.15e-07) l=4.5e-08 nf=1 \
        as=3.44e-14 ad=3.763e-14 ps=7.5e-07 pd=7.8e-07 nrd=1.16667 \
        nrs=1.16667 sa=3.45e-07 sb=9.9e-07 sd=160n sca=11.1138 \
        scb=0.00912362 scc=0.000187967 m=(1)
mp12 (\7\:Db \1\:SE net384 VDD) g45p1lvt w=(2.15e-07) l=4.5e-08 nf=1 \
        as=3.763e-14 ad=3.44e-14 ps=7.8e-07 pd=7.5e-07 nrd=1.16667 \
        nrs=1.16667 sa=5.65e-07 sb=7.7e-07 sd=160n sca=11.1138 \
        scb=0.00912362 scc=0.000187967 m=(1)
mp14 (\7\:Db SEb net392 VDD) g45p1lvt w=(2.15e-07) l=4.5e-08 nf=1 \
        as=2.903e-14 ad=3.44e-14 ps=7e-07 pd=7.5e-07 nrd=1.16667 \
        nrs=1.16667 sa=7.7e-07 sb=5.65e-07 sd=160n sca=11.4714 \
        scb=0.00922898 scc=0.00018799 m=(1)
mp13 (net392 \3\:SI \1\:VDD VDD) g45p1lvt w=(2.15e-07) l=4.5e-08 nf=1 \
        as=4.3e-14 ad=2.903e-14 ps=8.3e-07 pd=7e-07 nrd=1.16667 \
        nrs=1.16667 sa=9.5e-07 sb=3.85e-07 sd=160n sca=12.2443 \
        scb=0.00977105 scc=0.000188654 m=(1)
mp10 (\4\:SEb \5\:SE \1\:VDD VDD) g45p1lvt w=(2.15e-07) l=4.5e-08 nf=1 \
        as=4.3e-14 ad=3.01e-14 ps=8.3e-07 pd=7.1e-07 nrd=1.16667 \
        nrs=1.16667 sa=1.195e-06 sb=1.4e-07 sd=160n sca=15.1631 \
        scb=0.0142072 scc=0.000247556 m=(1)
C1 (CK VSS) capacitor c=8.20357e-17
C2 (SE VSS) capacitor c=5.49843e-17
C3 (SI VSS) capacitor c=7.27395e-17
C4 (VDD VSS) capacitor c=3.61725e-16
C5 (D VSS) capacitor c=5.56342e-17
C6 (Q VSS) capacitor c=6.15843e-17
C7 (QN VSS) capacitor c=2.45893e-17
C8 (net367 VSS) capacitor c=2.09166e-17
C9 (qbint VSS) capacitor c=4.84266e-17
C10 (CKb VSS) capacitor c=4.69622e-17
C11 (n30 VSS) capacitor c=5.1907e-17
C12 (mout VSS) capacitor c=7.74425e-17
C13 (CKbb VSS) capacitor c=2.27183e-17
C14 (n20 VSS) capacitor c=4.28996e-17
C15 (Db VSS) capacitor c=9.88259e-17
C16 (net449 VSS) capacitor c=6.91177e-18
C17 (SEb VSS) capacitor c=3.74835e-17
C18 (net376 VSS) capacitor c=5.92504e-18
C19 (net384 VSS) capacitor c=4.61231e-18
C20 (\5\:SE VSS) capacitor c=4.83673e-17
C21 (\3\:SI VSS) capacitor c=5.34157e-17
C22 (\1\:SE VSS) capacitor c=4.77396e-17
C23 (\3\:D VSS) capacitor c=4.65357e-17
C24 (\9\:CKb VSS) capacitor c=5.16464e-17
C25 (\7\:CKbb VSS) capacitor c=3.99332e-17
C26 (\8\:CKb VSS) capacitor c=6.85881e-17
C27 (\3\:CKb VSS) capacitor c=5.15212e-17
C28 (\3\:CKbb VSS) capacitor c=4.83167e-17
C29 (\7\:qbint VSS) capacitor c=3.87918e-17
C30 (\1\:CK VSS) capacitor c=3.28009e-17
C31 (\6\:qbint VSS) capacitor c=3.33047e-17
C32 (\4\:net367 VSS) capacitor c=2.94671e-17
C33 (\8\:SE VSS) capacitor c=3.05372e-17
C34 (\1\:SI VSS) capacitor c=7.52108e-17
C35 (\3\:SE VSS) capacitor c=6.5996e-17
C36 (\3\:SEb VSS) capacitor c=7.31249e-17
C37 (\1\:D VSS) capacitor c=4.24988e-17
C38 (\5\:CKb VSS) capacitor c=2.8974e-17
C39 (\10\:CKb VSS) capacitor c=2.39528e-17
C40 (\5\:CKbb VSS) capacitor c=8.50625e-17
C41 (\3\:mout VSS) capacitor c=4.89747e-17
C42 (\3\:n20 VSS) capacitor c=3.19636e-17
C43 (\10\:qbint VSS) capacitor c=3.85116e-17
C44 (\2\:n30 VSS) capacitor c=3.70448e-17
C45 (\3\:CK VSS) capacitor c=4.08944e-17
C46 (\5\:qbint VSS) capacitor c=2.37079e-17
C47 (\4\:qbint VSS) capacitor c=2.78473e-17
C48 (\3\:net367 VSS) capacitor c=3.22097e-17
C49 (\7\:SE VSS) capacitor c=2.19115e-17
C50 (\2\:SI VSS) capacitor c=7.02821e-17
C51 (\4\:SE VSS) capacitor c=5.35879e-17
C52 (\2\:SEb VSS) capacitor c=7.29678e-17
C53 (\2\:SE VSS) capacitor c=3.9233e-17
C54 (\2\:D VSS) capacitor c=6.54312e-17
C55 (\8\:CKbb VSS) capacitor c=4.31878e-17
C56 (\11\:CKb VSS) capacitor c=2.82601e-17
C57 (\6\:CKbb VSS) capacitor c=3.08509e-17
C58 (\2\:mout VSS) capacitor c=5.84527e-17
C59 (\2\:n20 VSS) capacitor c=3.86715e-17
C60 (\4\:CKb VSS) capacitor c=2.13263e-17
C61 (\4\:CKbb VSS) capacitor c=1.95882e-17
C62 (\2\:CKb VSS) capacitor c=4.50304e-17
C63 (\9\:qbint VSS) capacitor c=1.98193e-17
C64 (\3\:n30 VSS) capacitor c=2.19388e-17
C65 (\2\:CK VSS) capacitor c=3.73234e-17
C66 (\2\:qbint VSS) capacitor c=5.1788e-17
C67 (\4\:SEb VSS) capacitor c=1.23546e-17
C68 (\1\:VDD VSS) capacitor c=3.13082e-17
C69 (\7\:Db VSS) capacitor c=3.44112e-17
C70 (\6\:VDD VSS) capacitor c=4.2913e-17
C71 (\9\:CKbb VSS) capacitor c=7.84997e-17
C72 (\5\:Db VSS) capacitor c=1.09443e-16
C73 (\4\:n20 VSS) capacitor c=4.32272e-17
C74 (\10\:VDD VSS) capacitor c=1.65609e-17
C75 (\8\:mout VSS) capacitor c=3.69024e-17
C76 (\4\:n30 VSS) capacitor c=7.09059e-17
C77 (\13\:VDD VSS) capacitor c=1.53252e-17
C78 (\15\:qbint VSS) capacitor c=3.97522e-17
C79 (\15\:CKb VSS) capacitor c=1.26004e-16
C80 (\16\:VDD VSS) capacitor c=3.81138e-17
C81 (\3\:Q VSS) capacitor c=6.33873e-17
C82 (\5\:net367 VSS) capacitor c=3.13247e-17
C83 (\20\:VDD VSS) capacitor c=3.78639e-17
C84 (\1\:QN VSS) capacitor c=3.12571e-17
C85 (\3\:VDD VSS) capacitor c=7.37917e-17
C86 (\8\:SEb VSS) capacitor c=4.63284e-17
C87 (\15\:CKbb VSS) capacitor c=5.45853e-17
C88 (\9\:Db VSS) capacitor c=7.11032e-17
C89 (\8\:n20 VSS) capacitor c=5.71754e-17
C90 (\6\:mout VSS) capacitor c=4.87018e-17
C91 (\8\:n30 VSS) capacitor c=2.80423e-17
C92 (\13\:qbint VSS) capacitor c=1.05762e-16
C93 (\18\:CKb VSS) capacitor c=5.31584e-17
C94 (\1\:Q VSS) capacitor c=3.92221e-17
C95 (\9\:net367 VSS) capacitor c=2.85009e-17
C96 (\3\:QN VSS) capacitor c=4.02739e-17
C97 (\2\:net367 VSS) capacitor c=1.26125e-17
C98 (\3\:qbint VSS) capacitor c=3.79322e-17
C99 (\8\:qbint VSS) capacitor c=3.74092e-17
C100 (\2\:CKbb VSS) capacitor c=3.24845e-17
C101 (\6\:CKb VSS) capacitor c=6.77557e-17
C102 (\7\:CKb VSS) capacitor c=6.77563e-17
C103 (\6\:SE VSS) capacitor c=3.30539e-17
C104 (\7\:net367 VSS) capacitor c=3.01119e-17
C105 (\8\:net367 VSS) capacitor c=3.11728e-17
C106 (\4\:CK VSS) capacitor c=2.84121e-17
C107 (\11\:qbint VSS) capacitor c=3.9226e-17
C108 (\12\:qbint VSS) capacitor c=4.82973e-17
C109 (\17\:qbint VSS) capacitor c=8.64135e-17
C110 (\6\:n30 VSS) capacitor c=1.1186e-16
C111 (\7\:n30 VSS) capacitor c=1.18787e-16
C112 (\4\:mout VSS) capacitor c=5.67295e-17
C113 (\5\:mout VSS) capacitor c=6.24295e-17
C114 (\12\:CKb VSS) capacitor c=5.9022e-17
C115 (\13\:CKb VSS) capacitor c=7.1079e-17
C116 (\14\:CKb VSS) capacitor c=1.18768e-16
C117 (\17\:CKb VSS) capacitor c=6.09471e-17
C118 (\6\:n20 VSS) capacitor c=6.35748e-17
C119 (\7\:n20 VSS) capacitor c=5.81402e-17
C120 (\11\:CKbb VSS) capacitor c=1.41459e-16
C121 (\12\:CKbb VSS) capacitor c=6.56643e-17
C122 (\13\:CKbb VSS) capacitor c=1.19724e-16
C123 (\14\:CKbb VSS) capacitor c=1.21233e-16
C124 (\4\:D VSS) capacitor c=4.65838e-17
C125 (\3\:Db VSS) capacitor c=1.44157e-16
C126 (\9\:SE VSS) capacitor c=4.7511e-17
C127 (\10\:SE VSS) capacitor c=4.92747e-17
C128 (\11\:SE VSS) capacitor c=5.41879e-17
C129 (\4\:SI VSS) capacitor c=7.24755e-17
C130 (\6\:SEb VSS) capacitor c=6.766e-17
C131 (\7\:SEb VSS) capacitor c=7.09338e-17
C132 (\5\:VDD VSS) capacitor c=3.22493e-17
C133 (\9\:VDD VSS) capacitor c=3.46315e-17
C134 (\12\:VDD VSS) capacitor c=4.54224e-17
C135 (\15\:VDD VSS) capacitor c=1.53312e-17
C136 (\19\:VDD VSS) capacitor c=1.10953e-17
Rk8 (\4\:CK CK) resistor r=0.05411 c=0
Rk39 (\10\:SE SE) resistor r=0.08741 c=0
Rk38 (\9\:SE \10\:SE) resistor r=0.162 c=0
Rk40 (SE \11\:SE) resistor r=0.234 c=0
Rk41 (\4\:SI SI) resistor r=0.07108 c=0
Rk58 (\2\:VDD \4\:VDD) resistor r=0.3114 c=0
Rk59 (\4\:VDD \5\:VDD) resistor r=0.4212 c=0
Rk60 (\5\:VDD \7\:VDD) resistor r=0.2676 c=0
Rk61 (\5\:VDD \8\:VDD) resistor r=0.4306 c=0
Rk62 (\8\:VDD \9\:VDD) resistor r=0.1275 c=0
Rk63 (\9\:VDD \11\:VDD) resistor r=0.07323 c=0
Rk64 (\9\:VDD \12\:VDD) resistor r=0.5832 c=0
Rk65 (\12\:VDD \14\:VDD) resistor r=0.1018 c=0
Rk66 (\12\:VDD \15\:VDD) resistor r=0.4454 c=0
Rk67 (\15\:VDD \17\:VDD) resistor r=0.2934 c=0
Rk68 (\15\:VDD \18\:VDD) resistor r=0.04488 c=0
Rk71 (\19\:VDD VDD) resistor r=0.2024 c=0
Rk69 (\18\:VDD \19\:VDD) resistor r=0.3479 c=0
Rk70 (\19\:VDD \21\:VDD) resistor r=0.4145 c=0
Rk32 (\4\:D D) resistor r=0.07554 c=0
Rk6 (\2\:Q Q) resistor r=0.1433 c=0
Rk7 (Q \4\:Q) resistor r=0.2901 c=0
Rk2 (\4\:QN QN) resistor r=0.04898 c=0
Rk1 (\2\:QN \4\:QN) resistor r=0.2343 c=0
Rk45 (\2\:VSS \4\:VSS) resistor r=0.325 c=0
Rk46 (\4\:VSS \5\:VSS) resistor r=0.3955 c=0
Rk47 (\5\:VSS \6\:VSS) resistor r=0.4556 c=0
Rk48 (\6\:VSS \7\:VSS) resistor r=0.1125 c=0
Rk49 (\7\:VSS \8\:VSS) resistor r=0.5832 c=0
Rk50 (\8\:VSS \9\:VSS) resistor r=0.5063 c=0
Rk52 (\10\:VSS VSS) resistor r=0.2174 c=0
Rk51 (\9\:VSS \10\:VSS) resistor r=0.3329 c=0
Rk53 (\5\:VSS \12\:VSS) resistor r=0.268 c=0
Rk54 (\7\:VSS \14\:VSS) resistor r=0.1217 c=0
Rk55 (\8\:VSS \16\:VSS) resistor r=0.3264 c=0
Rk56 (\9\:VSS \18\:VSS) resistor r=0.1193 c=0
Rk57 (\10\:VSS \20\:VSS) resistor r=0.07323 c=0
Rk3 (\6\:net367 \7\:net367) resistor r=0.09342 c=0
Rk4 (\7\:net367 \8\:net367) resistor r=0.1189 c=0
Rk5 (\7\:net367 \10\:net367) resistor r=0.1293 c=0
Rk9 (\11\:qbint \12\:qbint) resistor r=0.2207 c=0
Rk10 (\12\:qbint \14\:qbint) resistor r=0.2138 c=0
Rk11 (\12\:qbint \16\:qbint) resistor r=0.2044 c=0
Rk12 (\14\:qbint \17\:qbint) resistor r=0.7123 c=0
Rk19 (\12\:CKb \13\:CKb) resistor r=0.4487 c=0
Rk20 (\13\:CKb \14\:CKb) resistor r=0.3722 c=0
Rk21 (\14\:CKb \16\:CKb) resistor r=0.7611 c=0
Rk22 (\14\:CKb \17\:CKb) resistor r=0.3257 c=0
Rk23 (\16\:CKb \19\:CKb) resistor r=0.3872 c=0
Rk13 (\5\:n30 \6\:n30) resistor r=0.4337 c=0
Rk14 (\6\:n30 \7\:n30) resistor r=0.6752 c=0
Rk15 (\6\:n30 \9\:n30) resistor r=0.1079 c=0
Rk16 (\4\:mout \5\:mout) resistor r=0.2657 c=0
Rk17 (\5\:mout \7\:mout) resistor r=0.1475 c=0
Rk18 (\5\:mout \9\:mout) resistor r=0.2912 c=0
Rk27 (\10\:CKbb \11\:CKbb) resistor r=0.5807 c=0
Rk28 (\11\:CKbb \12\:CKbb) resistor r=0.3773 c=0
Rk29 (\12\:CKbb \13\:CKbb) resistor r=0.2249 c=0
Rk30 (\13\:CKbb \14\:CKbb) resistor r=0.8335 c=0
Rk31 (\12\:CKbb \16\:CKbb) resistor r=0.2712 c=0
Rk24 (\5\:n20 \6\:n20) resistor r=0.1962 c=0
Rk25 (\6\:n20 \7\:n20) resistor r=0.3021 c=0
Rk26 (\6\:n20 \9\:n20) resistor r=0.2447 c=0
Rk33 (\2\:Db \3\:Db) resistor r=0.6712 c=0
Rk34 (\3\:Db \4\:Db) resistor r=0.4324 c=0
Rk35 (\4\:Db \6\:Db) resistor r=0.04625 c=0
Rk36 (\3\:Db \8\:Db) resistor r=0.2375 c=0
Rk37 (\4\:Db \10\:Db) resistor r=0.3945 c=0
Rk42 (\5\:SEb \6\:SEb) resistor r=0.07366 c=0
Rk43 (\6\:SEb \7\:SEb) resistor r=0.3518 c=0
Rk44 (\6\:SEb \9\:SEb) resistor r=0.4576 c=0
Rl9 (\1\:CK \2\:CK) resistor r=51.1559 c=0
Rl10 (\2\:CK \3\:CK) resistor r=93.4636 c=0
Rl38 (\3\:SE \4\:SE) resistor r=39.1533 c=0
Rl35 (\1\:SE \2\:SE) resistor r=54.5379 c=0
Rl41 (\5\:SE \6\:SE) resistor r=179.649 c=0
Rl43 (\6\:SE \8\:SE) resistor r=46.9565 c=0
Rl42 (\6\:SE \7\:SE) resistor r=1.2301 c=0
Rl40 (\2\:SI \3\:SI) resistor r=97.3098 c=0
Rl39 (\1\:SI \2\:SI) resistor r=110.771 c=0
Rl34 (\2\:D \3\:D) resistor r=96.8221 c=0
Rl33 (\1\:D \2\:D) resistor r=141.129 c=0
Rl3 (\2\:net367 \4\:net367) resistor r=34.3295 c=0
Rl2 (\2\:net367 \3\:net367) resistor r=49.7141 c=0
Rl1 (net367 \2\:net367) resistor r=2.0213 c=0
Rl4 (qbint \2\:qbint) resistor r=114.502 c=0
Rl7 (\2\:qbint \5\:qbint) resistor r=24.7951 c=0
Rl8 (\3\:qbint \6\:qbint) resistor r=53.0797 c=0
Rl6 (\3\:qbint \4\:qbint) resistor r=35.772 c=0
Rl5 (\2\:qbint \3\:qbint) resistor r=212.376 c=0
Rl13 (\7\:qbint \8\:qbint) resistor r=84.3295 c=0
Rl15 (\8\:qbint \10\:qbint) resistor r=86.2526 c=0
Rl14 (\8\:qbint \9\:qbint) resistor r=4.3144 c=0
Rl32 (\8\:CKb \11\:CKb) resistor r=24.2328 c=0
Rl20 (\3\:CKb \4\:CKb) resistor r=24.2328 c=0
Rl16 (CKb \2\:CKb) resistor r=76.1559 c=0
Rl30 (\6\:CKb \9\:CKb) resistor r=159.297 c=0
Rl27 (\5\:CKb \6\:CKb) resistor r=78.8241 c=0
Rl29 (\7\:CKb \8\:CKb) resistor r=203.39 c=0
Rl31 (\7\:CKb \10\:CKb) resistor r=30.4507 c=0
Rl28 (\6\:CKb \7\:CKb) resistor r=200.39 c=0
Rl11 (n30 \2\:n30) resistor r=180.616 c=0
Rl12 (\2\:n30 \3\:n30) resistor r=29.5379 c=0
Rl23 (mout \2\:mout) resistor r=123.769 c=0
Rl24 (\2\:mout \3\:mout) resistor r=29.5379 c=0
Rl26 (\7\:CKbb \8\:CKbb) resistor r=66.0764 c=0
Rl25 (\5\:CKbb \6\:CKbb) resistor r=35.3072 c=0
Rl18 (\2\:CKbb \3\:CKbb) resistor r=133.001 c=0
Rl17 (CKbb \2\:CKbb) resistor r=33.3555 c=0
Rl19 (\2\:CKbb \4\:CKbb) resistor r=9.7447 c=0
Rl21 (n20 \2\:n20) resistor r=58.7903 c=0
Rl22 (\2\:n20 \3\:n20) resistor r=87.6365 c=0
Rl36 (SEb \2\:SEb) resistor r=24.2328 c=0
Rl37 (\2\:SEb \3\:SEb) resistor r=193.351 c=0
Rz19 (\3\:VDD \4\:VDD) resistor r=15 c=0
Rz20 (\3\:VDD \8\:VDD) resistor r=6.25 c=0
Rz21 (\3\:VDD \18\:VDD) resistor r=6.25 c=0
Rz3 (\1\:Q \2\:Q) resistor r=75 c=0
Rz1 (\3\:QN \4\:QN) resistor r=75 c=0
Rz13 (\1\:VSS \2\:VSS) resistor r=75 c=0
Rz14 (\11\:VSS \12\:VSS) resistor r=75 c=0
Rz15 (\13\:VSS \14\:VSS) resistor r=75 c=0
Rz16 (\15\:VSS \16\:VSS) resistor r=75 c=0
Rz17 (\17\:VSS \18\:VSS) resistor r=75 c=0
Rz18 (\19\:VSS \20\:VSS) resistor r=75 c=0
Rz2 (\9\:net367 \10\:net367) resistor r=75 c=0
Rz4 (\13\:qbint \14\:qbint) resistor r=75 c=0
Rz7 (\18\:CKb \19\:CKb) resistor r=75 c=0
Rz5 (\8\:n30 \9\:n30) resistor r=75 c=0
Rz6 (\6\:mout \7\:mout) resistor r=75 c=0
Rz9 (\15\:CKbb \16\:CKbb) resistor r=75 c=0
Rz8 (\8\:n20 \9\:n20) resistor r=75 c=0
Rz10 (Db \2\:Db) resistor r=75 c=0
Rz11 (\9\:Db \10\:Db) resistor r=75 c=0
Rz12 (\8\:SEb \9\:SEb) resistor r=75 c=0
Ry16 (\1\:VDD \2\:VDD) resistor r=62 c=0
Ry17 (\6\:VDD \7\:VDD) resistor r=62 c=0
Ry18 (\10\:VDD \11\:VDD) resistor r=62 c=0
Ry19 (\13\:VDD \14\:VDD) resistor r=62 c=0
Ry20 (\16\:VDD \17\:VDD) resistor r=62 c=0
Ry21 (\20\:VDD \21\:VDD) resistor r=62 c=0
Ry3 (\3\:Q \4\:Q) resistor r=62 c=0
Ry1 (\1\:QN \2\:QN) resistor r=62 c=0
Ry13 (\3\:VSS \4\:VSS) resistor r=12.4 c=0
Ry14 (\3\:VSS \6\:VSS) resistor r=5.1667 c=0
Ry15 (\3\:VSS \9\:VSS) resistor r=5.1667 c=0
Ry2 (\5\:net367 \6\:net367) resistor r=62 c=0
Ry4 (\15\:qbint \16\:qbint) resistor r=62 c=0
Ry7 (\15\:CKb \16\:CKb) resistor r=62 c=0
Ry5 (\4\:n30 \5\:n30) resistor r=62 c=0
Ry6 (\8\:mout \9\:mout) resistor r=62 c=0
Ry9 (\9\:CKbb \10\:CKbb) resistor r=62 c=0
Ry8 (\4\:n20 \5\:n20) resistor r=62 c=0
Ry10 (\5\:Db \6\:Db) resistor r=62 c=0
Ry11 (\7\:Db \8\:Db) resistor r=62 c=0
Ry12 (\4\:SEb \5\:SEb) resistor r=62 c=0
Rx2 (\2\:CK \4\:CK) resistor r=45 c=0
Rx15 (\7\:SE \9\:SE) resistor r=45 c=0
Rx16 (\4\:SE \10\:SE) resistor r=45 c=0
Rx17 (\2\:SE \11\:SE) resistor r=45 c=0
Rx18 (\2\:SI \4\:SI) resistor r=45 c=0
Rx14 (\2\:D \4\:D) resistor r=45 c=0
Rx1 (net367 \8\:net367) resistor r=45 c=0
Rx3 (\9\:qbint \11\:qbint) resistor r=45 c=0
Rx4 (\2\:qbint \17\:qbint) resistor r=45 c=0
Rx7 (\11\:CKb \12\:CKb) resistor r=45 c=0
Rx8 (\4\:CKb \13\:CKb) resistor r=45 c=0
Rx9 (\2\:CKb \17\:CKb) resistor r=45 c=0
Rx5 (\3\:n30 \7\:n30) resistor r=45 c=0
Rx6 (\2\:mout \4\:mout) resistor r=45 c=0
Rx11 (\8\:CKbb \11\:CKbb) resistor r=45 c=0
Rx12 (\6\:CKbb \13\:CKbb) resistor r=45 c=0
Rx13 (\4\:CKbb \14\:CKbb) resistor r=45 c=0
Rx10 (\2\:n20 \7\:n20) resistor r=45 c=0
Rx19 (\2\:SEb \7\:SEb) resistor r=45 c=0
mn57 (\3\:QN \3\:net367 \19\:VSS VSS) g45n1lvt w=(1.45e-07) l=4.5e-08 \
        nf=1 as=5.335e-14 ad=2.393e-14 ps=1.62e-06 pd=6.2e-07 nrd=1.16667 \
        nrs=1.16667 sa=1.65e-07 sb=3.45e-07 sd=160n sca=23.279 \
        scb=0.0230742 scc=0.00267719 m=(1)
mn56 (\9\:net367 \4\:qbint \19\:VSS VSS) g45n1lvt w=(1.45e-07) l=4.5e-08 \
        nf=1 as=5.335e-14 ad=2.03e-14 ps=1.62e-06 pd=5.7e-07 nrd=1.16667 \
        nrs=1.16667 sa=3.7e-07 sb=1.4e-07 sd=160n sca=23.279 scb=0.0230742 \
        scc=0.00267719 m=(1)
mn55 (\1\:Q \5\:qbint \17\:VSS VSS) g45n1lvt w=(1.45e-07) l=4.5e-08 nf=1 \
        as=5.235e-14 ad=2.03e-14 ps=1.58e-06 pd=5.7e-07 nrd=1.16667 \
        nrs=1.16667 sa=1.4e-07 sb=4.25e-07 sd=160n sca=19.8813 \
        scb=0.0206549 scc=0.00197265 m=(1)
mn20 (\18\:CKb \3\:CK \17\:VSS VSS) g45n1lvt w=(1.45e-07) l=4.5e-08 nf=1 \
        as=5.235e-14 ad=3.19e-14 ps=1.58e-06 pd=7.3e-07 nrd=1.16667 \
        nrs=1.16667 sa=3.45e-07 sb=2.2e-07 sd=160n sca=19.8813 \
        scb=0.0206549 scc=0.00197265 m=(1)
mn45 (\13\:qbint \2\:n30 \15\:VSS VSS) g45n1lvt w=(1.45e-07) l=4.5e-08 \
        nf=1 as=3.625e-14 ad=2.828e-14 ps=7.9e-07 pd=6.8e-07 nrd=1.16667 \
        nrs=1.16667 sa=1.95e-07 sb=2e-06 sd=160n sca=14.7993 scb=0.0157101 \
        scc=0.000964917 m=(1)
mn50 (net436 \10\:qbint \15\:VSS VSS) g45n1lvt w=(1.45e-07) l=4.5e-08 \
        nf=1 as=3.625e-14 ad=1.958e-14 ps=7.9e-07 pd=5.6e-07 nrd=1.16667 \
        nrs=1.16667 sa=4.9e-07 sb=1.8e-06 sd=160n sca=14.7993 \
        scb=0.0157101 scc=0.000964917 m=(1)
mn51 (\8\:n30 CKb net436 VSS) g45n1lvt w=(1.45e-07) l=4.5e-08 nf=1 \
        as=1.958e-14 ad=3.045e-14 ps=5.6e-07 pd=7.1e-07 nrd=1.16667 \
        nrs=1.16667 sa=6.7e-07 sb=1.62e-06 sd=160n sca=14.7993 \
        scb=0.0157101 scc=0.000964917 m=(1)
mn40 (\8\:n30 CKbb \6\:mout VSS) g45n1lvt w=(1.45e-07) l=4.5e-08 nf=1 \
        as=5.655e-14 ad=3.045e-14 ps=1.07e-06 pd=7.1e-07 nrd=1.16667 \
        nrs=1.16667 sa=9.25e-07 sb=1.365e-06 sd=160n sca=14.7993 \
        scb=0.0157101 scc=0.000964917 m=(1)
mn30 (\6\:mout \3\:n20 \13\:VSS VSS) g45n1lvt w=(1.45e-07) l=4.5e-08 \
        nf=1 as=6.67e-14 ad=5.655e-14 ps=1.31e-06 pd=1.07e-06 nrd=1.16667 \
        nrs=1.16667 sa=1.36e-06 sb=9.3e-07 sd=160n sca=14.7993 \
        scb=0.0157101 scc=0.000964917 m=(1)
mn35 (net429 \3\:mout \13\:VSS VSS) g45n1lvt w=(1.45e-07) l=4.5e-08 nf=1 \
        as=6.67e-14 ad=8.7e-15 ps=1.31e-06 pd=4.1e-07 nrd=1.16667 \
        nrs=1.16667 sa=1.625e-06 sb=6.65e-07 sd=160n sca=14.7993 \
        scb=0.0157101 scc=0.000964917 m=(1)
mn36 (\8\:n20 \5\:CKbb net429 VSS) g45n1lvt w=(1.45e-07) l=4.5e-08 nf=1 \
        as=8.7e-15 ad=2.9e-14 ps=4.1e-07 pd=6.9e-07 nrd=1.16667 \
        nrs=1.16667 sa=1.73e-06 sb=5.6e-07 sd=160n sca=14.7993 \
        scb=0.0157101 scc=0.000964917 m=(1)
mn25 (\8\:n20 \10\:CKb \9\:Db VSS) g45n1lvt w=(1.45e-07) l=4.5e-08 nf=1 \
        as=4.568e-14 ad=2.9e-14 ps=9.2e-07 pd=6.9e-07 nrd=1.16667 \
        nrs=1.16667 sa=1.975e-06 sb=3.15e-07 sd=160n sca=14.7993 \
        scb=0.0157101 scc=0.000964917 m=(1)
mn21 (\15\:CKbb \5\:CKb \11\:VSS VSS) g45n1lvt w=(1.45e-07) l=4.5e-08 \
        nf=1 as=2.32e-14 ad=2.03e-14 ps=6.1e-07 pd=5.7e-07 nrd=1.16667 \
        nrs=1.16667 sa=1.4e-07 sb=1.145e-06 sd=160n sca=9.87692 \
        scb=0.0087933 scc=0.000232488 m=(1)
mn11 (net449 \1\:D \11\:VSS VSS) g45n1lvt w=(1.45e-07) l=4.5e-08 nf=1 \
        as=2.32e-14 ad=3.48e-14 ps=6.1e-07 pd=7.7e-07 nrd=1.16667 \
        nrs=1.16667 sa=3.45e-07 sb=9.4e-07 sd=160n sca=9.87692 \
        scb=0.0087933 scc=0.000232488 m=(1)
mn12 (Db \3\:SEb net449 VSS) g45n1lvt w=(1.45e-07) l=4.5e-08 nf=1 \
        as=3.48e-14 ad=2.32e-14 ps=7.7e-07 pd=6.1e-07 nrd=1.16667 \
        nrs=1.16667 sa=6.3e-07 sb=6.55e-07 sd=160n sca=9.87692 \
        scb=0.0087933 scc=0.000232488 m=(1)
mn14 (Db \3\:SE net461 VSS) g45n1lvt w=(1.45e-07) l=4.5e-08 nf=1 \
        as=8.7e-15 ad=2.32e-14 ps=4.1e-07 pd=6.1e-07 nrd=1.16667 \
        nrs=1.16667 sa=8.35e-07 sb=4.5e-07 sd=160n sca=9.87692 \
        scb=0.0087933 scc=0.000232488 m=(1)
mn13 (net461 \1\:SI \1\:VSS VSS) g45n1lvt w=(1.45e-07) l=4.5e-08 nf=1 \
        as=2.32e-14 ad=8.7e-15 ps=6.1e-07 pd=4.1e-07 nrd=1.16667 \
        nrs=1.16667 sa=9.4e-07 sb=3.45e-07 sd=160n sca=9.87692 \
        scb=0.0087933 scc=0.000232488 m=(1)
mn10 (\8\:SEb \8\:SE \1\:VSS VSS) g45n1lvt w=(1.45e-07) l=4.5e-08 nf=1 \
        as=2.32e-14 ad=2.03e-14 ps=6.1e-07 pd=5.7e-07 nrd=1.16667 \
        nrs=1.16667 sa=1.145e-06 sb=1.4e-07 sd=160n sca=9.87692 \
        scb=0.0087933 scc=0.000232488 m=(1)
ends SDFFXL
// End of subcircuit definition.
