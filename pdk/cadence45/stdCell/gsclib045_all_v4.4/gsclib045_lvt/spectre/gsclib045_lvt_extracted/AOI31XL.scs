// Generated for: spectre (May  1 09:12:14 2013 )
// Library name: gsclib045_lvt
// Cell name: AOI31XL
// View name: extracted

simulator lang=spectre

subckt AOI31XL A0 A1 A2 B0 VDD VSS Y
mp0 (net89 \1\:A0 \7\:VDD VDD) g45p1lvt w=(2.15e-07) l=4.5e-08 nf=1 \
        as=4.615e-14 ad=3.44e-14 ps=1.42e-06 pd=7.5e-07 nrd=1.16667 \
        nrs=1.16667 sa=1e-07 sb=9.95e-07 sd=160n sca=17.5166 scb=0.0182556 \
        scc=0.000475856 m=(1)
mp1 (net89 \1\:A1 \5\:VDD VDD) g45p1lvt w=(2.15e-07) l=4.5e-08 nf=1 \
        as=8.63e-14 ad=3.44e-14 ps=1.52e-06 pd=7.5e-07 nrd=1.16667 \
        nrs=1.16667 sa=3.05e-07 sb=7.9e-07 sd=160n sca=13.9261 \
        scb=0.0122243 scc=0.000335729 m=(1)
mp2 (\3\:net89 \1\:A2 \5\:VDD VDD) g45p1lvt w=(2.15e-07) l=4.5e-08 nf=1 \
        as=8.63e-14 ad=3.87e-14 ps=1.52e-06 pd=7.9e-07 nrd=1.16667 \
        nrs=1.16667 sa=5.7e-07 sb=5.25e-07 sd=160n sca=12.9171 \
        scb=0.0110416 scc=0.000332167 m=(1)
mp3 (\1\:Y \1\:B0 \3\:net89 VDD) g45p1lvt w=(2.15e-07) l=4.5e-08 nf=1 \
        as=3.87e-14 ad=6.45e-14 ps=7.9e-07 pd=1.03e-06 nrd=1.16667 \
        nrs=1.16667 sa=7.95e-07 sb=3e-07 sd=160n sca=13.7104 scb=0.0119478 \
        scc=0.000334396 m=(1)
C1 (A2 VSS) capacitor c=4.41141e-17
C2 (A1 VSS) capacitor c=9.6013e-17
C3 (Y VSS) capacitor c=2.38123e-17
C4 (VDD VSS) capacitor c=1.20794e-16
C5 (B0 VSS) capacitor c=7.12943e-17
C6 (A0 VSS) capacitor c=5.11081e-17
C7 (net97 VSS) capacitor c=1.59504e-18
C8 (net101 VSS) capacitor c=4.09452e-18
C9 (net89 VSS) capacitor c=3.01141e-17
C10 (\1\:B0 VSS) capacitor c=2.33522e-17
C11 (\1\:A2 VSS) capacitor c=5.16248e-17
C12 (\1\:A1 VSS) capacitor c=4.76408e-17
C13 (\1\:A0 VSS) capacitor c=2.83328e-17
C14 (\3\:B0 VSS) capacitor c=3.58858e-17
C15 (\3\:A2 VSS) capacitor c=2.68456e-17
C16 (\3\:A1 VSS) capacitor c=3.0964e-17
C17 (\3\:A0 VSS) capacitor c=3.66227e-17
C18 (\2\:B0 VSS) capacitor c=3.35159e-17
C19 (\2\:A2 VSS) capacitor c=3.55571e-17
C20 (\2\:A1 VSS) capacitor c=3.95756e-17
C21 (\2\:A0 VSS) capacitor c=3.35384e-17
C22 (\1\:Y VSS) capacitor c=4.14753e-17
C23 (\3\:net89 VSS) capacitor c=5.82191e-17
C24 (\5\:VDD VSS) capacitor c=1.2933e-17
C25 (\7\:VDD VSS) capacitor c=3.15995e-18
C26 (\4\:Y VSS) capacitor c=6.30346e-17
C27 (\4\:A0 VSS) capacitor c=1.51577e-17
C28 (\4\:A2 VSS) capacitor c=6.36291e-17
C29 (\4\:B0 VSS) capacitor c=3.33962e-17
C30 (\3\:Y VSS) capacitor c=6.09642e-17
C31 (\3\:VDD VSS) capacitor c=4.08884e-17
C32 (\4\:VDD VSS) capacitor c=8.90098e-18
Rk9 (\2\:VSS \4\:VSS) resistor r=0.5292 c=0
Rk11 (\5\:VSS VSS) resistor r=0.06678 c=0
Rk10 (\4\:VSS \5\:VSS) resistor r=0.2812 c=0
Rk12 (\5\:VSS \7\:VSS) resistor r=0.3578 c=0
Rk3 (A2 \4\:A2) resistor r=0.01337 c=0
Rk2 (\4\:A1 A1) resistor r=0.002876 c=0
Rk8 (\3\:Y Y) resistor r=0.08474 c=0
Rk6 (\2\:Y \3\:Y) resistor r=0.2153 c=0
Rk7 (\3\:Y \5\:Y) resistor r=0.4511 c=0
Rk15 (\4\:VDD VDD) resistor r=0.05185 c=0
Rk14 (\3\:VDD \4\:VDD) resistor r=0.2337 c=0
Rk16 (\3\:VDD \6\:VDD) resistor r=0.07243 c=0
Rk17 (\4\:VDD \8\:VDD) resistor r=0.07243 c=0
Rk5 (\4\:B0 B0) resistor r=0.02648 c=0
Rk1 (\4\:A0 A0) resistor r=0.073 c=0
Rk4 (\2\:net89 \4\:net89) resistor r=0.2755 c=0
Rl5 (\1\:A2 \2\:A2) resistor r=112.694 c=0
Rl6 (\2\:A2 \3\:A2) resistor r=24.2328 c=0
Rl3 (\1\:A1 \2\:A1) resistor r=79.5379 c=0
Rl4 (\2\:A1 \3\:A1) resistor r=60.3072 c=0
Rl7 (\1\:B0 \2\:B0) resistor r=24.2328 c=0
Rl8 (\2\:B0 \3\:B0) resistor r=112.694 c=0
Rl1 (\1\:A0 \2\:A0) resistor r=29.5379 c=0
Rl2 (\2\:A0 \3\:A0) resistor r=110.307 c=0
Rz2 (\1\:VSS \2\:VSS) resistor r=75 c=0
Rz3 (\6\:VSS \7\:VSS) resistor r=75 c=0
Rz1 (\4\:Y \5\:Y) resistor r=75 c=0
Ry3 (\1\:Y \2\:Y) resistor r=62 c=0
Ry5 (\5\:VDD \6\:VDD) resistor r=62 c=0
Ry6 (\7\:VDD \8\:VDD) resistor r=62 c=0
Ry1 (net89 \2\:net89) resistor r=62 c=0
Ry2 (\3\:net89 \4\:net89) resistor r=62 c=0
Rx3 (\2\:A2 \4\:A2) resistor r=45 c=0
Rx2 (\2\:A1 \4\:A1) resistor r=45 c=0
Rx4 (\2\:B0 \4\:B0) resistor r=45 c=0
Rx1 (\2\:A0 \4\:A0) resistor r=45 c=0
mn0 (net97 \3\:A0 \6\:VSS VSS) g45n1lvt w=(1.45e-07) l=4.5e-08 nf=1 \
        as=2.03e-14 ad=2.32e-14 ps=5.7e-07 pd=6.1e-07 nrd=1.16667 \
        nrs=1.16667 sa=1.4e-07 sb=8.35e-07 sd=160n sca=23.279 \
        scb=0.0230742 scc=0.00267719 m=(1)
mn1 (net101 \3\:A1 net97 VSS) g45n1lvt w=(1.45e-07) l=4.5e-08 nf=1 \
        as=2.32e-14 ad=3.19e-14 ps=6.1e-07 pd=7.3e-07 nrd=1.16667 \
        nrs=1.16667 sa=3.45e-07 sb=6.3e-07 sd=160n sca=23.279 \
        scb=0.0230742 scc=0.00267719 m=(1)
mn2 (\4\:Y \3\:A2 net101 VSS) g45n1lvt w=(1.45e-07) l=4.5e-08 nf=1 \
        as=3.19e-14 ad=2.61e-14 ps=7.3e-07 pd=6.5e-07 nrd=1.16667 \
        nrs=1.16667 sa=6.1e-07 sb=3.65e-07 sd=160n sca=23.279 \
        scb=0.0230742 scc=0.00267719 m=(1)
mn3 (\4\:Y \3\:B0 \1\:VSS VSS) g45n1lvt w=(1.45e-07) l=4.5e-08 nf=1 \
        as=2.03e-14 ad=2.61e-14 ps=5.7e-07 pd=6.5e-07 nrd=1.16667 \
        nrs=1.16667 sa=8.35e-07 sb=1.4e-07 sd=160n sca=23.279 \
        scb=0.0230742 scc=0.00267719 m=(1)
ends AOI31XL
// End of subcircuit definition.
