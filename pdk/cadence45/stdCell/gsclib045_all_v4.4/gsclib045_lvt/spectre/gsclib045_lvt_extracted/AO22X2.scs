// Generated for: spectre (May  1 09:11:42 2013 )
// Library name: gsclib045_lvt
// Cell name: AO22X2
// View name: extracted

simulator lang=spectre

subckt AO22X2 A0 A1 B0 B1 VDD VSS Y
mp0 (\5\:net111 \4\:A0 \9\:VDD VDD) g45p1lvt w=(2.15e-07) l=4.5e-08 nf=1 \
        as=8.21e-14 ad=3.01e-14 ps=1.45e-06 pd=7.1e-07 nrd=1.16667 \
        nrs=1.16667 sa=1.4e-07 sb=9e-07 sd=160n sca=24.7768 scb=0.0281397 \
        scc=0.00159433 m=(1)
mp1 (\3\:net111 \1\:A1 \9\:VDD VDD) g45p1lvt w=(2.15e-07) l=4.5e-08 nf=1 \
        as=8.21e-14 ad=4.192e-14 ps=1.45e-06 pd=8.2e-07 nrd=1.16667 \
        nrs=1.16667 sa=4.05e-07 sb=6.35e-07 sd=160n sca=13.7572 \
        scb=0.0118002 scc=0.000202164 m=(1)
mp3 (\12\:net128 \3\:B1 \3\:net111 VDD) g45p1lvt w=(2.15e-07) l=4.5e-08 \
        nf=1 as=4.192e-14 ad=4.515e-14 ps=8.2e-07 pd=8.5e-07 nrd=1.16667 \
        nrs=1.16667 sa=6.45e-07 sb=3.95e-07 sd=160n sca=11.856 \
        scb=0.00944487 scc=0.000188136 m=(1)
mp2 (\12\:net128 \4\:B0 net111 VDD) g45p1lvt w=(2.15e-07) l=4.5e-08 nf=1 \
        as=3.01e-14 ad=4.515e-14 ps=7.1e-07 pd=8.5e-07 nrd=1.16667 \
        nrs=1.16667 sa=9e-07 sb=1.4e-07 sd=160n sca=11.3991 scb=0.00920061 \
        scc=0.000187981 m=(1)
C1 (B0 VSS) capacitor c=3.93261e-17
C2 (A0 VSS) capacitor c=8.70006e-17
C3 (VDD VSS) capacitor c=1.57939e-16
C4 (B1 VSS) capacitor c=1.23903e-16
C5 (A1 VSS) capacitor c=4.83041e-17
C6 (Y VSS) capacitor c=5.15399e-17
C7 (net128 VSS) capacitor c=8.71314e-17
C8 (net132 VSS) capacitor c=6.0962e-18
C9 (net111 VSS) capacitor c=6.56962e-17
C10 (\4\:B0 VSS) capacitor c=3.17158e-17
C11 (\3\:B1 VSS) capacitor c=4.8075e-17
C12 (\1\:A1 VSS) capacitor c=4.68554e-17
C13 (\4\:A0 VSS) capacitor c=3.29479e-17
C14 (\3\:B0 VSS) capacitor c=4.92325e-17
C15 (\1\:B1 VSS) capacitor c=2.88307e-17
C16 (\3\:A1 VSS) capacitor c=6.25384e-17
C17 (\1\:A0 VSS) capacitor c=7.53278e-17
C18 (\4\:net128 VSS) capacitor c=3.18281e-17
C19 (\1\:B0 VSS) capacitor c=1.86447e-17
C20 (\2\:B1 VSS) capacitor c=4.60108e-17
C21 (\2\:A1 VSS) capacitor c=6.50997e-17
C22 (\3\:A0 VSS) capacitor c=1.35464e-17
C23 (\1\:VDD VSS) capacitor c=9.06369e-17
C24 (\3\:Y VSS) capacitor c=5.9449e-17
C25 (\12\:net128 VSS) capacitor c=9.75377e-17
C26 (\3\:net111 VSS) capacitor c=6.96778e-17
C27 (\9\:VDD VSS) capacitor c=1.19681e-17
C28 (\5\:net111 VSS) capacitor c=4.26113e-17
C29 (\1\:Y VSS) capacitor c=5.03799e-17
C30 (\10\:net128 VSS) capacitor c=3.61649e-17
C31 (\2\:A0 VSS) capacitor c=4.61252e-17
C32 (\2\:B0 VSS) capacitor c=2.69015e-17
C33 (\3\:net128 VSS) capacitor c=5.44837e-17
C34 (\4\:A1 VSS) capacitor c=5.15883e-17
C35 (\5\:B0 VSS) capacitor c=7.76559e-17
C36 (\8\:net128 VSS) capacitor c=7.05552e-17
C37 (\9\:net128 VSS) capacitor c=1.01401e-16
C38 (\5\:VDD VSS) capacitor c=2.85348e-17
C39 (\6\:VDD VSS) capacitor c=1.32263e-17
Rk6 (\5\:B0 B0) resistor r=0.005849 c=0
Rk1 (\5\:A0 A0) resistor r=0.003674 c=0
Rk19 (\1\:VSS \5\:VSS) resistor r=0.1925 c=0
Rk21 (\6\:VSS VSS) resistor r=0.07963 c=0
Rk20 (\5\:VSS \6\:VSS) resistor r=0.3201 c=0
Rk23 (\6\:VSS \10\:VSS) resistor r=0.2782 c=0
Rk13 (\1\:VDD \5\:VDD) resistor r=0.18 c=0
Rk15 (\6\:VDD VDD) resistor r=0.1172 c=0
Rk14 (\5\:VDD \6\:VDD) resistor r=0.2826 c=0
Rk17 (\6\:VDD \10\:VDD) resistor r=0.07311 c=0
Rk3 (\4\:B1 B1) resistor r=0.02017 c=0
Rk2 (\4\:A1 A1) resistor r=0.1211 c=0
Rk10 (\2\:Y Y) resistor r=0.373 c=0
Rk11 (Y \4\:Y) resistor r=0.1488 c=0
Rk7 (\8\:net128 \9\:net128) resistor r=0.3614 c=0
Rk8 (\9\:net128 \11\:net128) resistor r=0.2109 c=0
Rk9 (\9\:net128 \13\:net128) resistor r=0.4766 c=0
Rk4 (\2\:net111 \4\:net111) resistor r=0.4223 c=0
Rk5 (\4\:net111 \6\:net111) resistor r=0.3262 c=0
Rl10 (\2\:B0 \4\:B0) resistor r=37.3411 c=0
Rl9 (\2\:B0 \3\:B0) resistor r=179.649 c=0
Rl8 (\1\:B0 \2\:B0) resistor r=5.6742 c=0
Rl3 (\2\:A0 \4\:A0) resistor r=24.4619 c=0
Rl1 (\1\:A0 \2\:A0) resistor r=224.51 c=0
Rl2 (\2\:A0 \3\:A0) resistor r=6.4284 c=0
Rl7 (\2\:B1 \3\:B1) resistor r=164.56 c=0
Rl6 (\1\:B1 \2\:B1) resistor r=38.4615 c=0
Rl4 (\1\:A1 \2\:A1) resistor r=81.9251 c=0
Rl5 (\2\:A1 \3\:A1) resistor r=116.54 c=0
Rl12 (\3\:net128 net128) resistor r=131.714 c=0
Rl13 (\3\:net128 \4\:net128) resistor r=4.9601 c=0
Rz6 (\10\:VSS \9\:VSS) resistor r=75 c=0
Rz2 (\2\:Y \1\:Y) resistor r=75 c=0
Rz1 (\11\:net128 \10\:net128) resistor r=75 c=0
Ry8 (\10\:VDD \9\:VDD) resistor r=62 c=0
Ry5 (\4\:Y \3\:Y) resistor r=20.6667 c=0
Ry4 (\13\:net128 \12\:net128) resistor r=62 c=0
Ry1 (net111 \2\:net111) resistor r=62 c=0
Ry2 (\3\:net111 \4\:net111) resistor r=62 c=0
Ry3 (\5\:net111 \6\:net111) resistor r=62 c=0
Rx4 (\1\:B0 \5\:B0) resistor r=45 c=0
Rx1 (\3\:A0 \5\:A0) resistor r=45 c=0
Rx3 (\2\:B1 \4\:B1) resistor r=45 c=0
Rx2 (\2\:A1 \4\:A1) resistor r=45 c=0
Rx5 (\8\:net128 \4\:net128) resistor r=45 c=0
mn0 (net124 \1\:A0 \9\:VSS VSS) g45n1lvt w=(1.45e-07) l=4.5e-08 nf=1 \
        as=2.03e-14 ad=8.7e-15 ps=5.7e-07 pd=4.1e-07 nrd=1.16667 \
        nrs=1.16667 sa=1.4e-07 sb=1.37e-06 sd=160n sca=10.9472 \
        scb=0.0104991 scc=0.000356047 m=(1)
mn1 (\10\:net128 \3\:A1 net124 VSS) g45n1lvt w=(1.45e-07) l=4.5e-08 nf=1 \
        as=8.7e-15 ad=3.625e-14 ps=4.1e-07 pd=7.9e-07 nrd=1.16667 \
        nrs=1.16667 sa=2.45e-07 sb=1.265e-06 sd=160n sca=10.9472 \
        scb=0.0104991 scc=0.000356047 m=(1)
mn3 (\10\:net128 \1\:B1 net132 VSS) g45n1lvt w=(1.45e-07) l=4.5e-08 nf=1 \
        as=2.248e-14 ad=3.625e-14 ps=6e-07 pd=7.9e-07 nrd=1.16667 \
        nrs=1.16667 sa=5.4e-07 sb=9.7e-07 sd=160n sca=10.9472 \
        scb=0.0104991 scc=0.000356047 m=(1)
mn2 (net132 \3\:B0 \1\:VSS VSS) g45n1lvt w=(1.45e-07) l=4.5e-08 nf=1 \
        as=7.12e-14 ad=2.248e-14 ps=1.28e-06 pd=6e-07 nrd=1.16667 \
        nrs=1.16667 sa=7.4e-07 sb=7.7e-07 sd=160n sca=10.9472 \
        scb=0.0104991 scc=0.000356047 m=(1)
mn4 (\1\:Y \3\:net128 \1\:VSS VSS) g45n1lvt w=(2.6e-07) l=4.5e-08 nf=1 \
        as=5.38e-14 ad=4.16e-14 ps=1.04e-06 pd=8.4e-07 nrd=1.16667 \
        nrs=1.16667 sa=7.11635e-07 sb=3.45e-07 sd=160n sca=9.14564 \
        scb=0.00759168 scc=0.000213449 m=(2)
mp4 (\3\:Y net128 \1\:VDD VDD) g45p1lvt w=(3.9e-07) l=4.5e-08 nf=1 \
        as=4.92e-14 ad=6.24e-14 ps=1.06e-06 pd=1.1e-06 nrd=1.16667 \
        nrs=1.16667 sa=1.12308e-07 sb=3.45e-07 sd=160n sca=15.0157 \
        scb=0.0138815 scc=0.000273597 m=(2)
ends AO22X2
// End of subcircuit definition.
