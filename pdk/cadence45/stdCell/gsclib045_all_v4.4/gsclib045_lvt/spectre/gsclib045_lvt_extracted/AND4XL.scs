// Generated for: spectre (May  1 09:11:35 2013 )
// Library name: gsclib045_lvt
// Cell name: AND4XL
// View name: extracted

simulator lang=spectre

subckt AND4XL A B C D VDD VSS Y
mp3 (\4\:net100 \3\:D \9\:VDD VDD) g45p1lvt w=(2.15e-07) l=4.5e-08 nf=1 \
        as=3.01e-14 ad=3.44e-14 ps=7.1e-07 pd=7.5e-07 nrd=1.16667 \
        nrs=1.16667 sa=1.4e-07 sb=1.06e-06 sd=160n sca=18.9752 \
        scb=0.0206746 scc=0.000592578 m=(1)
mp2 (\4\:net100 \1\:C \7\:VDD VDD) g45p1lvt w=(2.15e-07) l=4.5e-08 nf=1 \
        as=5.515e-14 ad=3.44e-14 ps=1.45e-06 pd=7.5e-07 nrd=1.16667 \
        nrs=1.16667 sa=3.45e-07 sb=8.55e-07 sd=160n sca=13.6507 \
        scb=0.0115074 scc=0.000198787 m=(1)
mp1 (\6\:net100 \1\:B \7\:VDD VDD) g45p1lvt w=(2.15e-07) l=4.5e-08 nf=1 \
        as=5.515e-14 ad=4.515e-14 ps=1.45e-06 pd=8.5e-07 nrd=1.16667 \
        nrs=1.16667 sa=5.4e-07 sb=6.6e-07 sd=160n sca=12.6747 \
        scb=0.00982871 scc=0.000188391 m=(1)
mp0 (\6\:net100 \4\:A \1\:VDD VDD) g45p1lvt w=(2.15e-07) l=4.5e-08 nf=1 \
        as=8.21e-14 ad=4.515e-14 ps=1.45e-06 pd=8.5e-07 nrd=1.16667 \
        nrs=1.16667 sa=7.95e-07 sb=4.05e-07 sd=160n sca=13.816 \
        scb=0.0118118 scc=0.000202165 m=(1)
mp4 (\1\:Y net100 \1\:VDD VDD) g45p1lvt w=(2.15e-07) l=4.5e-08 nf=1 \
        as=8.21e-14 ad=3.01e-14 ps=1.45e-06 pd=7.1e-07 nrd=1.16667 \
        nrs=1.16667 sa=1.06e-06 sb=1.4e-07 sd=160n sca=24.7768 \
        scb=0.0281397 scc=0.00159433 m=(1)
C1 (Y VSS) capacitor c=4.81416e-17
C2 (B VSS) capacitor c=8.86712e-17
C3 (VDD VSS) capacitor c=1.19206e-16
C4 (C VSS) capacitor c=9.26199e-17
C5 (D VSS) capacitor c=6.50188e-17
C6 (A VSS) capacitor c=7.33827e-17
C7 (net100 VSS) capacitor c=5.87237e-17
C8 (\4\:A VSS) capacitor c=3.61024e-17
C9 (\1\:B VSS) capacitor c=5.76225e-17
C10 (\1\:C VSS) capacitor c=6.00376e-17
C11 (\3\:D VSS) capacitor c=4.34052e-17
C12 (\3\:net100 VSS) capacitor c=3.00996e-17
C13 (\3\:A VSS) capacitor c=6.7283e-17
C14 (\3\:B VSS) capacitor c=4.30691e-17
C15 (\3\:C VSS) capacitor c=6.39853e-17
C16 (\1\:D VSS) capacitor c=5.43835e-17
C17 (\2\:net100 VSS) capacitor c=4.84552e-17
C18 (\1\:A VSS) capacitor c=2.57161e-17
C19 (\2\:B VSS) capacitor c=6.02132e-17
C20 (\2\:C VSS) capacitor c=7.06354e-17
C21 (\2\:D VSS) capacitor c=5.9763e-17
C22 (\1\:Y VSS) capacitor c=5.83631e-17
C23 (\1\:VDD VSS) capacitor c=3.3193e-17
C24 (\6\:net100 VSS) capacitor c=1.13209e-16
C25 (\7\:VDD VSS) capacitor c=1.06942e-17
C26 (\4\:net100 VSS) capacitor c=5.22809e-17
C27 (\9\:VDD VSS) capacitor c=1.71678e-17
C28 (\3\:Y VSS) capacitor c=3.53081e-17
C29 (\9\:net100 VSS) capacitor c=6.94182e-17
C30 (\2\:A VSS) capacitor c=3.76843e-17
C31 (\4\:D VSS) capacitor c=3.78975e-17
C32 (\4\:C VSS) capacitor c=5.38913e-17
C33 (\4\:B VSS) capacitor c=5.22009e-17
C34 (\5\:A VSS) capacitor c=4.96635e-17
C35 (\8\:net100 VSS) capacitor c=1.12526e-16
C36 (\11\:net100 VSS) capacitor c=4.24243e-17
C37 (\4\:VDD VSS) capacitor c=1.5326e-17
C38 (\5\:VDD VSS) capacitor c=6.64162e-18
C39 (\6\:VDD VSS) capacitor c=8.78609e-18
Rk11 (\2\:Y Y) resistor r=0.4497 c=0
Rk12 (Y \4\:Y) resistor r=0.1253 c=0
Rk5 (B \4\:B) resistor r=0.08971 c=0
Rk20 (\4\:VSS VSS) resistor r=0.3006 c=0
Rk19 (\2\:VSS \4\:VSS) resistor r=0.35 c=0
Rk13 (\2\:VDD \4\:VDD) resistor r=0.2575 c=0
Rk14 (\4\:VDD \5\:VDD) resistor r=0.07752 c=0
Rk16 (\6\:VDD VDD) resistor r=0.03716 c=0
Rk15 (\5\:VDD \6\:VDD) resistor r=0.1851 c=0
Rk17 (\5\:VDD \8\:VDD) resistor r=0.07369 c=0
Rk18 (\6\:VDD \10\:VDD) resistor r=0.2669 c=0
Rk4 (C \4\:C) resistor r=0.08971 c=0
Rk1 (\4\:D \5\:D) resistor r=0.001403 c=0
Rk2 (\6\:D D) resistor r=0.001473 c=0
Rk3 (\5\:D \6\:D) resistor r=0.09276 c=0
Rk6 (A \5\:A) resistor r=0.1977 c=0
Rk7 (\5\:net100 \7\:net100) resistor r=0.2737 c=0
Rk8 (\7\:net100 \8\:net100) resistor r=0.6003 c=0
Rk9 (\8\:net100 \10\:net100) resistor r=0.507 c=0
Rk10 (\8\:net100 \11\:net100) resistor r=0.1838 c=0
Rl5 (\1\:B \2\:B) resistor r=150.692 c=0
Rl6 (\2\:B \3\:B) resistor r=100.692 c=0
Rl3 (\1\:C \2\:C) resistor r=150.692 c=0
Rl4 (\2\:C \3\:C) resistor r=100.692 c=0
Rl2 (\2\:D \3\:D) resistor r=157.224 c=0
Rl1 (\1\:D \2\:D) resistor r=101.9 c=0
Rl9 (\2\:A \4\:A) resistor r=73.8796 c=0
Rl8 (\2\:A \3\:A) resistor r=193.694 c=0
Rl7 (\1\:A \2\:A) resistor r=6.3321 c=0
Rl10 (net100 \2\:net100) resistor r=215.648 c=0
Rl11 (\2\:net100 \3\:net100) resistor r=34.4104 c=0
Rz2 (\3\:Y \4\:Y) resistor r=75 c=0
Rz4 (\1\:VSS \2\:VSS) resistor r=75 c=0
Rz1 (\9\:net100 \10\:net100) resistor r=75 c=0
Ry3 (\1\:Y \2\:Y) resistor r=62 c=0
Ry4 (\1\:VDD \2\:VDD) resistor r=62 c=0
Ry5 (\7\:VDD \8\:VDD) resistor r=62 c=0
Ry6 (\9\:VDD \10\:VDD) resistor r=62 c=0
Ry1 (\4\:net100 \5\:net100) resistor r=62 c=0
Ry2 (\6\:net100 \7\:net100) resistor r=62 c=0
Rx3 (\2\:B \4\:B) resistor r=45 c=0
Rx2 (\2\:C \4\:C) resistor r=45 c=0
Rx1 (\2\:D \4\:D) resistor r=45 c=0
Rx4 (\1\:A \5\:A) resistor r=45 c=0
Rx5 (\2\:net100 \11\:net100) resistor r=45 c=0
mn3 (\9\:net100 \1\:D net136 VSS) g45n1lvt w=(1.45e-07) l=4.5e-08 nf=1 \
        as=8.7e-15 ad=2.03e-14 ps=4.1e-07 pd=5.7e-07 nrd=1.16667 \
        nrs=1.16667 sa=1.4e-07 sb=8.65e-07 sd=160n sca=7.09016 \
        scb=0.00401586 scc=3.69756e-05 m=(1)
mn2 (net136 \3\:C net128 VSS) g45n1lvt w=(1.45e-07) l=4.5e-08 nf=1 \
        as=2.175e-14 ad=8.7e-15 ps=5.9e-07 pd=4.1e-07 nrd=1.16667 \
        nrs=1.16667 sa=2.45e-07 sb=7.6e-07 sd=160n sca=7.09016 \
        scb=0.00401586 scc=3.69756e-05 m=(1)
mn1 (net128 \3\:B net124 VSS) g45n1lvt w=(1.45e-07) l=4.5e-08 nf=1 \
        as=2.538e-14 ad=2.175e-14 ps=6.4e-07 pd=5.9e-07 nrd=1.16667 \
        nrs=1.16667 sa=4.4e-07 sb=5.65e-07 sd=160n sca=7.09016 \
        scb=0.00401586 scc=3.69756e-05 m=(1)
mn0 (net124 \3\:A \1\:VSS VSS) g45n1lvt w=(1.45e-07) l=4.5e-08 nf=1 \
        as=2.32e-14 ad=2.538e-14 ps=6.1e-07 pd=6.4e-07 nrd=1.16667 \
        nrs=1.16667 sa=6.6e-07 sb=3.45e-07 sd=160n sca=7.09016 \
        scb=0.00401586 scc=3.69756e-05 m=(1)
mn4 (\3\:Y \3\:net100 \1\:VSS VSS) g45n1lvt w=(1.45e-07) l=4.5e-08 nf=1 \
        as=2.32e-14 ad=2.03e-14 ps=6.1e-07 pd=5.7e-07 nrd=1.16667 \
        nrs=1.16667 sa=8.65e-07 sb=1.4e-07 sd=160n sca=7.09016 \
        scb=0.00401586 scc=3.69756e-05 m=(1)
ends AND4XL
// End of subcircuit definition.
