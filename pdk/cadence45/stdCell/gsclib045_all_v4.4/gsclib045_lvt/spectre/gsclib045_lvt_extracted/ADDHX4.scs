// Generated for: spectre (May  1 09:11:14 2013 )
// Library name: gsclib045_lvt
// Cell name: ADDHX4
// View name: extracted

simulator lang=spectre

subckt ADDHX4 A B CO S VDD VSS
mp7 (\17\:COb \1\:B \22\:VDD VDD) g45p1lvt w=(3.9e-07) l=4.5e-08 nf=1 \
        as=7.95e-14 ad=7.02e-14 ps=1.34e-06 pd=1.14e-06 nrd=1.16667 \
        nrs=1.16667 sa=1.7e-07 sb=1.58532e-06 sd=160n sca=31.1178 \
        scb=0.0283213 scc=0.00286476 m=(1)
mp6 (\17\:COb \1\:A \7\:VDD VDD) g45p1lvt w=(3.9e-07) l=4.5e-08 nf=1 \
        as=1.242e-13 ad=7.02e-14 ps=1.86e-06 pd=1.14e-06 nrd=1.16667 \
        nrs=1.16667 sa=3.95e-07 sb=1.48436e-06 sd=160n sca=26.3799 \
        scb=0.0202838 scc=0.00260575 m=(1)
mp4 (\19\:Sb \8\:B \8\:n0 VDD) g45p1lvt w=(3.9e-07) l=4.5e-08 nf=1 \
        as=1.1748e-13 ad=6.24e-14 ps=1.71e-06 pd=1.1e-06 nrd=1.16667 \
        nrs=1.16667 sa=1.14744e-06 sb=1.46006e-06 sd=160n sca=21.3455 \
        scb=0.0174972 scc=0.00212086 m=(1)
mp3 (\19\:Sb \3\:n1 n3 VDD) g45p1lvt w=(3.9e-07) l=4.5e-08 nf=1 \
        as=2.34e-14 ad=6.24e-14 ps=9e-07 pd=1.1e-06 nrd=1.16667 \
        nrs=1.16667 sa=1.23942e-06 sb=1.25506e-06 sd=160n sca=21.3455 \
        scb=0.0174972 scc=0.00212086 m=(1)
mp2 (n3 n0 \1\:VDD VDD) g45p1lvt w=(3.9e-07) l=4.5e-08 nf=1 \
        as=1.2415e-13 ad=2.34e-14 ps=1.9e-06 pd=9e-07 nrd=1.16667 \
        nrs=1.16667 sa=1.28654e-06 sb=1.15006e-06 sd=160n sca=21.3455 \
        scb=0.0174972 scc=0.00212086 m=(1)
mp8_1__rcx (\6\:CO COb \7\:VDD VDD) g45p1lvt w=(3.9e-07) l=4.5e-08 nf=1 \
        as=1.225e-13 ad=8.287e-14 ps=1.8425e-06 pd=1.205e-06 nrd=1.16667 \
        nrs=1.16667 sa=6.6e-07 sb=1.36545e-06 sd=160n sca=24.8553 \
        scb=0.0187947 scc=0.00260102 m=(4)
mp5_1__rcx (S Sb \1\:VDD VDD) g45p1lvt w=(3.9e-07) l=4.5e-08 nf=1 \
        as=1.1313e-13 ad=7.898e-14 ps=1.9e-06 pd=1.185e-06 nrd=1.16667 \
        nrs=1.16667 sa=1.35385e-06 sb=9.92308e-07 sd=160n sca=30.5009 \
        scb=0.0202006 scc=0.00336097 m=(4)
C1 (S VSS) capacitor c=1.67966e-16
C2 (VDD VSS) capacitor c=1.99958e-16
C3 (B VSS) capacitor c=1.45092e-17
C4 (CO VSS) capacitor c=1.6934e-17
C5 (A VSS) capacitor c=1.60478e-16
C6 (n4 VSS) capacitor c=1.54183e-18
C7 (COb VSS) capacitor c=3.17065e-16
C8 (n0 VSS) capacitor c=7.68892e-17
C9 (Sb VSS) capacitor c=2.71785e-16
C10 (n1 VSS) capacitor c=4.10293e-17
C11 (n2 VSS) capacitor c=2.92218e-18
C12 (n3 VSS) capacitor c=2.24885e-18
C13 (\12\:B VSS) capacitor c=3.21816e-17
C14 (\3\:n1 VSS) capacitor c=7.47592e-17
C15 (\8\:B VSS) capacitor c=4.05972e-17
C16 (\4\:A VSS) capacitor c=5.02021e-17
C17 (\1\:A VSS) capacitor c=6.06051e-17
C18 (\1\:B VSS) capacitor c=2.48675e-17
C19 (\9\:B VSS) capacitor c=3.15259e-17
C20 (\3\:n0 VSS) capacitor c=6.38859e-17
C21 (\5\:B VSS) capacitor c=7.53313e-17
C22 (\6\:A VSS) capacitor c=2.66154e-17
C23 (\3\:A VSS) capacitor c=5.68583e-17
C24 (\4\:B VSS) capacitor c=5.76025e-17
C25 (\11\:B VSS) capacitor c=2.99643e-17
C26 (\8\:Sb VSS) capacitor c=3.32437e-17
C27 (\2\:n0 VSS) capacitor c=5.11785e-17
C28 (\4\:n1 VSS) capacitor c=5.45024e-17
C29 (\2\:n1 VSS) capacitor c=4.16339e-17
C30 (\7\:B VSS) capacitor c=4.26416e-17
C31 (\5\:A VSS) capacitor c=5.09847e-17
C32 (\2\:A VSS) capacitor c=5.61814e-17
C33 (\3\:B VSS) capacitor c=1.3865e-17
C34 (\5\:n1 VSS) capacitor c=4.11434e-17
C35 (\1\:VDD VSS) capacitor c=1.40299e-16
C36 (\19\:Sb VSS) capacitor c=1.16114e-16
C37 (\8\:n0 VSS) capacitor c=2.5508e-17
C38 (\17\:COb VSS) capacitor c=8.45752e-17
C39 (\22\:VDD VSS) capacitor c=3.72637e-17
C40 (\4\:VDD VSS) capacitor c=3.4142e-17
C41 (\7\:n1 VSS) capacitor c=1.74468e-16
C42 (\16\:Sb VSS) capacitor c=8.69137e-17
C43 (\6\:n0 VSS) capacitor c=7.34947e-17
C44 (\1\:CO VSS) capacitor c=1.30871e-16
C45 (\19\:COb VSS) capacitor c=4.8399e-17
C46 (\2\:B VSS) capacitor c=2.31527e-17
C47 (\6\:B VSS) capacitor c=6.77939e-17
C48 (\16\:COb VSS) capacitor c=4.01273e-17
C49 (\6\:CO VSS) capacitor c=1.18177e-16
C50 (\7\:A VSS) capacitor c=1.54614e-16
C51 (\8\:A VSS) capacitor c=3.37715e-17
C52 (\4\:n0 VSS) capacitor c=1.05671e-16
C53 (\5\:n0 VSS) capacitor c=9.12069e-17
C54 (\18\:Sb VSS) capacitor c=1.12328e-16
C55 (\5\:S VSS) capacitor c=1.15679e-16
C56 (\13\:B VSS) capacitor c=2.25226e-16
C57 (\14\:B VSS) capacitor c=3.47504e-16
C58 (\15\:B VSS) capacitor c=1.7586e-16
C59 (\16\:B VSS) capacitor c=4.00978e-17
C60 (\9\:n1 VSS) capacitor c=2.16872e-16
C61 (\10\:n1 VSS) capacitor c=5.62797e-17
C62 (\7\:VDD VSS) capacitor c=1.22218e-16
C63 (\10\:VDD VSS) capacitor c=7.31301e-18
Rk53 (\7\:VSS VSS) resistor r=0.2051 c=0
Rk47 (\1\:VSS \7\:VSS) resistor r=0.5476 c=0
Rk18 (S \5\:S) resistor r=0.157 c=0
Rk32 (\1\:VDD \7\:VDD) resistor r=0.5435 c=0
Rk36 (\10\:VDD VDD) resistor r=0.03465 c=0
Rk35 (\7\:VDD \10\:VDD) resistor r=0.2443 c=0
Rk43 (\10\:VDD \23\:VDD) resistor r=0.2133 c=0
Rk22 (\13\:B \14\:B) resistor r=1.8713 c=0
Rk24 (\15\:B B) resistor r=0.03023 c=0
Rk23 (\14\:B \15\:B) resistor r=1.527 c=0
Rk25 (\14\:B \16\:B) resistor r=0.3289 c=0
Rk5 (\1\:CO CO) resistor r=0.01536 c=0
Rk6 (CO \6\:CO) resistor r=0.1937 c=0
Rk9 (\7\:A A) resistor r=1.2891 c=0
Rk10 (A \8\:A) resistor r=0.04495 c=0
Rk1 (\16\:COb \18\:COb) resistor r=0.2544 c=0
Rk2 (\18\:COb \20\:COb) resistor r=0.3424 c=0
Rk11 (\4\:n0 \5\:n0) resistor r=0.5809 c=0
Rk12 (\5\:n0 \7\:n0) resistor r=0.4289 c=0
Rk13 (\5\:n0 \9\:n0) resistor r=0.06399 c=0
Rk14 (\17\:Sb \18\:Sb) resistor r=0.4361 c=0
Rk15 (\18\:Sb \20\:Sb) resistor r=0.6442 c=0
Rk26 (\6\:n1 \8\:n1) resistor r=0.2725 c=0
Rk27 (\8\:n1 \9\:n1) resistor r=1.615 c=0
Rk28 (\9\:n1 \10\:n1) resistor r=0.2637 c=0
Rl1 (\1\:B \2\:B) resistor r=34.3295 c=0
Rl3 (\2\:B \4\:B) resistor r=65.0987 c=0
Rl2 (\2\:B \3\:B) resistor r=13.091 c=0
Rl25 (\6\:B \8\:B) resistor r=35.9003 c=0
Rl23 (\5\:B \6\:B) resistor r=133.089 c=0
Rl24 (\6\:B \7\:B) resistor r=156.691 c=0
Rl45 (\10\:B \12\:B) resistor r=34.4036 c=0
Rl43 (\9\:B \10\:B) resistor r=49.7882 c=0
Rl44 (\10\:B \11\:B) resistor r=4.5488 c=0
Rl20 (\4\:A \5\:A) resistor r=153.207 c=0
Rl21 (\5\:A \6\:A) resistor r=57.6695 c=0
Rl4 (\1\:A \2\:A) resistor r=57.6923 c=0
Rl5 (\2\:A \3\:A) resistor r=36.2311 c=0
Rl27 (n0 \2\:n0) resistor r=29.5379 c=0
Rl28 (\2\:n0 \3\:n0) resistor r=71.8456 c=0
Rl35 (Sb \8\:Sb) resistor r=6.6999 c=0
Rl26 (\3\:n1 \4\:n1) resistor r=24.2328 c=0
Rl22 (n1 \2\:n1) resistor r=24.2328 c=0
Rz9 (\1\:VDD \4\:VDD) resistor r=8.3333 c=0
Rz10 (\7\:VDD \4\:VDD) resistor r=6.25 c=0
Rz1 (\20\:COb \19\:COb) resistor r=75 c=0
Rz4 (\6\:n0 \7\:n0) resistor r=75 c=0
Rz5 (\17\:Sb \16\:Sb) resistor r=75 c=0
Rz8 (\7\:n1 \8\:n1) resistor r=75 c=0
Ry18 (\1\:VSS \4\:VSS) resistor r=6.8889 c=0
Ry19 (\7\:VSS \4\:VSS) resistor r=5.1667 c=0
Ry17 (\23\:VDD \22\:VDD) resistor r=62 c=0
Ry1 (\18\:COb \17\:COb) resistor r=62 c=0
Ry4 (\8\:n0 \9\:n0) resistor r=62 c=0
Ry5 (\20\:Sb \19\:Sb) resistor r=62 c=0
Ry9 (\5\:n1 \6\:n1) resistor r=62 c=0
Rx6 (\11\:B \13\:B) resistor r=45 c=0
Rx7 (\3\:B \15\:B) resistor r=45 c=0
Rx8 (\7\:B \16\:B) resistor r=45 c=0
Rx2 (\5\:A \7\:A) resistor r=45 c=0
Rx3 (\2\:A \8\:A) resistor r=45 c=0
Rx1 (\16\:COb COb) resistor r=45 c=0
Rx4 (\2\:n0 \4\:n0) resistor r=45 c=0
Rx5 (\18\:Sb \8\:Sb) resistor r=45 c=0
Rx9 (\2\:n1 \9\:n1) resistor r=45 c=0
Rx10 (\4\:n1 \10\:n1) resistor r=45 c=0
mn7 (\19\:COb \4\:B n4 VSS) g45n1lvt w=(2.6e-07) l=4.5e-08 nf=1 \
        as=1.56e-14 ad=3.64e-14 ps=6.4e-07 pd=8e-07 nrd=1.16667 \
        nrs=1.16667 sa=1.4e-07 sb=1.67577e-06 sd=160n sca=15.3338 \
        scb=0.0153436 scc=0.00119435 m=(1)
mn6 (n4 \3\:A \7\:VSS VSS) g45n1lvt w=(2.6e-07) l=4.5e-08 nf=1 \
        as=4.68e-14 ad=1.56e-14 ps=8.8e-07 pd=6.4e-07 nrd=1.16667 \
        nrs=1.16667 sa=2.45e-07 sb=1.62529e-06 sd=160n sca=15.3338 \
        scb=0.0153436 scc=0.00119435 m=(1)
mn4 (\16\:Sb n1 \6\:n0 VSS) g45n1lvt w=(2.6e-07) l=4.5e-08 nf=1 \
        as=6.95e-14 ad=5.46e-14 ps=1.32e-06 pd=9.4e-07 nrd=1.16667 \
        nrs=1.16667 sa=1.13038e-06 sb=1.40038e-06 sd=160n sca=12.4994 \
        scb=0.0122912 scc=0.000683921 m=(1)
mn3 (\16\:Sb \5\:B n2 VSS) g45n1lvt w=(2.6e-07) l=4.5e-08 nf=1 \
        as=2.34e-14 ad=5.46e-14 ps=7e-07 pd=9.4e-07 nrd=1.16667 \
        nrs=1.16667 sa=1.25298e-06 sb=1.14538e-06 sd=160n sca=12.4994 \
        scb=0.0122912 scc=0.000683921 m=(1)
mn2 (n2 \3\:n0 \1\:VSS VSS) g45n1lvt w=(2.6e-07) l=4.5e-08 nf=1 \
        as=9.435e-14 ad=2.34e-14 ps=1.62e-06 pd=7e-07 nrd=1.16667 \
        nrs=1.16667 sa=1.31788e-06 sb=1.01038e-06 sd=160n sca=12.4994 \
        scb=0.0122912 scc=0.000683921 m=(1)
mn5_1__rcx (\5\:S Sb \1\:VSS VSS) g45n1lvt w=(2.6e-07) l=4.5e-08 nf=1 \
        as=9.385e-14 ad=4.29e-14 ps=1.605e-06 pd=8.5e-07 nrd=1.16667 \
        nrs=1.16667 sa=1.17058e-06 sb=9.86058e-07 sd=160n sca=17.5885 \
        scb=0.0172826 scc=0.00162584 m=(4)
mn8_1__rcx (\1\:CO COb \7\:VSS VSS) g45n1lvt w=(2.6e-07) l=4.5e-08 nf=1 \
        as=7.134e-14 ad=7.605e-14 ps=1.275e-06 pd=1.105e-06 nrd=1.16667 \
        nrs=1.16667 sa=4.7e-07 sb=1.51712e-06 sd=160n sca=15.3338 \
        scb=0.0153436 scc=0.00119435 m=(4)
mn0 (\6\:n0 \6\:A \7\:VSS VSS) g45n1lvt w=(1.45e-07) l=4.5e-08 nf=1 \
        as=5.355e-14 ad=6.95e-14 ps=1.1e-06 pd=1.32e-06 nrd=1.16667 \
        nrs=1.16667 sa=1.67948e-06 sb=1.76845e-06 sd=160n sca=10.0732 \
        scb=0.00911402 scc=0.000253284 m=(1)
mn1 (\7\:n1 \9\:B \1\:VSS VSS) g45n1lvt w=(1.45e-07) l=4.5e-08 nf=1 \
        as=8.985e-14 ad=2.03e-14 ps=1.6e-06 pd=5.7e-07 nrd=1.16667 \
        nrs=1.16667 sa=1.46276e-06 sb=1.4e-07 sd=160n sca=23.279 \
        scb=0.0230742 scc=0.00267719 m=(1)
mp0 (\8\:n0 \4\:A \7\:VDD VDD) g45p1lvt w=(2.15e-07) l=4.5e-08 nf=1 \
        as=1.342e-13 ad=1.1748e-13 ps=1.79e-06 pd=1.71e-06 nrd=1.16667 \
        nrs=1.16667 sa=1.79e-06 sb=1.96419e-06 sd=160n sca=14.5646 \
        scb=0.0142004 scc=0.000753562 m=(1)
mp1 (\5\:n1 \12\:B \1\:VDD VDD) g45p1lvt w=(2.15e-07) l=4.5e-08 nf=1 \
        as=7.515e-14 ad=3.118e-14 ps=1.9e-06 pd=7.2e-07 nrd=1.16667 \
        nrs=1.16667 sa=1.66547e-06 sb=1.45e-07 sd=160n sca=56.1973 \
        scb=0.0435219 scc=0.00667686 m=(1)
ends ADDHX4
// End of subcircuit definition.
