// Generated for: spectre (May  1 09:16:53 2013 )
// Library name: gsclib045_lvt
// Cell name: NAND4BBXL
// View name: extracted

simulator lang=spectre

subckt NAND4BBXL AN BN C D VDD VSS Y
mp1 (\9\:n1 \1\:BN \10\:VDD VDD) g45p1lvt w=(2.15e-07) l=4.5e-08 nf=1 \
        as=3.01e-14 ad=3.01e-14 ps=7.1e-07 pd=7.1e-07 nrd=1.16667 \
        nrs=1.16667 sa=1.4e-07 sb=1.4e-07 sd=160n sca=35.6444 \
        scb=0.0398802 scc=0.00365724 m=(1)
mp5 (\6\:Y \3\:D \8\:VDD VDD) g45p1lvt w=(2.15e-07) l=4.5e-08 nf=1 \
        as=3.01e-14 ad=3.44e-14 ps=7.1e-07 pd=7.5e-07 nrd=1.16667 \
        nrs=1.16667 sa=1.4e-07 sb=1.115e-06 sd=160n sca=11.5997 \
        scb=0.00852753 scc=9.93622e-05 m=(1)
mp4 (\6\:Y \1\:C \5\:VDD VDD) g45p1lvt w=(2.15e-07) l=4.5e-08 nf=1 \
        as=3.44e-14 ad=3.44e-14 ps=7.5e-07 pd=7.5e-07 nrd=1.16667 \
        nrs=1.16667 sa=3.45e-07 sb=9.1e-07 sd=160n sca=10.7035 \
        scb=0.00787982 scc=9.84727e-05 m=(1)
mp3 (\1\:Y n1 \5\:VDD VDD) g45p1lvt w=(2.15e-07) l=4.5e-08 nf=1 \
        as=3.44e-14 ad=4.837e-14 ps=7.5e-07 pd=8.8e-07 nrd=1.16667 \
        nrs=1.16667 sa=5.5e-07 sb=7.05e-07 sd=160n sca=10.8626 \
        scb=0.00795231 scc=9.85034e-05 m=(1)
mp2 (\1\:Y n0 \1\:VDD VDD) g45p1lvt w=(2.15e-07) l=4.5e-08 nf=1 \
        as=3.44e-14 ad=4.837e-14 ps=7.5e-07 pd=8.8e-07 nrd=1.16667 \
        nrs=1.16667 sa=8.2e-07 sb=4.35e-07 sd=160n sca=12.5842 \
        scb=0.00978897 scc=0.000105974 m=(1)
mp0 (\4\:n0 \1\:AN \1\:VDD VDD) g45p1lvt w=(2.15e-07) l=4.5e-08 nf=1 \
        as=3.44e-14 ad=4.945e-14 ps=7.5e-07 pd=8.9e-07 nrd=1.16667 \
        nrs=1.16667 sa=1.025e-06 sb=2.3e-07 sd=160n sca=17.2741 \
        scb=0.017802 scc=0.000385905 m=(1)
C1 (Y VSS) capacitor c=1.07936e-16
C2 (VDD VSS) capacitor c=1.5415e-16
C3 (C VSS) capacitor c=3.2821e-17
C4 (n1 VSS) capacitor c=7.03393e-17
C5 (n2 VSS) capacitor c=1.62358e-18
C6 (n3 VSS) capacitor c=3.97837e-18
C7 (n4 VSS) capacitor c=3.98504e-18
C8 (n0 VSS) capacitor c=6.44613e-17
C9 (\1\:AN VSS) capacitor c=4.74691e-17
C10 (\1\:C VSS) capacitor c=5.52043e-17
C11 (\3\:D VSS) capacitor c=3.88582e-17
C12 (\1\:BN VSS) capacitor c=3.25973e-17
C13 (\3\:AN VSS) capacitor c=4.83788e-17
C14 (\3\:n0 VSS) capacitor c=2.92781e-17
C15 (\4\:n1 VSS) capacitor c=2.8513e-17
C16 (\3\:C VSS) capacitor c=8.72685e-17
C17 (\1\:D VSS) capacitor c=7.94349e-17
C18 (\4\:BN VSS) capacitor c=3.2757e-17
C19 (\2\:AN VSS) capacitor c=5.6314e-17
C20 (\2\:n0 VSS) capacitor c=6.7194e-17
C21 (\3\:n1 VSS) capacitor c=2.80347e-17
C22 (\2\:C VSS) capacitor c=8.04354e-17
C23 (\2\:D VSS) capacitor c=7.52575e-17
C24 (\3\:BN VSS) capacitor c=1.11021e-17
C25 (\4\:n0 VSS) capacitor c=5.6998e-17
C26 (\1\:VDD VSS) capacitor c=4.4467e-17
C27 (\1\:Y VSS) capacitor c=1.5138e-17
C28 (\5\:VDD VSS) capacitor c=2.78974e-17
C29 (\6\:Y VSS) capacitor c=5.97423e-17
C30 (\8\:VDD VSS) capacitor c=1.87504e-17
C31 (\9\:n1 VSS) capacitor c=7.18964e-17
C32 (\10\:VDD VSS) capacitor c=3.06447e-17
C33 (\8\:n0 VSS) capacitor c=3.08909e-17
C34 (\4\:Y VSS) capacitor c=1.10934e-16
C35 (\7\:n1 VSS) capacitor c=2.81927e-17
C36 (\2\:BN VSS) capacitor c=1.76581e-17
C37 (\2\:n1 VSS) capacitor c=4.52918e-17
C38 (\5\:BN VSS) capacitor c=1.05485e-16
C39 (\4\:D VSS) capacitor c=5.51938e-17
C40 (\5\:D VSS) capacitor c=6.50216e-17
C41 (\4\:C VSS) capacitor c=7.49875e-17
C42 (\5\:n1 VSS) capacitor c=8.06688e-17
C43 (\6\:n1 VSS) capacitor c=8.00497e-17
C44 (\3\:Y VSS) capacitor c=3.50449e-17
C45 (\4\:AN VSS) capacitor c=1.05358e-16
C46 (\6\:n0 VSS) capacitor c=5.49869e-17
C47 (\7\:n0 VSS) capacitor c=4.28403e-17
C48 (\4\:VDD VSS) capacitor c=2.24455e-17
C49 (\7\:VDD VSS) capacitor c=1.37046e-17
Rk1 (BN \5\:BN) resistor r=0.005134 c=0
Rk3 (\5\:BN \6\:BN) resistor r=0.02321 c=0
Rk2 (\6\:BN \7\:BN) resistor r=0.005134 c=0
Rk15 (AN \4\:AN) resistor r=0.01812 c=0
Rk12 (\3\:Y Y) resistor r=0.1133 c=0
Rk11 (\2\:Y \3\:Y) resistor r=0.05606 c=0
Rk13 (Y \5\:Y) resistor r=0.8519 c=0
Rk14 (\3\:Y \7\:Y) resistor r=0.3009 c=0
Rk26 (\4\:VSS VSS) resistor r=0.4015 c=0
Rk25 (\2\:VSS \4\:VSS) resistor r=0.4774 c=0
Rk27 (VSS \6\:VSS) resistor r=0.2196 c=0
Rk19 (\2\:VDD \4\:VDD) resistor r=0.4267 c=0
Rk20 (\4\:VDD \6\:VDD) resistor r=0.2167 c=0
Rk23 (\7\:VDD VDD) resistor r=0.2081 c=0
Rk21 (\4\:VDD \7\:VDD) resistor r=0.1934 c=0
Rk22 (\7\:VDD \9\:VDD) resistor r=0.175 c=0
Rk24 (VDD \11\:VDD) resistor r=0.3814 c=0
Rk7 (C \4\:C) resistor r=0.01074 c=0
Rk4 (D \4\:D) resistor r=0.01414 c=0
Rk6 (\4\:D \5\:D) resistor r=0.0542 c=0
Rk5 (\5\:D \6\:D) resistor r=0.01424 c=0
Rk8 (\5\:n1 \6\:n1) resistor r=0.458 c=0
Rk9 (\6\:n1 \8\:n1) resistor r=0.144 c=0
Rk10 (\6\:n1 \10\:n1) resistor r=0.3449 c=0
Rk16 (\5\:n0 \6\:n0) resistor r=0.5358 c=0
Rk17 (\6\:n0 \7\:n0) resistor r=0.2395 c=0
Rk18 (\6\:n0 \9\:n0) resistor r=0.2002 c=0
Rl1 (\1\:BN \2\:BN) resistor r=105.483 c=0
Rl3 (\2\:BN \4\:BN) resistor r=95.868 c=0
Rl2 (\2\:BN \3\:BN) resistor r=1.2666 c=0
Rl13 (\1\:AN \2\:AN) resistor r=148.769 c=0
Rl14 (\2\:AN \3\:AN) resistor r=139.153 c=0
Rl6 (\1\:C \2\:C) resistor r=127.615 c=0
Rl7 (\2\:C \3\:C) resistor r=160.307 c=0
Rl5 (\2\:D \3\:D) resistor r=57.8815 c=0
Rl4 (\1\:D \2\:D) resistor r=232.258 c=0
Rl8 (n1 \2\:n1) resistor r=266.187 c=0
Rl10 (\2\:n1 \4\:n1) resistor r=37.3411 c=0
Rl9 (\2\:n1 \3\:n1) resistor r=3.1183 c=0
Rl11 (n0 \2\:n0) resistor r=251.156 c=0
Rl12 (\2\:n0 \3\:n0) resistor r=33.8482 c=0
Rz2 (\4\:Y \5\:Y) resistor r=75 c=0
Rz5 (\1\:VSS \2\:VSS) resistor r=75 c=0
Rz6 (\5\:VSS \6\:VSS) resistor r=75 c=0
Rz1 (\7\:n1 \8\:n1) resistor r=75 c=0
Rz3 (\8\:n0 \9\:n0) resistor r=75 c=0
Ry2 (\1\:Y \2\:Y) resistor r=62 c=0
Ry3 (\6\:Y \7\:Y) resistor r=62 c=0
Ry5 (\1\:VDD \2\:VDD) resistor r=62 c=0
Ry6 (\5\:VDD \6\:VDD) resistor r=62 c=0
Ry7 (\8\:VDD \9\:VDD) resistor r=62 c=0
Ry8 (\10\:VDD \11\:VDD) resistor r=62 c=0
Ry1 (\9\:n1 \10\:n1) resistor r=62 c=0
Ry4 (\4\:n0 \5\:n0) resistor r=62 c=0
Rx1 (\3\:BN \7\:BN) resistor r=45 c=0
Rx5 (\2\:AN \4\:AN) resistor r=45 c=0
Rx3 (\2\:C \4\:C) resistor r=45 c=0
Rx2 (\2\:D \6\:D) resistor r=45 c=0
Rx4 (\3\:n1 \5\:n1) resistor r=45 c=0
Rx6 (\2\:n0 \7\:n0) resistor r=45 c=0
mn1 (\7\:n1 \4\:BN \5\:VSS VSS) g45n1lvt w=(1.45e-07) l=4.5e-08 nf=1 \
        as=2.03e-14 ad=2.973e-14 ps=5.7e-07 pd=7e-07 nrd=1.16667 \
        nrs=1.16667 sa=1.4e-07 sb=2.05e-07 sd=160n sca=7.47547 \
        scb=0.00467957 scc=5.27432e-05 m=(1)
mn5 (\4\:Y \1\:D n2 VSS) g45n1lvt w=(1.45e-07) l=4.5e-08 nf=1 as=8.7e-15 \
        ad=2.03e-14 ps=4.1e-07 pd=5.7e-07 nrd=1.16667 nrs=1.16667 \
        sa=1.4e-07 sb=9.25e-07 sd=160n sca=8.0352 scb=0.00565402 \
        scc=8.19771e-05 m=(1)
mn4 (n2 \3\:C n3 VSS) g45n1lvt w=(1.45e-07) l=4.5e-08 nf=1 as=2.32e-14 \
        ad=8.7e-15 ps=6.1e-07 pd=4.1e-07 nrd=1.16667 nrs=1.16667 \
        sa=2.45e-07 sb=8.2e-07 sd=160n sca=8.0352 scb=0.00565402 \
        scc=8.19771e-05 m=(1)
mn3 (n3 \4\:n1 n4 VSS) g45n1lvt w=(1.45e-07) l=4.5e-08 nf=1 as=3.263e-14 \
        ad=2.32e-14 ps=7.4e-07 pd=6.1e-07 nrd=1.16667 nrs=1.16667 \
        sa=4.5e-07 sb=6.15e-07 sd=160n sca=8.0352 scb=0.00565402 \
        scc=8.19771e-05 m=(1)
mn2 (n4 \3\:n0 \1\:VSS VSS) g45n1lvt w=(1.45e-07) l=4.5e-08 nf=1 \
        as=2.32e-14 ad=3.263e-14 ps=6.1e-07 pd=7.4e-07 nrd=1.16667 \
        nrs=1.16667 sa=7.2e-07 sb=3.45e-07 sd=160n sca=8.0352 \
        scb=0.00565402 scc=8.19771e-05 m=(1)
mn0 (\8\:n0 \3\:AN \1\:VSS VSS) g45n1lvt w=(1.45e-07) l=4.5e-08 nf=1 \
        as=2.32e-14 ad=2.03e-14 ps=6.1e-07 pd=5.7e-07 nrd=1.16667 \
        nrs=1.16667 sa=9.25e-07 sb=1.4e-07 sd=160n sca=8.0352 \
        scb=0.00565402 scc=8.19771e-05 m=(1)
ends NAND4BBXL
// End of subcircuit definition.
