// Generated for: spectre (May  1 09:18:06 2013 )
// Library name: gsclib045_lvt
// Cell name: OAI221X4
// View name: extracted

simulator lang=spectre

subckt OAI221X4 A0 A1 B0 B1 C0 VDD VSS Y
mp0_1__rcx (2 \1\:A0 \21\:VDD VDD) g45p1lvt w=(3.9e-07) l=4.5e-08 nf=1 \
        as=5.46e-14 ad=2.34e-14 ps=1.06e-06 pd=9e-07 nrd=1.16667 \
        nrs=1.16667 sa=1.4e-07 sb=9.71923e-07 sd=160n sca=15.6591 \
        scb=0.0148836 scc=0.000346323 m=(1)
mp1_1__rcx (\15\:Y \5\:A1 2 VDD) g45p1lvt w=(3.9e-07) l=4.5e-08 nf=1 \
        as=2.34e-14 ad=6.24e-14 ps=9e-07 pd=1.1e-06 nrd=1.16667 \
        nrs=1.16667 sa=2.45e-07 sb=8.99231e-07 sd=160n sca=13.9858 \
        scb=0.012083 scc=0.000300035 m=(1)
mp1_2__rcx (\15\:Y \1\:A1 3 VDD) g45p1lvt w=(3.9e-07) l=4.5e-08 nf=1 \
        as=2.34e-14 ad=6.24e-14 ps=9e-07 pd=1.1e-06 nrd=1.16667 \
        nrs=1.16667 sa=4.5e-07 sb=7.57308e-07 sd=160n sca=12.4846 \
        scb=0.0103323 scc=0.000291984 m=(1)
mp0_2__rcx (3 \6\:A0 \18\:VDD VDD) g45p1lvt w=(3.9e-07) l=4.5e-08 nf=1 \
        as=1.044e-13 ad=2.34e-14 ps=2.16e-06 pd=9e-07 nrd=1.16667 \
        nrs=1.16667 sa=5.55e-07 sb=6.84615e-07 sd=160n sca=12.0928 \
        scb=0.0101069 scc=0.000291823 m=(1)
mp0_3__rcx (4 \4\:A0 \18\:VDD VDD) g45p1lvt w=(3.9e-07) l=4.5e-08 nf=1 \
        as=1.044e-13 ad=2.34e-14 ps=2.16e-06 pd=9e-07 nrd=1.16667 \
        nrs=1.16667 sa=3.83077e-07 sb=2e-06 sd=160n sca=11.7201 \
        scb=0.00999512 scc=0.000291798 m=(1)
mp1_3__rcx (\13\:Y \12\:A1 4 VDD) g45p1lvt w=(3.9e-07) l=4.5e-08 nf=1 \
        as=2.34e-14 ad=6.24e-14 ps=9e-07 pd=1.1e-06 nrd=1.16667 \
        nrs=1.16667 sa=4.88077e-07 sb=2e-06 sd=160n sca=11.7201 \
        scb=0.00999512 scc=0.000291798 m=(1)
mp1 (\13\:Y \7\:A1 5 VDD) g45p1lvt w=(3.9e-07) l=4.5e-08 nf=1 as=2.34e-14 \
        ad=6.24e-14 ps=9e-07 pd=1.1e-06 nrd=1.16667 nrs=1.16667 \
        sa=6.93077e-07 sb=2e-06 sd=160n sca=11.7201 scb=0.00999512 \
        scc=0.000291798 m=(1)
mp0 (5 \10\:A0 \14\:VDD VDD) g45p1lvt w=(3.9e-07) l=4.5e-08 nf=1 \
        as=1.6185e-13 ad=2.34e-14 ps=1.61e-06 pd=9e-07 nrd=1.16667 \
        nrs=1.16667 sa=7.98077e-07 sb=2e-06 sd=160n sca=11.7201 \
        scb=0.00999512 scc=0.000291798 m=(1)
mp2_1__rcx (9 \1\:B0 \14\:VDD VDD) g45p1lvt w=(3.9e-07) l=4.5e-08 nf=1 \
        as=1.6185e-13 ad=6.24e-14 ps=1.61e-06 pd=1.1e-06 nrd=1.16667 \
        nrs=1.16667 sa=1.25808e-06 sb=2e-06 sd=160n sca=11.7201 \
        scb=0.00999512 scc=0.000291798 m=(1)
mp3_1__rcx (\11\:Y \6\:B1 9 VDD) g45p1lvt w=(3.9e-07) l=4.5e-08 nf=1 \
        as=6.24e-14 ad=6.24e-14 ps=1.1e-06 pd=1.1e-06 nrd=1.16667 \
        nrs=1.16667 sa=1.43231e-06 sb=2e-06 sd=160n sca=11.7201 \
        scb=0.00999512 scc=0.000291798 m=(1)
mp3_2__rcx (\11\:Y \1\:B1 6 VDD) g45p1lvt w=(3.9e-07) l=4.5e-08 nf=1 \
        as=2.34e-14 ad=6.24e-14 ps=9e-07 pd=1.1e-06 nrd=1.16667 \
        nrs=1.16667 sa=1.57423e-06 sb=1.91e-06 sd=160n sca=11.7201 \
        scb=0.00999512 scc=0.000291798 m=(1)
mp2_2__rcx (6 \7\:B0 \11\:VDD VDD) g45p1lvt w=(3.9e-07) l=4.5e-08 nf=1 \
        as=6.24e-14 ad=2.34e-14 ps=1.1e-06 pd=9e-07 nrd=1.16667 \
        nrs=1.16667 sa=1.64692e-06 sb=1.805e-06 sd=160n sca=11.7201 \
        scb=0.00999512 scc=0.000291798 m=(1)
mp2_3__rcx (7 \9\:B0 \11\:VDD VDD) g45p1lvt w=(3.9e-07) l=4.5e-08 nf=1 \
        as=6.24e-14 ad=2.34e-14 ps=1.1e-06 pd=9e-07 nrd=1.16667 \
        nrs=1.16667 sa=1.78885e-06 sb=1.6e-06 sd=160n sca=11.7201 \
        scb=0.00999512 scc=0.000291798 m=(1)
mp3_3__rcx (\9\:Y \12\:B1 7 VDD) g45p1lvt w=(3.9e-07) l=4.5e-08 nf=1 \
        as=2.34e-14 ad=6.24e-14 ps=9e-07 pd=1.1e-06 nrd=1.16667 \
        nrs=1.16667 sa=1.86154e-06 sb=1.495e-06 sd=160n sca=11.7201 \
        scb=0.00999512 scc=0.000291798 m=(1)
mp3 (\9\:Y \13\:B1 10 VDD) g45p1lvt w=(3.9e-07) l=4.5e-08 nf=1 \
        as=8.385e-14 ad=6.24e-14 ps=1.21e-06 pd=1.1e-06 nrd=1.16667 \
        nrs=1.16667 sa=2e-06 sb=1.29e-06 sd=160n sca=11.7201 \
        scb=0.00999512 scc=0.000291798 m=(1)
mp2 (10 \12\:B0 \1\:VDD VDD) g45p1lvt w=(3.9e-07) l=4.5e-08 nf=1 \
        as=6.24e-14 ad=8.385e-14 ps=1.1e-06 pd=1.21e-06 nrd=1.16667 \
        nrs=1.16667 sa=2e-06 sb=1.03e-06 sd=160n sca=11.7201 \
        scb=0.00999512 scc=0.000291798 m=(1)
mp4_1__rcx (\5\:Y C0 \1\:VDD VDD) g45p1lvt w=(3.9e-07) l=4.5e-08 nf=1 \
        as=6.728e-14 ad=6.24e-14 ps=1.125e-06 pd=1.1e-06 nrd=1.16667 \
        nrs=1.16667 sa=2e-06 sb=8.25e-07 sd=160n sca=11.7295 \
        scb=0.00999684 scc=0.000291798 m=(4)
C1 (C0 VSS) capacitor c=3.36373e-16
C2 (A0 VSS) capacitor c=1.97825e-17
C3 (B0 VSS) capacitor c=6.15857e-16
C4 (A1 VSS) capacitor c=4.05582e-16
C5 (VDD VSS) capacitor c=2.94321e-16
C6 (Y VSS) capacitor c=4.1395e-17
C7 (net128 VSS) capacitor c=3.37966e-16
C8 (net132 VSS) capacitor c=4.44941e-16
C9 (3 VSS) capacitor c=1.84995e-18
C10 (4 VSS) capacitor c=1.84995e-18
C11 (5 VSS) capacitor c=1.84995e-18
C12 (9 VSS) capacitor c=7.40403e-18
C13 (6 VSS) capacitor c=2.39145e-18
C14 (7 VSS) capacitor c=2.39145e-18
C15 (10 VSS) capacitor c=9.90489e-18
C16 (\12\:B0 VSS) capacitor c=4.0664e-17
C17 (\13\:B1 VSS) capacitor c=3.23913e-17
C18 (\12\:B1 VSS) capacitor c=6.95997e-17
C19 (\9\:B0 VSS) capacitor c=5.76561e-17
C20 (\7\:B0 VSS) capacitor c=7.65343e-17
C21 (\1\:B1 VSS) capacitor c=6.75498e-17
C22 (\6\:B1 VSS) capacitor c=4.01614e-17
C23 (\1\:B0 VSS) capacitor c=3.4966e-17
C24 (\10\:A0 VSS) capacitor c=6.2371e-17
C25 (\7\:A1 VSS) capacitor c=7.33816e-17
C26 (\12\:A1 VSS) capacitor c=6.75628e-17
C27 (\4\:A0 VSS) capacitor c=8.53293e-17
C28 (\6\:A0 VSS) capacitor c=8.37609e-17
C29 (\1\:A1 VSS) capacitor c=6.39443e-17
C30 (\5\:A1 VSS) capacitor c=7.16094e-17
C31 (\1\:A0 VSS) capacitor c=6.97693e-17
C32 (\3\:B1 VSS) capacitor c=3.57945e-16
C33 (\2\:A0 VSS) capacitor c=5.53418e-16
C34 (\1\:VDD VSS) capacitor c=1.62283e-16
C35 (\5\:Y VSS) capacitor c=2.11528e-16
C36 (\9\:Y VSS) capacitor c=1.2021e-16
C37 (\11\:VDD VSS) capacitor c=3.37095e-17
C38 (\11\:Y VSS) capacitor c=1.39743e-16
C39 (\14\:VDD VSS) capacitor c=4.32116e-17
C40 (\13\:Y VSS) capacitor c=1.38579e-16
C41 (\18\:VDD VSS) capacitor c=3.27399e-17
C42 (\15\:Y VSS) capacitor c=8.90205e-17
C43 (\21\:VDD VSS) capacitor c=1.11674e-17
C44 (\4\:VDD VSS) capacitor c=4.59218e-17
C45 (\1\:Y VSS) capacitor c=1.18185e-16
C46 (\7\:net128 VSS) capacitor c=2.72714e-16
C47 (\8\:A1 VSS) capacitor c=4.31468e-17
C48 (\2\:B1 VSS) capacitor c=3.3092e-17
C49 (\10\:VDD VSS) capacitor c=4.10504e-17
C50 (\13\:VDD VSS) capacitor c=3.03952e-17
C51 (\17\:VDD VSS) capacitor c=1.80824e-17
C52 (\20\:VDD VSS) capacitor c=1.71616e-17
Rk5 (\2\:A0 A0) resistor r=0.01833 c=0
Rk39 (\1\:VDD \10\:VDD) resistor r=0.3832 c=0
Rk40 (\10\:VDD \12\:VDD) resistor r=0.1816 c=0
Rk41 (\10\:VDD \13\:VDD) resistor r=0.4882 c=0
Rk42 (\13\:VDD \15\:VDD) resistor r=0.1816 c=0
Rk43 (\13\:VDD \16\:VDD) resistor r=0.2804 c=0
Rk44 (\16\:VDD \17\:VDD) resistor r=0.1602 c=0
Rk45 (\17\:VDD \19\:VDD) resistor r=0.1816 c=0
Rk48 (\20\:VDD VDD) resistor r=0.09477 c=0
Rk46 (\17\:VDD \20\:VDD) resistor r=0.2953 c=0
Rk47 (\20\:VDD \22\:VDD) resistor r=0.1861 c=0
Rk55 (\3\:VSS VSS) resistor r=0.0196 c=0
Rk49 (\2\:VSS \3\:VSS) resistor r=0.8568 c=0
Rk23 (Y \5\:Y) resistor r=0.3502 c=0
Rk22 (\1\:Y Y) resistor r=0.1668 c=0
Rk25 (\5\:Y \10\:Y) resistor r=0.5056 c=0
Rk26 (\10\:Y \12\:Y) resistor r=0.4546 c=0
Rk27 (\12\:Y \14\:Y) resistor r=0.6899 c=0
Rk28 (\14\:Y \16\:Y) resistor r=0.6463 c=0
Rk7 (\3\:B1 B1) resistor r=0.005369 c=0
Rk10 (net128 \7\:net128) resistor r=0.4036 c=0
Rl19 (\2\:A0 \10\:A0) resistor r=24.2328 c=0
Rl8 (\2\:A0 \4\:A0) resistor r=100.276 c=0
Rl9 (\2\:A0 \6\:A0) resistor r=101.477 c=0
Rl1 (\2\:A0 \1\:A0) resistor r=69.387 c=0
Rl40 (B0 \12\:B0) resistor r=29.9065 c=0
Rl33 (B0 \9\:B0) resistor r=21.9171 c=0
Rl31 (B0 \7\:B0) resistor r=77.1158 c=0
Rl21 (B0 \1\:B0) resistor r=40.3846 c=0
Rl3 (A1 \1\:A1) resistor r=62.2713 c=0
Rl6 (A1 \5\:A1) resistor r=109.593 c=0
Rl14 (\8\:A1 A1) resistor r=3.3726 c=0
Rl13 (\8\:A1 \7\:A1) resistor r=119.437 c=0
Rl17 (\8\:A1 \12\:A1) resistor r=83.3806 c=0
Rl38 (\3\:B1 \13\:B1) resistor r=88.6564 c=0
Rl37 (\3\:B1 \12\:B1) resistor r=100.195 c=0
Rl23 (\2\:B1 \1\:B1) resistor r=82.2563 c=0
Rl27 (\2\:B1 \6\:B1) resistor r=126.408 c=0
Rl24 (\2\:B1 \3\:B1) resistor r=3.9095 c=0
Rz18 (\1\:VDD \4\:VDD) resistor r=6.8182 c=0
Rz19 (\16\:VDD \4\:VDD) resistor r=6.25 c=0
Ry10 (\12\:VDD \11\:VDD) resistor r=62 c=0
Ry11 (\15\:VDD \14\:VDD) resistor r=62 c=0
Ry12 (\19\:VDD \18\:VDD) resistor r=62 c=0
Ry13 (\22\:VDD \21\:VDD) resistor r=62 c=0
Ry14 (\2\:VSS \1\:VSS) resistor r=5.6364 c=0
Ry15 (\3\:VSS \1\:VSS) resistor r=5.1667 c=0
Ry3 (\10\:Y \9\:Y) resistor r=62 c=0
Ry4 (\12\:Y \11\:Y) resistor r=62 c=0
Ry5 (\14\:Y \13\:Y) resistor r=62 c=0
Ry6 (\16\:Y \15\:Y) resistor r=62 c=0
mn2_1__rcx (net132 B0 net128 VSS) g45n1lvt w=(2.6e-07) l=4.5e-08 nf=1 \
        as=4.16e-14 ad=4.03e-14 ps=8.4e-07 pd=8.3e-07 nrd=1.16667 \
        nrs=1.16667 sa=1.4e-07 sb=2e-06 sd=160n sca=16.9678 scb=0.0167861 \
        scc=0.00150639 m=(4)
mn3_1__rcx (net132 \3\:B1 net128 VSS) g45n1lvt w=(2.6e-07) l=4.5e-08 nf=1 \
        as=4.16e-14 ad=4.16e-14 ps=8.4e-07 pd=8.4e-07 nrd=1.16667 \
        nrs=1.16667 sa=3.45e-07 sb=2e-06 sd=160n sca=16.9678 scb=0.0167861 \
        scc=0.00150639 m=(4)
mn0_1__rcx (\7\:net128 \2\:A0 \3\:VSS VSS) g45n1lvt w=(2.6e-07) \
        l=4.5e-08 nf=1 as=3.9e-14 ad=4.225e-14 ps=8.2e-07 pd=8.45e-07 \
        nrd=1.16667 nrs=1.16667 sa=1.4e-07 sb=1.585e-06 sd=160n \
        sca=16.9678 scb=0.0167861 scc=0.00150639 m=(4)
mn1_1__rcx (\7\:net128 A1 \3\:VSS VSS) g45n1lvt w=(2.6e-07) l=4.5e-08 \
        nf=1 as=4.16e-14 ad=4.225e-14 ps=8.4e-07 pd=8.45e-07 nrd=1.16667 \
        nrs=1.16667 sa=3.55e-07 sb=1.37e-06 sd=160n sca=16.9678 \
        scb=0.0167861 scc=0.00150639 m=(4)
mn4_1__rcx (\1\:Y C0 net132 VSS) g45n1lvt w=(2.6e-07) l=4.5e-08 nf=1 \
        as=4.03e-14 ad=4.16e-14 ps=8.3e-07 pd=8.4e-07 nrd=1.16667 \
        nrs=1.16667 sa=1.78e-06 sb=7.55e-07 sd=160n sca=16.9678 \
        scb=0.0167861 scc=0.00150639 m=(4)
ends OAI221X4
// End of subcircuit definition.
