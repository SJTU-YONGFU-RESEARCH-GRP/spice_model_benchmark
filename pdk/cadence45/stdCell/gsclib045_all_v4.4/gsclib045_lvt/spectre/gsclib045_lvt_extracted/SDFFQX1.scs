// Generated for: spectre (May  1 09:14:41 2013 )
// Library name: gsclib045_lvt
// Cell name: SDFFQX1
// View name: extracted

simulator lang=spectre

subckt SDFFQX1 CK D Q SE SI VDD VSS
mp55 (\1\:Q \4\:qbint \16\:VDD VDD) g45p1lvt w=(3.9e-07) l=4.5e-08 nf=1 \
        as=7.288e-14 ad=5.46e-14 ps=1.23e-06 pd=1.06e-06 nrd=1.16667 \
        nrs=1.16667 sa=1.4e-07 sb=3.1641e-07 sd=160n sca=31.6283 \
        scb=0.0342226 scc=0.00291148 m=(1)
C1 (D VSS) capacitor c=4.3067e-17
C2 (VDD VSS) capacitor c=3.31884e-16
C3 (CK VSS) capacitor c=5.90759e-17
C4 (SE VSS) capacitor c=3.08013e-17
C5 (SI VSS) capacitor c=1.32611e-16
C6 (qbint VSS) capacitor c=2.27149e-17
C7 (CKb VSS) capacitor c=4.4339e-17
C8 (n30 VSS) capacitor c=5.33233e-17
C9 (mout VSS) capacitor c=7.97432e-17
C10 (CKbb VSS) capacitor c=2.02515e-17
C11 (n20 VSS) capacitor c=4.09305e-17
C12 (Db VSS) capacitor c=9.49768e-17
C13 (n1 VSS) capacitor c=5.34612e-18
C14 (SEb VSS) capacitor c=7.17568e-17
C15 (n8 VSS) capacitor c=4.67726e-18
C16 (n6 VSS) capacitor c=7.53389e-20
C17 (n2 VSS) capacitor c=5.98587e-18
C18 (\5\:SE VSS) capacitor c=5.31411e-17
C19 (\1\:SI VSS) capacitor c=7.69307e-17
C20 (\1\:SE VSS) capacitor c=4.0696e-17
C21 (\1\:D VSS) capacitor c=6.87584e-17
C22 (\5\:CKb VSS) capacitor c=5.38282e-17
C23 (\6\:CKbb VSS) capacitor c=4.47157e-17
C24 (\8\:CKb VSS) capacitor c=7.1457e-17
C25 (\3\:n20 VSS) capacitor c=4.10905e-17
C26 (\3\:CKb VSS) capacitor c=5.9405e-17
C27 (\3\:CKbb VSS) capacitor c=4.97296e-17
C28 (\5\:qbint VSS) capacitor c=5.06633e-17
C29 (\1\:CK VSS) capacitor c=3.09963e-17
C30 (\4\:qbint VSS) capacitor c=4.76205e-17
C31 (\7\:SE VSS) capacitor c=2.97817e-17
C32 (\3\:SI VSS) capacitor c=7.18951e-17
C33 (\3\:SE VSS) capacitor c=6.70128e-17
C34 (\3\:SEb VSS) capacitor c=5.65183e-17
C35 (\3\:D VSS) capacitor c=4.12888e-17
C36 (\9\:CKb VSS) capacitor c=4.243e-17
C37 (\10\:CKb VSS) capacitor c=2.82446e-17
C38 (\4\:CKbb VSS) capacitor c=8.46074e-17
C39 (\3\:mout VSS) capacitor c=5.4077e-17
C40 (\8\:qbint VSS) capacitor c=4.09269e-17
C41 (\2\:n30 VSS) capacitor c=4.47301e-17
C42 (\3\:CK VSS) capacitor c=4.25627e-17
C43 (\3\:qbint VSS) capacitor c=2.93131e-17
C44 (\6\:SE VSS) capacitor c=5.18592e-17
C45 (\2\:SI VSS) capacitor c=8.32905e-17
C46 (\4\:SE VSS) capacitor c=5.04202e-17
C47 (\2\:SEb VSS) capacitor c=9.63878e-17
C48 (\2\:SE VSS) capacitor c=4.28289e-17
C49 (\2\:D VSS) capacitor c=7.41421e-17
C50 (\7\:CKbb VSS) capacitor c=4.71616e-17
C51 (\11\:CKb VSS) capacitor c=3.10076e-17
C52 (\5\:CKbb VSS) capacitor c=2.73565e-17
C53 (\2\:mout VSS) capacitor c=5.48523e-17
C54 (\2\:n20 VSS) capacitor c=4.64309e-17
C55 (\4\:CKb VSS) capacitor c=2.65635e-17
C56 (\2\:CKbb VSS) capacitor c=5.28768e-17
C57 (\2\:CKb VSS) capacitor c=3.38524e-17
C58 (\7\:qbint VSS) capacitor c=4.69798e-17
C59 (\3\:n30 VSS) capacitor c=2.17608e-17
C60 (\2\:CK VSS) capacitor c=2.7812e-17
C61 (\4\:SEb VSS) capacitor c=1.24536e-17
C62 (\1\:VDD VSS) capacitor c=5.35086e-17
C63 (\8\:Db VSS) capacitor c=4.498e-17
C64 (\10\:VDD VSS) capacitor c=4.27543e-17
C65 (\8\:CKbb VSS) capacitor c=7.95722e-17
C66 (\4\:Db VSS) capacitor c=1.01784e-16
C67 (\4\:n20 VSS) capacitor c=3.48671e-17
C68 (\12\:VDD VSS) capacitor c=1.4421e-17
C69 (\6\:mout VSS) capacitor c=4.03868e-17
C70 (\4\:n30 VSS) capacitor c=7.53643e-17
C71 (\14\:VDD VSS) capacitor c=1.40891e-17
C72 (\13\:qbint VSS) capacitor c=4.52892e-17
C73 (\15\:CKb VSS) capacitor c=9.84307e-17
C74 (\16\:VDD VSS) capacitor c=4.43344e-17
C75 (\1\:Q VSS) capacitor c=5.55795e-17
C76 (\3\:VDD VSS) capacitor c=5.49465e-17
C77 (\8\:SEb VSS) capacitor c=7.8405e-17
C78 (\14\:CKbb VSS) capacitor c=4.23607e-17
C79 (\6\:Db VSS) capacitor c=7.09639e-17
C80 (\8\:n20 VSS) capacitor c=4.73779e-17
C81 (\8\:mout VSS) capacitor c=3.2959e-17
C82 (\6\:n30 VSS) capacitor c=1.07637e-16
C83 (\11\:qbint VSS) capacitor c=8.125e-17
C84 (\17\:CKb VSS) capacitor c=6.68854e-17
C85 (\3\:Q VSS) capacitor c=5.16402e-17
C86 (\2\:qbint VSS) capacitor c=1.56914e-17
C87 (\6\:CKb VSS) capacitor c=7.18416e-17
C88 (\7\:CKb VSS) capacitor c=6.54101e-17
C89 (\4\:CK VSS) capacitor c=5.65784e-17
C90 (\9\:qbint VSS) capacitor c=3.05027e-17
C91 (\10\:qbint VSS) capacitor c=3.3011e-17
C92 (\15\:qbint VSS) capacitor c=1.37711e-16
C93 (\8\:n30 VSS) capacitor c=6.60874e-17
C94 (\4\:mout VSS) capacitor c=5.07211e-17
C95 (\5\:mout VSS) capacitor c=4.60666e-17
C96 (\12\:CKb VSS) capacitor c=5.58299e-17
C97 (\13\:CKb VSS) capacitor c=8.17717e-17
C98 (\14\:CKb VSS) capacitor c=1.00261e-16
C99 (\20\:CKb VSS) capacitor c=5.20221e-17
C100 (\6\:n20 VSS) capacitor c=5.5125e-17
C101 (\7\:n20 VSS) capacitor c=5.34583e-17
C102 (\10\:CKbb VSS) capacitor c=1.36948e-16
C103 (\11\:CKbb VSS) capacitor c=5.29749e-17
C104 (\12\:CKbb VSS) capacitor c=8.52368e-17
C105 (\13\:CKbb VSS) capacitor c=1.11785e-16
C106 (\16\:CKbb VSS) capacitor c=1.81274e-17
C107 (\4\:D VSS) capacitor c=6.3317e-17
C108 (\3\:Db VSS) capacitor c=1.56626e-16
C109 (\8\:SE VSS) capacitor c=3.76099e-17
C110 (\9\:SE VSS) capacitor c=7.96144e-17
C111 (\10\:SE VSS) capacitor c=6.20285e-17
C112 (\6\:SEb VSS) capacitor c=1.00294e-16
C113 (\7\:SEb VSS) capacitor c=8.75154e-17
C114 (\5\:VDD VSS) capacitor c=2.51039e-17
C115 (\6\:VDD VSS) capacitor c=5.5946e-17
C116 (\8\:VDD VSS) capacitor c=1.47947e-17
C117 (\9\:VDD VSS) capacitor c=1.41803e-17
Rk28 (\4\:D D) resistor r=0.09047 c=0
Rk1 (\2\:Q Q) resistor r=0.3595 c=0
Rk2 (Q \4\:Q) resistor r=0.0595 c=0
Rk40 (\2\:VDD \4\:VDD) resistor r=0.5204 c=0
Rk41 (\4\:VDD \5\:VDD) resistor r=0.08755 c=0
Rk42 (\5\:VDD \6\:VDD) resistor r=0.5486 c=0
Rk43 (\6\:VDD \7\:VDD) resistor r=0.4661 c=0
Rk44 (\7\:VDD \8\:VDD) resistor r=0.04242 c=0
Rk46 (\9\:VDD VDD) resistor r=0.1074 c=0
Rk45 (\8\:VDD \9\:VDD) resistor r=0.4007 c=0
Rk47 (\5\:VDD \11\:VDD) resistor r=0.2336 c=0
Rk48 (\6\:VDD \13\:VDD) resistor r=0.07369 c=0
Rk49 (\8\:VDD \15\:VDD) resistor r=0.1024 c=0
Rk50 (\9\:VDD \17\:VDD) resistor r=0.2714 c=0
Rk3 (\4\:CK CK) resistor r=0.194 c=0
Rk33 (SE \8\:SE) resistor r=0.03328 c=0
Rk34 (\8\:SE \9\:SE) resistor r=0.1953 c=0
Rk35 (\9\:SE \10\:SE) resistor r=0.3246 c=0
Rk36 (\4\:SI SI) resistor r=0.001381 c=0
Rk51 (\2\:VSS \4\:VSS) resistor r=0.5536 c=0
Rk52 (\4\:VSS \5\:VSS) resistor r=0.08755 c=0
Rk53 (\5\:VSS \6\:VSS) resistor r=0.5577 c=0
Rk54 (\6\:VSS \7\:VSS) resistor r=0.4551 c=0
Rk55 (\5\:VSS \9\:VSS) resistor r=0.268 c=0
Rk56 (\6\:VSS \11\:VSS) resistor r=0.04329 c=0
Rk58 (\12\:VSS VSS) resistor r=0.1074 c=0
Rk57 (\7\:VSS \12\:VSS) resistor r=0.4447 c=0
Rk59 (\7\:VSS \14\:VSS) resistor r=0.07145 c=0
Rk60 (\12\:VSS \16\:VSS) resistor r=0.2929 c=0
Rk4 (\9\:qbint \10\:qbint) resistor r=0.1677 c=0
Rk5 (\10\:qbint \12\:qbint) resistor r=0.1221 c=0
Rk6 (\10\:qbint \14\:qbint) resistor r=0.2355 c=0
Rk7 (\12\:qbint \15\:qbint) resistor r=0.7734 c=0
Rk13 (\12\:CKb \13\:CKb) resistor r=0.4684 c=0
Rk14 (\13\:CKb \14\:CKb) resistor r=0.3626 c=0
Rk15 (\14\:CKb \16\:CKb) resistor r=0.6335 c=0
Rk16 (\16\:CKb \18\:CKb) resistor r=0.2774 c=0
Rk17 (\13\:CKb \19\:CKb) resistor r=0.0153 c=0
Rk18 (\14\:CKb \20\:CKb) resistor r=0.3252 c=0
Rk8 (\5\:n30 \7\:n30) resistor r=0.4351 c=0
Rk9 (\7\:n30 \8\:n30) resistor r=0.51 c=0
Rk10 (\4\:mout \5\:mout) resistor r=0.2384 c=0
Rk11 (\5\:mout \7\:mout) resistor r=0.2366 c=0
Rk12 (\5\:mout \9\:mout) resistor r=0.1276 c=0
Rk22 (\9\:CKbb \10\:CKbb) resistor r=0.5614 c=0
Rk23 (\10\:CKbb \11\:CKbb) resistor r=0.3571 c=0
Rk24 (\11\:CKbb \12\:CKbb) resistor r=0.2134 c=0
Rk25 (\12\:CKbb \13\:CKbb) resistor r=0.7606 c=0
Rk26 (\11\:CKbb \15\:CKbb) resistor r=0.2505 c=0
Rk27 (\12\:CKbb \16\:CKbb) resistor r=0.03035 c=0
Rk19 (\5\:n20 \6\:n20) resistor r=0.1344 c=0
Rk20 (\6\:n20 \7\:n20) resistor r=0.264 c=0
Rk21 (\6\:n20 \9\:n20) resistor r=0.2513 c=0
Rk29 (\2\:Db \3\:Db) resistor r=0.7183 c=0
Rk30 (\3\:Db \5\:Db) resistor r=0.4026 c=0
Rk31 (\5\:Db \7\:Db) resistor r=0.3935 c=0
Rk32 (\3\:Db \9\:Db) resistor r=0.2962 c=0
Rk37 (\5\:SEb \6\:SEb) resistor r=0.04776 c=0
Rk38 (\6\:SEb \7\:SEb) resistor r=0.5307 c=0
Rk39 (\6\:SEb \9\:SEb) resistor r=0.6657 c=0
Rl27 (\1\:D \2\:D) resistor r=171.411 c=0
Rl28 (\2\:D \3\:D) resistor r=100.257 c=0
Rl4 (\1\:CK \2\:CK) resistor r=29.5379 c=0
Rl5 (\2\:CK \3\:CK) resistor r=56.461 c=0
Rl35 (\5\:SE \6\:SE) resistor r=187.23 c=0
Rl36 (\6\:SE \7\:SE) resistor r=42.9995 c=0
Rl32 (\3\:SE \4\:SE) resistor r=37.6944 c=0
Rl29 (\1\:SE \2\:SE) resistor r=74.2328 c=0
Rl33 (\1\:SI \2\:SI) resistor r=116.54 c=0
Rl34 (\2\:SI \3\:SI) resistor r=110.771 c=0
Rl3 (\2\:qbint \4\:qbint) resistor r=68.9449 c=0
Rl2 (\2\:qbint \3\:qbint) resistor r=34.3295 c=0
Rl1 (qbint \2\:qbint) resistor r=1.2713 c=0
Rl8 (\5\:qbint \6\:qbint) resistor r=112.741 c=0
Rl10 (\6\:qbint \8\:qbint) resistor r=34.3295 c=0
Rl9 (\6\:qbint \7\:qbint) resistor r=0.5166 c=0
Rl26 (\8\:CKb \11\:CKb) resistor r=24.2328 c=0
Rl14 (\3\:CKb \4\:CKb) resistor r=47.3097 c=0
Rl11 (CKb \2\:CKb) resistor r=43.4636 c=0
Rl21 (\5\:CKb \6\:CKb) resistor r=162.261 c=0
Rl24 (\6\:CKb \9\:CKb) resistor r=96.8761 c=0
Rl23 (\7\:CKb \8\:CKb) resistor r=159.159 c=0
Rl25 (\7\:CKb \10\:CKb) resistor r=30.4507 c=0
Rl22 (\6\:CKb \7\:CKb) resistor r=181.607 c=0
Rl6 (n30 \2\:n30) resistor r=146.154 c=0
Rl7 (\2\:n30 \3\:n30) resistor r=29.5379 c=0
Rl17 (mout \2\:mout) resistor r=91.0764 c=0
Rl18 (\2\:mout \3\:mout) resistor r=29.5379 c=0
Rl20 (\6\:CKbb \7\:CKbb) resistor r=43.4636 c=0
Rl19 (\4\:CKbb \5\:CKbb) resistor r=67.9995 c=0
Rl13 (\2\:CKbb \3\:CKbb) resistor r=114.381 c=0
Rl12 (CKbb \2\:CKbb) resistor r=25.0391 c=0
Rl16 (\2\:n20 \3\:n20) resistor r=33.5406 c=0
Rl15 (n20 \2\:n20) resistor r=86.3335 c=0
Rl30 (SEb \2\:SEb) resistor r=107.398 c=0
Rl31 (\2\:SEb \3\:SEb) resistor r=153.955 c=0
Rz1 (\3\:Q \4\:Q) resistor r=75 c=0
Rz11 (\3\:VDD \4\:VDD) resistor r=7.5 c=0
Rz12 (\3\:VDD \7\:VDD) resistor r=6.25 c=0
Rz13 (\1\:VSS \2\:VSS) resistor r=75 c=0
Rz14 (\8\:VSS \9\:VSS) resistor r=75 c=0
Rz15 (\10\:VSS \11\:VSS) resistor r=75 c=0
Rz16 (\13\:VSS \14\:VSS) resistor r=75 c=0
Rz17 (\15\:VSS \16\:VSS) resistor r=75 c=0
Rz2 (\11\:qbint \12\:qbint) resistor r=75 c=0
Rz5 (\17\:CKb \18\:CKb) resistor r=75 c=0
Rz3 (\6\:n30 \7\:n30) resistor r=75 c=0
Rz4 (\8\:mout \9\:mout) resistor r=75 c=0
Rz7 (\14\:CKbb \15\:CKbb) resistor r=75 c=0
Rz6 (\8\:n20 \9\:n20) resistor r=75 c=0
Rz8 (Db \2\:Db) resistor r=75 c=0
Rz9 (\6\:Db \7\:Db) resistor r=75 c=0
Rz10 (\8\:SEb \9\:SEb) resistor r=75 c=0
Ry1 (\1\:Q \2\:Q) resistor r=20.6667 c=0
Ry11 (\1\:VDD \2\:VDD) resistor r=62 c=0
Ry12 (\10\:VDD \11\:VDD) resistor r=62 c=0
Ry13 (\12\:VDD \13\:VDD) resistor r=62 c=0
Ry14 (\14\:VDD \15\:VDD) resistor r=62 c=0
Ry15 (\16\:VDD \17\:VDD) resistor r=62 c=0
Ry16 (\3\:VSS \4\:VSS) resistor r=6.2 c=0
Ry17 (\3\:VSS \7\:VSS) resistor r=5.1667 c=0
Ry2 (\13\:qbint \14\:qbint) resistor r=62 c=0
Ry5 (\15\:CKb \16\:CKb) resistor r=62 c=0
Ry3 (\4\:n30 \5\:n30) resistor r=62 c=0
Ry4 (\6\:mout \7\:mout) resistor r=62 c=0
Ry7 (\8\:CKbb \9\:CKbb) resistor r=62 c=0
Ry6 (\4\:n20 \5\:n20) resistor r=62 c=0
Ry8 (\4\:Db \5\:Db) resistor r=62 c=0
Ry9 (\8\:Db \9\:Db) resistor r=62 c=0
Ry10 (\4\:SEb \5\:SEb) resistor r=62 c=0
Rx13 (\2\:D \4\:D) resistor r=45 c=0
Rx1 (\2\:CK \4\:CK) resistor r=45 c=0
Rx14 (\6\:SE \8\:SE) resistor r=45 c=0
Rx15 (\4\:SE \9\:SE) resistor r=45 c=0
Rx16 (\2\:SE \10\:SE) resistor r=45 c=0
Rx17 (\2\:SI \4\:SI) resistor r=45 c=0
Rx2 (\7\:qbint \9\:qbint) resistor r=45 c=0
Rx3 (qbint \15\:qbint) resistor r=45 c=0
Rx6 (\11\:CKb \12\:CKb) resistor r=45 c=0
Rx7 (\4\:CKb \19\:CKb) resistor r=45 c=0
Rx8 (\2\:CKb \20\:CKb) resistor r=45 c=0
Rx4 (\3\:n30 \8\:n30) resistor r=45 c=0
Rx5 (\2\:mout \4\:mout) resistor r=45 c=0
Rx10 (\7\:CKbb \10\:CKbb) resistor r=45 c=0
Rx11 (\2\:CKbb \13\:CKbb) resistor r=45 c=0
Rx12 (\5\:CKbb \16\:CKbb) resistor r=45 c=0
Rx9 (\2\:n20 \7\:n20) resistor r=45 c=0
Rx18 (\2\:SEb \7\:SEb) resistor r=45 c=0
mn55 (\3\:Q \3\:qbint \15\:VSS VSS) g45n1lvt w=(2.6e-07) l=4.5e-08 nf=1 \
        as=4.873e-14 ad=3.64e-14 ps=9.7e-07 pd=8e-07 nrd=1.16667 \
        nrs=1.16667 sa=1.4e-07 sb=3.18462e-07 sd=160n sca=17.5885 \
        scb=0.0172826 scc=0.00162584 m=(1)
mn20 (\17\:CKb \3\:CK \15\:VSS VSS) g45n1lvt w=(1.45e-07) l=4.5e-08 nf=1 \
        as=4.873e-14 ad=2.755e-14 ps=9.7e-07 pd=6.7e-07 nrd=1.16667 \
        nrs=1.16667 sa=4.1e-07 sb=1.9e-07 sd=160n sca=23.279 scb=0.0230742 \
        scc=0.00267719 m=(1)
mn45 (\11\:qbint \2\:n30 \13\:VSS VSS) g45n1lvt w=(1.45e-07) l=4.5e-08 \
        nf=1 as=5.19e-14 ad=2.465e-14 ps=1.6e-06 pd=6.3e-07 nrd=1.16667 \
        nrs=1.16667 sa=1.7e-07 sb=1.845e-06 sd=160n sca=23.279 \
        scb=0.0230742 scc=0.00267719 m=(1)
mn50 (n7 \8\:qbint \13\:VSS VSS) g45n1lvt w=(1.45e-07) l=4.5e-08 nf=1 \
        as=5.19e-14 ad=2.32e-14 ps=1.6e-06 pd=6.1e-07 nrd=1.16667 \
        nrs=1.16667 sa=3.65e-07 sb=1.65e-06 sd=160n sca=23.279 \
        scb=0.0230742 scc=0.00267719 m=(1)
mn51 (\6\:n30 CKb n7 VSS) g45n1lvt w=(1.45e-07) l=4.5e-08 nf=1 \
        as=2.32e-14 ad=3.335e-14 ps=6.1e-07 pd=7.5e-07 nrd=1.16667 \
        nrs=1.16667 sa=5.7e-07 sb=1.445e-06 sd=160n sca=23.279 \
        scb=0.0230742 scc=0.00267719 m=(1)
mn40 (\8\:mout CKbb \6\:n30 VSS) g45n1lvt w=(1.45e-07) l=4.5e-08 nf=1 \
        as=3.335e-14 ad=4.568e-14 ps=7.5e-07 pd=9.2e-07 nrd=1.16667 \
        nrs=1.16667 sa=8.45e-07 sb=1.17e-06 sd=160n sca=23.279 \
        scb=0.0230742 scc=0.00267719 m=(1)
mn30 (\8\:mout n20 \10\:VSS VSS) g45n1lvt w=(1.45e-07) l=4.5e-08 nf=1 \
        as=5.48e-14 ad=4.568e-14 ps=1.64e-06 pd=9.2e-07 nrd=1.16667 \
        nrs=1.16667 sa=1.205e-06 sb=8.1e-07 sd=160n sca=23.279 \
        scb=0.0230742 scc=0.00267719 m=(1)
mn36 (n5 \3\:mout \10\:VSS VSS) g45n1lvt w=(1.45e-07) l=4.5e-08 nf=1 \
        as=5.48e-14 ad=8.7e-15 ps=1.64e-06 pd=4.1e-07 nrd=1.16667 \
        nrs=1.16667 sa=1.42e-06 sb=5.95e-07 sd=160n sca=23.279 \
        scb=0.0230742 scc=0.00267719 m=(1)
mn35 (\8\:n20 \4\:CKbb n5 VSS) g45n1lvt w=(1.45e-07) l=4.5e-08 nf=1 \
        as=8.7e-15 ad=2.32e-14 ps=4.1e-07 pd=6.1e-07 nrd=1.16667 \
        nrs=1.16667 sa=1.525e-06 sb=4.9e-07 sd=160n sca=23.279 \
        scb=0.0230742 scc=0.00267719 m=(1)
mn25 (\6\:Db \10\:CKb \8\:n20 VSS) g45n1lvt w=(1.45e-07) l=4.5e-08 nf=1 \
        as=2.32e-14 ad=4.133e-14 ps=6.1e-07 pd=8.6e-07 nrd=1.16667 \
        nrs=1.16667 sa=1.73e-06 sb=2.85e-07 sd=160n sca=23.279 \
        scb=0.0230742 scc=0.00267719 m=(1)
mn21 (\14\:CKbb \9\:CKb \8\:VSS VSS) g45n1lvt w=(1.45e-07) l=4.5e-08 \
        nf=1 as=2.32e-14 ad=2.03e-14 ps=6.1e-07 pd=5.7e-07 nrd=1.16667 \
        nrs=1.16667 sa=1.4e-07 sb=1.09e-06 sd=160n sca=9.87692 \
        scb=0.0087933 scc=0.000232488 m=(1)
mn11 (n1 \3\:D \8\:VSS VSS) g45n1lvt w=(1.45e-07) l=4.5e-08 nf=1 \
        as=2.32e-14 ad=2.683e-14 ps=6.1e-07 pd=6.6e-07 nrd=1.16667 \
        nrs=1.16667 sa=3.45e-07 sb=8.85e-07 sd=160n sca=9.87692 \
        scb=0.0087933 scc=0.000232488 m=(1)
mn12 (Db \3\:SEb n1 VSS) g45n1lvt w=(1.45e-07) l=4.5e-08 nf=1 \
        as=2.683e-14 ad=2.32e-14 ps=6.6e-07 pd=6.1e-07 nrd=1.16667 \
        nrs=1.16667 sa=5.75e-07 sb=6.55e-07 sd=160n sca=9.87692 \
        scb=0.0087933 scc=0.000232488 m=(1)
mn14 (Db \3\:SE n3 VSS) g45n1lvt w=(1.45e-07) l=4.5e-08 nf=1 as=8.7e-15 \
        ad=2.32e-14 ps=4.1e-07 pd=6.1e-07 nrd=1.16667 nrs=1.16667 \
        sa=7.8e-07 sb=4.5e-07 sd=160n sca=9.87692 scb=0.0087933 \
        scc=0.000232488 m=(1)
mn13 (n3 \3\:SI \1\:VSS VSS) g45n1lvt w=(1.45e-07) l=4.5e-08 nf=1 \
        as=2.32e-14 ad=8.7e-15 ps=6.1e-07 pd=4.1e-07 nrd=1.16667 \
        nrs=1.16667 sa=8.85e-07 sb=3.45e-07 sd=160n sca=9.87692 \
        scb=0.0087933 scc=0.000232488 m=(1)
mn10 (\8\:SEb \7\:SE \1\:VSS VSS) g45n1lvt w=(1.45e-07) l=4.5e-08 nf=1 \
        as=2.32e-14 ad=2.03e-14 ps=6.1e-07 pd=5.7e-07 nrd=1.16667 \
        nrs=1.16667 sa=1.09e-06 sb=1.4e-07 sd=160n sca=9.87692 \
        scb=0.0087933 scc=0.000232488 m=(1)
mp20 (\15\:CKb \1\:CK \16\:VDD VDD) g45p1lvt w=(2.15e-07) l=4.5e-08 nf=1 \
        as=7.288e-14 ad=4.085e-14 ps=1.23e-06 pd=8.1e-07 nrd=1.16667 \
        nrs=1.16667 sa=4.1e-07 sb=1.9e-07 sd=160n sca=28.366 scb=0.0254155 \
        scc=0.00302764 m=(1)
mp45 (\13\:qbint n30 \14\:VDD VDD) g45p1lvt w=(2.15e-07) l=4.5e-08 nf=1 \
        as=9.23e-14 ad=3.01e-14 ps=1.62e-06 pd=7.1e-07 nrd=1.16667 \
        nrs=1.16667 sa=1.4e-07 sb=1.845e-06 sd=160n sca=14.5646 \
        scb=0.0142004 scc=0.000753562 m=(1)
mp50 (n8 \5\:qbint \14\:VDD VDD) g45p1lvt w=(2.15e-07) l=4.5e-08 nf=1 \
        as=9.23e-14 ad=5.482e-14 ps=1.62e-06 pd=9.4e-07 nrd=1.16667 \
        nrs=1.16667 sa=4.05e-07 sb=1.58e-06 sd=160n sca=14.5646 \
        scb=0.0142004 scc=0.000753562 m=(1)
mp51 (\4\:n30 \3\:CKbb n8 VDD) g45p1lvt w=(2.15e-07) l=4.5e-08 nf=1 \
        as=5.482e-14 ad=3.44e-14 ps=9.4e-07 pd=7.5e-07 nrd=1.16667 \
        nrs=1.16667 sa=7.05e-07 sb=1.28e-06 sd=160n sca=14.5646 \
        scb=0.0142004 scc=0.000753562 m=(1)
mp40 (\4\:n30 \3\:CKb \6\:mout VDD) g45p1lvt w=(2.15e-07) l=4.5e-08 nf=1 \
        as=3.655e-14 ad=3.44e-14 ps=7.7e-07 pd=7.5e-07 nrd=1.16667 \
        nrs=1.16667 sa=9.1e-07 sb=1.075e-06 sd=160n sca=14.5646 \
        scb=0.0142004 scc=0.000753562 m=(1)
mp30 (\6\:mout \3\:n20 \12\:VDD VDD) g45p1lvt w=(2.15e-07) l=4.5e-08 \
        nf=1 as=9.23e-14 ad=3.655e-14 ps=1.62e-06 pd=7.7e-07 nrd=1.16667 \
        nrs=1.16667 sa=1.125e-06 sb=8.6e-07 sd=160n sca=14.5646 \
        scb=0.0142004 scc=0.000753562 m=(1)
mp35 (n6 mout \12\:VDD VDD) g45p1lvt w=(2.15e-07) l=4.5e-08 nf=1 \
        as=9.23e-14 ad=1.29e-14 ps=1.62e-06 pd=5.5e-07 nrd=1.16667 \
        nrs=1.16667 sa=1.39e-06 sb=5.95e-07 sd=160n sca=14.5646 \
        scb=0.0142004 scc=0.000753562 m=(1)
mp36 (\4\:n20 \8\:CKb n6 VDD) g45p1lvt w=(2.15e-07) l=4.5e-08 nf=1 \
        as=1.29e-14 ad=3.87e-14 ps=5.5e-07 pd=7.9e-07 nrd=1.16667 \
        nrs=1.16667 sa=1.495e-06 sb=4.9e-07 sd=160n sca=14.5646 \
        scb=0.0142004 scc=0.000753562 m=(1)
mp25 (\4\:n20 \6\:CKbb \4\:Db VDD) g45p1lvt w=(2.15e-07) l=4.5e-08 nf=1 \
        as=5.697e-14 ad=3.87e-14 ps=9.6e-07 pd=7.9e-07 nrd=1.16667 \
        nrs=1.16667 sa=1.72e-06 sb=2.65e-07 sd=160n sca=14.5646 \
        scb=0.0142004 scc=0.000753562 m=(1)
mp21 (\8\:CKbb \5\:CKb \10\:VDD VDD) g45p1lvt w=(2.15e-07) l=4.5e-08 \
        nf=1 as=3.44e-14 ad=3.01e-14 ps=7.5e-07 pd=7.1e-07 nrd=1.16667 \
        nrs=1.16667 sa=1.4e-07 sb=1.09e-06 sd=160n sca=10.3256 \
        scb=0.00769229 scc=9.29431e-05 m=(1)
mp11 (n2 \1\:D \10\:VDD VDD) g45p1lvt w=(2.15e-07) l=4.5e-08 nf=1 \
        as=3.44e-14 ad=3.978e-14 ps=7.5e-07 pd=8e-07 nrd=1.16667 \
        nrs=1.16667 sa=3.45e-07 sb=8.85e-07 sd=160n sca=10.3256 \
        scb=0.00769229 scc=9.29431e-05 m=(1)
mp12 (\8\:Db \1\:SE n2 VDD) g45p1lvt w=(2.15e-07) l=4.5e-08 nf=1 \
        as=3.978e-14 ad=3.44e-14 ps=8e-07 pd=7.5e-07 nrd=1.16667 \
        nrs=1.16667 sa=5.75e-07 sb=6.55e-07 sd=160n sca=10.5972 \
        scb=0.00776431 scc=9.29552e-05 m=(1)
mp14 (\8\:Db SEb n4 VDD) g45p1lvt w=(2.15e-07) l=4.5e-08 nf=1 as=1.29e-14 \
        ad=3.44e-14 ps=5.5e-07 pd=7.5e-07 nrd=1.16667 nrs=1.16667 \
        sa=7.8e-07 sb=4.5e-07 sd=160n sca=11.4263 scb=0.00831104 \
        scc=9.35693e-05 m=(1)
mp13 (n4 \1\:SI \1\:VDD VDD) g45p1lvt w=(2.15e-07) l=4.5e-08 nf=1 \
        as=3.44e-14 ad=1.29e-14 ps=7.5e-07 pd=5.5e-07 nrd=1.16667 \
        nrs=1.16667 sa=8.85e-07 sb=3.45e-07 sd=160n sca=12.2213 \
        scb=0.00924687 scc=9.7291e-05 m=(1)
mp10 (\4\:SEb \5\:SE \1\:VDD VDD) g45p1lvt w=(2.15e-07) l=4.5e-08 nf=1 \
        as=3.44e-14 ad=3.01e-14 ps=7.5e-07 pd=7.1e-07 nrd=1.16667 \
        nrs=1.16667 sa=1.09e-06 sb=1.4e-07 sd=160n sca=16.0509 \
        scb=0.0157301 scc=0.000264062 m=(1)
ends SDFFQX1
// End of subcircuit definition.
