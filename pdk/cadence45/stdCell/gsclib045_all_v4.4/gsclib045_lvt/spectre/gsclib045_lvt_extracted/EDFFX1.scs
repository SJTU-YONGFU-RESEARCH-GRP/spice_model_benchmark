// Generated for: spectre (May  1 09:14:25 2013 )
// Library name: gsclib045_lvt
// Cell name: EDFFX1
// View name: extracted

simulator lang=spectre

subckt EDFFX1 CK D E Q QN VDD VSS
mp20 (\10\:Ckb \1\:CK \21\:VDD VDD) g45p1lvt w=(2.15e-07) l=4.5e-08 nf=1 \
        as=4.3e-14 ad=3.44e-14 ps=8.3e-07 pd=7.5e-07 nrd=1.16667 \
        nrs=1.16667 sa=1.6e-07 sb=4.15e-07 sd=160n sca=18.4817 \
        scb=0.0199259 scc=0.00053385 m=(1)
mp21 (\18\:CKbb \9\:Ckb \21\:VDD VDD) g45p1lvt w=(2.15e-07) l=4.5e-08 \
        nf=1 as=4.3e-14 ad=3.655e-14 ps=8.3e-07 pd=7.7e-07 nrd=1.16667 \
        nrs=1.16667 sa=4.05e-07 sb=1.7e-07 sd=160n sca=13.2059 \
        scb=0.0110334 scc=0.000224619 m=(1)
mp25 (\9\:n20 CKbb \5\:Db VDD) g45p1lvt w=(2.15e-07) l=4.5e-08 nf=1 \
        as=3.01e-14 ad=3.44e-14 ps=7.1e-07 pd=7.5e-07 nrd=1.16667 \
        nrs=1.16667 sa=1.4e-07 sb=1.88733e-06 sd=160n sca=13.9534 \
        scb=0.0134231 scc=0.000640578 m=(1)
mp36 (\9\:n20 \3\:Ckb net342 VDD) g45p1lvt w=(2.15e-07) l=4.5e-08 nf=1 \
        as=1.505e-14 ad=3.44e-14 ps=5.7e-07 pd=7.5e-07 nrd=1.16667 \
        nrs=1.16667 sa=3.45e-07 sb=1.79674e-06 sd=160n sca=13.9534 \
        scb=0.0134231 scc=0.000640578 m=(1)
mp35 (net342 mout \19\:VDD VDD) g45p1lvt w=(2.15e-07) l=4.5e-08 nf=1 \
        as=6.29e-14 ad=1.505e-14 ps=1.13e-06 pd=5.7e-07 nrd=1.16667 \
        nrs=1.16667 sa=4.6e-07 sb=1.74593e-06 sd=160n sca=13.9534 \
        scb=0.0134231 scc=0.000640578 m=(1)
mp30 (\4\:mout n20 \19\:VDD VDD) g45p1lvt w=(2.15e-07) l=4.5e-08 nf=1 \
        as=6.29e-14 ad=5.912e-14 ps=1.13e-06 pd=9.8e-07 nrd=1.16667 \
        nrs=1.16667 sa=7.25e-07 sb=1.62884e-06 sd=160n sca=13.9534 \
        scb=0.0134231 scc=0.000640578 m=(1)
mp40 (\8\:n30 \2\:Ckb \4\:mout VDD) g45p1lvt w=(2.15e-07) l=4.5e-08 nf=1 \
        as=5.912e-14 ad=4.73e-14 ps=9.8e-07 pd=8.7e-07 nrd=1.16667 \
        nrs=1.16667 sa=1.045e-06 sb=1.48744e-06 sd=160n sca=13.9534 \
        scb=0.0134231 scc=0.000640578 m=(1)
mp51 (\8\:n30 \7\:CKbb net362 VDD) g45p1lvt w=(2.15e-07) l=4.5e-08 nf=1 \
        as=2.687e-14 ad=4.73e-14 ps=6.8e-07 pd=8.7e-07 nrd=1.16667 \
        nrs=1.16667 sa=1.31e-06 sb=1.3536e-06 sd=160n sca=13.9534 \
        scb=0.0134231 scc=0.000640578 m=(1)
mp50 (net362 \4\:qbint \17\:VDD VDD) g45p1lvt w=(2.15e-07) l=4.5e-08 \
        nf=1 as=9.585e-14 ad=2.687e-14 ps=1.6e-06 pd=6.8e-07 nrd=1.16667 \
        nrs=1.16667 sa=1.48e-06 sb=1.1836e-06 sd=160n sca=13.9534 \
        scb=0.0134231 scc=0.000640578 m=(1)
mp1 (\16\:qbint \1\:E \3\:Db VDD) g45p1lvt w=(2.15e-07) l=4.5e-08 nf=1 \
        as=7.632e-14 ad=5.415e-14 ps=1.14e-06 pd=1e-06 nrd=1.16667 \
        nrs=1.16667 sa=1.28407e-06 sb=1.3e-06 sd=160n sca=10.718 \
        scb=0.00841932 scc=0.00013813 m=(1)
mp3 (\3\:Db Eb n1 VDD) g45p1lvt w=(2.15e-07) l=4.5e-08 nf=1 as=3.333e-14 \
        ad=7.632e-14 ps=7.4e-07 pd=1.14e-06 nrd=1.16667 nrs=1.16667 \
        sa=1.47198e-06 sb=9e-07 sd=160n sca=10.718 scb=0.00841932 \
        scc=0.00013813 m=(1)
mp2 (n1 \1\:D \15\:VDD VDD) g45p1lvt w=(2.15e-07) l=4.5e-08 nf=1 \
        as=9.245e-14 ad=3.333e-14 ps=1.29e-06 pd=7.4e-07 nrd=1.16667 \
        nrs=1.16667 sa=1.56035e-06 sb=7e-07 sd=160n sca=10.718 \
        scb=0.00841932 scc=0.00013813 m=(1)
mp0 (\8\:Eb \5\:E \15\:VDD VDD) g45p1lvt w=(2.15e-07) l=4.5e-08 nf=1 \
        as=9.245e-14 ad=4.838e-14 ps=1.29e-06 pd=8.8e-07 nrd=1.16667 \
        nrs=1.16667 sa=1.77023e-06 sb=2.25e-07 sd=160n sca=10.718 \
        scb=0.00841932 scc=0.00013813 m=(1)
mp56 (\9\:qint \5\:qbint \13\:VDD VDD) g45p1lvt w=(2.15e-07) l=4.5e-08 \
        nf=1 as=6.535e-14 ad=2.63e-14 ps=1.16e-06 pd=7.1e-07 nrd=1.16667 \
        nrs=1.16667 sa=3.75e-07 sb=1.22326e-07 sd=160n sca=46.2776 \
        scb=0.0284965 scc=0.00588421 m=(1)
C1 (D VSS) capacitor c=8.40011e-17
C2 (VDD VSS) capacitor c=3.33878e-16
C3 (CK VSS) capacitor c=6.52601e-17
C4 (E VSS) capacitor c=9.54546e-17
C5 (Q VSS) capacitor c=2.85804e-17
C6 (Ckb VSS) capacitor c=8.53126e-17
C7 (CKbb VSS) capacitor c=3.39822e-17
C8 (n20 VSS) capacitor c=5.80581e-17
C9 (Db VSS) capacitor c=1.16219e-16
C10 (mout VSS) capacitor c=6.14457e-17
C11 (n30 VSS) capacitor c=7.78665e-17
C12 (qbint VSS) capacitor c=3.10353e-17
C13 (Eb VSS) capacitor c=3.93968e-17
C14 (qint VSS) capacitor c=3.96525e-17
C15 (net342 VSS) capacitor c=1.45033e-18
C16 (net362 VSS) capacitor c=1.61612e-18
C17 (\5\:qbint VSS) capacitor c=2.26564e-17
C18 (\8\:qbint VSS) capacitor c=3.01909e-17
C19 (\5\:E VSS) capacitor c=2.14147e-17
C20 (\1\:D VSS) capacitor c=4.00153e-17
C21 (\1\:E VSS) capacitor c=4.12108e-17
C22 (\4\:qbint VSS) capacitor c=4.56902e-17
C23 (\7\:CKbb VSS) capacitor c=5.28052e-17
C24 (\2\:Ckb VSS) capacitor c=1.30479e-16
C25 (\3\:Ckb VSS) capacitor c=1.25892e-16
C26 (\9\:Ckb VSS) capacitor c=4.06667e-17
C27 (\1\:CK VSS) capacitor c=3.45373e-17
C28 (\4\:qint VSS) capacitor c=2.9831e-17
C29 (\9\:qbint VSS) capacitor c=1.80605e-17
C30 (\10\:qbint VSS) capacitor c=2.20695e-17
C31 (\7\:E VSS) capacitor c=4.45729e-17
C32 (\3\:D VSS) capacitor c=4.26495e-17
C33 (\3\:E VSS) capacitor c=4.98427e-17
C34 (\3\:Eb VSS) capacitor c=6.60266e-17
C35 (\4\:n30 VSS) capacitor c=3.14602e-17
C36 (\3\:qbint VSS) capacitor c=6.4611e-17
C37 (\5\:CKbb VSS) capacitor c=3.36549e-17
C38 (\4\:n20 VSS) capacitor c=3.15199e-17
C39 (\3\:mout VSS) capacitor c=6.94062e-17
C40 (\3\:CKbb VSS) capacitor c=8.17604e-17
C41 (\8\:Ckb VSS) capacitor c=2.93879e-17
C42 (\7\:Ckb VSS) capacitor c=2.46352e-17
C43 (\3\:CK VSS) capacitor c=3.89345e-17
C44 (\3\:qint VSS) capacitor c=1.46096e-17
C45 (\7\:qbint VSS) capacitor c=1.53631e-17
C46 (\6\:E VSS) capacitor c=2.78233e-17
C47 (\2\:D VSS) capacitor c=4.76773e-17
C48 (\2\:Eb VSS) capacitor c=7.95762e-17
C49 (\4\:E VSS) capacitor c=5.06111e-17
C50 (\2\:E VSS) capacitor c=2.09307e-17
C51 (\3\:n30 VSS) capacitor c=1.86493e-17
C52 (\8\:CKbb VSS) capacitor c=3.94217e-17
C53 (\6\:CKbb VSS) capacitor c=4.24286e-17
C54 (\3\:n20 VSS) capacitor c=1.63675e-17
C55 (\2\:mout VSS) capacitor c=4.96563e-17
C56 (\4\:CKbb VSS) capacitor c=2.57274e-17
C57 (\2\:CKbb VSS) capacitor c=4.77483e-17
C58 (\6\:Ckb VSS) capacitor c=1.78633e-17
C59 (\2\:CK VSS) capacitor c=4.27421e-17
C60 (\1\:QN VSS) capacitor c=4.07915e-17
C61 (\11\:VDD VSS) capacitor c=2.54141e-17
C62 (\9\:qint VSS) capacitor c=2.6284e-17
C63 (\13\:VDD VSS) capacitor c=7.37376e-17
C64 (\1\:Q VSS) capacitor c=7.63151e-17
C65 (\8\:Eb VSS) capacitor c=7.12624e-17
C66 (\15\:VDD VSS) capacitor c=3.47924e-17
C67 (\3\:Db VSS) capacitor c=2.44599e-16
C68 (\16\:qbint VSS) capacitor c=4.50607e-17
C69 (\17\:VDD VSS) capacitor c=2.37579e-17
C70 (\8\:n30 VSS) capacitor c=7.38632e-17
C71 (\4\:mout VSS) capacitor c=3.2421e-17
C72 (\19\:VDD VSS) capacitor c=4.80485e-17
C73 (\9\:n20 VSS) capacitor c=4.19835e-17
C74 (\5\:Db VSS) capacitor c=2.55209e-16
C75 (\18\:CKbb VSS) capacitor c=8.4515e-17
C76 (\21\:VDD VSS) capacitor c=3.26099e-17
C77 (\10\:Ckb VSS) capacitor c=4.55267e-17
C78 (\1\:VDD VSS) capacitor c=7.27798e-17
C79 (\3\:QN VSS) capacitor c=2.71516e-17
C80 (\7\:qint VSS) capacitor c=2.17196e-17
C81 (\3\:Q VSS) capacitor c=4.9349e-17
C82 (\4\:Eb VSS) capacitor c=4.39085e-17
C83 (\12\:qbint VSS) capacitor c=2.25099e-16
C84 (\5\:n30 VSS) capacitor c=5.56679e-17
C85 (\8\:mout VSS) capacitor c=7.34156e-17
C86 (\7\:n20 VSS) capacitor c=3.82446e-17
C87 (\7\:Db VSS) capacitor c=9.57513e-17
C88 (\13\:CKbb VSS) capacitor c=9.15059e-17
C89 (\13\:Ckb VSS) capacitor c=1.85299e-17
C90 (\2\:n20 VSS) capacitor c=2.36768e-17
C91 (\4\:Ckb VSS) capacitor c=7.31788e-17
C92 (\5\:Ckb VSS) capacitor c=3.51512e-17
C93 (\2\:qbint VSS) capacitor c=2.74292e-17
C94 (\2\:n30 VSS) capacitor c=2.14216e-17
C95 (\6\:qbint VSS) capacitor c=1.12921e-17
C96 (\2\:qint VSS) capacitor c=5.72301e-18
C97 (\12\:Ckb VSS) capacitor c=4.69547e-17
C98 (\15\:Ckb VSS) capacitor c=5.08168e-17
C99 (\4\:CK VSS) capacitor c=4.65406e-17
C100 (\5\:n20 VSS) capacitor c=4.96788e-17
C101 (\6\:n20 VSS) capacitor c=5.4232e-17
C102 (\6\:mout VSS) capacitor c=6.21278e-17
C103 (\7\:mout VSS) capacitor c=5.70407e-17
C104 (\9\:CKbb VSS) capacitor c=2.53859e-17
C105 (\10\:CKbb VSS) capacitor c=1.25505e-16
C106 (\12\:CKbb VSS) capacitor c=6.5403e-17
C107 (\15\:CKbb VSS) capacitor c=4.9673e-17
C108 (\16\:CKbb VSS) capacitor c=1.01595e-16
C109 (\17\:CKbb VSS) capacitor c=7.37441e-17
C110 (\7\:n30 VSS) capacitor c=5.79298e-17
C111 (\10\:n30 VSS) capacitor c=4.12398e-17
C112 (\4\:D VSS) capacitor c=5.11124e-17
C113 (\8\:E VSS) capacitor c=6.39419e-17
C114 (\9\:E VSS) capacitor c=1.07044e-16
C115 (\10\:E VSS) capacitor c=6.85673e-17
C116 (\6\:Eb VSS) capacitor c=1.01877e-16
C117 (\7\:Eb VSS) capacitor c=1.09241e-16
C118 (\11\:qbint VSS) capacitor c=1.85883e-16
C119 (\14\:qbint VSS) capacitor c=5.74703e-17
C120 (\15\:qbint VSS) capacitor c=3.95398e-17
C121 (\5\:qint VSS) capacitor c=1.32297e-17
C122 (\6\:qint VSS) capacitor c=1.56262e-17
C123 (\3\:VDD VSS) capacitor c=3.59859e-18
C124 (\4\:VDD VSS) capacitor c=1.82786e-17
C125 (\5\:VDD VSS) capacitor c=1.73197e-17
C126 (\7\:VDD VSS) capacitor c=5.08102e-17
C127 (\8\:VDD VSS) capacitor c=2.95524e-17
C128 (\10\:VDD VSS) capacitor c=1.67997e-17
Rk25 (\4\:D D) resistor r=0.02915 c=0
Rk42 (\2\:QN QN) resistor r=0.3009 c=0
Rk43 (QN \4\:QN) resistor r=0.05391 c=0
Rk59 (\2\:VSS \3\:VSS) resistor r=0.06245 c=0
Rk60 (\3\:VSS \4\:VSS) resistor r=0.1224 c=0
Rk61 (\4\:VSS \5\:VSS) resistor r=0.5709 c=0
Rk62 (\5\:VSS \6\:VSS) resistor r=0.04491 c=0
Rk63 (\6\:VSS \7\:VSS) resistor r=0.4759 c=0
Rk64 (\7\:VSS \8\:VSS) resistor r=0.5108 c=0
Rk65 (\8\:VSS \9\:VSS) resistor r=0.2153 c=0
Rk67 (\10\:VSS VSS) resistor r=0.1474 c=0
Rk66 (\9\:VSS \10\:VSS) resistor r=0.4032 c=0
Rk68 (\3\:VSS \12\:VSS) resistor r=0.07415 c=0
Rk69 (\4\:VSS \14\:VSS) resistor r=0.07415 c=0
Rk70 (\5\:VSS \16\:VSS) resistor r=0.1219 c=0
Rk71 (\7\:VSS \18\:VSS) resistor r=0.3279 c=0
Rk72 (\8\:VSS \20\:VSS) resistor r=0.102 c=0
Rk73 (\10\:VSS \22\:VSS) resistor r=0.2812 c=0
Rk44 (\2\:VDD \3\:VDD) resistor r=0.05493 c=0
Rk45 (\3\:VDD \4\:VDD) resistor r=0.1976 c=0
Rk46 (\4\:VDD \5\:VDD) resistor r=0.5033 c=0
Rk47 (\5\:VDD \6\:VDD) resistor r=0.04491 c=0
Rk48 (\6\:VDD \7\:VDD) resistor r=0.506 c=0
Rk49 (\7\:VDD \8\:VDD) resistor r=0.5108 c=0
Rk50 (\8\:VDD \9\:VDD) resistor r=0.1852 c=0
Rk52 (\10\:VDD VDD) resistor r=0.1474 c=0
Rk51 (\9\:VDD \10\:VDD) resistor r=0.4032 c=0
Rk53 (\3\:VDD \12\:VDD) resistor r=0.3034 c=0
Rk54 (\4\:VDD \14\:VDD) resistor r=0.3955 c=0
Rk55 (\5\:VDD \16\:VDD) resistor r=0.2525 c=0
Rk56 (\7\:VDD \18\:VDD) resistor r=0.102 c=0
Rk57 (\8\:VDD \20\:VDD) resistor r=0.2247 c=0
Rk58 (\10\:VDD \22\:VDD) resistor r=0.2724 c=0
Rk4 (\4\:CK CK) resistor r=0.1913 c=0
Rk28 (\9\:E E) resistor r=0.591 c=0
Rk26 (\8\:E \9\:E) resistor r=0.298 c=0
Rk27 (\9\:E \10\:E) resistor r=0.4474 c=0
Rk29 (E \11\:E) resistor r=0.005986 c=0
Rk33 (Q \2\:Q) resistor r=0.1437 c=0
Rk34 (Q \4\:Q) resistor r=0.1526 c=0
Rk1 (\11\:Ckb \12\:Ckb) resistor r=0.3871 c=0
Rk2 (\12\:Ckb \14\:Ckb) resistor r=0.1224 c=0
Rk3 (\12\:Ckb \15\:Ckb) resistor r=0.2161 c=0
Rk11 (\9\:CKbb \10\:CKbb) resistor r=0.02782 c=0
Rk12 (\10\:CKbb \11\:CKbb) resistor r=0.881 c=0
Rk13 (\11\:CKbb \12\:CKbb) resistor r=0.2309 c=0
Rk14 (\12\:CKbb \14\:CKbb) resistor r=0.2964 c=0
Rk15 (\10\:CKbb \15\:CKbb) resistor r=0.2216 c=0
Rk16 (\11\:CKbb \16\:CKbb) resistor r=0.0153 c=0
Rk17 (\12\:CKbb \17\:CKbb) resistor r=0.3653 c=0
Rk18 (\14\:CKbb \19\:CKbb) resistor r=0.5279 c=0
Rk5 (\5\:n20 \6\:n20) resistor r=0.2834 c=0
Rk6 (\6\:n20 \8\:n20) resistor r=0.1271 c=0
Rk7 (\6\:n20 \10\:n20) resistor r=0.2466 c=0
Rk22 (\2\:Db \4\:Db) resistor r=0.6236 c=0
Rk23 (\4\:Db \6\:Db) resistor r=1.6561 c=0
Rk24 (\6\:Db \8\:Db) resistor r=0.5727 c=0
Rk8 (\5\:mout \6\:mout) resistor r=0.1508 c=0
Rk9 (\6\:mout \7\:mout) resistor r=0.2802 c=0
Rk10 (\6\:mout \9\:mout) resistor r=0.3002 c=0
Rk19 (\6\:n30 \7\:n30) resistor r=0.2364 c=0
Rk20 (\7\:n30 \9\:n30) resistor r=0.4212 c=0
Rk21 (\7\:n30 \10\:n30) resistor r=0.1677 c=0
Rk35 (\11\:qbint \13\:qbint) resistor r=1.6067 c=0
Rk36 (\13\:qbint \14\:qbint) resistor r=0.3925 c=0
Rk37 (\14\:qbint \15\:qbint) resistor r=0.1573 c=0
Rk38 (\14\:qbint \17\:qbint) resistor r=0.09343 c=0
Rk30 (\5\:Eb \6\:Eb) resistor r=0.2046 c=0
Rk31 (\6\:Eb \7\:Eb) resistor r=0.6985 c=0
Rk32 (\6\:Eb \9\:Eb) resistor r=0.4704 c=0
Rk39 (\5\:qint \6\:qint) resistor r=0.05315 c=0
Rk40 (\6\:qint \8\:qint) resistor r=0.09647 c=0
Rk41 (\6\:qint \10\:qint) resistor r=0.1264 c=0
Rl30 (\1\:D \2\:D) resistor r=106.461 c=0
Rl31 (\2\:D \3\:D) resistor r=77.6149 c=0
Rl1 (\1\:CK \2\:CK) resistor r=95.3867 c=0
Rl2 (\2\:CK \3\:CK) resistor r=99.2328 c=0
Rl32 (\5\:E \6\:E) resistor r=29.5379 c=0
Rl33 (\6\:E \7\:E) resistor r=154.538 c=0
Rl27 (\3\:E \4\:E) resistor r=89.8977 c=0
Rl26 (\1\:E \2\:E) resistor r=33.8482 c=0
Rl13 (\2\:Ckb \3\:Ckb) resistor r=389.516 c=0
Rl12 (Ckb \2\:Ckb) resistor r=237.593 c=0
Rl17 (\6\:Ckb \7\:Ckb) resistor r=35.7134 c=0
Rl14 (\3\:Ckb \4\:Ckb) resistor r=174.543 c=0
Rl18 (\4\:Ckb \8\:Ckb) resistor r=30.4507 c=0
Rl19 (\5\:Ckb \9\:Ckb) resistor r=135.772 c=0
Rl16 (\5\:Ckb \6\:Ckb) resistor r=15.7162 c=0
Rl15 (\4\:Ckb \5\:Ckb) resistor r=214.3 c=0
Rl11 (\7\:CKbb \8\:CKbb) resistor r=29.5379 c=0
Rl10 (\5\:CKbb \6\:CKbb) resistor r=39.1533 c=0
Rl4 (\3\:CKbb \4\:CKbb) resistor r=58.8482 c=0
Rl3 (CKbb \2\:CKbb) resistor r=62.9746 c=0
Rl7 (n20 \2\:n20) resistor r=102.726 c=0
Rl9 (\2\:n20 \4\:n20) resistor r=37.3411 c=0
Rl8 (\2\:n20 \3\:n20) resistor r=1.2301 c=0
Rl5 (mout \2\:mout) resistor r=24.2328 c=0
Rl6 (\2\:mout \3\:mout) resistor r=97.3098 c=0
Rl23 (n30 \2\:n30) resistor r=107.406 c=0
Rl25 (\2\:n30 \4\:n30) resistor r=34.3295 c=0
Rl24 (\2\:n30 \3\:n30) resistor r=1.2666 c=0
Rl36 (\7\:qbint \8\:qbint) resistor r=56.5101 c=0
Rl38 (\7\:qbint \10\:qbint) resistor r=24.5191 c=0
Rl22 (\2\:qbint \4\:qbint) resistor r=34.3295 c=0
Rl21 (\2\:qbint \3\:qbint) resistor r=107.406 c=0
Rl20 (qbint \2\:qbint) resistor r=11.5001 c=0
Rl34 (\5\:qbint \6\:qbint) resistor r=53.0797 c=0
Rl37 (\6\:qbint \9\:qbint) resistor r=35.772 c=0
Rl35 (\6\:qbint \7\:qbint) resistor r=35.7515 c=0
Rl28 (Eb \2\:Eb) resistor r=106.925 c=0
Rl29 (\2\:Eb \3\:Eb) resistor r=201.477 c=0
Rl39 (qint \2\:qint) resistor r=60.772 c=0
Rl41 (\2\:qint \4\:qint) resistor r=28.0797 c=0
Rl40 (\2\:qint \3\:qint) resistor r=34.9887 c=0
Rz12 (\3\:QN \4\:QN) resistor r=75 c=0
Rz16 (\11\:VSS \12\:VSS) resistor r=75 c=0
Rz17 (\13\:VSS \14\:VSS) resistor r=75 c=0
Rz18 (\15\:VSS \16\:VSS) resistor r=75 c=0
Rz19 (\17\:VSS \18\:VSS) resistor r=75 c=0
Rz20 (\19\:VSS \20\:VSS) resistor r=75 c=0
Rz21 (\21\:VSS \22\:VSS) resistor r=75 c=0
Rz13 (\1\:VDD \2\:VDD) resistor r=18.75 c=0
Rz14 (\1\:VDD \6\:VDD) resistor r=6.25 c=0
Rz15 (\1\:VDD \9\:VDD) resistor r=6.25 c=0
Rz9 (\3\:Q \4\:Q) resistor r=75 c=0
Rz1 (\13\:Ckb \14\:Ckb) resistor r=75 c=0
Rz4 (\13\:CKbb \14\:CKbb) resistor r=75 c=0
Rz2 (\7\:n20 \8\:n20) resistor r=75 c=0
Rz6 (Db \2\:Db) resistor r=75 c=0
Rz7 (\7\:Db \8\:Db) resistor r=75 c=0
Rz3 (\8\:mout \9\:mout) resistor r=75 c=0
Rz5 (\5\:n30 \6\:n30) resistor r=75 c=0
Rz10 (\12\:qbint \13\:qbint) resistor r=75 c=0
Rz8 (\4\:Eb \5\:Eb) resistor r=75 c=0
Rz11 (\7\:qint \8\:qint) resistor r=75 c=0
Ry12 (\1\:QN \2\:QN) resistor r=20.6667 c=0
Ry19 (\1\:VSS \2\:VSS) resistor r=15.5 c=0
Ry20 (\1\:VSS \6\:VSS) resistor r=5.1667 c=0
Ry21 (\1\:VSS \9\:VSS) resistor r=5.1667 c=0
Ry13 (\11\:VDD \12\:VDD) resistor r=62 c=0
Ry14 (\13\:VDD \14\:VDD) resistor r=20.6667 c=0
Ry15 (\15\:VDD \16\:VDD) resistor r=62 c=0
Ry16 (\17\:VDD \18\:VDD) resistor r=62 c=0
Ry17 (\19\:VDD \20\:VDD) resistor r=62 c=0
Ry18 (\21\:VDD \22\:VDD) resistor r=62 c=0
Ry9 (\1\:Q \2\:Q) resistor r=20.6667 c=0
Ry1 (\10\:Ckb \11\:Ckb) resistor r=62 c=0
Ry4 (\18\:CKbb \19\:CKbb) resistor r=62 c=0
Ry2 (\9\:n20 \10\:n20) resistor r=62 c=0
Ry6 (\3\:Db \4\:Db) resistor r=62 c=0
Ry7 (\5\:Db \6\:Db) resistor r=62 c=0
Ry3 (\4\:mout \5\:mout) resistor r=62 c=0
Ry5 (\8\:n30 \9\:n30) resistor r=62 c=0
Ry10 (\16\:qbint \17\:qbint) resistor r=62 c=0
Ry8 (\8\:Eb \9\:Eb) resistor r=62 c=0
Ry11 (\9\:qint \10\:qint) resistor r=62 c=0
Rx10 (\2\:D \4\:D) resistor r=45 c=0
Rx2 (\2\:CK \4\:CK) resistor r=45 c=0
Rx11 (\4\:E \8\:E) resistor r=45 c=0
Rx12 (\2\:E \10\:E) resistor r=45 c=0
Rx13 (\6\:E \11\:E) resistor r=45 c=0
Rx1 (\6\:Ckb \15\:Ckb) resistor r=45 c=0
Rx5 (\6\:CKbb \9\:CKbb) resistor r=45 c=0
Rx6 (\8\:CKbb \15\:CKbb) resistor r=45 c=0
Rx7 (\4\:CKbb \16\:CKbb) resistor r=45 c=0
Rx8 (\2\:CKbb \17\:CKbb) resistor r=45 c=0
Rx3 (\3\:n20 \5\:n20) resistor r=45 c=0
Rx4 (\2\:mout \7\:mout) resistor r=45 c=0
Rx9 (\3\:n30 \10\:n30) resistor r=45 c=0
Rx15 (\7\:qbint \11\:qbint) resistor r=45 c=0
Rx16 (qbint \15\:qbint) resistor r=45 c=0
Rx14 (\2\:Eb \7\:Eb) resistor r=45 c=0
Rx17 (\3\:qint \5\:qint) resistor r=45 c=0
mn20 (\13\:Ckb \3\:CK \21\:VSS VSS) g45n1lvt w=(1.45e-07) l=4.5e-08 nf=1 \
        as=2.32e-14 ad=2.32e-14 ps=6.1e-07 pd=6.1e-07 nrd=1.16667 \
        nrs=1.16667 sa=1.6e-07 sb=4.15e-07 sd=160n sca=10.9472 \
        scb=0.0104991 scc=0.000356047 m=(1)
mn21 (\13\:CKbb \7\:Ckb \21\:VSS VSS) g45n1lvt w=(1.45e-07) l=4.5e-08 \
        nf=1 as=2.32e-14 ad=3.045e-14 ps=6.1e-07 pd=7.1e-07 nrd=1.16667 \
        nrs=1.16667 sa=3.65e-07 sb=2.1e-07 sd=160n sca=10.9472 \
        scb=0.0104991 scc=0.000356047 m=(1)
mn25 (\7\:Db \8\:Ckb \7\:n20 VSS) g45n1lvt w=(1.45e-07) l=4.5e-08 nf=1 \
        as=2.827e-14 ad=4.132e-14 ps=6.8e-07 pd=8.6e-07 nrd=1.16667 \
        nrs=1.16667 sa=2.85e-07 sb=1.89034e-06 sd=160n sca=23.279 \
        scb=0.0230742 scc=0.00267719 m=(1)
mn36 (\7\:n20 \3\:CKbb net411 VSS) g45n1lvt w=(1.45e-07) l=4.5e-08 nf=1 \
        as=9.42e-15 ad=2.827e-14 ps=4.2e-07 pd=6.8e-07 nrd=1.16667 \
        nrs=1.16667 sa=5.25e-07 sb=1.79103e-06 sd=160n sca=23.279 \
        scb=0.0230742 scc=0.00267719 m=(1)
mn35 (net411 \3\:mout \19\:VSS VSS) g45n1lvt w=(1.45e-07) l=4.5e-08 nf=1 \
        as=8.41e-14 ad=9.43e-15 ps=1.6e-06 pd=4.2e-07 nrd=1.16667 \
        nrs=1.16667 sa=6.35e-07 sb=1.74552e-06 sd=160n sca=23.279 \
        scb=0.0230742 scc=0.00267719 m=(1)
mn30 (\8\:mout \4\:n20 \19\:VSS VSS) g45n1lvt w=(1.45e-07) l=4.5e-08 \
        nf=1 as=8.41e-14 ad=3.988e-14 ps=1.6e-06 pd=8.4e-07 nrd=1.16667 \
        nrs=1.16667 sa=9e-07 sb=1.63586e-06 sd=160n sca=23.279 \
        scb=0.0230742 scc=0.00267719 m=(1)
mn40 (\8\:mout \5\:CKbb \5\:n30 VSS) g45n1lvt w=(1.45e-07) l=4.5e-08 nf=1 \
        as=3.988e-14 ad=3.988e-14 ps=8.4e-07 pd=8.4e-07 nrd=1.16667 \
        nrs=1.16667 sa=1.22e-06 sb=1.50345e-06 sd=160n sca=23.279 \
        scb=0.0230742 scc=0.00267719 m=(1)
mn51 (\5\:n30 Ckb net415 VSS) g45n1lvt w=(1.45e-07) l=4.5e-08 nf=1 \
        as=1.015e-14 ad=3.988e-14 ps=4.3e-07 pd=8.4e-07 nrd=1.16667 \
        nrs=1.16667 sa=1.54e-06 sb=1.27138e-06 sd=160n sca=23.279 \
        scb=0.0230742 scc=0.00267719 m=(1)
mn50 (net415 \3\:qbint \17\:VSS VSS) g45n1lvt w=(1.45e-07) l=4.5e-08 \
        nf=1 as=4.03e-14 ad=1.015e-14 ps=8.5e-07 pd=4.3e-07 nrd=1.16667 \
        nrs=1.16667 sa=1.655e-06 sb=1.15638e-06 sd=160n sca=23.279 \
        scb=0.0230742 scc=0.00267719 m=(1)
mn1 (\12\:qbint \3\:Eb Db VSS) g45n1lvt w=(1.45e-07) l=4.5e-08 nf=1 \
        as=4.205e-14 ad=4.877e-14 ps=8.7e-07 pd=1e-06 nrd=1.16667 \
        nrs=1.16667 sa=1.37103e-06 sb=1.11e-06 sd=160n sca=15.2405 \
        scb=0.016218 scc=0.00104639 m=(1)
mn3 (Db \3\:E n0 VSS) g45n1lvt w=(1.45e-07) l=4.5e-08 nf=1 as=1.667e-14 \
        ad=4.205e-14 ps=5.2e-07 pd=8.7e-07 nrd=1.16667 nrs=1.16667 \
        sa=1.50966e-06 sb=7.75e-07 sd=160n sca=15.2405 scb=0.016218 \
        scc=0.00104639 m=(1)
mn2 (n0 \3\:D \15\:VSS VSS) g45n1lvt w=(1.45e-07) l=4.5e-08 nf=1 \
        as=9.775e-14 ad=1.668e-14 ps=1.74e-06 pd=5.2e-07 nrd=1.16667 \
        nrs=1.16667 sa=1.57586e-06 sb=6.15e-07 sd=160n sca=15.2405 \
        scb=0.016218 scc=0.00104639 m=(1)
mn0 (\4\:Eb \7\:E \15\:VSS VSS) g45n1lvt w=(1.45e-07) l=4.5e-08 nf=1 \
        as=9.775e-14 ad=2.03e-14 ps=1.74e-06 pd=5.7e-07 nrd=1.16667 \
        nrs=1.16667 sa=1.77241e-06 sb=1.4e-07 sd=160n sca=15.2405 \
        scb=0.016218 scc=0.00104639 m=(1)
mn56 (\7\:qint \9\:qbint \13\:VSS VSS) g45n1lvt w=(1.45e-07) l=4.5e-08 \
        nf=1 as=6.545e-14 ad=2.03e-14 ps=1.73e-06 pd=5.7e-07 nrd=1.16667 \
        nrs=1.16667 sa=3.55e-07 sb=1.4e-07 sd=160n sca=23.279 \
        scb=0.0230742 scc=0.00267719 m=(1)
mn45 (\12\:qbint \4\:n30 \17\:VSS VSS) g45n1lvt w=(2.05e-07) l=4.5e-08 \
        nf=1 as=4.03e-14 ad=4.877e-14 ps=8.5e-07 pd=1e-06 nrd=1.16667 \
        nrs=1.16667 sa=1.39902e-06 sb=1.05488e-06 sd=160n sca=19.867 \
        scb=0.0198061 scc=0.00201945 m=(1)
mn55 (\3\:Q \10\:qbint \13\:VSS VSS) g45n1lvt w=(2.6e-07) l=4.5e-08 nf=1 \
        as=6.545e-14 ad=4.16e-14 ps=1.73e-06 pd=8.4e-07 nrd=1.16667 \
        nrs=1.16667 sa=1.6e-07 sb=2.31058e-07 sd=160n sca=17.5885 \
        scb=0.0172826 scc=0.00162584 m=(1)
mn57 (\3\:QN \4\:qint \11\:VSS VSS) g45n1lvt w=(2.6e-07) l=4.5e-08 nf=1 \
        as=5.04e-14 ad=3.64e-14 ps=1.5e-06 pd=8e-07 nrd=1.16667 \
        nrs=1.16667 sa=1e-07 sb=1.4e-07 sd=160n sca=17.5885 scb=0.0172826 \
        scc=0.00162584 m=(1)
mp45 (\16\:qbint n30 \17\:VDD VDD) g45p1lvt w=(3.1e-07) l=4.5e-08 nf=1 \
        as=9.585e-14 ad=5.415e-14 ps=1.6e-06 pd=1e-06 nrd=1.16667 \
        nrs=1.16667 sa=1.26234e-06 sb=1.1075e-06 sd=160n sca=12.6932 \
        scb=0.0113709 scc=0.000458931 m=(1)
mp55 (\1\:Q \8\:qbint \13\:VDD VDD) g45p1lvt w=(3.9e-07) l=4.5e-08 nf=1 \
        as=6.535e-14 ad=5.46e-14 ps=1.16e-06 pd=1.06e-06 nrd=1.16667 \
        nrs=1.16667 sa=1.4e-07 sb=2.59808e-07 sd=160n sca=30.5009 \
        scb=0.0202006 scc=0.00336097 m=(1)
mp57 (\1\:QN qint \11\:VDD VDD) g45p1lvt w=(3.9e-07) l=4.5e-08 nf=1 \
        as=4.56e-14 ad=6.24e-14 ps=1.09e-06 pd=1.1e-06 nrd=1.16667 \
        nrs=1.16667 sa=1.16923e-07 sb=1.6e-07 sd=160n sca=34.4399 \
        scb=0.0250891 scc=0.0034155 m=(1)
ends EDFFX1
// End of subcircuit definition.
