// Generated for: spectre (May  1 09:14:22 2013 )
// Library name: gsclib045_lvt
// Cell name: EDFFTRX2
// View name: extracted

simulator lang=spectre

subckt EDFFTRX2 CK D E Q QN RN VDD VSS
mp1 (\5\:Db \1\:D \28\:VDD VDD) g45p1lvt w=(2.15e-07) l=4.5e-08 nf=1 \
        as=1.091e-13 ad=3.01e-14 ps=1.9e-06 pd=7.1e-07 nrd=1.16667 \
        nrs=1.16667 sa=1.4e-07 sb=4.05e-07 sd=160n sca=47.4597 \
        scb=0.0295856 scc=0.00588691 m=(1)
mp0 (\7\:Eb \1\:E \28\:VDD VDD) g45p1lvt w=(2.15e-07) l=4.5e-08 nf=1 \
        as=1.091e-13 ad=3.01e-14 ps=1.9e-06 pd=7.1e-07 nrd=1.16667 \
        nrs=1.16667 sa=4.05e-07 sb=1.4e-07 sd=160n sca=46.1185 \
        scb=0.028424 scc=0.00588418 m=(1)
mp7 (\9\:Dp Db \3\:n3 VDD) g45p1lvt w=(2.15e-07) l=4.5e-08 nf=1 \
        as=6.558e-14 ad=3.655e-14 ps=1.04e-06 pd=7.7e-07 nrd=1.16667 \
        nrs=1.16667 sa=1.7e-07 sb=4.9e-07 sd=160n sca=45.7906 \
        scb=0.0283307 scc=0.00588417 m=(1)
mp6 (\12\:Dp \4\:E \3\:n3 VDD) g45p1lvt w=(2.15e-07) l=4.5e-08 nf=1 \
        as=6.558e-14 ad=3.01e-14 ps=1.04e-06 pd=7.1e-07 nrd=1.16667 \
        nrs=1.16667 sa=5.2e-07 sb=1.4e-07 sd=160n sca=45.7906 \
        scb=0.0283307 scc=0.00588417 m=(1)
mp4 (n3 Eb \3\:n2 VDD) g45p1lvt w=(2.15e-07) l=4.5e-08 nf=1 as=3.01e-14 \
        ad=3.44e-14 ps=7.1e-07 pd=7.5e-07 nrd=1.16667 nrs=1.16667 \
        sa=1.4e-07 sb=8.1e-07 sd=160n sca=39.8855 scb=0.0273598 \
        scc=0.00519679 m=(1)
mp5 (n3 \2\:qbint n2 VDD) g45p1lvt w=(2.15e-07) l=4.5e-08 nf=1 \
        as=3.44e-14 ad=3.44e-14 ps=7.5e-07 pd=7.5e-07 nrd=1.16667 \
        nrs=1.16667 sa=3.45e-07 sb=6.05e-07 sd=160n sca=39.8855 \
        scb=0.0273598 scc=0.00519679 m=(1)
mp3 (n2 RNb \26\:VDD VDD) g45p1lvt w=(2.15e-07) l=4.5e-08 nf=1 \
        as=7.128e-14 ad=3.44e-14 ps=1.93e-06 pd=7.5e-07 nrd=1.16667 \
        nrs=1.16667 sa=5.5e-07 sb=4e-07 sd=160n sca=39.8855 scb=0.0273598 \
        scc=0.00519679 m=(1)
mp2 (\4\:RNb \1\:RN \26\:VDD VDD) g45p1lvt w=(2.15e-07) l=4.5e-08 nf=1 \
        as=7.128e-14 ad=3.87e-14 ps=1.93e-06 pd=7.9e-07 nrd=1.16667 \
        nrs=1.16667 sa=7.7e-07 sb=1.8e-07 sd=160n sca=39.8855 \
        scb=0.0273598 scc=0.00519679 m=(1)
mp21 (\11\:CKbb CKb \24\:VDD VDD) g45p1lvt w=(2.15e-07) l=4.5e-08 nf=1 \
        as=6.14e-14 ad=3.01e-14 ps=1.7e-06 pd=7.1e-07 nrd=1.16667 \
        nrs=1.16667 sa=1.4e-07 sb=2e-06 sd=160n sca=17.9376 scb=0.0177709 \
        scc=0.00142383 m=(1)
mp25 (n22 Dp \24\:VDD VDD) g45p1lvt w=(2.15e-07) l=4.5e-08 nf=1 \
        as=6.14e-14 ad=6.773e-14 ps=1.7e-06 pd=1.06e-06 nrd=1.16667 \
        nrs=1.16667 sa=3.35e-07 sb=2e-06 sd=160n sca=17.9376 scb=0.0177709 \
        scc=0.00142383 m=(1)
mp26 (\7\:n20 \3\:CKbb n22 VDD) g45p1lvt w=(2.15e-07) l=4.5e-08 nf=1 \
        as=6.773e-14 ad=6.558e-14 ps=1.06e-06 pd=1.04e-06 nrd=1.16667 \
        nrs=1.16667 sa=6.95e-07 sb=1.97e-06 sd=160n sca=17.9376 \
        scb=0.0177709 scc=0.00142383 m=(1)
mp36 (\7\:n20 \6\:CKb net427 VDD) g45p1lvt w=(2.15e-07) l=4.5e-08 nf=1 \
        as=1.29e-14 ad=6.558e-14 ps=5.5e-07 pd=1.04e-06 nrd=1.16667 \
        nrs=1.16667 sa=1.045e-06 sb=1.62e-06 sd=160n sca=17.9376 \
        scb=0.0177709 scc=0.00142383 m=(1)
mp35 (net427 mout \22\:VDD VDD) g45p1lvt w=(2.15e-07) l=4.5e-08 nf=1 \
        as=9.71e-14 ad=1.29e-14 ps=1.7e-06 pd=5.5e-07 nrd=1.16667 \
        nrs=1.16667 sa=1.15e-06 sb=1.515e-06 sd=160n sca=17.9376 \
        scb=0.0177709 scc=0.00142383 m=(1)
mp30 (\8\:mout n20 \22\:VDD VDD) g45p1lvt w=(2.15e-07) l=4.5e-08 nf=1 \
        as=9.71e-14 ad=5.697e-14 ps=1.7e-06 pd=9.6e-07 nrd=1.16667 \
        nrs=1.16667 sa=1.415e-06 sb=1.25e-06 sd=160n sca=17.9376 \
        scb=0.0177709 scc=0.00142383 m=(1)
mp40 (\7\:n30 \8\:CKb \8\:mout VDD) g45p1lvt w=(2.15e-07) l=4.5e-08 nf=1 \
        as=5.697e-14 ad=7.203e-14 ps=9.6e-07 pd=1.1e-06 nrd=1.16667 \
        nrs=1.16667 sa=1.725e-06 sb=9.4e-07 sd=160n sca=17.9376 \
        scb=0.0177709 scc=0.00142383 m=(1)
mp51 (\7\:n30 \4\:CKbb net411 VDD) g45p1lvt w=(2.15e-07) l=4.5e-08 nf=1 \
        as=3.225e-14 ad=7.203e-14 ps=7.3e-07 pd=1.1e-06 nrd=1.16667 \
        nrs=1.16667 sa=2e-06 sb=5.6e-07 sd=160n sca=17.9376 scb=0.0177709 \
        scc=0.00142383 m=(1)
mp50 (net411 \4\:qbint \20\:VDD VDD) g45p1lvt w=(2.15e-07) l=4.5e-08 \
        nf=1 as=6.48e-14 ad=3.225e-14 ps=1.22e-06 pd=7.3e-07 nrd=1.16667 \
        nrs=1.16667 sa=2e-06 sb=3.65e-07 sd=160n sca=17.9376 scb=0.0177709 \
        scc=0.00142383 m=(1)
mp20 (\19\:CKb \3\:CK \3\:VDD VDD) g45p1lvt w=(2.15e-07) l=4.5e-08 nf=1 \
        as=1.08e-13 ad=3.83e-14 ps=1.72e-06 pd=9.1e-07 nrd=1.16667 \
        nrs=1.16667 sa=1.7814e-07 sb=1.285e-06 sd=160n sca=17.9376 \
        scb=0.0177709 scc=0.00142383 m=(1)
mp56 (\8\:qint \13\:qbint \3\:VDD VDD) g45p1lvt w=(2.15e-07) l=4.5e-08 \
        nf=1 as=7.015e-14 ad=3.01e-14 ps=1.7e-06 pd=7.1e-07 nrd=1.16667 \
        nrs=1.16667 sa=1.32314e-06 sb=1.4e-07 sd=160n sca=23.0212 \
        scb=0.0246876 scc=0.0015445 m=(1)
C1 (D VSS) capacitor c=8.29098e-17
C2 (CK VSS) capacitor c=4.73364e-17
C3 (RN VSS) capacitor c=5.57101e-17
C4 (Q VSS) capacitor c=3.88117e-17
C5 (VDD VSS) capacitor c=5.60071e-16
C6 (E VSS) capacitor c=2.08757e-17
C7 (QN VSS) capacitor c=5.91592e-17
C8 (Db VSS) capacitor c=3.56612e-17
C9 (Eb VSS) capacitor c=6.10995e-17
C10 (n1 VSS) capacitor c=6.21654e-19
C11 (Dp VSS) capacitor c=6.3423e-17
C12 (qbint VSS) capacitor c=3.21704e-17
C13 (RNb VSS) capacitor c=5.32431e-17
C14 (CKb VSS) capacitor c=5.61675e-17
C15 (CKbb VSS) capacitor c=5.282e-17
C16 (n21 VSS) capacitor c=1.756e-18
C17 (n20 VSS) capacitor c=3.82986e-17
C18 (net516 VSS) capacitor c=3.35896e-18
C19 (mout VSS) capacitor c=7.69035e-17
C20 (n30 VSS) capacitor c=5.46344e-17
C21 (net496 VSS) capacitor c=5.58966e-19
C22 (qint VSS) capacitor c=2.00783e-16
C23 (n3 VSS) capacitor c=7.38829e-17
C24 (n2 VSS) capacitor c=6.5131e-17
C25 (n22 VSS) capacitor c=4.23483e-18
C26 (net427 VSS) capacitor c=1.65611e-18
C27 (net411 VSS) capacitor c=4.16996e-18
C28 (\13\:qbint VSS) capacitor c=4.01784e-17
C29 (\3\:CK VSS) capacitor c=2.98862e-17
C30 (\4\:qbint VSS) capacitor c=4.91284e-17
C31 (\4\:CKbb VSS) capacitor c=3.84331e-17
C32 (\8\:CKb VSS) capacitor c=3.62959e-17
C33 (\6\:CKb VSS) capacitor c=6.15235e-17
C34 (\3\:CKbb VSS) capacitor c=2.21641e-17
C35 (\1\:RN VSS) capacitor c=3.49156e-17
C36 (\2\:qbint VSS) capacitor c=6.4623e-17
C37 (\4\:E VSS) capacitor c=3.97491e-17
C38 (\1\:E VSS) capacitor c=3.59676e-17
C39 (\1\:D VSS) capacitor c=4.35622e-17
C40 (\14\:qbint VSS) capacitor c=5.09996e-17
C41 (\7\:qbint VSS) capacitor c=1.8793e-16
C42 (\1\:CK VSS) capacitor c=4.03265e-17
C43 (\4\:n30 VSS) capacitor c=4.22541e-17
C44 (\6\:qbint VSS) capacitor c=7.78634e-17
C45 (\10\:CKb VSS) capacitor c=6.45902e-17
C46 (\6\:CKbb VSS) capacitor c=4.0062e-17
C47 (\3\:n20 VSS) capacitor c=3.68774e-17
C48 (\3\:mout VSS) capacitor c=2.87014e-17
C49 (\4\:CKb VSS) capacitor c=4.38862e-17
C50 (\2\:Dp VSS) capacitor c=5.37731e-17
C51 (\3\:CKb VSS) capacitor c=2.95903e-17
C52 (\3\:RN VSS) capacitor c=4.32025e-17
C53 (\3\:RNb VSS) capacitor c=3.47572e-17
C54 (\3\:qbint VSS) capacitor c=9.23277e-17
C55 (\2\:Eb VSS) capacitor c=4.8393e-17
C56 (\6\:E VSS) capacitor c=4.54803e-17
C57 (\3\:Db VSS) capacitor c=6.5907e-17
C58 (\3\:E VSS) capacitor c=3.18422e-17
C59 (\3\:D VSS) capacitor c=3.11322e-17
C60 (\15\:qbint VSS) capacitor c=2.54334e-17
C61 (\2\:CK VSS) capacitor c=4.00973e-17
C62 (\3\:n30 VSS) capacitor c=1.92576e-17
C63 (\5\:qbint VSS) capacitor c=2.65295e-17
C64 (\5\:CKbb VSS) capacitor c=4.92498e-17
C65 (\11\:CKb VSS) capacitor c=3.08473e-17
C66 (\9\:CKb VSS) capacitor c=2.28724e-17
C67 (\2\:n20 VSS) capacitor c=3.58919e-17
C68 (\2\:mout VSS) capacitor c=4.97986e-17
C69 (\7\:CKb VSS) capacitor c=5.60391e-17
C70 (\2\:CKbb VSS) capacitor c=4.81203e-17
C71 (\5\:CKb VSS) capacitor c=4.09406e-17
C72 (\3\:Dp VSS) capacitor c=2.16669e-17
C73 (\2\:CKb VSS) capacitor c=4.38719e-17
C74 (\2\:RN VSS) capacitor c=3.98795e-17
C75 (\2\:RNb VSS) capacitor c=4.86111e-17
C76 (\3\:Eb VSS) capacitor c=2.7071e-17
C77 (\5\:E VSS) capacitor c=3.45453e-17
C78 (\2\:Db VSS) capacitor c=2.31669e-17
C79 (\2\:E VSS) capacitor c=3.42014e-17
C80 (\2\:D VSS) capacitor c=3.04938e-17
C81 (\8\:qint VSS) capacitor c=2.75392e-17
C82 (\3\:QN VSS) capacitor c=7.06298e-18
C83 (\2\:Q VSS) capacitor c=5.37516e-17
C84 (\19\:CKb VSS) capacitor c=1.01042e-16
C85 (\18\:qbint VSS) capacitor c=5.63259e-17
C86 (\20\:VDD VSS) capacitor c=8.10667e-17
C87 (\7\:n30 VSS) capacitor c=7.24717e-17
C88 (\8\:mout VSS) capacitor c=5.64147e-17
C89 (\22\:VDD VSS) capacitor c=2.53818e-17
C90 (\7\:n20 VSS) capacitor c=3.31182e-17
C91 (\24\:VDD VSS) capacitor c=1.60933e-17
C92 (\11\:CKbb VSS) capacitor c=1.50497e-17
C93 (\4\:RNb VSS) capacitor c=4.90021e-17
C94 (\26\:VDD VSS) capacitor c=1.69881e-17
C95 (\3\:n2 VSS) capacitor c=7.60482e-17
C96 (\12\:Dp VSS) capacitor c=3.88321e-17
C97 (\3\:n3 VSS) capacitor c=7.83223e-17
C98 (\9\:Dp VSS) capacitor c=5.83972e-17
C99 (\7\:Eb VSS) capacitor c=7.79021e-17
C100 (\28\:VDD VSS) capacitor c=1.77564e-17
C101 (\5\:Db VSS) capacitor c=1.54408e-16
C102 (\1\:VDD VSS) capacitor c=9.9312e-17
C103 (\12\:qint VSS) capacitor c=1.1249e-17
C104 (\1\:QN VSS) capacitor c=4.01044e-17
C105 (\4\:Q VSS) capacitor c=2.80771e-17
C106 (\23\:CKb VSS) capacitor c=2.92375e-17
C107 (\23\:qbint VSS) capacitor c=6.72231e-17
C108 (\9\:n30 VSS) capacitor c=2.53589e-17
C109 (\4\:mout VSS) capacitor c=4.60428e-17
C110 (\4\:n20 VSS) capacitor c=7.6865e-17
C111 (\7\:CKbb VSS) capacitor c=5.12178e-17
C112 (\8\:RNb VSS) capacitor c=3.82071e-17
C113 (\4\:Dp VSS) capacitor c=2.02129e-16
C114 (\7\:Dp VSS) capacitor c=8.4757e-17
C115 (\5\:Eb VSS) capacitor c=1.48582e-16
C116 (\7\:Db VSS) capacitor c=1.01082e-16
C117 (\4\:D VSS) capacitor c=2.94681e-17
C118 (\2\:n30 VSS) capacitor c=1.57177e-17
C119 (\4\:Db VSS) capacitor c=9.8757e-17
C120 (\7\:E VSS) capacitor c=1.20638e-16
C121 (\8\:E VSS) capacitor c=1.20678e-16
C122 (\9\:E VSS) capacitor c=3.4816e-17
C123 (\4\:Eb VSS) capacitor c=1.38198e-16
C124 (\4\:RN VSS) capacitor c=4.40057e-17
C125 (\6\:RNb VSS) capacitor c=5.65463e-17
C126 (\7\:RNb VSS) capacitor c=4.50558e-17
C127 (\6\:Dp VSS) capacitor c=1.1631e-16
C128 (\11\:Dp VSS) capacitor c=1.4153e-16
C129 (\6\:n20 VSS) capacitor c=6.87411e-17
C130 (\9\:n20 VSS) capacitor c=6.31519e-17
C131 (\6\:mout VSS) capacitor c=6.68623e-17
C132 (\7\:mout VSS) capacitor c=5.66977e-17
C133 (\9\:CKbb VSS) capacitor c=7.79547e-17
C134 (\10\:CKbb VSS) capacitor c=2.41764e-16
C135 (\13\:CKbb VSS) capacitor c=2.45166e-16
C136 (\5\:n30 VSS) capacitor c=6.63497e-17
C137 (\6\:n30 VSS) capacitor c=8.71947e-17
C138 (\12\:CKb VSS) capacitor c=2.73348e-17
C139 (\13\:CKb VSS) capacitor c=8.32462e-17
C140 (\14\:CKb VSS) capacitor c=1.24335e-16
C141 (\15\:CKb VSS) capacitor c=1.48424e-16
C142 (\16\:CKb VSS) capacitor c=9.44063e-17
C143 (\17\:CKb VSS) capacitor c=4.03116e-17
C144 (\18\:CKb VSS) capacitor c=8.88133e-17
C145 (\21\:CKb VSS) capacitor c=8.28745e-17
C146 (\22\:CKb VSS) capacitor c=4.15072e-17
C147 (\4\:CK VSS) capacitor c=8.15965e-17
C148 (\1\:Q VSS) capacitor c=4.36891e-17
C149 (\16\:qbint VSS) capacitor c=8.88892e-17
C150 (\17\:qbint VSS) capacitor c=1.27389e-16
C151 (\20\:qbint VSS) capacitor c=9.48609e-17
C152 (\21\:qbint VSS) capacitor c=3.81266e-16
C153 (\22\:qbint VSS) capacitor c=9.19214e-17
C154 (\25\:qbint VSS) capacitor c=2.42086e-16
C155 (\10\:qint VSS) capacitor c=2.17792e-17
C156 (\11\:qint VSS) capacitor c=2.24578e-17
C157 (\3\:VDD VSS) capacitor c=1.03072e-16
C158 (\7\:VDD VSS) capacitor c=3.31811e-17
C159 (\8\:VDD VSS) capacitor c=5.29291e-17
C160 (\10\:VDD VSS) capacitor c=2.00065e-17
C161 (\11\:VDD VSS) capacitor c=5.6708e-17
C162 (\13\:VDD VSS) capacitor c=1.79536e-17
Rk1 (\4\:D D) resistor r=0.1009 c=0
Rk43 (\4\:CK CK) resistor r=0.08837 c=0
Rk11 (RN \4\:RN) resistor r=0.141 c=0
Rk44 (Q \1\:Q) resistor r=0.07065 c=0
Rk45 (\1\:Q \3\:Q) resistor r=0.1486 c=0
Rk46 (\1\:Q \5\:Q) resistor r=0.1584 c=0
Rk79 (\2\:VSS \3\:VSS) resistor r=0.09007 c=0
Rk82 (\3\:VSS \6\:VSS) resistor r=0.233 c=0
Rk83 (\6\:VSS \7\:VSS) resistor r=0.1443 c=0
Rk84 (\7\:VSS \8\:VSS) resistor r=0.5904 c=0
Rk85 (\8\:VSS \9\:VSS) resistor r=0.4662 c=0
Rk86 (\9\:VSS \10\:VSS) resistor r=0.065 c=0
Rk87 (\10\:VSS \11\:VSS) resistor r=0.466 c=0
Rk88 (\11\:VSS \12\:VSS) resistor r=0.3657 c=0
Rk89 (\12\:VSS \13\:VSS) resistor r=0.1475 c=0
Rk90 (\13\:VSS \14\:VSS) resistor r=0.1578 c=0
Rk92 (\15\:VSS VSS) resistor r=0.2804 c=0
Rk91 (\14\:VSS \15\:VSS) resistor r=0.2706 c=0
Rk96 (\7\:VSS \23\:VSS) resistor r=0.0433 c=0
Rk97 (\8\:VSS \25\:VSS) resistor r=0.2424 c=0
Rk98 (\10\:VSS \27\:VSS) resistor r=0.1225 c=0
Rk99 (\11\:VSS \29\:VSS) resistor r=0.1632 c=0
Rk100 (\12\:VSS \31\:VSS) resistor r=0.193 c=0
Rk101 (\13\:VSS \33\:VSS) resistor r=0.1739 c=0
Rk102 (\15\:VSS \35\:VSS) resistor r=0.2811 c=0
Rk59 (\2\:VDD \3\:VDD) resistor r=0.05497 c=0
Rk62 (\3\:VDD \6\:VDD) resistor r=0.2255 c=0
Rk63 (\6\:VDD \7\:VDD) resistor r=0.1452 c=0
Rk64 (\7\:VDD \8\:VDD) resistor r=0.5754 c=0
Rk65 (\8\:VDD \9\:VDD) resistor r=0.4803 c=0
Rk66 (\9\:VDD \10\:VDD) resistor r=0.05998 c=0
Rk67 (\10\:VDD \11\:VDD) resistor r=0.4209 c=0
Rk68 (\11\:VDD \12\:VDD) resistor r=0.7219 c=0
Rk70 (\13\:VDD VDD) resistor r=0.2945 c=0
Rk69 (\12\:VDD \13\:VDD) resistor r=0.2546 c=0
Rk74 (\7\:VDD \21\:VDD) resistor r=0.3763 c=0
Rk75 (\8\:VDD \23\:VDD) resistor r=0.0433 c=0
Rk76 (\10\:VDD \25\:VDD) resistor r=0.07381 c=0
Rk77 (\11\:VDD \27\:VDD) resistor r=0.07381 c=0
Rk78 (\13\:VDD \29\:VDD) resistor r=0.0433 c=0
Rk5 (\8\:E E) resistor r=0.003075 c=0
Rk4 (\7\:E \8\:E) resistor r=0.8144 c=0
Rk6 (\8\:E \9\:E) resistor r=0.199 c=0
Rk47 (\2\:QN QN) resistor r=0.2696 c=0
Rk48 (QN \4\:QN) resistor r=0.005786 c=0
Rk2 (\4\:Db \6\:Db) resistor r=0.738 c=0
Rk3 (\6\:Db \8\:Db) resistor r=0.8318 c=0
Rk7 (\4\:Eb \6\:Eb) resistor r=1.0163 c=0
Rk8 (\6\:Eb \8\:Eb) resistor r=0.3423 c=0
Rk15 (\5\:Dp \6\:Dp) resistor r=0.5923 c=0
Rk16 (\6\:Dp \8\:Dp) resistor r=0.4251 c=0
Rk17 (\8\:Dp \10\:Dp) resistor r=0.2574 c=0
Rk18 (\5\:Dp \11\:Dp) resistor r=1.1713 c=0
Rk19 (\6\:Dp \13\:Dp) resistor r=0.198 c=0
Rk49 (\16\:qbint \17\:qbint) resistor r=0.7471 c=0
Rk50 (\17\:qbint \19\:qbint) resistor r=0.4259 c=0
Rk51 (\19\:qbint \20\:qbint) resistor r=0.2321 c=0
Rk52 (\20\:qbint \21\:qbint) resistor r=0.508 c=0
Rk53 (\17\:qbint \22\:qbint) resistor r=0.345 c=0
Rk54 (\20\:qbint \24\:qbint) resistor r=0.2945 c=0
Rk55 (\21\:qbint \25\:qbint) resistor r=2.2653 c=0
Rk12 (\5\:RNb \6\:RNb) resistor r=0.2592 c=0
Rk13 (\6\:RNb \7\:RNb) resistor r=0.2581 c=0
Rk14 (\6\:RNb \9\:RNb) resistor r=0.125 c=0
Rk33 (\12\:CKb \13\:CKb) resistor r=0.06796 c=0
Rk34 (\13\:CKb \14\:CKb) resistor r=0.2633 c=0
Rk35 (\14\:CKb \15\:CKb) resistor r=0.6951 c=0
Rk36 (\15\:CKb \16\:CKb) resistor r=0.7289 c=0
Rk37 (\16\:CKb \17\:CKb) resistor r=0.2224 c=0
Rk38 (\13\:CKb \18\:CKb) resistor r=0.5879 c=0
Rk39 (\18\:CKb \20\:CKb) resistor r=0.457 c=0
Rk40 (\14\:CKb \21\:CKb) resistor r=0.372 c=0
Rk41 (\15\:CKb \22\:CKb) resistor r=0.1884 c=0
Rk42 (\18\:CKb \24\:CKb) resistor r=0.04879 c=0
Rk26 (\8\:CKbb \9\:CKbb) resistor r=0.3813 c=0
Rk27 (\9\:CKbb \10\:CKbb) resistor r=0.4399 c=0
Rk28 (\9\:CKbb \12\:CKbb) resistor r=0.1224 c=0
Rk29 (\10\:CKbb \13\:CKbb) resistor r=1.6181 c=0
Rk20 (\5\:n20 \6\:n20) resistor r=0.3743 c=0
Rk21 (\6\:n20 \8\:n20) resistor r=0.04277 c=0
Rk22 (\6\:n20 \9\:n20) resistor r=0.3528 c=0
Rk23 (\5\:mout \6\:mout) resistor r=0.1766 c=0
Rk24 (\6\:mout \7\:mout) resistor r=0.2948 c=0
Rk25 (\6\:mout \9\:mout) resistor r=0.2219 c=0
Rk30 (\5\:n30 \6\:n30) resistor r=0.3819 c=0
Rk31 (\6\:n30 \8\:n30) resistor r=0.3835 c=0
Rk32 (\6\:n30 \10\:n30) resistor r=0.07121 c=0
Rk56 (\9\:qint \10\:qint) resistor r=0.1943 c=0
Rk57 (\10\:qint \11\:qint) resistor r=0.1513 c=0
Rk58 (\10\:qint \13\:qint) resistor r=0.1342 c=0
Rk9 (\2\:n3 \4\:n3) resistor r=0.5725 c=0
Rk10 (\2\:n2 \4\:n2) resistor r=0.3322 c=0
Rl1 (\1\:D \2\:D) resistor r=79.5379 c=0
Rl2 (\2\:D \3\:D) resistor r=39.1533 c=0
Rl39 (\2\:CK \3\:CK) resistor r=29.9451 c=0
Rl38 (\1\:CK \2\:CK) resistor r=115.385 c=0
Rl15 (\1\:RN \2\:RN) resistor r=26.9231 c=0
Rl16 (\2\:RN \3\:RN) resistor r=100.795 c=0
Rl7 (\4\:E \5\:E) resistor r=90.6605 c=0
Rl8 (\5\:E \6\:E) resistor r=39.6174 c=0
Rl3 (\1\:E \2\:E) resistor r=35.3066 c=0
Rl4 (\2\:E \3\:E) resistor r=84.4104 c=0
Rl6 (Db \3\:Db) resistor r=92.3077 c=0
Rl5 (Db \2\:Db) resistor r=50.6918 c=0
Rl9 (Eb \2\:Eb) resistor r=151.923 c=0
Rl10 (\2\:Eb \3\:Eb) resistor r=24.2328 c=0
Rl19 (Dp \2\:Dp) resistor r=151.923 c=0
Rl20 (\2\:Dp \3\:Dp) resistor r=25.2509 c=0
Rl51 (\14\:qbint \13\:qbint) resistor r=130.769 c=0
Rl34 (\6\:qbint \4\:qbint) resistor r=151.923 c=0
Rl12 (\3\:qbint \2\:qbint) resistor r=172.643 c=0
Rl52 (\15\:qbint \13\:qbint) resistor r=37.6504 c=0
Rl33 (\5\:qbint \4\:qbint) resistor r=29.5379 c=0
Rl11 (qbint \2\:qbint) resistor r=102.252 c=0
Rl13 (RNb \2\:RNb) resistor r=82.4874 c=0
Rl14 (\2\:RNb \3\:RNb) resistor r=42.2849 c=0
Rl32 (\10\:CKb \11\:CKb) resistor r=89.6174 c=0
Rl29 (\8\:CKb \9\:CKb) resistor r=33.8482 c=0
Rl24 (\6\:CKb \7\:CKb) resistor r=66.5405 c=0
Rl21 (\4\:CKb \5\:CKb) resistor r=86.0515 c=0
Rl17 (CKb \2\:CKb) resistor r=89.6174 c=0
Rl18 (\2\:CKb \3\:CKb) resistor r=68.7849 c=0
Rl30 (\4\:CKbb \5\:CKbb) resistor r=49.2328 c=0
Rl31 (\5\:CKbb \6\:CKbb) resistor r=114.939 c=0
Rl23 (\2\:CKbb \3\:CKbb) resistor r=24.2328 c=0
Rl22 (CKbb \2\:CKbb) resistor r=157.246 c=0
Rl27 (n20 \2\:n20) resistor r=24.2328 c=0
Rl28 (\2\:n20 \3\:n20) resistor r=99.2328 c=0
Rl25 (mout \2\:mout) resistor r=93.4057 c=0
Rl26 (\2\:mout \3\:mout) resistor r=26.098 c=0
Rl35 (n30 \2\:n30) resistor r=78.5603 c=0
Rl37 (\2\:n30 \4\:n30) resistor r=43.9449 c=0
Rl36 (\2\:n30 \3\:n30) resistor r=2.7666 c=0
Rz11 (\5\:Q \4\:Q) resistor r=75 c=0
Rz22 (\23\:VSS \22\:VSS) resistor r=75 c=0
Rz23 (\25\:VSS \24\:VSS) resistor r=75 c=0
Rz24 (\27\:VSS \26\:VSS) resistor r=75 c=0
Rz25 (\29\:VSS \28\:VSS) resistor r=75 c=0
Rz26 (\31\:VSS \30\:VSS) resistor r=75 c=0
Rz27 (\33\:VSS \32\:VSS) resistor r=75 c=0
Rz28 (\35\:VSS \34\:VSS) resistor r=75 c=0
Rz15 (\2\:VDD \1\:VDD) resistor r=25 c=0
Rz16 (\6\:VDD \1\:VDD) resistor r=6.25 c=0
Rz17 (\9\:VDD \1\:VDD) resistor r=6.25 c=0
Rz18 (\12\:VDD \1\:VDD) resistor r=6.25 c=0
Rz12 (\2\:QN \1\:QN) resistor r=75 c=0
Rz1 (\7\:Db \8\:Db) resistor r=75 c=0
Rz2 (\5\:Eb \6\:Eb) resistor r=75 c=0
Rz4 (\4\:Dp \5\:Dp) resistor r=75 c=0
Rz5 (\7\:Dp \8\:Dp) resistor r=75 c=0
Rz13 (\24\:qbint \23\:qbint) resistor r=75 c=0
Rz3 (\8\:RNb \9\:RNb) resistor r=75 c=0
Rz10 (\23\:CKb \24\:CKb) resistor r=75 c=0
Rz8 (\7\:CKbb \8\:CKbb) resistor r=75 c=0
Rz6 (\4\:n20 \5\:n20) resistor r=75 c=0
Rz7 (\4\:mout \5\:mout) resistor r=75 c=0
Rz9 (\9\:n30 \10\:n30) resistor r=75 c=0
Rz14 (\13\:qint \12\:qint) resistor r=75 c=0
Ry15 (\3\:Q \2\:Q) resistor r=62 c=0
Ry27 (\2\:VSS \1\:VSS) resistor r=20.6667 c=0
Ry28 (\6\:VSS \1\:VSS) resistor r=5.1667 c=0
Ry29 (\9\:VSS \1\:VSS) resistor r=5.1667 c=0
Ry30 (\14\:VSS \1\:VSS) resistor r=5.1667 c=0
Ry22 (\21\:VDD \20\:VDD) resistor r=62 c=0
Ry23 (\23\:VDD \22\:VDD) resistor r=62 c=0
Ry24 (\25\:VDD \24\:VDD) resistor r=62 c=0
Ry25 (\27\:VDD \26\:VDD) resistor r=62 c=0
Ry26 (\29\:VDD \28\:VDD) resistor r=62 c=0
Ry16 (\4\:QN \3\:QN) resistor r=62 c=0
Ry1 (\5\:Db \6\:Db) resistor r=62 c=0
Ry2 (\7\:Eb \8\:Eb) resistor r=62 c=0
Ry8 (\9\:Dp \10\:Dp) resistor r=62 c=0
Ry9 (\12\:Dp \13\:Dp) resistor r=62 c=0
Ry17 (\19\:qbint \18\:qbint) resistor r=62 c=0
Ry7 (\4\:RNb \5\:RNb) resistor r=62 c=0
Ry14 (\19\:CKb \20\:CKb) resistor r=62 c=0
Ry12 (\11\:CKbb \12\:CKbb) resistor r=62 c=0
Ry10 (\7\:n20 \8\:n20) resistor r=62 c=0
Ry11 (\8\:mout \9\:mout) resistor r=62 c=0
Ry13 (\7\:n30 \8\:n30) resistor r=62 c=0
Ry18 (\9\:qint \8\:qint) resistor r=62 c=0
Ry3 (n3 \2\:n3) resistor r=62 c=0
Ry4 (\3\:n3 \4\:n3) resistor r=62 c=0
Ry5 (n2 \2\:n2) resistor r=62 c=0
Ry6 (\3\:n2 \4\:n2) resistor r=62 c=0
Rx1 (\2\:D \4\:D) resistor r=45 c=0
Rx19 (\2\:CK \4\:CK) resistor r=45 c=0
Rx6 (\2\:RN \4\:RN) resistor r=45 c=0
Rx3 (\5\:E \7\:E) resistor r=45 c=0
Rx4 (\2\:E \9\:E) resistor r=45 c=0
Rx2 (\2\:Db \4\:Db) resistor r=45 c=0
Rx5 (\3\:Eb \4\:Eb) resistor r=45 c=0
Rx8 (\3\:Dp \11\:Dp) resistor r=45 c=0
Rx20 (\16\:qbint \15\:qbint) resistor r=45 c=0
Rx21 (\21\:qbint \5\:qbint) resistor r=45 c=0
Rx22 (\22\:qbint \7\:qbint) resistor r=22.5 c=0
Rx23 (\25\:qbint qbint) resistor r=45 c=0
Rx7 (\2\:RNb \7\:RNb) resistor r=45 c=0
Rx14 (\11\:CKb \12\:CKb) resistor r=45 c=0
Rx15 (\5\:CKb \16\:CKb) resistor r=45 c=0
Rx16 (\2\:CKb \17\:CKb) resistor r=45 c=0
Rx17 (\9\:CKb \21\:CKb) resistor r=45 c=0
Rx18 (\7\:CKb \22\:CKb) resistor r=45 c=0
Rx11 (\2\:CKbb \10\:CKbb) resistor r=45 c=0
Rx12 (\5\:CKbb \13\:CKbb) resistor r=45 c=0
Rx9 (\2\:n20 \9\:n20) resistor r=45 c=0
Rx10 (\2\:mout \7\:mout) resistor r=45 c=0
Rx13 (\3\:n30 \5\:n30) resistor r=45 c=0
Rx24 (\11\:qint qint) resistor r=45 c=0
mn1 (\7\:Db \3\:D \34\:VSS VSS) g45n1lvt w=(1.45e-07) l=4.5e-08 nf=1 \
        as=2.32e-14 ad=2.03e-14 ps=6.1e-07 pd=5.7e-07 nrd=1.16667 \
        nrs=1.16667 sa=1.4e-07 sb=3.75e-07 sd=160n sca=10.4914 \
        scb=0.00978575 scc=0.000300434 m=(1)
mn0 (\5\:Eb \3\:E \34\:VSS VSS) g45n1lvt w=(1.45e-07) l=4.5e-08 nf=1 \
        as=2.32e-14 ad=2.465e-14 ps=6.1e-07 pd=6.3e-07 nrd=1.16667 \
        nrs=1.16667 sa=3.45e-07 sb=1.7e-07 sd=160n sca=10.4914 \
        scb=0.00978575 scc=0.000300434 m=(1)
mn7 (\7\:Dp \3\:Db n1 VSS) g45n1lvt w=(1.45e-07) l=4.5e-08 nf=1 \
        as=8.7e-15 ad=2.03e-14 ps=4.1e-07 pd=5.7e-07 nrd=1.16667 \
        nrs=1.16667 sa=1.4e-07 sb=2.75e-07 sd=160n sca=23.279 \
        scb=0.0230742 scc=0.00267719 m=(1)
mn6 (n1 \6\:E \32\:VSS VSS) g45n1lvt w=(1.45e-07) l=4.5e-08 nf=1 \
        as=5.885e-14 ad=8.7e-15 ps=1.2e-06 pd=4.1e-07 nrd=1.16667 \
        nrs=1.16667 sa=2.45e-07 sb=1.7e-07 sd=160n sca=23.279 \
        scb=0.0230742 scc=0.00267719 m=(1)
mn4 (n0 \2\:Eb \30\:VSS VSS) g45n1lvt w=(1.45e-07) l=4.5e-08 nf=1 \
        as=5.597e-14 ad=8.7e-15 ps=1.1e-06 pd=4.1e-07 nrd=1.16667 \
        nrs=1.16667 sa=2.95e-07 sb=8e-07 sd=160n sca=10.0732 \
        scb=0.00911402 scc=0.000253284 m=(1)
mn5 (\4\:Dp \3\:qbint n0 VSS) g45n1lvt w=(1.45e-07) l=4.5e-08 nf=1 \
        as=8.7e-15 ad=2.32e-14 ps=4.1e-07 pd=6.1e-07 nrd=1.16667 \
        nrs=1.16667 sa=4e-07 sb=6.95e-07 sd=160n sca=10.0732 \
        scb=0.00911402 scc=0.000253284 m=(1)
mn3 (\4\:Dp \3\:RNb \28\:VSS VSS) g45n1lvt w=(1.45e-07) l=4.5e-08 nf=1 \
        as=5.11e-14 ad=2.32e-14 ps=1.05e-06 pd=6.1e-07 nrd=1.16667 \
        nrs=1.16667 sa=6.05e-07 sb=4.9e-07 sd=160n sca=10.0732 \
        scb=0.00911402 scc=0.000253284 m=(1)
mn2 (\8\:RNb \3\:RN \28\:VSS VSS) g45n1lvt w=(1.45e-07) l=4.5e-08 nf=1 \
        as=5.11e-14 ad=3.262e-14 ps=1.05e-06 pd=7.4e-07 nrd=1.16667 \
        nrs=1.16667 sa=8.7e-07 sb=2.25e-07 sd=160n sca=10.0732 \
        scb=0.00911402 scc=0.000253284 m=(1)
mn21 (\7\:CKbb \3\:CKb \26\:VSS VSS) g45n1lvt w=(1.45e-07) l=4.5e-08 \
        nf=1 as=7.37e-14 ad=4.132e-14 ps=1.41e-06 pd=8.6e-07 nrd=1.16667 \
        nrs=1.16667 sa=2.85e-07 sb=2e-06 sd=160n sca=15.7071 scb=0.0167369 \
        scc=0.00113434 m=(1)
mn25 (n21 \2\:Dp \26\:VSS VSS) g45n1lvt w=(1.45e-07) l=4.5e-08 nf=1 \
        as=7.37e-14 ad=4.06e-14 ps=1.41e-06 pd=8.5e-07 nrd=1.16667 \
        nrs=1.16667 sa=5.9e-07 sb=2e-06 sd=160n sca=15.7071 scb=0.0167369 \
        scc=0.00113434 m=(1)
mn26 (\4\:n20 \4\:CKb n21 VSS) g45n1lvt w=(1.45e-07) l=4.5e-08 nf=1 \
        as=4.06e-14 ad=2.32e-14 ps=8.5e-07 pd=6.1e-07 nrd=1.16667 \
        nrs=1.16667 sa=9.15e-07 sb=2e-06 sd=160n sca=15.7071 scb=0.0167369 \
        scc=0.00113434 m=(1)
mn36 (\4\:n20 CKbb net516 VSS) g45n1lvt w=(1.45e-07) l=4.5e-08 nf=1 \
        as=3.48e-14 ad=2.32e-14 ps=7.7e-07 pd=6.1e-07 nrd=1.16667 \
        nrs=1.16667 sa=1.12e-06 sb=1.86e-06 sd=160n sca=15.7071 \
        scb=0.0167369 scc=0.00113434 m=(1)
mn35 (net516 \3\:mout \24\:VSS VSS) g45n1lvt w=(1.45e-07) l=4.5e-08 nf=1 \
        as=4.69e-14 ad=3.48e-14 ps=9.8e-07 pd=7.7e-07 nrd=1.16667 \
        nrs=1.16667 sa=1.405e-06 sb=1.575e-06 sd=160n sca=15.7071 \
        scb=0.0167369 scc=0.00113434 m=(1)
mn30 (\4\:mout \3\:n20 \24\:VSS VSS) g45n1lvt w=(1.45e-07) l=4.5e-08 \
        nf=1 as=4.69e-14 ad=7.54e-14 ps=9.8e-07 pd=1.33e-06 nrd=1.16667 \
        nrs=1.16667 sa=1.67e-06 sb=1.31e-06 sd=160n sca=15.7071 \
        scb=0.0167369 scc=0.00113434 m=(1)
mn40 (\9\:n30 \6\:CKbb \4\:mout VSS) g45n1lvt w=(1.45e-07) l=4.5e-08 nf=1 \
        as=7.54e-14 ad=2.32e-14 ps=1.33e-06 pd=6.1e-07 nrd=1.16667 \
        nrs=1.16667 sa=2e-06 sb=7.45e-07 sd=160n sca=15.7071 scb=0.0167369 \
        scc=0.00113434 m=(1)
mn51 (\9\:n30 \10\:CKb net496 VSS) g45n1lvt w=(1.45e-07) l=4.5e-08 nf=1 \
        as=1.015e-14 ad=2.32e-14 ps=4.3e-07 pd=6.1e-07 nrd=1.16667 \
        nrs=1.16667 sa=2e-06 sb=5.4e-07 sd=160n sca=15.7071 scb=0.0167369 \
        scc=0.00113434 m=(1)
mn50 (net496 \6\:qbint \22\:VSS VSS) g45n1lvt w=(1.45e-07) l=4.5e-08 \
        nf=1 as=8.6e-14 ad=1.015e-14 ps=1.6e-06 pd=4.3e-07 nrd=1.16667 \
        nrs=1.16667 sa=2e-06 sb=4.25e-07 sd=160n sca=15.7071 scb=0.0167369 \
        scc=0.00113434 m=(1)
mn20 (\23\:CKb \1\:CK \3\:VSS VSS) g45n1lvt w=(1.45e-07) l=4.5e-08 nf=1 \
        as=3.687e-14 ad=2.03e-14 ps=8.7e-07 pd=5.7e-07 nrd=1.16667 \
        nrs=1.16667 sa=1.4e-07 sb=1.06793e-06 sd=160n sca=12.2839 \
        scb=0.0124725 scc=0.000542081 m=(1)
mn56 (\12\:qint \14\:qbint \3\:VSS VSS) g45n1lvt w=(1.45e-07) l=4.5e-08 \
        nf=1 as=4.365e-14 ad=2.03e-14 ps=9e-07 pd=5.7e-07 nrd=1.16667 \
        nrs=1.16667 sa=1.05069e-06 sb=1.4e-07 sd=160n sca=23.279 \
        scb=0.0230742 scc=0.00267719 m=(1)
mn45 (\23\:qbint \4\:n30 \22\:VSS VSS) g45n1lvt w=(2.6e-07) l=4.5e-08 \
        nf=1 as=8.6e-14 ad=4.16e-14 ps=1.6e-06 pd=8.4e-07 nrd=1.16667 \
        nrs=1.16667 sa=1.17577e-06 sb=1.6e-07 sd=160n sca=17.5885 \
        scb=0.0172826 scc=0.00162584 m=(1)
mn55 (\4\:Q \7\:qbint \3\:VSS VSS) g45n1lvt w=(2.6e-07) l=4.5e-08 nf=1 \
        as=3.924e-14 ad=4.68e-14 ps=8.55e-07 pd=8.8e-07 nrd=1.16667 \
        nrs=1.16667 sa=2.45e-07 sb=9.06058e-07 sd=160n sca=17.5885 \
        scb=0.0172826 scc=0.00162584 m=(2)
mn57 (\1\:QN qint \3\:VSS VSS) g45n1lvt w=(2.6e-07) l=4.5e-08 nf=1 \
        as=4.262e-14 ad=4.16e-14 ps=8.7e-07 pd=8.4e-07 nrd=1.16667 \
        nrs=1.16667 sa=6.75e-07 sb=4.76058e-07 sd=160n sca=17.5885 \
        scb=0.0172826 scc=0.00162584 m=(2)
mp45 (\18\:qbint n30 \20\:VDD VDD) g45p1lvt w=(3.9e-07) l=4.5e-08 nf=1 \
        as=6.48e-14 ad=4.5e-14 ps=1.22e-06 pd=1.06e-06 nrd=1.16667 \
        nrs=1.16667 sa=1.14744e-06 sb=1.15385e-07 sd=160n sca=14.3987 \
        scb=0.0130081 scc=0.000814275 m=(1)
mp55_1__rcx (\2\:Q \7\:qbint \3\:VDD VDD) g45p1lvt w=(3.9e-07) l=4.5e-08 \
        nf=1 as=1.029e-13 ad=6.24e-14 ps=1.57e-06 pd=1.1e-06 nrd=1.16667 \
        nrs=1.16667 sa=3.2609e-07 sb=9.04551e-07 sd=160n sca=14.3987 \
        scb=0.0130081 scc=0.000814275 m=(2)
mp57_1__rcx (\3\:QN qint \3\:VDD VDD) g45p1lvt w=(3.9e-07) l=4.5e-08 \
        nf=1 as=8.397e-14 ad=6.24e-14 ps=1.56e-06 pd=1.1e-06 nrd=1.16667 \
        nrs=1.16667 sa=7.9609e-07 sb=4.34551e-07 sd=160n sca=14.9766 \
        scb=0.0132237 scc=0.000814354 m=(2)
ends EDFFTRX2
// End of subcircuit definition.
