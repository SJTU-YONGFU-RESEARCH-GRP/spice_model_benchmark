// Generated for: spectre (May  1 09:15:55 2013 )
// Library name: gsclib045_lvt
// Cell name: BMXIX4
// View name: extracted

simulator lang=spectre

subckt BMXIX4 A M0 M1 PPN S VDD VSS X2
mp0 (\11\:M0b \1\:M0 \20\:VDD VDD) g45p1lvt w=(2.15e-07) l=4.5e-08 nf=1 \
        as=1.276e-13 ad=3.44e-14 ps=2.05e-06 pd=7.5e-07 nrd=1.16667 \
        nrs=1.16667 sa=1.6e-07 sb=2e-06 sd=160n sca=44.4931 scb=0.0420172 \
        scc=0.00520661 m=(1)
mp3 (n4 \1\:S \20\:VDD VDD) g45p1lvt w=(2.15e-07) l=4.5e-08 nf=1 \
        as=1.276e-13 ad=5.053e-14 ps=2.05e-06 pd=9e-07 nrd=1.16667 \
        nrs=1.16667 sa=5.25e-07 sb=2e-06 sd=160n sca=34.6718 scb=0.0267184 \
        scc=0.00427277 m=(1)
mp4 (\6\:n0 \4\:M0 n4 VDD) g45p1lvt w=(2.15e-07) l=4.5e-08 nf=1 \
        as=5.053e-14 ad=3.44e-14 ps=9e-07 pd=7.5e-07 nrd=1.16667 \
        nrs=1.16667 sa=8.05e-07 sb=1.73e-06 sd=160n sca=33.4709 \
        scb=0.0258398 scc=0.00427134 m=(1)
mp6 (\6\:n0 \3\:M0b n6 VDD) g45p1lvt w=(2.15e-07) l=4.5e-08 nf=1 \
        as=1.29e-14 ad=3.44e-14 ps=5.5e-07 pd=7.5e-07 nrd=1.16667 \
        nrs=1.16667 sa=1.01e-06 sb=1.525e-06 sd=160n sca=33.2772 \
        scb=0.0257934 scc=0.00427133 m=(1)
mp5 (n6 \5\:A \18\:VDD VDD) g45p1lvt w=(2.15e-07) l=4.5e-08 nf=1 \
        as=6.515e-14 ad=1.29e-14 ps=1.85e-06 pd=5.5e-07 nrd=1.16667 \
        nrs=1.16667 sa=1.115e-06 sb=1.42e-06 sd=160n sca=33.2772 \
        scb=0.0257934 scc=0.00427133 m=(1)
mp9 (n10 \1\:A \18\:VDD VDD) g45p1lvt w=(2.15e-07) l=4.5e-08 nf=1 \
        as=6.515e-14 ad=5.483e-14 ps=1.85e-06 pd=9.4e-07 nrd=1.16667 \
        nrs=1.16667 sa=1.31e-06 sb=1.225e-06 sd=160n sca=33.2772 \
        scb=0.0257934 scc=0.00427133 m=(1)
mp10 (\3\:n1 \3\:M1b n10 VDD) g45p1lvt w=(2.15e-07) l=4.5e-08 nf=1 \
        as=5.483e-14 ad=3.44e-14 ps=9.4e-07 pd=7.5e-07 nrd=1.16667 \
        nrs=1.16667 sa=1.61e-06 sb=9.25e-07 sd=160n sca=33.2772 \
        scb=0.0257934 scc=0.00427133 m=(1)
mp8 (\3\:n1 \3\:M1 n8 VDD) g45p1lvt w=(2.15e-07) l=4.5e-08 nf=1 \
        as=1.29e-14 ad=3.44e-14 ps=5.5e-07 pd=7.5e-07 nrd=1.16667 \
        nrs=1.16667 sa=1.815e-06 sb=7.2e-07 sd=160n sca=33.2772 \
        scb=0.0257934 scc=0.00427133 m=(1)
mp7 (n8 \5\:S \16\:VDD VDD) g45p1lvt w=(2.15e-07) l=4.5e-08 nf=1 \
        as=1.3835e-13 ad=1.29e-14 ps=2.15e-06 pd=5.5e-07 nrd=1.16667 \
        nrs=1.16667 sa=1.92e-06 sb=6.15e-07 sd=160n sca=33.2772 \
        scb=0.0257934 scc=0.00427133 m=(1)
mp1 (\7\:M1b \7\:M1 \16\:VDD VDD) g45p1lvt w=(2.15e-07) l=4.5e-08 nf=1 \
        as=1.3835e-13 ad=4.3e-14 ps=2.15e-06 pd=8.3e-07 nrd=1.16667 \
        nrs=1.16667 sa=2e-06 sb=2e-07 sd=160n sca=33.2772 scb=0.0257934 \
        scc=0.00427133 m=(1)
mp2 (\5\:X2b \3\:X2 \1\:VDD VDD) g45p1lvt w=(2.15e-07) l=4.5e-08 nf=1 \
        as=6.605e-14 ad=3.01e-14 ps=1.47e-06 pd=7.1e-07 nrd=1.16667 \
        nrs=1.16667 sa=1.4e-07 sb=9.6e-07 sd=160n sca=45.7906 \
        scb=0.0283307 scc=0.00588417 m=(1)
C1 (M0 VSS) capacitor c=8.21772e-17
C2 (M1 VSS) capacitor c=6.1837e-17
C3 (PPN VSS) capacitor c=2.5799e-16
C4 (S VSS) capacitor c=1.9167e-16
C5 (VDD VSS) capacitor c=2.98273e-16
C6 (X2 VSS) capacitor c=9.3282e-17
C7 (A VSS) capacitor c=3.09218e-17
C8 (M0b VSS) capacitor c=6.45388e-17
C9 (n0 VSS) capacitor c=7.04878e-17
C10 (n5 VSS) capacitor c=2.40959e-18
C11 (n1 VSS) capacitor c=9.76882e-17
C12 (M1b VSS) capacitor c=3.29135e-17
C13 (net293 VSS) capacitor c=2.18053e-16
C14 (X2b VSS) capacitor c=5.31012e-17
C15 (n4 VSS) capacitor c=2.52684e-18
C16 (n6 VSS) capacitor c=1.68863e-18
C17 (n10 VSS) capacitor c=4.47851e-18
C18 (n8 VSS) capacitor c=1.39476e-18
C19 (\3\:X2 VSS) capacitor c=3.22391e-17
C20 (\5\:X2 VSS) capacitor c=6.93209e-17
C21 (\4\:X2b VSS) capacitor c=5.1023e-17
C22 (\7\:M1 VSS) capacitor c=3.34264e-17
C23 (\5\:S VSS) capacitor c=1.20386e-16
C24 (\3\:M1 VSS) capacitor c=7.36917e-17
C25 (\3\:M1b VSS) capacitor c=8.07422e-17
C26 (\1\:A VSS) capacitor c=2.3944e-17
C27 (\5\:A VSS) capacitor c=5.46861e-17
C28 (\3\:M0b VSS) capacitor c=7.36352e-17
C29 (\4\:M0 VSS) capacitor c=5.79648e-17
C30 (\1\:S VSS) capacitor c=2.90609e-17
C31 (\1\:M0 VSS) capacitor c=2.46997e-17
C32 (\6\:X2 VSS) capacitor c=3.71014e-17
C33 (\3\:X2b VSS) capacitor c=3.3467e-17
C34 (\2\:X2 VSS) capacitor c=3.94626e-17
C35 (\5\:M1 VSS) capacitor c=3.34144e-17
C36 (\4\:S VSS) capacitor c=8.3457e-17
C37 (\1\:M1 VSS) capacitor c=4.76448e-17
C38 (\4\:A VSS) capacitor c=2.95317e-17
C39 (\6\:A VSS) capacitor c=2.93899e-17
C40 (\5\:M0 VSS) capacitor c=5.77878e-17
C41 (\3\:S VSS) capacitor c=7.63379e-17
C42 (\3\:M0 VSS) capacitor c=4.62464e-17
C43 (\6\:net293 VSS) capacitor c=2.22152e-17
C44 (\7\:X2 VSS) capacitor c=1.81558e-17
C45 (\1\:X2 VSS) capacitor c=3.1642e-17
C46 (\6\:M1 VSS) capacitor c=2.70097e-17
C47 (\2\:M1b VSS) capacitor c=8.63625e-17
C48 (\6\:S VSS) capacitor c=3.04223e-17
C49 (\4\:M1 VSS) capacitor c=4.99136e-17
C50 (\2\:M1 VSS) capacitor c=2.15507e-17
C51 (\2\:A VSS) capacitor c=2.7715e-17
C52 (\4\:M0b VSS) capacitor c=3.58138e-17
C53 (\6\:M0 VSS) capacitor c=3.16274e-17
C54 (\2\:M0b VSS) capacitor c=3.26941e-17
C55 (\2\:S VSS) capacitor c=5.48357e-17
C56 (\2\:M0 VSS) capacitor c=4.29784e-17
C57 (\1\:VDD VSS) capacitor c=1.87401e-16
C58 (\5\:X2b VSS) capacitor c=3.91558e-17
C59 (\7\:n1 VSS) capacitor c=9.05502e-17
C60 (\15\:net293 VSS) capacitor c=1.50963e-16
C61 (\3\:n0 VSS) capacitor c=2.95593e-16
C62 (\7\:M1b VSS) capacitor c=6.33166e-17
C63 (\16\:VDD VSS) capacitor c=2.40243e-17
C64 (\3\:n1 VSS) capacitor c=3.22252e-16
C65 (\18\:VDD VSS) capacitor c=1.72928e-17
C66 (\6\:n0 VSS) capacitor c=3.10742e-16
C67 (\20\:VDD VSS) capacitor c=1.36952e-17
C68 (\11\:M0b VSS) capacitor c=4.6435e-17
C69 (\3\:VDD VSS) capacitor c=9.05561e-17
C70 (\9\:X2b VSS) capacitor c=2.65736e-17
C71 (\5\:n1 VSS) capacitor c=2.5163e-16
C72 (\17\:net293 VSS) capacitor c=1.01854e-16
C73 (\4\:M1b VSS) capacitor c=5.89671e-17
C74 (\8\:n0 VSS) capacitor c=1.13976e-16
C75 (\8\:M0b VSS) capacitor c=2.0979e-17
C76 (\3\:A VSS) capacitor c=2.92124e-17
C77 (\2\:X2b VSS) capacitor c=3.35976e-17
C78 (\4\:X2 VSS) capacitor c=5.58272e-17
C79 (\7\:M0 VSS) capacitor c=7.30551e-17
C80 (\8\:M0 VSS) capacitor c=5.18334e-17
C81 (\5\:M0b VSS) capacitor c=1.52428e-16
C82 (\6\:M0b VSS) capacitor c=1.38602e-16
C83 (\7\:M0b VSS) capacitor c=4.11995e-17
C84 (\10\:M0b VSS) capacitor c=2.35668e-17
C85 (\7\:A VSS) capacitor c=5.35239e-17
C86 (\7\:S VSS) capacitor c=1.45992e-16
C87 (\8\:S VSS) capacitor c=5.77937e-17
C88 (\8\:M1 VSS) capacitor c=7.78361e-17
C89 (\9\:M1 VSS) capacitor c=8.03732e-17
C90 (\10\:M1 VSS) capacitor c=1.03755e-16
C91 (\6\:M1b VSS) capacitor c=5.06216e-17
C92 (\8\:X2 VSS) capacitor c=1.30922e-16
C93 (\7\:X2b VSS) capacitor c=2.26138e-17
C94 (\8\:X2b VSS) capacitor c=1.87493e-17
C95 (\14\:net293 VSS) capacitor c=1.19189e-16
C96 (\8\:VDD VSS) capacitor c=4.60389e-17
C97 (\9\:VDD VSS) capacitor c=1.592e-17
C98 (\11\:VDD VSS) capacitor c=2.47691e-17
Rk1 (\7\:M0 M0) resistor r=0.5202 c=0
Rk2 (M0 \8\:M0) resistor r=0.2854 c=0
Rk11 (\8\:M1 M1) resistor r=0.3572 c=0
Rk12 (M1 \9\:M1) resistor r=0.01532 c=0
Rk13 (\9\:M1 \10\:M1) resistor r=0.6634 c=0
Rk9 (\7\:S S) resistor r=1.1385 c=0
Rk10 (S \8\:S) resistor r=0.3351 c=0
Rk39 (\1\:VDD \7\:VDD) resistor r=0.2255 c=0
Rk40 (\7\:VDD \8\:VDD) resistor r=0.7037 c=0
Rk41 (\8\:VDD \9\:VDD) resistor r=0.4392 c=0
Rk42 (\9\:VDD \10\:VDD) resistor r=0.05654 c=0
Rk44 (\11\:VDD VDD) resistor r=0.129 c=0
Rk43 (\10\:VDD \11\:VDD) resistor r=0.4202 c=0
Rk47 (\8\:VDD \17\:VDD) resistor r=0.04332 c=0
Rk48 (\9\:VDD \19\:VDD) resistor r=0.04332 c=0
Rk49 (\11\:VDD \21\:VDD) resistor r=0.04332 c=0
Rk21 (\9\:X2 X2) resistor r=0.003305 c=0
Rk20 (\8\:X2 \9\:X2) resistor r=0.6718 c=0
Rk8 (A \7\:A) resistor r=0.03906 c=0
Rk53 (\1\:VSS \7\:VSS) resistor r=0.2406 c=0
Rk54 (\7\:VSS \8\:VSS) resistor r=0.6168 c=0
Rk55 (\8\:VSS \9\:VSS) resistor r=0.5881 c=0
Rk57 (\10\:VSS VSS) resistor r=0.1149 c=0
Rk56 (\9\:VSS \10\:VSS) resistor r=0.4365 c=0
Rk60 (\8\:VSS \16\:VSS) resistor r=0.07405 c=0
Rk61 (\9\:VSS \18\:VSS) resistor r=0.1618 c=0
Rk62 (\10\:VSS \20\:VSS) resistor r=0.1967 c=0
Rk3 (\5\:M0b \6\:M0b) resistor r=1.049 c=0
Rk4 (\6\:M0b \7\:M0b) resistor r=0.3176 c=0
Rk5 (\7\:M0b \9\:M0b) resistor r=0.1435 c=0
Rk6 (\6\:M0b \10\:M0b) resistor r=0.08444 c=0
Rk7 (\7\:M0b \12\:M0b) resistor r=0.325 c=0
Rk16 (\2\:n0 \4\:n0) resistor r=0.3782 c=0
Rk17 (\4\:n0 \5\:n0) resistor r=0.1747 c=0
Rk18 (\5\:n0 \7\:n0) resistor r=1.6976 c=0
Rk19 (\7\:n0 \9\:n0) resistor r=0.6814 c=0
Rk22 (\2\:n1 \4\:n1) resistor r=0.5269 c=0
Rk23 (\4\:n1 \6\:n1) resistor r=1.8847 c=0
Rk24 (\6\:n1 \8\:n1) resistor r=0.511 c=0
Rk14 (\5\:M1b \6\:M1b) resistor r=0.3062 c=0
Rk15 (\5\:M1b \8\:M1b) resistor r=0.2797 c=0
Rk28 (\14\:net293 \16\:net293) resistor r=0.8735 c=0
Rk29 (\16\:net293 \18\:net293) resistor r=0.5134 c=0
Rk25 (\6\:X2b \7\:X2b) resistor r=0.1599 c=0
Rk26 (\7\:X2b \8\:X2b) resistor r=0.07445 c=0
Rk27 (\7\:X2b \10\:X2b) resistor r=0.0638 c=0
Rl6 (\4\:M0 \5\:M0) resistor r=200 c=0
Rl7 (\4\:M0 \6\:M0) resistor r=87.2302 c=0
Rl1 (\1\:M0 \2\:M0) resistor r=24.2328 c=0
Rl2 (\2\:M0 \3\:M0) resistor r=147.31 c=0
Rl21 (\6\:M1 \7\:M1) resistor r=32.4874 c=0
Rl20 (\5\:M1 \6\:M1) resistor r=44.4893 c=0
Rl15 (\3\:M1 \4\:M1) resistor r=35.7713 c=0
Rl14 (\1\:M1 \2\:M1) resistor r=24.2328 c=0
Rl18 (\4\:S \5\:S) resistor r=278.412 c=0
Rl19 (\5\:S \6\:S) resistor r=49.2328 c=0
Rl3 (\1\:S \2\:S) resistor r=65.3618 c=0
Rl4 (\2\:S \3\:S) resistor r=130.564 c=0
Rl29 (\5\:X2 \7\:X2) resistor r=26.1559 c=0
Rl22 (\1\:X2 \2\:X2) resistor r=49.2922 c=0
Rl26 (\3\:X2 \4\:X2) resistor r=28.0797 c=0
Rl27 (\4\:X2 \5\:X2) resistor r=221.58 c=0
Rl28 (\4\:X2 \6\:X2) resistor r=60.772 c=0
Rl9 (\1\:A \2\:A) resistor r=46.1884 c=0
Rl12 (\2\:A \5\:A) resistor r=63.6565 c=0
Rl11 (\3\:A \4\:A) resistor r=105.833 c=0
Rl13 (\3\:A \6\:A) resistor r=155.254 c=0
Rl10 (\2\:A \3\:A) resistor r=11.0904 c=0
Rl8 (\3\:M0b \4\:M0b) resistor r=24.2328 c=0
Rl5 (M0b \2\:M0b) resistor r=73.0541 c=0
Rl17 (\2\:M1b \3\:M1b) resistor r=236.093 c=0
Rl16 (M1b \2\:M1b) resistor r=74.2328 c=0
Rl34 (net293 \6\:net293) resistor r=4.6806 c=0
Rl25 (\2\:X2b \4\:X2b) resistor r=76.1566 c=0
Rl24 (\2\:X2b \3\:X2b) resistor r=28.0797 c=0
Rl23 (X2b \2\:X2b) resistor r=154.219 c=0
Rz11 (\1\:VDD \3\:VDD) resistor r=75 c=0
Rz12 (\7\:VDD \3\:VDD) resistor r=6.25 c=0
Rz13 (\10\:VDD \3\:VDD) resistor r=6.25 c=0
Rz17 (\16\:VSS \15\:VSS) resistor r=75 c=0
Rz18 (\18\:VSS \17\:VSS) resistor r=75 c=0
Rz19 (\20\:VSS \19\:VSS) resistor r=75 c=0
Rz1 (\8\:M0b \9\:M0b) resistor r=75 c=0
Rz3 (n0 \2\:n0) resistor r=75 c=0
Rz4 (\8\:n0 \9\:n0) resistor r=75 c=0
Rz5 (n1 \2\:n1) resistor r=75 c=0
Rz6 (\5\:n1 \6\:n1) resistor r=75 c=0
Rz2 (\4\:M1b \5\:M1b) resistor r=75 c=0
Rz8 (\18\:net293 \17\:net293) resistor r=75 c=0
Rz7 (\9\:X2b \10\:X2b) resistor r=75 c=0
Ry15 (\17\:VDD \16\:VDD) resistor r=62 c=0
Ry16 (\19\:VDD \18\:VDD) resistor r=62 c=0
Ry17 (\21\:VDD \20\:VDD) resistor r=62 c=0
Ry18 (\1\:VSS \3\:VSS) resistor r=62 c=0
Ry19 (\7\:VSS \3\:VSS) resistor r=5.1667 c=0
Ry20 (\9\:VSS \3\:VSS) resistor r=5.1667 c=0
Ry1 (\11\:M0b \12\:M0b) resistor r=62 c=0
Ry3 (\3\:n0 \4\:n0) resistor r=62 c=0
Ry4 (\3\:n0 \5\:n0) resistor r=62 c=0
Ry5 (\6\:n0 \7\:n0) resistor r=62 c=0
Ry6 (\3\:n1 \4\:n1) resistor r=62 c=0
Ry7 (\7\:n1 \8\:n1) resistor r=62 c=0
Ry2 (\7\:M1b \8\:M1b) resistor r=62 c=0
Ry9 (\16\:net293 \15\:net293) resistor r=31 c=0
Ry8 (\5\:X2b \6\:X2b) resistor r=62 c=0
Rx1 (\6\:M0 \7\:M0) resistor r=45 c=0
Rx2 (\2\:M0 \8\:M0) resistor r=45 c=0
Rx8 (\6\:M1 \8\:M1) resistor r=45 c=0
Rx9 (\4\:M1 \9\:M1) resistor r=45 c=0
Rx10 (\2\:M1 \10\:M1) resistor r=45 c=0
Rx6 (\6\:S \7\:S) resistor r=45 c=0
Rx7 (\2\:S \8\:S) resistor r=45 c=0
Rx12 (\1\:X2 \8\:X2) resistor r=45 c=0
Rx13 (\7\:X2 \9\:X2) resistor r=45 c=0
Rx5 (\2\:A \7\:A) resistor r=45 c=0
Rx3 (\4\:M0b \5\:M0b) resistor r=45 c=0
Rx4 (\2\:M0b \10\:M0b) resistor r=45 c=0
Rx11 (\2\:M1b \6\:M1b) resistor r=45 c=0
Rx15 (\14\:net293 \6\:net293) resistor r=45 c=0
Rx14 (X2b \8\:X2b) resistor r=45 c=0
mn0 (\8\:M0b \3\:M0 \19\:VSS VSS) g45n1lvt w=(1.45e-07) l=4.5e-08 nf=1 \
        as=2.32e-14 ad=2.32e-14 ps=6.1e-07 pd=6.1e-07 nrd=1.16667 \
        nrs=1.16667 sa=1.6e-07 sb=2e-06 sd=160n sca=7.09016 scb=0.00401586 \
        scc=3.69756e-05 m=(1)
mn3 (n3 \3\:S \19\:VSS VSS) g45n1lvt w=(1.45e-07) l=4.5e-08 nf=1 \
        as=2.32e-14 ad=8.7e-15 ps=6.1e-07 pd=4.1e-07 nrd=1.16667 \
        nrs=1.16667 sa=3.65e-07 sb=1.905e-06 sd=160n sca=7.09016 \
        scb=0.00401586 scc=3.69756e-05 m=(1)
mn4 (\8\:n0 M0b n3 VSS) g45n1lvt w=(1.45e-07) l=4.5e-08 nf=1 as=8.7e-15 \
        ad=4.205e-14 ps=4.1e-07 pd=8.7e-07 nrd=1.16667 nrs=1.16667 \
        sa=4.7e-07 sb=1.8e-06 sd=160n sca=7.09016 scb=0.00401586 \
        scc=3.69756e-05 m=(1)
mn6 (\8\:n0 \5\:M0 n5 VSS) g45n1lvt w=(1.45e-07) l=4.5e-08 nf=1 \
        as=3.045e-14 ad=4.205e-14 ps=7.1e-07 pd=8.7e-07 nrd=1.16667 \
        nrs=1.16667 sa=8.05e-07 sb=1.465e-06 sd=160n sca=7.09016 \
        scb=0.00401586 scc=3.69756e-05 m=(1)
mn5 (n5 \6\:A \17\:VSS VSS) g45n1lvt w=(1.45e-07) l=4.5e-08 nf=1 \
        as=2.32e-14 ad=3.045e-14 ps=6.1e-07 pd=7.1e-07 nrd=1.16667 \
        nrs=1.16667 sa=1.06e-06 sb=1.21e-06 sd=160n sca=7.09016 \
        scb=0.00401586 scc=3.69756e-05 m=(1)
mn9 (n9 \4\:A \17\:VSS VSS) g45n1lvt w=(1.45e-07) l=4.5e-08 nf=1 \
        as=2.32e-14 ad=2.537e-14 ps=6.1e-07 pd=6.4e-07 nrd=1.16667 \
        nrs=1.16667 sa=1.265e-06 sb=1.005e-06 sd=160n sca=7.09016 \
        scb=0.00401586 scc=3.69756e-05 m=(1)
mn10 (n1 \1\:M1 n9 VSS) g45n1lvt w=(1.45e-07) l=4.5e-08 nf=1 as=2.537e-14 \
        ad=6.67e-14 ps=6.4e-07 pd=1.21e-06 nrd=1.16667 nrs=1.16667 \
        sa=1.485e-06 sb=7.85e-07 sd=160n sca=7.09016 scb=0.00401586 \
        scc=3.69756e-05 m=(1)
mn8 (n1 M1b n7 VSS) g45n1lvt w=(1.45e-07) l=4.5e-08 nf=1 as=1.957e-14 \
        ad=6.67e-14 ps=5.6e-07 pd=1.21e-06 nrd=1.16667 nrs=1.16667 \
        sa=1.99e-06 sb=2.8e-07 sd=160n sca=7.09016 scb=0.00401586 \
        scc=3.69756e-05 m=(1)
mn7 (n7 \4\:S \15\:VSS VSS) g45n1lvt w=(1.45e-07) l=4.5e-08 nf=1 \
        as=5.19e-14 ad=1.957e-14 ps=1.6e-06 pd=5.6e-07 nrd=1.16667 \
        nrs=1.16667 sa=2e-06 sb=1e-07 sd=160n sca=7.09016 scb=0.00401586 \
        scc=3.69756e-05 m=(1)
mn1 (\4\:M1b \5\:M1 \15\:VSS VSS) g45n1lvt w=(1.45e-07) l=4.5e-08 nf=1 \
        as=5.19e-14 ad=2.03e-14 ps=1.6e-06 pd=5.7e-07 nrd=1.16667 \
        nrs=1.16667 sa=1e-07 sb=1.4e-07 sd=160n sca=23.279 scb=0.0230742 \
        scc=0.00267719 m=(1)
mn2 (\9\:X2b \6\:X2 \1\:VSS VSS) g45n1lvt w=(1.45e-07) l=4.5e-08 nf=1 \
        as=3.47e-14 ad=2.03e-14 ps=8.4e-07 pd=5.7e-07 nrd=1.16667 \
        nrs=1.16667 sa=1.4e-07 sb=9.6e-07 sd=160n sca=23.279 scb=0.0230742 \
        scc=0.00267719 m=(1)
mn11 (\17\:net293 \2\:X2 n0 VSS) g45n1lvt w=(2.6e-07) l=4.5e-08 nf=1 \
        as=3.64e-14 ad=4.16e-14 ps=8e-07 pd=8.4e-07 nrd=1.16667 \
        nrs=1.16667 sa=1.4e-07 sb=3.30385e-07 sd=160n sca=15.3338 \
        scb=0.0153436 scc=0.00119435 m=(1)
mn12 (\5\:n1 \3\:X2b \17\:net293 VSS) g45n1lvt w=(2.6e-07) l=4.5e-08 nf=1 \
        as=4.16e-14 ad=3.26e-14 ps=8.4e-07 pd=8.3e-07 nrd=1.16667 \
        nrs=1.16667 sa=3.45e-07 sb=1.25385e-07 sd=160n sca=15.3338 \
        scb=0.0153436 scc=0.00119435 m=(1)
mn13_1__rcx (PPN net293 \1\:VSS VSS) g45n1lvt w=(2.6e-07) l=4.5e-08 nf=1 \
        as=3.858e-14 ad=4.16e-14 ps=8.3e-07 pd=8.4e-07 nrd=1.16667 \
        nrs=1.16667 sa=2.36635e-07 sb=7.55e-07 sd=160n sca=17.5885 \
        scb=0.0172826 scc=0.00162584 m=(4)
mp11 (\15\:net293 \4\:X2b \3\:n0 VDD) g45p1lvt w=(3.9e-07) l=4.5e-08 nf=1 \
        as=9.945e-14 ad=6.24e-14 ps=1.29e-06 pd=1.1e-06 nrd=1.16667 \
        nrs=1.16667 sa=2.55e-07 sb=3.45e-07 sd=160n sca=24.4353 \
        scb=0.0186618 scc=0.00260099 m=(1)
mp12 (\7\:n1 \5\:X2 \15\:net293 VDD) g45p1lvt w=(3.9e-07) l=4.5e-08 nf=1 \
        as=6.24e-14 ad=5.46e-14 ps=1.1e-06 pd=1.06e-06 nrd=1.16667 \
        nrs=1.16667 sa=4.6e-07 sb=1.4e-07 sd=160n sca=24.4353 \
        scb=0.0186618 scc=0.00260099 m=(1)
mp13_1__rcx (PPN net293 \1\:VDD VDD) g45p1lvt w=(3.9e-07) l=4.5e-08 nf=1 \
        as=6.136e-14 ad=6.24e-14 ps=1.1825e-06 pd=1.1e-06 nrd=1.16667 \
        nrs=1.16667 sa=2.35962e-07 sb=7.55e-07 sd=160n sca=30.8435 \
        scb=0.0202998 scc=0.00336099 m=(4)
ends BMXIX4
// End of subcircuit definition.
