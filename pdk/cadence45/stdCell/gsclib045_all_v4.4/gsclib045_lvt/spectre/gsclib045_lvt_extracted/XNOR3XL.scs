// Generated for: spectre (May  1 09:19:45 2013 )
// Library name: gsclib045_lvt
// Cell name: XNOR3XL
// View name: extracted

simulator lang=spectre

subckt XNOR3XL A B C VDD VSS Y
mp3 (\14\:n62 \1\:A \7\:VDD VDD) g45p1lvt w=(3.1e-07) l=4.5e-08 nf=1 \
        as=1.085e-13 ad=4.34e-14 ps=1.7e-06 pd=9e-07 nrd=1.16667 \
        nrs=1.16667 sa=1.4e-07 sb=5.2e-07 sd=160n sca=24.5071 \
        scb=0.0280884 scc=0.00153635 m=(1)
mp4 (\16\:n61 \8\:B \7\:VDD VDD) g45p1lvt w=(3.1e-07) l=4.5e-08 nf=1 \
        as=1.085e-13 ad=7.595e-14 ps=1.7e-06 pd=1.11e-06 nrd=1.16667 \
        nrs=1.16667 sa=4.15e-07 sb=2.45e-07 sd=160n sca=16.826 \
        scb=0.0155728 scc=0.000870508 m=(1)
mp9 (\6\:n8 \3\:n62 \9\:VDD VDD) g45p1lvt w=(3.1e-07) l=4.5e-08 nf=1 \
        as=7.07e-14 ad=6.82e-14 ps=1.26e-06 pd=1.06e-06 nrd=1.16667 \
        nrs=1.16667 sa=1.7e-07 sb=7.61774e-07 sd=160n sca=10.5719 \
        scb=0.0081746 scc=0.000117241 m=(1)
mp1 (\6\:n8 n61 n9 VDD) g45p1lvt w=(3.1e-07) l=4.5e-08 nf=1 as=9.18e-14 \
        ad=6.82e-14 ps=1.64e-06 pd=1.06e-06 nrd=1.16667 nrs=1.16667 \
        sa=4.35e-07 sb=4.96774e-07 sd=160n sca=10.5719 scb=0.0081746 \
        scc=0.000117241 m=(1)
mp2 (\7\:n62 \3\:B n9 VDD) g45p1lvt w=(3.1e-07) l=4.5e-08 nf=1 \
        as=9.18e-14 ad=6.355e-14 ps=1.64e-06 pd=1.03e-06 nrd=1.16667 \
        nrs=1.16667 sa=4.26452e-07 sb=5.65242e-07 sd=160n sca=14.8314 \
        scb=0.0138806 scc=0.000865287 m=(1)
mp11 (\7\:n62 \4\:n61 \8\:n12 VDD) g45p1lvt w=(3.1e-07) l=4.5e-08 nf=1 \
        as=6.415e-14 ad=6.355e-14 ps=1.21e-06 pd=1.03e-06 nrd=1.16667 \
        nrs=1.16667 sa=6.76452e-07 sb=3.15242e-07 sd=160n sca=14.8314 \
        scb=0.0138806 scc=0.000865287 m=(1)
mp10 (\4\:n8 \2\:B \8\:n12 VDD) g45p1lvt w=(3.1e-07) l=4.5e-08 nf=1 \
        as=6.415e-14 ad=5.93e-14 ps=1.21e-06 pd=1.07e-06 nrd=1.16667 \
        nrs=1.16667 sa=7.23468e-07 sb=1.7e-07 sd=160n sca=10.9702 \
        scb=0.00883933 scc=0.000174052 m=(1)
mp6 (\5\:n9 \3\:n60 \8\:n11 VDD) g45p1lvt w=(3.1e-07) l=4.5e-08 nf=1 \
        as=4.96e-14 ad=1.055e-13 ps=9.4e-07 pd=1.46e-06 nrd=1.16667 \
        nrs=1.16667 sa=2.9e-07 sb=3.75e-07 sd=160n sca=14.8314 \
        scb=0.0138806 scc=0.000865287 m=(1)
mp5 (\3\:n12 \7\:C \8\:n11 VDD) g45p1lvt w=(3.1e-07) l=4.5e-08 nf=1 \
        as=4.96e-14 ad=5.27e-14 ps=9.4e-07 pd=9.6e-07 nrd=1.16667 \
        nrs=1.16667 sa=4.95e-07 sb=1.7e-07 sd=160n sca=14.8314 \
        scb=0.0138806 scc=0.000865287 m=(1)
mp7 (\5\:n60 \3\:C \1\:VDD VDD) g45p1lvt w=(3.1e-07) l=4.5e-08 nf=1 \
        as=1.265e-13 ad=5.27e-14 ps=1.85e-06 pd=9.6e-07 nrd=1.16667 \
        nrs=1.16667 sa=1.7e-07 sb=4.30242e-07 sd=160n sca=16.2999 \
        scb=0.0148905 scc=0.000867022 m=(1)
C1 (B VSS) capacitor c=6.80083e-17
C2 (A VSS) capacitor c=7.43427e-17
C3 (VDD VSS) capacitor c=3.44831e-16
C4 (C VSS) capacitor c=4.1704e-17
C5 (n62 VSS) capacitor c=7.11225e-17
C6 (n61 VSS) capacitor c=6.31146e-17
C7 (n8 VSS) capacitor c=7.51274e-17
C8 (n9 VSS) capacitor c=3.11911e-16
C9 (n12 VSS) capacitor c=7.43811e-17
C10 (n11 VSS) capacitor c=2.57878e-17
C11 (n60 VSS) capacitor c=4.5807e-17
C12 (\3\:C VSS) capacitor c=2.90607e-17
C13 (\7\:C VSS) capacitor c=3.50857e-17
C14 (\3\:n60 VSS) capacitor c=6.82021e-17
C15 (\2\:B VSS) capacitor c=1.00432e-16
C16 (\4\:n61 VSS) capacitor c=7.10522e-17
C17 (\3\:B VSS) capacitor c=9.42401e-17
C18 (\3\:n62 VSS) capacitor c=4.57291e-17
C19 (\8\:B VSS) capacitor c=5.01902e-17
C20 (\1\:A VSS) capacitor c=4.23357e-17
C21 (\3\:n11 VSS) capacitor c=2.77589e-17
C22 (\6\:C VSS) capacitor c=4.51524e-17
C23 (\4\:n60 VSS) capacitor c=3.67992e-17
C24 (\1\:C VSS) capacitor c=4.04835e-17
C25 (\10\:n61 VSS) capacitor c=5.55351e-17
C26 (\1\:B VSS) capacitor c=1.03974e-16
C27 (\9\:n61 VSS) capacitor c=2.37092e-17
C28 (\6\:B VSS) capacitor c=3.82956e-17
C29 (\7\:B VSS) capacitor c=3.58637e-17
C30 (\4\:A VSS) capacitor c=3.03162e-17
C31 (\2\:n11 VSS) capacitor c=2.09504e-17
C32 (\5\:C VSS) capacitor c=5.75866e-17
C33 (\2\:C VSS) capacitor c=2.4221e-17
C34 (\2\:n8 VSS) capacitor c=7.9545e-17
C35 (\11\:n61 VSS) capacitor c=4.0297e-17
C36 (\7\:n61 VSS) capacitor c=2.51989e-17
C37 (\2\:n61 VSS) capacitor c=8.07537e-17
C38 (\4\:n62 VSS) capacitor c=2.891e-17
C39 (\2\:n62 VSS) capacitor c=5.0723e-17
C40 (\3\:n61 VSS) capacitor c=6.89989e-17
C41 (\5\:B VSS) capacitor c=8.44512e-17
C42 (\3\:A VSS) capacitor c=1.31466e-17
C43 (\1\:Y VSS) capacitor c=3.59021e-17
C44 (\1\:VDD VSS) capacitor c=8.71473e-17
C45 (\5\:n60 VSS) capacitor c=6.51648e-17
C46 (\3\:n12 VSS) capacitor c=1.45275e-16
C47 (\8\:n11 VSS) capacitor c=9.58654e-17
C48 (\5\:n9 VSS) capacitor c=2.36861e-16
C49 (\4\:n8 VSS) capacitor c=1.27877e-16
C50 (\8\:n12 VSS) capacitor c=6.83969e-17
C51 (\7\:n62 VSS) capacitor c=1.5597e-16
C52 (\6\:n8 VSS) capacitor c=1.04556e-16
C53 (\9\:VDD VSS) capacitor c=1.0529e-17
C54 (\16\:n61 VSS) capacitor c=6.90032e-17
C55 (\7\:VDD VSS) capacitor c=4.0424e-17
C56 (\14\:n62 VSS) capacitor c=2.69317e-17
C57 (\3\:VDD VSS) capacitor c=1.54697e-16
C58 (\3\:Y VSS) capacitor c=5.09216e-17
C59 (\8\:n60 VSS) capacitor c=4.83363e-17
C60 (\6\:n11 VSS) capacitor c=9.11801e-17
C61 (\8\:n9 VSS) capacitor c=5.50551e-17
C62 (\9\:n8 VSS) capacitor c=1.27726e-16
C63 (\6\:n12 VSS) capacitor c=1.01194e-16
C64 (\5\:n62 VSS) capacitor c=9.30211e-17
C65 (\3\:n9 VSS) capacitor c=1.12753e-16
C66 (\11\:n8 VSS) capacitor c=1.40467e-16
C67 (\14\:n61 VSS) capacitor c=5.74085e-17
C68 (\11\:n62 VSS) capacitor c=1.16932e-16
C69 (\2\:A VSS) capacitor c=1.99891e-17
C70 (\5\:n61 VSS) capacitor c=4.78755e-17
C71 (\6\:n61 VSS) capacitor c=2.53724e-17
C72 (\4\:B VSS) capacitor c=1.55453e-16
C73 (\2\:n60 VSS) capacitor c=4.93801e-17
C74 (\4\:C VSS) capacitor c=3.87849e-17
C75 (\5\:A VSS) capacitor c=3.65661e-17
C76 (\9\:B VSS) capacitor c=4.75994e-17
C77 (\12\:n61 VSS) capacitor c=1.02811e-17
C78 (\13\:n61 VSS) capacitor c=4.20573e-17
C79 (\18\:n61 VSS) capacitor c=6.24628e-17
C80 (\19\:n61 VSS) capacitor c=6.61654e-17
C81 (\9\:n62 VSS) capacitor c=1.33378e-16
C82 (\10\:n62 VSS) capacitor c=1.64099e-16
C83 (\13\:n62 VSS) capacitor c=7.37082e-17
C84 (\20\:n61 VSS) capacitor c=4.17144e-17
C85 (\21\:n61 VSS) capacitor c=5.86403e-17
C86 (\3\:n8 VSS) capacitor c=5.21822e-17
C87 (\8\:n8 VSS) capacitor c=2.14728e-17
C88 (\8\:C VSS) capacitor c=3.04943e-17
C89 (\9\:C VSS) capacitor c=3.66184e-17
C90 (\5\:n12 VSS) capacitor c=1.66591e-16
C91 (\7\:n60 VSS) capacitor c=4.30346e-17
C92 (\4\:n11 VSS) capacitor c=3.85109e-17
C93 (\5\:n11 VSS) capacitor c=1.9163e-16
C94 (\6\:VDD VSS) capacitor c=1.28389e-17
Rk2 (B \9\:B) resistor r=0.07476 c=0
Rk1 (\5\:A A) resistor r=0.08124 c=0
Rk32 (\2\:Y Y) resistor r=0.2806 c=0
Rk33 (Y \4\:Y) resistor r=0.03227 c=0
Rk34 (\2\:VDD \4\:VDD) resistor r=0.5553 c=0
Rk35 (\4\:VDD \5\:VDD) resistor r=1.1034 c=0
Rk37 (\6\:VDD VDD) resistor r=0.2895 c=0
Rk36 (\5\:VDD \6\:VDD) resistor r=0.05904 c=0
Rk38 (VDD \8\:VDD) resistor r=0.1989 c=0
Rk39 (\6\:VDD \10\:VDD) resistor r=0.04331 c=0
Rk40 (\2\:VSS \4\:VSS) resistor r=0.5469 c=0
Rk41 (\4\:VSS \5\:VSS) resistor r=1.1034 c=0
Rk43 (\6\:VSS VSS) resistor r=0.2519 c=0
Rk42 (\5\:VSS \6\:VSS) resistor r=0.09666 c=0
Rk44 (VSS \8\:VSS) resistor r=0.122 c=0
Rk45 (\6\:VSS \10\:VSS) resistor r=0.04331 c=0
Rk21 (\8\:C C) resistor r=0.1487 c=0
Rk22 (C \9\:C) resistor r=0.1626 c=0
Rk8 (\6\:n62 \8\:n62) resistor r=0.5309 c=0
Rk9 (\8\:n62 \9\:n62) resistor r=0.7002 c=0
Rk10 (\9\:n62 \10\:n62) resistor r=0.7521 c=0
Rk11 (\10\:n62 \12\:n62) resistor r=0.6936 c=0
Rk12 (\12\:n62 \13\:n62) resistor r=0.5851 c=0
Rk13 (\10\:n62 \15\:n62) resistor r=0.113 c=0
Rk3 (\12\:n61 \13\:n61) resistor r=0.03536 c=0
Rk4 (\13\:n61 \15\:n61) resistor r=0.2047 c=0
Rk5 (\13\:n61 \17\:n61) resistor r=0.2322 c=0
Rk7 (\18\:n61 \19\:n61) resistor r=0.2584 c=0
Rk14 (\20\:n61 \21\:n61) resistor r=0.1661 c=0
Rk15 (\3\:n8 \5\:n8) resistor r=0.2376 c=0
Rk16 (\5\:n8 \7\:n8) resistor r=0.7362 c=0
Rk17 (\8\:n8 \10\:n8) resistor r=0.1186 c=0
Rk18 (\10\:n8 \12\:n8) resistor r=0.9606 c=0
Rk6 (\2\:n9 \4\:n9) resistor r=0.8462 c=0
Rk19 (\6\:n9 \7\:n9) resistor r=1.0098 c=0
Rk20 (\9\:n9 \10\:n9) resistor r=0.4429 c=0
Rk23 (\2\:n12 \4\:n12) resistor r=0.3763 c=0
Rk24 (\4\:n12 \5\:n12) resistor r=0.7219 c=0
Rk25 (\5\:n12 \7\:n12) resistor r=0.6327 c=0
Rk26 (\5\:n12 \9\:n12) resistor r=0.339 c=0
Rk29 (\4\:n11 \5\:n11) resistor r=0.1546 c=0
Rk30 (\5\:n11 \7\:n11) resistor r=0.8123 c=0
Rk31 (\5\:n11 \9\:n11) resistor r=0.7381 c=0
Rk27 (\6\:n60 \7\:n60) resistor r=0.1817 c=0
Rk28 (\7\:n60 \9\:n60) resistor r=0.09164 c=0
Rl14 (\2\:B \3\:B) resistor r=284.181 c=0
Rl13 (\1\:B \2\:B) resistor r=244.165 c=0
Rl19 (\5\:B \8\:B) resistor r=97.3098 c=0
Rl18 (\5\:B \7\:B) resistor r=30.0021 c=0
Rl15 (\3\:B \4\:B) resistor r=241.851 c=0
Rl17 (\4\:B \6\:B) resistor r=57.3738 c=0
Rl16 (\4\:B \5\:B) resistor r=336.808 c=0
Rl1 (\1\:A \2\:A) resistor r=107.406 c=0
Rl3 (\2\:A \4\:A) resistor r=34.3295 c=0
Rl2 (\2\:A \3\:A) resistor r=8.3038 c=0
Rl29 (\5\:C \7\:C) resistor r=26.1559 c=0
Rl22 (\1\:C \2\:C) resistor r=47.59 c=0
Rl26 (\3\:C \4\:C) resistor r=28.0797 c=0
Rl28 (\4\:C \6\:C) resistor r=103.08 c=0
Rl27 (\4\:C \5\:C) resistor r=172.554 c=0
Rl5 (\3\:n62 \4\:n62) resistor r=132.902 c=0
Rl4 (n62 \2\:n62) resistor r=221.411 c=0
Rl20 (\10\:n61 \11\:n61) resistor r=47.3097 c=0
Rl6 (n61 \2\:n61) resistor r=135.771 c=0
Rl7 (\2\:n61 \3\:n61) resistor r=213.948 c=0
Rl8 (\4\:n61 \5\:n61) resistor r=98.7765 c=0
Rl11 (\5\:n61 \8\:n61) resistor r=17.233 c=0
Rl12 (\6\:n61 \9\:n61) resistor r=34.3295 c=0
Rl10 (\6\:n61 \7\:n61) resistor r=8.3038 c=0
Rl9 (\5\:n61 \6\:n61) resistor r=101.615 c=0
Rl21 (n8 \2\:n8) resistor r=176.032 c=0
Rl30 (n11 \2\:n11) resistor r=41.5405 c=0
Rl31 (\2\:n11 \3\:n11) resistor r=64.6174 c=0
Rl24 (\2\:n60 \3\:n60) resistor r=159.593 c=0
Rl25 (\2\:n60 \4\:n60) resistor r=70.8353 c=0
Rl23 (n60 \2\:n60) resistor r=106.101 c=0
Rz12 (\3\:Y \4\:Y) resistor r=75 c=0
Rz13 (\3\:VDD \4\:VDD) resistor r=7.5 c=0
Rz14 (\3\:VDD \5\:VDD) resistor r=6.25 c=0
Rz15 (\1\:VSS \2\:VSS) resistor r=18.75 c=0
Rz16 (\7\:VSS \8\:VSS) resistor r=75 c=0
Rz17 (\9\:VSS \10\:VSS) resistor r=75 c=0
Rz3 (\5\:n62 \6\:n62) resistor r=75 c=0
Rz4 (\11\:n62 \12\:n62) resistor r=75 c=0
Rz1 (\14\:n61 \15\:n61) resistor r=75 c=0
Rz5 (\9\:n8 \10\:n8) resistor r=75 c=0
Rz6 (\11\:n8 \12\:n8) resistor r=75 c=0
Rz2 (\3\:n9 \4\:n9) resistor r=75 c=0
Rz7 (\8\:n9 \9\:n9) resistor r=75 c=0
Rz8 (n12 \2\:n12) resistor r=75 c=0
Rz9 (\6\:n12 \7\:n12) resistor r=75 c=0
Rz11 (\6\:n11 \7\:n11) resistor r=75 c=0
Rz10 (\8\:n60 \9\:n60) resistor r=75 c=0
Ry14 (\1\:Y \2\:Y) resistor r=62 c=0
Ry15 (\1\:VDD \2\:VDD) resistor r=12.4 c=0
Ry16 (\7\:VDD \8\:VDD) resistor r=31 c=0
Ry17 (\9\:VDD \10\:VDD) resistor r=62 c=0
Ry18 (\3\:VSS \4\:VSS) resistor r=6.2 c=0
Ry19 (\3\:VSS \5\:VSS) resistor r=5.1667 c=0
Ry3 (\7\:n62 \8\:n62) resistor r=62 c=0
Ry4 (\14\:n62 \15\:n62) resistor r=62 c=0
Ry1 (\16\:n61 \17\:n61) resistor r=62 c=0
Ry5 (\4\:n8 \5\:n8) resistor r=62 c=0
Ry6 (\6\:n8 \7\:n8) resistor r=62 c=0
Ry2 (n9 \2\:n9) resistor r=62 c=0
Ry7 (\5\:n9 \6\:n9) resistor r=62 c=0
Ry8 (n9 \7\:n9) resistor r=62 c=0
Ry9 (\5\:n9 \10\:n9) resistor r=62 c=0
Ry10 (\3\:n12 \4\:n12) resistor r=62 c=0
Ry11 (\8\:n12 \9\:n12) resistor r=62 c=0
Ry13 (\8\:n11 \9\:n11) resistor r=62 c=0
Ry12 (\5\:n60 \6\:n60) resistor r=62 c=0
Rx2 (\5\:B \9\:B) resistor r=45 c=0
Rx1 (\3\:A \5\:A) resistor r=45 c=0
Rx12 (\5\:C \8\:C) resistor r=45 c=0
Rx13 (\2\:C \9\:C) resistor r=45 c=0
Rx6 (\4\:n62 \9\:n62) resistor r=45 c=0
Rx7 (\2\:n62 \13\:n62) resistor r=45 c=0
Rx3 (\3\:n61 \12\:n61) resistor r=45 c=0
Rx4 (\2\:n61 \18\:n61) resistor r=45 c=0
Rx5 (\7\:n61 \19\:n61) resistor r=45 c=0
Rx8 (\11\:n61 \20\:n61) resistor r=45 c=0
Rx9 (\8\:n61 \21\:n61) resistor r=45 c=0
Rx10 (n8 \3\:n8) resistor r=45 c=0
Rx11 (\2\:n8 \8\:n8) resistor r=45 c=0
Rx15 (\2\:n11 \4\:n11) resistor r=45 c=0
Rx14 (n60 \7\:n60) resistor r=45 c=0
mn3 (\11\:n62 \4\:A \7\:VSS VSS) g45n1lvt w=(2.05e-07) l=4.5e-08 nf=1 \
        as=8.54e-14 ad=3.485e-14 ps=1.54e-06 pd=7.5e-07 nrd=1.16667 \
        nrs=1.16667 sa=1.7e-07 sb=4.19756e-07 sd=160n sca=15.0894 \
        scb=0.0156086 scc=0.00108313 m=(1)
mn10 (\6\:n12 \10\:n61 \9\:n8 VSS) g45n1lvt w=(2.05e-07) l=4.5e-08 nf=1 \
        as=4.565e-14 ad=3.82e-14 ps=9.3e-07 pd=7.9e-07 nrd=1.16667 \
        nrs=1.16667 sa=1.32634e-06 sb=1.7e-07 sd=160n sca=8.54927 \
        scb=0.00659983 scc=0.000133988 m=(1)
mn8 (\3\:Y \3\:n11 \1\:VSS VSS) g45n1lvt w=(2.05e-07) l=4.5e-08 nf=1 \
        as=1.055e-13 ad=3.485e-14 ps=1.77e-06 pd=7.5e-07 nrd=1.16667 \
        nrs=1.16667 sa=4.9439e-07 sb=1.7e-07 sd=160n sca=19.867 \
        scb=0.0198061 scc=0.00201945 m=(1)
mn4 (\14\:n61 \7\:B \7\:VSS VSS) g45n1lvt w=(1.9e-07) l=4.5e-08 nf=1 \
        as=8.54e-14 ad=3.23e-14 ps=1.54e-06 pd=7.2e-07 nrd=1.16667 \
        nrs=1.16667 sa=4.45e-07 sb=1.7e-07 sd=160n sca=14.2386 \
        scb=0.0147775 scc=0.000909887 m=(1)
mn9 (\11\:n8 n62 \9\:VSS VSS) g45n1lvt w=(1.9e-07) l=4.5e-08 nf=1 \
        as=5.75e-14 ad=5.26e-14 ps=1.14e-06 pd=1e-06 nrd=1.16667 \
        nrs=1.16667 sa=1.7e-07 sb=1.42e-06 sd=160n sca=8.3036 \
        scb=0.00616975 scc=0.000110509 m=(1)
mn1 (\3\:n9 \6\:B \11\:n8 VSS) g45n1lvt w=(1.9e-07) l=4.5e-08 nf=1 \
        as=5.26e-14 ad=7.6e-14 ps=1e-06 pd=1.18e-06 nrd=1.16667 \
        nrs=1.16667 sa=4.35e-07 sb=1.155e-06 sd=160n sca=8.3036 \
        scb=0.00616975 scc=0.000110509 m=(1)
mn2 (\3\:n9 \9\:n61 \5\:n62 VSS) g45n1lvt w=(1.9e-07) l=4.5e-08 nf=1 \
        as=4.94e-14 ad=7.6e-14 ps=9e-07 pd=1.18e-06 nrd=1.16667 \
        nrs=1.16667 sa=8.8e-07 sb=7.1e-07 sd=160n sca=8.3036 \
        scb=0.00616975 scc=0.000110509 m=(1)
mn11 (\6\:n12 \1\:B \5\:n62 VSS) g45n1lvt w=(1.9e-07) l=4.5e-08 nf=1 \
        as=4.94e-14 ad=3.82e-14 ps=9e-07 pd=7.9e-07 nrd=1.16667 \
        nrs=1.16667 sa=1.185e-06 sb=4.05e-07 sd=160n sca=8.3036 \
        scb=0.00616975 scc=0.000110509 m=(1)
mn6 (\6\:n11 \1\:C \8\:n9 VSS) g45n1lvt w=(1.9e-07) l=4.5e-08 nf=1 \
        as=3.23e-14 ad=4.18e-14 ps=7.2e-07 pd=8.2e-07 nrd=1.16667 \
        nrs=1.16667 sa=1.7e-07 sb=4.35e-07 sd=160n sca=11.8451 \
        scb=0.0117279 scc=0.00051251 m=(1)
mn5 (\6\:n11 \4\:n60 n12 VSS) g45n1lvt w=(1.9e-07) l=4.5e-08 nf=1 \
        as=4.31e-14 ad=4.18e-14 ps=9e-07 pd=8.2e-07 nrd=1.16667 \
        nrs=1.16667 sa=4.35e-07 sb=1.7e-07 sd=160n sca=11.8451 \
        scb=0.0117279 scc=0.00051251 m=(1)
mn7 (\8\:n60 \6\:C \1\:VSS VSS) g45n1lvt w=(1.9e-07) l=4.5e-08 nf=1 \
        as=1.055e-13 ad=3.23e-14 ps=1.77e-06 pd=7.2e-07 nrd=1.16667 \
        nrs=1.16667 sa=1.7e-07 sb=5.2e-07 sd=160n sca=20.6114 \
        scb=0.0205722 scc=0.00215666 m=(1)
mp8 (\1\:Y n11 \1\:VDD VDD) g45p1lvt w=(2.05e-07) l=4.5e-08 nf=1 \
        as=1.265e-13 ad=3.485e-14 ps=1.85e-06 pd=7.5e-07 nrd=1.16667 \
        nrs=1.16667 sa=5.2e-07 sb=1.7e-07 sd=160n sca=28.0221 scb=0.032906 \
        scc=0.00213116 m=(1)
ends XNOR3XL
// End of subcircuit definition.
