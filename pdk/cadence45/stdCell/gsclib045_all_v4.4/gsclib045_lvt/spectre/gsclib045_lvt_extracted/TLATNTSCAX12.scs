// Generated for: spectre (May  1 09:19:17 2013 )
// Library name: gsclib045_lvt
// Cell name: TLATNTSCAX12
// View name: extracted

simulator lang=spectre

subckt TLATNTSCAX12 CK E ECK SE VDD VSS
mp1 (\5\:Eb \1\:E net246 VDD) g45p1lvt w=(2.15e-07) l=4.5e-08 nf=1 \
        as=1.29e-14 ad=3.01e-14 ps=5.5e-07 pd=7.1e-07 nrd=1.16667 \
        nrs=1.16667 sa=1.4e-07 sb=5.65e-07 sd=160n sca=16.4413 \
        scb=0.0164604 scc=0.000341327 m=(1)
mp0 (net246 \1\:SE \36\:VDD VDD) g45p1lvt w=(2.15e-07) l=4.5e-08 nf=1 \
        as=3.548e-14 ad=1.29e-14 ps=7.6e-07 pd=5.5e-07 nrd=1.16667 \
        nrs=1.16667 sa=2.45e-07 sb=4.6e-07 sd=160n sca=14.2155 \
        scb=0.0125694 scc=0.000239267 m=(1)
mp2 (\14\:CKb \3\:CK \36\:VDD VDD) g45p1lvt w=(2.15e-07) l=4.5e-08 nf=1 \
        as=3.548e-14 ad=5.375e-14 ps=7.6e-07 pd=9.3e-07 nrd=1.16667 \
        nrs=1.16667 sa=4.55e-07 sb=2.5e-07 sd=160n sca=12.3184 \
        scb=0.0100356 scc=0.000221045 m=(1)
mp5 (\5\:n5 \3\:CKbb \7\:Eb VDD) g45p1lvt w=(2.15e-07) l=4.5e-08 nf=1 \
        as=4.085e-14 ad=3.44e-14 ps=8.1e-07 pd=7.5e-07 nrd=1.16667 \
        nrs=1.16667 sa=1.9e-07 sb=8.6e-07 sd=160n sca=10.2815 \
        scb=0.00760864 scc=8.81378e-05 m=(1)
mp16 (\5\:n5 \3\:CKb net234 VDD) g45p1lvt w=(2.15e-07) l=4.5e-08 nf=1 \
        as=1.29e-14 ad=3.44e-14 ps=5.5e-07 pd=7.5e-07 nrd=1.16667 \
        nrs=1.16667 sa=3.95e-07 sb=6.55e-07 sd=160n sca=10.2815 \
        scb=0.00760864 scc=8.81378e-05 m=(1)
mp15 (net234 Eint \34\:VDD VDD) g45p1lvt w=(2.15e-07) l=4.5e-08 nf=1 \
        as=1.0667e-13 ad=1.29e-14 ps=1.63e-06 pd=5.5e-07 nrd=1.16667 \
        nrs=1.16667 sa=5e-07 sb=5.5e-07 sd=160n sca=10.2815 scb=0.00760864 \
        scc=8.81378e-05 m=(1)
mp3 (\19\:CKbb \5\:CKb \34\:VDD VDD) g45p1lvt w=(2.15e-07) l=4.5e-08 \
        nf=1 as=1.0667e-13 ad=3.01e-14 ps=1.63e-06 pd=7.1e-07 nrd=1.16667 \
        nrs=1.16667 sa=9.1e-07 sb=1.4e-07 sd=160n sca=10.2815 \
        scb=0.00760864 scc=8.81378e-05 m=(1)
C1 (CK VSS) capacitor c=8.95505e-17
C2 (VDD VSS) capacitor c=3.60021e-16
C3 (SE VSS) capacitor c=1.34944e-16
C4 (ECK VSS) capacitor c=9.77948e-16
C5 (E VSS) capacitor c=3.86626e-17
C6 (Eb VSS) capacitor c=7.90184e-17
C7 (CKb VSS) capacitor c=2.83599e-17
C8 (n5 VSS) capacitor c=5.15547e-17
C9 (net263 VSS) capacitor c=9.54971e-20
C10 (CKbb VSS) capacitor c=5.15934e-17
C11 (Eint VSS) capacitor c=9.08193e-17
C12 (16 VSS) capacitor c=2.31897e-18
C13 (ECKb VSS) capacitor c=5.14329e-16
C14 (17 VSS) capacitor c=1.81972e-18
C15 (18 VSS) capacitor c=1.81972e-18
C16 (net234 VSS) capacitor c=1.57238e-18
C17 (\5\:CKbb VSS) capacitor c=5.64245e-16
C18 (\3\:n5 VSS) capacitor c=3.67683e-17
C19 (\5\:CKb VSS) capacitor c=5.85611e-17
C20 (\3\:CKb VSS) capacitor c=6.51976e-17
C21 (\3\:CKbb VSS) capacitor c=6.6579e-17
C22 (\3\:CK VSS) capacitor c=5.28082e-17
C23 (\1\:SE VSS) capacitor c=8.60065e-17
C24 (\1\:E VSS) capacitor c=9.51576e-17
C25 (\13\:CKbb VSS) capacitor c=5.72202e-17
C26 (\13\:Eint VSS) capacitor c=4.71328e-17
C27 (\12\:Eint VSS) capacitor c=4.70981e-17
C28 (\9\:CKbb VSS) capacitor c=4.4582e-17
C29 (\8\:CKbb VSS) capacitor c=3.26598e-17
C30 (\5\:Eint VSS) capacitor c=5.48508e-17
C31 (\6\:CKb VSS) capacitor c=5.88101e-17
C32 (\3\:Eint VSS) capacitor c=8.77237e-17
C33 (\1\:CK VSS) capacitor c=2.66958e-17
C34 (\3\:SE VSS) capacitor c=3.97085e-17
C35 (\4\:E VSS) capacitor c=2.70068e-17
C36 (\12\:ECKb VSS) capacitor c=1.16594e-17
C37 (\6\:Eint VSS) capacitor c=4.13802e-16
C38 (\2\:n5 VSS) capacitor c=3.85649e-17
C39 (\7\:CKb VSS) capacitor c=1.64962e-17
C40 (\4\:Eint VSS) capacitor c=9.40462e-17
C41 (\4\:CKbb VSS) capacitor c=5.18655e-17
C42 (\4\:CKb VSS) capacitor c=4.70143e-17
C43 (\2\:CKb VSS) capacitor c=1.87066e-17
C44 (\2\:CK VSS) capacitor c=5.18401e-17
C45 (\2\:SE VSS) capacitor c=8.69267e-17
C46 (\3\:E VSS) capacitor c=1.21009e-17
C47 (\1\:VDD VSS) capacitor c=7.78419e-16
C48 (\23\:Eint VSS) capacitor c=7.83738e-17
C49 (\19\:CKbb VSS) capacitor c=1.11176e-16
C50 (\34\:VDD VSS) capacitor c=2.59668e-17
C51 (\5\:n5 VSS) capacitor c=2.18121e-16
C52 (\7\:Eb VSS) capacitor c=1.38994e-16
C53 (\14\:CKb VSS) capacitor c=1.05307e-16
C54 (\36\:VDD VSS) capacitor c=4.39336e-17
C55 (\5\:Eb VSS) capacitor c=9.66782e-18
C56 (\4\:VDD VSS) capacitor c=5.6266e-17
C57 (\38\:ECKb VSS) capacitor c=7.98735e-17
C58 (\44\:ECKb VSS) capacitor c=1.02676e-16
C59 (\21\:Eint VSS) capacitor c=3.40232e-17
C60 (\16\:CKbb VSS) capacitor c=1.55727e-16
C61 (\7\:n5 VSS) capacitor c=1.03966e-16
C62 (\12\:CKb VSS) capacitor c=1.03022e-16
C63 (\9\:Eb VSS) capacitor c=9.61959e-17
C64 (\2\:E VSS) capacitor c=6.11468e-17
C65 (\2\:CKbb VSS) capacitor c=4.16718e-17
C66 (\10\:Eint VSS) capacitor c=2.84897e-17
C67 (\11\:Eint VSS) capacitor c=2.65271e-17
C68 (\5\:E VSS) capacitor c=5.55546e-17
C69 (\4\:CK VSS) capacitor c=4.3494e-17
C70 (\4\:Eb VSS) capacitor c=1.5214e-16
C71 (\8\:CKb VSS) capacitor c=8.95548e-17
C72 (\9\:CKb VSS) capacitor c=7.27159e-17
C73 (\10\:CKb VSS) capacitor c=4.99854e-17
C74 (\11\:CKb VSS) capacitor c=6.27316e-17
C75 (\4\:n5 VSS) capacitor c=1.70365e-16
C76 (\20\:Eint VSS) capacitor c=5.39555e-17
C77 (\25\:Eint VSS) capacitor c=6.5889e-17
C78 (\18\:CKbb VSS) capacitor c=1.14216e-16
C79 (\32\:ECKb VSS) capacitor c=1.66684e-17
C80 (\33\:ECKb VSS) capacitor c=4.1834e-17
C81 (\34\:ECKb VSS) capacitor c=2.6649e-16
C82 (\14\:VDD VSS) capacitor c=3.40279e-17
C83 (\16\:VDD VSS) capacitor c=2.16747e-17
Rk3 (\4\:CK CK) resistor r=0.09973 c=0
Rk58 (\1\:VDD \14\:VDD) resistor r=0.401 c=0
Rk59 (\14\:VDD \15\:VDD) resistor r=0.2983 c=0
Rk61 (\16\:VDD VDD) resistor r=0.2278 c=0
Rk60 (\15\:VDD \16\:VDD) resistor r=0.3234 c=0
Rk71 (\14\:VDD \35\:VDD) resistor r=0.1029 c=0
Rk72 (\16\:VDD \37\:VDD) resistor r=0.2845 c=0
Rk2 (\4\:SE SE) resistor r=0.003006 c=0
Rk1 (E \5\:E) resistor r=0.2018 c=0
Rk79 (\1\:VSS \10\:VSS) resistor r=0.2306 c=0
Rk80 (\10\:VSS \11\:VSS) resistor r=0.1227 c=0
Rk81 (\11\:VSS \12\:VSS) resistor r=0.3282 c=0
Rk82 (\12\:VSS \13\:VSS) resistor r=0.5139 c=0
Rk83 (\13\:VSS \14\:VSS) resistor r=0.2381 c=0
Rk85 (\15\:VSS VSS) resistor r=0.2284 c=0
Rk84 (\14\:VSS \15\:VSS) resistor r=0.3234 c=0
Rk86 (VSS \17\:VSS) resistor r=0.1799 c=0
Rk92 (\11\:VSS \29\:VSS) resistor r=0.2705 c=0
Rk93 (\12\:VSS \31\:VSS) resistor r=0.229 c=0
Rk94 (\13\:VSS \33\:VSS) resistor r=0.1632 c=0
Rk95 (\15\:VSS \35\:VSS) resistor r=0.1769 c=0
Rk4 (\2\:Eb \3\:Eb) resistor r=0.5121 c=0
Rk5 (\3\:Eb \4\:Eb) resistor r=0.771 c=0
Rk6 (\4\:Eb \6\:Eb) resistor r=0.1318 c=0
Rk7 (\3\:Eb \8\:Eb) resistor r=0.03276 c=0
Rk8 (\4\:Eb \10\:Eb) resistor r=0.5861 c=0
Rk9 (\8\:CKb \9\:CKb) resistor r=0.4779 c=0
Rk10 (\9\:CKb \10\:CKb) resistor r=0.2858 c=0
Rk11 (\9\:CKb \11\:CKb) resistor r=0.3374 c=0
Rk12 (\10\:CKb \13\:CKb) resistor r=0.2398 c=0
Rk13 (\13\:CKb \15\:CKb) resistor r=0.6458 c=0
Rk14 (\4\:n5 \6\:n5) resistor r=1.2303 c=0
Rk15 (\6\:n5 \8\:n5) resistor r=0.565 c=0
Rk22 (\5\:CKbb \17\:CKbb) resistor r=1.0511 c=0
Rk23 (\17\:CKbb \18\:CKbb) resistor r=0.4421 c=0
Rk24 (\18\:CKbb \20\:CKbb) resistor r=0.5519 c=0
Rk17 (\6\:Eint \20\:Eint) resistor r=0.2793 c=0
Rk18 (\20\:Eint \22\:Eint) resistor r=0.07904 c=0
Rk19 (\20\:Eint \24\:Eint) resistor r=0.3136 c=0
Rk20 (\24\:Eint \25\:Eint) resistor r=0.2793 c=0
Rk25 (\32\:ECKb \33\:ECKb) resistor r=0.06154 c=0
Rk26 (\33\:ECKb \34\:ECKb) resistor r=0.3873 c=0
Rk29 (\33\:ECKb \39\:ECKb) resistor r=0.2 c=0
Rk32 (\39\:ECKb \45\:ECKb) resistor r=0.5909 c=0
Rl7 (\2\:CK \3\:CK) resistor r=220.33 c=0
Rl6 (\1\:CK \2\:CK) resistor r=40.3846 c=0
Rl4 (\1\:SE \2\:SE) resistor r=160.771 c=0
Rl5 (\2\:SE \3\:SE) resistor r=95.3867 c=0
Rl1 (\1\:E \2\:E) resistor r=261.048 c=0
Rl3 (\2\:E \4\:E) resistor r=30.2311 c=0
Rl2 (\2\:E \3\:E) resistor r=12.2705 c=0
Rl16 (\5\:CKb \6\:CKb) resistor r=216.873 c=0
Rl17 (\6\:CKb \7\:CKb) resistor r=29.5379 c=0
Rl9 (\3\:CKb \4\:CKb) resistor r=24.2328 c=0
Rl8 (CKb \2\:CKb) resistor r=74.2328 c=0
Rl19 (\2\:n5 \3\:n5) resistor r=26.3736 c=0
Rl18 (n5 \2\:n5) resistor r=80.7692 c=0
Rl38 (\5\:CKbb \13\:CKbb) resistor r=31.9251 c=0
Rl25 (\5\:CKbb \9\:CKbb) resistor r=33.8489 c=0
Rl24 (\5\:CKbb \8\:CKbb) resistor r=31.9251 c=0
Rl11 (\2\:CKbb \3\:CKbb) resistor r=167.286 c=0
Rl10 (\2\:CKbb CKbb) resistor r=70.8353 c=0
Rl12 (\2\:CKbb \4\:CKbb) resistor r=67.233 c=0
Rl20 (\6\:Eint \5\:Eint) resistor r=55.7464 c=0
Rl13 (\2\:Eint Eint) resistor r=135.914 c=0
Rl14 (\2\:Eint \3\:Eint) resistor r=196.745 c=0
Rl15 (\2\:Eint \4\:Eint) resistor r=3.7936 c=0
Rl31 (\10\:Eint \13\:Eint) resistor r=28.0797 c=0
Rl28 (\10\:Eint \6\:Eint) resistor r=87.5028 c=0
Rl30 (\11\:Eint \12\:Eint) resistor r=25.0634 c=0
Rl32 (\11\:Eint \6\:Eint) resistor r=28.0958 c=0
Rl29 (\11\:Eint \10\:Eint) resistor r=109.96 c=0
Rl49 (ECKb \12\:ECKb) resistor r=5.6351 c=0
Rz14 (\1\:VDD \4\:VDD) resistor r=3.75 c=0
Rz16 (\15\:VDD \4\:VDD) resistor r=6.25 c=0
Rz18 (\17\:VSS \16\:VSS) resistor r=75 c=0
Rz24 (\29\:VSS \28\:VSS) resistor r=75 c=0
Rz25 (\31\:VSS \30\:VSS) resistor r=75 c=0
Rz26 (\33\:VSS \32\:VSS) resistor r=75 c=0
Rz27 (\35\:VSS \34\:VSS) resistor r=75 c=0
Rz1 (Eb \2\:Eb) resistor r=75 c=0
Rz2 (\9\:Eb \10\:Eb) resistor r=75 c=0
Rz3 (\12\:CKb \13\:CKb) resistor r=75 c=0
Rz4 (\7\:n5 \8\:n5) resistor r=75 c=0
Rz6 (\17\:CKbb \16\:CKbb) resistor r=75 c=0
Rz5 (\22\:Eint \21\:Eint) resistor r=75 c=0
Rz7 (\39\:ECKb \38\:ECKb) resistor r=75 c=0
Rz8 (\45\:ECKb \44\:ECKb) resistor r=75 c=0
Ry25 (\35\:VDD \34\:VDD) resistor r=62 c=0
Ry26 (\37\:VDD \36\:VDD) resistor r=62 c=0
Ry27 (\1\:VSS \4\:VSS) resistor r=7.75 c=0
Ry28 (\10\:VSS \4\:VSS) resistor r=5.1667 c=0
Ry29 (\14\:VSS \4\:VSS) resistor r=5.1667 c=0
Ry1 (\5\:Eb \6\:Eb) resistor r=62 c=0
Ry2 (\7\:Eb \8\:Eb) resistor r=62 c=0
Ry3 (\14\:CKb \15\:CKb) resistor r=62 c=0
Ry4 (\5\:n5 \6\:n5) resistor r=62 c=0
Ry6 (\20\:CKbb \19\:CKbb) resistor r=62 c=0
Ry5 (\24\:Eint \23\:Eint) resistor r=62 c=0
Rx3 (\2\:CK \4\:CK) resistor r=45 c=0
Rx2 (\2\:SE \4\:SE) resistor r=45 c=0
Rx1 (\3\:E \5\:E) resistor r=45 c=0
Rx4 (\4\:CKb \8\:CKb) resistor r=45 c=0
Rx5 (\2\:CKb \10\:CKb) resistor r=45 c=0
Rx6 (\7\:CKb \11\:CKb) resistor r=45 c=0
Rx7 (\2\:n5 \4\:n5) resistor r=45 c=0
Rx13 (\18\:CKbb \4\:CKbb) resistor r=45 c=0
Rx10 (\25\:Eint \4\:Eint) resistor r=45 c=0
Rx14 (\32\:ECKb \12\:ECKb) resistor r=45 c=0
mn1 (\9\:Eb \4\:E \16\:VSS VSS) g45n1lvt w=(1.45e-07) l=4.5e-08 nf=1 \
        as=2.03e-14 ad=2.61e-14 ps=5.7e-07 pd=6.5e-07 nrd=1.16667 \
        nrs=1.16667 sa=1.4e-07 sb=6.6e-07 sd=160n sca=6.59604 \
        scb=0.00318587 scc=2.16275e-05 m=(1)
mn0 (\9\:Eb \3\:SE \34\:VSS VSS) g45n1lvt w=(1.45e-07) l=4.5e-08 nf=1 \
        as=3.19e-14 ad=2.61e-14 ps=7.3e-07 pd=6.5e-07 nrd=1.16667 \
        nrs=1.16667 sa=3.65e-07 sb=4.35e-07 sd=160n sca=6.59604 \
        scb=0.00318587 scc=2.16275e-05 m=(1)
mn2 (\12\:CKb \1\:CK \34\:VSS VSS) g45n1lvt w=(1.45e-07) l=4.5e-08 nf=1 \
        as=3.19e-14 ad=2.465e-14 ps=7.3e-07 pd=6.3e-07 nrd=1.16667 \
        nrs=1.16667 sa=6.3e-07 sb=1.7e-07 sd=160n sca=6.59604 \
        scb=0.00318587 scc=2.16275e-05 m=(1)
mn5 (Eb CKb \7\:n5 VSS) g45n1lvt w=(1.45e-07) l=4.5e-08 nf=1 as=3.48e-14 \
        ad=2.03e-14 ps=7.7e-07 pd=5.7e-07 nrd=1.16667 nrs=1.16667 \
        sa=1.4e-07 sb=9.1e-07 sd=160n sca=23.279 scb=0.0230742 \
        scc=0.00267719 m=(1)
mn16 (\7\:n5 CKbb net263 VSS) g45n1lvt w=(1.45e-07) l=4.5e-08 nf=1 \
        as=8.7e-15 ad=3.48e-14 ps=4.1e-07 pd=7.7e-07 nrd=1.16667 \
        nrs=1.16667 sa=4.25e-07 sb=6.25e-07 sd=160n sca=23.279 \
        scb=0.0230742 scc=0.00267719 m=(1)
mn15 (net263 \3\:Eint \32\:VSS VSS) g45n1lvt w=(1.45e-07) l=4.5e-08 nf=1 \
        as=8.398e-14 ad=8.7e-15 ps=1.55e-06 pd=4.1e-07 nrd=1.16667 \
        nrs=1.16667 sa=5.3e-07 sb=5.2e-07 sd=160n sca=23.279 scb=0.0230742 \
        scc=0.00267719 m=(1)
mn3 (\16\:CKbb \6\:CKb \32\:VSS VSS) g45n1lvt w=(1.45e-07) l=4.5e-08 \
        nf=1 as=8.398e-14 ad=2.03e-14 ps=1.55e-06 pd=5.7e-07 nrd=1.16667 \
        nrs=1.16667 sa=9.1e-07 sb=1.4e-07 sd=160n sca=23.279 scb=0.0230742 \
        scc=0.00267719 m=(1)
mn10 (\21\:Eint n5 \30\:VSS VSS) g45n1lvt w=(2.6e-07) l=4.5e-08 nf=1 \
        as=6.56e-14 ad=5.85e-14 ps=1.1e-06 pd=9.7e-07 nrd=1.16667 \
        nrs=1.16667 sa=2.25e-07 sb=1.33e-06 sd=160n sca=15.3338 \
        scb=0.0153436 scc=0.00119435 m=(1)
mn20_1__rcx (16 \5\:Eint \30\:VSS VSS) g45n1lvt w=(2.6e-07) l=4.5e-08 \
        nf=1 as=6.56e-14 ad=2.47e-14 ps=1.1e-06 pd=7.1e-07 nrd=1.16667 \
        nrs=1.16667 sa=4.9e-07 sb=1.065e-06 sd=160n sca=15.3338 \
        scb=0.0153436 scc=0.00119435 m=(1)
mn21_1__rcx (\44\:ECKb \8\:CKbb 16 VSS) g45n1lvt w=(2.6e-07) l=4.5e-08 \
        nf=1 as=2.47e-14 ad=4.16e-14 ps=7.1e-07 pd=8.4e-07 nrd=1.16667 \
        nrs=1.16667 sa=6.3e-07 sb=9.25e-07 sd=160n sca=15.3338 \
        scb=0.0153436 scc=0.00119435 m=(1)
mn21_2__rcx (\44\:ECKb \9\:CKbb 17 VSS) g45n1lvt w=(2.6e-07) l=4.5e-08 \
        nf=1 as=1.56e-14 ad=4.16e-14 ps=6.4e-07 pd=8.4e-07 nrd=1.16667 \
        nrs=1.16667 sa=8.35e-07 sb=7.2e-07 sd=160n sca=15.3338 \
        scb=0.0153436 scc=0.00119435 m=(1)
mn20_2__rcx (17 \12\:Eint \28\:VSS VSS) g45n1lvt w=(2.6e-07) l=4.5e-08 \
        nf=1 as=8.45e-14 ad=1.56e-14 ps=1.17e-06 pd=6.4e-07 nrd=1.16667 \
        nrs=1.16667 sa=9.4e-07 sb=6.15e-07 sd=160n sca=15.3338 \
        scb=0.0153436 scc=0.00119435 m=(1)
mn20 (18 \13\:Eint \28\:VSS VSS) g45n1lvt w=(2.6e-07) l=4.5e-08 nf=1 \
        as=8.45e-14 ad=1.56e-14 ps=1.17e-06 pd=6.4e-07 nrd=1.16667 \
        nrs=1.16667 sa=1.31e-06 sb=2.45e-07 sd=160n sca=15.3338 \
        scb=0.0153436 scc=0.00119435 m=(1)
mn21 (\38\:ECKb \13\:CKbb 18 VSS) g45n1lvt w=(2.6e-07) l=4.5e-08 nf=1 \
        as=1.56e-14 ad=3.64e-14 ps=6.4e-07 pd=8e-07 nrd=1.16667 \
        nrs=1.16667 sa=1.415e-06 sb=1.4e-07 sd=160n sca=15.3338 \
        scb=0.0153436 scc=0.00119435 m=(1)
mn22_1__rcx (ECK ECKb \1\:VSS VSS) g45n1lvt w=(3.1e-07) l=4.5e-08 nf=1 \
        as=4.836e-14 ad=4.96e-14 ps=9.32e-07 pd=9.4e-07 nrd=1.16667 \
        nrs=1.16667 sa=1.4e-07 sb=1.985e-06 sd=160n sca=15.9751 \
        scb=0.0153507 scc=0.00137372 m=(10)
mp10 (\23\:Eint \3\:n5 \1\:VDD VDD) g45p1lvt w=(3.9e-07) l=4.5e-08 nf=1 \
        as=6.24e-14 ad=5.76e-14 ps=1.1e-06 pd=1.29e-06 nrd=1.16667 \
        nrs=1.16667 sa=1.47692e-07 sb=1.78269e-06 sd=160n sca=15.8351 \
        scb=0.0142471 scc=0.00110276 m=(1)
mp20_1__rcx (\34\:ECKb \6\:Eint \1\:VDD VDD) g45p1lvt w=(3.9e-07) \
        l=4.5e-08 nf=1 as=7.93e-14 ad=7.1e-14 ps=1.18667e-06 pd=1.18e-06 \
        nrd=1.16667 nrs=1.16667 sa=3.52692e-07 sb=1.75641e-06 sd=160n \
        sca=15.8351 scb=0.0142471 scc=0.00110276 m=(3)
mp21_1__rcx (\34\:ECKb \5\:CKbb \1\:VDD VDD) g45p1lvt w=(3.9e-07) \
        l=4.5e-08 nf=1 as=7.807e-14 ad=7.1e-14 ps=1.22e-06 pd=1.18e-06 \
        nrd=1.16667 nrs=1.16667 sa=5.46282e-07 sb=2e-06 sd=160n \
        sca=12.8992 scb=0.0114532 scc=0.000515529 m=(3)
mp22_1__rcx (ECK ECKb \1\:VDD VDD) g45p1lvt w=(4.7e-07) l=4.5e-08 nf=1 \
        as=7.768e-14 ad=7.52e-14 ps=1.276e-06 pd=1.26e-06 nrd=1.16667 \
        nrs=1.16667 sa=1.45777e-06 sb=1.985e-06 sd=160n sca=17.506 \
        scb=0.014809 scc=0.00143528 m=(10)
ends TLATNTSCAX12
// End of subcircuit definition.
