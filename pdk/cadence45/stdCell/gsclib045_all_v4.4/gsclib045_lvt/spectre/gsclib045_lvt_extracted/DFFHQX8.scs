// Generated for: spectre (May  1 09:13:32 2013 )
// Library name: gsclib045_lvt
// Cell name: DFFHQX8
// View name: extracted

simulator lang=spectre

subckt DFFHQX8 CK D Q VDD VSS
mp55_1__rcx (Q qbint \7\:VDD VDD) g45p1lvt w=(4.45e-07) l=4.5e-08 nf=1 \
        as=7.073e-14 ad=6.993e-14 ps=1.21e-06 pd=1.20429e-06 nrd=1.16667 \
        nrs=1.16667 sa=1.4e-07 sb=1.91719e-06 sd=160n sca=40.5428 \
        scb=0.0363846 scc=0.00414682 m=(7)
C1 (VDD VSS) capacitor c=2.52616e-16
C2 (CK VSS) capacitor c=4.3404e-17
C3 (D VSS) capacitor c=5.81481e-17
C4 (Q VSS) capacitor c=5.10493e-16
C5 (qbint VSS) capacitor c=3.67397e-16
C6 (n30 VSS) capacitor c=2.27475e-16
C7 (CKb VSS) capacitor c=7.23343e-17
C8 (CKbb VSS) capacitor c=4.49646e-17
C9 (net172 VSS) capacitor c=2.18678e-18
C10 (mout VSS) capacitor c=9.83896e-17
C11 (n20 VSS) capacitor c=2.05258e-17
C12 (net192 VSS) capacitor c=3.2229e-18
C13 (net123 VSS) capacitor c=1.92235e-18
C14 (net147 VSS) capacitor c=1.1106e-18
C15 (n22 VSS) capacitor c=8.95344e-18
C16 (\3\:CK VSS) capacitor c=3.31274e-17
C17 (\3\:D VSS) capacitor c=4.68007e-17
C18 (\5\:CKbb VSS) capacitor c=7.37724e-17
C19 (\8\:CKb VSS) capacitor c=7.07877e-17
C20 (\4\:n20 VSS) capacitor c=3.55238e-17
C21 (\7\:CKb VSS) capacitor c=2.51359e-17
C22 (\26\:qbint VSS) capacitor c=6.45216e-17
C23 (\2\:CKb VSS) capacitor c=4.35789e-17
C24 (\1\:CK VSS) capacitor c=2.87435e-17
C25 (\1\:D VSS) capacitor c=6.94164e-17
C26 (\10\:CKb VSS) capacitor c=6.14882e-17
C27 (\7\:CKbb VSS) capacitor c=3.08556e-17
C28 (\3\:mout VSS) capacitor c=4.15689e-17
C29 (\3\:n20 VSS) capacitor c=4.58835e-17
C30 (\3\:CKbb VSS) capacitor c=3.0622e-17
C31 (\6\:CKb VSS) capacitor c=6.43996e-17
C32 (\23\:qbint VSS) capacitor c=4.79933e-17
C33 (\2\:CK VSS) capacitor c=3.15804e-17
C34 (\2\:D VSS) capacitor c=5.05945e-17
C35 (\11\:CKb VSS) capacitor c=3.89668e-17
C36 (\6\:CKbb VSS) capacitor c=5.45428e-17
C37 (\9\:CKb VSS) capacitor c=3.19886e-17
C38 (\2\:mout VSS) capacitor c=5.4393e-17
C39 (\4\:CKb VSS) capacitor c=2.68599e-17
C40 (\4\:CKbb VSS) capacitor c=4.10243e-17
C41 (\2\:CKbb VSS) capacitor c=3.37937e-17
C42 (\25\:qbint VSS) capacitor c=2.49776e-17
C43 (\3\:CKb VSS) capacitor c=2.61802e-17
C44 (\11\:qbint VSS) capacitor c=2.32764e-17
C45 (\19\:CKb VSS) capacitor c=5.89885e-17
C46 (\13\:VDD VSS) capacitor c=6.03084e-17
C47 (\9\:n20 VSS) capacitor c=6.387e-17
C48 (\15\:VDD VSS) capacitor c=3.9656e-17
C49 (\8\:mout VSS) capacitor c=7.4377e-17
C50 (\12\:n30 VSS) capacitor c=1.83537e-16
C51 (\17\:VDD VSS) capacitor c=2.14788e-17
C52 (\15\:CKbb VSS) capacitor c=8.77164e-17
C53 (\1\:VDD VSS) capacitor c=5.37548e-17
C54 (\12\:CKb VSS) capacitor c=7.05931e-17
C55 (\5\:n20 VSS) capacitor c=6.79016e-17
C56 (\6\:mout VSS) capacitor c=5.5373e-17
C57 (\14\:n30 VSS) capacitor c=1.04977e-16
C58 (\13\:CKbb VSS) capacitor c=6.18718e-17
C59 (\24\:qbint VSS) capacitor c=3.88591e-17
C60 (\5\:CKb VSS) capacitor c=4.42755e-17
C61 (\2\:n20 VSS) capacitor c=2.55133e-17
C62 (\27\:qbint VSS) capacitor c=7.93643e-17
C63 (\28\:qbint VSS) capacitor c=2.58886e-16
C64 (\31\:qbint VSS) capacitor c=4.13885e-17
C65 (\11\:n30 VSS) capacitor c=1.32357e-16
C66 (\4\:mout VSS) capacitor c=5.57945e-17
C67 (\5\:mout VSS) capacitor c=7.83921e-17
C68 (\8\:CKbb VSS) capacitor c=1.24819e-16
C69 (\9\:CKbb VSS) capacitor c=1.49716e-16
C70 (\10\:CKbb VSS) capacitor c=1.057e-16
C71 (\11\:CKbb VSS) capacitor c=6.73784e-17
C72 (\12\:CKbb VSS) capacitor c=6.2011e-17
C73 (\7\:n20 VSS) capacitor c=7.01305e-17
C74 (\8\:n20 VSS) capacitor c=4.41306e-17
C75 (\4\:D VSS) capacitor c=6.67967e-17
C76 (\5\:CK VSS) capacitor c=2.58803e-17
C77 (\14\:CKb VSS) capacitor c=1.16206e-16
C78 (\15\:CKb VSS) capacitor c=1.24374e-16
C79 (\16\:CKb VSS) capacitor c=1.11907e-16
C80 (\17\:CKb VSS) capacitor c=1.27456e-16
C81 (\18\:CKb VSS) capacitor c=1.15985e-16
C82 (\21\:CKb VSS) capacitor c=5.24819e-17
C83 (\3\:VDD VSS) capacitor c=2.01052e-17
C84 (\4\:VDD VSS) capacitor c=1.95174e-17
C85 (\6\:VDD VSS) capacitor c=3.82766e-17
C86 (\7\:VDD VSS) capacitor c=4.61755e-16
Rk44 (\2\:VSS \3\:VSS) resistor r=0.1828 c=0
Rk45 (\3\:VSS \4\:VSS) resistor r=0.4384 c=0
Rk46 (\4\:VSS \5\:VSS) resistor r=0.1302 c=0
Rk47 (\5\:VSS \6\:VSS) resistor r=0.4411 c=0
Rk54 (\7\:VSS VSS) resistor r=0.1074 c=0
Rk48 (\6\:VSS \7\:VSS) resistor r=0.3832 c=0
Rk55 (\3\:VSS \14\:VSS) resistor r=0.2139 c=0
Rk56 (\4\:VSS \16\:VSS) resistor r=0.1889 c=0
Rk57 (\6\:VSS \18\:VSS) resistor r=0.2148 c=0
Rk63 (\2\:VDD \3\:VDD) resistor r=0.2505 c=0
Rk64 (\3\:VDD \4\:VDD) resistor r=0.3707 c=0
Rk65 (\4\:VDD \5\:VDD) resistor r=0.1302 c=0
Rk66 (\5\:VDD \6\:VDD) resistor r=0.4627 c=0
Rk73 (\7\:VDD VDD) resistor r=0.1074 c=0
Rk67 (\6\:VDD \7\:VDD) resistor r=0.3597 c=0
Rk74 (\3\:VDD \14\:VDD) resistor r=0.3079 c=0
Rk75 (\4\:VDD \16\:VDD) resistor r=0.1859 c=0
Rk76 (\6\:VDD \18\:VDD) resistor r=0.0433 c=0
Rk34 (\4\:CK \5\:CK) resistor r=0.003538 c=0
Rk35 (\6\:CK CK) resistor r=0.003656 c=0
Rk36 (\5\:CK \6\:CK) resistor r=0.04834 c=0
Rk33 (D \4\:D) resistor r=0.1009 c=0
Rk11 (\27\:qbint \28\:qbint) resistor r=0.4437 c=0
Rk14 (\28\:qbint \31\:qbint) resistor r=0.1477 c=0
Rk19 (\11\:n30 \13\:n30) resistor r=1.0951 c=0
Rk20 (\13\:n30 \15\:n30) resistor r=0.4999 c=0
Rk37 (\13\:CKb \14\:CKb) resistor r=0.6524 c=0
Rk38 (\14\:CKb \15\:CKb) resistor r=0.2949 c=0
Rk39 (\15\:CKb \16\:CKb) resistor r=0.4758 c=0
Rk40 (\16\:CKb \17\:CKb) resistor r=0.5591 c=0
Rk41 (\17\:CKb \18\:CKb) resistor r=0.7952 c=0
Rk42 (\15\:CKb \20\:CKb) resistor r=0.4751 c=0
Rk43 (\17\:CKb \21\:CKb) resistor r=0.3051 c=0
Rk24 (\8\:CKbb \9\:CKbb) resistor r=0.8612 c=0
Rk25 (\9\:CKbb \10\:CKbb) resistor r=0.4501 c=0
Rk26 (\10\:CKbb \11\:CKbb) resistor r=0.2699 c=0
Rk27 (\9\:CKbb \12\:CKbb) resistor r=0.2854 c=0
Rk28 (\10\:CKbb \14\:CKbb) resistor r=0.3471 c=0
Rk29 (\11\:CKbb \16\:CKbb) resistor r=0.4396 c=0
Rk21 (\4\:mout \5\:mout) resistor r=0.2777 c=0
Rk22 (\5\:mout \7\:mout) resistor r=0.1804 c=0
Rk23 (\5\:mout \9\:mout) resistor r=0.2844 c=0
Rk30 (\6\:n20 \7\:n20) resistor r=0.4097 c=0
Rk31 (\7\:n20 \8\:n20) resistor r=0.2942 c=0
Rk32 (\7\:n20 \10\:n20) resistor r=0.1572 c=0
Rl53 (\2\:CK \3\:CK) resistor r=83.7912 c=0
Rl52 (\1\:CK \2\:CK) resistor r=101.923 c=0
Rl51 (\2\:D \3\:D) resistor r=65.3618 c=0
Rl50 (\1\:D \2\:D) resistor r=117.103 c=0
Rl10 (qbint \11\:qbint) resistor r=4.8851 c=0
Rl35 (\24\:qbint \26\:qbint) resistor r=101.385 c=0
Rl33 (\24\:qbint \23\:qbint) resistor r=62.9711 c=0
Rl34 (\24\:qbint \25\:qbint) resistor r=4.5402 c=0
Rl31 (CKb \2\:CKb) resistor r=197.643 c=0
Rl49 (\10\:CKb \11\:CKb) resistor r=52.6149 c=0
Rl46 (\8\:CKb \9\:CKb) resistor r=24.2328 c=0
Rl32 (\2\:CKb \3\:CKb) resistor r=50.6918 c=0
Rl40 (\5\:CKb \7\:CKb) resistor r=47.4388 c=0
Rl39 (\5\:CKb \6\:CKb) resistor r=181.166 c=0
Rl38 (\4\:CKb \5\:CKb) resistor r=89.2399 c=0
Rl47 (\5\:CKbb \6\:CKbb) resistor r=156.882 c=0
Rl48 (\6\:CKbb \7\:CKbb) resistor r=30.0511 c=0
Rl37 (\3\:CKbb \4\:CKbb) resistor r=52.6149 c=0
Rl36 (CKbb \2\:CKbb) resistor r=35.3072 c=0
Rl44 (mout \2\:mout) resistor r=116.483 c=0
Rl45 (\2\:mout \3\:mout) resistor r=37.6365 c=0
Rl43 (\2\:n20 \4\:n20) resistor r=37.3411 c=0
Rl42 (\2\:n20 \3\:n20) resistor r=139.264 c=0
Rl41 (n20 \2\:n20) resistor r=3.1216 c=0
Rz12 (\14\:VSS \13\:VSS) resistor r=75 c=0
Rz13 (\16\:VSS \15\:VSS) resistor r=75 c=0
Rz14 (\18\:VSS \17\:VSS) resistor r=75 c=0
Rz20 (\2\:VDD \1\:VDD) resistor r=25 c=0
Rz21 (\5\:VDD \1\:VDD) resistor r=6.25 c=0
Rz22 (\7\:VDD \1\:VDD) resistor r=6.25 c=0
Rz7 (\15\:n30 \14\:n30) resistor r=75 c=0
Rz11 (\12\:CKb \13\:CKb) resistor r=75 c=0
Rz9 (\13\:CKbb \14\:CKbb) resistor r=75 c=0
Rz8 (\6\:mout \7\:mout) resistor r=75 c=0
Rz10 (\5\:n20 \6\:n20) resistor r=75 c=0
Ry12 (\2\:VSS \1\:VSS) resistor r=20.6667 c=0
Ry13 (\5\:VSS \1\:VSS) resistor r=5.1667 c=0
Ry14 (\7\:VSS \1\:VSS) resistor r=5.1667 c=0
Ry15 (\14\:VDD \13\:VDD) resistor r=62 c=0
Ry16 (\16\:VDD \15\:VDD) resistor r=62 c=0
Ry17 (\18\:VDD \17\:VDD) resistor r=62 c=0
Ry7 (\13\:n30 \12\:n30) resistor r=31 c=0
Ry11 (\19\:CKb \20\:CKb) resistor r=62 c=0
Ry9 (\15\:CKbb \16\:CKbb) resistor r=62 c=0
Ry8 (\8\:mout \9\:mout) resistor r=62 c=0
Ry10 (\9\:n20 \10\:n20) resistor r=31 c=0
Rx10 (\2\:CK \4\:CK) resistor r=45 c=0
Rx9 (\2\:D \4\:D) resistor r=45 c=0
Rx1 (\27\:qbint \25\:qbint) resistor r=45 c=0
Rx2 (\31\:qbint \11\:qbint) resistor r=45 c=0
Rx3 (\11\:n30 n30) resistor r=45 c=0
Rx11 (\11\:CKb \14\:CKb) resistor r=45 c=0
Rx12 (\9\:CKb \16\:CKb) resistor r=45 c=0
Rx13 (\3\:CKb \18\:CKb) resistor r=45 c=0
Rx14 (\4\:CKb \21\:CKb) resistor r=45 c=0
Rx5 (\6\:CKbb \8\:CKbb) resistor r=45 c=0
Rx6 (\2\:CKbb \11\:CKbb) resistor r=45 c=0
Rx7 (\4\:CKbb \12\:CKbb) resistor r=45 c=0
Rx4 (\2\:mout \4\:mout) resistor r=45 c=0
Rx8 (n20 \8\:n20) resistor r=45 c=0
mn55_1__rcx (Q qbint \7\:VSS VSS) g45n1lvt w=(2.95e-07) l=4.5e-08 nf=1 \
        as=4.69e-14 ad=4.636e-14 ps=9.1e-07 pd=9.0429e-07 nrd=1.16667 \
        nrs=1.16667 sa=1.4e-07 sb=1.90729e-06 sd=160n sca=16.4223 \
        scb=0.0158966 scc=0.0014413 m=(7)
mn45 (\28\:qbint n30 \7\:VSS VSS) g45n1lvt w=(2.6e-07) l=4.5e-08 nf=1 \
        as=4.277e-14 ad=3.987e-14 ps=8.6333e-07 pd=8.2667e-07 nrd=1.16667 \
        nrs=1.16667 sa=1.575e-06 sb=5.5e-07 sd=160n sca=17.5885 \
        scb=0.0172826 scc=0.00162584 m=(3)
mn21 (\13\:CKbb CKb \17\:VSS VSS) g45n1lvt w=(1.45e-07) l=4.5e-08 nf=1 \
        as=3.595e-14 ad=2.03e-14 ps=7.9e-07 pd=5.7e-07 nrd=1.16667 \
        nrs=1.16667 sa=1.4e-07 sb=2e-06 sd=160n sca=9.33388 scb=0.00788941 \
        scc=0.00017958 m=(1)
mn20 (\12\:CKb \1\:CK \13\:VSS VSS) g45n1lvt w=(1.45e-07) l=4.5e-08 nf=1 \
        as=6.69e-14 ad=2.03e-14 ps=1.25e-06 pd=5.7e-07 nrd=1.16667 \
        nrs=1.16667 sa=2e-06 sb=1.4e-07 sd=160n sca=7.688 scb=0.00504888 \
        scc=6.29443e-05 m=(1)
mn50 (net172 \23\:qbint \17\:VSS VSS) g45n1lvt w=(2.05e-07) l=4.5e-08 \
        nf=1 as=3.595e-14 ad=2.665e-14 ps=7.9e-07 pd=6.7e-07 nrd=1.16667 \
        nrs=1.16667 sa=3.0622e-07 sb=1.96488e-06 sd=160n sca=8.54927 \
        scb=0.00659983 scc=0.000133988 m=(1)
mn51 (\14\:n30 \6\:CKb net172 VSS) g45n1lvt w=(2.05e-07) l=4.5e-08 nf=1 \
        as=2.665e-14 ad=5.433e-14 ps=6.7e-07 pd=9.4e-07 nrd=1.16667 \
        nrs=1.16667 sa=4.8122e-07 sb=1.91366e-06 sd=160n sca=8.54927 \
        scb=0.00659983 scc=0.000133988 m=(1)
mn40 (\6\:mout \3\:CKbb \14\:n30 VSS) g45n1lvt w=(2.05e-07) l=4.5e-08 \
        nf=1 as=5.432e-14 ad=7.688e-14 ps=9.4e-07 pd=1.16e-06 nrd=1.16667 \
        nrs=1.16667 sa=7.9122e-07 sb=1.7522e-06 sd=160n sca=8.54927 \
        scb=0.00659983 scc=0.000133988 m=(1)
mn30 (\6\:mout \3\:n20 \15\:VSS VSS) g45n1lvt w=(2.05e-07) l=4.5e-08 \
        nf=1 as=4.93e-14 ad=7.688e-14 ps=9.2e-07 pd=1.16e-06 nrd=1.16667 \
        nrs=1.16667 sa=1.21122e-06 sb=1.3322e-06 sd=160n sca=8.54927 \
        scb=0.00659983 scc=0.000133988 m=(1)
mn35 (net192 \3\:mout \15\:VSS VSS) g45n1lvt w=(2.05e-07) l=4.5e-08 nf=1 \
        as=4.93e-14 ad=2.87e-14 ps=9.2e-07 pd=6.9e-07 nrd=1.16667 \
        nrs=1.16667 sa=1.47622e-06 sb=1.0672e-06 sd=160n sca=8.54927 \
        scb=0.00659983 scc=0.000133988 m=(1)
mn36 (\5\:n20 \7\:CKbb net192 VSS) g45n1lvt w=(2.05e-07) l=4.5e-08 nf=1 \
        as=2.87e-14 ad=5.638e-14 ps=6.9e-07 pd=9.6e-07 nrd=1.16667 \
        nrs=1.16667 sa=1.66122e-06 sb=8.82195e-07 sd=160n sca=8.54927 \
        scb=0.00659983 scc=0.000133988 m=(1)
mn26 (\5\:n20 \10\:CKb n21 VSS) g45n1lvt w=(2.05e-07) l=4.5e-08 nf=1 \
        as=1.23e-14 ad=5.638e-14 ps=5.3e-07 pd=9.6e-07 nrd=1.16667 \
        nrs=1.16667 sa=1.94585e-06 sb=5.62195e-07 sd=160n sca=8.54927 \
        scb=0.00659983 scc=0.000133988 m=(1)
mn25 (n21 \1\:D \13\:VSS VSS) g45n1lvt w=(2.05e-07) l=4.5e-08 nf=1 \
        as=6.69e-14 ad=1.23e-14 ps=1.25e-06 pd=5.3e-07 nrd=1.16667 \
        nrs=1.16667 sa=1.97659e-06 sb=4.57195e-07 sd=160n sca=8.54927 \
        scb=0.00659983 scc=0.000133988 m=(1)
mp45_1__rcx (\28\:qbint n30 \7\:VDD VDD) g45p1lvt w=(3.9e-07) l=4.5e-08 \
        nf=1 as=8.583e-14 ad=5.98e-14 ps=1.31667e-06 pd=1.08667e-06 \
        nrd=1.16667 nrs=1.16667 sa=1.575e-06 sb=6.1e-07 sd=160n \
        sca=18.3796 scb=0.0159892 scc=0.00159615 m=(3)
mp21 (\15\:CKbb \2\:CKb \17\:VDD VDD) g45p1lvt w=(2.15e-07) l=4.5e-08 \
        nf=1 as=1.0425e-13 ad=3.01e-14 ps=1.74e-06 pd=7.1e-07 nrd=1.16667 \
        nrs=1.16667 sa=1.4e-07 sb=2e-06 sd=160n sca=20.4333 scb=0.0198015 \
        scc=0.00193653 m=(1)
mp20 (\19\:CKb \3\:CK \13\:VDD VDD) g45p1lvt w=(2.15e-07) l=4.5e-08 nf=1 \
        as=1.1435e-13 ad=3.01e-14 ps=1.56e-06 pd=7.1e-07 nrd=1.16667 \
        nrs=1.16667 sa=2e-06 sb=1.4e-07 sd=160n sca=25.2301 scb=0.0262115 \
        scc=0.00203777 m=(1)
mp50 (net123 \26\:qbint \17\:VDD VDD) g45p1lvt w=(3.1e-07) l=4.5e-08 \
        nf=1 as=1.0425e-13 ad=3.565e-14 ps=1.74e-06 pd=8.5e-07 nrd=1.16667 \
        nrs=1.16667 sa=3.32984e-07 sb=1.9571e-06 sd=160n sca=17.3904 \
        scb=0.0162056 scc=0.00137566 m=(1)
mp51 (\12\:n30 CKbb net123 VDD) g45p1lvt w=(3.1e-07) l=4.5e-08 nf=1 \
        as=3.565e-14 ad=5.89e-14 ps=8.5e-07 pd=1e-06 nrd=1.16667 \
        nrs=1.16667 sa=4.92984e-07 sb=1.90806e-06 sd=160n sca=17.3904 \
        scb=0.0162056 scc=0.00137566 m=(1)
mp40 (\8\:mout \7\:CKb \12\:n30 VDD) g45p1lvt w=(3.1e-07) l=4.5e-08 nf=1 \
        as=5.89e-14 ad=1.581e-13 ps=1e-06 pd=1.64e-06 nrd=1.16667 \
        nrs=1.16667 sa=7.27984e-07 sb=1.82218e-06 sd=160n sca=17.3904 \
        scb=0.0162056 scc=0.00137566 m=(1)
mp30 (\8\:mout \4\:n20 \15\:VDD VDD) g45p1lvt w=(3.1e-07) l=4.5e-08 nf=1 \
        as=8.8e-14 ad=1.581e-13 ps=1.39e-06 pd=1.64e-06 nrd=1.16667 \
        nrs=1.16667 sa=1.28298e-06 sb=1.26718e-06 sd=160n sca=17.3904 \
        scb=0.0162056 scc=0.00137566 m=(1)
mp35 (net147 mout \15\:VDD VDD) g45p1lvt w=(3.1e-07) l=4.5e-08 nf=1 \
        as=8.8e-14 ad=1.86e-14 ps=1.39e-06 pd=7.4e-07 nrd=1.16667 \
        nrs=1.16667 sa=1.54798e-06 sb=1.00218e-06 sd=160n sca=17.3904 \
        scb=0.0162056 scc=0.00137566 m=(1)
mp36 (\9\:n20 \8\:CKb net147 VDD) g45p1lvt w=(3.1e-07) l=4.5e-08 nf=1 \
        as=1.86e-14 ad=5.27e-14 ps=7.4e-07 pd=9.6e-07 nrd=1.16667 \
        nrs=1.16667 sa=1.65298e-06 sb=8.97177e-07 sd=160n sca=17.3904 \
        scb=0.0162056 scc=0.00137566 m=(1)
mp26 (\9\:n20 \5\:CKbb n22 VDD) g45p1lvt w=(3.1e-07) l=4.5e-08 nf=1 \
        as=4.34e-14 ad=5.27e-14 ps=9e-07 pd=9.6e-07 nrd=1.16667 \
        nrs=1.16667 sa=1.86798e-06 sb=6.82177e-07 sd=160n sca=17.3904 \
        scb=0.0162056 scc=0.00137566 m=(1)
mp25 (n22 \3\:D \13\:VDD VDD) g45p1lvt w=(3.1e-07) l=4.5e-08 nf=1 \
        as=1.1435e-13 ad=4.34e-14 ps=1.56e-06 pd=9e-07 nrd=1.16667 \
        nrs=1.16667 sa=1.96629e-06 sb=4.97177e-07 sd=160n sca=17.5841 \
        scb=0.016252 scc=0.00137566 m=(1)
ends DFFHQX8
// End of subcircuit definition.
