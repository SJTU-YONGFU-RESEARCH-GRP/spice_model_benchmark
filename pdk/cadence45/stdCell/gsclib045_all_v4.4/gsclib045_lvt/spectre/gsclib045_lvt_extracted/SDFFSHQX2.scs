// Generated for: spectre (May  1 09:14:56 2013 )
// Library name: gsclib045_lvt
// Cell name: SDFFSHQX2
// View name: extracted

simulator lang=spectre

subckt SDFFSHQX2 CK D Q SE SI SN VDD VSS
mp11 (net390 \1\:D \15\:VDD VDD) g45p1lvt w=(3.9e-07) l=4.5e-08 nf=1 \
        as=1.0082e-13 ad=5.07e-14 ps=1.49e-06 pd=1.04e-06 nrd=1.16667 \
        nrs=1.16667 sa=3.60513e-07 sb=6.62308e-07 sd=160n sca=15.4348 \
        scb=0.0139233 scc=0.00102271 m=(1)
mp12 (Db \3\:SE net390 VDD) g45p1lvt w=(3.9e-07) l=4.5e-08 nf=1 \
        as=5.07e-14 ad=8.775e-14 ps=1.04e-06 pd=1.23e-06 nrd=1.16667 \
        nrs=1.16667 sa=5.35513e-07 sb=4.87308e-07 sd=160n sca=15.4348 \
        scb=0.0139233 scc=0.00102271 m=(1)
mp14 (Db \3\:SEb net398 VDD) g45p1lvt w=(3.9e-07) l=4.5e-08 nf=1 \
        as=2.34e-14 ad=8.775e-14 ps=9e-07 pd=1.23e-06 nrd=1.16667 \
        nrs=1.16667 sa=8.05513e-07 sb=2.17308e-07 sd=160n sca=15.9046 \
        scb=0.0140803 scc=0.00102275 m=(1)
mp13 (net398 \1\:SI \13\:VDD VDD) g45p1lvt w=(3.9e-07) l=4.5e-08 nf=1 \
        as=4.38e-14 ad=2.34e-14 ps=1.06e-06 pd=9e-07 nrd=1.16667 \
        nrs=1.16667 sa=9.10513e-07 sb=1.12308e-07 sd=160n sca=16.3434 \
        scb=0.0143715 scc=0.00102303 m=(1)
mp55 (\1\:Q qbint \27\:VDD VDD) g45p1lvt w=(3.9e-07) l=4.5e-08 nf=1 \
        as=5.998e-14 ad=6.24e-14 ps=1.105e-06 pd=1.1e-06 nrd=1.16667 \
        nrs=1.16667 sa=1.4e-07 sb=5.19615e-07 sd=160n sca=35.0309 \
        scb=0.0261374 scc=0.00344587 m=(2)
C1 (D VSS) capacitor c=5.29578e-17
C2 (Q VSS) capacitor c=2.63499e-17
C3 (VDD VSS) capacitor c=3.40445e-16
C4 (CK VSS) capacitor c=3.8702e-17
C5 (SN VSS) capacitor c=1.84821e-16
C6 (SI VSS) capacitor c=8.02379e-17
C7 (qbint VSS) capacitor c=1.40635e-16
C8 (n30 VSS) capacitor c=5.23765e-17
C9 (net459 VSS) capacitor c=2.63748e-18
C10 (net467 VSS) capacitor c=1.87807e-18
C11 (CKb VSS) capacitor c=4.52896e-17
C12 (mout VSS) capacitor c=5.12983e-17
C13 (CKbb VSS) capacitor c=5.1398e-17
C14 (net435 VSS) capacitor c=3.39619e-19
C15 (n20 VSS) capacitor c=4.91548e-17
C16 (net427 VSS) capacitor c=1.92109e-18
C17 (Db VSS) capacitor c=1.1167e-16
C18 (net443 VSS) capacitor c=1.81971e-18
C19 (SEb VSS) capacitor c=6.68262e-17
C20 (net455 VSS) capacitor c=4.80003e-18
C21 (net355 VSS) capacitor c=7.8405e-17
C22 (net378 VSS) capacitor c=4.33373e-18
C23 (net390 VSS) capacitor c=4.1468e-18
C24 (net398 VSS) capacitor c=1.95393e-18
C25 (\8\:SE VSS) capacitor c=3.4574e-17
C26 (\1\:SI VSS) capacitor c=7.3495e-17
C27 (\3\:SEb VSS) capacitor c=6.52087e-17
C28 (\3\:SE VSS) capacitor c=5.99551e-17
C29 (\1\:D VSS) capacitor c=5.27788e-17
C30 (\1\:CK VSS) capacitor c=2.67583e-17
C31 (\12\:CKb VSS) capacitor c=2.40208e-17
C32 (\4\:CKbb VSS) capacitor c=3.15583e-17
C33 (\5\:CKb VSS) capacitor c=4.87043e-17
C34 (\4\:mout VSS) capacitor c=6.52329e-17
C35 (\5\:SN VSS) capacitor c=4.06403e-17
C36 (\4\:CKb VSS) capacitor c=6.19004e-17
C37 (\9\:qbint VSS) capacitor c=5.80743e-17
C38 (\1\:SN VSS) capacitor c=3.36685e-17
C39 (\7\:SE VSS) capacitor c=2.45497e-17
C40 (\3\:SI VSS) capacitor c=5.37251e-17
C41 (\4\:SE VSS) capacitor c=4.14574e-17
C42 (\4\:D VSS) capacitor c=7.1203e-17
C43 (\3\:CK VSS) capacitor c=3.778e-17
C44 (\7\:CKb VSS) capacitor c=1.75142e-17
C45 (\11\:CKb VSS) capacitor c=2.24303e-17
C46 (\6\:CKbb VSS) capacitor c=7.52173e-17
C47 (\3\:n20 VSS) capacitor c=7.76901e-17
C48 (\7\:SN VSS) capacitor c=6.98078e-17
C49 (\2\:CKbb VSS) capacitor c=4.37712e-17
C50 (\11\:qbint VSS) capacitor c=4.65681e-17
C51 (\4\:SN VSS) capacitor c=5.67273e-17
C52 (\3\:n30 VSS) capacitor c=3.54965e-17
C53 (\5\:SE VSS) capacitor c=1.53897e-17
C54 (\2\:SI VSS) capacitor c=5.5495e-17
C55 (\4\:SEb VSS) capacitor c=3.98124e-17
C56 (\1\:SE VSS) capacitor c=3.58581e-17
C57 (\2\:SEb VSS) capacitor c=4.73597e-17
C58 (\3\:D VSS) capacitor c=3.49529e-17
C59 (\2\:CK VSS) capacitor c=4.47669e-17
C60 (\10\:CKb VSS) capacitor c=3.90015e-17
C61 (\5\:CKbb VSS) capacitor c=4.31262e-17
C62 (\6\:CKb VSS) capacitor c=4.90181e-17
C63 (\3\:mout VSS) capacitor c=1.77446e-17
C64 (\2\:n20 VSS) capacitor c=6.06074e-17
C65 (\6\:SN VSS) capacitor c=5.19323e-17
C66 (\3\:CKb VSS) capacitor c=4.26894e-17
C67 (\3\:CKbb VSS) capacitor c=2.72914e-17
C68 (\2\:CKb VSS) capacitor c=4.28918e-17
C69 (\10\:qbint VSS) capacitor c=5.30469e-17
C70 (\3\:SN VSS) capacitor c=2.38004e-17
C71 (\4\:n30 VSS) capacitor c=3.7446e-17
C72 (\6\:qbint VSS) capacitor c=2.24367e-17
C73 (\1\:VDD VSS) capacitor c=3.28119e-17
C74 (\10\:SEb VSS) capacitor c=8.45943e-17
C75 (\13\:VDD VSS) capacitor c=2.77711e-17
C76 (\15\:VDD VSS) capacitor c=6.11299e-17
C77 (\22\:CKb VSS) capacitor c=7.29473e-17
C78 (\17\:VDD VSS) capacitor c=6.76547e-17
C79 (\10\:CKbb VSS) capacitor c=1.04989e-16
C80 (\6\:Db VSS) capacitor c=1.18822e-16
C81 (\4\:n20 VSS) capacitor c=3.96176e-17
C82 (\19\:VDD VSS) capacitor c=1.86511e-17
C83 (\13\:mout VSS) capacitor c=5.70336e-17
C84 (\21\:VDD VSS) capacitor c=1.99312e-17
C85 (\15\:mout VSS) capacitor c=2.70037e-17
C86 (\7\:n30 VSS) capacitor c=6.19422e-17
C87 (\23\:VDD VSS) capacitor c=1.1498e-17
C88 (\3\:net355 VSS) capacitor c=7.87767e-17
C89 (\25\:VDD VSS) capacitor c=9.79775e-18
C90 (\17\:qbint VSS) capacitor c=6.49483e-17
C91 (\1\:Q VSS) capacitor c=9.20826e-17
C92 (\4\:VDD VSS) capacitor c=6.37141e-17
C93 (\8\:SEb VSS) capacitor c=9.85662e-17
C94 (\8\:Db VSS) capacitor c=4.23144e-17
C95 (\18\:CKb VSS) capacitor c=8.03194e-17
C96 (\12\:CKbb VSS) capacitor c=6.41608e-17
C97 (\4\:Db VSS) capacitor c=1.99635e-16
C98 (\8\:n20 VSS) capacitor c=8.32121e-17
C99 (\11\:mout VSS) capacitor c=5.43357e-17
C100 (\9\:mout VSS) capacitor c=6.31458e-17
C101 (\9\:n30 VSS) capacitor c=7.07719e-17
C102 (\13\:qbint VSS) capacitor c=7.67654e-17
C103 (\4\:Q VSS) capacitor c=1.1876e-17
C104 (\2\:n30 VSS) capacitor c=3.59063e-17
C105 (\2\:SN VSS) capacitor c=2.79941e-17
C106 (\2\:mout VSS) capacitor c=4.31512e-17
C107 (\9\:CKb VSS) capacitor c=2.42316e-17
C108 (\2\:D VSS) capacitor c=3.72314e-17
C109 (\3\:Q VSS) capacitor c=2.20301e-17
C110 (\2\:SE VSS) capacitor c=5.63567e-17
C111 (\6\:SE VSS) capacitor c=1.42305e-17
C112 (\12\:qbint VSS) capacitor c=8.11808e-17
C113 (\15\:qbint VSS) capacitor c=3.28239e-17
C114 (\16\:qbint VSS) capacitor c=2.91872e-17
C115 (\5\:n30 VSS) capacitor c=1.13745e-16
C116 (\6\:n30 VSS) capacitor c=1.1092e-16
C117 (\9\:SN VSS) capacitor c=2.04698e-16
C118 (\5\:mout VSS) capacitor c=4.13086e-17
C119 (\7\:mout VSS) capacitor c=8.53503e-17
C120 (\8\:mout VSS) capacitor c=7.08672e-17
C121 (\6\:n20 VSS) capacitor c=8.36992e-17
C122 (\7\:n20 VSS) capacitor c=6.43714e-17
C123 (\13\:CKb VSS) capacitor c=1.0808e-16
C124 (\14\:CKb VSS) capacitor c=2.00808e-16
C125 (\15\:CKb VSS) capacitor c=2.56147e-16
C126 (\16\:CKb VSS) capacitor c=1.48657e-16
C127 (\17\:CKb VSS) capacitor c=4.22448e-17
C128 (\7\:CKbb VSS) capacitor c=5.78912e-17
C129 (\8\:CKbb VSS) capacitor c=1.69929e-16
C130 (\9\:CKbb VSS) capacitor c=1.85398e-16
C131 (\20\:CKb VSS) capacitor c=7.64401e-17
C132 (\21\:CKb VSS) capacitor c=2.72184e-17
C133 (\4\:CK VSS) capacitor c=7.79089e-17
C134 (\5\:D VSS) capacitor c=6.69652e-17
C135 (\3\:Db VSS) capacitor c=2.35149e-16
C136 (\5\:SEb VSS) capacitor c=2.19109e-17
C137 (\6\:SEb VSS) capacitor c=7.8353e-17
C138 (\7\:SEb VSS) capacitor c=9.75325e-17
C139 (\4\:SI VSS) capacitor c=4.68195e-17
C140 (\9\:SE VSS) capacitor c=8.61384e-17
C141 (\10\:SE VSS) capacitor c=9.99832e-17
C142 (\3\:VDD VSS) capacitor c=1.39465e-17
C143 (\6\:VDD VSS) capacitor c=1.99923e-17
C144 (\7\:VDD VSS) capacitor c=3.01125e-17
C145 (\9\:VDD VSS) capacitor c=2.19016e-17
C146 (\10\:VDD VSS) capacitor c=3.06811e-17
C147 (\11\:VDD VSS) capacitor c=2.68916e-17
C148 (\27\:VDD VSS) capacitor c=1.5213e-16
Rk36 (\5\:D D) resistor r=0.1605 c=0
Rk69 (\2\:VSS \3\:VSS) resistor r=0.5113 c=0
Rk70 (\3\:VSS \5\:VSS) resistor r=0.1152 c=0
Rk71 (\5\:VSS \6\:VSS) resistor r=0.2633 c=0
Rk72 (\6\:VSS \7\:VSS) resistor r=0.3976 c=0
Rk73 (\7\:VSS \8\:VSS) resistor r=0.3401 c=0
Rk74 (\8\:VSS \9\:VSS) resistor r=0.2281 c=0
Rk75 (\9\:VSS \10\:VSS) resistor r=0.3509 c=0
Rk76 (\10\:VSS \11\:VSS) resistor r=0.6246 c=0
Rk77 (\11\:VSS \12\:VSS) resistor r=0.03744 c=0
Rk80 (\13\:VSS VSS) resistor r=0.08235 c=0
Rk78 (\12\:VSS \13\:VSS) resistor r=0.2129 c=0
Rk81 (\3\:VSS \16\:VSS) resistor r=0.1917 c=0
Rk82 (\6\:VSS \18\:VSS) resistor r=0.1884 c=0
Rk83 (\7\:VSS \20\:VSS) resistor r=0.04334 c=0
Rk84 (\9\:VSS \22\:VSS) resistor r=0.2977 c=0
Rk85 (\10\:VSS \24\:VSS) resistor r=0.2925 c=0
Rk86 (\12\:VSS \26\:VSS) resistor r=0.2205 c=0
Rk2 (\3\:Q Q) resistor r=0.07426 c=0
Rk1 (\2\:Q \3\:Q) resistor r=0.2624 c=0
Rk3 (\3\:Q \5\:Q) resistor r=0.06087 c=0
Rk48 (\2\:VDD \3\:VDD) resistor r=0.6599 c=0
Rk49 (\3\:VDD \5\:VDD) resistor r=0.1152 c=0
Rk50 (\5\:VDD \6\:VDD) resistor r=0.2633 c=0
Rk51 (\6\:VDD \7\:VDD) resistor r=0.4337 c=0
Rk52 (\7\:VDD \8\:VDD) resistor r=0.3059 c=0
Rk53 (\8\:VDD \9\:VDD) resistor r=0.2999 c=0
Rk54 (\9\:VDD \10\:VDD) resistor r=0.2336 c=0
Rk55 (\10\:VDD \11\:VDD) resistor r=0.4519 c=0
Rk56 (\11\:VDD \12\:VDD) resistor r=0.2121 c=0
Rk57 (\3\:VDD \14\:VDD) resistor r=0.2454 c=0
Rk58 (\6\:VDD \16\:VDD) resistor r=0.336 c=0
Rk59 (\7\:VDD \18\:VDD) resistor r=0.4615 c=0
Rk60 (\9\:VDD \20\:VDD) resistor r=0.04334 c=0
Rk61 (\10\:VDD \22\:VDD) resistor r=0.04334 c=0
Rk62 (\11\:VDD \24\:VDD) resistor r=0.04334 c=0
Rk63 (\12\:VDD \26\:VDD) resistor r=0.07151 c=0
Rk68 (\27\:VDD VDD) resistor r=0.08235 c=0
Rk64 (\12\:VDD \27\:VDD) resistor r=0.2643 c=0
Rk35 (CK \4\:CK) resistor r=0.03865 c=0
Rk46 (SE \9\:SE) resistor r=0.005081 c=0
Rk47 (\9\:SE \10\:SE) resistor r=0.4235 c=0
Rk12 (SN \8\:SN) resistor r=0.02276 c=0
Rk13 (\8\:SN \9\:SN) resistor r=1.4232 c=0
Rk45 (SI \4\:SI) resistor r=0.07182 c=0
Rk4 (\12\:qbint \14\:qbint) resistor r=0.5082 c=0
Rk5 (\14\:qbint \15\:qbint) resistor r=0.182 c=0
Rk6 (\15\:qbint \16\:qbint) resistor r=0.1523 c=0
Rk7 (\15\:qbint \18\:qbint) resistor r=0.2507 c=0
Rk9 (\5\:n30 \6\:n30) resistor r=0.6647 c=0
Rk10 (\6\:n30 \8\:n30) resistor r=0.2376 c=0
Rk11 (\6\:n30 \10\:n30) resistor r=0.2901 c=0
Rk24 (\13\:CKb \14\:CKb) resistor r=0.719 c=0
Rk25 (\14\:CKb \15\:CKb) resistor r=1.0761 c=0
Rk26 (\15\:CKb \16\:CKb) resistor r=1.038 c=0
Rk27 (\14\:CKb \17\:CKb) resistor r=0.1713 c=0
Rk32 (\19\:CKb \20\:CKb) resistor r=0.3871 c=0
Rk33 (\20\:CKb \21\:CKb) resistor r=0.1422 c=0
Rk34 (\20\:CKb \23\:CKb) resistor r=0.5243 c=0
Rk14 (\5\:mout \6\:mout) resistor r=0.229 c=0
Rk15 (\6\:mout \7\:mout) resistor r=0.04688 c=0
Rk16 (\7\:mout \8\:mout) resistor r=0.4107 c=0
Rk17 (\8\:mout \10\:mout) resistor r=0.3424 c=0
Rk18 (\6\:mout \12\:mout) resistor r=0.1863 c=0
Rk19 (\7\:mout \14\:mout) resistor r=0.278 c=0
Rk20 (\8\:mout \16\:mout) resistor r=0.07544 c=0
Rk28 (\7\:CKbb \8\:CKbb) resistor r=0.2563 c=0
Rk29 (\8\:CKbb \9\:CKbb) resistor r=1.2996 c=0
Rk30 (\8\:CKbb \11\:CKbb) resistor r=0.5365 c=0
Rk31 (\11\:CKbb \13\:CKbb) resistor r=0.324 c=0
Rk21 (\5\:n20 \6\:n20) resistor r=0.113 c=0
Rk22 (\6\:n20 \7\:n20) resistor r=0.3854 c=0
Rk23 (\6\:n20 \9\:n20) resistor r=0.3773 c=0
Rk37 (\2\:Db \3\:Db) resistor r=0.7304 c=0
Rk38 (\3\:Db \5\:Db) resistor r=1.1244 c=0
Rk39 (\5\:Db \7\:Db) resistor r=0.5304 c=0
Rk40 (\3\:Db \9\:Db) resistor r=0.27 c=0
Rk41 (\5\:SEb \6\:SEb) resistor r=0.04823 c=0
Rk42 (\6\:SEb \7\:SEb) resistor r=0.3083 c=0
Rk43 (\6\:SEb \9\:SEb) resistor r=0.557 c=0
Rk44 (\7\:SEb \11\:SEb) resistor r=0.5177 c=0
Rk8 (\2\:net355 \4\:net355) resistor r=0.2316 c=0
Rl37 (\1\:D \2\:D) resistor r=84.8746 c=0
Rl39 (\2\:D \4\:D) resistor r=97.7584 c=0
Rl38 (\2\:D \3\:D) resistor r=73.0022 c=0
Rl35 (\1\:CK \2\:CK) resistor r=51.1559 c=0
Rl36 (\2\:CK \3\:CK) resistor r=141.541 c=0
Rl43 (\2\:SE \3\:SE) resistor r=133.211 c=0
Rl44 (\2\:SE \4\:SE) resistor r=48.5834 c=0
Rl42 (\1\:SE \2\:SE) resistor r=12.4379 c=0
Rl49 (\6\:SE \8\:SE) resistor r=88.1757 c=0
Rl48 (\6\:SE \7\:SE) resistor r=47.791 c=0
Rl47 (\5\:SE \6\:SE) resistor r=6.7128 c=0
Rl20 (\5\:SN \6\:SN) resistor r=41.4941 c=0
Rl21 (\6\:SN \7\:SN) resistor r=147.31 c=0
Rl11 (\1\:SN \2\:SN) resistor r=34.3295 c=0
Rl13 (\2\:SN \4\:SN) resistor r=111.253 c=0
Rl12 (\2\:SN \3\:SN) resistor r=16.2825 c=0
Rl45 (\1\:SI \2\:SI) resistor r=26.098 c=0
Rl46 (\2\:SI \3\:SI) resistor r=122.252 c=0
Rl14 (\10\:qbint \9\:qbint) resistor r=103.846 c=0
Rl15 (\10\:qbint \11\:qbint) resistor r=26.3736 c=0
Rl5 (\6\:qbint qbint) resistor r=5.1512 c=0
Rl8 (n30 \2\:n30) resistor r=93.4643 c=0
Rl9 (\2\:n30 \3\:n30) resistor r=28.0797 c=0
Rl10 (\2\:n30 \4\:n30) resistor r=91.222 c=0
Rl30 (\7\:CKb \8\:CKb) resistor r=22.0693 c=0
Rl33 (\10\:CKb \11\:CKb) resistor r=24.2328 c=0
Rl27 (\5\:CKb \6\:CKb) resistor r=78.079 c=0
Rl19 (\3\:CKb \4\:CKb) resistor r=143.744 c=0
Rl16 (CKb \2\:CKb) resistor r=29.5379 c=0
Rl34 (\9\:CKb \12\:CKb) resistor r=47.1143 c=0
Rl31 (\8\:CKb \9\:CKb) resistor r=10.2272 c=0
Rl32 (\9\:CKb \10\:CKb) resistor r=144.788 c=0
Rl26 (\2\:mout \4\:mout) resistor r=110.418 c=0
Rl24 (mout \2\:mout) resistor r=100.368 c=0
Rl25 (\2\:mout \3\:mout) resistor r=3.7301 c=0
Rl17 (CKbb \2\:CKbb) resistor r=125 c=0
Rl28 (\4\:CKbb \5\:CKbb) resistor r=24.2328 c=0
Rl29 (\5\:CKbb \6\:CKbb) resistor r=191.428 c=0
Rl18 (CKbb \3\:CKbb) resistor r=50.6918 c=0
Rl22 (n20 \2\:n20) resistor r=29.5379 c=0
Rl23 (\2\:n20 \3\:n20) resistor r=194.488 c=0
Rl41 (\3\:SEb \4\:SEb) resistor r=24.2328 c=0
Rl40 (SEb \2\:SEb) resistor r=39.6174 c=0
Rz15 (\2\:VSS \1\:VSS) resistor r=75 c=0
Rz16 (\16\:VSS \15\:VSS) resistor r=75 c=0
Rz17 (\18\:VSS \17\:VSS) resistor r=75 c=0
Rz18 (\20\:VSS \19\:VSS) resistor r=75 c=0
Rz19 (\22\:VSS \21\:VSS) resistor r=75 c=0
Rz20 (\24\:VSS \23\:VSS) resistor r=75 c=0
Rz21 (\26\:VSS \25\:VSS) resistor r=75 c=0
Rz1 (\5\:Q \4\:Q) resistor r=75 c=0
Rz12 (\5\:VDD \4\:VDD) resistor r=9.375 c=0
Rz13 (\8\:VDD \4\:VDD) resistor r=6.25 c=0
Rz14 (\12\:VDD \4\:VDD) resistor r=6.25 c=0
Rz2 (\14\:qbint \13\:qbint) resistor r=75 c=0
Rz3 (\9\:n30 \10\:n30) resistor r=75 c=0
Rz8 (\18\:CKb \19\:CKb) resistor r=75 c=0
Rz4 (\9\:mout \10\:mout) resistor r=75 c=0
Rz5 (\11\:mout \12\:mout) resistor r=75 c=0
Rz7 (\12\:CKbb \13\:CKbb) resistor r=75 c=0
Rz6 (\8\:n20 \9\:n20) resistor r=75 c=0
Rz9 (\4\:Db \5\:Db) resistor r=75 c=0
Rz10 (\8\:Db \9\:Db) resistor r=75 c=0
Rz11 (\8\:SEb \9\:SEb) resistor r=75 c=0
Ry24 (\5\:VSS \4\:VSS) resistor r=7.75 c=0
Ry25 (\8\:VSS \4\:VSS) resistor r=5.1667 c=0
Ry26 (\11\:VSS \4\:VSS) resistor r=5.1667 c=0
Ry1 (\2\:Q \1\:Q) resistor r=20.6667 c=0
Ry14 (\2\:VDD \1\:VDD) resistor r=62 c=0
Ry15 (\14\:VDD \13\:VDD) resistor r=62 c=0
Ry16 (\16\:VDD \15\:VDD) resistor r=20.6667 c=0
Ry17 (\18\:VDD \17\:VDD) resistor r=62 c=0
Ry18 (\20\:VDD \19\:VDD) resistor r=62 c=0
Ry19 (\22\:VDD \21\:VDD) resistor r=62 c=0
Ry20 (\24\:VDD \23\:VDD) resistor r=62 c=0
Ry21 (\26\:VDD \25\:VDD) resistor r=62 c=0
Ry2 (\18\:qbint \17\:qbint) resistor r=31 c=0
Ry5 (\7\:n30 \8\:n30) resistor r=62 c=0
Ry10 (\22\:CKb \23\:CKb) resistor r=62 c=0
Ry6 (\13\:mout \14\:mout) resistor r=62 c=0
Ry7 (\15\:mout \16\:mout) resistor r=62 c=0
Ry9 (\10\:CKbb \11\:CKbb) resistor r=62 c=0
Ry8 (\4\:n20 \5\:n20) resistor r=62 c=0
Ry11 (Db \2\:Db) resistor r=20.6667 c=0
Ry12 (\6\:Db \7\:Db) resistor r=62 c=0
Ry13 (\10\:SEb \11\:SEb) resistor r=62 c=0
Ry3 (net355 \2\:net355) resistor r=62 c=0
Ry4 (\3\:net355 \4\:net355) resistor r=62 c=0
Rx16 (\3\:D \5\:D) resistor r=45 c=0
Rx15 (\2\:CK \4\:CK) resistor r=45 c=0
Rx20 (\5\:SE \9\:SE) resistor r=45 c=0
Rx21 (\1\:SE \10\:SE) resistor r=45 c=0
Rx4 (\3\:SN \8\:SN) resistor r=45 c=0
Rx5 (\6\:SN \9\:SN) resistor r=45 c=0
Rx19 (\2\:SI \4\:SI) resistor r=45 c=0
Rx1 (\12\:qbint \10\:qbint) resistor r=45 c=0
Rx2 (\16\:qbint \6\:qbint) resistor r=45 c=0
Rx3 (\4\:n30 \5\:n30) resistor r=45 c=0
Rx8 (\10\:CKb \13\:CKb) resistor r=45 c=0
Rx9 (\3\:CKb \15\:CKb) resistor r=45 c=0
Rx10 (\2\:CKb \16\:CKb) resistor r=45 c=0
Rx11 (\6\:CKb \17\:CKb) resistor r=45 c=0
Rx14 (\8\:CKb \21\:CKb) resistor r=45 c=0
Rx6 (\3\:mout \5\:mout) resistor r=45 c=0
Rx12 (\5\:CKbb \7\:CKbb) resistor r=45 c=0
Rx13 (\3\:CKbb \9\:CKbb) resistor r=45 c=0
Rx7 (\2\:n20 \7\:n20) resistor r=45 c=0
Rx17 (\2\:SEb \5\:SEb) resistor r=45 c=0
Rx18 (\4\:SEb \7\:SEb) resistor r=45 c=0
mn11 (net443 \4\:D \17\:VSS VSS) g45n1lvt w=(2.6e-07) l=4.5e-08 nf=1 \
        as=6.322e-14 ad=1.82e-14 ps=1.17e-06 pd=6.6e-07 nrd=1.16667 \
        nrs=1.16667 sa=3.51923e-07 sb=7.2e-07 sd=160n sca=8.51051 \
        scb=0.00656948 scc=0.000151659 m=(1)
mn12 (\8\:Db SEb net443 VSS) g45n1lvt w=(2.6e-07) l=4.5e-08 nf=1 \
        as=1.82e-14 ad=4.16e-14 ps=6.6e-07 pd=8.4e-07 nrd=1.16667 \
        nrs=1.16667 sa=4.66923e-07 sb=6.05e-07 sd=160n sca=8.51051 \
        scb=0.00656948 scc=0.000151659 m=(1)
mn14 (\8\:Db \4\:SE net455 VSS) g45n1lvt w=(2.6e-07) l=4.5e-08 nf=1 \
        as=5.59e-14 ad=4.16e-14 ps=9.5e-07 pd=8.4e-07 nrd=1.16667 \
        nrs=1.16667 sa=6.71923e-07 sb=4e-07 sd=160n sca=8.51051 \
        scb=0.00656948 scc=0.000151659 m=(1)
mn13 (net455 \3\:SI \15\:VSS VSS) g45n1lvt w=(2.6e-07) l=4.5e-08 nf=1 \
        as=3.64e-14 ad=5.59e-14 ps=8e-07 pd=9.5e-07 nrd=1.16667 \
        nrs=1.16667 sa=9.31923e-07 sb=1.4e-07 sd=160n sca=8.51051 \
        scb=0.00656948 scc=0.000151659 m=(1)
mn55_1__rcx (\4\:Q qbint \13\:VSS VSS) g45n1lvt w=(2.6e-07) l=4.5e-08 \
        nf=1 as=3.735e-14 ad=4.81e-14 ps=8.2e-07 pd=8.9e-07 nrd=1.16667 \
        nrs=1.16667 sa=1.4e-07 sb=5.23173e-07 sd=160n sca=14.4034 \
        scb=0.0144248 scc=0.00102063 m=(2)
mn45 (\13\:qbint \3\:n30 \13\:VSS VSS) g45n1lvt w=(2.05e-07) l=4.5e-08 \
        nf=1 as=3.83e-14 ad=2.87e-14 ps=8.4e-07 pd=6.9e-07 nrd=1.16667 \
        nrs=1.16667 sa=5.75e-07 sb=1.4e-07 sd=160n sca=11.814 \
        scb=0.0116374 scc=0.000520744 m=(1)
mn50 (net459 \4\:SN \25\:VSS VSS) g45n1lvt w=(2.05e-07) l=4.5e-08 nf=1 \
        as=3.215e-14 ad=1.742e-14 ps=8.8e-07 pd=5.8e-07 nrd=1.16667 \
        nrs=1.16667 sa=1.1878e-07 sb=7.3e-07 sd=160n sca=11.814 \
        scb=0.0116374 scc=0.000520744 m=(1)
mn51 (net467 \11\:qbint net459 VSS) g45n1lvt w=(2.05e-07) l=4.5e-08 nf=1 \
        as=1.742e-14 ad=2.767e-14 ps=5.8e-07 pd=6.8e-07 nrd=1.16667 \
        nrs=1.16667 sa=2.4878e-07 sb=6e-07 sd=160n sca=11.814 \
        scb=0.0116374 scc=0.000520744 m=(1)
mn52 (\9\:n30 CKb net467 VSS) g45n1lvt w=(2.05e-07) l=4.5e-08 nf=1 \
        as=2.767e-14 ad=4.817e-14 ps=6.8e-07 pd=8.8e-07 nrd=1.16667 \
        nrs=1.16667 sa=4.2878e-07 sb=4.2e-07 sd=160n sca=11.814 \
        scb=0.0116374 scc=0.000520744 m=(1)
mn40 (\9\:n30 \2\:CKbb \9\:mout VSS) g45n1lvt w=(2.05e-07) l=4.5e-08 nf=1 \
        as=2.87e-14 ad=4.817e-14 ps=6.9e-07 pd=8.8e-07 nrd=1.16667 \
        nrs=1.16667 sa=7.0878e-07 sb=1.4e-07 sd=160n sca=11.814 \
        scb=0.0116374 scc=0.000520744 m=(1)
mn30 (net435 \7\:SN \23\:VSS VSS) g45n1lvt w=(2.05e-07) l=4.5e-08 nf=1 \
        as=3.587e-14 ad=1.332e-14 ps=7.6e-07 pd=5.4e-07 nrd=1.16667 \
        nrs=1.16667 sa=1.75e-07 sb=2.5e-07 sd=160n sca=11.814 \
        scb=0.0116374 scc=0.000520744 m=(1)
mn31 (\11\:mout \3\:n20 net435 VSS) g45n1lvt w=(2.05e-07) l=4.5e-08 nf=1 \
        as=1.332e-14 ad=2.87e-14 ps=5.4e-07 pd=6.9e-07 nrd=1.16667 \
        nrs=1.16667 sa=2.85e-07 sb=1.4e-07 sd=160n sca=11.814 \
        scb=0.0116374 scc=0.000520744 m=(1)
mn35 (net427 mout \21\:VSS VSS) g45n1lvt w=(2.05e-07) l=4.5e-08 nf=1 \
        as=2.87e-14 ad=2.05e-14 ps=6.9e-07 pd=6.1e-07 nrd=1.16667 \
        nrs=1.16667 sa=1.4e-07 sb=6.35e-07 sd=160n sca=12.7388 \
        scb=0.0128661 scc=0.000666764 m=(1)
mn36 (\8\:n20 \6\:CKbb net427 VSS) g45n1lvt w=(2.05e-07) l=4.5e-08 nf=1 \
        as=2.05e-14 ad=4.305e-14 ps=6.1e-07 pd=8.3e-07 nrd=1.16667 \
        nrs=1.16667 sa=2.85e-07 sb=4.9e-07 sd=160n sca=12.7388 \
        scb=0.0128661 scc=0.000666764 m=(1)
mn25 (\8\:n20 \11\:CKb \4\:Db VSS) g45n1lvt w=(2.05e-07) l=4.5e-08 nf=1 \
        as=4.817e-14 ad=4.305e-14 ps=8.8e-07 pd=8.3e-07 nrd=1.16667 \
        nrs=1.16667 sa=5.4e-07 sb=2.35e-07 sd=160n sca=12.7388 \
        scb=0.0128661 scc=0.000666764 m=(1)
mn21 (\12\:CKbb \7\:CKb \19\:VSS VSS) g45n1lvt w=(1.45e-07) l=4.5e-08 \
        nf=1 as=7.445e-14 ad=2.03e-14 ps=1.46e-06 pd=5.7e-07 nrd=1.16667 \
        nrs=1.16667 sa=1.4e-07 sb=1.7e-07 sd=160n sca=19.8813 \
        scb=0.0206549 scc=0.00197265 m=(1)
mn20 (\18\:CKb \3\:CK \17\:VSS VSS) g45n1lvt w=(1.45e-07) l=4.5e-08 nf=1 \
        as=6.322e-14 ad=2.175e-14 ps=1.17e-06 pd=5.9e-07 nrd=1.16667 \
        nrs=1.16667 sa=1.5e-07 sb=1.09e-06 sd=160n sca=10.0732 \
        scb=0.00911402 scc=0.000253284 m=(1)
mn10 (\8\:SEb \7\:SE \1\:VSS VSS) g45n1lvt w=(1.45e-07) l=4.5e-08 nf=1 \
        as=2.03e-14 ad=2.972e-14 ps=5.7e-07 pd=7e-07 nrd=1.16667 \
        nrs=1.16667 sa=2.05e-07 sb=1.4e-07 sd=160n sca=10.4914 \
        scb=0.00978575 scc=0.000300434 m=(1)
mp45 (\17\:qbint n30 \27\:VDD VDD) g45p1lvt w=(3.1e-07) l=4.5e-08 nf=1 \
        as=6.535e-14 ad=4.34e-14 ps=1.15e-06 pd=9e-07 nrd=1.16667 \
        nrs=1.16667 sa=5.75e-07 sb=1.4e-07 sd=160n sca=36.0877 \
        scb=0.0235247 scc=0.00420471 m=(1)
mp50 (\3\:net355 \1\:SN \25\:VDD VDD) g45p1lvt w=(3.1e-07) l=4.5e-08 \
        nf=1 as=5.665e-14 ad=4.96e-14 ps=1.65e-06 pd=9.4e-07 nrd=1.16667 \
        nrs=1.16667 sa=1e-07 sb=3.05e-07 sd=160n sca=17.9343 scb=0.0166254 \
        scc=0.0014837 m=(1)
mp51 (\3\:net355 \9\:qbint \23\:VDD VDD) g45p1lvt w=(3.1e-07) l=4.5e-08 \
        nf=1 as=5.665e-14 ad=4.96e-14 ps=1.65e-06 pd=9.4e-07 nrd=1.16667 \
        nrs=1.16667 sa=3.05e-07 sb=1e-07 sd=160n sca=17.9343 scb=0.0166254 \
        scc=0.0014837 m=(1)
mp52 (\7\:n30 CKbb net355 VDD) g45p1lvt w=(3.1e-07) l=4.5e-08 nf=1 \
        as=4.34e-14 ad=4.96e-14 ps=9e-07 pd=9.4e-07 nrd=1.16667 \
        nrs=1.16667 sa=1.4e-07 sb=3.20484e-07 sd=160n sca=35.6995 \
        scb=0.0234062 scc=0.00420468 m=(1)
mp40 (\7\:n30 \4\:CKb \15\:mout VDD) g45p1lvt w=(3.1e-07) l=4.5e-08 nf=1 \
        as=3.58e-14 ad=4.96e-14 ps=9e-07 pd=9.4e-07 nrd=1.16667 \
        nrs=1.16667 sa=3.45e-07 sb=1.15484e-07 sd=160n sca=35.6995 \
        scb=0.0234062 scc=0.00420468 m=(1)
mp30 (\13\:mout \5\:SN \21\:VDD VDD) g45p1lvt w=(3.1e-07) l=4.5e-08 nf=1 \
        as=5.065e-14 ad=4.96e-14 ps=1.41e-06 pd=9.4e-07 nrd=1.16667 \
        nrs=1.16667 sa=1e-07 sb=1.16e-06 sd=160n sca=11.3312 \
        scb=0.00941412 scc=0.000228915 m=(1)
mp31 (\13\:mout n20 \19\:VDD VDD) g45p1lvt w=(3.1e-07) l=4.5e-08 nf=1 \
        as=9.52e-14 ad=4.96e-14 ps=1.51e-06 pd=9.4e-07 nrd=1.16667 \
        nrs=1.16667 sa=3.05e-07 sb=9.55e-07 sd=160n sca=11.3312 \
        scb=0.00941412 scc=0.000228915 m=(1)
mp35 (net378 \4\:mout \19\:VDD VDD) g45p1lvt w=(3.1e-07) l=4.5e-08 nf=1 \
        as=9.52e-14 ad=4.185e-14 ps=1.51e-06 pd=8.9e-07 nrd=1.16667 \
        nrs=1.16667 sa=5.7e-07 sb=6.9e-07 sd=160n sca=11.3312 \
        scb=0.00941412 scc=0.000228915 m=(1)
mp36 (\4\:n20 \5\:CKb net378 VDD) g45p1lvt w=(3.1e-07) l=4.5e-08 nf=1 \
        as=4.185e-14 ad=7.13e-14 ps=8.9e-07 pd=1.08e-06 nrd=1.16667 \
        nrs=1.16667 sa=7.5e-07 sb=5.1e-07 sd=160n sca=11.3312 \
        scb=0.00941412 scc=0.000228915 m=(1)
mp25 (\4\:n20 \4\:CKbb \6\:Db VDD) g45p1lvt w=(3.1e-07) l=4.5e-08 nf=1 \
        as=7.285e-14 ad=7.13e-14 ps=1.09e-06 pd=1.08e-06 nrd=1.16667 \
        nrs=1.16667 sa=1.025e-06 sb=2.35e-07 sd=160n sca=11.3312 \
        scb=0.00941412 scc=0.000228915 m=(1)
mp21 (\10\:CKbb \12\:CKb \17\:VDD VDD) g45p1lvt w=(2.15e-07) l=4.5e-08 \
        nf=1 as=3.01e-14 ad=3.01e-14 ps=7.1e-07 pd=7.1e-07 nrd=1.16667 \
        nrs=1.16667 sa=1.4e-07 sb=1.4e-07 sd=160n sca=45.7906 \
        scb=0.0283307 scc=0.00588417 m=(1)
mp20 (\22\:CKb \1\:CK \15\:VDD VDD) g45p1lvt w=(2.15e-07) l=4.5e-08 nf=1 \
        as=1.0082e-13 ad=3.01e-14 ps=1.49e-06 pd=7.1e-07 nrd=1.16667 \
        nrs=1.16667 sa=1.4e-07 sb=1.0593e-06 sd=160n sca=12.1244 \
        scb=0.0107968 scc=0.000332109 m=(1)
mp10 (\10\:SEb \8\:SE \1\:VDD VDD) g45p1lvt w=(2.15e-07) l=4.5e-08 nf=1 \
        as=3.01e-14 ad=3.01e-14 ps=7.1e-07 pd=7.1e-07 nrd=1.16667 \
        nrs=1.16667 sa=1.4e-07 sb=1.4e-07 sd=160n sca=59.4536 \
        scb=0.0473468 scc=0.00729053 m=(1)
ends SDFFSHQX2
// End of subcircuit definition.
