// Generated for: spectre (May  1 09:14:38 2013 )
// Library name: gsclib045_lvt
// Cell name: SDFFNSRX2
// View name: extracted

simulator lang=spectre

subckt SDFFNSRX2 CKN D Q QN RN SE SI SN VDD VSS
mp10 (\7\:SEb \1\:SE \33\:VDD VDD) g45p1lvt w=(2.15e-07) l=4.5e-08 nf=1 \
        as=6.227e-14 ad=3.01e-14 ps=1.7e-06 pd=7.1e-07 nrd=1.16667 \
        nrs=1.16667 sa=1.4e-07 sb=5.62558e-07 sd=160n sca=26.8497 \
        scb=0.0316789 scc=0.0018946 m=(1)
mp13 (net453 \1\:SI \33\:VDD VDD) g45p1lvt w=(2.15e-07) l=4.5e-08 nf=1 \
        as=6.227e-14 ad=1.29e-14 ps=1.7e-06 pd=5.5e-07 nrd=1.16667 \
        nrs=1.16667 sa=2.02791e-07 sb=1.05e-06 sd=160n sca=13.4953 \
        scb=0.011285 scc=0.000140006 m=(1)
mp14 (\8\:Db SEb net453 VDD) g45p1lvt w=(2.15e-07) l=4.5e-08 nf=1 \
        as=1.29e-14 ad=3.655e-14 ps=5.5e-07 pd=7.7e-07 nrd=1.16667 \
        nrs=1.16667 sa=3.07791e-07 sb=9.45e-07 sd=160n sca=12.2741 \
        scb=0.0094438 scc=0.000122647 m=(1)
mp12 (\8\:Db \4\:SE net461 VDD) g45p1lvt w=(2.15e-07) l=4.5e-08 nf=1 \
        as=5.375e-14 ad=3.655e-14 ps=9.3e-07 pd=7.7e-07 nrd=1.16667 \
        nrs=1.16667 sa=5.22791e-07 sb=7.3e-07 sd=160n sca=11.0664 \
        scb=0.00830854 scc=0.000119688 m=(1)
mp11 (net461 \3\:D \27\:VDD VDD) g45p1lvt w=(2.15e-07) l=4.5e-08 nf=1 \
        as=5.375e-14 ad=5.375e-14 ps=9.3e-07 pd=9.3e-07 nrd=1.16667 \
        nrs=1.16667 sa=8.17791e-07 sb=4.35e-07 sd=160n sca=10.5619 \
        scb=0.00813366 scc=0.000119634 m=(1)
mp20 (\13\:CKNb \3\:CKN \27\:VDD VDD) g45p1lvt w=(2.15e-07) l=4.5e-08 \
        nf=1 as=5.375e-14 ad=3.01e-14 ps=9.3e-07 pd=7.1e-07 nrd=1.16667 \
        nrs=1.16667 sa=1.11279e-06 sb=1.4e-07 sd=160n sca=10.5619 \
        scb=0.00813366 scc=0.000119634 m=(1)
mp21 (\13\:CKNbb \9\:CKNb \25\:VDD VDD) g45p1lvt w=(2.15e-07) l=4.5e-08 \
        nf=1 as=3.01e-14 ad=3.01e-14 ps=7.1e-07 pd=7.1e-07 nrd=1.16667 \
        nrs=1.16667 sa=1.4e-07 sb=1.4e-07 sd=160n sca=37.431 scb=0.0268495 \
        scc=0.00487383 m=(1)
mp25 (\7\:n20 \8\:CKNb Db VDD) g45p1lvt w=(2.15e-07) l=4.5e-08 nf=1 \
        as=3.01e-14 ad=7.203e-14 ps=7.1e-07 pd=1.1e-06 nrd=1.16667 \
        nrs=1.16667 sa=1.4e-07 sb=1.485e-06 sd=160n sca=29.9075 \
        scb=0.0247057 scc=0.00372713 m=(1)
mp36 (\7\:n20 \3\:CKNbb net486 VDD) g45p1lvt w=(2.15e-07) l=4.5e-08 nf=1 \
        as=1.29e-14 ad=7.203e-14 ps=5.5e-07 pd=1.1e-06 nrd=1.16667 \
        nrs=1.16667 sa=5.2e-07 sb=1.105e-06 sd=160n sca=29.9075 \
        scb=0.0247057 scc=0.00372713 m=(1)
mp35 (net486 mout \22\:VDD VDD) g45p1lvt w=(2.15e-07) l=4.5e-08 nf=1 \
        as=1.3178e-13 ad=1.29e-14 ps=2.08e-06 pd=5.5e-07 nrd=1.16667 \
        nrs=1.16667 sa=6.25e-07 sb=1e-06 sd=160n sca=29.9075 scb=0.0247057 \
        scc=0.00372713 m=(1)
mp30 (\14\:mout \4\:SN \22\:VDD VDD) g45p1lvt w=(2.15e-07) l=4.5e-08 \
        nf=1 as=1.3178e-13 ad=5.697e-14 ps=2.08e-06 pd=9.6e-07 nrd=1.16667 \
        nrs=1.16667 sa=1.015e-06 sb=6.1e-07 sd=160n sca=29.9075 \
        scb=0.0247057 scc=0.00372713 m=(1)
mp32 (\14\:mout \3\:n20 net478 VDD) g45p1lvt w=(2.15e-07) l=4.5e-08 nf=1 \
        as=3.332e-14 ad=5.697e-14 ps=7.4e-07 pd=9.6e-07 nrd=1.16667 \
        nrs=1.16667 sa=1.325e-06 sb=3e-07 sd=160n sca=29.9075 \
        scb=0.0247057 scc=0.00372713 m=(1)
mp31 (net478 \4\:RNb \20\:VDD VDD) g45p1lvt w=(2.15e-07) l=4.5e-08 nf=1 \
        as=4.765e-14 ad=3.332e-14 ps=1.48e-06 pd=7.4e-07 nrd=1.16667 \
        nrs=1.16667 sa=1.525e-06 sb=1e-07 sd=160n sca=29.9075 \
        scb=0.0247057 scc=0.00372713 m=(1)
mp40 (\7\:n35 \5\:CKNbb \10\:mout VDD) g45p1lvt w=(2.15e-07) l=4.5e-08 \
        nf=1 as=4.085e-14 ad=5.482e-14 ps=8.1e-07 pd=9.4e-07 nrd=1.16667 \
        nrs=1.16667 sa=1.9e-07 sb=4.4e-07 sd=160n sca=31.508 scb=0.0252524 \
        scc=0.00399199 m=(1)
mp53 (\7\:n35 CKNb \3\:net566 VDD) g45p1lvt w=(2.15e-07) l=4.5e-08 nf=1 \
        as=3.01e-14 ad=5.483e-14 ps=7.1e-07 pd=9.4e-07 nrd=1.16667 \
        nrs=1.16667 sa=4.9e-07 sb=1.4e-07 sd=160n sca=31.508 scb=0.0252524 \
        scc=0.00399199 m=(1)
mp51 (net414 \2\:RNb \18\:VDD VDD) g45p1lvt w=(2.15e-07) l=4.5e-08 nf=1 \
        as=5.69e-14 ad=2.902e-14 ps=1.85e-06 pd=7e-07 nrd=1.16667 \
        nrs=1.16667 sa=1e-07 sb=6.6093e-07 sd=160n sca=31.508 \
        scb=0.0252524 scc=0.00399199 m=(1)
mp52 (net566 qbint net414 VDD) g45p1lvt w=(2.15e-07) l=4.5e-08 nf=1 \
        as=2.902e-14 ad=3.58e-14 ps=7e-07 pd=8.2e-07 nrd=1.16667 \
        nrs=1.16667 sa=2.8e-07 sb=4.8093e-07 sd=160n sca=31.508 \
        scb=0.0252524 scc=0.00399199 m=(1)
mp50 (net566 \6\:SN \16\:VDD VDD) g45p1lvt w=(2.15e-07) l=4.5e-08 nf=1 \
        as=7.005e-14 ad=3.58e-14 ps=1.79e-06 pd=8.2e-07 nrd=1.16667 \
        nrs=1.16667 sa=4.22326e-07 sb=3.5e-07 sd=160n sca=22.8495 \
        scb=0.0214046 scc=0.00242442 m=(1)
mp22 (\10\:RNb \1\:RN \1\:VDD VDD) g45p1lvt w=(2.15e-07) l=4.5e-08 nf=1 \
        as=5.19e-14 ad=3.01e-14 ps=1.1e-06 pd=7.1e-07 nrd=1.16667 \
        nrs=1.16667 sa=1.4e-07 sb=9.22442e-07 sd=160n sca=10.1832 \
        scb=0.00742094 scc=7.76436e-05 m=(1)
mp56 (\8\:qint \11\:qbint \1\:VDD VDD) g45p1lvt w=(2.15e-07) l=4.5e-08 \
        nf=1 as=6.333e-14 ad=3.655e-14 ps=1.29e-06 pd=7.7e-07 nrd=1.16667 \
        nrs=1.16667 sa=9.69651e-07 sb=1.7e-07 sd=160n sca=18.4729 \
        scb=0.019884 scc=0.000529148 m=(1)
C1 (D VSS) capacitor c=5.99304e-17
C2 (RN VSS) capacitor c=6.6084e-17
C3 (SN VSS) capacitor c=5.37819e-17
C4 (Q VSS) capacitor c=3.2512e-17
C5 (VDD VSS) capacitor c=6.09251e-16
C6 (SE VSS) capacitor c=3.10553e-17
C7 (SI VSS) capacitor c=4.04003e-17
C8 (CKN VSS) capacitor c=4.1167e-17
C9 (QN VSS) capacitor c=3.80325e-17
C10 (SEb VSS) capacitor c=6.03137e-17
C11 (Db VSS) capacitor c=8.03014e-17
C12 (CKNb VSS) capacitor c=6.97143e-17
C13 (CKNbb VSS) capacitor c=4.09279e-17
C14 (n20 VSS) capacitor c=4.04073e-17
C15 (mout VSS) capacitor c=5.76441e-17
C16 (net521 VSS) capacitor c=6.29801e-17
C17 (RNb VSS) capacitor c=5.28819e-17
C18 (n35 VSS) capacitor c=5.05777e-17
C19 (net0363 VSS) capacitor c=8.10305e-17
C20 (net498 VSS) capacitor c=8.59232e-17
C21 (qbint VSS) capacitor c=6.43075e-17
C22 (qint VSS) capacitor c=1.62171e-16
C23 (net453 VSS) capacitor c=3.39026e-19
C24 (net461 VSS) capacitor c=4.24823e-18
C25 (net486 VSS) capacitor c=4.25379e-19
C26 (net478 VSS) capacitor c=2.54471e-18
C27 (net566 VSS) capacitor c=1.37938e-16
C28 (net414 VSS) capacitor c=4.1836e-18
C29 (\11\:qbint VSS) capacitor c=3.33531e-17
C30 (\4\:qbint VSS) capacitor c=4.99015e-16
C31 (\1\:RN VSS) capacitor c=5.66354e-17
C32 (\6\:SN VSS) capacitor c=7.8052e-17
C33 (\2\:RNb VSS) capacitor c=3.70547e-17
C34 (\5\:CKNbb VSS) capacitor c=3.97122e-17
C35 (\4\:RNb VSS) capacitor c=1.32456e-16
C36 (\3\:n20 VSS) capacitor c=4.77876e-17
C37 (\4\:SN VSS) capacitor c=3.41311e-17
C38 (\3\:CKNbb VSS) capacitor c=7.23711e-17
C39 (\8\:CKNb VSS) capacitor c=1.9555e-17
C40 (\9\:CKNb VSS) capacitor c=1.62926e-17
C41 (\3\:CKN VSS) capacitor c=3.90769e-17
C42 (\3\:D VSS) capacitor c=3.48465e-17
C43 (\4\:SE VSS) capacitor c=8.2189e-17
C44 (\1\:SI VSS) capacitor c=8.03029e-17
C45 (\1\:SE VSS) capacitor c=6.22786e-17
C46 (\13\:qbint VSS) capacitor c=5.63797e-17
C47 (\3\:RN VSS) capacitor c=3.91114e-17
C48 (\4\:n35 VSS) capacitor c=4.20112e-17
C49 (\8\:SN VSS) capacitor c=6.00061e-17
C50 (\3\:qbint VSS) capacitor c=3.52994e-17
C51 (\7\:CKNbb VSS) capacitor c=4.30944e-17
C52 (\2\:CKNb VSS) capacitor c=1.37759e-16
C53 (\5\:RNb VSS) capacitor c=4.92555e-17
C54 (\1\:SN VSS) capacitor c=5.86289e-17
C55 (\3\:mout VSS) capacitor c=7.24592e-17
C56 (\3\:CKNb VSS) capacitor c=2.11133e-16
C57 (\10\:CKNb VSS) capacitor c=2.77224e-17
C58 (\1\:CKN VSS) capacitor c=2.59282e-17
C59 (\1\:D VSS) capacitor c=5.86161e-17
C60 (\3\:SEb VSS) capacitor c=4.28277e-17
C61 (\6\:SE VSS) capacitor c=3.3788e-17
C62 (\3\:SI VSS) capacitor c=7.26745e-17
C63 (\3\:SE VSS) capacitor c=2.84571e-17
C64 (\12\:qbint VSS) capacitor c=4.48631e-17
C65 (\6\:qint VSS) capacitor c=2.08192e-17
C66 (\2\:RN VSS) capacitor c=5.08559e-17
C67 (\3\:n35 VSS) capacitor c=2.20754e-17
C68 (\7\:SN VSS) capacitor c=3.31128e-17
C69 (\2\:qbint VSS) capacitor c=4.23613e-17
C70 (\3\:RNb VSS) capacitor c=1.19578e-16
C71 (\8\:CKNbb VSS) capacitor c=3.22152e-17
C72 (\6\:CKNbb VSS) capacitor c=3.04115e-17
C73 (\2\:n20 VSS) capacitor c=4.96131e-17
C74 (\5\:SN VSS) capacitor c=2.21333e-17
C75 (\3\:SN VSS) capacitor c=4.05616e-17
C76 (\2\:mout VSS) capacitor c=5.2013e-17
C77 (\4\:CKNbb VSS) capacitor c=2.74822e-17
C78 (\2\:CKNbb VSS) capacitor c=4.28194e-17
C79 (\7\:CKNb VSS) capacitor c=1.00758e-17
C80 (\2\:CKN VSS) capacitor c=3.23261e-17
C81 (\2\:D VSS) capacitor c=5.45989e-17
C82 (\4\:SEb VSS) capacitor c=4.01799e-17
C83 (\5\:SE VSS) capacitor c=6.23074e-17
C84 (\2\:SEb VSS) capacitor c=4.30089e-17
C85 (\2\:SI VSS) capacitor c=6.43341e-17
C86 (\2\:SE VSS) capacitor c=4.34135e-17
C87 (\8\:qint VSS) capacitor c=3.92722e-17
C88 (\1\:QN VSS) capacitor c=5.25659e-17
C89 (\1\:Q VSS) capacitor c=4.95386e-17
C90 (\1\:VDD VSS) capacitor c=1.44794e-16
C91 (\10\:RNb VSS) capacitor c=2.06755e-17
C92 (\20\:qbint VSS) capacitor c=5.7422e-17
C93 (\16\:VDD VSS) capacitor c=1.53559e-17
C94 (\18\:VDD VSS) capacitor c=3.0296e-17
C95 (\3\:net566 VSS) capacitor c=1.326e-16
C96 (\7\:n35 VSS) capacitor c=2.21775e-17
C97 (\10\:mout VSS) capacitor c=3.58322e-17
C98 (\20\:VDD VSS) capacitor c=3.02704e-17
C99 (\14\:mout VSS) capacitor c=3.31507e-17
C100 (\22\:VDD VSS) capacitor c=3.398e-17
C101 (\7\:n20 VSS) capacitor c=7.51635e-17
C102 (\13\:CKNbb VSS) capacitor c=7.26858e-17
C103 (\25\:VDD VSS) capacitor c=4.31278e-17
C104 (\13\:CKNb VSS) capacitor c=5.22449e-17
C105 (\27\:VDD VSS) capacitor c=3.15395e-17
C106 (\8\:Db VSS) capacitor c=1.24861e-16
C107 (\33\:VDD VSS) capacitor c=9.12668e-18
C108 (\7\:SEb VSS) capacitor c=6.63688e-17
C109 (\5\:VDD VSS) capacitor c=1.2122e-16
C110 (\12\:qint VSS) capacitor c=2.08846e-17
C111 (\3\:QN VSS) capacitor c=3.01933e-17
C112 (\4\:Q VSS) capacitor c=7.94207e-17
C113 (\6\:RNb VSS) capacitor c=1.15486e-16
C114 (\17\:qbint VSS) capacitor c=6.56592e-17
C115 (\3\:net0363 VSS) capacitor c=1.1429e-16
C116 (\3\:net498 VSS) capacitor c=6.83497e-17
C117 (\9\:n35 VSS) capacitor c=6.33204e-17
C118 (\4\:mout VSS) capacitor c=4.25046e-17
C119 (\12\:mout VSS) capacitor c=4.30649e-17
C120 (\3\:net521 VSS) capacitor c=7.73926e-17
C121 (\5\:n20 VSS) capacitor c=1.92369e-16
C122 (\3\:Db VSS) capacitor c=1.92414e-16
C123 (\17\:CKNbb VSS) capacitor c=5.08338e-17
C124 (\15\:CKNb VSS) capacitor c=4.4735e-17
C125 (\6\:Db VSS) capacitor c=1.95816e-17
C126 (\9\:SEb VSS) capacitor c=7.45446e-17
C127 (\2\:SN VSS) capacitor c=3.17557e-17
C128 (\4\:SI VSS) capacitor c=6.43544e-17
C129 (\7\:SE VSS) capacitor c=4.89284e-17
C130 (\8\:SE VSS) capacitor c=3.21936e-17
C131 (\4\:CKNb VSS) capacitor c=5.70421e-17
C132 (\5\:CKNb VSS) capacitor c=2.00903e-17
C133 (\5\:SEb VSS) capacitor c=1.77922e-16
C134 (\6\:SEb VSS) capacitor c=1.37607e-16
C135 (\11\:SEb VSS) capacitor c=4.09563e-17
C136 (\4\:D VSS) capacitor c=4.58691e-17
C137 (\4\:CKN VSS) capacitor c=5.59471e-17
C138 (\2\:n35 VSS) capacitor c=1.52141e-17
C139 (\11\:CKNb VSS) capacitor c=4.79752e-17
C140 (\12\:CKNb VSS) capacitor c=5.99366e-17
C141 (\5\:Db VSS) capacitor c=2.37532e-16
C142 (\9\:SN VSS) capacitor c=6.08864e-17
C143 (\4\:n20 VSS) capacitor c=1.7277e-16
C144 (\6\:mout VSS) capacitor c=5.50605e-17
C145 (\7\:mout VSS) capacitor c=8.38154e-17
C146 (\8\:mout VSS) capacitor c=7.45116e-17
C147 (\9\:mout VSS) capacitor c=5.84333e-17
C148 (\9\:CKNbb VSS) capacitor c=8.11993e-17
C149 (\10\:CKNbb VSS) capacitor c=3.20411e-16
C150 (\11\:CKNbb VSS) capacitor c=2.0917e-16
C151 (\12\:CKNbb VSS) capacitor c=6.7034e-17
C152 (\15\:CKNbb VSS) capacitor c=1.73626e-17
C153 (\16\:CKNbb VSS) capacitor c=6.39142e-17
C154 (\10\:SN VSS) capacitor c=2.71789e-16
C155 (\11\:SN VSS) capacitor c=2.78709e-16
C156 (\5\:n35 VSS) capacitor c=1.75253e-16
C157 (\6\:n35 VSS) capacitor c=1.49006e-16
C158 (\8\:RNb VSS) capacitor c=1.35585e-16
C159 (\9\:RNb VSS) capacitor c=1.14692e-16
C160 (\4\:RN VSS) capacitor c=6.13246e-17
C161 (\3\:Q VSS) capacitor c=5.12148e-17
C162 (\14\:qbint VSS) capacitor c=1.10416e-16
C163 (\19\:qbint VSS) capacitor c=6.44683e-17
C164 (\23\:qbint VSS) capacitor c=7.2705e-17
C165 (\10\:qint VSS) capacitor c=3.88769e-17
C166 (\11\:qint VSS) capacitor c=3.27452e-17
C167 (\4\:VDD VSS) capacitor c=3.2375e-17
C168 (\7\:VDD VSS) capacitor c=4.96373e-17
C169 (\8\:VDD VSS) capacitor c=5.73577e-17
C170 (\10\:VDD VSS) capacitor c=2.30923e-17
C171 (\11\:VDD VSS) capacitor c=2.80807e-17
C172 (\32\:VDD VSS) capacitor c=3.32651e-17
Rk10 (\4\:D D) resistor r=0.015 c=0
Rk47 (RN \4\:RN) resistor r=0.177 c=0
Rk89 (\1\:VSS \7\:VSS) resistor r=0.3296 c=0
Rk90 (\7\:VSS \8\:VSS) resistor r=0.2706 c=0
Rk91 (\8\:VSS \9\:VSS) resistor r=1.1256 c=0
Rk92 (\9\:VSS \10\:VSS) resistor r=0.07753 c=0
Rk93 (\10\:VSS \11\:VSS) resistor r=0.7335 c=0
Rk94 (\11\:VSS \12\:VSS) resistor r=0.4124 c=0
Rk95 (\12\:VSS \13\:VSS) resistor r=0.05497 c=0
Rk97 (\14\:VSS VSS) resistor r=0.1149 c=0
Rk96 (\13\:VSS \14\:VSS) resistor r=0.4361 c=0
Rk100 (\7\:VSS \20\:VSS) resistor r=0.3564 c=0
Rk101 (\9\:VSS \22\:VSS) resistor r=0.338 c=0
Rk102 (\11\:VSS \24\:VSS) resistor r=0.0433 c=0
Rk103 (\12\:VSS \26\:VSS) resistor r=0.1726 c=0
Rk104 (\14\:VSS \28\:VSS) resistor r=0.1817 c=0
Rk19 (\9\:SN SN) resistor r=0.1631 c=0
Rk40 (\10\:SN \11\:SN) resistor r=2.1227 c=0
Rk49 (\3\:Q Q) resistor r=0.05081 c=0
Rk48 (\2\:Q \3\:Q) resistor r=0.1385 c=0
Rk50 (\3\:Q \5\:Q) resistor r=0.4019 c=0
Rk64 (\1\:VDD \4\:VDD) resistor r=0.3256 c=0
Rk65 (\4\:VDD \6\:VDD) resistor r=0.2907 c=0
Rk66 (\6\:VDD \7\:VDD) resistor r=0.1302 c=0
Rk67 (\7\:VDD \8\:VDD) resistor r=0.7393 c=0
Rk68 (\8\:VDD \9\:VDD) resistor r=0.3333 c=0
Rk69 (\9\:VDD \10\:VDD) resistor r=0.09759 c=0
Rk70 (\10\:VDD \11\:VDD) resistor r=0.5838 c=0
Rk71 (\11\:VDD \12\:VDD) resistor r=0.5213 c=0
Rk74 (\4\:VDD \17\:VDD) resistor r=0.07381 c=0
Rk75 (\7\:VDD \19\:VDD) resistor r=0.1572 c=0
Rk76 (\8\:VDD \21\:VDD) resistor r=0.1526 c=0
Rk77 (\10\:VDD \23\:VDD) resistor r=0.07381 c=0
Rk78 (\23\:VDD \24\:VDD) resistor r=0.1501 c=0
Rk79 (\11\:VDD \26\:VDD) resistor r=0.4058 c=0
Rk80 (\12\:VDD \28\:VDD) resistor r=0.3003 c=0
Rk85 (\32\:VDD VDD) resistor r=0.1074 c=0
Rk83 (\12\:VDD \32\:VDD) resistor r=0.4442 c=0
Rk84 (\32\:VDD \34\:VDD) resistor r=0.07381 c=0
Rk2 (\7\:SE SE) resistor r=0.1426 c=0
Rk3 (SE \8\:SE) resistor r=0.05367 c=0
Rk1 (SI \4\:SI) resistor r=0.02867 c=0
Rk11 (CKN \4\:CKN) resistor r=0.1124 c=0
Rk51 (\2\:QN QN) resistor r=0.1716 c=0
Rk52 (QN \4\:QN) resistor r=0.05987 c=0
Rk4 (\5\:SEb \6\:SEb) resistor r=1.1937 c=0
Rk5 (\6\:SEb \8\:SEb) resistor r=0.2534 c=0
Rk6 (\8\:SEb \10\:SEb) resistor r=0.6366 c=0
Rk7 (\6\:SEb \11\:SEb) resistor r=0.1561 c=0
Rk15 (\2\:Db \4\:Db) resistor r=0.4096 c=0
Rk16 (\4\:Db \5\:Db) resistor r=1.532 c=0
Rk17 (\5\:Db \7\:Db) resistor r=0.1012 c=0
Rk18 (\5\:Db \9\:Db) resistor r=0.7111 c=0
Rk12 (\11\:CKNb \12\:CKNb) resistor r=0.3582 c=0
Rk13 (\12\:CKNb \14\:CKNb) resistor r=0.4916 c=0
Rk14 (\12\:CKNb \16\:CKNb) resistor r=0.178 c=0
Rk30 (\9\:CKNbb \10\:CKNbb) resistor r=0.6269 c=0
Rk31 (\10\:CKNbb \11\:CKNbb) resistor r=1.6418 c=0
Rk32 (\11\:CKNbb \12\:CKNbb) resistor r=0.2063 c=0
Rk33 (\12\:CKNbb \14\:CKNbb) resistor r=0.4036 c=0
Rk34 (\11\:CKNbb \15\:CKNbb) resistor r=0.05041 c=0
Rk35 (\12\:CKNbb \16\:CKNbb) resistor r=0.3465 c=0
Rk36 (\14\:CKNbb \18\:CKNbb) resistor r=0.2847 c=0
Rk20 (\4\:n20 \6\:n20) resistor r=1.2023 c=0
Rk21 (\6\:n20 \8\:n20) resistor r=0.3838 c=0
Rk23 (\5\:mout \6\:mout) resistor r=0.2236 c=0
Rk24 (\6\:mout \7\:mout) resistor r=0.4568 c=0
Rk25 (\7\:mout \8\:mout) resistor r=0.3521 c=0
Rk26 (\8\:mout \9\:mout) resistor r=0.3157 c=0
Rk27 (\6\:mout \11\:mout) resistor r=0.1203 c=0
Rk28 (\7\:mout \13\:mout) resistor r=0.215 c=0
Rk29 (\8\:mout \15\:mout) resistor r=0.1168 c=0
Rk22 (\2\:net521 \4\:net521) resistor r=0.5226 c=0
Rk44 (\7\:RNb \8\:RNb) resistor r=0.6011 c=0
Rk45 (\8\:RNb \9\:RNb) resistor r=0.7204 c=0
Rk46 (\8\:RNb \11\:RNb) resistor r=0.0503 c=0
Rk41 (\5\:n35 \6\:n35) resistor r=1.125 c=0
Rk42 (\6\:n35 \8\:n35) resistor r=0.05676 c=0
Rk43 (\6\:n35 \10\:n35) resistor r=0.2943 c=0
Rk37 (\2\:net0363 \4\:net0363) resistor r=0.7252 c=0
Rk38 (\2\:net498 \4\:net498) resistor r=0.3862 c=0
Rk53 (\14\:qbint \4\:qbint) resistor r=0.8478 c=0
Rk55 (\4\:qbint \18\:qbint) resistor r=0.5105 c=0
Rk56 (\18\:qbint \19\:qbint) resistor r=0.1593 c=0
Rk57 (\19\:qbint \21\:qbint) resistor r=0.2594 c=0
Rk59 (\19\:qbint \23\:qbint) resistor r=0.3557 c=0
Rk60 (\9\:qint \10\:qint) resistor r=0.3681 c=0
Rk61 (\10\:qint \11\:qint) resistor r=0.1802 c=0
Rk62 (\10\:qint \13\:qint) resistor r=0.1138 c=0
Rk39 (\2\:net566 \4\:net566) resistor r=0.7765 c=0
Rl10 (\2\:D \3\:D) resistor r=112.637 c=0
Rl9 (\1\:D \2\:D) resistor r=161.538 c=0
Rl45 (\1\:RN \2\:RN) resistor r=156.925 c=0
Rl46 (\2\:RN \3\:RN) resistor r=37.6944 c=0
Rl41 (\6\:SN \8\:SN) resistor r=140.385 c=0
Rl40 (\6\:SN \7\:SN) resistor r=70.3288 c=0
Rl20 (\4\:SN \5\:SN) resistor r=50.6918 c=0
Rl19 (\2\:SN \4\:SN) resistor r=99.6815 c=0
Rl17 (\1\:SN \2\:SN) resistor r=105.747 c=0
Rl18 (\2\:SN \3\:SN) resistor r=78.0596 c=0
Rl6 (\4\:SE \5\:SE) resistor r=276.489 c=0
Rl7 (\5\:SE \6\:SE) resistor r=26.3736 c=0
Rl1 (\1\:SE \2\:SE) resistor r=193 c=0
Rl2 (\2\:SE \3\:SE) resistor r=29.5379 c=0
Rl3 (\1\:SI \2\:SI) resistor r=104.538 c=0
Rl4 (\2\:SI \3\:SI) resistor r=168 c=0
Rl12 (\2\:CKN \3\:CKN) resistor r=135.714 c=0
Rl11 (\1\:CKN \2\:CKN) resistor r=30.7692 c=0
Rl8 (\3\:SEb \4\:SEb) resistor r=93.4636 c=0
Rl5 (SEb \2\:SEb) resistor r=24.2328 c=0
Rl24 (CKNb \2\:CKNb) resistor r=158.747 c=0
Rl25 (\2\:CKNb \3\:CKNb) resistor r=905.335 c=0
Rl30 (\4\:CKNb \8\:CKNb) resistor r=30.4507 c=0
Rl26 (\3\:CKNb \4\:CKNb) resistor r=224.543 c=0
Rl31 (\5\:CKNb \9\:CKNb) resistor r=28.0797 c=0
Rl27 (\4\:CKNb \5\:CKNb) resistor r=149.196 c=0
Rl32 (\6\:CKNb \10\:CKNb) resistor r=46.9565 c=0
Rl29 (\6\:CKNb \7\:CKNb) resistor r=3.7301 c=0
Rl28 (\5\:CKNb \6\:CKNb) resistor r=25.0362 c=0
Rl33 (\7\:CKNbb \8\:CKNbb) resistor r=81.9251 c=0
Rl23 (\5\:CKNbb \6\:CKNbb) resistor r=24.2328 c=0
Rl14 (\3\:CKNbb \4\:CKNbb) resistor r=37.6944 c=0
Rl13 (CKNbb \2\:CKNbb) resistor r=39.1533 c=0
Rl22 (\2\:n20 \3\:n20) resistor r=89.5604 c=0
Rl21 (n20 \2\:n20) resistor r=33.4411 c=0
Rl15 (mout \2\:mout) resistor r=24.2328 c=0
Rl16 (\2\:mout \3\:mout) resistor r=91.5405 c=0
Rl34 (RNb \2\:RNb) resistor r=132.325 c=0
Rl37 (\4\:RNb \5\:RNb) resistor r=172.643 c=0
Rl35 (\2\:RNb \3\:RNb) resistor r=24.2328 c=0
Rl36 (\3\:RNb \4\:RNb) resistor r=987.26 c=0
Rl42 (n35 \2\:n35) resistor r=34.3295 c=0
Rl44 (\2\:n35 \4\:n35) resistor r=74.7141 c=0
Rl43 (\2\:n35 \3\:n35) resistor r=2.0166 c=0
Rl58 (\12\:qbint \11\:qbint) resistor r=26.098 c=0
Rl59 (\12\:qbint \13\:qbint) resistor r=137.637 c=0
Rl38 (\2\:qbint qbint) resistor r=60.7713 c=0
Rl39 (\2\:qbint \3\:qbint) resistor r=37.6944 c=0
Rl56 (qint \6\:qint) resistor r=4.9938 c=0
Rz28 (\20\:VSS \19\:VSS) resistor r=75 c=0
Rz29 (\22\:VSS \21\:VSS) resistor r=75 c=0
Rz30 (\24\:VSS \23\:VSS) resistor r=75 c=0
Rz31 (\26\:VSS \25\:VSS) resistor r=75 c=0
Rz32 (\28\:VSS \27\:VSS) resistor r=75 c=0
Rz17 (\5\:Q \4\:Q) resistor r=75 c=0
Rz24 (\1\:VDD \5\:VDD) resistor r=10.7143 c=0
Rz21 (\6\:VDD \5\:VDD) resistor r=6.25 c=0
Rz22 (\9\:VDD \5\:VDD) resistor r=6.25 c=0
Rz23 (\12\:VDD \5\:VDD) resistor r=6.25 c=0
Rz18 (\4\:QN \3\:QN) resistor r=75 c=0
Rz1 (\9\:SEb \10\:SEb) resistor r=75 c=0
Rz3 (\3\:Db \4\:Db) resistor r=75 c=0
Rz4 (\6\:Db \7\:Db) resistor r=75 c=0
Rz2 (\15\:CKNb \16\:CKNb) resistor r=75 c=0
Rz10 (\17\:CKNbb \18\:CKNbb) resistor r=75 c=0
Rz5 (\5\:n20 \6\:n20) resistor r=75 c=0
Rz8 (\4\:mout \5\:mout) resistor r=75 c=0
Rz9 (\12\:mout \13\:mout) resistor r=75 c=0
Rz6 (net521 \2\:net521) resistor r=75 c=0
Rz7 (\3\:net521 \4\:net521) resistor r=75 c=0
Rz16 (\6\:RNb \7\:RNb) resistor r=75 c=0
Rz15 (\9\:n35 \10\:n35) resistor r=75 c=0
Rz11 (net0363 \2\:net0363) resistor r=75 c=0
Rz12 (\3\:net0363 \4\:net0363) resistor r=75 c=0
Rz13 (net498 \2\:net498) resistor r=75 c=0
Rz14 (\3\:net498 \4\:net498) resistor r=75 c=0
Rz19 (\18\:qbint \17\:qbint) resistor r=75 c=0
Rz20 (\13\:qint \12\:qint) resistor r=75 c=0
Ry28 (\1\:VSS \3\:VSS) resistor r=8.8571 c=0
Ry29 (\8\:VSS \3\:VSS) resistor r=5.1667 c=0
Ry30 (\10\:VSS \3\:VSS) resistor r=5.1667 c=0
Ry31 (\13\:VSS \3\:VSS) resistor r=5.1667 c=0
Ry13 (\2\:Q \1\:Q) resistor r=20.6667 c=0
Ry19 (\17\:VDD \16\:VDD) resistor r=62 c=0
Ry20 (\19\:VDD \18\:VDD) resistor r=62 c=0
Ry21 (\21\:VDD \20\:VDD) resistor r=62 c=0
Ry22 (\23\:VDD \22\:VDD) resistor r=62 c=0
Ry23 (\24\:VDD \22\:VDD) resistor r=62 c=0
Ry24 (\26\:VDD \25\:VDD) resistor r=62 c=0
Ry25 (\28\:VDD \27\:VDD) resistor r=62 c=0
Ry27 (\34\:VDD \33\:VDD) resistor r=62 c=0
Ry14 (\2\:QN \1\:QN) resistor r=62 c=0
Ry1 (\7\:SEb \8\:SEb) resistor r=62 c=0
Ry3 (Db \2\:Db) resistor r=62 c=0
Ry4 (\8\:Db \9\:Db) resistor r=62 c=0
Ry2 (\13\:CKNb \14\:CKNb) resistor r=62 c=0
Ry8 (\13\:CKNbb \14\:CKNbb) resistor r=62 c=0
Ry5 (\7\:n20 \8\:n20) resistor r=62 c=0
Ry6 (\10\:mout \11\:mout) resistor r=62 c=0
Ry7 (\14\:mout \15\:mout) resistor r=62 c=0
Ry12 (\10\:RNb \11\:RNb) resistor r=62 c=0
Ry11 (\7\:n35 \8\:n35) resistor r=62 c=0
Ry15 (\21\:qbint \20\:qbint) resistor r=62 c=0
Ry16 (\9\:qint \8\:qint) resistor r=62 c=0
Ry9 (net566 \2\:net566) resistor r=62 c=0
Ry10 (\3\:net566 \4\:net566) resistor r=62 c=0
Rx6 (\2\:D \4\:D) resistor r=45 c=0
Rx20 (\2\:RN \4\:RN) resistor r=45 c=0
Rx9 (\3\:SN \9\:SN) resistor r=45 c=0
Rx16 (\7\:SN \10\:SN) resistor r=45 c=0
Rx17 (\5\:SN \11\:SN) resistor r=45 c=0
Rx2 (\2\:SE \7\:SE) resistor r=45 c=0
Rx3 (\5\:SE \8\:SE) resistor r=45 c=0
Rx1 (\2\:SI \4\:SI) resistor r=45 c=0
Rx7 (\2\:CKN \4\:CKN) resistor r=45 c=0
Rx4 (\4\:SEb \5\:SEb) resistor r=45 c=0
Rx5 (\2\:SEb \11\:SEb) resistor r=45 c=0
Rx8 (\7\:CKNb \11\:CKNb) resistor r=45 c=0
Rx12 (\8\:CKNbb \9\:CKNbb) resistor r=45 c=0
Rx13 (\6\:CKNbb \10\:CKNbb) resistor r=45 c=0
Rx14 (\4\:CKNbb \15\:CKNbb) resistor r=45 c=0
Rx15 (\2\:CKNbb \16\:CKNbb) resistor r=45 c=0
Rx10 (\2\:n20 \4\:n20) resistor r=45 c=0
Rx11 (\2\:mout \9\:mout) resistor r=45 c=0
Rx19 (\3\:RNb \9\:RNb) resistor r=45 c=0
Rx18 (\3\:n35 \5\:n35) resistor r=45 c=0
Rx21 (\14\:qbint \12\:qbint) resistor r=45 c=0
Rx24 (\23\:qbint \2\:qbint) resistor r=45 c=0
Rx25 (\11\:qint \6\:qint) resistor r=45 c=0
mn10 (\9\:SEb \3\:SE \27\:VSS VSS) g45n1lvt w=(1.45e-07) l=4.5e-08 nf=1 \
        as=2.537e-14 ad=2.103e-14 ps=6.4e-07 pd=5.8e-07 nrd=1.16667 \
        nrs=1.16667 sa=1.45e-07 sb=1.09e-06 sd=160n sca=6.67224 \
        scb=0.00331168 scc=2.36561e-05 m=(1)
mn13 (net538 \3\:SI \27\:VSS VSS) g45n1lvt w=(1.45e-07) l=4.5e-08 nf=1 \
        as=2.537e-14 ad=1.16e-14 ps=6.4e-07 pd=4.5e-07 nrd=1.16667 \
        nrs=1.16667 sa=3.65e-07 sb=8.7e-07 sd=160n sca=6.67224 \
        scb=0.00331168 scc=2.36561e-05 m=(1)
mn14 (\6\:Db \6\:SE net538 VSS) g45n1lvt w=(1.45e-07) l=4.5e-08 nf=1 \
        as=1.16e-14 ad=5.075e-14 ps=4.5e-07 pd=9.9e-07 nrd=1.16667 \
        nrs=1.16667 sa=4.9e-07 sb=7.45e-07 sd=160n sca=6.67224 \
        scb=0.00331168 scc=2.36561e-05 m=(1)
mn12 (\6\:Db \3\:SEb net546 VSS) g45n1lvt w=(1.45e-07) l=4.5e-08 nf=1 \
        as=1.522e-14 ad=5.075e-14 ps=5e-07 pd=9.9e-07 nrd=1.16667 \
        nrs=1.16667 sa=8.85e-07 sb=3.5e-07 sd=160n sca=6.67224 \
        scb=0.00331168 scc=2.36561e-05 m=(1)
mn11 (net546 \1\:D \25\:VSS VSS) g45n1lvt w=(1.45e-07) l=4.5e-08 nf=1 \
        as=5.025e-14 ad=1.522e-14 ps=1.35e-06 pd=5e-07 nrd=1.16667 \
        nrs=1.16667 sa=1.035e-06 sb=2e-07 sd=160n sca=6.67224 \
        scb=0.00331168 scc=2.36561e-05 m=(1)
mn20 (\15\:CKNb \1\:CKN \25\:VSS VSS) g45n1lvt w=(1.45e-07) l=4.5e-08 \
        nf=1 as=5.025e-14 ad=4.132e-14 ps=1.35e-06 pd=8.6e-07 nrd=1.16667 \
        nrs=1.16667 sa=1e-07 sb=2.85e-07 sd=160n sca=23.279 scb=0.0230742 \
        scc=0.00267719 m=(1)
mn21 (\17\:CKNbb \10\:CKNb \23\:VSS VSS) g45n1lvt w=(1.45e-07) l=4.5e-08 \
        nf=1 as=7.245e-14 ad=2.61e-14 ps=1.66e-06 pd=6.5e-07 nrd=1.16667 \
        nrs=1.16667 sa=1.60345e-07 sb=1.8e-07 sd=160n sca=19.1673 \
        scb=0.0200674 scc=0.00182521 m=(1)
mn25 (\3\:Db CKNbb \5\:n20 VSS) g45n1lvt w=(1.45e-07) l=4.5e-08 nf=1 \
        as=3.19e-14 ad=2.03e-14 ps=7.3e-07 pd=5.7e-07 nrd=1.16667 \
        nrs=1.16667 sa=1.4e-07 sb=1.53e-06 sd=160n sca=12.2839 \
        scb=0.0124725 scc=0.000542081 m=(1)
mn36 (\5\:n20 \3\:CKNb net582 VSS) g45n1lvt w=(1.45e-07) l=4.5e-08 nf=1 \
        as=8.7e-15 ad=3.19e-14 ps=4.1e-07 pd=7.3e-07 nrd=1.16667 \
        nrs=1.16667 sa=4.05e-07 sb=1.265e-06 sd=160n sca=12.2839 \
        scb=0.0124725 scc=0.000542081 m=(1)
mn35 (net582 \3\:mout \21\:VSS VSS) g45n1lvt w=(1.45e-07) l=4.5e-08 nf=1 \
        as=7.975e-14 ad=8.7e-15 ps=1.39e-06 pd=4.1e-07 nrd=1.16667 \
        nrs=1.16667 sa=5.1e-07 sb=1.16e-06 sd=160n sca=12.2839 \
        scb=0.0124725 scc=0.000542081 m=(1)
mn30 (\3\:net521 \1\:SN \21\:VSS VSS) g45n1lvt w=(1.45e-07) l=4.5e-08 \
        nf=1 as=7.975e-14 ad=2.32e-14 ps=1.39e-06 pd=6.1e-07 nrd=1.16667 \
        nrs=1.16667 sa=1.105e-06 sb=5.65e-07 sd=160n sca=12.2839 \
        scb=0.0124725 scc=0.000542081 m=(1)
mn32 (\12\:mout n20 \3\:net521 VSS) g45n1lvt w=(1.45e-07) l=4.5e-08 nf=1 \
        as=2.32e-14 ad=2.537e-14 ps=6.1e-07 pd=6.4e-07 nrd=1.16667 \
        nrs=1.16667 sa=1.31e-06 sb=3.6e-07 sd=160n sca=12.2839 \
        scb=0.0124725 scc=0.000542081 m=(1)
mn31 (\12\:mout \5\:RNb net521 VSS) g45n1lvt w=(1.45e-07) l=4.5e-08 nf=1 \
        as=2.03e-14 ad=2.537e-14 ps=5.7e-07 pd=6.4e-07 nrd=1.16667 \
        nrs=1.16667 sa=1.53e-06 sb=1.4e-07 sd=160n sca=12.2839 \
        scb=0.0124725 scc=0.000542081 m=(1)
mn40 (\4\:mout \2\:CKNb \9\:n35 VSS) g45n1lvt w=(1.45e-07) l=4.5e-08 nf=1 \
        as=2.32e-14 ad=4.132e-14 ps=6.1e-07 pd=8.6e-07 nrd=1.16667 \
        nrs=1.16667 sa=2.85e-07 sb=3.45e-07 sd=160n sca=15.2405 \
        scb=0.016218 scc=0.00104639 m=(1)
mn53 (\9\:n35 \7\:CKNbb net0363 VSS) g45n1lvt w=(1.45e-07) l=4.5e-08 nf=1 \
        as=2.03e-14 ad=2.32e-14 ps=5.7e-07 pd=6.1e-07 nrd=1.16667 \
        nrs=1.16667 sa=4.9e-07 sb=1.4e-07 sd=160n sca=15.2405 scb=0.016218 \
        scc=0.00104639 m=(1)
mn51 (\3\:net0363 RNb \3\:net498 VSS) g45n1lvt w=(1.45e-07) l=4.5e-08 \
        nf=1 as=2.03e-14 ad=2.32e-14 ps=5.7e-07 pd=6.1e-07 nrd=1.16667 \
        nrs=1.16667 sa=1.4e-07 sb=7.55e-07 sd=160n sca=15.2405 \
        scb=0.016218 scc=0.00104639 m=(1)
mn52 (\3\:net0363 \3\:qbint net498 VSS) g45n1lvt w=(1.45e-07) l=4.5e-08 \
        nf=1 as=2.32e-14 ad=2.32e-14 ps=6.1e-07 pd=6.1e-07 nrd=1.16667 \
        nrs=1.16667 sa=3.45e-07 sb=5.5e-07 sd=160n sca=15.2405 \
        scb=0.016218 scc=0.00104639 m=(1)
mn50 (net498 \8\:SN \19\:VSS VSS) g45n1lvt w=(1.45e-07) l=4.5e-08 nf=1 \
        as=2.92e-14 ad=2.32e-14 ps=7.3e-07 pd=6.1e-07 nrd=1.16667 \
        nrs=1.16667 sa=5.5e-07 sb=3.45e-07 sd=160n sca=15.2405 \
        scb=0.016218 scc=0.00104639 m=(1)
mn22 (\6\:RNb \3\:RN \1\:VSS VSS) g45n1lvt w=(1.45e-07) l=4.5e-08 nf=1 \
        as=5.685e-14 ad=2.03e-14 ps=1.53e-06 pd=5.7e-07 nrd=1.16667 \
        nrs=1.16667 sa=1.4e-07 sb=1.28e-06 sd=160n sca=16.7245 \
        scb=0.0178071 scc=0.00133148 m=(1)
mn56 (\12\:qint \13\:qbint \1\:VSS VSS) g45n1lvt w=(1.45e-07) l=4.5e-08 \
        nf=1 as=3.47e-14 ad=2.03e-14 ps=8.4e-07 pd=5.7e-07 nrd=1.16667 \
        nrs=1.16667 sa=1.28e-06 sb=1.4e-07 sd=160n sca=16.7245 \
        scb=0.0178071 scc=0.00133148 m=(1)
mn45 (\17\:qbint \4\:n35 \19\:VSS VSS) g45n1lvt w=(2.05e-07) l=4.5e-08 \
        nf=1 as=2.92e-14 ad=2.87e-14 ps=7.3e-07 pd=6.9e-07 nrd=1.16667 \
        nrs=1.16667 sa=5.63293e-07 sb=1.4e-07 sd=160n sca=19.867 \
        scb=0.0198061 scc=0.00201945 m=(1)
mn55 (\4\:Q \4\:qbint \1\:VSS VSS) g45n1lvt w=(2.6e-07) l=4.5e-08 nf=1 \
        as=6.027e-14 ad=4.94e-14 ps=1.27e-06 pd=9e-07 nrd=1.16667 \
        nrs=1.16667 sa=2.36635e-07 sb=9.66635e-07 sd=160n sca=13.198 \
        scb=0.0131159 scc=0.000803647 m=(2)
mn57 (\3\:QN qint \1\:VSS VSS) g45n1lvt w=(2.6e-07) l=4.5e-08 nf=1 \
        as=4.92e-14 ad=4.16e-14 ps=9.25e-07 pd=8.4e-07 nrd=1.16667 \
        nrs=1.16667 sa=7.61635e-07 sb=4.41635e-07 sd=160n sca=13.198 \
        scb=0.0131159 scc=0.000803647 m=(2)
mp45 (\20\:qbint n35 \16\:VDD VDD) g45p1lvt w=(3.1e-07) l=4.5e-08 nf=1 \
        as=7.005e-14 ad=4.495e-14 ps=1.79e-06 pd=9.1e-07 nrd=1.16667 \
        nrs=1.16667 sa=4.65726e-07 sb=1.45e-07 sd=160n sca=19.1541 \
        scb=0.0174883 scc=0.00172295 m=(1)
mp55_1__rcx (\1\:Q \4\:qbint \1\:VDD VDD) g45p1lvt w=(3.9e-07) l=4.5e-08 \
        nf=1 as=7.342e-14 ad=7.41e-14 ps=1.305e-06 pd=1.16e-06 nrd=1.16667 \
        nrs=1.16667 sa=2.35064e-07 sb=8.25385e-07 sd=160n sca=13.3279 \
        scb=0.011929 scc=0.000599966 m=(2)
mp57_1__rcx (\1\:QN qint \1\:VDD VDD) g45p1lvt w=(3.9e-07) l=4.5e-08 \
        nf=1 as=7.914e-14 ad=6.24e-14 ps=1.4e-06 pd=1.1e-06 nrd=1.16667 \
        nrs=1.16667 sa=5.23141e-07 sb=4.40385e-07 sd=160n sca=31.0979 \
        scb=0.0204275 scc=0.00336106 m=(2)
ends SDFFNSRX2
// End of subcircuit definition.
