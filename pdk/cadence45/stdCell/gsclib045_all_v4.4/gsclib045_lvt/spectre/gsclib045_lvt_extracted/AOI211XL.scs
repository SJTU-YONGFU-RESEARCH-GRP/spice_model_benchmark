// Generated for: spectre (May  1 09:11:47 2013 )
// Library name: gsclib045_lvt
// Cell name: AOI211XL
// View name: extracted

simulator lang=spectre

subckt AOI211XL A0 A1 B0 C0 VDD VSS Y
mp0 (net91 \3\:A0 \4\:VDD VDD) g45p1lvt w=(2.15e-07) l=4.5e-08 nf=1 \
        as=3.44e-14 ad=3.01e-14 ps=7.5e-07 pd=7.1e-07 nrd=1.16667 \
        nrs=1.16667 sa=1.4e-07 sb=8.95e-07 sd=160n sca=21.1265 \
        scb=0.0233936 scc=0.000954114 m=(1)
mp1 (\3\:net91 \1\:A1 \4\:VDD VDD) g45p1lvt w=(2.15e-07) l=4.5e-08 nf=1 \
        as=3.44e-14 ad=5.268e-14 ps=7.5e-07 pd=9.2e-07 nrd=1.16667 \
        nrs=1.16667 sa=3.45e-07 sb=6.9e-07 sd=160n sca=13.9396 \
        scb=0.0112937 scc=0.000117391 m=(1)
mp2 (net82 \1\:B0 \3\:net91 VDD) g45p1lvt w=(2.15e-07) l=4.5e-08 nf=1 \
        as=5.268e-14 ad=3.44e-14 ps=9.2e-07 pd=7.5e-07 nrd=1.16667 \
        nrs=1.16667 sa=6.35e-07 sb=4e-07 sd=160n sca=13.5585 scb=0.010525 \
        scc=0.000106027 m=(1)
mp3 (\1\:Y \1\:C0 net82 VDD) g45p1lvt w=(2.15e-07) l=4.5e-08 nf=1 \
        as=3.44e-14 ad=4.193e-14 ps=7.5e-07 pd=8.2e-07 nrd=1.16667 \
        nrs=1.16667 sa=8.4e-07 sb=1.95e-07 sd=160n sca=18.7951 \
        scb=0.0200922 scc=0.000572349 m=(1)
C1 (C0 VSS) capacitor c=5.26787e-17
C2 (B0 VSS) capacitor c=3.89959e-17
C3 (VDD VSS) capacitor c=1.16235e-16
C4 (A1 VSS) capacitor c=5.4051e-17
C5 (Y VSS) capacitor c=5.07836e-17
C6 (net91 VSS) capacitor c=6.267e-17
C7 (\1\:C0 VSS) capacitor c=4.76361e-17
C8 (\1\:B0 VSS) capacitor c=5.43928e-17
C9 (\1\:A1 VSS) capacitor c=5.56121e-17
C10 (\3\:A0 VSS) capacitor c=5.46735e-17
C11 (\3\:C0 VSS) capacitor c=3.80707e-17
C12 (\3\:B0 VSS) capacitor c=3.43463e-17
C13 (\3\:A1 VSS) capacitor c=5.68629e-17
C14 (\1\:A0 VSS) capacitor c=6.96987e-17
C15 (\2\:C0 VSS) capacitor c=5.26859e-17
C16 (\2\:B0 VSS) capacitor c=5.77268e-17
C17 (\2\:A1 VSS) capacitor c=5.87627e-17
C18 (\2\:A0 VSS) capacitor c=5.32385e-17
C19 (\1\:Y VSS) capacitor c=1.59008e-17
C20 (\3\:net91 VSS) capacitor c=5.01604e-17
C21 (\4\:VDD VSS) capacitor c=3.17741e-17
C22 (\6\:Y VSS) capacitor c=2.80975e-17
C23 (\4\:Y VSS) capacitor c=6.70976e-17
C24 (\4\:A0 VSS) capacitor c=1.9679e-17
C25 (\6\:A0 VSS) capacitor c=7.83369e-17
C26 (\4\:A1 VSS) capacitor c=5.15877e-17
C27 (\4\:B0 VSS) capacitor c=7.06757e-17
C28 (\4\:C0 VSS) capacitor c=6.28574e-17
C29 (\3\:Y VSS) capacitor c=7.18478e-17
C30 (\3\:VDD VSS) capacitor c=3.11002e-17
Rk7 (C0 \4\:C0) resistor r=0.225 c=0
Rk1 (\4\:A0 \5\:A0) resistor r=0.002021 c=0
Rk2 (A0 \6\:A0) resistor r=0.001953 c=0
Rk3 (\4\:A0 \6\:A0) resistor r=0.05142 c=0
Rk6 (B0 \4\:B0) resistor r=0.1148 c=0
Rk13 (\3\:VSS VSS) resistor r=0.06475 c=0
Rk12 (\2\:VSS \3\:VSS) resistor r=0.1939 c=0
Rk14 (\3\:VSS \5\:VSS) resistor r=0.1854 c=0
Rk15 (\5\:VSS \7\:VSS) resistor r=0.3057 c=0
Rk17 (\3\:VDD VDD) resistor r=0.1174 c=0
Rk18 (\3\:VDD \5\:VDD) resistor r=0.234 c=0
Rk4 (\4\:A1 A1) resistor r=0.1584 c=0
Rk8 (\2\:Y Y) resistor r=0.1267 c=0
Rk9 (Y \3\:Y) resistor r=0.4242 c=0
Rk10 (\3\:Y \5\:Y) resistor r=0.3839 c=0
Rk11 (\3\:Y \7\:Y) resistor r=0.0641 c=0
Rk5 (\2\:net91 \4\:net91) resistor r=0.3117 c=0
Rl7 (\1\:C0 \2\:C0) resistor r=181.461 c=0
Rl8 (\2\:C0 \3\:C0) resistor r=89.1533 c=0
Rl2 (\2\:A0 \3\:A0) resistor r=225.722 c=0
Rl1 (\1\:A0 \2\:A0) resistor r=105.323 c=0
Rl5 (\1\:B0 \2\:B0) resistor r=193 c=0
Rl6 (\2\:B0 \3\:B0) resistor r=77.6149 c=0
Rl3 (\1\:A1 \2\:A1) resistor r=178.079 c=0
Rl4 (\2\:A1 \3\:A1) resistor r=89.6174 c=0
Rz3 (\1\:VSS \2\:VSS) resistor r=75 c=0
Rz4 (\6\:VSS \7\:VSS) resistor r=75 c=0
Rz1 (\4\:Y \5\:Y) resistor r=75 c=0
Rz2 (\6\:Y \7\:Y) resistor r=75 c=0
Ry5 (\4\:VDD \5\:VDD) resistor r=62 c=0
Ry3 (\1\:Y \2\:Y) resistor r=62 c=0
Ry1 (net91 \2\:net91) resistor r=62 c=0
Ry2 (\3\:net91 \4\:net91) resistor r=62 c=0
Rx4 (\2\:C0 \4\:C0) resistor r=45 c=0
Rx1 (\2\:A0 \5\:A0) resistor r=45 c=0
Rx3 (\2\:B0 \4\:B0) resistor r=45 c=0
Rx2 (\2\:A1 \4\:A1) resistor r=45 c=0
mn0 (net95 \1\:A0 \1\:VSS VSS) g45n1lvt w=(1.45e-07) l=4.5e-08 nf=1 \
        as=2.03e-14 ad=8.7e-15 ps=5.7e-07 pd=4.1e-07 nrd=1.16667 \
        nrs=1.16667 sa=1.4e-07 sb=7.4e-07 sd=160n sca=7.09016 \
        scb=0.00401586 scc=3.69756e-05 m=(1)
mn1 (\4\:Y \3\:A1 net95 VSS) g45n1lvt w=(1.45e-07) l=4.5e-08 nf=1 \
        as=8.7e-15 ad=3.553e-14 ps=4.1e-07 pd=7.8e-07 nrd=1.16667 \
        nrs=1.16667 sa=2.45e-07 sb=6.35e-07 sd=160n sca=7.09016 \
        scb=0.00401586 scc=3.69756e-05 m=(1)
mn2 (\4\:Y \3\:B0 \6\:VSS VSS) g45n1lvt w=(1.45e-07) l=4.5e-08 nf=1 \
        as=2.32e-14 ad=3.553e-14 ps=6.1e-07 pd=7.8e-07 nrd=1.16667 \
        nrs=1.16667 sa=5.35e-07 sb=3.45e-07 sd=160n sca=7.09016 \
        scb=0.00401586 scc=3.69756e-05 m=(1)
mn3 (\6\:Y \3\:C0 \6\:VSS VSS) g45n1lvt w=(1.45e-07) l=4.5e-08 nf=1 \
        as=2.32e-14 ad=2.03e-14 ps=6.1e-07 pd=5.7e-07 nrd=1.16667 \
        nrs=1.16667 sa=7.4e-07 sb=1.4e-07 sd=160n sca=7.09016 \
        scb=0.00401586 scc=3.69756e-05 m=(1)
ends AOI211XL
// End of subcircuit definition.
