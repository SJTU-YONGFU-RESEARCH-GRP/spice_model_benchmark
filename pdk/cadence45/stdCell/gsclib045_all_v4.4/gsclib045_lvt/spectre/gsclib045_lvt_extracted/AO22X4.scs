// Generated for: spectre (May  1 09:11:43 2013 )
// Library name: gsclib045_lvt
// Cell name: AO22X4
// View name: extracted

simulator lang=spectre

subckt AO22X4 A0 A1 B0 B1 VDD VSS Y
mp0 (\5\:n3 \1\:A0 \12\:VDD VDD) g45p1lvt w=(3.9e-07) l=4.5e-08 nf=1 \
        as=6.24e-14 ad=5.46e-14 ps=1.1e-06 pd=1.06e-06 nrd=1.16667 \
        nrs=1.16667 sa=1.4e-07 sb=7.6e-07 sd=160n sca=18.7619 \
        scb=0.0191068 scc=0.000809457 m=(1)
mp1 (\3\:n3 \1\:A1 \12\:VDD VDD) g45p1lvt w=(3.9e-07) l=4.5e-08 nf=1 \
        as=6.24e-14 ad=6.24e-14 ps=1.1e-06 pd=1.1e-06 nrd=1.16667 \
        nrs=1.16667 sa=3.45e-07 sb=5.55e-07 sd=160n sca=15.4935 \
        scb=0.0137026 scc=0.000701664 m=(1)
mp3 (\19\:n0 \1\:B1 \3\:n3 VDD) g45p1lvt w=(3.9e-07) l=4.5e-08 nf=1 \
        as=6.24e-14 ad=6.435e-14 ps=1.1e-06 pd=1.11e-06 nrd=1.16667 \
        nrs=1.16667 sa=5.5e-07 sb=3.5e-07 sd=160n sca=14.3467 \
        scb=0.0126321 scc=0.000698974 m=(1)
mp2 (\19\:n0 \4\:B0 n3 VDD) g45p1lvt w=(3.9e-07) l=4.5e-08 nf=1 \
        as=5.46e-14 ad=6.435e-14 ps=1.06e-06 pd=1.11e-06 nrd=1.16667 \
        nrs=1.16667 sa=7.6e-07 sb=1.4e-07 sd=160n sca=13.8244 \
        scb=0.0124477 scc=0.000698915 m=(1)
mp4_1__rcx (\1\:Y n0 \1\:VDD VDD) g45p1lvt w=(3.9e-07) l=4.5e-08 nf=1 \
        as=6.076e-14 ad=6.24e-14 ps=1.2575e-06 pd=1.1e-06 nrd=1.16667 \
        nrs=1.16667 sa=1e-07 sb=7.55e-07 sd=160n sca=26.0272 scb=0.019144 \
        scc=0.00277829 m=(4)
C1 (B0 VSS) capacitor c=6.45029e-17
C2 (A0 VSS) capacitor c=8.99733e-17
C3 (Y VSS) capacitor c=3.98225e-17
C4 (VDD VSS) capacitor c=9.5668e-17
C5 (B1 VSS) capacitor c=1.50948e-16
C6 (n1 VSS) capacitor c=1.95858e-18
C7 (n0 VSS) capacitor c=3.26823e-16
C8 (n2 VSS) capacitor c=6.9018e-18
C9 (n3 VSS) capacitor c=5.27882e-17
C10 (\4\:B0 VSS) capacitor c=5.01082e-17
C11 (\1\:B1 VSS) capacitor c=6.08453e-17
C12 (\1\:A1 VSS) capacitor c=5.04952e-17
C13 (\1\:A0 VSS) capacitor c=5.11663e-17
C14 (\3\:B0 VSS) capacitor c=4.76583e-17
C15 (\4\:B1 VSS) capacitor c=3.87366e-17
C16 (\3\:A1 VSS) capacitor c=5.50276e-17
C17 (\3\:A0 VSS) capacitor c=3.0127e-17
C18 (\1\:B0 VSS) capacitor c=1.92429e-17
C19 (\3\:B1 VSS) capacitor c=4.81485e-17
C20 (\2\:A1 VSS) capacitor c=4.4978e-17
C21 (\2\:A0 VSS) capacitor c=3.51039e-17
C22 (\1\:VDD VSS) capacitor c=1.49143e-16
C23 (\1\:Y VSS) capacitor c=1.75452e-16
C24 (\19\:n0 VSS) capacitor c=7.233e-17
C25 (\3\:n3 VSS) capacitor c=8.55288e-17
C26 (\12\:VDD VSS) capacitor c=4.58298e-17
C27 (\5\:n3 VSS) capacitor c=5.16738e-17
C28 (\4\:Y VSS) capacitor c=1.13843e-16
C29 (\17\:n0 VSS) capacitor c=5.8502e-17
C30 (\2\:B0 VSS) capacitor c=2.65359e-17
C31 (\4\:A1 VSS) capacitor c=1.21377e-16
C32 (\5\:B0 VSS) capacitor c=3.78018e-17
C33 (\16\:n0 VSS) capacitor c=1.07288e-16
C34 (\6\:VDD VSS) capacitor c=2.34155e-17
C35 (\7\:VDD VSS) capacitor c=2.16145e-17
Rk6 (\5\:B0 B0) resistor r=0.09861 c=0
Rk1 (A0 \4\:A0) resistor r=0.002995 c=0
Rk12 (\1\:Y Y) resistor r=0.1925 c=0
Rk13 (Y \4\:Y) resistor r=0.1889 c=0
Rk18 (\1\:VDD \6\:VDD) resistor r=0.07248 c=0
Rk20 (\7\:VDD VDD) resistor r=0.1775 c=0
Rk19 (\6\:VDD \7\:VDD) resistor r=0.3231 c=0
Rk23 (\7\:VDD \13\:VDD) resistor r=0.2363 c=0
Rk3 (\5\:B1 B1) resistor r=0.002995 c=0
Rk2 (\4\:A1 A1) resistor r=0.003681 c=0
Rk26 (\5\:VSS VSS) resistor r=0.07474 c=0
Rk25 (\1\:VSS \5\:VSS) resistor r=0.4264 c=0
Rk29 (\5\:VSS \10\:VSS) resistor r=0.2196 c=0
Rk8 (n0 \16\:n0) resistor r=0.3828 c=0
Rk9 (\16\:n0 \18\:n0) resistor r=0.3614 c=0
Rk10 (\16\:n0 \20\:n0) resistor r=0.3493 c=0
Rk4 (\2\:n3 \4\:n3) resistor r=0.3523 c=0
Rk5 (\4\:n3 \6\:n3) resistor r=0.4372 c=0
Rl10 (\2\:B0 \4\:B0) resistor r=59.3295 c=0
Rl9 (\2\:B0 \3\:B0) resistor r=105.483 c=0
Rl8 (\1\:B0 \2\:B0) resistor r=5.915 c=0
Rl1 (\1\:A0 \2\:A0) resistor r=114.56 c=0
Rl2 (\2\:A0 \3\:A0) resistor r=26.098 c=0
Rl5 (\1\:B1 \2\:B1) resistor r=130.483 c=0
Rl7 (\2\:B1 \4\:B1) resistor r=34.3295 c=0
Rl6 (\2\:B1 \3\:B1) resistor r=0.5166 c=0
Rl3 (\1\:A1 \2\:A1) resistor r=48.7687 c=0
Rl4 (\2\:A1 \3\:A1) resistor r=98.7687 c=0
Rz7 (\10\:VSS \9\:VSS) resistor r=75 c=0
Rz1 (\18\:n0 \17\:n0) resistor r=75 c=0
Ry10 (\13\:VDD \12\:VDD) resistor r=62 c=0
Ry4 (\20\:n0 \19\:n0) resistor r=62 c=0
Ry1 (n3 \2\:n3) resistor r=62 c=0
Ry2 (\3\:n3 \4\:n3) resistor r=31 c=0
Ry3 (\5\:n3 \6\:n3) resistor r=31 c=0
Rx4 (\1\:B0 \5\:B0) resistor r=45 c=0
Rx1 (\2\:A0 \4\:A0) resistor r=45 c=0
Rx3 (\3\:B1 \5\:B1) resistor r=45 c=0
Rx2 (\2\:A1 \4\:A1) resistor r=45 c=0
mn0 (n1 \3\:A0 \9\:VSS VSS) g45n1lvt w=(2.6e-07) l=4.5e-08 nf=1 \
        as=3.64e-14 ad=4.16e-14 ps=8e-07 pd=8.4e-07 nrd=1.16667 \
        nrs=1.16667 sa=1.4e-07 sb=1.65e-06 sd=160n sca=10.104 \
        scb=0.00906063 scc=0.000325539 m=(1)
mn1 (\17\:n0 \3\:A1 n1 VSS) g45n1lvt w=(2.6e-07) l=4.5e-08 nf=1 \
        as=4.16e-14 ad=4.16e-14 ps=8.4e-07 pd=8.4e-07 nrd=1.16667 \
        nrs=1.16667 sa=3.45e-07 sb=1.445e-06 sd=160n sca=10.104 \
        scb=0.00906063 scc=0.000325539 m=(1)
mn3 (\17\:n0 \4\:B1 n2 VSS) g45n1lvt w=(2.6e-07) l=4.5e-08 nf=1 \
        as=4.29e-14 ad=4.16e-14 ps=8.5e-07 pd=8.4e-07 nrd=1.16667 \
        nrs=1.16667 sa=5.5e-07 sb=1.24e-06 sd=160n sca=10.104 \
        scb=0.00906063 scc=0.000325539 m=(1)
mn2 (n2 \3\:B0 \1\:VSS VSS) g45n1lvt w=(2.6e-07) l=4.5e-08 nf=1 \
        as=4.81e-14 ad=4.29e-14 ps=8.9e-07 pd=8.5e-07 nrd=1.16667 \
        nrs=1.16667 sa=7.6e-07 sb=1.03e-06 sd=160n sca=10.104 \
        scb=0.00906063 scc=0.000325539 m=(1)
mn4_1__rcx (\4\:Y n0 \1\:VSS VSS) g45n1lvt w=(2.6e-07) l=4.5e-08 nf=1 \
        as=4.68e-14 ad=4.16e-14 ps=8.8e-07 pd=8.4e-07 nrd=1.16667 \
        nrs=1.16667 sa=9.9e-07 sb=8e-07 sd=160n sca=10.104 scb=0.00906063 \
        scc=0.000325539 m=(4)
ends AO22X4
// End of subcircuit definition.
