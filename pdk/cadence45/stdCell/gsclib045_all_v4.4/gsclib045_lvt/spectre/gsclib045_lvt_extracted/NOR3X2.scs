// Generated for: spectre (May  1 09:17:23 2013 )
// Library name: gsclib045_lvt
// Cell name: NOR3X2
// View name: extracted

simulator lang=spectre

subckt NOR3X2 A B C VDD VSS Y
mp0_1__rcx (2 \1\:A \1\:VDD VDD) g45p1lvt w=(3.9e-07) l=4.5e-08 nf=1 \
        as=5.46e-14 ad=2.34e-14 ps=1.06e-06 pd=9e-07 nrd=1.16667 \
        nrs=1.16667 sa=1.4e-07 sb=9.8e-07 sd=160n sca=25.9035 \
        scb=0.0222272 scc=0.0023141 m=(1)
mp1_1__rcx (2 \1\:B 6 VDD) g45p1lvt w=(3.9e-07) l=4.5e-08 nf=1 \
        as=8.58e-14 ad=2.34e-14 ps=1.22e-06 pd=9e-07 nrd=1.16667 \
        nrs=1.16667 sa=2.45e-07 sb=8.75e-07 sd=160n sca=24.3732 \
        scb=0.019725 scc=0.00227862 m=(1)
mp2_1__rcx (\7\:Y \5\:C 6 VDD) g45p1lvt w=(3.9e-07) l=4.5e-08 nf=1 \
        as=8.58e-14 ad=6.24e-14 ps=1.22e-06 pd=1.1e-06 nrd=1.16667 \
        nrs=1.16667 sa=5.1e-07 sb=6.1e-07 sd=160n sca=23.0721 \
        scb=0.0181341 scc=0.00227242 m=(1)
mp2 (\7\:Y \1\:C 7 VDD) g45p1lvt w=(3.9e-07) l=4.5e-08 nf=1 as=4.485e-14 \
        ad=6.24e-14 ps=1.01e-06 pd=1.1e-06 nrd=1.16667 nrs=1.16667 \
        sa=7.15e-07 sb=4.05e-07 sd=160n sca=23.4984 scb=0.0186248 \
        scc=0.00227326 m=(1)
mp1 (7 \4\:B 3 VDD) g45p1lvt w=(3.9e-07) l=4.5e-08 nf=1 as=2.34e-14 \
        ad=4.485e-14 ps=9e-07 pd=1.01e-06 nrd=1.16667 nrs=1.16667 \
        sa=8.75e-07 sb=2.45e-07 sd=160n sca=25.0585 scb=0.0207887 \
        scc=0.00228936 m=(1)
mp0 (3 \7\:A \6\:VDD VDD) g45p1lvt w=(3.9e-07) l=4.5e-08 nf=1 \
        as=5.46e-14 ad=2.34e-14 ps=1.06e-06 pd=9e-07 nrd=1.16667 \
        nrs=1.16667 sa=9.8e-07 sb=1.4e-07 sd=160n sca=27.2119 \
        scb=0.0245429 scc=0.0023829 m=(1)
C1 (B VSS) capacitor c=2.89866e-17
C2 (VDD VSS) capacitor c=7.00392e-17
C3 (C VSS) capacitor c=4.99222e-17
C4 (A VSS) capacitor c=1.30546e-17
C5 (Y VSS) capacitor c=1.02319e-16
C6 (7 VSS) capacitor c=3.66078e-18
C7 (3 VSS) capacitor c=2.41617e-18
C8 (\7\:A VSS) capacitor c=7.91493e-17
C9 (\4\:B VSS) capacitor c=9.27523e-17
C10 (\1\:C VSS) capacitor c=5.29994e-17
C11 (\5\:C VSS) capacitor c=2.25529e-17
C12 (\1\:B VSS) capacitor c=8.12404e-17
C13 (\1\:A VSS) capacitor c=1.00891e-16
C14 (\2\:C VSS) capacitor c=2.18976e-17
C15 (\2\:B VSS) capacitor c=3.8976e-16
C16 (\6\:VDD VSS) capacitor c=3.14069e-17
C17 (\7\:Y VSS) capacitor c=8.66386e-17
C18 (\1\:VDD VSS) capacitor c=2.55059e-17
C19 (\1\:Y VSS) capacitor c=1.46403e-16
C20 (\3\:Y VSS) capacitor c=9.78022e-17
C21 (\2\:A VSS) capacitor c=4.45709e-16
C22 (\3\:C VSS) capacitor c=1.03407e-16
C23 (\7\:C VSS) capacitor c=5.04872e-17
C24 (\3\:VDD VSS) capacitor c=9.64684e-18
C25 (\5\:VDD VSS) capacitor c=2.52708e-17
Rk2 (B \2\:B) resistor r=0.09157 c=0
Rk18 (\3\:VDD VDD) resistor r=0.1022 c=0
Rk17 (\2\:VDD \3\:VDD) resistor r=0.3681 c=0
Rk19 (\3\:VDD \5\:VDD) resistor r=0.2477 c=0
Rk20 (\5\:VDD \7\:VDD) resistor r=0.5432 c=0
Rk1 (\7\:C C) resistor r=0.1869 c=0
Rk5 (\2\:A A) resistor r=0.02692 c=0
Rk8 (\1\:Y Y) resistor r=0.2446 c=0
Rk9 (Y \8\:Y) resistor r=0.8071 c=0
Rl11 (\2\:B \4\:B) resistor r=75.6918 c=0
Rl4 (\2\:B \1\:B) resistor r=82.4874 c=0
Rl6 (\2\:C \1\:C) resistor r=53.0601 c=0
Rl9 (\2\:C \5\:C) resistor r=24.2328 c=0
Rl7 (\3\:C \2\:C) resistor r=60.4528 c=0
Rl14 (\2\:A \7\:A) resistor r=95.3867 c=0
Rl1 (\2\:A \1\:A) resistor r=176.203 c=0
Rz2 (\1\:Y \3\:Y) resistor r=75 c=0
Ry3 (\1\:VDD \2\:VDD) resistor r=20.6667 c=0
Ry4 (\6\:VDD \7\:VDD) resistor r=62 c=0
Ry1 (\8\:Y \7\:Y) resistor r=62 c=0
Rx1 (\7\:C \2\:C) resistor r=45 c=0
mn0 (\1\:Y \2\:A VSS VSS) g45n1lvt w=(2.6e-07) l=4.5e-08 nf=1 \
        as=5.11e-14 ad=4.16e-14 ps=1.01e-06 pd=8.4e-07 nrd=1.16667 \
        nrs=1.16667 sa=1.4e-07 sb=1.315e-06 sd=160n sca=8.65991 \
        scb=0.00681295 scc=0.000165238 m=(2)
mn1 (\1\:Y \2\:B VSS VSS) g45n1lvt w=(2.6e-07) l=4.5e-08 nf=1 \
        as=7.88e-14 ad=4.16e-14 ps=1.32e-06 pd=8.4e-07 nrd=1.16667 \
        nrs=1.16667 sa=3.45e-07 sb=1.11e-06 sd=160n sca=8.65991 \
        scb=0.00681295 scc=0.000165238 m=(2)
mn2 (\3\:Y \3\:C VSS VSS) g45n1lvt w=(2.6e-07) l=4.5e-08 nf=1 \
        as=7.88e-14 ad=4.16e-14 ps=1.32e-06 pd=8.4e-07 nrd=1.16667 \
        nrs=1.16667 sa=6.1e-07 sb=8.45e-07 sd=160n sca=8.65991 \
        scb=0.00681295 scc=0.000165238 m=(2)
ends NOR3X2
// End of subcircuit definition.
