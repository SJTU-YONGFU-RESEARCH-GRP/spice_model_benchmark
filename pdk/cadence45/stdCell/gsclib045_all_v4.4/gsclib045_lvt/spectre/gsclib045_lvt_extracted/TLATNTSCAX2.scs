// Generated for: spectre (May  1 09:19:19 2013 )
// Library name: gsclib045_lvt
// Cell name: TLATNTSCAX2
// View name: extracted

simulator lang=spectre

subckt TLATNTSCAX2 CK E ECK SE VDD VSS
mp1 (\4\:Eb \1\:E net246 VDD) g45p1lvt w=(2.15e-07) l=4.5e-08 nf=1 \
        as=1.29e-14 ad=3.01e-14 ps=5.5e-07 pd=7.1e-07 nrd=1.16667 \
        nrs=1.16667 sa=1.4e-07 sb=5.65e-07 sd=160n sca=16.5928 \
        scb=0.0167268 scc=0.000352369 m=(1)
mp0 (net246 \1\:SE \15\:VDD VDD) g45p1lvt w=(2.15e-07) l=4.5e-08 nf=1 \
        as=3.655e-14 ad=1.29e-14 ps=7.7e-07 pd=5.5e-07 nrd=1.16667 \
        nrs=1.16667 sa=2.45e-07 sb=4.6e-07 sd=160n sca=14.2912 \
        scb=0.0126949 scc=0.000241023 m=(1)
mp2 (\15\:CKb \1\:CK \15\:VDD VDD) g45p1lvt w=(2.15e-07) l=4.5e-08 nf=1 \
        as=3.655e-14 ad=5.268e-14 ps=7.7e-07 pd=9.2e-07 nrd=1.16667 \
        nrs=1.16667 sa=4.6e-07 sb=2.45e-07 sd=160n sca=12.3184 \
        scb=0.0100356 scc=0.000221045 m=(1)
mp5 (\5\:n5 \3\:CKbb \6\:Eb VDD) g45p1lvt w=(2.15e-07) l=4.5e-08 nf=1 \
        as=4.73e-14 ad=3.44e-14 ps=8.7e-07 pd=7.5e-07 nrd=1.16667 \
        nrs=1.16667 sa=2.2e-07 sb=8.6e-07 sd=160n sca=10.1832 \
        scb=0.00742094 scc=7.76436e-05 m=(1)
mp16 (\5\:n5 \3\:CKb net234 VDD) g45p1lvt w=(2.15e-07) l=4.5e-08 nf=1 \
        as=1.29e-14 ad=3.44e-14 ps=5.5e-07 pd=7.5e-07 nrd=1.16667 \
        nrs=1.16667 sa=4.25e-07 sb=6.55e-07 sd=160n sca=10.1832 \
        scb=0.00742094 scc=7.76436e-05 m=(1)
mp15 (net234 \3\:Eint \11\:VDD VDD) g45p1lvt w=(2.15e-07) l=4.5e-08 nf=1 \
        as=9.947e-14 ad=1.29e-14 ps=1.51e-06 pd=5.5e-07 nrd=1.16667 \
        nrs=1.16667 sa=5.3e-07 sb=5.5e-07 sd=160n sca=10.1832 \
        scb=0.00742094 scc=7.76436e-05 m=(1)
mp3 (\11\:CKbb \5\:CKb \11\:VDD VDD) g45p1lvt w=(2.15e-07) l=4.5e-08 \
        nf=1 as=9.947e-14 ad=3.01e-14 ps=1.51e-06 pd=7.1e-07 nrd=1.16667 \
        nrs=1.16667 sa=9.4e-07 sb=1.4e-07 sd=160n sca=10.1832 \
        scb=0.00742094 scc=7.76436e-05 m=(1)
mp10 (\10\:Eint n5 \8\:VDD VDD) g45p1lvt w=(2.15e-07) l=4.5e-08 nf=1 \
        as=4.085e-14 ad=3.01e-14 ps=8.1e-07 pd=7.1e-07 nrd=1.16667 \
        nrs=1.16667 sa=1.4e-07 sb=1.025e-06 sd=160n sca=37.431 \
        scb=0.0268495 scc=0.00487383 m=(1)
mp20 (\11\:ECKb \5\:Eint \8\:VDD VDD) g45p1lvt w=(2.15e-07) l=4.5e-08 \
        nf=1 as=4.085e-14 ad=3.44e-14 ps=8.1e-07 pd=7.5e-07 nrd=1.16667 \
        nrs=1.16667 sa=3.75e-07 sb=7.9e-07 sd=160n sca=37.431 \
        scb=0.0268495 scc=0.00487383 m=(1)
mp21 (\11\:ECKb \4\:CKbb \1\:VDD VDD) g45p1lvt w=(2.15e-07) l=4.5e-08 \
        nf=1 as=5.943e-14 ad=3.44e-14 ps=1.17e-06 pd=7.5e-07 nrd=1.16667 \
        nrs=1.16667 sa=5.8e-07 sb=5.85e-07 sd=160n sca=37.6758 \
        scb=0.0269122 scc=0.00487384 m=(1)
C1 (CK VSS) capacitor c=1.33118e-16
C2 (VDD VSS) capacitor c=2.55756e-16
C3 (E VSS) capacitor c=3.77849e-17
C4 (ECK VSS) capacitor c=4.55001e-17
C5 (Eb VSS) capacitor c=8.65009e-17
C6 (CKb VSS) capacitor c=2.57983e-17
C7 (n5 VSS) capacitor c=3.08616e-17
C8 (net263 VSS) capacitor c=1.44726e-18
C9 (CKbb VSS) capacitor c=3.39797e-17
C10 (Eint VSS) capacitor c=5.16181e-17
C11 (ECKb VSS) capacitor c=1.2707e-16
C12 (net234 VSS) capacitor c=2.53537e-18
C13 (\4\:CKbb VSS) capacitor c=5.61466e-17
C14 (\5\:Eint VSS) capacitor c=3.55618e-17
C15 (\5\:CKb VSS) capacitor c=5.91367e-17
C16 (\3\:Eint VSS) capacitor c=7.35679e-17
C17 (\3\:CKb VSS) capacitor c=7.06014e-17
C18 (\3\:CKbb VSS) capacitor c=6.98474e-17
C19 (\1\:CK VSS) capacitor c=5.02798e-17
C20 (\1\:SE VSS) capacitor c=8.49686e-17
C21 (\1\:E VSS) capacitor c=9.10573e-17
C22 (\5\:CKbb VSS) capacitor c=4.93011e-17
C23 (\7\:Eint VSS) capacitor c=5.01917e-17
C24 (\3\:n5 VSS) capacitor c=4.38882e-17
C25 (\6\:CKb VSS) capacitor c=3.75649e-17
C26 (\3\:CK VSS) capacitor c=3.838e-17
C27 (\3\:SE VSS) capacitor c=4.19884e-17
C28 (\4\:E VSS) capacitor c=3.0915e-17
C29 (\5\:ECKb VSS) capacitor c=1.68388e-17
C30 (\6\:CKbb VSS) capacitor c=2.69221e-17
C31 (\6\:Eint VSS) capacitor c=3.23439e-17
C32 (\2\:n5 VSS) capacitor c=2.23497e-17
C33 (\7\:CKb VSS) capacitor c=2.15961e-17
C34 (\4\:Eint VSS) capacitor c=2.75093e-17
C35 (\2\:CKbb VSS) capacitor c=7.79215e-17
C36 (\4\:CKb VSS) capacitor c=5.54741e-17
C37 (\2\:CKb VSS) capacitor c=2.00052e-17
C38 (\2\:CK VSS) capacitor c=4.8353e-17
C39 (\2\:SE VSS) capacitor c=8.34317e-17
C40 (\3\:E VSS) capacitor c=1.51621e-17
C41 (\1\:VDD VSS) capacitor c=9.87648e-17
C42 (\1\:ECK VSS) capacitor c=1.04494e-16
C43 (\11\:ECKb VSS) capacitor c=3.5039e-17
C44 (\8\:VDD VSS) capacitor c=5.21986e-17
C45 (\10\:Eint VSS) capacitor c=6.17936e-17
C46 (\11\:CKbb VSS) capacitor c=1.2105e-16
C47 (\11\:VDD VSS) capacitor c=3.49311e-17
C48 (\5\:n5 VSS) capacitor c=2.1945e-16
C49 (\6\:Eb VSS) capacitor c=1.45137e-16
C50 (\15\:CKb VSS) capacitor c=1.13894e-16
C51 (\15\:VDD VSS) capacitor c=4.46143e-17
C52 (\4\:Eb VSS) capacitor c=9.7267e-18
C53 (\3\:VDD VSS) capacitor c=5.54496e-17
C54 (\13\:ECKb VSS) capacitor c=2.98466e-17
C55 (\12\:Eint VSS) capacitor c=3.05548e-17
C56 (\8\:CKbb VSS) capacitor c=1.62019e-16
C57 (\7\:n5 VSS) capacitor c=1.09244e-16
C58 (\8\:Eb VSS) capacitor c=1.10551e-16
C59 (\12\:CKb VSS) capacitor c=2.5205e-17
C60 (\2\:E VSS) capacitor c=6.06119e-17
C61 (\2\:Eint VSS) capacitor c=5.81674e-17
C62 (\5\:E VSS) capacitor c=3.01848e-17
C63 (\4\:SE VSS) capacitor c=1.36709e-16
C64 (\3\:Eb VSS) capacitor c=1.47932e-16
C65 (\8\:CKb VSS) capacitor c=1.63576e-16
C66 (\9\:CKb VSS) capacitor c=1.2179e-16
C67 (\10\:CKb VSS) capacitor c=3.48657e-17
C68 (\11\:CKb VSS) capacitor c=8.70417e-17
C69 (\14\:CKb VSS) capacitor c=9.18975e-17
C70 (\4\:n5 VSS) capacitor c=1.29382e-16
C71 (\8\:Eint VSS) capacitor c=3.70125e-17
C72 (\9\:Eint VSS) capacitor c=3.59012e-17
C73 (\14\:Eint VSS) capacitor c=9.20531e-17
C74 (\7\:CKbb VSS) capacitor c=7.33757e-17
C75 (\10\:CKbb VSS) capacitor c=1.59978e-16
C76 (\9\:ECKb VSS) capacitor c=1.90599e-17
C77 (\10\:ECKb VSS) capacitor c=2.38863e-17
C78 (\7\:VDD VSS) capacitor c=5.04925e-17
C79 (\10\:VDD VSS) capacitor c=4.30776e-17
C80 (\14\:VDD VSS) capacitor c=2.23162e-17
Rk3 (CK \4\:CK) resistor r=0.003004 c=0
Rk41 (\1\:VDD \7\:VDD) resistor r=0.231 c=0
Rk42 (\7\:VDD \9\:VDD) resistor r=0.4301 c=0
Rk43 (\7\:VDD \10\:VDD) resistor r=0.4862 c=0
Rk44 (\10\:VDD \12\:VDD) resistor r=0.1028 c=0
Rk45 (\10\:VDD \13\:VDD) resistor r=0.2356 c=0
Rk48 (\14\:VDD VDD) resistor r=0.2253 c=0
Rk46 (\13\:VDD \14\:VDD) resistor r=0.3259 c=0
Rk47 (\14\:VDD \16\:VDD) resistor r=0.2841 c=0
Rk2 (\4\:SE SE) resistor r=0.003004 c=0
Rk1 (E \5\:E) resistor r=0.06309 c=0
Rk29 (\1\:VSS \5\:VSS) resistor r=0.2008 c=0
Rk30 (\5\:VSS \6\:VSS) resistor r=0.4712 c=0
Rk31 (\6\:VSS \7\:VSS) resistor r=0.2807 c=0
Rk33 (\8\:VSS VSS) resistor r=0.2259 c=0
Rk32 (\7\:VSS \8\:VSS) resistor r=0.3259 c=0
Rk35 (\5\:VSS \12\:VSS) resistor r=0.07405 c=0
Rk36 (\6\:VSS \14\:VSS) resistor r=0.4311 c=0
Rk37 (\8\:VSS \16\:VSS) resistor r=0.1821 c=0
Rk38 (VSS \18\:VSS) resistor r=0.1797 c=0
Rk26 (\2\:ECK ECK) resistor r=0.374 c=0
Rk27 (ECK \4\:ECK) resistor r=0.002898 c=0
Rk4 (\2\:Eb \3\:Eb) resistor r=0.5762 c=0
Rk5 (\3\:Eb \5\:Eb) resistor r=0.135 c=0
Rk6 (\3\:Eb \7\:Eb) resistor r=0.7275 c=0
Rk7 (\7\:Eb \9\:Eb) resistor r=0.6683 c=0
Rk8 (\8\:CKb \9\:CKb) resistor r=1.1313 c=0
Rk9 (\9\:CKb \10\:CKb) resistor r=0.1776 c=0
Rk10 (\10\:CKb \11\:CKb) resistor r=0.2195 c=0
Rk11 (\11\:CKb \13\:CKb) resistor r=0.05533 c=0
Rk12 (\9\:CKb \14\:CKb) resistor r=0.5911 c=0
Rk13 (\11\:CKb \16\:CKb) resistor r=0.6736 c=0
Rk14 (\4\:n5 \6\:n5) resistor r=1.0569 c=0
Rk15 (\6\:n5 \8\:n5) resistor r=0.6514 c=0
Rk20 (\7\:CKbb \9\:CKbb) resistor r=0.6167 c=0
Rk21 (\9\:CKbb \10\:CKbb) resistor r=0.712 c=0
Rk22 (\10\:CKbb \12\:CKbb) resistor r=0.6091 c=0
Rk16 (\8\:Eint \9\:Eint) resistor r=0.2087 c=0
Rk17 (\9\:Eint \11\:Eint) resistor r=0.2236 c=0
Rk18 (\9\:Eint \13\:Eint) resistor r=0.135 c=0
Rk19 (\11\:Eint \14\:Eint) resistor r=0.4748 c=0
Rk23 (\9\:ECKb \10\:ECKb) resistor r=0.05317 c=0
Rk24 (\10\:ECKb \12\:ECKb) resistor r=0.1335 c=0
Rk25 (\10\:ECKb \14\:ECKb) resistor r=0.1115 c=0
Rl6 (\1\:CK \2\:CK) resistor r=158.384 c=0
Rl7 (\2\:CK \3\:CK) resistor r=100.692 c=0
Rl4 (\1\:SE \2\:SE) resistor r=158.79 c=0
Rl5 (\2\:SE \3\:SE) resistor r=93.4057 c=0
Rl1 (\1\:E \2\:E) resistor r=236.048 c=0
Rl3 (\2\:E \4\:E) resistor r=53.3081 c=0
Rl2 (\2\:E \3\:E) resistor r=13.5863 c=0
Rl15 (\5\:CKb \6\:CKb) resistor r=228.846 c=0
Rl16 (\6\:CKb \7\:CKb) resistor r=29.5379 c=0
Rl9 (\3\:CKb \4\:CKb) resistor r=62.6944 c=0
Rl8 (CKb \2\:CKb) resistor r=79.5379 c=0
Rl18 (n5 \3\:n5) resistor r=98.0769 c=0
Rl17 (n5 \2\:n5) resistor r=48.7687 c=0
Rl21 (\4\:CKbb \5\:CKbb) resistor r=113.027 c=0
Rl22 (\5\:CKbb \6\:CKbb) resistor r=29.5379 c=0
Rl11 (\2\:CKbb \3\:CKbb) resistor r=228.4 c=0
Rl10 (CKbb \2\:CKbb) resistor r=76.1559 c=0
Rl19 (\5\:Eint \6\:Eint) resistor r=42.9995 c=0
Rl20 (\6\:Eint \7\:Eint) resistor r=29.5379 c=0
Rl13 (\2\:Eint \3\:Eint) resistor r=119.539 c=0
Rl12 (Eint \2\:Eint) resistor r=137.202 c=0
Rl14 (\2\:Eint \4\:Eint) resistor r=8.149 c=0
Rl26 (ECKb \5\:ECKb) resistor r=8.6997 c=0
Rz15 (\1\:VDD \3\:VDD) resistor r=10.7143 c=0
Rz16 (\13\:VDD \3\:VDD) resistor r=6.25 c=0
Rz11 (\12\:VSS \11\:VSS) resistor r=75 c=0
Rz12 (\14\:VSS \13\:VSS) resistor r=75 c=0
Rz13 (\16\:VSS \15\:VSS) resistor r=75 c=0
Rz14 (\18\:VSS \17\:VSS) resistor r=75 c=0
Rz8 (\4\:ECK \3\:ECK) resistor r=75 c=0
Rz1 (Eb \2\:Eb) resistor r=75 c=0
Rz2 (\8\:Eb \9\:Eb) resistor r=75 c=0
Rz3 (\12\:CKb \13\:CKb) resistor r=75 c=0
Rz4 (\7\:n5 \8\:n5) resistor r=75 c=0
Rz6 (\8\:CKbb \9\:CKbb) resistor r=75 c=0
Rz5 (\12\:Eint \13\:Eint) resistor r=75 c=0
Rz7 (\14\:ECKb \13\:ECKb) resistor r=75 c=0
Ry13 (\9\:VDD \8\:VDD) resistor r=62 c=0
Ry14 (\12\:VDD \11\:VDD) resistor r=62 c=0
Ry15 (\16\:VDD \15\:VDD) resistor r=62 c=0
Ry9 (\1\:VSS \3\:VSS) resistor r=8.8571 c=0
Ry10 (\7\:VSS \3\:VSS) resistor r=5.1667 c=0
Ry8 (\2\:ECK \1\:ECK) resistor r=20.6667 c=0
Ry1 (\4\:Eb \5\:Eb) resistor r=62 c=0
Ry2 (\6\:Eb \7\:Eb) resistor r=62 c=0
Ry3 (\15\:CKb \16\:CKb) resistor r=62 c=0
Ry4 (\5\:n5 \6\:n5) resistor r=62 c=0
Ry6 (\11\:CKbb \12\:CKbb) resistor r=62 c=0
Ry5 (\10\:Eint \11\:Eint) resistor r=62 c=0
Ry7 (\12\:ECKb \11\:ECKb) resistor r=62 c=0
Rx3 (\2\:CK \4\:CK) resistor r=45 c=0
Rx2 (\2\:SE \4\:SE) resistor r=45 c=0
Rx1 (\3\:E \5\:E) resistor r=45 c=0
Rx4 (\7\:CKb \8\:CKb) resistor r=45 c=0
Rx5 (\2\:CKb \10\:CKb) resistor r=45 c=0
Rx6 (\4\:CKb \14\:CKb) resistor r=45 c=0
Rx7 (\2\:n5 \4\:n5) resistor r=45 c=0
Rx10 (\6\:CKbb \7\:CKbb) resistor r=45 c=0
Rx11 (\2\:CKbb \10\:CKbb) resistor r=45 c=0
Rx8 (\6\:Eint \8\:Eint) resistor r=45 c=0
Rx9 (\4\:Eint \14\:Eint) resistor r=45 c=0
Rx12 (\9\:ECKb \5\:ECKb) resistor r=45 c=0
mn1 (Eb \4\:E \17\:VSS VSS) g45n1lvt w=(1.45e-07) l=4.5e-08 nf=1 \
        as=2.03e-14 ad=2.537e-14 ps=5.7e-07 pd=6.4e-07 nrd=1.16667 \
        nrs=1.16667 sa=1.4e-07 sb=5.75e-07 sd=160n sca=6.59604 \
        scb=0.00318587 scc=2.16275e-05 m=(1)
mn0 (Eb \3\:SE \15\:VSS VSS) g45n1lvt w=(1.45e-07) l=4.5e-08 nf=1 \
        as=2.465e-14 ad=2.537e-14 ps=6.3e-07 pd=6.4e-07 nrd=1.16667 \
        nrs=1.16667 sa=3.6e-07 sb=3.55e-07 sd=160n sca=6.59604 \
        scb=0.00318587 scc=2.16275e-05 m=(1)
mn2 (\12\:CKb \3\:CK \15\:VSS VSS) g45n1lvt w=(1.45e-07) l=4.5e-08 nf=1 \
        as=2.465e-14 ad=2.03e-14 ps=6.3e-07 pd=5.7e-07 nrd=1.16667 \
        nrs=1.16667 sa=5.75e-07 sb=1.4e-07 sd=160n sca=6.59604 \
        scb=0.00318587 scc=2.16275e-05 m=(1)
mn5 (\8\:Eb CKb \7\:n5 VSS) g45n1lvt w=(1.45e-07) l=4.5e-08 nf=1 \
        as=5.365e-14 ad=2.03e-14 ps=1.03e-06 pd=5.7e-07 nrd=1.16667 \
        nrs=1.16667 sa=1.4e-07 sb=1.085e-06 sd=160n sca=20.6444 \
        scb=0.0212501 scc=0.00213091 m=(1)
mn16 (\7\:n5 CKbb net263 VSS) g45n1lvt w=(1.45e-07) l=4.5e-08 nf=1 \
        as=1.957e-14 ad=5.365e-14 ps=5.6e-07 pd=1.03e-06 nrd=1.16667 \
        nrs=1.16667 sa=5.55e-07 sb=6.7e-07 sd=160n sca=20.6444 \
        scb=0.0212501 scc=0.00213091 m=(1)
mn15 (net263 Eint \13\:VSS VSS) g45n1lvt w=(1.45e-07) l=4.5e-08 nf=1 \
        as=2.972e-14 ad=1.957e-14 ps=7e-07 pd=5.6e-07 nrd=1.16667 \
        nrs=1.16667 sa=7.35e-07 sb=4.9e-07 sd=160n sca=20.6444 \
        scb=0.0212501 scc=0.00213091 m=(1)
mn3 (\8\:CKbb \6\:CKb \13\:VSS VSS) g45n1lvt w=(1.45e-07) l=4.5e-08 nf=1 \
        as=2.972e-14 ad=3.48e-14 ps=7e-07 pd=7.7e-07 nrd=1.16667 \
        nrs=1.16667 sa=9.85e-07 sb=2.4e-07 sd=160n sca=20.6444 \
        scb=0.0212501 scc=0.00213091 m=(1)
mn10 (\12\:Eint \3\:n5 \11\:VSS VSS) g45n1lvt w=(1.45e-07) l=4.5e-08 \
        nf=1 as=6.01e-14 ad=2.392e-14 ps=1.72e-06 pd=6.2e-07 nrd=1.16667 \
        nrs=1.16667 sa=1.65e-07 sb=4.95e-07 sd=160n sca=23.279 \
        scb=0.0230742 scc=0.00267719 m=(1)
mn20 (net271 \7\:Eint \11\:VSS VSS) g45n1lvt w=(1.45e-07) l=4.5e-08 nf=1 \
        as=6.01e-14 ad=1.087e-14 ps=1.72e-06 pd=4.4e-07 nrd=1.16667 \
        nrs=1.16667 sa=4e-07 sb=2.6e-07 sd=160n sca=23.279 scb=0.0230742 \
        scc=0.00267719 m=(1)
mn21 (\13\:ECKb \5\:CKbb net271 VSS) g45n1lvt w=(1.45e-07) l=4.5e-08 nf=1 \
        as=1.087e-14 ad=2.03e-14 ps=4.4e-07 pd=5.7e-07 nrd=1.16667 \
        nrs=1.16667 sa=5.2e-07 sb=1.4e-07 sd=160n sca=23.279 scb=0.0230742 \
        scc=0.00267719 m=(1)
mn22_1__rcx (\3\:ECK ECKb \1\:VSS VSS) g45n1lvt w=(2.6e-07) l=4.5e-08 \
        nf=1 as=4.34e-14 ad=4.16e-14 ps=1.15e-06 pd=8.4e-07 nrd=1.16667 \
        nrs=1.16667 sa=1e-07 sb=3.45e-07 sd=160n sca=17.5885 scb=0.0172826 \
        scc=0.00162584 m=(2)
mp22 (\1\:ECK ECKb \1\:VDD VDD) g45p1lvt w=(3.9e-07) l=4.5e-08 nf=1 \
        as=5.701e-14 ad=6.24e-14 ps=1.115e-06 pd=1.1e-06 nrd=1.16667 \
        nrs=1.16667 sa=4.96923e-07 sb=3.45e-07 sd=160n sca=31.7575 \
        scb=0.0209755 scc=0.00336197 m=(2)
ends TLATNTSCAX2
// End of subcircuit definition.
