// Generated for: spectre (May  1 09:18:45 2013 )
// Library name: gsclib045_lvt
// Cell name: OR2XL
// View name: extracted

simulator lang=spectre

subckt OR2XL A B VDD VSS Y
mp1 (\7\:n0 \1\:B n1 VDD) g45p1lvt w=(2.15e-07) l=4.5e-08 nf=1 \
        as=1.29e-14 ad=3.01e-14 ps=5.5e-07 pd=7.1e-07 nrd=1.16667 \
        nrs=1.16667 sa=1.4e-07 sb=4.5e-07 sd=160n sca=33.4025 \
        scb=0.0357193 scc=0.00295004 m=(1)
mp0 (n1 \1\:A \1\:VDD VDD) g45p1lvt w=(2.15e-07) l=4.5e-08 nf=1 \
        as=3.44e-14 ad=1.29e-14 ps=7.5e-07 pd=5.5e-07 nrd=1.16667 \
        nrs=1.16667 sa=2.45e-07 sb=3.45e-07 sd=160n sca=30.554 \
        scb=0.0308989 scc=0.00253599 m=(1)
mp2 (\3\:Y n0 \1\:VDD VDD) g45p1lvt w=(2.15e-07) l=4.5e-08 nf=1 \
        as=3.44e-14 ad=3.01e-14 ps=7.5e-07 pd=7.1e-07 nrd=1.16667 \
        nrs=1.16667 sa=4.5e-07 sb=1.4e-07 sd=160n sca=35.6113 \
        scb=0.0387304 scc=0.00336179 m=(1)
C1 (A VSS) capacitor c=6.32582e-17
C2 (Y VSS) capacitor c=3.92013e-17
C3 (B VSS) capacitor c=2.98766e-17
C4 (VDD VSS) capacitor c=5.35883e-17
C5 (n0 VSS) capacitor c=4.14599e-17
C6 (n1 VSS) capacitor c=1.01303e-18
C7 (\1\:A VSS) capacitor c=5.34902e-17
C8 (\1\:B VSS) capacitor c=6.45544e-17
C9 (\3\:n0 VSS) capacitor c=3.23313e-17
C10 (\3\:A VSS) capacitor c=5.03122e-17
C11 (\4\:B VSS) capacitor c=2.86088e-17
C12 (\2\:n0 VSS) capacitor c=3.45433e-17
C13 (\2\:A VSS) capacitor c=5.5723e-17
C14 (\3\:B VSS) capacitor c=1.20072e-17
C15 (\3\:Y VSS) capacitor c=2.75928e-17
C16 (\1\:VDD VSS) capacitor c=3.83653e-17
C17 (\7\:n0 VSS) capacitor c=4.85782e-17
C18 (\1\:Y VSS) capacitor c=3.60123e-17
C19 (\4\:n0 VSS) capacitor c=1.3289e-17
C20 (\2\:B VSS) capacitor c=3.38542e-17
C21 (\5\:B VSS) capacitor c=3.43006e-17
C22 (\4\:A VSS) capacitor c=3.60364e-17
C23 (\6\:n0 VSS) capacitor c=6.50724e-17
C24 (\9\:n0 VSS) capacitor c=5.67076e-17
C25 (\4\:VDD VSS) capacitor c=1.28254e-17
Rk2 (\4\:A A) resistor r=0.05173 c=0
Rk6 (\2\:Y Y) resistor r=0.2341 c=0
Rk7 (Y \4\:Y) resistor r=0.1131 c=0
Rk9 (\4\:VSS VSS) resistor r=0.1509 c=0
Rk8 (\2\:VSS \4\:VSS) resistor r=0.1159 c=0
Rk10 (VSS \6\:VSS) resistor r=0.07913 c=0
Rk1 (B \5\:B) resistor r=0.09876 c=0
Rk12 (\4\:VDD VDD) resistor r=0.1501 c=0
Rk11 (\2\:VDD \4\:VDD) resistor r=0.4078 c=0
Rk3 (\5\:n0 \6\:n0) resistor r=0.1202 c=0
Rk4 (\6\:n0 \8\:n0) resistor r=0.4183 c=0
Rk5 (\6\:n0 \9\:n0) resistor r=0.1765 c=0
Rl4 (\1\:A \2\:A) resistor r=31.461 c=0
Rl5 (\2\:A \3\:A) resistor r=100.692 c=0
Rl1 (\1\:B \2\:B) resistor r=125.308 c=0
Rl3 (\2\:B \4\:B) resistor r=37.2017 c=0
Rl2 (\2\:B \3\:B) resistor r=5.1011 c=0
Rl6 (n0 \2\:n0) resistor r=100.692 c=0
Rl7 (\2\:n0 \3\:n0) resistor r=31.461 c=0
Rz2 (\1\:Y \2\:Y) resistor r=75 c=0
Rz3 (\1\:VSS \2\:VSS) resistor r=75 c=0
Rz4 (\5\:VSS \6\:VSS) resistor r=75 c=0
Rz1 (\4\:n0 \5\:n0) resistor r=75 c=0
Ry2 (\3\:Y \4\:Y) resistor r=62 c=0
Ry4 (\1\:VDD \2\:VDD) resistor r=62 c=0
Ry1 (\7\:n0 \8\:n0) resistor r=62 c=0
Rx2 (\2\:A \4\:A) resistor r=45 c=0
Rx1 (\3\:B \5\:B) resistor r=45 c=0
Rx3 (\2\:n0 \9\:n0) resistor r=45 c=0
mn1 (\4\:n0 \4\:B \5\:VSS VSS) g45n1lvt w=(1.45e-07) l=4.5e-08 nf=1 \
        as=4.38e-14 ad=2.32e-14 ps=1.32e-06 pd=6.1e-07 nrd=1.16667 \
        nrs=1.16667 sa=1e-07 sb=5.6e-07 sd=160n sca=11.9911 scb=0.0120555 \
        scc=0.000498628 m=(1)
mn0 (\4\:n0 \3\:A \1\:VSS VSS) g45n1lvt w=(1.45e-07) l=4.5e-08 nf=1 \
        as=5.09e-14 ad=2.32e-14 ps=1.41e-06 pd=6.1e-07 nrd=1.16667 \
        nrs=1.16667 sa=3.05e-07 sb=3.55e-07 sd=160n sca=11.9911 \
        scb=0.0120555 scc=0.000498628 m=(1)
mn2 (\1\:Y \3\:n0 \1\:VSS VSS) g45n1lvt w=(1.45e-07) l=4.5e-08 nf=1 \
        as=5.09e-14 ad=2.175e-14 ps=1.41e-06 pd=5.9e-07 nrd=1.16667 \
        nrs=1.16667 sa=5.1e-07 sb=1.5e-07 sd=160n sca=11.9911 \
        scb=0.0120555 scc=0.000498628 m=(1)
ends OR2XL
// End of subcircuit definition.
