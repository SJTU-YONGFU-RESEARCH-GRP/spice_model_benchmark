// Generated for: spectre (May  1 09:13:52 2013 )
// Library name: gsclib045_lvt
// Cell name: DFFSHQX4
// View name: extracted

simulator lang=spectre

subckt DFFSHQX4 CK D Q SN VDD VSS
mp55_1__rcx (Q qbint VDD VDD) g45p1lvt w=(3.9e-07) l=4.5e-08 nf=1 \
        as=5.925e-14 ad=6.24e-14 ps=1.09e-06 pd=1.1e-06 nrd=1.16667 \
        nrs=1.16667 sa=1.4e-07 sb=1.45423e-06 sd=160n sca=22.4235 \
        scb=0.0255651 scc=0.00113526 m=(4)
C1 (SN VSS) capacitor c=1.82218e-16
C2 (Q VSS) capacitor c=2.69567e-16
C3 (VDD VSS) capacitor c=6.51843e-16
C4 (CK VSS) capacitor c=3.97026e-17
C5 (D VSS) capacitor c=8.72754e-17
C6 (qbint VSS) capacitor c=2.70345e-16
C7 (n35 VSS) capacitor c=2.18414e-16
C8 (n40 VSS) capacitor c=5.57845e-18
C9 (CKb VSS) capacitor c=3.13224e-17
C10 (mout VSS) capacitor c=5.05697e-17
C11 (CKbb VSS) capacitor c=4.08565e-17
C12 (n20 VSS) capacitor c=4.85595e-17
C13 (n30 VSS) capacitor c=4.75291e-18
C14 (n21 VSS) capacitor c=1.2771e-18
C15 (n41 VSS) capacitor c=8.21586e-17
C16 (n31 VSS) capacitor c=1.65053e-18
C17 (n22 VSS) capacitor c=3.18329e-18
C18 (\1\:CK VSS) capacitor c=2.44566e-17
C19 (\9\:CKb VSS) capacitor c=4.72683e-17
C20 (\1\:D VSS) capacitor c=5.65405e-17
C21 (\4\:CKbb VSS) capacitor c=3.72814e-17
C22 (\6\:CKb VSS) capacitor c=8.27753e-17
C23 (\4\:mout VSS) capacitor c=8.78553e-17
C24 (\4\:SN VSS) capacitor c=6.34609e-17
C25 (\4\:CKb VSS) capacitor c=4.18074e-17
C26 (\14\:qbint VSS) capacitor c=6.06824e-17
C27 (\1\:SN VSS) capacitor c=4.93381e-17
C28 (\3\:CK VSS) capacitor c=1.76411e-17
C29 (\11\:CKb VSS) capacitor c=2.53752e-17
C30 (\3\:D VSS) capacitor c=6.29423e-17
C31 (\7\:CKb VSS) capacitor c=7.43199e-17
C32 (\6\:CKbb VSS) capacitor c=7.56819e-17
C33 (\3\:n20 VSS) capacitor c=6.27775e-17
C34 (\6\:SN VSS) capacitor c=4.64925e-17
C35 (\2\:CKbb VSS) capacitor c=5.13159e-17
C36 (\16\:qbint VSS) capacitor c=2.64499e-17
C37 (\3\:SN VSS) capacitor c=4.37341e-17
C38 (\2\:CK VSS) capacitor c=1.79042e-17
C39 (\10\:CKb VSS) capacitor c=3.83579e-17
C40 (\2\:D VSS) capacitor c=5.73651e-17
C41 (\5\:CKbb VSS) capacitor c=6.0275e-17
C42 (\8\:CKb VSS) capacitor c=4.92415e-17
C43 (\5\:CKb VSS) capacitor c=3.71044e-17
C44 (\3\:mout VSS) capacitor c=2.39291e-17
C45 (\2\:n20 VSS) capacitor c=6.15729e-17
C46 (\5\:SN VSS) capacitor c=4.11569e-17
C47 (\3\:CKb VSS) capacitor c=2.54397e-17
C48 (\3\:CKbb VSS) capacitor c=1.99241e-17
C49 (\2\:CKb VSS) capacitor c=3.62967e-17
C50 (\15\:qbint VSS) capacitor c=4.46043e-17
C51 (\2\:SN VSS) capacitor c=5.37153e-17
C52 (\8\:qbint VSS) capacitor c=2.27696e-17
C53 (\1\:VDD VSS) capacitor c=3.35337e-17
C54 (\12\:CKb VSS) capacitor c=6.42658e-17
C55 (\13\:CKbb VSS) capacitor c=2.29289e-17
C56 (\7\:VDD VSS) capacitor c=4.12888e-17
C57 (\8\:n20 VSS) capacitor c=6.02003e-17
C58 (\9\:VDD VSS) capacitor c=2.38033e-17
C59 (\5\:mout VSS) capacitor c=3.56163e-17
C60 (\12\:VDD VSS) capacitor c=2.10405e-17
C61 (\14\:mout VSS) capacitor c=3.96732e-17
C62 (\8\:n35 VSS) capacitor c=9.36784e-17
C63 (\15\:VDD VSS) capacitor c=3.44289e-17
C64 (\3\:n41 VSS) capacitor c=1.0623e-16
C65 (\22\:qbint VSS) capacitor c=8.3988e-17
C66 (\3\:VDD VSS) capacitor c=6.23613e-17
C67 (\14\:CKb VSS) capacitor c=1.28202e-16
C68 (\11\:CKbb VSS) capacitor c=6.70204e-17
C69 (\4\:n20 VSS) capacitor c=7.85559e-17
C70 (\12\:mout VSS) capacitor c=1.93051e-17
C71 (\9\:mout VSS) capacitor c=7.85819e-17
C72 (\12\:n35 VSS) capacitor c=9.63784e-17
C73 (\20\:qbint VSS) capacitor c=2.60392e-17
C74 (\2\:mout VSS) capacitor c=2.60152e-17
C75 (\17\:qbint VSS) capacitor c=6.68967e-17
C76 (\18\:qbint VSS) capacitor c=5.49204e-17
C77 (\19\:qbint VSS) capacitor c=3.99434e-17
C78 (\10\:n35 VSS) capacitor c=1.49608e-16
C79 (\11\:n35 VSS) capacitor c=1.01195e-16
C80 (\7\:SN VSS) capacitor c=1.58296e-16
C81 (\8\:SN VSS) capacitor c=8.7522e-17
C82 (\7\:mout VSS) capacitor c=3.45324e-17
C83 (\8\:mout VSS) capacitor c=7.15411e-17
C84 (\11\:mout VSS) capacitor c=4.32789e-17
C85 (\16\:mout VSS) capacitor c=5.12972e-17
C86 (\6\:n20 VSS) capacitor c=1.04199e-16
C87 (\7\:n20 VSS) capacitor c=6.13937e-17
C88 (\4\:D VSS) capacitor c=4.3469e-17
C89 (\7\:CKbb VSS) capacitor c=4.12168e-17
C90 (\8\:CKbb VSS) capacitor c=2.0828e-16
C91 (\9\:CKbb VSS) capacitor c=1.95863e-16
C92 (\10\:CKbb VSS) capacitor c=1.0019e-16
C93 (\16\:CKb VSS) capacitor c=8.97159e-17
C94 (\17\:CKb VSS) capacitor c=7.46073e-17
C95 (\18\:CKb VSS) capacitor c=1.89662e-16
C96 (\19\:CKb VSS) capacitor c=2.31207e-16
C97 (\20\:CKb VSS) capacitor c=6.9008e-17
C98 (\21\:CKb VSS) capacitor c=2.74742e-17
C99 (\22\:CKb VSS) capacitor c=2.90794e-17
C100 (\4\:CK VSS) capacitor c=8.586e-17
C101 (\5\:VDD VSS) capacitor c=3.01396e-17
C102 (\11\:VDD VSS) capacitor c=4.00317e-17
C103 (\14\:VDD VSS) capacitor c=3.38997e-17
Rk15 (\7\:SN SN) resistor r=1.175 c=0
Rk16 (SN \8\:SN) resistor r=0.4637 c=0
Rk42 (\2\:VSS \4\:VSS) resistor r=0.5234 c=0
Rk43 (\4\:VSS \5\:VSS) resistor r=0.3836 c=0
Rk44 (\5\:VSS \6\:VSS) resistor r=0.3307 c=0
Rk45 (\6\:VSS \7\:VSS) resistor r=0.08759 c=0
Rk46 (\7\:VSS \8\:VSS) resistor r=0.3008 c=0
Rk52 (\9\:VSS VSS) resistor r=0.0151 c=0
Rk47 (\8\:VSS \9\:VSS) resistor r=0.8223 c=0
Rk53 (\5\:VSS \15\:VSS) resistor r=0.2656 c=0
Rk54 (\6\:VSS \17\:VSS) resistor r=0.267 c=0
Rk55 (\8\:VSS \19\:VSS) resistor r=0.2333 c=0
Rk60 (\2\:VDD \4\:VDD) resistor r=0.5094 c=0
Rk61 (\4\:VDD \5\:VDD) resistor r=0.351 c=0
Rk62 (\5\:VDD \6\:VDD) resistor r=0.4513 c=0
Rk63 (\5\:VDD \8\:VDD) resistor r=0.3137 c=0
Rk64 (\6\:VDD \10\:VDD) resistor r=0.07149 c=0
Rk65 (\6\:VDD \11\:VDD) resistor r=0.2735 c=0
Rk66 (\11\:VDD \13\:VDD) resistor r=0.04332 c=0
Rk69 (\14\:VDD VDD) resistor r=0.2304 c=0
Rk67 (\11\:VDD \14\:VDD) resistor r=0.6082 c=0
Rk68 (\14\:VDD \16\:VDD) resistor r=0.1889 c=0
Rk41 (\4\:CK CK) resistor r=0.0524 c=0
Rk27 (D \4\:D) resistor r=0.07894 c=0
Rk7 (\17\:qbint \18\:qbint) resistor r=0.3857 c=0
Rk8 (\18\:qbint \19\:qbint) resistor r=0.1733 c=0
Rk9 (\18\:qbint \21\:qbint) resistor r=0.1278 c=0
Rk10 (\18\:qbint \23\:qbint) resistor r=0.4097 c=0
Rk12 (\9\:n35 \10\:n35) resistor r=0.3993 c=0
Rk13 (\10\:n35 \11\:n35) resistor r=0.5893 c=0
Rk14 (\10\:n35 \13\:n35) resistor r=0.4609 c=0
Rk33 (\13\:CKb \15\:CKb) resistor r=0.3993 c=0
Rk34 (\15\:CKb \16\:CKb) resistor r=0.6629 c=0
Rk35 (\16\:CKb \17\:CKb) resistor r=0.288 c=0
Rk36 (\17\:CKb \18\:CKb) resistor r=0.1012 c=0
Rk37 (\18\:CKb \19\:CKb) resistor r=1.6357 c=0
Rk38 (\19\:CKb \20\:CKb) resistor r=0.3867 c=0
Rk39 (\16\:CKb \21\:CKb) resistor r=0.05282 c=0
Rk40 (\18\:CKb \22\:CKb) resistor r=0.0961 c=0
Rk17 (\6\:mout \7\:mout) resistor r=0.1781 c=0
Rk18 (\7\:mout \8\:mout) resistor r=0.1875 c=0
Rk19 (\8\:mout \10\:mout) resistor r=0.4517 c=0
Rk20 (\7\:mout \11\:mout) resistor r=0.2354 c=0
Rk21 (\11\:mout \13\:mout) resistor r=0.0734 c=0
Rk22 (\8\:mout \15\:mout) resistor r=0.1392 c=0
Rk23 (\11\:mout \16\:mout) resistor r=0.226 c=0
Rk28 (\7\:CKbb \8\:CKbb) resistor r=0.1304 c=0
Rk29 (\8\:CKbb \9\:CKbb) resistor r=1.6237 c=0
Rk30 (\8\:CKbb \10\:CKbb) resistor r=0.3576 c=0
Rk31 (\10\:CKbb \12\:CKbb) resistor r=0.3589 c=0
Rk32 (\10\:CKbb \14\:CKbb) resistor r=0.02968 c=0
Rk24 (\5\:n20 \6\:n20) resistor r=0.5758 c=0
Rk25 (\6\:n20 \7\:n20) resistor r=0.2468 c=0
Rk26 (\6\:n20 \9\:n20) resistor r=0.2607 c=0
Rk11 (\2\:n41 \4\:n41) resistor r=0.5697 c=0
Rl27 (\4\:SN \5\:SN) resistor r=113.719 c=0
Rl28 (\5\:SN \6\:SN) resistor r=29.5379 c=0
Rl19 (\1\:SN \2\:SN) resistor r=87.2302 c=0
Rl20 (\2\:SN \3\:SN) resistor r=98.7687 c=0
Rl42 (\1\:CK \2\:CK) resistor r=39.6174 c=0
Rl43 (\2\:CK \3\:CK) resistor r=24.2328 c=0
Rl38 (\1\:D \2\:D) resistor r=60.3072 c=0
Rl39 (\2\:D \3\:D) resistor r=67.1242 c=0
Rl21 (\15\:qbint \14\:qbint) resistor r=158.848 c=0
Rl22 (\15\:qbint \16\:qbint) resistor r=24.2328 c=0
Rl7 (qbint \8\:qbint) resistor r=4.8851 c=0
Rl17 (n35 \6\:n35) resistor r=3.3229 c=0
Rl40 (\9\:CKb \10\:CKb) resistor r=131.461 c=0
Rl41 (\10\:CKb \11\:CKb) resistor r=31.461 c=0
Rl35 (\7\:CKb \8\:CKb) resistor r=24.2328 c=0
Rl34 (\5\:CKb \6\:CKb) resistor r=46.8184 c=0
Rl26 (\3\:CKb \4\:CKb) resistor r=30.3481 c=0
Rl23 (CKb \2\:CKb) resistor r=66.8207 c=0
Rl33 (\2\:mout \4\:mout) resistor r=82.3738 c=0
Rl31 (mout \2\:mout) resistor r=96.1317 c=0
Rl32 (\2\:mout \3\:mout) resistor r=37.675 c=0
Rl24 (CKbb \2\:CKbb) resistor r=138.462 c=0
Rl36 (\4\:CKbb \5\:CKbb) resistor r=24.2328 c=0
Rl37 (\5\:CKbb \6\:CKbb) resistor r=151.11 c=0
Rl25 (CKbb \3\:CKbb) resistor r=29.5379 c=0
Rl29 (n20 \2\:n20) resistor r=30.7692 c=0
Rl30 (\2\:n20 \3\:n20) resistor r=131.434 c=0
Rz10 (\2\:VSS \1\:VSS) resistor r=75 c=0
Rz11 (\15\:VSS \14\:VSS) resistor r=75 c=0
Rz12 (\17\:VSS \16\:VSS) resistor r=75 c=0
Rz13 (\19\:VSS \18\:VSS) resistor r=75 c=0
Rz20 (VDD \3\:VDD) resistor r=6.25 c=0
Rz18 (\4\:VDD \3\:VDD) resistor r=18.75 c=0
Rz19 (\6\:VDD \3\:VDD) resistor r=6.25 c=0
Rz3 (\21\:qbint \20\:qbint) resistor r=75 c=0
Rz4 (\13\:n35 \12\:n35) resistor r=75 c=0
Rz9 (\14\:CKb \15\:CKb) resistor r=75 c=0
Rz5 (\9\:mout \10\:mout) resistor r=75 c=0
Rz6 (\12\:mout \13\:mout) resistor r=75 c=0
Rz8 (\11\:CKbb \12\:CKbb) resistor r=75 c=0
Rz7 (\4\:n20 \5\:n20) resistor r=75 c=0
Ry12 (\4\:VSS \3\:VSS) resistor r=15.5 c=0
Ry13 (\7\:VSS \3\:VSS) resistor r=5.1667 c=0
Ry14 (\9\:VSS \3\:VSS) resistor r=5.1667 c=0
Ry15 (\2\:VDD \1\:VDD) resistor r=62 c=0
Ry16 (\8\:VDD \7\:VDD) resistor r=62 c=0
Ry17 (\10\:VDD \9\:VDD) resistor r=62 c=0
Ry18 (\13\:VDD \12\:VDD) resistor r=62 c=0
Ry19 (\16\:VDD \15\:VDD) resistor r=62 c=0
Ry3 (\23\:qbint \22\:qbint) resistor r=31 c=0
Ry6 (\9\:n35 \8\:n35) resistor r=62 c=0
Ry11 (\12\:CKb \13\:CKb) resistor r=62 c=0
Ry7 (\5\:mout \6\:mout) resistor r=62 c=0
Ry8 (\14\:mout \15\:mout) resistor r=62 c=0
Ry10 (\13\:CKbb \14\:CKbb) resistor r=62 c=0
Ry9 (\8\:n20 \9\:n20) resistor r=62 c=0
Ry4 (n41 \2\:n41) resistor r=62 c=0
Ry5 (\3\:n41 \4\:n41) resistor r=31 c=0
Rx4 (\5\:SN \7\:SN) resistor r=45 c=0
Rx5 (\2\:SN \8\:SN) resistor r=45 c=0
Rx16 (\2\:CK \4\:CK) resistor r=45 c=0
Rx8 (\2\:D \4\:D) resistor r=45 c=0
Rx1 (\17\:qbint \15\:qbint) resistor r=45 c=0
Rx2 (\19\:qbint \8\:qbint) resistor r=45 c=0
Rx3 (\11\:n35 \6\:n35) resistor r=45 c=0
Rx11 (\8\:CKb \17\:CKb) resistor r=45 c=0
Rx12 (\3\:CKb \19\:CKb) resistor r=45 c=0
Rx13 (\2\:CKb \20\:CKb) resistor r=45 c=0
Rx14 (\10\:CKb \21\:CKb) resistor r=45 c=0
Rx15 (\5\:CKb \22\:CKb) resistor r=45 c=0
Rx6 (\3\:mout \16\:mout) resistor r=45 c=0
Rx9 (\5\:CKbb \7\:CKbb) resistor r=45 c=0
Rx10 (\3\:CKbb \9\:CKbb) resistor r=45 c=0
Rx7 (\2\:n20 \7\:n20) resistor r=45 c=0
mn55 (Q qbint \9\:VSS VSS) g45n1lvt w=(2.6e-07) l=4.5e-08 nf=1 \
        as=3.948e-14 ad=4.16e-14 ps=8.3e-07 pd=8.4e-07 nrd=1.16667 \
        nrs=1.16667 sa=1.4e-07 sb=1.72817e-06 sd=160n sca=17.5885 \
        scb=0.0172826 scc=0.00162584 m=(4)
mn50 (n42 \3\:SN \9\:VSS VSS) g45n1lvt w=(2.05e-07) l=4.5e-08 nf=1 \
        as=4.715e-14 ad=3.28e-14 ps=8.7e-07 pd=7.3e-07 nrd=1.16667 \
        nrs=1.16667 sa=1.44e-06 sb=1.01e-06 sd=160n sca=13.8179 \
        scb=0.0141903 scc=0.000851218 m=(1)
mn51 (n40 \16\:qbint n42 VSS) g45n1lvt w=(2.05e-07) l=4.5e-08 nf=1 \
        as=3.28e-14 ad=7.073e-14 ps=7.3e-07 pd=1.1e-06 nrd=1.16667 \
        nrs=1.16667 sa=1.645e-06 sb=8.05e-07 sd=160n sca=13.8179 \
        scb=0.0141903 scc=0.000851218 m=(1)
mn52 (\12\:n35 CKb n40 VSS) g45n1lvt w=(2.05e-07) l=4.5e-08 nf=1 \
        as=7.073e-14 ad=4.715e-14 ps=1.1e-06 pd=8.7e-07 nrd=1.16667 \
        nrs=1.16667 sa=2e-06 sb=4.15e-07 sd=160n sca=13.8179 scb=0.0141903 \
        scc=0.000851218 m=(1)
mn40 (\12\:n35 \2\:CKbb \9\:mout VSS) g45n1lvt w=(2.05e-07) l=4.5e-08 \
        nf=1 as=2.87e-14 ad=4.715e-14 ps=6.9e-07 pd=8.7e-07 nrd=1.16667 \
        nrs=1.16667 sa=2e-06 sb=1.4e-07 sd=160n sca=13.8179 scb=0.0141903 \
        scc=0.000851218 m=(1)
mn30 (n25 \6\:SN \18\:VSS VSS) g45n1lvt w=(2.05e-07) l=4.5e-08 nf=1 \
        as=2.87e-14 ad=1.23e-14 ps=6.9e-07 pd=5.3e-07 nrd=1.16667 \
        nrs=1.16667 sa=1.4e-07 sb=2.45e-07 sd=160n sca=9.70996 \
        scb=0.0085072 scc=0.000244399 m=(1)
mn31 (\12\:mout \3\:n20 n25 VSS) g45n1lvt w=(2.05e-07) l=4.5e-08 nf=1 \
        as=1.23e-14 ad=2.87e-14 ps=5.3e-07 pd=6.9e-07 nrd=1.16667 \
        nrs=1.16667 sa=2.45e-07 sb=1.4e-07 sd=160n sca=9.70996 \
        scb=0.0085072 scc=0.000244399 m=(1)
mn36 (n30 mout \16\:VSS VSS) g45n1lvt w=(2.05e-07) l=4.5e-08 nf=1 \
        as=2.87e-14 ad=2.665e-14 ps=6.9e-07 pd=6.7e-07 nrd=1.16667 \
        nrs=1.16667 sa=1.4e-07 sb=9.64512e-07 sd=160n sca=11.535 \
        scb=0.0112489 scc=0.00047927 m=(1)
mn35 (\4\:n20 \6\:CKbb n30 VSS) g45n1lvt w=(2.05e-07) l=4.5e-08 nf=1 \
        as=2.665e-14 ad=3.28e-14 ps=6.7e-07 pd=7.3e-07 nrd=1.16667 \
        nrs=1.16667 sa=3.15e-07 sb=7.89512e-07 sd=160n sca=11.535 \
        scb=0.0112489 scc=0.00047927 m=(1)
mn26 (\4\:n20 \7\:CKb n21 VSS) g45n1lvt w=(2.05e-07) l=4.5e-08 nf=1 \
        as=1.23e-14 ad=3.28e-14 ps=5.3e-07 pd=7.3e-07 nrd=1.16667 \
        nrs=1.16667 sa=5.2e-07 sb=5.84512e-07 sd=160n sca=11.535 \
        scb=0.0112489 scc=0.00047927 m=(1)
mn25 (n21 \3\:D \14\:VSS VSS) g45n1lvt w=(2.05e-07) l=4.5e-08 nf=1 \
        as=4.392e-14 ad=1.23e-14 ps=9e-07 pd=5.3e-07 nrd=1.16667 \
        nrs=1.16667 sa=6.25e-07 sb=4.79512e-07 sd=160n sca=11.535 \
        scb=0.0112489 scc=0.00047927 m=(1)
mn45_1__rcx (\20\:qbint n35 \9\:VSS VSS) g45n1lvt w=(2.05e-07) l=4.5e-08 \
        nf=1 as=4.273e-14 ad=3.28e-14 ps=8.55e-07 pd=7.3e-07 nrd=1.16667 \
        nrs=1.16667 sa=9.6e-07 sb=1.49e-06 sd=160n sca=13.8179 \
        scb=0.0141903 scc=0.000851218 m=(2)
mn21 (\11\:CKbb \11\:CKb \14\:VSS VSS) g45n1lvt w=(1.45e-07) l=4.5e-08 \
        nf=1 as=4.392e-14 ad=4.785e-14 ps=9e-07 pd=9.5e-07 nrd=1.16667 \
        nrs=1.16667 sa=9.15e-07 sb=3.3e-07 sd=160n sca=12.9138 \
        scb=0.0133404 scc=0.000640143 m=(1)
mn20 (\14\:CKb \3\:CK \1\:VSS VSS) g45n1lvt w=(1.45e-07) l=4.5e-08 nf=1 \
        as=3.698e-14 ad=2.32e-14 ps=8e-07 pd=6.1e-07 nrd=1.16667 \
        nrs=1.16667 sa=1.6e-07 sb=2.55e-07 sd=160n sca=23.279 \
        scb=0.0230742 scc=0.00267719 m=(1)
mp50 (\3\:n41 \1\:SN VDD VDD) g45p1lvt w=(3.1e-07) l=4.5e-08 nf=1 \
        as=6.51e-14 ad=4.96e-14 ps=1.04e-06 pd=9.4e-07 nrd=1.16667 \
        nrs=1.16667 sa=1.44e-06 sb=3.45e-07 sd=160n sca=10.6008 \
        scb=0.00822388 scc=0.000121216 m=(1)
mp51 (\3\:n41 \14\:qbint \15\:VDD VDD) g45p1lvt w=(3.1e-07) l=4.5e-08 \
        nf=1 as=4.34e-14 ad=4.96e-14 ps=9e-07 pd=9.4e-07 nrd=1.16667 \
        nrs=1.16667 sa=1.645e-06 sb=1.4e-07 sd=160n sca=10.6008 \
        scb=0.00822388 scc=0.000121216 m=(1)
mp52 (\8\:n35 CKbb n41 VDD) g45p1lvt w=(3.1e-07) l=4.5e-08 nf=1 \
        as=4.34e-14 ad=6.045e-14 ps=9e-07 pd=1.01e-06 nrd=1.16667 \
        nrs=1.16667 sa=1.4e-07 sb=3.98065e-07 sd=160n sca=19.1541 \
        scb=0.0174883 scc=0.00172295 m=(1)
mp40 (\8\:n35 \4\:CKb \14\:mout VDD) g45p1lvt w=(3.1e-07) l=4.5e-08 nf=1 \
        as=4.9e-14 ad=6.045e-14 ps=1.12e-06 pd=1.01e-06 nrd=1.16667 \
        nrs=1.16667 sa=3.8e-07 sb=1.58065e-07 sd=160n sca=19.1541 \
        scb=0.0174883 scc=0.00172295 m=(1)
mp30 (\5\:mout \4\:SN \12\:VDD VDD) g45p1lvt w=(3.1e-07) l=4.5e-08 nf=1 \
        as=6.04e-14 ad=4.96e-14 ps=1.8e-06 pd=9.4e-07 nrd=1.16667 \
        nrs=1.16667 sa=1e-07 sb=1.32798e-06 sd=160n sca=35.6995 \
        scb=0.0234062 scc=0.00420468 m=(1)
mp31 (\5\:mout n20 \9\:VDD VDD) g45p1lvt w=(3.1e-07) l=4.5e-08 nf=1 \
        as=1.1e-13 ad=4.96e-14 ps=2.12e-06 pd=9.4e-07 nrd=1.16667 \
        nrs=1.16667 sa=3.05e-07 sb=1.12298e-06 sd=160n sca=35.6995 \
        scb=0.0234062 scc=0.00420468 m=(1)
mp35 (n31 \4\:mout \9\:VDD VDD) g45p1lvt w=(3.1e-07) l=4.5e-08 nf=1 \
        as=1.1e-13 ad=1.86e-14 ps=2.12e-06 pd=7.4e-07 nrd=1.16667 \
        nrs=1.16667 sa=6.1e-07 sb=8.17984e-07 sd=160n sca=35.6995 \
        scb=0.0234062 scc=0.00420468 m=(1)
mp36 (\8\:n20 \6\:CKb n31 VDD) g45p1lvt w=(3.1e-07) l=4.5e-08 nf=1 \
        as=1.86e-14 ad=1.0365e-13 ps=7.4e-07 pd=1.49e-06 nrd=1.16667 \
        nrs=1.16667 sa=7.15e-07 sb=7.12984e-07 sd=160n sca=35.6995 \
        scb=0.0234062 scc=0.00420468 m=(1)
mp26 (\8\:n20 \4\:CKbb n22 VDD) g45p1lvt w=(3.1e-07) l=4.5e-08 nf=1 \
        as=4.185e-14 ad=1.0365e-13 ps=8.9e-07 pd=1.49e-06 nrd=1.16667 \
        nrs=1.16667 sa=9.14032e-07 sb=4.84597e-07 sd=160n sca=19.1541 \
        scb=0.0174883 scc=0.00172295 m=(1)
mp25 (n22 \1\:D \7\:VDD VDD) g45p1lvt w=(3.1e-07) l=4.5e-08 nf=1 \
        as=5.465e-14 ad=4.185e-14 ps=1.04e-06 pd=8.9e-07 nrd=1.16667 \
        nrs=1.16667 sa=1.09403e-06 sb=3.04597e-07 sd=160n sca=19.1541 \
        scb=0.0174883 scc=0.00172295 m=(1)
mp45 (\22\:qbint n35 VDD VDD) g45p1lvt w=(3.1e-07) l=4.5e-08 nf=1 \
        as=6.135e-14 ad=5.58e-14 ps=1.07e-06 pd=9.8e-07 nrd=1.16667 \
        nrs=1.16667 sa=9.6e-07 sb=8.25e-07 sd=160n sca=10.6008 \
        scb=0.00822388 scc=0.000121216 m=(2)
mp21 (\13\:CKbb \9\:CKb \7\:VDD VDD) g45p1lvt w=(2.15e-07) l=4.5e-08 \
        nf=1 as=5.465e-14 ad=3.01e-14 ps=1.04e-06 pd=7.1e-07 nrd=1.16667 \
        nrs=1.16667 sa=1.2536e-06 sb=1.4e-07 sd=160n sca=13.4401 \
        scb=0.0126994 scc=0.000544006 m=(1)
mp20 (\12\:CKb \1\:CK \1\:VDD VDD) g45p1lvt w=(2.15e-07) l=4.5e-08 nf=1 \
        as=3.01e-14 ad=3.01e-14 ps=7.1e-07 pd=7.1e-07 nrd=1.16667 \
        nrs=1.16667 sa=1.4e-07 sb=1.4e-07 sd=160n sca=51.6924 \
        scb=0.0366725 scc=0.00607082 m=(1)
ends DFFSHQX4
// End of subcircuit definition.
