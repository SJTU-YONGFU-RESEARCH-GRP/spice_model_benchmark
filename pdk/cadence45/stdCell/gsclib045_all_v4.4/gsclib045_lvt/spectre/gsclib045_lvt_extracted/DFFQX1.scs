// Generated for: spectre (May  1 09:13:37 2013 )
// Library name: gsclib045_lvt
// Cell name: DFFQX1
// View name: extracted

simulator lang=spectre

subckt DFFQX1 CK D Q VDD VSS
mp55 (\1\:Q \4\:qbint \13\:VDD VDD) g45p1lvt w=(3.9e-07) l=4.5e-08 nf=1 \
        as=5.405e-14 ad=5.46e-14 ps=1.12e-06 pd=1.06e-06 nrd=1.16667 \
        nrs=1.16667 sa=1.4e-07 sb=2.70897e-07 sd=160n sca=21.8895 \
        scb=0.024842 scc=0.00105464 m=(1)
C1 (D VSS) capacitor c=1.31132e-16
C2 (VDD VSS) capacitor c=2.74421e-16
C3 (Q VSS) capacitor c=5.24339e-17
C4 (CK VSS) capacitor c=1.15329e-16
C5 (qbint VSS) capacitor c=1.95314e-17
C6 (CKb VSS) capacitor c=2.14077e-17
C7 (n30 VSS) capacitor c=3.62825e-17
C8 (n35 VSS) capacitor c=3.63289e-18
C9 (mout VSS) capacitor c=4.34151e-17
C10 (CKbb VSS) capacitor c=4.97474e-17
C11 (n20 VSS) capacitor c=3.19962e-17
C12 (n25 VSS) capacitor c=1.27446e-18
C13 (n21 VSS) capacitor c=1.25e-18
C14 (n36 VSS) capacitor c=1.26428e-18
C15 (n26 VSS) capacitor c=1.13617e-18
C16 (n22 VSS) capacitor c=3.43716e-18
C17 (\10\:CKb VSS) capacitor c=4.23821e-17
C18 (\3\:D VSS) capacitor c=3.13717e-17
C19 (\5\:CKbb VSS) capacitor c=6.77985e-17
C20 (\5\:CKb VSS) capacitor c=5.39144e-17
C21 (\4\:mout VSS) capacitor c=9.18303e-17
C22 (\4\:n20 VSS) capacitor c=3.9671e-17
C23 (\2\:CKbb VSS) capacitor c=4.69135e-17
C24 (\5\:qbint VSS) capacitor c=6.6422e-17
C25 (\3\:n30 VSS) capacitor c=3.68391e-17
C26 (\3\:CK VSS) capacitor c=4.07492e-17
C27 (\4\:qbint VSS) capacitor c=6.39105e-17
C28 (\8\:CKb VSS) capacitor c=3.14537e-17
C29 (\1\:D VSS) capacitor c=6.93126e-17
C30 (\6\:CKb VSS) capacitor c=5.83045e-17
C31 (\6\:CKbb VSS) capacitor c=5.22411e-17
C32 (\3\:n20 VSS) capacitor c=5.04355e-17
C33 (\3\:CKbb VSS) capacitor c=3.51611e-17
C34 (\3\:CKb VSS) capacitor c=6.7508e-17
C35 (\8\:qbint VSS) capacitor c=3.80203e-17
C36 (\1\:CK VSS) capacitor c=5.95756e-17
C37 (\3\:qbint VSS) capacitor c=3.62166e-17
C38 (\9\:CKb VSS) capacitor c=4.90183e-17
C39 (\2\:D VSS) capacitor c=5.8373e-17
C40 (\7\:CKb VSS) capacitor c=5.51139e-17
C41 (\7\:CKbb VSS) capacitor c=2.50927e-17
C42 (\4\:CKb VSS) capacitor c=5.56172e-17
C43 (\3\:mout VSS) capacitor c=3.3056e-17
C44 (\4\:CKbb VSS) capacitor c=4.54235e-17
C45 (\2\:CKb VSS) capacitor c=6.49404e-17
C46 (\7\:qbint VSS) capacitor c=3.32248e-17
C47 (\4\:n30 VSS) capacitor c=3.23236e-17
C48 (\2\:CK VSS) capacitor c=4.16642e-17
C49 (\8\:CKbb VSS) capacitor c=4.50264e-17
C50 (\1\:VDD VSS) capacitor c=3.55994e-17
C51 (\9\:n20 VSS) capacitor c=6.55276e-17
C52 (\9\:VDD VSS) capacitor c=2.19094e-17
C53 (\9\:mout VSS) capacitor c=6.36204e-17
C54 (\9\:n30 VSS) capacitor c=6.41875e-17
C55 (\11\:VDD VSS) capacitor c=2.40299e-17
C56 (\14\:qbint VSS) capacitor c=5.55534e-17
C57 (\15\:CKb VSS) capacitor c=1.67238e-16
C58 (\13\:VDD VSS) capacitor c=3.13618e-17
C59 (\1\:Q VSS) capacitor c=5.20251e-17
C60 (\3\:VDD VSS) capacitor c=7.5529e-17
C61 (\14\:CKbb VSS) capacitor c=1.52227e-17
C62 (\5\:n20 VSS) capacitor c=7.66509e-17
C63 (\7\:mout VSS) capacitor c=3.34202e-17
C64 (\5\:n30 VSS) capacitor c=5.87235e-17
C65 (\11\:qbint VSS) capacitor c=9.47533e-17
C66 (\19\:CKb VSS) capacitor c=1.11081e-16
C67 (\3\:Q VSS) capacitor c=1.80725e-17
C68 (\2\:qbint VSS) capacitor c=2.31753e-17
C69 (\2\:n30 VSS) capacitor c=3.05192e-17
C70 (\6\:qbint VSS) capacitor c=3.57103e-17
C71 (\2\:n20 VSS) capacitor c=3.66147e-17
C72 (\2\:mout VSS) capacitor c=4.67378e-17
C73 (\9\:qbint VSS) capacitor c=3.67416e-17
C74 (\10\:qbint VSS) capacitor c=5.04519e-17
C75 (\13\:qbint VSS) capacitor c=1.38074e-16
C76 (\7\:n30 VSS) capacitor c=6.1748e-17
C77 (\8\:n30 VSS) capacitor c=4.1286e-17
C78 (\5\:mout VSS) capacitor c=4.07122e-17
C79 (\6\:mout VSS) capacitor c=6.19696e-17
C80 (\7\:n20 VSS) capacitor c=7.83547e-17
C81 (\8\:n20 VSS) capacitor c=3.1902e-17
C82 (\11\:CKb VSS) capacitor c=7.27311e-17
C83 (\12\:CKb VSS) capacitor c=6.87735e-17
C84 (\13\:CKb VSS) capacitor c=1.18899e-16
C85 (\14\:CKb VSS) capacitor c=1.8522e-16
C86 (\17\:CKb VSS) capacitor c=3.28474e-17
C87 (\18\:CKb VSS) capacitor c=4.99865e-17
C88 (\10\:CKbb VSS) capacitor c=1.21008e-16
C89 (\11\:CKbb VSS) capacitor c=1.77094e-16
C90 (\12\:CKbb VSS) capacitor c=1.27976e-16
C91 (\13\:CKbb VSS) capacitor c=5.90153e-17
C92 (\5\:VDD VSS) capacitor c=4.58442e-17
C93 (\7\:VDD VSS) capacitor c=1.90514e-17
C94 (\8\:VDD VSS) capacitor c=2.25062e-17
Rk17 (D \4\:D) resistor r=0.006754 c=0
Rk30 (\2\:VSS \3\:VSS) resistor r=0.1299 c=0
Rk31 (\3\:VSS \5\:VSS) resistor r=0.5242 c=0
Rk32 (\5\:VSS \6\:VSS) resistor r=0.06253 c=0
Rk34 (\7\:VSS VSS) resistor r=0.125 c=0
Rk33 (\6\:VSS \7\:VSS) resistor r=0.3634 c=0
Rk35 (\3\:VSS \8\:VSS) resistor r=0.3285 c=0
Rk36 (\8\:VSS \10\:VSS) resistor r=0.4417 c=0
Rk37 (\6\:VSS \12\:VSS) resistor r=0.3706 c=0
Rk38 (\7\:VSS \14\:VSS) resistor r=0.2547 c=0
Rk39 (\2\:VDD \4\:VDD) resistor r=0.2755 c=0
Rk40 (\4\:VDD \5\:VDD) resistor r=0.4003 c=0
Rk41 (\5\:VDD \6\:VDD) resistor r=0.4505 c=0
Rk42 (\6\:VDD \7\:VDD) resistor r=0.05154 c=0
Rk44 (\8\:VDD VDD) resistor r=0.125 c=0
Rk43 (\7\:VDD \8\:VDD) resistor r=0.3725 c=0
Rk45 (\5\:VDD \10\:VDD) resistor r=0.04334 c=0
Rk46 (\7\:VDD \12\:VDD) resistor r=0.04334 c=0
Rk47 (\8\:VDD \14\:VDD) resistor r=0.2063 c=0
Rk1 (\2\:Q Q) resistor r=0.3432 c=0
Rk2 (Q \4\:Q) resistor r=0.06947 c=0
Rk3 (\4\:CK CK) resistor r=0.003008 c=0
Rk4 (\9\:qbint \10\:qbint) resistor r=0.1472 c=0
Rk5 (\10\:qbint \12\:qbint) resistor r=0.2486 c=0
Rk6 (\12\:qbint \13\:qbint) resistor r=0.7919 c=0
Rk7 (\10\:qbint \15\:qbint) resistor r=0.2188 c=0
Rk18 (\11\:CKb \12\:CKb) resistor r=0.3178 c=0
Rk19 (\12\:CKb \13\:CKb) resistor r=0.179 c=0
Rk20 (\13\:CKb \14\:CKb) resistor r=0.9691 c=0
Rk21 (\14\:CKb \16\:CKb) resistor r=0.7408 c=0
Rk22 (\13\:CKb \17\:CKb) resistor r=0.1169 c=0
Rk23 (\14\:CKb \18\:CKb) resistor r=0.2253 c=0
Rk24 (\16\:CKb \20\:CKb) resistor r=0.6646 c=0
Rk8 (\6\:n30 \7\:n30) resistor r=0.473 c=0
Rk9 (\7\:n30 \8\:n30) resistor r=0.1426 c=0
Rk10 (\7\:n30 \10\:n30) resistor r=0.235 c=0
Rk11 (\5\:mout \6\:mout) resistor r=0.1256 c=0
Rk12 (\6\:mout \8\:mout) resistor r=0.1685 c=0
Rk13 (\6\:mout \10\:mout) resistor r=0.3693 c=0
Rk25 (\9\:CKbb \10\:CKbb) resistor r=0.3743 c=0
Rk26 (\10\:CKbb \11\:CKbb) resistor r=0.7505 c=0
Rk27 (\11\:CKbb \12\:CKbb) resistor r=0.9062 c=0
Rk28 (\12\:CKbb \13\:CKbb) resistor r=0.2986 c=0
Rk29 (\10\:CKbb \15\:CKbb) resistor r=0.09559 c=0
Rk14 (\6\:n20 \7\:n20) resistor r=0.5238 c=0
Rk15 (\7\:n20 \8\:n20) resistor r=0.09453 c=0
Rk16 (\7\:n20 \10\:n20) resistor r=0.3553 c=0
Rl27 (\2\:D \3\:D) resistor r=41.5405 c=0
Rl26 (\1\:D \2\:D) resistor r=137.694 c=0
Rl5 (\2\:CK \3\:CK) resistor r=54.9442 c=0
Rl4 (\1\:CK \2\:CK) resistor r=153.021 c=0
Rl3 (\2\:qbint \4\:qbint) resistor r=130.483 c=0
Rl2 (\2\:qbint \3\:qbint) resistor r=34.3295 c=0
Rl1 (qbint \2\:qbint) resistor r=1.2713 c=0
Rl9 (\5\:qbint \6\:qbint) resistor r=111.253 c=0
Rl11 (\6\:qbint \8\:qbint) resistor r=88.1757 c=0
Rl10 (\6\:qbint \7\:qbint) resistor r=9.8995 c=0
Rl29 (\9\:CKb \10\:CKb) resistor r=99.5316 c=0
Rl28 (\8\:CKb \9\:CKb) resistor r=82.9508 c=0
Rl25 (\6\:CKb \7\:CKb) resistor r=89.8977 c=0
Rl22 (\4\:CKb \5\:CKb) resistor r=53.733 c=0
Rl13 (CKb \2\:CKb) resistor r=24.2328 c=0
Rl14 (\2\:CKb \3\:CKb) resistor r=213.278 c=0
Rl7 (\2\:n30 \3\:n30) resistor r=51.0755 c=0
Rl6 (n30 \2\:n30) resistor r=151.076 c=0
Rl8 (\2\:n30 \4\:n30) resistor r=13.6663 c=0
Rl21 (\2\:mout \4\:mout) resistor r=151.605 c=0
Rl19 (mout \2\:mout) resistor r=82.6702 c=0
Rl20 (\2\:mout \3\:mout) resistor r=32.6176 c=0
Rl23 (\5\:CKbb \6\:CKbb) resistor r=207.692 c=0
Rl24 (\6\:CKbb \7\:CKbb) resistor r=26.1559 c=0
Rl15 (\3\:CKbb \4\:CKbb) resistor r=78.079 c=0
Rl12 (CKbb \2\:CKbb) resistor r=68.7438 c=0
Rl18 (\2\:n20 \4\:n20) resistor r=79.6488 c=0
Rl17 (\2\:n20 \3\:n20) resistor r=118.11 c=0
Rl16 (n20 \2\:n20) resistor r=10.9374 c=0
Rz8 (\1\:VSS \2\:VSS) resistor r=75 c=0
Rz9 (\9\:VSS \10\:VSS) resistor r=75 c=0
Rz10 (\11\:VSS \12\:VSS) resistor r=75 c=0
Rz11 (\13\:VSS \14\:VSS) resistor r=75 c=0
Rz12 (\3\:VDD \4\:VDD) resistor r=15 c=0
Rz13 (\3\:VDD \6\:VDD) resistor r=6.25 c=0
Rz1 (\3\:Q \4\:Q) resistor r=75 c=0
Rz2 (\11\:qbint \12\:qbint) resistor r=75 c=0
Rz6 (\19\:CKb \20\:CKb) resistor r=75 c=0
Rz3 (\5\:n30 \6\:n30) resistor r=75 c=0
Rz4 (\7\:mout \8\:mout) resistor r=75 c=0
Rz7 (\14\:CKbb \15\:CKbb) resistor r=75 c=0
Rz5 (\5\:n20 \6\:n20) resistor r=75 c=0
Ry8 (\4\:VSS \5\:VSS) resistor r=5.1667 c=0
Ry9 (\4\:VSS \8\:VSS) resistor r=12.4 c=0
Ry10 (\1\:VDD \2\:VDD) resistor r=62 c=0
Ry11 (\9\:VDD \10\:VDD) resistor r=62 c=0
Ry12 (\11\:VDD \12\:VDD) resistor r=62 c=0
Ry13 (\13\:VDD \14\:VDD) resistor r=62 c=0
Ry1 (\1\:Q \2\:Q) resistor r=20.6667 c=0
Ry2 (\14\:qbint \15\:qbint) resistor r=62 c=0
Ry6 (\15\:CKb \16\:CKb) resistor r=62 c=0
Ry3 (\9\:n30 \10\:n30) resistor r=62 c=0
Ry4 (\9\:mout \10\:mout) resistor r=62 c=0
Ry7 (\8\:CKbb \9\:CKbb) resistor r=62 c=0
Ry5 (\9\:n20 \10\:n20) resistor r=62 c=0
Rx7 (\2\:D \4\:D) resistor r=45 c=0
Rx1 (\2\:CK \4\:CK) resistor r=45 c=0
Rx2 (\7\:qbint \9\:qbint) resistor r=45 c=0
Rx3 (qbint \13\:qbint) resistor r=45 c=0
Rx8 (\9\:CKb \11\:CKb) resistor r=45 c=0
Rx9 (\7\:CKb \12\:CKb) resistor r=45 c=0
Rx10 (\4\:CKb \17\:CKb) resistor r=45 c=0
Rx11 (\2\:CKb \18\:CKb) resistor r=45 c=0
Rx4 (\4\:n30 \8\:n30) resistor r=45 c=0
Rx5 (\3\:mout \5\:mout) resistor r=45 c=0
Rx12 (\7\:CKbb \11\:CKbb) resistor r=45 c=0
Rx13 (\4\:CKbb \12\:CKbb) resistor r=45 c=0
Rx14 (CKbb \13\:CKbb) resistor r=45 c=0
Rx6 (n20 \8\:n20) resistor r=45 c=0
mn55 (\3\:Q \3\:qbint \13\:VSS VSS) g45n1lvt w=(2.6e-07) l=4.5e-08 nf=1 \
        as=4.365e-14 ad=3.64e-14 ps=9e-07 pd=8e-07 nrd=1.16667 nrs=1.16667 \
        sa=1.4e-07 sb=3.18462e-07 sd=160n sca=12.1772 scb=0.0118935 \
        scc=0.000630577 m=(1)
mn20 (\19\:CKb \1\:CK \13\:VSS VSS) g45n1lvt w=(1.45e-07) l=4.5e-08 nf=1 \
        as=4.365e-14 ad=3.263e-14 ps=9e-07 pd=7.4e-07 nrd=1.16667 \
        nrs=1.16667 sa=3.75e-07 sb=2.25e-07 sd=160n sca=15.2405 \
        scb=0.016218 scc=0.00104639 m=(1)
mn45 (\11\:qbint n30 \11\:VSS VSS) g45n1lvt w=(1.45e-07) l=4.5e-08 nf=1 \
        as=3.045e-14 ad=2.03e-14 ps=7.1e-07 pd=5.7e-07 nrd=1.16667 \
        nrs=1.16667 sa=1.4e-07 sb=2e-06 sd=160n sca=19.8813 scb=0.0206549 \
        scc=0.00197265 m=(1)
mn50 (n35 \8\:qbint \11\:VSS VSS) g45n1lvt w=(1.45e-07) l=4.5e-08 nf=1 \
        as=3.045e-14 ad=2.03e-14 ps=7.1e-07 pd=5.7e-07 nrd=1.16667 \
        nrs=1.16667 sa=3.95e-07 sb=2e-06 sd=160n sca=19.8813 scb=0.0206549 \
        scc=0.00197265 m=(1)
mn51 (\5\:n30 \3\:CKb n35 VSS) g45n1lvt w=(1.45e-07) l=4.5e-08 nf=1 \
        as=2.03e-14 ad=3.698e-14 ps=5.7e-07 pd=8e-07 nrd=1.16667 \
        nrs=1.16667 sa=5.8e-07 sb=1.895e-06 sd=160n sca=19.8813 \
        scb=0.0206549 scc=0.00197265 m=(1)
mn40 (\5\:n30 \3\:CKbb \7\:mout VSS) g45n1lvt w=(1.45e-07) l=4.5e-08 nf=1 \
        as=3.045e-14 ad=3.698e-14 ps=7.1e-07 pd=8e-07 nrd=1.16667 \
        nrs=1.16667 sa=8.8e-07 sb=1.595e-06 sd=160n sca=19.8813 \
        scb=0.0206549 scc=0.00197265 m=(1)
mn30 (\7\:mout \3\:n20 \1\:VSS VSS) g45n1lvt w=(1.45e-07) l=4.5e-08 nf=1 \
        as=8.758e-14 ad=3.045e-14 ps=1.61e-06 pd=7.1e-07 nrd=1.16667 \
        nrs=1.16667 sa=1.135e-06 sb=1.34e-06 sd=160n sca=19.8813 \
        scb=0.0206549 scc=0.00197265 m=(1)
mn35 (n25 mout \1\:VSS VSS) g45n1lvt w=(1.45e-07) l=4.5e-08 nf=1 \
        as=8.758e-14 ad=2.465e-14 ps=1.61e-06 pd=6.3e-07 nrd=1.16667 \
        nrs=1.16667 sa=1.515e-06 sb=9.6e-07 sd=160n sca=19.8813 \
        scb=0.0206549 scc=0.00197265 m=(1)
mn36 (\5\:n20 \6\:CKbb n25 VSS) g45n1lvt w=(1.45e-07) l=4.5e-08 nf=1 \
        as=2.465e-14 ad=3.045e-14 ps=6.3e-07 pd=7.1e-07 nrd=1.16667 \
        nrs=1.16667 sa=1.73e-06 sb=7.45e-07 sd=160n sca=19.8813 \
        scb=0.0206549 scc=0.00197265 m=(1)
mn26 (\5\:n20 \6\:CKb n21 VSS) g45n1lvt w=(1.45e-07) l=4.5e-08 nf=1 \
        as=8.7e-15 ad=3.045e-14 ps=4.1e-07 pd=7.1e-07 nrd=1.16667 \
        nrs=1.16667 sa=1.985e-06 sb=4.9e-07 sd=160n sca=19.8813 \
        scb=0.0206549 scc=0.00197265 m=(1)
mn25 (n21 \1\:D \9\:VSS VSS) g45n1lvt w=(1.45e-07) l=4.5e-08 nf=1 \
        as=2.9e-14 ad=8.7e-15 ps=6.9e-07 pd=4.1e-07 nrd=1.16667 \
        nrs=1.16667 sa=2e-06 sb=3.85e-07 sd=160n sca=19.8813 scb=0.0206549 \
        scc=0.00197265 m=(1)
mn21 (\14\:CKbb \8\:CKb \9\:VSS VSS) g45n1lvt w=(1.45e-07) l=4.5e-08 \
        nf=1 as=2.9e-14 ad=2.03e-14 ps=6.9e-07 pd=5.7e-07 nrd=1.16667 \
        nrs=1.16667 sa=2e-06 sb=1.4e-07 sd=160n sca=19.8813 scb=0.0206549 \
        scc=0.00197265 m=(1)
mp20 (\15\:CKb \3\:CK \13\:VDD VDD) g45p1lvt w=(2.15e-07) l=4.5e-08 nf=1 \
        as=5.405e-14 ad=4.193e-14 ps=1.12e-06 pd=8.2e-07 nrd=1.16667 \
        nrs=1.16667 sa=3.55e-07 sb=1.95e-07 sd=160n sca=12.8473 \
        scb=0.0101159 scc=8.80993e-05 m=(1)
mp45 (\14\:qbint \3\:n30 \11\:VDD VDD) g45p1lvt w=(2.15e-07) l=4.5e-08 \
        nf=1 as=7.55e-14 ad=3.01e-14 ps=1.34e-06 pd=7.1e-07 nrd=1.16667 \
        nrs=1.16667 sa=1.4e-07 sb=2e-06 sd=160n sca=10.2815 scb=0.00760864 \
        scc=8.81378e-05 m=(1)
mp50 (n36 \5\:qbint \11\:VDD VDD) g45p1lvt w=(2.15e-07) l=4.5e-08 nf=1 \
        as=7.55e-14 ad=1.935e-14 ps=1.34e-06 pd=6.1e-07 nrd=1.16667 \
        nrs=1.16667 sa=4.05e-07 sb=2e-06 sd=160n sca=10.2815 \
        scb=0.00760864 scc=8.81378e-05 m=(1)
mp51 (\9\:n30 \2\:CKbb n36 VDD) g45p1lvt w=(2.15e-07) l=4.5e-08 nf=1 \
        as=1.935e-14 ad=4.515e-14 ps=6.1e-07 pd=8.5e-07 nrd=1.16667 \
        nrs=1.16667 sa=5.4e-07 sb=1.975e-06 sd=160n sca=10.2815 \
        scb=0.00760864 scc=8.81378e-05 m=(1)
mp40 (\9\:n30 CKb \9\:mout VDD) g45p1lvt w=(2.15e-07) l=4.5e-08 nf=1 \
        as=6.558e-14 ad=4.515e-14 ps=1.04e-06 pd=8.5e-07 nrd=1.16667 \
        nrs=1.16667 sa=7.95e-07 sb=1.72e-06 sd=160n sca=10.2815 \
        scb=0.00760864 scc=8.81378e-05 m=(1)
mp30 (\9\:mout \4\:n20 \9\:VDD VDD) g45p1lvt w=(2.15e-07) l=4.5e-08 nf=1 \
        as=7.55e-14 ad=6.558e-14 ps=1.34e-06 pd=1.04e-06 nrd=1.16667 \
        nrs=1.16667 sa=1.145e-06 sb=1.37e-06 sd=160n sca=10.2815 \
        scb=0.00760864 scc=8.81378e-05 m=(1)
mp35 (n26 \4\:mout \9\:VDD VDD) g45p1lvt w=(2.15e-07) l=4.5e-08 nf=1 \
        as=7.55e-14 ad=1.29e-14 ps=1.34e-06 pd=5.5e-07 nrd=1.16667 \
        nrs=1.16667 sa=1.41e-06 sb=1.105e-06 sd=160n sca=10.2815 \
        scb=0.00760864 scc=8.81378e-05 m=(1)
mp36 (\9\:n20 \5\:CKb n26 VDD) g45p1lvt w=(2.15e-07) l=4.5e-08 nf=1 \
        as=1.29e-14 ad=3.87e-14 ps=5.5e-07 pd=7.9e-07 nrd=1.16667 \
        nrs=1.16667 sa=1.515e-06 sb=1e-06 sd=160n sca=10.2815 \
        scb=0.00760864 scc=8.81378e-05 m=(1)
mp26 (\9\:n20 \5\:CKbb n22 VDD) g45p1lvt w=(2.15e-07) l=4.5e-08 nf=1 \
        as=5.913e-14 ad=3.87e-14 ps=9.8e-07 pd=7.9e-07 nrd=1.16667 \
        nrs=1.16667 sa=1.74e-06 sb=7.75e-07 sd=160n sca=10.5668 \
        scb=0.00768563 scc=8.81513e-05 m=(1)
mp25 (n22 \3\:D \1\:VDD VDD) g45p1lvt w=(2.15e-07) l=4.5e-08 nf=1 \
        as=3.44e-14 ad=5.913e-14 ps=7.5e-07 pd=9.8e-07 nrd=1.16667 \
        nrs=1.16667 sa=2e-06 sb=4.55e-07 sd=160n sca=12.3276 \
        scb=0.00937389 scc=9.38578e-05 m=(1)
mp21 (\8\:CKbb \10\:CKb \1\:VDD VDD) g45p1lvt w=(2.15e-07) l=4.5e-08 \
        nf=1 as=3.44e-14 ad=5.375e-14 ps=7.5e-07 pd=9.3e-07 nrd=1.16667 \
        nrs=1.16667 sa=2e-06 sb=2.5e-07 sd=160n sca=16.5578 scb=0.0165885 \
        scc=0.000310105 m=(1)
ends DFFQX1
// End of subcircuit definition.
