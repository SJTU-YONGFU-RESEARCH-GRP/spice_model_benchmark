// Generated for: spectre (May  1 09:10:55 2013 )
// Library name: gsclib045_lvt
// Cell name: ADDFHX4
// View name: extracted

simulator lang=spectre

subckt ADDFHX4 A B CI CO S VDD VSS
mp2 (n3 \1\:A \23\:VDD VDD) g45p1lvt w=(3.9e-07) l=4.5e-08 nf=1 \
        as=1.245e-13 ad=5.46e-14 ps=1.9e-06 pd=1.06e-06 nrd=1.16667 \
        nrs=1.16667 sa=1.4e-07 sb=5.70769e-07 sd=160n sca=30.5009 \
        scb=0.0202006 scc=0.00336097 m=(1)
mp3 (\3\:n3 \1\:B \23\:VDD VDD) g45p1lvt w=(3.9e-07) l=4.5e-08 nf=1 \
        as=1.245e-13 ad=6.24e-14 ps=1.9e-06 pd=1.1e-06 nrd=1.16667 \
        nrs=1.16667 sa=3.86923e-07 sb=3.45e-07 sd=160n sca=22.2743 \
        scb=0.0178838 scc=0.00227235 m=(1)
mp4 (\24\:COb \1\:CI \3\:n3 VDD) g45p1lvt w=(3.9e-07) l=4.5e-08 nf=1 \
        as=6.24e-14 ad=5.46e-14 ps=1.1e-06 pd=1.06e-06 nrd=1.16667 \
        nrs=1.16667 sa=5.91923e-07 sb=1.4e-07 sd=160n sca=22.2743 \
        scb=0.0178838 scc=0.00227235 m=(1)
mp1 (\18\:COb \7\:B n1 VDD) g45p1lvt w=(3.9e-07) l=4.5e-08 nf=1 \
        as=2.34e-14 ad=5.46e-14 ps=9e-07 pd=1.06e-06 nrd=1.16667 \
        nrs=1.16667 sa=1.4e-07 sb=1.20192e-06 sd=160n sca=19.0259 \
        scb=0.0163587 scc=0.00171562 m=(1)
mp0 (n1 \6\:A \21\:VDD VDD) g45p1lvt w=(3.9e-07) l=4.5e-08 nf=1 \
        as=1.206e-13 ad=2.34e-14 ps=1.8e-06 pd=9e-07 nrd=1.16667 \
        nrs=1.16667 sa=2.45e-07 sb=1.09692e-06 sd=160n sca=19.0259 \
        scb=0.0163587 scc=0.00171562 m=(1)
mp7 (\3\:n5 \5\:CI \21\:VDD VDD) g45p1lvt w=(3.9e-07) l=4.5e-08 nf=1 \
        as=1.206e-13 ad=6.24e-14 ps=1.8e-06 pd=1.1e-06 nrd=1.16667 \
        nrs=1.16667 sa=5.1e-07 sb=8.31923e-07 sd=160n sca=19.0259 \
        scb=0.0163587 scc=0.00171562 m=(1)
mp6 (\3\:n5 \11\:B \19\:VDD VDD) g45p1lvt w=(3.9e-07) l=4.5e-08 nf=1 \
        as=1.206e-13 ad=6.24e-14 ps=1.8e-06 pd=1.1e-06 nrd=1.16667 \
        nrs=1.16667 sa=7.15e-07 sb=6.26923e-07 sd=160n sca=19.0259 \
        scb=0.0163587 scc=0.00171562 m=(1)
mp5 (n5 \7\:A \19\:VDD VDD) g45p1lvt w=(3.9e-07) l=4.5e-08 nf=1 \
        as=1.206e-13 ad=6.24e-14 ps=1.8e-06 pd=1.1e-06 nrd=1.16667 \
        nrs=1.16667 sa=9.8e-07 sb=3.61923e-07 sd=160n sca=19.0259 \
        scb=0.0163587 scc=0.00171562 m=(1)
mp8 (\24\:Sb \13\:COb n5 VDD) g45p1lvt w=(3.9e-07) l=4.5e-08 nf=1 \
        as=6.24e-14 ad=6.12e-14 ps=1.1e-06 pd=1.35e-06 nrd=1.16667 \
        nrs=1.16667 sa=1.185e-06 sb=1.56923e-07 sd=160n sca=19.0259 \
        scb=0.0163587 scc=0.00171562 m=(1)
mp11 (\22\:Sb \12\:CI n9 VDD) g45p1lvt w=(3.9e-07) l=4.5e-08 nf=1 \
        as=4.485e-14 ad=5.46e-14 ps=1.01e-06 pd=1.06e-06 nrd=1.16667 \
        nrs=1.16667 sa=1.4e-07 sb=1.295e-06 sd=160n sca=14.3987 \
        scb=0.0130081 scc=0.000814275 m=(1)
mp10 (n9 \12\:B n8 VDD) g45p1lvt w=(3.9e-07) l=4.5e-08 nf=1 as=3.51e-14 \
        ad=4.485e-14 ps=9.6e-07 pd=1.01e-06 nrd=1.16667 nrs=1.16667 \
        sa=3e-07 sb=1.135e-06 sd=160n sca=14.3987 scb=0.0130081 \
        scc=0.000814275 m=(1)
mp9 (n8 \10\:A \1\:VDD VDD) g45p1lvt w=(3.9e-07) l=4.5e-08 nf=1 \
        as=7.8e-14 ad=3.51e-14 ps=1.18e-06 pd=9.6e-07 nrd=1.16667 \
        nrs=1.16667 sa=4.35e-07 sb=1e-06 sd=160n sca=14.3987 scb=0.0130081 \
        scc=0.000814275 m=(1)
mp13_1__rcx (\6\:S Sb \1\:VDD VDD) g45p1lvt w=(3.9e-07) l=4.5e-08 nf=1 \
        as=6.435e-14 ad=6.24e-14 ps=1.11e-06 pd=1.1e-06 nrd=1.16667 \
        nrs=1.16667 sa=6.8e-07 sb=7.55e-07 sd=160n sca=14.4678 \
        scb=0.0130219 scc=0.000814276 m=(4)
mp12_1__rcx (\1\:CO COb \12\:VDD VDD) g45p1lvt w=(3.9e-07) l=4.5e-08 \
        nf=1 as=6.045e-14 ad=6.24e-14 ps=1.09e-06 pd=1.1e-06 nrd=1.16667 \
        nrs=1.16667 sa=1.4e-07 sb=7.65e-07 sd=160n sca=37.1131 scb=0.03221 \
        scc=0.00363789 m=(4)
C1 (A VSS) capacitor c=1.06394e-16
C2 (CO VSS) capacitor c=1.34744e-17
C3 (S VSS) capacitor c=1.52666e-17
C4 (VDD VSS) capacitor c=2.6745e-16
C5 (B VSS) capacitor c=6.85253e-17
C6 (CI VSS) capacitor c=8.8949e-17
C7 (COb VSS) capacitor c=2.93584e-16
C8 (n2 VSS) capacitor c=8.94103e-17
C9 (n0 VSS) capacitor c=1.23995e-18
C10 (n4 VSS) capacitor c=8.08485e-17
C11 (Sb VSS) capacitor c=3.0296e-16
C12 (n7 VSS) capacitor c=1.61961e-18
C13 (n6 VSS) capacitor c=3.29036e-18
C14 (n3 VSS) capacitor c=6.39087e-17
C15 (n1 VSS) capacitor c=2.07034e-18
C16 (n5 VSS) capacitor c=8.06683e-17
C17 (n9 VSS) capacitor c=3.59321e-18
C18 (n8 VSS) capacitor c=3.22966e-18
C19 (\10\:A VSS) capacitor c=7.09646e-17
C20 (\12\:B VSS) capacitor c=7.08189e-17
C21 (\12\:CI VSS) capacitor c=7.6403e-17
C22 (\13\:COb VSS) capacitor c=3.57281e-17
C23 (\7\:A VSS) capacitor c=7.20271e-17
C24 (\11\:B VSS) capacitor c=5.50043e-17
C25 (\5\:CI VSS) capacitor c=7.21388e-17
C26 (\6\:A VSS) capacitor c=8.98701e-17
C27 (\7\:B VSS) capacitor c=7.18386e-17
C28 (\1\:CI VSS) capacitor c=5.43441e-17
C29 (\1\:B VSS) capacitor c=5.74577e-17
C30 (\1\:A VSS) capacitor c=6.01259e-17
C31 (\12\:A VSS) capacitor c=4.87399e-17
C32 (\14\:B VSS) capacitor c=9.41098e-17
C33 (\9\:CI VSS) capacitor c=6.0005e-17
C34 (\15\:COb VSS) capacitor c=6.03615e-17
C35 (\9\:A VSS) capacitor c=5.0202e-17
C36 (\10\:B VSS) capacitor c=6.05021e-17
C37 (\8\:CI VSS) capacitor c=3.82892e-17
C38 (\4\:A VSS) capacitor c=7.92377e-17
C39 (\4\:B VSS) capacitor c=8.94527e-17
C40 (\3\:CI VSS) capacitor c=3.31129e-17
C41 (\3\:B VSS) capacitor c=5.42085e-17
C42 (\3\:A VSS) capacitor c=4.10396e-17
C43 (\11\:A VSS) capacitor c=4.21019e-17
C44 (\13\:B VSS) capacitor c=5.9095e-17
C45 (\11\:CI VSS) capacitor c=3.38895e-17
C46 (\16\:COb VSS) capacitor c=3.40075e-17
C47 (\8\:A VSS) capacitor c=5.20734e-17
C48 (\8\:B VSS) capacitor c=2.98917e-17
C49 (\7\:CI VSS) capacitor c=5.28386e-17
C50 (\5\:A VSS) capacitor c=6.24656e-17
C51 (\6\:B VSS) capacitor c=1.63981e-17
C52 (\4\:CI VSS) capacitor c=4.10263e-17
C53 (\2\:B VSS) capacitor c=3.67442e-17
C54 (\2\:A VSS) capacitor c=2.62767e-17
C55 (\1\:VDD VSS) capacitor c=1.76775e-16
C56 (\22\:Sb VSS) capacitor c=7.46846e-17
C57 (\24\:Sb VSS) capacitor c=6.06525e-17
C58 (\19\:VDD VSS) capacitor c=1.73964e-17
C59 (\3\:n5 VSS) capacitor c=9.4874e-17
C60 (\21\:VDD VSS) capacitor c=1.56286e-17
C61 (\18\:COb VSS) capacitor c=1.25427e-16
C62 (\24\:COb VSS) capacitor c=3.43465e-17
C63 (\3\:n3 VSS) capacitor c=8.35584e-17
C64 (\23\:VDD VSS) capacitor c=1.64207e-17
C65 (\1\:CO VSS) capacitor c=1.94229e-16
C66 (\3\:VDD VSS) capacitor c=5.19165e-17
C67 (\2\:S VSS) capacitor c=1.12127e-16
C68 (\18\:Sb VSS) capacitor c=9.84188e-17
C69 (\20\:Sb VSS) capacitor c=5.8947e-17
C70 (\3\:n4 VSS) capacitor c=7.8415e-17
C71 (\27\:COb VSS) capacitor c=6.1148e-17
C72 (\29\:COb VSS) capacitor c=1.56147e-17
C73 (\3\:n2 VSS) capacitor c=7.77248e-17
C74 (\6\:CO VSS) capacitor c=1.04064e-16
C75 (\2\:CI VSS) capacitor c=3.43984e-17
C76 (\5\:B VSS) capacitor c=3.5978e-17
C77 (\9\:B VSS) capacitor c=2.74209e-17
C78 (\14\:COb VSS) capacitor c=3.50887e-17
C79 (\10\:CI VSS) capacitor c=4.79924e-17
C80 (\17\:COb VSS) capacitor c=1.74083e-16
C81 (\20\:COb VSS) capacitor c=1.02038e-16
C82 (\21\:COb VSS) capacitor c=1.89139e-16
C83 (\26\:COb VSS) capacitor c=1.51242e-16
C84 (\13\:CI VSS) capacitor c=1.50163e-16
C85 (\14\:CI VSS) capacitor c=1.86663e-16
C86 (\15\:B VSS) capacitor c=1.27692e-16
C87 (\16\:B VSS) capacitor c=2.07754e-16
C88 (\17\:B VSS) capacitor c=7.49019e-17
C89 (\18\:B VSS) capacitor c=7.70813e-17
C90 (\13\:A VSS) capacitor c=3.78398e-17
C91 (\14\:A VSS) capacitor c=1.83155e-16
C92 (\15\:A VSS) capacitor c=2.16499e-16
C93 (\16\:A VSS) capacitor c=1.38447e-16
C94 (\17\:Sb VSS) capacitor c=1.49807e-16
C95 (\1\:S VSS) capacitor c=2.98876e-17
C96 (\6\:S VSS) capacitor c=1.94739e-16
C97 (\8\:VDD VSS) capacitor c=1.26916e-17
C98 (\9\:VDD VSS) capacitor c=3.1028e-17
C99 (\10\:VDD VSS) capacitor c=2.7261e-17
C100 (\12\:VDD VSS) capacitor c=1.50598e-16
Rk27 (\13\:A A) resistor r=0.08561 c=0
Rk28 (A \14\:A) resistor r=0.7093 c=0
Rk29 (\14\:A \15\:A) resistor r=0.6289 c=0
Rk30 (\15\:A \16\:A) resistor r=0.9088 c=0
Rk46 (\1\:VSS \7\:VSS) resistor r=0.4512 c=0
Rk47 (\7\:VSS \8\:VSS) resistor r=0.1929 c=0
Rk48 (\8\:VSS \9\:VSS) resistor r=0.2053 c=0
Rk49 (\9\:VSS \10\:VSS) resistor r=0.5704 c=0
Rk50 (\10\:VSS \11\:VSS) resistor r=0.2321 c=0
Rk54 (\12\:VSS VSS) resistor r=0.03215 c=0
Rk51 (\11\:VSS \12\:VSS) resistor r=0.1026 c=0
Rk57 (\8\:VSS \20\:VSS) resistor r=0.1026 c=0
Rk58 (\9\:VSS \22\:VSS) resistor r=0.1742 c=0
Rk59 (\10\:VSS \24\:VSS) resistor r=0.04331 c=0
Rk2 (\1\:CO CO) resistor r=0.242 c=0
Rk4 (CO \6\:CO) resistor r=0.05252 c=0
Rk37 (S \1\:S) resistor r=0.007742 c=0
Rk38 (\1\:S \2\:S) resistor r=0.1493 c=0
Rk40 (\1\:S \6\:S) resistor r=0.324 c=0
Rk66 (\1\:VDD \7\:VDD) resistor r=0.4512 c=0
Rk67 (\7\:VDD \8\:VDD) resistor r=0.1769 c=0
Rk68 (\8\:VDD \9\:VDD) resistor r=0.2334 c=0
Rk69 (\9\:VDD \10\:VDD) resistor r=0.5554 c=0
Rk70 (\10\:VDD \11\:VDD) resistor r=0.233 c=0
Rk74 (\12\:VDD VDD) resistor r=0.03215 c=0
Rk71 (\11\:VDD \12\:VDD) resistor r=0.1177 c=0
Rk77 (\8\:VDD \20\:VDD) resistor r=0.04331 c=0
Rk78 (\9\:VDD \22\:VDD) resistor r=0.04331 c=0
Rk79 (\10\:VDD \24\:VDD) resistor r=0.07393 c=0
Rk24 (\16\:B B) resistor r=0.6363 c=0
Rk23 (\15\:B \16\:B) resistor r=0.814 c=0
Rk25 (B \17\:B) resistor r=0.06383 c=0
Rk26 (\17\:B \18\:B) resistor r=0.534 c=0
Rk20 (\14\:CI CI) resistor r=0.4248 c=0
Rk19 (\13\:CI \14\:CI) resistor r=0.8934 c=0
Rk21 (CI \15\:CI) resistor r=0.003053 c=0
Rk22 (\14\:CI \16\:CI) resistor r=0.04261 c=0
Rk10 (\17\:COb \19\:COb) resistor r=1.1276 c=0
Rk11 (\19\:COb \20\:COb) resistor r=0.2594 c=0
Rk13 (\21\:COb COb) resistor r=0.3988 c=0
Rk12 (\20\:COb \21\:COb) resistor r=0.8996 c=0
Rk15 (\20\:COb \25\:COb) resistor r=0.04927 c=0
Rk16 (\21\:COb \26\:COb) resistor r=0.949 c=0
Rk17 (\26\:COb \28\:COb) resistor r=0.3306 c=0
Rk18 (\26\:COb \30\:COb) resistor r=0.05759 c=0
Rk7 (\2\:n2 \4\:n2) resistor r=0.2822 c=0
Rk9 (\2\:n4 \4\:n4) resistor r=0.2822 c=0
Rk32 (Sb \17\:Sb) resistor r=0.1901 c=0
Rk33 (\17\:Sb \19\:Sb) resistor r=0.593 c=0
Rk34 (\19\:Sb \21\:Sb) resistor r=0.2807 c=0
Rk35 (\17\:Sb \23\:Sb) resistor r=0.7415 c=0
Rk36 (\23\:Sb \25\:Sb) resistor r=0.2136 c=0
Rk6 (\2\:n3 \4\:n3) resistor r=0.2734 c=0
Rk8 (\2\:n5 \4\:n5) resistor r=0.2822 c=0
Rl39 (\10\:A \11\:A) resistor r=108.384 c=0
Rl40 (\11\:A \12\:A) resistor r=44.9225 c=0
Rl29 (\7\:A \8\:A) resistor r=85.7713 c=0
Rl30 (\8\:A \9\:A) resistor r=62.6944 c=0
Rl22 (\5\:A \6\:A) resistor r=62.8119 c=0
Rl21 (\4\:A \5\:A) resistor r=82.2239 c=0
Rl11 (\1\:A \2\:A) resistor r=66.5405 c=0
Rl12 (\2\:A \3\:A) resistor r=24.2328 c=0
Rl37 (\12\:B \13\:B) resistor r=44.9225 c=0
Rl38 (\13\:B \14\:B) resistor r=108.384 c=0
Rl13 (\1\:B \2\:B) resistor r=29.5379 c=0
Rl14 (\2\:B \3\:B) resistor r=75.6918 c=0
Rl20 (\5\:B \7\:B) resistor r=45.0334 c=0
Rl18 (\4\:B \5\:B) resistor r=127.291 c=0
Rl19 (\5\:B \6\:B) resistor r=3.1183 c=0
Rl28 (\9\:B \11\:B) resistor r=34.3295 c=0
Rl27 (\9\:B \10\:B) resistor r=134.329 c=0
Rl26 (\8\:B \9\:B) resistor r=11.5001 c=0
Rl15 (\1\:CI \2\:CI) resistor r=99.2335 c=0
Rl16 (\2\:CI \3\:CI) resistor r=28.0797 c=0
Rl17 (\2\:CI \4\:CI) resistor r=132.351 c=0
Rl23 (\5\:CI \6\:CI) resistor r=134.329 c=0
Rl25 (\6\:CI \8\:CI) resistor r=34.3295 c=0
Rl24 (\6\:CI \7\:CI) resistor r=0.5166 c=0
Rl36 (\10\:CI \12\:CI) resistor r=134.297 c=0
Rl34 (\9\:CI \10\:CI) resistor r=48.0548 c=0
Rl35 (\10\:CI \11\:CI) resistor r=68.4415 c=0
Rl31 (\14\:COb \13\:COb) resistor r=28.0797 c=0
Rl32 (\14\:COb \15\:COb) resistor r=145.387 c=0
Rl33 (\14\:COb \16\:COb) resistor r=99.1945 c=0
Rz16 (\20\:VSS \19\:VSS) resistor r=75 c=0
Rz17 (\22\:VSS \21\:VSS) resistor r=75 c=0
Rz18 (\24\:VSS \23\:VSS) resistor r=75 c=0
Rz22 (\1\:VDD \3\:VDD) resistor r=18.75 c=0
Rz23 (\7\:VDD \3\:VDD) resistor r=6.25 c=0
Rz24 (\11\:VDD \3\:VDD) resistor r=6.25 c=0
Rz7 (\28\:COb \27\:COb) resistor r=75 c=0
Rz8 (\30\:COb \29\:COb) resistor r=75 c=0
Rz3 (n2 \2\:n2) resistor r=75 c=0
Rz4 (\3\:n2 \4\:n2) resistor r=75 c=0
Rz5 (n4 \2\:n4) resistor r=75 c=0
Rz6 (\3\:n4 \4\:n4) resistor r=75 c=0
Rz9 (\19\:Sb \18\:Sb) resistor r=75 c=0
Rz10 (\21\:Sb \20\:Sb) resistor r=75 c=0
Ry13 (\1\:VSS \3\:VSS) resistor r=15.5 c=0
Ry14 (\7\:VSS \3\:VSS) resistor r=5.1667 c=0
Ry15 (\11\:VSS \3\:VSS) resistor r=5.1667 c=0
Ry19 (\20\:VDD \19\:VDD) resistor r=62 c=0
Ry20 (\22\:VDD \21\:VDD) resistor r=62 c=0
Ry21 (\24\:VDD \23\:VDD) resistor r=62 c=0
Ry7 (\19\:COb \18\:COb) resistor r=62 c=0
Ry8 (\25\:COb \24\:COb) resistor r=20.6667 c=0
Ry9 (\23\:Sb \22\:Sb) resistor r=62 c=0
Ry10 (\25\:Sb \24\:Sb) resistor r=62 c=0
Ry3 (n3 \2\:n3) resistor r=62 c=0
Ry4 (\3\:n3 \4\:n3) resistor r=62 c=0
Ry5 (n5 \2\:n5) resistor r=62 c=0
Ry6 (\3\:n5 \4\:n5) resistor r=62 c=0
Rx11 (\11\:A \13\:A) resistor r=45 c=0
Rx12 (\8\:A \14\:A) resistor r=45 c=0
Rx13 (\5\:A \15\:A) resistor r=45 c=0
Rx14 (\2\:A \16\:A) resistor r=45 c=0
Rx7 (\13\:B \15\:B) resistor r=45 c=0
Rx8 (\8\:B \16\:B) resistor r=45 c=0
Rx9 (\6\:B \17\:B) resistor r=45 c=0
Rx10 (\2\:B \18\:B) resistor r=45 c=0
Rx4 (\11\:CI \13\:CI) resistor r=45 c=0
Rx5 (\4\:CI \15\:CI) resistor r=45 c=0
Rx6 (\7\:CI \16\:CI) resistor r=45 c=0
Rx1 (\17\:COb \16\:COb) resistor r=45 c=0
mn2 (\3\:n2 \3\:A \23\:VSS VSS) g45n1lvt w=(2.6e-07) l=4.5e-08 nf=1 \
        as=8.72e-14 ad=3.64e-14 ps=1.46e-06 pd=8e-07 nrd=1.16667 \
        nrs=1.16667 sa=1.4e-07 sb=6.1e-07 sd=160n sca=11.5806 \
        scb=0.0111274 scc=0.000535497 m=(1)
mn3 (n2 \3\:B \23\:VSS VSS) g45n1lvt w=(2.6e-07) l=4.5e-08 nf=1 \
        as=8.72e-14 ad=4.16e-14 ps=1.46e-06 pd=8.4e-07 nrd=1.16667 \
        nrs=1.16667 sa=4.05e-07 sb=3.45e-07 sd=160n sca=11.5806 \
        scb=0.0111274 scc=0.000535497 m=(1)
mn4 (\29\:COb \3\:CI n2 VSS) g45n1lvt w=(2.6e-07) l=4.5e-08 nf=1 \
        as=4.16e-14 ad=3.64e-14 ps=8.4e-07 pd=8e-07 nrd=1.16667 \
        nrs=1.16667 sa=6.1e-07 sb=1.4e-07 sd=160n sca=11.5806 \
        scb=0.0111274 scc=0.000535497 m=(1)
mn1 (\27\:COb \4\:B n0 VSS) g45n1lvt w=(2.6e-07) l=4.5e-08 nf=1 \
        as=1.56e-14 ad=3.64e-14 ps=6.4e-07 pd=8e-07 nrd=1.16667 \
        nrs=1.16667 sa=1.4e-07 sb=1.14e-06 sd=160n sca=7.84363 \
        scb=0.00546499 scc=9.84911e-05 m=(1)
mn0 (n0 \4\:A \21\:VSS VSS) g45n1lvt w=(2.6e-07) l=4.5e-08 nf=1 \
        as=4.16e-14 ad=1.56e-14 ps=8.4e-07 pd=6.4e-07 nrd=1.16667 \
        nrs=1.16667 sa=2.45e-07 sb=1.035e-06 sd=160n sca=7.84363 \
        scb=0.00546499 scc=9.84911e-05 m=(1)
mn7 (\3\:n4 \8\:CI \21\:VSS VSS) g45n1lvt w=(2.6e-07) l=4.5e-08 nf=1 \
        as=4.16e-14 ad=4.16e-14 ps=8.4e-07 pd=8.4e-07 nrd=1.16667 \
        nrs=1.16667 sa=4.5e-07 sb=8.3e-07 sd=160n sca=7.84363 \
        scb=0.00546499 scc=9.84911e-05 m=(1)
mn6 (\3\:n4 \10\:B \19\:VSS VSS) g45n1lvt w=(2.6e-07) l=4.5e-08 nf=1 \
        as=7.52e-14 ad=4.16e-14 ps=1.26e-06 pd=8.4e-07 nrd=1.16667 \
        nrs=1.16667 sa=6.55e-07 sb=6.25e-07 sd=160n sca=7.84363 \
        scb=0.00546499 scc=9.84911e-05 m=(1)
mn5 (n4 \9\:A \19\:VSS VSS) g45n1lvt w=(2.6e-07) l=4.5e-08 nf=1 \
        as=7.52e-14 ad=4.16e-14 ps=1.26e-06 pd=8.4e-07 nrd=1.16667 \
        nrs=1.16667 sa=9.2e-07 sb=3.6e-07 sd=160n sca=7.84363 \
        scb=0.00546499 scc=9.84911e-05 m=(1)
mn8 (\20\:Sb \15\:COb n4 VSS) g45n1lvt w=(2.6e-07) l=4.5e-08 nf=1 \
        as=4.16e-14 ad=4.03e-14 ps=8.4e-07 pd=8.3e-07 nrd=1.16667 \
        nrs=1.16667 sa=1.125e-06 sb=1.55e-07 sd=160n sca=7.84363 \
        scb=0.00546499 scc=9.84911e-05 m=(1)
mn11 (\18\:Sb \9\:CI n7 VSS) g45n1lvt w=(2.6e-07) l=4.5e-08 nf=1 \
        as=1.56e-14 ad=3.22e-14 ps=6.4e-07 pd=8e-07 nrd=1.16667 \
        nrs=1.16667 sa=1.23846e-07 sb=1.25e-06 sd=160n sca=9.14564 \
        scb=0.00759168 scc=0.000213449 m=(1)
mn10 (n7 \14\:B n6 VSS) g45n1lvt w=(2.6e-07) l=4.5e-08 nf=1 as=2.34e-14 \
        ad=1.56e-14 ps=7e-07 pd=6.4e-07 nrd=1.16667 nrs=1.16667 \
        sa=2.28846e-07 sb=1.145e-06 sd=160n sca=9.14564 scb=0.00759168 \
        scc=0.000213449 m=(1)
mn9 (n6 \12\:A \1\:VSS VSS) g45n1lvt w=(2.6e-07) l=4.5e-08 nf=1 \
        as=5.2e-14 ad=2.34e-14 ps=9.2e-07 pd=7e-07 nrd=1.16667 nrs=1.16667 \
        sa=3.63846e-07 sb=1.01e-06 sd=160n sca=9.14564 scb=0.00759168 \
        scc=0.000213449 m=(1)
mn13_1__rcx (\2\:S Sb \1\:VSS VSS) g45n1lvt w=(2.6e-07) l=4.5e-08 nf=1 \
        as=4.42e-14 ad=4.16e-14 ps=8.6e-07 pd=8.4e-07 nrd=1.16667 \
        nrs=1.16667 sa=6.08846e-07 sb=7.65e-07 sd=160n sca=9.14564 \
        scb=0.00759168 scc=0.000213449 m=(4)
mn12_1__rcx (\6\:CO COb \12\:VSS VSS) g45n1lvt w=(2.6e-07) l=4.5e-08 \
        nf=1 as=4.03e-14 ad=4.16e-14 ps=8.3e-07 pd=8.4e-07 nrd=1.16667 \
        nrs=1.16667 sa=1.4e-07 sb=7.65e-07 sd=160n sca=15.3338 \
        scb=0.0153436 scc=0.00119435 m=(4)
ends ADDFHX4
// End of subcircuit definition.
