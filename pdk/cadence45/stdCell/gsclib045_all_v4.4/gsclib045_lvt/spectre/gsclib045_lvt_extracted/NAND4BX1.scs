// Generated for: spectre (May  1 09:16:55 2013 )
// Library name: gsclib045_lvt
// Cell name: NAND4BX1
// View name: extracted

simulator lang=spectre

subckt NAND4BX1 AN B C D VDD VSS Y
mp4 (\4\:Y \3\:D \9\:VDD VDD) g45p1lvt w=(3.9e-07) l=4.5e-08 nf=1 \
        as=5.46e-14 ad=6.24e-14 ps=1.06e-06 pd=1.1e-06 nrd=1.16667 \
        nrs=1.16667 sa=1.4e-07 sb=9.05577e-07 sd=160n sca=18.7456 \
        scb=0.0202985 scc=0.000573036 m=(1)
mp3 (\4\:Y \1\:C \7\:VDD VDD) g45p1lvt w=(3.9e-07) l=4.5e-08 nf=1 \
        as=6.63e-14 ad=6.24e-14 ps=1.12e-06 pd=1.1e-06 nrd=1.16667 \
        nrs=1.16667 sa=3.45e-07 sb=7.00577e-07 sd=160n sca=13.8229 \
        scb=0.0117387 scc=0.000240879 m=(1)
mp2 (\1\:Y \1\:B \7\:VDD VDD) g45p1lvt w=(3.9e-07) l=4.5e-08 nf=1 \
        as=6.63e-14 ad=6.24e-14 ps=1.12e-06 pd=1.1e-06 nrd=1.16667 \
        nrs=1.16667 sa=5.6e-07 sb=4.85577e-07 sd=160n sca=12.9393 \
        scb=0.0102305 scc=0.000232248 m=(1)
mp1 (\1\:Y net118 \1\:VDD VDD) g45p1lvt w=(3.9e-07) l=4.5e-08 nf=1 \
        as=6.535e-14 ad=6.24e-14 ps=1.16e-06 pd=1.1e-06 nrd=1.16667 \
        nrs=1.16667 sa=7.65e-07 sb=2.80577e-07 sd=160n sca=13.8723 \
        scb=0.0118284 scc=0.000241736 m=(1)
C1 (B VSS) capacitor c=1.19711e-16
C2 (VDD VSS) capacitor c=1.07729e-16
C3 (C VSS) capacitor c=1.27829e-16
C4 (D VSS) capacitor c=1.31225e-16
C5 (AN VSS) capacitor c=7.62135e-17
C6 (Y VSS) capacitor c=7.81456e-17
C7 (net130 VSS) capacitor c=1.12121e-18
C8 (net126 VSS) capacitor c=4.06786e-18
C9 (net118 VSS) capacitor c=6.3095e-17
C10 (\1\:AN VSS) capacitor c=3.97615e-17
C11 (\1\:B VSS) capacitor c=5.51567e-17
C12 (\1\:C VSS) capacitor c=5.30129e-17
C13 (\3\:D VSS) capacitor c=4.19441e-17
C14 (\3\:AN VSS) capacitor c=3.39936e-17
C15 (\3\:net118 VSS) capacitor c=5.36452e-17
C16 (\3\:B VSS) capacitor c=5.22137e-17
C17 (\3\:C VSS) capacitor c=4.80064e-17
C18 (\1\:D VSS) capacitor c=4.27323e-17
C19 (\2\:AN VSS) capacitor c=4.11575e-17
C20 (\2\:net118 VSS) capacitor c=4.95466e-17
C21 (\2\:B VSS) capacitor c=4.9958e-17
C22 (\2\:C VSS) capacitor c=4.848e-17
C23 (\2\:D VSS) capacitor c=3.84165e-17
C24 (\4\:net118 VSS) capacitor c=5.64567e-17
C25 (\1\:VDD VSS) capacitor c=3.69396e-17
C26 (\1\:Y VSS) capacitor c=6.15461e-17
C27 (\7\:VDD VSS) capacitor c=4.15604e-17
C28 (\4\:Y VSS) capacitor c=3.17151e-17
C29 (\9\:VDD VSS) capacitor c=3.07872e-17
C30 (\6\:net118 VSS) capacitor c=6.31019e-17
C31 (\6\:Y VSS) capacitor c=6.20536e-17
C32 (\3\:Y VSS) capacitor c=6.02955e-17
C33 (\4\:AN VSS) capacitor c=3.2921e-17
C34 (\8\:net118 VSS) capacitor c=5.95336e-17
C35 (\4\:VDD VSS) capacitor c=1.96084e-17
C36 (\5\:VDD VSS) capacitor c=1.07291e-17
C37 (\6\:VDD VSS) capacitor c=1.0534e-17
Rk20 (\4\:VSS VSS) resistor r=0.3005 c=0
Rk19 (\2\:VSS \4\:VSS) resistor r=0.3945 c=0
Rk3 (B \4\:B) resistor r=0.002506 c=0
Rk13 (\2\:VDD \4\:VDD) resistor r=0.337 c=0
Rk14 (\4\:VDD \5\:VDD) resistor r=0.05243 c=0
Rk16 (\6\:VDD VDD) resistor r=0.04216 c=0
Rk15 (\5\:VDD \6\:VDD) resistor r=0.2051 c=0
Rk17 (\5\:VDD \8\:VDD) resistor r=0.1831 c=0
Rk18 (\6\:VDD \10\:VDD) resistor r=0.1776 c=0
Rk2 (C \4\:C) resistor r=0.002814 c=0
Rk1 (\4\:D D) resistor r=0.002995 c=0
Rk10 (\4\:AN AN) resistor r=0.02096 c=0
Rk5 (\3\:Y Y) resistor r=0.3173 c=0
Rk4 (\2\:Y \3\:Y) resistor r=0.3736 c=0
Rk6 (\3\:Y \5\:Y) resistor r=0.05755 c=0
Rk7 (Y \7\:Y) resistor r=0.4874 c=0
Rk11 (\5\:net118 \7\:net118) resistor r=0.4299 c=0
Rk12 (\7\:net118 \8\:net118) resistor r=0.2576 c=0
Rl5 (\1\:B \2\:B) resistor r=79.5379 c=0
Rl6 (\2\:B \3\:B) resistor r=67.9995 c=0
Rl3 (\1\:C \2\:C) resistor r=75.6918 c=0
Rl4 (\2\:C \3\:C) resistor r=71.8456 c=0
Rl2 (\2\:D \3\:D) resistor r=79.0354 c=0
Rl1 (\1\:D \2\:D) resistor r=69.2308 c=0
Rl9 (\1\:AN \2\:AN) resistor r=92.3077 c=0
Rl10 (\2\:AN \3\:AN) resistor r=57.1429 c=0
Rl7 (net118 \2\:net118) resistor r=103.378 c=0
Rl8 (\2\:net118 \3\:net118) resistor r=43.7671 c=0
Rz4 (\1\:VSS \2\:VSS) resistor r=75 c=0
Rz1 (\6\:Y \7\:Y) resistor r=75 c=0
Rz2 (\6\:net118 \7\:net118) resistor r=75 c=0
Ry4 (\1\:VDD \2\:VDD) resistor r=62 c=0
Ry5 (\7\:VDD \8\:VDD) resistor r=62 c=0
Ry6 (\9\:VDD \10\:VDD) resistor r=62 c=0
Ry1 (\1\:Y \2\:Y) resistor r=31 c=0
Ry2 (\4\:Y \5\:Y) resistor r=31 c=0
Ry3 (\4\:net118 \5\:net118) resistor r=62 c=0
Rx3 (\2\:B \4\:B) resistor r=45 c=0
Rx2 (\2\:C \4\:C) resistor r=45 c=0
Rx1 (\2\:D \4\:D) resistor r=45 c=0
Rx4 (\2\:AN \4\:AN) resistor r=45 c=0
Rx5 (\2\:net118 \8\:net118) resistor r=45 c=0
mn4 (\6\:Y \1\:D net130 VSS) g45n1lvt w=(2.6e-07) l=4.5e-08 nf=1 \
        as=2.86e-14 ad=3.64e-14 ps=7.4e-07 pd=8e-07 nrd=1.16667 \
        nrs=1.16667 sa=1.4e-07 sb=7.71058e-07 sd=160n sca=15.3338 \
        scb=0.0153436 scc=0.00119435 m=(1)
mn3 (net130 \3\:C net126 VSS) g45n1lvt w=(2.6e-07) l=4.5e-08 nf=1 \
        as=4.42e-14 ad=2.86e-14 ps=8.6e-07 pd=7.4e-07 nrd=1.16667 \
        nrs=1.16667 sa=2.95e-07 sb=6.16058e-07 sd=160n sca=15.3338 \
        scb=0.0153436 scc=0.00119435 m=(1)
mn2 (net126 \3\:B net122 VSS) g45n1lvt w=(2.6e-07) l=4.5e-08 nf=1 \
        as=2.21e-14 ad=4.42e-14 ps=6.9e-07 pd=8.6e-07 nrd=1.16667 \
        nrs=1.16667 sa=5.1e-07 sb=4.01058e-07 sd=160n sca=15.3338 \
        scb=0.0153436 scc=0.00119435 m=(1)
mn1 (net122 \3\:net118 \1\:VSS VSS) g45n1lvt w=(2.6e-07) l=4.5e-08 nf=1 \
        as=4.365e-14 ad=2.21e-14 ps=9e-07 pd=6.9e-07 nrd=1.16667 \
        nrs=1.16667 sa=6.4e-07 sb=2.71058e-07 sd=160n sca=15.3338 \
        scb=0.0153436 scc=0.00119435 m=(1)
mn0 (\6\:net118 \3\:AN \1\:VSS VSS) g45n1lvt w=(1.45e-07) l=4.5e-08 nf=1 \
        as=4.365e-14 ad=2.03e-14 ps=9e-07 pd=5.7e-07 nrd=1.16667 \
        nrs=1.16667 sa=8.75e-07 sb=1.4e-07 sd=160n sca=19.8813 \
        scb=0.0206549 scc=0.00197265 m=(1)
mp0 (\4\:net118 \1\:AN \1\:VDD VDD) g45p1lvt w=(2.15e-07) l=4.5e-08 nf=1 \
        as=6.535e-14 ad=3.44e-14 ps=1.16e-06 pd=7.5e-07 nrd=1.16667 \
        nrs=1.16667 sa=1e-06 sb=1.6e-07 sd=160n sca=21.4608 scb=0.0245314 \
        scc=0.000949294 m=(1)
ends NAND4BX1
// End of subcircuit definition.
