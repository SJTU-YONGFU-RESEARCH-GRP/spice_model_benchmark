// Generated for: spectre (May  1 09:13:10 2013 )
// Library name: gsclib045_lvt
// Cell name: CLKMX2X3
// View name: extracted

simulator lang=spectre

subckt CLKMX2X3 A B S0 VDD VSS Y
mp0 (\8\:S0b \1\:S0 \10\:VDD VDD) g45p1lvt w=(2.15e-07) l=4.5e-08 nf=1 \
        as=1.1695e-13 ad=4.837e-14 ps=1.64e-06 pd=8.8e-07 nrd=1.16667 \
        nrs=1.16667 sa=2.25e-07 sb=1.9e-06 sd=160n sca=26.5704 \
        scb=0.0277882 scc=0.00223218 m=(1)
C1 (A VSS) capacitor c=1.27158e-16
C2 (Y VSS) capacitor c=2.0593e-17
C3 (VDD VSS) capacitor c=1.26258e-16
C4 (S0b VSS) capacitor c=6.98721e-17
C5 (n0 VSS) capacitor c=2.27031e-16
C6 (net140 VSS) capacitor c=9.82845e-18
C7 (net123 VSS) capacitor c=4.6781e-18
C8 (net115 VSS) capacitor c=4.39319e-18
C9 (\4\:B VSS) capacitor c=4.6208e-17
C10 (\3\:S0b VSS) capacitor c=5.02267e-17
C11 (\7\:S0 VSS) capacitor c=4.69184e-17
C12 (\1\:A VSS) capacitor c=5.73292e-17
C13 (\1\:S0 VSS) capacitor c=2.41403e-17
C14 (\3\:B VSS) capacitor c=4.66115e-17
C15 (\4\:S0 VSS) capacitor c=5.90533e-17
C16 (\3\:A VSS) capacitor c=7.25038e-17
C17 (\3\:S0 VSS) capacitor c=3.27893e-17
C18 (\1\:B VSS) capacitor c=2.45845e-17
C19 (\4\:S0b VSS) capacitor c=3.64091e-17
C20 (\6\:S0 VSS) capacitor c=5.52903e-17
C21 (\2\:S0b VSS) capacitor c=4.3976e-17
C22 (\2\:A VSS) capacitor c=4.96406e-17
C23 (\2\:S0 VSS) capacitor c=2.73216e-17
C24 (\1\:Y VSS) capacitor c=1.52576e-16
C25 (\1\:VDD VSS) capacitor c=1.56739e-16
C26 (\14\:n0 VSS) capacitor c=9.89126e-17
C27 (\10\:VDD VSS) capacitor c=5.00951e-17
C28 (\8\:S0b VSS) capacitor c=5.56441e-17
C29 (\12\:n0 VSS) capacitor c=5.77752e-17
C30 (\10\:S0b VSS) capacitor c=1.83759e-17
C31 (\2\:B VSS) capacitor c=2.74855e-17
C32 (\8\:S0 VSS) capacitor c=1.31401e-16
C33 (\9\:S0 VSS) capacitor c=1.13866e-16
C34 (\5\:S0b VSS) capacitor c=7.42628e-17
C35 (\6\:S0b VSS) capacitor c=9.31933e-17
C36 (\7\:S0b VSS) capacitor c=8.27887e-17
C37 (\5\:B VSS) capacitor c=1.22253e-16
C38 (\10\:n0 VSS) capacitor c=4.07464e-17
C39 (\11\:n0 VSS) capacitor c=9.68201e-17
C40 (\4\:Y VSS) capacitor c=6.43327e-17
C41 (\5\:VDD VSS) capacitor c=1.75903e-17
C42 (\6\:VDD VSS) capacitor c=1.22762e-17
Rk2 (\8\:S0 S0) resistor r=0.8194 c=0
Rk3 (S0 \9\:S0) resistor r=0.002989 c=0
Rk26 (\1\:VSS \5\:VSS) resistor r=0.1525 c=0
Rk28 (\6\:VSS VSS) resistor r=0.1422 c=0
Rk27 (\5\:VSS \6\:VSS) resistor r=0.4077 c=0
Rk30 (\6\:VSS \10\:VSS) resistor r=0.294 c=0
Rk13 (\1\:Y Y) resistor r=0.01846 c=0
Rk14 (Y \4\:Y) resistor r=0.2044 c=0
Rk19 (\1\:VDD \5\:VDD) resistor r=0.1525 c=0
Rk21 (\6\:VDD VDD) resistor r=0.2898 c=0
Rk20 (\5\:VDD \6\:VDD) resistor r=0.2601 c=0
Rk24 (\6\:VDD \11\:VDD) resistor r=0.2439 c=0
Rk8 (B \5\:B) resistor r=0.004698 c=0
Rk4 (\5\:S0b \6\:S0b) resistor r=0.34 c=0
Rk5 (\6\:S0b \7\:S0b) resistor r=0.5036 c=0
Rk6 (\7\:S0b \9\:S0b) resistor r=0.3484 c=0
Rk7 (\7\:S0b \11\:S0b) resistor r=0.0962 c=0
Rk9 (\10\:n0 \11\:n0) resistor r=0.2249 c=0
Rk10 (\11\:n0 \13\:n0) resistor r=0.3794 c=0
Rk11 (\11\:n0 \15\:n0) resistor r=0.5369 c=0
Rl1 (\1\:S0 \2\:S0) resistor r=36.5385 c=0
Rl2 (\2\:S0 \3\:S0) resistor r=101.099 c=0
Rl8 (\5\:S0 \7\:S0) resistor r=69.3988 c=0
Rl6 (\4\:S0 \5\:S0) resistor r=143.857 c=0
Rl7 (\5\:S0 \6\:S0) resistor r=1.2666 c=0
Rl3 (\1\:A \2\:A) resistor r=65.3618 c=0
Rl4 (\2\:A \3\:A) resistor r=82.4874 c=0
Rl12 (\2\:B \4\:B) resistor r=34.3295 c=0
Rl11 (\2\:B \3\:B) resistor r=117.022 c=0
Rl10 (\1\:B \2\:B) resistor r=2.0213 c=0
Rl9 (\3\:S0b \4\:S0b) resistor r=51.3412 c=0
Rl5 (S0b \2\:S0b) resistor r=24.2328 c=0
Rz8 (\10\:VSS \9\:VSS) resistor r=75 c=0
Rz1 (\10\:S0b \11\:S0b) resistor r=75 c=0
Rz2 (\13\:n0 \12\:n0) resistor r=75 c=0
Ry8 (\11\:VDD \10\:VDD) resistor r=62 c=0
Ry1 (\8\:S0b \9\:S0b) resistor r=62 c=0
Ry2 (\15\:n0 \14\:n0) resistor r=20.6667 c=0
Rx2 (\6\:S0 \8\:S0) resistor r=45 c=0
Rx3 (\2\:S0 \9\:S0) resistor r=45 c=0
Rx1 (\2\:A A) resistor r=45 c=0
Rx6 (\1\:B \5\:B) resistor r=45 c=0
Rx4 (\4\:S0b \5\:S0b) resistor r=45 c=0
Rx5 (\2\:S0b \6\:S0b) resistor r=45 c=0
Rx7 (\10\:n0 n0) resistor r=45 c=0
mn0 (\10\:S0b \3\:S0 \9\:VSS VSS) g45n1lvt w=(1.45e-07) l=4.5e-08 nf=1 \
        as=6.95e-14 ad=2.03e-14 ps=1.32e-06 pd=5.7e-07 nrd=1.16667 \
        nrs=1.16667 sa=1.4e-07 sb=1.955e-06 sd=160n sca=11.9911 \
        scb=0.0120555 scc=0.000498628 m=(1)
mn1 (net148 \3\:A \9\:VSS VSS) g45n1lvt w=(2.6e-07) l=4.5e-08 nf=1 \
        as=6.95e-14 ad=1.56e-14 ps=1.32e-06 pd=6.4e-07 nrd=1.16667 \
        nrs=1.16667 sa=3.70481e-07 sb=1.51e-06 sd=160n sca=10.104 \
        scb=0.00906063 scc=0.000325539 m=(1)
mn2 (\12\:n0 S0b net148 VSS) g45n1lvt w=(2.6e-07) l=4.5e-08 nf=1 \
        as=1.56e-14 ad=4.16e-14 ps=6.4e-07 pd=8.4e-07 nrd=1.16667 \
        nrs=1.16667 sa=4.75481e-07 sb=1.405e-06 sd=160n sca=10.104 \
        scb=0.00906063 scc=0.000325539 m=(1)
mn4 (\12\:n0 \4\:S0 net140 VSS) g45n1lvt w=(2.6e-07) l=4.5e-08 nf=1 \
        as=8.32e-14 ad=4.16e-14 ps=1.16e-06 pd=8.4e-07 nrd=1.16667 \
        nrs=1.16667 sa=6.80481e-07 sb=1.2e-06 sd=160n sca=10.104 \
        scb=0.00906063 scc=0.000325539 m=(1)
mn3 (net140 \3\:B \1\:VSS VSS) g45n1lvt w=(2.6e-07) l=4.5e-08 nf=1 \
        as=4.16e-14 ad=8.32e-14 ps=8.4e-07 pd=1.16e-06 nrd=1.16667 \
        nrs=1.16667 sa=1.04548e-06 sb=8.35e-07 sd=160n sca=10.104 \
        scb=0.00906063 scc=0.000325539 m=(1)
mn5_1__rcx (\4\:Y n0 \1\:VSS VSS) g45n1lvt w=(2.6e-07) l=4.5e-08 nf=1 \
        as=4.16e-14 ad=5.373e-14 ps=8.4e-07 pd=9.3333e-07 nrd=1.16667 \
        nrs=1.16667 sa=1.25048e-06 sb=6.3e-07 sd=160n sca=10.104 \
        scb=0.00906063 scc=0.000325539 m=(3)
mp1 (net123 \1\:A \10\:VDD VDD) g45p1lvt w=(3.9e-07) l=4.5e-08 nf=1 \
        as=1.1695e-13 ad=5.265e-14 ps=1.64e-06 pd=1.05e-06 nrd=1.16667 \
        nrs=1.16667 sa=4.48718e-07 sb=1.425e-06 sd=160n sca=16.6245 \
        scb=0.014685 scc=0.00118863 m=(1)
mp2 (\14\:n0 \7\:S0 net123 VDD) g45p1lvt w=(3.9e-07) l=4.5e-08 nf=1 \
        as=5.265e-14 ad=6.24e-14 ps=1.05e-06 pd=1.1e-06 nrd=1.16667 \
        nrs=1.16667 sa=6.28718e-07 sb=1.245e-06 sd=160n sca=16.2669 \
        scb=0.0145797 scc=0.00118861 m=(1)
mp4 (\14\:n0 \3\:S0b net115 VDD) g45p1lvt w=(3.9e-07) l=4.5e-08 nf=1 \
        as=6.24e-14 ad=6.24e-14 ps=1.1e-06 pd=1.1e-06 nrd=1.16667 \
        nrs=1.16667 sa=8.33718e-07 sb=1.04e-06 sd=160n sca=16.2669 \
        scb=0.0145797 scc=0.00118861 m=(1)
mp3 (net115 \4\:B \1\:VDD VDD) g45p1lvt w=(3.9e-07) l=4.5e-08 nf=1 \
        as=6.24e-14 ad=6.24e-14 ps=1.1e-06 pd=1.1e-06 nrd=1.16667 \
        nrs=1.16667 sa=1.03872e-06 sb=8.35e-07 sd=160n sca=16.2669 \
        scb=0.0145797 scc=0.00118861 m=(1)
mp5_1__rcx (\1\:Y n0 \1\:VDD VDD) g45p1lvt w=(3.9e-07) l=4.5e-08 nf=1 \
        as=6.24e-14 ad=8.06e-14 ps=1.1e-06 pd=1.19333e-06 nrd=1.16667 \
        nrs=1.16667 sa=1.24372e-06 sb=6.3e-07 sd=160n sca=16.6869 \
        scb=0.0147126 scc=0.00118865 m=(3)
ends CLKMX2X3
// End of subcircuit definition.
