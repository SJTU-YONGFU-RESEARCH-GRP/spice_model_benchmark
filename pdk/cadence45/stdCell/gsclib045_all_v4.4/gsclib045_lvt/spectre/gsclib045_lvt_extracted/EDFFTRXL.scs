// Generated for: spectre (May  1 09:14:24 2013 )
// Library name: gsclib045_lvt
// Cell name: EDFFTRXL
// View name: extracted

simulator lang=spectre

subckt EDFFTRXL CK D E Q QN RN VDD VSS
mp57 (\1\:QN \4\:qint \21\:VDD VDD) g45p1lvt w=(2.15e-07) l=4.5e-08 nf=1 \
        as=5.515e-14 ad=3.762e-14 ps=1.45e-06 pd=7.8e-07 nrd=1.16667 \
        nrs=1.16667 sa=1.75e-07 sb=3.35e-07 sd=160n sca=49.7297 \
        scb=0.0332192 scc=0.00593869 m=(1)
mp56 (\5\:qint \7\:qbint \21\:VDD VDD) g45p1lvt w=(2.15e-07) l=4.5e-08 \
        nf=1 as=5.515e-14 ad=3.01e-14 ps=1.45e-06 pd=7.1e-07 nrd=1.16667 \
        nrs=1.16667 sa=3.7e-07 sb=1.4e-07 sd=160n sca=47.2218 \
        scb=0.0292973 scc=0.00588575 m=(1)
mp55 (\3\:Q \5\:qbint \18\:VDD VDD) g45p1lvt w=(2.15e-07) l=4.5e-08 nf=1 \
        as=5.805e-14 ad=3.01e-14 ps=1.51e-06 pd=7.1e-07 nrd=1.16667 \
        nrs=1.16667 sa=1.4e-07 sb=3.4e-07 sd=160n sca=45.7906 \
        scb=0.0283307 scc=0.00588417 m=(1)
mp20 (\22\:CKb \1\:CK \18\:VDD VDD) g45p1lvt w=(2.15e-07) l=4.5e-08 nf=1 \
        as=5.805e-14 ad=3.117e-14 ps=1.51e-06 pd=7.2e-07 nrd=1.16667 \
        nrs=1.16667 sa=3.35e-07 sb=1.45e-07 sd=160n sca=45.7906 \
        scb=0.0283307 scc=0.00588417 m=(1)
mp45 (\17\:qbint n30 \15\:VDD VDD) g45p1lvt w=(2.15e-07) l=4.5e-08 nf=1 \
        as=4.3e-14 ad=3.87e-14 ps=8.3e-07 pd=7.9e-07 nrd=1.16667 \
        nrs=1.16667 sa=1.8e-07 sb=2e-06 sd=160n sca=15.2551 scb=0.0150251 \
        scc=0.000885438 m=(1)
mp50 (net411 \9\:qbint \15\:VDD VDD) g45p1lvt w=(2.15e-07) l=4.5e-08 \
        nf=1 as=4.3e-14 ad=1.29e-14 ps=8.3e-07 pd=5.5e-07 nrd=1.16667 \
        nrs=1.16667 sa=4.25e-07 sb=1.975e-06 sd=160n sca=15.2551 \
        scb=0.0150251 scc=0.000885438 m=(1)
mp51 (\4\:n30 \5\:CKbb net411 VDD) g45p1lvt w=(2.15e-07) l=4.5e-08 nf=1 \
        as=1.29e-14 ad=3.87e-14 ps=5.5e-07 pd=7.9e-07 nrd=1.16667 \
        nrs=1.16667 sa=5.3e-07 sb=1.87e-06 sd=160n sca=15.2551 \
        scb=0.0150251 scc=0.000885438 m=(1)
mp40 (\4\:n30 \3\:CKb \7\:mout VDD) g45p1lvt w=(2.15e-07) l=4.5e-08 nf=1 \
        as=6.558e-14 ad=3.87e-14 ps=1.04e-06 pd=7.9e-07 nrd=1.16667 \
        nrs=1.16667 sa=7.55e-07 sb=1.645e-06 sd=160n sca=15.2551 \
        scb=0.0150251 scc=0.000885438 m=(1)
mp30 (\7\:mout n20 \12\:VDD VDD) g45p1lvt w=(2.15e-07) l=4.5e-08 nf=1 \
        as=9.35e-14 ad=6.558e-14 ps=1.64e-06 pd=1.04e-06 nrd=1.16667 \
        nrs=1.16667 sa=1.105e-06 sb=1.295e-06 sd=160n sca=15.2551 \
        scb=0.0150251 scc=0.000885438 m=(1)
mp35 (net427 \4\:mout \12\:VDD VDD) g45p1lvt w=(2.15e-07) l=4.5e-08 nf=1 \
        as=9.35e-14 ad=1.29e-14 ps=1.64e-06 pd=5.5e-07 nrd=1.16667 \
        nrs=1.16667 sa=1.37e-06 sb=1.03e-06 sd=160n sca=15.2551 \
        scb=0.0150251 scc=0.000885438 m=(1)
mp36 (\6\:n20 \5\:CKb net427 VDD) g45p1lvt w=(2.15e-07) l=4.5e-08 nf=1 \
        as=1.29e-14 ad=6.342e-14 ps=5.5e-07 pd=1.02e-06 nrd=1.16667 \
        nrs=1.16667 sa=1.475e-06 sb=9.25e-07 sd=160n sca=15.2551 \
        scb=0.0150251 scc=0.000885438 m=(1)
mp26 (\6\:n20 CKbb n22 VDD) g45p1lvt w=(2.15e-07) l=4.5e-08 nf=1 \
        as=2.902e-14 ad=6.342e-14 ps=7e-07 pd=1.02e-06 nrd=1.16667 \
        nrs=1.16667 sa=1.815e-06 sb=5.85e-07 sd=160n sca=15.2551 \
        scb=0.0150251 scc=0.000885438 m=(1)
mp25 (n22 \3\:Dp \9\:VDD VDD) g45p1lvt w=(2.15e-07) l=4.5e-08 nf=1 \
        as=9.35e-14 ad=2.902e-14 ps=1.64e-06 pd=7e-07 nrd=1.16667 \
        nrs=1.16667 sa=1.995e-06 sb=4.05e-07 sd=160n sca=15.2551 \
        scb=0.0150251 scc=0.000885438 m=(1)
mp21 (\6\:CKbb \9\:CKb \9\:VDD VDD) g45p1lvt w=(2.15e-07) l=4.5e-08 nf=1 \
        as=9.35e-14 ad=3.01e-14 ps=1.64e-06 pd=7.1e-07 nrd=1.16667 \
        nrs=1.16667 sa=2e-06 sb=1.4e-07 sd=160n sca=15.2551 scb=0.0150251 \
        scc=0.000885438 m=(1)
mp2 (\6\:RNb \1\:RN \7\:VDD VDD) g45p1lvt w=(2.15e-07) l=4.5e-08 nf=1 \
        as=7.638e-14 ad=4.085e-14 ps=1.87e-06 pd=8.1e-07 nrd=1.16667 \
        nrs=1.16667 sa=1.9e-07 sb=8.1e-07 sd=160n sca=20.4333 \
        scb=0.0198015 scc=0.00193653 m=(1)
mp3 (\3\:n2 \3\:RNb \7\:VDD VDD) g45p1lvt w=(2.15e-07) l=4.5e-08 nf=1 \
        as=7.638e-14 ad=3.44e-14 ps=1.87e-06 pd=7.5e-07 nrd=1.16667 \
        nrs=1.16667 sa=4.5e-07 sb=5.5e-07 sd=160n sca=20.4333 \
        scb=0.0198015 scc=0.00193653 m=(1)
mp5 (n3 \12\:qbint \3\:n2 VDD) g45p1lvt w=(2.15e-07) l=4.5e-08 nf=1 \
        as=3.44e-14 ad=3.44e-14 ps=7.5e-07 pd=7.5e-07 nrd=1.16667 \
        nrs=1.16667 sa=6.55e-07 sb=3.45e-07 sd=160n sca=20.4333 \
        scb=0.0198015 scc=0.00193653 m=(1)
mp4 (n3 Eb n2 VDD) g45p1lvt w=(2.15e-07) l=4.5e-08 nf=1 as=3.01e-14 \
        ad=3.44e-14 ps=7.1e-07 pd=7.5e-07 nrd=1.16667 nrs=1.16667 \
        sa=8.6e-07 sb=1.4e-07 sd=160n sca=20.4333 scb=0.0198015 \
        scc=0.00193653 m=(1)
mp6 (\11\:Dp \3\:E \3\:n3 VDD) g45p1lvt w=(2.15e-07) l=4.5e-08 nf=1 \
        as=3.548e-14 ad=3.01e-14 ps=7.6e-07 pd=7.1e-07 nrd=1.16667 \
        nrs=1.16667 sa=1.4e-07 sb=3.6e-07 sd=160n sca=20.4333 \
        scb=0.0198015 scc=0.00193653 m=(1)
mp7 (\13\:Dp Db \3\:n3 VDD) g45p1lvt w=(2.15e-07) l=4.5e-08 nf=1 \
        as=3.548e-14 ad=3.225e-14 ps=7.6e-07 pd=7.3e-07 nrd=1.16667 \
        nrs=1.16667 sa=3.5e-07 sb=1.5e-07 sd=160n sca=20.4333 \
        scb=0.0198015 scc=0.00193653 m=(1)
mp0 (\4\:Eb \4\:E \1\:VDD VDD) g45p1lvt w=(2.15e-07) l=4.5e-08 nf=1 \
        as=9.23e-14 ad=3.01e-14 ps=1.62e-06 pd=7.1e-07 nrd=1.16667 \
        nrs=1.16667 sa=1.4e-07 sb=4.05e-07 sd=160n sca=47.1147 \
        scb=0.0291776 scc=0.00588536 m=(1)
mp1 (\4\:Db \1\:D \1\:VDD VDD) g45p1lvt w=(2.15e-07) l=4.5e-08 nf=1 \
        as=9.23e-14 ad=3.01e-14 ps=1.62e-06 pd=7.1e-07 nrd=1.16667 \
        nrs=1.16667 sa=4.05e-07 sb=1.4e-07 sd=160n sca=51.1829 \
        scb=0.0357894 scc=0.00602791 m=(1)
C1 (D VSS) capacitor c=5.99379e-17
C2 (QN VSS) capacitor c=2.11747e-17
C3 (CK VSS) capacitor c=4.9175e-17
C4 (E VSS) capacitor c=2.25194e-17
C5 (VDD VSS) capacitor c=4.2366e-16
C6 (RN VSS) capacitor c=5.94607e-17
C7 (Q VSS) capacitor c=3.41818e-17
C8 (qint VSS) capacitor c=1.99277e-17
C9 (qbint VSS) capacitor c=2.59914e-17
C10 (CKb VSS) capacitor c=7.86065e-17
C11 (n30 VSS) capacitor c=4.11133e-17
C12 (mout VSS) capacitor c=5.34747e-17
C13 (CKbb VSS) capacitor c=3.18728e-17
C14 (n20 VSS) capacitor c=3.08015e-17
C15 (net516 VSS) capacitor c=5.49529e-19
C16 (Dp VSS) capacitor c=3.37706e-17
C17 (RNb VSS) capacitor c=3.56371e-17
C18 (n0 VSS) capacitor c=1.31823e-18
C19 (Eb VSS) capacitor c=4.94482e-17
C20 (n1 VSS) capacitor c=1.36217e-18
C21 (Db VSS) capacitor c=6.09555e-17
C22 (net411 VSS) capacitor c=2.30706e-18
C23 (net427 VSS) capacitor c=9.1065e-19
C24 (n2 VSS) capacitor c=8.75512e-17
C25 (n3 VSS) capacitor c=8.31943e-17
C26 (\1\:D VSS) capacitor c=2.88716e-17
C27 (\4\:E VSS) capacitor c=3.82554e-17
C28 (\3\:E VSS) capacitor c=4.02709e-17
C29 (\12\:qbint VSS) capacitor c=5.57319e-17
C30 (\3\:RNb VSS) capacitor c=5.55509e-17
C31 (\1\:RN VSS) capacitor c=3.47521e-17
C32 (\9\:CKb VSS) capacitor c=4.86142e-17
C33 (\3\:Dp VSS) capacitor c=7.85875e-17
C34 (\5\:CKb VSS) capacitor c=6.32232e-17
C35 (\4\:mout VSS) capacitor c=7.4386e-17
C36 (\3\:CKb VSS) capacitor c=3.91677e-17
C37 (\5\:CKbb VSS) capacitor c=9.8771e-17
C38 (\9\:qbint VSS) capacitor c=6.28842e-17
C39 (\1\:CK VSS) capacitor c=4.21284e-17
C40 (\5\:qbint VSS) capacitor c=2.39768e-17
C41 (\7\:qbint VSS) capacitor c=3.59089e-17
C42 (\4\:qint VSS) capacitor c=3.79462e-17
C43 (\4\:D VSS) capacitor c=2.7304e-17
C44 (\7\:E VSS) capacitor c=2.64686e-17
C45 (\2\:Db VSS) capacitor c=8.36855e-17
C46 (\1\:E VSS) capacitor c=6.86908e-17
C47 (\3\:Eb VSS) capacitor c=4.78378e-17
C48 (\11\:qbint VSS) capacitor c=1.06129e-16
C49 (\3\:RN VSS) capacitor c=3.66225e-17
C50 (\11\:CKb VSS) capacitor c=3.42002e-17
C51 (\2\:Dp VSS) capacitor c=5.55903e-17
C52 (\7\:CKb VSS) capacitor c=5.25719e-17
C53 (\3\:CKbb VSS) capacitor c=1.12448e-16
C54 (\3\:n20 VSS) capacitor c=4.47093e-17
C55 (\4\:CKbb VSS) capacitor c=1.07223e-16
C56 (\8\:qbint VSS) capacitor c=8.02733e-17
C57 (\3\:n30 VSS) capacitor c=3.49951e-17
C58 (\4\:CK VSS) capacitor c=2.89943e-17
C59 (\4\:qbint VSS) capacitor c=2.68202e-17
C60 (\3\:qint VSS) capacitor c=3.10119e-17
C61 (\3\:D VSS) capacitor c=2.70618e-17
C62 (\6\:E VSS) capacitor c=2.96512e-17
C63 (\3\:Db VSS) capacitor c=2.08189e-17
C64 (\2\:E VSS) capacitor c=7.03827e-17
C65 (\2\:Eb VSS) capacitor c=4.53359e-17
C66 (\13\:qbint VSS) capacitor c=3.11218e-17
C67 (\2\:RNb VSS) capacitor c=6.13286e-17
C68 (\2\:RN VSS) capacitor c=3.68349e-17
C69 (\10\:CKb VSS) capacitor c=3.49195e-17
C70 (\8\:CKb VSS) capacitor c=5.20647e-17
C71 (\2\:CKbb VSS) capacitor c=7.33439e-17
C72 (\6\:CKb VSS) capacitor c=4.77335e-17
C73 (\3\:mout VSS) capacitor c=1.84463e-17
C74 (\2\:n20 VSS) capacitor c=3.48598e-17
C75 (\4\:CKb VSS) capacitor c=3.74112e-17
C76 (\2\:CKb VSS) capacitor c=3.33242e-17
C77 (\10\:qbint VSS) capacitor c=3.2609e-17
C78 (\2\:n30 VSS) capacitor c=3.11272e-17
C79 (\3\:CK VSS) capacitor c=3.27109e-17
C80 (\6\:qbint VSS) capacitor c=1.75412e-17
C81 (\4\:Db VSS) capacitor c=1.12604e-16
C82 (\1\:VDD VSS) capacitor c=3.67483e-17
C83 (\4\:Eb VSS) capacitor c=5.45156e-17
C84 (\13\:Dp VSS) capacitor c=8.10531e-17
C85 (\3\:n3 VSS) capacitor c=7.91054e-17
C86 (\11\:Dp VSS) capacitor c=2.87588e-17
C87 (\3\:n2 VSS) capacitor c=7.56859e-17
C88 (\7\:VDD VSS) capacitor c=1.4978e-17
C89 (\6\:RNb VSS) capacitor c=4.45852e-17
C90 (\6\:CKbb VSS) capacitor c=3.36334e-17
C91 (\9\:VDD VSS) capacitor c=1.71702e-17
C92 (\6\:n20 VSS) capacitor c=8.67237e-17
C93 (\12\:VDD VSS) capacitor c=1.71406e-17
C94 (\7\:mout VSS) capacitor c=4.97728e-17
C95 (\4\:n30 VSS) capacitor c=5.23474e-17
C96 (\15\:VDD VSS) capacitor c=7.21225e-17
C97 (\17\:qbint VSS) capacitor c=4.36425e-17
C98 (\22\:CKb VSS) capacitor c=6.29044e-17
C99 (\18\:VDD VSS) capacitor c=1.95968e-17
C100 (\3\:Q VSS) capacitor c=5.17014e-17
C101 (\5\:qint VSS) capacitor c=2.28015e-17
C102 (\21\:VDD VSS) capacitor c=5.29173e-18
C103 (\1\:QN VSS) capacitor c=1.57713e-17
C104 (\3\:VDD VSS) capacitor c=1.02175e-16
C105 (\7\:Db VSS) capacitor c=3.15762e-17
C106 (\6\:Eb VSS) capacitor c=1.2372e-16
C107 (\4\:Dp VSS) capacitor c=1.14397e-16
C108 (\6\:Dp VSS) capacitor c=9.39935e-17
C109 (\8\:RNb VSS) capacitor c=4.85908e-17
C110 (\10\:CKbb VSS) capacitor c=4.61633e-17
C111 (\4\:n20 VSS) capacitor c=8.41906e-17
C112 (\9\:mout VSS) capacitor c=4.40442e-17
C113 (\8\:n30 VSS) capacitor c=3.60315e-17
C114 (\21\:qbint VSS) capacitor c=5.03417e-17
C115 (\17\:CKb VSS) capacitor c=1.0264e-16
C116 (\1\:Q VSS) capacitor c=3.24295e-17
C117 (\9\:qint VSS) capacitor c=2.54322e-17
C118 (\3\:QN VSS) capacitor c=3.37505e-17
C119 (\2\:qint VSS) capacitor c=1.25457e-17
C120 (\2\:qbint VSS) capacitor c=3.05967e-17
C121 (\3\:qbint VSS) capacitor c=3.71043e-17
C122 (\2\:mout VSS) capacitor c=4.0254e-17
C123 (\7\:qint VSS) capacitor c=2.72793e-17
C124 (\8\:qint VSS) capacitor c=2.85445e-17
C125 (\5\:CK VSS) capacitor c=8.61213e-17
C126 (\5\:E VSS) capacitor c=2.12177e-17
C127 (\6\:n30 VSS) capacitor c=5.14445e-17
C128 (\7\:n30 VSS) capacitor c=5.3896e-17
C129 (\5\:mout VSS) capacitor c=6.20765e-17
C130 (\6\:mout VSS) capacitor c=5.59206e-17
C131 (\8\:n20 VSS) capacitor c=8.23113e-17
C132 (\12\:CKb VSS) capacitor c=4.55626e-17
C133 (\13\:CKb VSS) capacitor c=1.0637e-16
C134 (\14\:CKb VSS) capacitor c=1.51247e-16
C135 (\15\:CKb VSS) capacitor c=9.92545e-17
C136 (\16\:CKb VSS) capacitor c=7.02737e-17
C137 (\19\:CKb VSS) capacitor c=5.11489e-17
C138 (\20\:CKb VSS) capacitor c=8.14007e-17
C139 (\21\:CKb VSS) capacitor c=2.118e-17
C140 (\8\:CKbb VSS) capacitor c=5.56928e-17
C141 (\9\:CKbb VSS) capacitor c=7.06839e-17
C142 (\4\:RN VSS) capacitor c=5.93641e-17
C143 (\4\:RNb VSS) capacitor c=6.85199e-17
C144 (\5\:RNb VSS) capacitor c=5.8536e-17
C145 (\14\:qbint VSS) capacitor c=2.00829e-16
C146 (\16\:qbint VSS) capacitor c=7.46564e-17
C147 (\19\:qbint VSS) capacitor c=6.55387e-17
C148 (\20\:qbint VSS) capacitor c=2.72491e-16
C149 (\8\:Dp VSS) capacitor c=2.14683e-16
C150 (\9\:Dp VSS) capacitor c=1.41053e-16
C151 (\10\:Dp VSS) capacitor c=1.16776e-16
C152 (\8\:E VSS) capacitor c=6.14714e-17
C153 (\9\:E VSS) capacitor c=7.63942e-17
C154 (\8\:Eb VSS) capacitor c=1.56915e-16
C155 (\5\:D VSS) capacitor c=7.3523e-17
C156 (\6\:Db VSS) capacitor c=9.33773e-17
C157 (\5\:VDD VSS) capacitor c=4.68845e-17
C158 (\11\:VDD VSS) capacitor c=4.16062e-17
C159 (\14\:VDD VSS) capacitor c=2.84274e-17
C160 (\20\:VDD VSS) capacitor c=1.0232e-17
Rk51 (D \5\:D) resistor r=0.08319 c=0
Rk2 (\4\:QN QN) resistor r=0.07348 c=0
Rk1 (\2\:QN \4\:QN) resistor r=0.2244 c=0
Rk8 (\5\:CK CK) resistor r=0.05475 c=0
Rk47 (E \8\:E) resistor r=0.02903 c=0
Rk48 (\8\:E \9\:E) resistor r=0.2684 c=0
Rk54 (\2\:VDD \4\:VDD) resistor r=0.4336 c=0
Rk55 (\4\:VDD \5\:VDD) resistor r=0.6791 c=0
Rk56 (\5\:VDD \6\:VDD) resistor r=0.4234 c=0
Rk57 (\5\:VDD \8\:VDD) resistor r=0.07358 c=0
Rk58 (\6\:VDD \10\:VDD) resistor r=0.1484 c=0
Rk59 (\6\:VDD \11\:VDD) resistor r=0.4616 c=0
Rk60 (\11\:VDD \13\:VDD) resistor r=0.1022 c=0
Rk61 (\11\:VDD \14\:VDD) resistor r=0.5059 c=0
Rk62 (\14\:VDD \16\:VDD) resistor r=0.3882 c=0
Rk63 (\14\:VDD \17\:VDD) resistor r=0.2354 c=0
Rk64 (\17\:VDD \19\:VDD) resistor r=0.2628 c=0
Rk67 (\20\:VDD VDD) resistor r=0.2126 c=0
Rk65 (\17\:VDD \20\:VDD) resistor r=0.3388 c=0
Rk66 (\20\:VDD \22\:VDD) resistor r=0.2233 c=0
Rk29 (RN \4\:RN) resistor r=0.1689 c=0
Rk6 (Q \2\:Q) resistor r=0.05094 c=0
Rk7 (Q \4\:Q) resistor r=0.1768 c=0
Rk68 (\2\:VSS \4\:VSS) resistor r=0.6181 c=0
Rk69 (\4\:VSS \5\:VSS) resistor r=0.2204 c=0
Rk70 (\5\:VSS \6\:VSS) resistor r=0.1375 c=0
Rk71 (\6\:VSS \7\:VSS) resistor r=0.2427 c=0
Rk72 (\7\:VSS \8\:VSS) resistor r=0.5023 c=0
Rk73 (\5\:VSS \10\:VSS) resistor r=0.1854 c=0
Rk74 (\6\:VSS \12\:VSS) resistor r=0.1854 c=0
Rk75 (\7\:VSS \14\:VSS) resistor r=0.2524 c=0
Rk76 (\8\:VSS \15\:VSS) resistor r=0.4284 c=0
Rk77 (\15\:VSS \16\:VSS) resistor r=0.4683 c=0
Rk78 (\16\:VSS \17\:VSS) resistor r=0.3056 c=0
Rk79 (\17\:VSS \18\:VSS) resistor r=0.0374 c=0
Rk81 (\19\:VSS VSS) resistor r=0.2126 c=0
Rk80 (\18\:VSS \19\:VSS) resistor r=0.3004 c=0
Rk82 (\8\:VSS \21\:VSS) resistor r=0.07144 c=0
Rk83 (\15\:VSS \23\:VSS) resistor r=0.2805 c=0
Rk84 (\16\:VSS \25\:VSS) resistor r=0.07358 c=0
Rk85 (\18\:VSS \27\:VSS) resistor r=0.07358 c=0
Rk86 (\19\:VSS \29\:VSS) resistor r=0.07358 c=0
Rk3 (\6\:qint \7\:qint) resistor r=0.1176 c=0
Rk4 (\7\:qint \8\:qint) resistor r=0.1192 c=0
Rk5 (\7\:qint \10\:qint) resistor r=0.1056 c=0
Rk33 (\14\:qbint \15\:qbint) resistor r=1.9541 c=0
Rk34 (\15\:qbint \16\:qbint) resistor r=0.5433 c=0
Rk35 (\16\:qbint \18\:qbint) resistor r=0.07984 c=0
Rk36 (\18\:qbint \19\:qbint) resistor r=0.421 c=0
Rk37 (\15\:qbint \20\:qbint) resistor r=0.04368 c=0
Rk38 (\16\:qbint \22\:qbint) resistor r=0.2761 c=0
Rk17 (\12\:CKb \13\:CKb) resistor r=0.2329 c=0
Rk18 (\13\:CKb \14\:CKb) resistor r=0.6727 c=0
Rk19 (\14\:CKb \15\:CKb) resistor r=0.6357 c=0
Rk20 (\15\:CKb \16\:CKb) resistor r=0.2131 c=0
Rk21 (\16\:CKb \18\:CKb) resistor r=0.6107 c=0
Rk22 (\14\:CKb \19\:CKb) resistor r=0.2285 c=0
Rk23 (\15\:CKb \20\:CKb) resistor r=0.3593 c=0
Rk24 (\16\:CKb \21\:CKb) resistor r=0.04287 c=0
Rk25 (\18\:CKb \23\:CKb) resistor r=0.3113 c=0
Rk9 (\5\:n30 \6\:n30) resistor r=0.2465 c=0
Rk10 (\6\:n30 \7\:n30) resistor r=0.2913 c=0
Rk11 (\6\:n30 \9\:n30) resistor r=0.1274 c=0
Rk12 (\5\:mout \6\:mout) resistor r=0.2623 c=0
Rk13 (\6\:mout \8\:mout) resistor r=0.2355 c=0
Rk14 (\6\:mout \10\:mout) resistor r=0.1379 c=0
Rk26 (\7\:CKbb \8\:CKbb) resistor r=0.1171 c=0
Rk27 (\8\:CKbb \9\:CKbb) resistor r=0.3948 c=0
Rk28 (\8\:CKbb \11\:CKbb) resistor r=0.2213 c=0
Rk15 (\5\:n20 \7\:n20) resistor r=0.3957 c=0
Rk16 (\7\:n20 \8\:n20) resistor r=0.4817 c=0
Rk41 (\5\:Dp \7\:Dp) resistor r=0.7688 c=0
Rk42 (\7\:Dp \8\:Dp) resistor r=0.07676 c=0
Rk43 (\8\:Dp \9\:Dp) resistor r=1.2187 c=0
Rk44 (\8\:Dp \10\:Dp) resistor r=0.6473 c=0
Rk45 (\10\:Dp \12\:Dp) resistor r=0.0496 c=0
Rk46 (\10\:Dp \14\:Dp) resistor r=0.3172 c=0
Rk30 (\4\:RNb \5\:RNb) resistor r=0.3251 c=0
Rk31 (\5\:RNb \7\:RNb) resistor r=0.2296 c=0
Rk32 (\5\:RNb \9\:RNb) resistor r=0.2124 c=0
Rk49 (\5\:Eb \7\:Eb) resistor r=0.2817 c=0
Rk50 (\7\:Eb \8\:Eb) resistor r=0.8339 c=0
Rk52 (\5\:Db \6\:Db) resistor r=0.871 c=0
Rk53 (\5\:Db \8\:Db) resistor r=0.2562 c=0
Rk39 (\2\:n2 \4\:n2) resistor r=0.3108 c=0
Rk40 (\2\:n3 \4\:n3) resistor r=0.4708 c=0
Rl49 (\1\:D \2\:D) resistor r=42.0262 c=0
Rl51 (\2\:D \4\:D) resistor r=53.5647 c=0
Rl50 (\2\:D \3\:D) resistor r=3.1741 c=0
Rl10 (\1\:CK \2\:CK) resistor r=49.7141 c=0
Rl12 (\2\:CK \4\:CK) resistor r=34.3295 c=0
Rl11 (\2\:CK \3\:CK) resistor r=0.5166 c=0
Rl43 (\2\:E \3\:E) resistor r=63.4387 c=0
Rl42 (\1\:E \2\:E) resistor r=134.41 c=0
Rl46 (\4\:E \5\:E) resistor r=49.2335 c=0
Rl48 (\5\:E \7\:E) resistor r=39.6181 c=0
Rl47 (\5\:E \6\:E) resistor r=92.681 c=0
Rl34 (\1\:RN \2\:RN) resistor r=24.2328 c=0
Rl35 (\2\:RN \3\:RN) resistor r=137.694 c=0
Rl3 (\2\:qint \4\:qint) resistor r=49.7141 c=0
Rl2 (\2\:qint \3\:qint) resistor r=34.3295 c=0
Rl1 (qint \2\:qint) resistor r=0.5213 c=0
Rl38 (\11\:qbint \12\:qbint) resistor r=211.104 c=0
Rl15 (\8\:qbint \9\:qbint) resistor r=145.073 c=0
Rl39 (\12\:qbint \13\:qbint) resistor r=30.0021 c=0
Rl16 (\9\:qbint \10\:qbint) resistor r=24.2328 c=0
Rl8 (\5\:qbint \6\:qbint) resistor r=24.2328 c=0
Rl7 (\2\:qbint \5\:qbint) resistor r=60.772 c=0
Rl4 (qbint \2\:qbint) resistor r=28.0797 c=0
Rl9 (\3\:qbint \7\:qbint) resistor r=60.772 c=0
Rl6 (\3\:qbint \4\:qbint) resistor r=28.0797 c=0
Rl5 (\2\:qbint \3\:qbint) resistor r=141.671 c=0
Rl32 (\9\:CKb \10\:CKb) resistor r=89.6174 c=0
Rl33 (\10\:CKb \11\:CKb) resistor r=24.2328 c=0
Rl29 (\7\:CKb \8\:CKb) resistor r=24.2328 c=0
Rl24 (\5\:CKb \6\:CKb) resistor r=37.2302 c=0
Rl18 (\3\:CKb \4\:CKb) resistor r=39.6174 c=0
Rl17 (CKb \2\:CKb) resistor r=71.8456 c=0
Rl13 (n30 \2\:n30) resistor r=87.2302 c=0
Rl14 (\2\:n30 \3\:n30) resistor r=29.5379 c=0
Rl23 (\2\:mout \4\:mout) resistor r=82.5332 c=0
Rl21 (mout \2\:mout) resistor r=38.6163 c=0
Rl22 (\2\:mout \3\:mout) resistor r=4.287 c=0
Rl28 (\4\:CKbb \5\:CKbb) resistor r=174.131 c=0
Rl27 (\3\:CKbb \4\:CKbb) resistor r=459.181 c=0
Rl25 (CKbb \2\:CKbb) resistor r=28.079 c=0
Rl26 (\2\:CKbb \3\:CKbb) resistor r=166.427 c=0
Rl19 (n20 \2\:n20) resistor r=24.2328 c=0
Rl20 (\2\:n20 \3\:n20) resistor r=89.6174 c=0
Rl31 (\2\:Dp \3\:Dp) resistor r=145.72 c=0
Rl30 (Dp \2\:Dp) resistor r=24.2328 c=0
Rl37 (\2\:RNb \3\:RNb) resistor r=85.7713 c=0
Rl36 (RNb \2\:RNb) resistor r=93.9465 c=0
Rl40 (Eb \2\:Eb) resistor r=119.922 c=0
Rl41 (\2\:Eb \3\:Eb) resistor r=44.9225 c=0
Rl44 (Db \2\:Db) resistor r=223.077 c=0
Rl45 (Db \3\:Db) resistor r=24.2328 c=0
Rz1 (\3\:QN \4\:QN) resistor r=75 c=0
Rz15 (\3\:VDD \4\:VDD) resistor r=7.5 c=0
Rz16 (\3\:VDD \6\:VDD) resistor r=6.25 c=0
Rz17 (\3\:VDD \17\:VDD) resistor r=6.25 c=0
Rz3 (\1\:Q \2\:Q) resistor r=75 c=0
Rz18 (\1\:VSS \2\:VSS) resistor r=75 c=0
Rz19 (\9\:VSS \10\:VSS) resistor r=75 c=0
Rz20 (\11\:VSS \12\:VSS) resistor r=75 c=0
Rz21 (\13\:VSS \14\:VSS) resistor r=75 c=0
Rz22 (\20\:VSS \21\:VSS) resistor r=75 c=0
Rz23 (\22\:VSS \23\:VSS) resistor r=75 c=0
Rz24 (\24\:VSS \25\:VSS) resistor r=75 c=0
Rz25 (\26\:VSS \27\:VSS) resistor r=75 c=0
Rz26 (\28\:VSS \29\:VSS) resistor r=75 c=0
Rz2 (\9\:qint \10\:qint) resistor r=75 c=0
Rz10 (\21\:qbint \22\:qbint) resistor r=75 c=0
Rz7 (\17\:CKb \18\:CKb) resistor r=75 c=0
Rz4 (\8\:n30 \9\:n30) resistor r=75 c=0
Rz5 (\9\:mout \10\:mout) resistor r=75 c=0
Rz8 (\10\:CKbb \11\:CKbb) resistor r=75 c=0
Rz6 (\4\:n20 \5\:n20) resistor r=75 c=0
Rz11 (\4\:Dp \5\:Dp) resistor r=75 c=0
Rz12 (\6\:Dp \7\:Dp) resistor r=75 c=0
Rz9 (\8\:RNb \9\:RNb) resistor r=75 c=0
Rz13 (\6\:Eb \7\:Eb) resistor r=75 c=0
Rz14 (\7\:Db \8\:Db) resistor r=75 c=0
Ry1 (\1\:QN \2\:QN) resistor r=62 c=0
Ry19 (\1\:VDD \2\:VDD) resistor r=62 c=0
Ry20 (\7\:VDD \8\:VDD) resistor r=62 c=0
Ry21 (\9\:VDD \10\:VDD) resistor r=62 c=0
Ry22 (\12\:VDD \13\:VDD) resistor r=62 c=0
Ry23 (\15\:VDD \16\:VDD) resistor r=62 c=0
Ry24 (\18\:VDD \19\:VDD) resistor r=62 c=0
Ry25 (\21\:VDD \22\:VDD) resistor r=62 c=0
Ry3 (\3\:Q \4\:Q) resistor r=62 c=0
Ry26 (\3\:VSS \4\:VSS) resistor r=6.2 c=0
Ry27 (\3\:VSS \8\:VSS) resistor r=5.1667 c=0
Ry28 (\3\:VSS \17\:VSS) resistor r=5.1667 c=0
Ry2 (\5\:qint \6\:qint) resistor r=62 c=0
Ry10 (\17\:qbint \18\:qbint) resistor r=62 c=0
Ry7 (\22\:CKb \23\:CKb) resistor r=62 c=0
Ry4 (\4\:n30 \5\:n30) resistor r=62 c=0
Ry5 (\7\:mout \8\:mout) resistor r=62 c=0
Ry8 (\6\:CKbb \7\:CKbb) resistor r=62 c=0
Ry6 (\6\:n20 \7\:n20) resistor r=62 c=0
Ry15 (\11\:Dp \12\:Dp) resistor r=62 c=0
Ry16 (\13\:Dp \14\:Dp) resistor r=62 c=0
Ry9 (\6\:RNb \7\:RNb) resistor r=62 c=0
Ry17 (\4\:Eb \5\:Eb) resistor r=62 c=0
Ry18 (\4\:Db \5\:Db) resistor r=62 c=0
Ry11 (n2 \2\:n2) resistor r=62 c=0
Ry12 (\3\:n2 \4\:n2) resistor r=62 c=0
Ry13 (n3 \2\:n3) resistor r=62 c=0
Ry14 (\3\:n3 \4\:n3) resistor r=62 c=0
Rx21 (\3\:D \5\:D) resistor r=45 c=0
Rx2 (\3\:CK \5\:CK) resistor r=45 c=0
Rx18 (\6\:E \8\:E) resistor r=45 c=0
Rx19 (\2\:E \9\:E) resistor r=45 c=0
Rx12 (\2\:RN \4\:RN) resistor r=45 c=0
Rx1 (qint \8\:qint) resistor r=45 c=0
Rx14 (\13\:qbint \14\:qbint) resistor r=45 c=0
Rx15 (\6\:qbint \19\:qbint) resistor r=45 c=0
Rx16 (\10\:qbint \20\:qbint) resistor r=45 c=0
Rx6 (\10\:CKb \12\:CKb) resistor r=45 c=0
Rx7 (\8\:CKb \13\:CKb) resistor r=45 c=0
Rx8 (\6\:CKb \19\:CKb) resistor r=45 c=0
Rx9 (\4\:CKb \20\:CKb) resistor r=45 c=0
Rx10 (\2\:CKb \21\:CKb) resistor r=45 c=0
Rx3 (\2\:n30 \7\:n30) resistor r=45 c=0
Rx4 (\3\:mout \5\:mout) resistor r=45 c=0
Rx11 (\2\:CKbb \9\:CKbb) resistor r=45 c=0
Rx5 (\2\:n20 \8\:n20) resistor r=45 c=0
Rx17 (Dp \9\:Dp) resistor r=45 c=0
Rx13 (\2\:RNb \4\:RNb) resistor r=45 c=0
Rx20 (\2\:Eb \8\:Eb) resistor r=45 c=0
Rx22 (\3\:Db \6\:Db) resistor r=45 c=0
mn57 (\3\:QN \3\:qint \28\:VSS VSS) g45n1lvt w=(1.45e-07) l=4.5e-08 nf=1 \
        as=5.19e-14 ad=2.537e-14 ps=1.6e-06 pd=6.4e-07 nrd=1.16667 \
        nrs=1.16667 sa=1.75e-07 sb=3.35e-07 sd=160n sca=23.279 \
        scb=0.0230742 scc=0.00267719 m=(1)
mn56 (\9\:qint \4\:qbint \28\:VSS VSS) g45n1lvt w=(1.45e-07) l=4.5e-08 \
        nf=1 as=5.19e-14 ad=2.03e-14 ps=1.6e-06 pd=5.7e-07 nrd=1.16667 \
        nrs=1.16667 sa=3.7e-07 sb=1.4e-07 sd=160n sca=23.279 scb=0.0230742 \
        scc=0.00267719 m=(1)
mn55 (\1\:Q qbint \26\:VSS VSS) g45n1lvt w=(1.45e-07) l=4.5e-08 nf=1 \
        as=5.19e-14 ad=2.03e-14 ps=1.6e-06 pd=5.7e-07 nrd=1.16667 \
        nrs=1.16667 sa=1.4e-07 sb=3.35e-07 sd=160n sca=23.279 \
        scb=0.0230742 scc=0.00267719 m=(1)
mn20 (\17\:CKb \4\:CK \26\:VSS VSS) g45n1lvt w=(1.45e-07) l=4.5e-08 nf=1 \
        as=5.19e-14 ad=2.03e-14 ps=1.6e-06 pd=5.7e-07 nrd=1.16667 \
        nrs=1.16667 sa=3.35e-07 sb=1.4e-07 sd=160n sca=23.279 \
        scb=0.0230742 scc=0.00267719 m=(1)
mn45 (\21\:qbint \3\:n30 \24\:VSS VSS) g45n1lvt w=(1.45e-07) l=4.5e-08 \
        nf=1 as=5.54e-14 ad=2.9e-14 ps=1.65e-06 pd=6.9e-07 nrd=1.16667 \
        nrs=1.16667 sa=2e-07 sb=2e-06 sd=160n sca=23.279 scb=0.0230742 \
        scc=0.00267719 m=(1)
mn50 (net496 \8\:qbint \24\:VSS VSS) g45n1lvt w=(1.45e-07) l=4.5e-08 \
        nf=1 as=5.54e-14 ad=8.7e-15 ps=1.65e-06 pd=4.1e-07 nrd=1.16667 \
        nrs=1.16667 sa=4.15e-07 sb=2e-06 sd=160n sca=23.279 scb=0.0230742 \
        scc=0.00267719 m=(1)
mn51 (\8\:n30 CKb net496 VSS) g45n1lvt w=(1.45e-07) l=4.5e-08 nf=1 \
        as=8.7e-15 ad=2.32e-14 ps=4.1e-07 pd=6.1e-07 nrd=1.16667 \
        nrs=1.16667 sa=5.2e-07 sb=1.9e-06 sd=160n sca=23.279 scb=0.0230742 \
        scc=0.00267719 m=(1)
mn40 (\8\:n30 \4\:CKbb \9\:mout VSS) g45n1lvt w=(1.45e-07) l=4.5e-08 nf=1 \
        as=5.147e-14 ad=2.32e-14 ps=1e-06 pd=6.1e-07 nrd=1.16667 \
        nrs=1.16667 sa=7.25e-07 sb=1.695e-06 sd=160n sca=23.279 \
        scb=0.0230742 scc=0.00267719 m=(1)
mn30 (\9\:mout \3\:n20 \22\:VSS VSS) g45n1lvt w=(1.45e-07) l=4.5e-08 \
        nf=1 as=5.632e-14 ad=5.147e-14 ps=1.11e-06 pd=1e-06 nrd=1.16667 \
        nrs=1.16667 sa=1.125e-06 sb=1.295e-06 sd=160n sca=23.279 \
        scb=0.0230742 scc=0.00267719 m=(1)
mn35 (net516 mout \22\:VSS VSS) g45n1lvt w=(1.45e-07) l=4.5e-08 nf=1 \
        as=5.632e-14 ad=8.7e-15 ps=1.11e-06 pd=4.1e-07 nrd=1.16667 \
        nrs=1.16667 sa=1.455e-06 sb=9.65e-07 sd=160n sca=23.279 \
        scb=0.0230742 scc=0.00267719 m=(1)
mn36 (\4\:n20 \3\:CKbb net516 VSS) g45n1lvt w=(1.45e-07) l=4.5e-08 nf=1 \
        as=8.7e-15 ad=4.132e-14 ps=4.1e-07 pd=8.6e-07 nrd=1.16667 \
        nrs=1.16667 sa=1.56e-06 sb=8.6e-07 sd=160n sca=23.279 \
        scb=0.0230742 scc=0.00267719 m=(1)
mn26 (\4\:n20 \7\:CKb n21 VSS) g45n1lvt w=(1.45e-07) l=4.5e-08 nf=1 \
        as=1.957e-14 ad=4.132e-14 ps=5.6e-07 pd=8.6e-07 nrd=1.16667 \
        nrs=1.16667 sa=1.89e-06 sb=5.3e-07 sd=160n sca=23.279 \
        scb=0.0230742 scc=0.00267719 m=(1)
mn25 (n21 \2\:Dp \20\:VSS VSS) g45n1lvt w=(1.45e-07) l=4.5e-08 nf=1 \
        as=5.407e-14 ad=1.957e-14 ps=1.63e-06 pd=5.6e-07 nrd=1.16667 \
        nrs=1.16667 sa=2e-06 sb=3.5e-07 sd=160n sca=23.279 scb=0.0230742 \
        scc=0.00267719 m=(1)
mn21 (\10\:CKbb \11\:CKb \20\:VSS VSS) g45n1lvt w=(1.45e-07) l=4.5e-08 \
        nf=1 as=5.407e-14 ad=2.03e-14 ps=1.63e-06 pd=5.7e-07 nrd=1.16667 \
        nrs=1.16667 sa=2e-06 sb=1.4e-07 sd=160n sca=23.279 scb=0.0230742 \
        scc=0.00267719 m=(1)
mn2 (\8\:RNb \3\:RN \13\:VSS VSS) g45n1lvt w=(1.45e-07) l=4.5e-08 nf=1 \
        as=4.567e-14 ad=2.32e-14 ps=9.2e-07 pd=6.1e-07 nrd=1.16667 \
        nrs=1.16667 sa=1.6e-07 sb=8.4e-07 sd=160n sca=9.00614 \
        scb=0.00733335 scc=0.00015104 m=(1)
mn3 (\6\:Dp RNb \13\:VSS VSS) g45n1lvt w=(1.45e-07) l=4.5e-08 nf=1 \
        as=4.567e-14 ad=2.32e-14 ps=9.2e-07 pd=6.1e-07 nrd=1.16667 \
        nrs=1.16667 sa=5.2e-07 sb=4.8e-07 sd=160n sca=9.00614 \
        scb=0.00733335 scc=0.00015104 m=(1)
mn5 (\6\:Dp \11\:qbint n0 VSS) g45n1lvt w=(1.45e-07) l=4.5e-08 nf=1 \
        as=8.7e-15 ad=2.32e-14 ps=4.1e-07 pd=6.1e-07 nrd=1.16667 \
        nrs=1.16667 sa=7.25e-07 sb=2.75e-07 sd=160n sca=9.00614 \
        scb=0.00733335 scc=0.00015104 m=(1)
mn4 (n0 \3\:Eb \11\:VSS VSS) g45n1lvt w=(1.45e-07) l=4.5e-08 nf=1 \
        as=3.485e-14 ad=8.7e-15 ps=8e-07 pd=4.1e-07 nrd=1.16667 \
        nrs=1.16667 sa=8.3e-07 sb=1.7e-07 sd=160n sca=9.00614 \
        scb=0.00733335 scc=0.00015104 m=(1)
mn6 (n1 \1\:E \9\:VSS VSS) g45n1lvt w=(1.45e-07) l=4.5e-08 nf=1 \
        as=2.03e-14 ad=8.7e-15 ps=5.7e-07 pd=4.1e-07 nrd=1.16667 \
        nrs=1.16667 sa=1.4e-07 sb=2.45e-07 sd=160n sca=7.00131 \
        scb=0.00386446 scc=3.38236e-05 m=(1)
mn7 (\4\:Dp \2\:Db n1 VSS) g45n1lvt w=(1.45e-07) l=4.5e-08 nf=1 \
        as=8.7e-15 ad=2.03e-14 ps=4.1e-07 pd=5.7e-07 nrd=1.16667 \
        nrs=1.16667 sa=2.45e-07 sb=1.4e-07 sd=160n sca=7.00131 \
        scb=0.00386446 scc=3.38236e-05 m=(1)
mn0 (\6\:Eb \7\:E \1\:VSS VSS) g45n1lvt w=(1.45e-07) l=4.5e-08 nf=1 \
        as=2.9e-14 ad=2.03e-14 ps=6.9e-07 pd=5.7e-07 nrd=1.16667 \
        nrs=1.16667 sa=1.4e-07 sb=4.05e-07 sd=160n sca=23.279 \
        scb=0.0230742 scc=0.00267719 m=(1)
mn1 (\7\:Db \4\:D \1\:VSS VSS) g45n1lvt w=(1.45e-07) l=4.5e-08 nf=1 \
        as=2.9e-14 ad=2.32e-14 ps=6.9e-07 pd=6.1e-07 nrd=1.16667 \
        nrs=1.16667 sa=3.85e-07 sb=1.6e-07 sd=160n sca=23.279 \
        scb=0.0230742 scc=0.00267719 m=(1)
ends EDFFTRXL
// End of subcircuit definition.
