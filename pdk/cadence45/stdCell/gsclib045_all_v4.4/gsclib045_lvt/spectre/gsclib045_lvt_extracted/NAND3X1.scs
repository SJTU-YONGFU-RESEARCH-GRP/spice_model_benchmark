// Generated for: spectre (May  1 09:16:42 2013 )
// Library name: gsclib045_lvt
// Cell name: NAND3X1
// View name: extracted

simulator lang=spectre

subckt NAND3X1 A B C VDD VSS Y
mp0 (\4\:Y \1\:A \5\:VDD VDD) g45p1lvt w=(3.9e-07) l=4.5e-08 nf=1 \
        as=5.46e-14 ad=6.24e-14 ps=1.06e-06 pd=1.1e-06 nrd=1.16667 \
        nrs=1.16667 sa=1.4e-07 sb=5.5e-07 sd=160n sca=25.4535 \
        scb=0.0286798 scc=0.00163825 m=(1)
mp1 (\4\:Y \1\:B \1\:VDD VDD) g45p1lvt w=(3.9e-07) l=4.5e-08 nf=1 \
        as=6.24e-14 ad=6.24e-14 ps=1.1e-06 pd=1.1e-06 nrd=1.16667 \
        nrs=1.16667 sa=3.45e-07 sb=3.45e-07 sd=160n sca=16.4103 \
        scb=0.0148066 scc=0.000275039 m=(1)
mp2 (\6\:Y \1\:C \1\:VDD VDD) g45p1lvt w=(3.9e-07) l=4.5e-08 nf=1 \
        as=6.24e-14 ad=5.46e-14 ps=1.1e-06 pd=1.06e-06 nrd=1.16667 \
        nrs=1.16667 sa=5.5e-07 sb=1.4e-07 sd=160n sca=16.6925 \
        scb=0.0153965 scc=0.00029244 m=(1)
C1 (Y VSS) capacitor c=6.1411e-18
C2 (C VSS) capacitor c=2.03918e-17
C3 (VDD VSS) capacitor c=8.15229e-17
C4 (B VSS) capacitor c=1.9667e-17
C5 (n0 VSS) capacitor c=3.35995e-18
C6 (\1\:C VSS) capacitor c=5.16852e-17
C7 (\1\:B VSS) capacitor c=5.86769e-17
C8 (\1\:A VSS) capacitor c=3.66925e-17
C9 (\3\:C VSS) capacitor c=4.61067e-17
C10 (\3\:B VSS) capacitor c=6.45398e-17
C11 (\3\:A VSS) capacitor c=4.30211e-17
C12 (\2\:C VSS) capacitor c=4.10889e-17
C13 (\2\:B VSS) capacitor c=4.9341e-17
C14 (\2\:A VSS) capacitor c=3.87468e-17
C15 (\6\:Y VSS) capacitor c=3.96301e-17
C16 (\1\:VDD VSS) capacitor c=6.80171e-17
C17 (\4\:Y VSS) capacitor c=8.23247e-17
C18 (\5\:VDD VSS) capacitor c=4.69274e-17
C19 (\1\:Y VSS) capacitor c=8.29015e-17
C20 (\5\:A VSS) capacitor c=1.71198e-17
C21 (\6\:A VSS) capacitor c=3.06487e-17
C22 (\4\:B VSS) capacitor c=2.89706e-17
C23 (\4\:C VSS) capacitor c=6.53855e-17
C24 (\3\:Y VSS) capacitor c=5.25677e-17
C25 (\4\:VDD VSS) capacitor c=2.62736e-17
Rk1 (\4\:A \5\:A) resistor r=0.009432 c=0
Rk2 (A \6\:A) resistor r=0.009274 c=0
Rk3 (\4\:A \6\:A) resistor r=0.0314 c=0
Rk14 (VSS \4\:VSS) resistor r=0.3197 c=0
Rk8 (\3\:Y Y) resistor r=0.05218 c=0
Rk6 (\2\:Y \3\:Y) resistor r=0.4304 c=0
Rk7 (\3\:Y \5\:Y) resistor r=0.386 c=0
Rk9 (Y \7\:Y) resistor r=0.06453 c=0
Rk5 (C \4\:C) resistor r=0.02186 c=0
Rk11 (\4\:VDD VDD) resistor r=0.2001 c=0
Rk10 (\2\:VDD \4\:VDD) resistor r=0.2926 c=0
Rk12 (VDD \6\:VDD) resistor r=0.2441 c=0
Rk4 (B \4\:B) resistor r=0.02903 c=0
Rl1 (\1\:A \2\:A) resistor r=26.098 c=0
Rl2 (\2\:A \3\:A) resistor r=114.56 c=0
Rl5 (\1\:C \2\:C) resistor r=127.402 c=0
Rl6 (\2\:C \3\:C) resistor r=26.3736 c=0
Rl3 (\1\:B \2\:B) resistor r=75.6918 c=0
Rl4 (\2\:B \3\:B) resistor r=71.8456 c=0
Rz3 (\3\:VSS \4\:VSS) resistor r=37.5 c=0
Rz1 (\1\:Y \2\:Y) resistor r=37.5 c=0
Ry1 (\4\:Y \5\:Y) resistor r=31 c=0
Ry2 (\6\:Y \7\:Y) resistor r=31 c=0
Ry3 (\1\:VDD \2\:VDD) resistor r=31 c=0
Ry4 (\5\:VDD \6\:VDD) resistor r=31 c=0
Rx1 (\2\:A \5\:A) resistor r=45 c=0
Rx3 (\2\:C \4\:C) resistor r=45 c=0
Rx2 (\2\:B \4\:B) resistor r=45 c=0
mn0 (n1 \3\:A \3\:VSS VSS) g45n1lvt w=(2.6e-07) l=4.5e-08 nf=1 \
        as=3.64e-14 ad=4.16e-14 ps=8e-07 pd=8.4e-07 nrd=1.16667 \
        nrs=1.16667 sa=1.4e-07 sb=5.15e-07 sd=160n sca=15.3338 \
        scb=0.0153436 scc=0.00119435 m=(1)
mn1 (n0 \3\:B n1 VSS) g45n1lvt w=(2.6e-07) l=4.5e-08 nf=1 as=4.16e-14 \
        ad=1.82e-14 ps=8.4e-07 pd=6.6e-07 nrd=1.16667 nrs=1.16667 \
        sa=3.45e-07 sb=3.1e-07 sd=160n sca=15.3338 scb=0.0153436 \
        scc=0.00119435 m=(1)
mn2 (\1\:Y \3\:C n0 VSS) g45n1lvt w=(2.6e-07) l=4.5e-08 nf=1 as=1.82e-14 \
        ad=5.07e-14 ps=6.6e-07 pd=9.1e-07 nrd=1.16667 nrs=1.16667 \
        sa=4.6e-07 sb=1.95e-07 sd=160n sca=15.3338 scb=0.0153436 \
        scc=0.00119435 m=(1)
ends NAND3X1
// End of subcircuit definition.
