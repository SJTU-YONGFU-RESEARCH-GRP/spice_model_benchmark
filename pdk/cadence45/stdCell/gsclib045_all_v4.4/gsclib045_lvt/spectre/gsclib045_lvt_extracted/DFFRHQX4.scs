// Generated for: spectre (May  1 09:13:44 2013 )
// Library name: gsclib045_lvt
// Cell name: DFFRHQX4
// View name: extracted

simulator lang=spectre

subckt DFFRHQX4 CK D Q RN VDD VSS
mp20 (\13\:CKb \3\:CK \12\:VDD VDD) g45p1lvt w=(2.15e-07) l=4.5e-08 nf=1 \
        as=6.335e-14 ad=3.01e-14 ps=1.36e-06 pd=7.1e-07 nrd=1.16667 \
        nrs=1.16667 sa=1.4e-07 sb=7.81395e-07 sd=160n sca=16.1121 \
        scb=0.0158148 scc=0.000267169 m=(1)
mp21 (\15\:CKbb \4\:CKb \1\:VDD VDD) g45p1lvt w=(2.15e-07) l=4.5e-08 \
        nf=1 as=4.39e-14 ad=3.01e-14 ps=9.4e-07 pd=7.1e-07 nrd=1.16667 \
        nrs=1.16667 sa=7.18023e-07 sb=1.4e-07 sd=160n sca=19.509 \
        scb=0.0211666 scc=0.000797427 m=(1)
C1 (CK VSS) capacitor c=4.52823e-17
C2 (D VSS) capacitor c=1.25185e-16
C3 (Q VSS) capacitor c=2.18479e-16
C4 (VDD VSS) capacitor c=3.99573e-16
C5 (RN VSS) capacitor c=6.3568e-16
C6 (CKb VSS) capacitor c=6.06128e-17
C7 (qbint VSS) capacitor c=3.03649e-16
C8 (16 VSS) capacitor c=1.38261e-18
C9 (n30 VSS) capacitor c=1.08162e-16
C10 (17 VSS) capacitor c=2.73804e-18
C11 (n40 VSS) capacitor c=5.97173e-18
C12 (mout VSS) capacitor c=3.76356e-17
C13 (CKbb VSS) capacitor c=5.50556e-17
C14 (n20 VSS) capacitor c=2.29934e-17
C15 (n25 VSS) capacitor c=5.40073e-19
C16 (n41 VSS) capacitor c=9.26454e-18
C17 (n26 VSS) capacitor c=6.7518e-17
C18 (n22 VSS) capacitor c=2.11974e-18
C19 (\4\:CKb VSS) capacitor c=8.47619e-17
C20 (\1\:D VSS) capacitor c=9.79194e-17
C21 (\7\:CKbb VSS) capacitor c=6.8772e-17
C22 (\8\:CKb VSS) capacitor c=4.72494e-17
C23 (\9\:RN VSS) capacitor c=4.23735e-17
C24 (\4\:n20 VSS) capacitor c=4.97104e-17
C25 (\2\:CKb VSS) capacitor c=7.249e-17
C26 (\16\:qbint VSS) capacitor c=3.96401e-17
C27 (\3\:CK VSS) capacitor c=5.45427e-17
C28 (\7\:CKb VSS) capacitor c=6.20639e-17
C29 (\3\:D VSS) capacitor c=3.58372e-17
C30 (\9\:CKb VSS) capacitor c=4.96307e-17
C31 (\5\:CKbb VSS) capacitor c=3.82523e-17
C32 (\3\:mout VSS) capacitor c=3.57244e-17
C33 (\7\:RN VSS) capacitor c=3.58849e-17
C34 (\3\:n20 VSS) capacitor c=2.34241e-17
C35 (\3\:CKbb VSS) capacitor c=4.2501e-17
C36 (\18\:qbint VSS) capacitor c=4.52097e-17
C37 (\6\:RN VSS) capacitor c=3.06832e-17
C38 (\5\:n30 VSS) capacitor c=3.33057e-17
C39 (\4\:n30 VSS) capacitor c=3.73922e-17
C40 (\1\:RN VSS) capacitor c=3.83282e-17
C41 (\1\:CK VSS) capacitor c=3.22646e-17
C42 (\2\:D VSS) capacitor c=4.16305e-17
C43 (\8\:CKbb VSS) capacitor c=3.27252e-17
C44 (\6\:CKbb VSS) capacitor c=3.78954e-17
C45 (\6\:CKb VSS) capacitor c=2.6492e-17
C46 (\2\:mout VSS) capacitor c=3.43771e-17
C47 (\8\:RN VSS) capacitor c=3.88479e-17
C48 (\4\:CKbb VSS) capacitor c=3.15597e-17
C49 (\3\:CKb VSS) capacitor c=2.00924e-17
C50 (\2\:CKbb VSS) capacitor c=4.64243e-17
C51 (\17\:qbint VSS) capacitor c=4.95283e-17
C52 (\2\:CK VSS) capacitor c=4.11258e-17
C53 (\15\:CKbb VSS) capacitor c=2.05148e-17
C54 (\1\:VDD VSS) capacitor c=3.90029e-17
C55 (\5\:n20 VSS) capacitor c=1.01674e-16
C56 (\6\:VDD VSS) capacitor c=2.69566e-17
C57 (\3\:n26 VSS) capacitor c=8.91592e-17
C58 (\10\:VDD VSS) capacitor c=2.95189e-17
C59 (\5\:mout VSS) capacitor c=1.74742e-16
C60 (\11\:n30 VSS) capacitor c=8.50119e-17
C61 (\16\:VDD VSS) capacitor c=1.54157e-17
C62 (\13\:CKb VSS) capacitor c=2.16106e-17
C63 (\3\:VDD VSS) capacitor c=7.11312e-17
C64 (\9\:CKbb VSS) capacitor c=4.57923e-17
C65 (\9\:n20 VSS) capacitor c=1.22539e-17
C66 (\7\:mout VSS) capacitor c=8.0056e-17
C67 (\7\:n30 VSS) capacitor c=6.43068e-17
C68 (\27\:qbint VSS) capacitor c=8.21173e-17
C69 (\15\:CKb VSS) capacitor c=7.87631e-17
C70 (\2\:n20 VSS) capacitor c=2.08828e-17
C71 (\5\:CKb VSS) capacitor c=4.48338e-17
C72 (\4\:CK VSS) capacitor c=7.47775e-17
C73 (\19\:qbint VSS) capacitor c=6.13842e-17
C74 (\20\:qbint VSS) capacitor c=1.69316e-16
C75 (\24\:qbint VSS) capacitor c=4.94381e-17
C76 (\9\:n30 VSS) capacitor c=1.44501e-16
C77 (\10\:n30 VSS) capacitor c=1.07034e-16
C78 (\10\:RN VSS) capacitor c=2.44847e-16
C79 (\4\:mout VSS) capacitor c=1.17589e-16
C80 (\10\:CKb VSS) capacitor c=1.52402e-16
C81 (\11\:CKb VSS) capacitor c=3.76341e-16
C82 (\12\:CKb VSS) capacitor c=2.78782e-16
C83 (\7\:n20 VSS) capacitor c=9.47129e-17
C84 (\8\:n20 VSS) capacitor c=1.10394e-16
C85 (\11\:CKbb VSS) capacitor c=6.92546e-17
C86 (\12\:CKbb VSS) capacitor c=6.60106e-17
C87 (\13\:CKbb VSS) capacitor c=2.34528e-16
C88 (\14\:CKbb VSS) capacitor c=7.80773e-17
C89 (\17\:CKbb VSS) capacitor c=4.09386e-17
C90 (\18\:CKbb VSS) capacitor c=1.9132e-16
C91 (\19\:CKbb VSS) capacitor c=2.75251e-17
C92 (\20\:CKbb VSS) capacitor c=4.34635e-17
C93 (\5\:VDD VSS) capacitor c=3.90114e-17
C94 (\9\:VDD VSS) capacitor c=2.7761e-17
C95 (\12\:VDD VSS) capacitor c=2.22649e-16
Rk1 (CK \4\:CK) resistor r=0.0258 c=0
Rk30 (D \4\:D) resistor r=0.006018 c=0
Rk40 (\2\:VDD \4\:VDD) resistor r=0.3675 c=0
Rk41 (\4\:VDD \5\:VDD) resistor r=0.4887 c=0
Rk42 (\5\:VDD \7\:VDD) resistor r=0.04333 c=0
Rk43 (\5\:VDD \8\:VDD) resistor r=0.3124 c=0
Rk44 (\8\:VDD \9\:VDD) resistor r=0.04401 c=0
Rk45 (\9\:VDD \11\:VDD) resistor r=0.04333 c=0
Rk57 (\12\:VDD VDD) resistor r=0.1476 c=0
Rk46 (\9\:VDD \12\:VDD) resistor r=0.5957 c=0
Rk49 (\12\:VDD \17\:VDD) resistor r=0.07416 c=0
Rk16 (\10\:RN RN) resistor r=1.7073 c=0
Rk58 (\2\:VSS \4\:VSS) resistor r=0.3016 c=0
Rk59 (\4\:VSS \5\:VSS) resistor r=0.8034 c=0
Rk60 (\5\:VSS \6\:VSS) resistor r=0.05499 c=0
Rk61 (\6\:VSS \7\:VSS) resistor r=0.682 c=0
Rk66 (\8\:VSS VSS) resistor r=0.1902 c=0
Rk62 (\7\:VSS \8\:VSS) resistor r=0.401 c=0
Rk67 (\6\:VSS \13\:VSS) resistor r=0.2629 c=0
Rk68 (\7\:VSS \15\:VSS) resistor r=0.2224 c=0
Rk23 (\10\:CKb \11\:CKb) resistor r=1.0979 c=0
Rk24 (\11\:CKb \12\:CKb) resistor r=2.2583 c=0
Rk25 (\12\:CKb \14\:CKb) resistor r=0.02105 c=0
Rk26 (\12\:CKb \16\:CKb) resistor r=0.5817 c=0
Rk7 (\19\:qbint \20\:qbint) resistor r=0.2999 c=0
Rk10 (\20\:qbint \24\:qbint) resistor r=0.3086 c=0
Rk12 (\20\:qbint \28\:qbint) resistor r=0.4197 c=0
Rk13 (\8\:n30 \9\:n30) resistor r=0.3868 c=0
Rk14 (\9\:n30 \10\:n30) resistor r=0.6042 c=0
Rk15 (\9\:n30 \12\:n30) resistor r=0.5374 c=0
Rk20 (\4\:mout \6\:mout) resistor r=0.8324 c=0
Rk21 (\6\:mout \8\:mout) resistor r=0.3792 c=0
Rk31 (\10\:CKbb \11\:CKbb) resistor r=0.4033 c=0
Rk32 (\11\:CKbb \12\:CKbb) resistor r=0.3044 c=0
Rk33 (\12\:CKbb \13\:CKbb) resistor r=0.4052 c=0
Rk34 (\13\:CKbb \14\:CKbb) resistor r=0.3692 c=0
Rk35 (\11\:CKbb \16\:CKbb) resistor r=0.04182 c=0
Rk36 (\12\:CKbb \17\:CKbb) resistor r=0.1515 c=0
Rk37 (\13\:CKbb \18\:CKbb) resistor r=1.6215 c=0
Rk38 (\18\:CKbb \19\:CKbb) resistor r=0.1091 c=0
Rk39 (\18\:CKbb \20\:CKbb) resistor r=0.1758 c=0
Rk27 (\6\:n20 \7\:n20) resistor r=0.4954 c=0
Rk28 (\7\:n20 \8\:n20) resistor r=0.7269 c=0
Rk29 (\7\:n20 \10\:n20) resistor r=0.05483 c=0
Rk22 (\2\:n26 \4\:n26) resistor r=0.23 c=0
Rl2 (\2\:CK \3\:CK) resistor r=168.407 c=0
Rl1 (\1\:CK \2\:CK) resistor r=30.7692 c=0
Rl41 (\1\:D \2\:D) resistor r=89.1533 c=0
Rl42 (\2\:D \3\:D) resistor r=39.1533 c=0
Rl25 (RN \6\:RN) resistor r=26.3736 c=0
Rl17 (RN \1\:RN) resistor r=30.7692 c=0
Rl36 (\8\:RN \9\:RN) resistor r=45.3867 c=0
Rl35 (\8\:RN \7\:RN) resistor r=130.323 c=0
Rl45 (\4\:CKb \7\:CKb) resistor r=213.462 c=0
Rl47 (\8\:CKb \9\:CKb) resistor r=153.846 c=0
Rl29 (CKb \2\:CKb) resistor r=176.122 c=0
Rl30 (\2\:CKb \3\:CKb) resistor r=24.2328 c=0
Rl43 (\4\:CKb \5\:CKb) resistor r=298.055 c=0
Rl46 (\5\:CKb \8\:CKb) resistor r=70.8353 c=0
Rl44 (\5\:CKb \6\:CKb) resistor r=85.2376 c=0
Rl26 (\17\:qbint \16\:qbint) resistor r=35.7713 c=0
Rl27 (\17\:qbint \18\:qbint) resistor r=147.31 c=0
Rl22 (n30 \5\:n30) resistor r=76.1559 c=0
Rl21 (n30 \4\:n30) resistor r=75.6397 c=0
Rl37 (mout \2\:mout) resistor r=28.079 c=0
Rl38 (\2\:mout \3\:mout) resistor r=93.4636 c=0
Rl40 (\7\:CKbb \8\:CKbb) resistor r=35.3072 c=0
Rl39 (\5\:CKbb \6\:CKbb) resistor r=75.6918 c=0
Rl31 (\3\:CKbb \4\:CKbb) resistor r=46.8456 c=0
Rl28 (CKbb \2\:CKbb) resistor r=85.7713 c=0
Rl34 (\2\:n20 \4\:n20) resistor r=110.772 c=0
Rl33 (\2\:n20 \3\:n20) resistor r=35.772 c=0
Rl32 (n20 \2\:n20) resistor r=32.3537 c=0
Rz9 (\4\:VDD \3\:VDD) resistor r=18.75 c=0
Rz10 (\8\:VDD \3\:VDD) resistor r=6.25 c=0
Rz11 (\12\:VDD \3\:VDD) resistor r=6.25 c=0
Rz12 (\2\:VSS \1\:VSS) resistor r=75 c=0
Rz13 (\13\:VSS \12\:VSS) resistor r=75 c=0
Rz14 (\15\:VSS \14\:VSS) resistor r=75 c=0
Rz6 (\15\:CKb \16\:CKb) resistor r=75 c=0
Rz3 (\28\:qbint \27\:qbint) resistor r=75 c=0
Rz4 (\8\:n30 \7\:n30) resistor r=75 c=0
Rz5 (\7\:mout \8\:mout) resistor r=75 c=0
Rz8 (\9\:CKbb \10\:CKbb) resistor r=75 c=0
Rz7 (\9\:n20 \10\:n20) resistor r=75 c=0
Ry12 (\2\:VDD \1\:VDD) resistor r=62 c=0
Ry13 (\7\:VDD \6\:VDD) resistor r=62 c=0
Ry14 (\11\:VDD \10\:VDD) resistor r=62 c=0
Ry16 (\17\:VDD \16\:VDD) resistor r=62 c=0
Ry20 (\4\:VSS \3\:VSS) resistor r=15.5 c=0
Ry21 (\5\:VSS \3\:VSS) resistor r=5.1667 c=0
Ry22 (\8\:VSS \3\:VSS) resistor r=5.1667 c=0
Ry9 (\13\:CKb \14\:CKb) resistor r=62 c=0
Ry5 (\12\:n30 \11\:n30) resistor r=62 c=0
Ry6 (\5\:mout \6\:mout) resistor r=62 c=0
Ry11 (\15\:CKbb \16\:CKbb) resistor r=62 c=0
Ry10 (\5\:n20 \6\:n20) resistor r=62 c=0
Ry7 (n26 \2\:n26) resistor r=62 c=0
Ry8 (\3\:n26 \4\:n26) resistor r=62 c=0
Rx1 (\2\:CK \4\:CK) resistor r=45 c=0
Rx12 (\2\:D \4\:D) resistor r=45 c=0
Rx5 (\10\:RN \8\:RN) resistor r=45 c=0
Rx9 (\6\:CKb \10\:CKb) resistor r=45 c=0
Rx10 (\3\:CKb \11\:CKb) resistor r=45 c=0
Rx2 (\19\:qbint \17\:qbint) resistor r=45 c=0
Rx3 (\24\:qbint qbint) resistor r=45 c=0
Rx4 (\10\:n30 n30) resistor r=45 c=0
Rx8 (\2\:mout \4\:mout) resistor r=45 c=0
Rx13 (\6\:CKbb \14\:CKbb) resistor r=45 c=0
Rx14 (\8\:CKbb \17\:CKbb) resistor r=45 c=0
Rx15 (\4\:CKbb \19\:CKbb) resistor r=45 c=0
Rx16 (\2\:CKbb \20\:CKbb) resistor r=45 c=0
Rx11 (n20 \8\:n20) resistor r=45 c=0
mn20 (\15\:CKb \1\:CK \8\:VSS VSS) g45n1lvt w=(1.45e-07) l=4.5e-08 nf=1 \
        as=3.542e-14 ad=2.03e-14 ps=8.5e-07 pd=5.7e-07 nrd=1.16667 \
        nrs=1.16667 sa=1.4e-07 sb=1.60172e-06 sd=160n sca=16.2011 \
        scb=0.0172667 scc=0.0012292 m=(1)
mn21 (\9\:CKbb \7\:CKb \1\:VSS VSS) g45n1lvt w=(1.45e-07) l=4.5e-08 nf=1 \
        as=2.92e-14 ad=3.263e-14 ps=7.3e-07 pd=7.4e-07 nrd=1.16667 \
        nrs=1.16667 sa=2e-06 sb=2.25e-07 sd=160n sca=9.33388 \
        scb=0.00788941 scc=0.00017958 m=(1)
mn55_1__rcx (Q qbint \8\:VSS VSS) g45n1lvt w=(2.6e-07) l=4.5e-08 nf=1 \
        as=4.384e-14 ad=4.485e-14 ps=8.875e-07 pd=8.65e-07 nrd=1.16667 \
        nrs=1.16667 sa=2.39423e-07 sb=1.73346e-06 sd=160n sca=12.8392 \
        scb=0.0126987 scc=0.00074151 m=(4)
mn45_1__rcx (16 \1\:RN \8\:VSS VSS) g45n1lvt w=(2.05e-07) l=4.5e-08 nf=1 \
        as=5.675e-14 ad=1.947e-14 ps=1.02e-06 pd=6e-07 nrd=1.16667 \
        nrs=1.16667 sa=1.14476e-06 sb=2e-06 sd=160n sca=10.7727 \
        scb=0.0101457 scc=0.000373012 m=(1)
mn46_1__rcx (\27\:qbint \4\:n30 16 VSS) g45n1lvt w=(2.05e-07) l=4.5e-08 \
        nf=1 as=1.947e-14 ad=3.28e-14 ps=6e-07 pd=7.3e-07 nrd=1.16667 \
        nrs=1.16667 sa=1.28476e-06 sb=2e-06 sd=160n sca=10.7727 \
        scb=0.0101457 scc=0.000373012 m=(1)
mn46 (\27\:qbint \5\:n30 17 VSS) g45n1lvt w=(2.05e-07) l=4.5e-08 nf=1 \
        as=2.358e-14 ad=3.28e-14 ps=6.4e-07 pd=7.3e-07 nrd=1.16667 \
        nrs=1.16667 sa=1.48976e-06 sb=2e-06 sd=160n sca=10.7727 \
        scb=0.0101457 scc=0.000373012 m=(1)
mn45 (17 \6\:RN \14\:VSS VSS) g45n1lvt w=(2.05e-07) l=4.5e-08 nf=1 \
        as=7.715e-14 ad=2.358e-14 ps=1.2e-06 pd=6.4e-07 nrd=1.16667 \
        nrs=1.16667 sa=1.64976e-06 sb=2e-06 sd=160n sca=10.7727 \
        scb=0.0101457 scc=0.000373012 m=(1)
mn50 (n40 \18\:qbint \14\:VSS VSS) g45n1lvt w=(2.05e-07) l=4.5e-08 nf=1 \
        as=7.715e-14 ad=6.355e-14 ps=1.2e-06 pd=1.03e-06 nrd=1.16667 \
        nrs=1.16667 sa=1.96354e-06 sb=2e-06 sd=160n sca=10.7727 \
        scb=0.0101457 scc=0.000373012 m=(1)
mn51 (\7\:n30 CKb n40 VSS) g45n1lvt w=(2.05e-07) l=4.5e-08 nf=1 \
        as=6.355e-14 ad=3.28e-14 ps=1.03e-06 pd=7.3e-07 nrd=1.16667 \
        nrs=1.16667 sa=2e-06 sb=2e-06 sd=160n sca=10.7727 scb=0.0101457 \
        scc=0.000373012 m=(1)
mn40 (\7\:n30 \3\:CKbb \7\:mout VSS) g45n1lvt w=(2.05e-07) l=4.5e-08 nf=1 \
        as=7.175e-14 ad=3.28e-14 ps=1.11e-06 pd=7.3e-07 nrd=1.16667 \
        nrs=1.16667 sa=2e-06 sb=2e-06 sd=160n sca=10.7727 scb=0.0101457 \
        scc=0.000373012 m=(1)
mn30 (\7\:mout \3\:n20 \12\:VSS VSS) g45n1lvt w=(2.05e-07) l=4.5e-08 \
        nf=1 as=8.815e-14 ad=7.175e-14 ps=1.27e-06 pd=1.11e-06 nrd=1.16667 \
        nrs=1.16667 sa=2e-06 sb=1.93707e-06 sd=160n sca=10.7727 \
        scb=0.0101457 scc=0.000373012 m=(1)
mn35 (n27 \7\:RN \12\:VSS VSS) g45n1lvt w=(2.05e-07) l=4.5e-08 nf=1 \
        as=8.815e-14 ad=5.433e-14 ps=1.27e-06 pd=9.4e-07 nrd=1.16667 \
        nrs=1.16667 sa=2e-06 sb=1.54341e-06 sd=160n sca=10.7727 \
        scb=0.0101457 scc=0.000373012 m=(1)
mn36 (n25 \3\:mout n27 VSS) g45n1lvt w=(2.05e-07) l=4.5e-08 nf=1 \
        as=5.433e-14 ad=5.228e-14 ps=9.4e-07 pd=9.2e-07 nrd=1.16667 \
        nrs=1.16667 sa=2e-06 sb=1.23341e-06 sd=160n sca=10.7727 \
        scb=0.0101457 scc=0.000373012 m=(1)
mn37 (\9\:n20 \5\:CKbb n25 VSS) g45n1lvt w=(2.05e-07) l=4.5e-08 nf=1 \
        as=5.228e-14 ad=3.28e-14 ps=9.2e-07 pd=7.3e-07 nrd=1.16667 \
        nrs=1.16667 sa=2e-06 sb=9.33415e-07 sd=160n sca=10.7727 \
        scb=0.0101457 scc=0.000373012 m=(1)
mn26 (\9\:n20 \9\:CKb n21 VSS) g45n1lvt w=(2.05e-07) l=4.5e-08 nf=1 \
        as=7.175e-14 ad=3.28e-14 ps=1.11e-06 pd=7.3e-07 nrd=1.16667 \
        nrs=1.16667 sa=2e-06 sb=7.28415e-07 sd=160n sca=10.7727 \
        scb=0.0101457 scc=0.000373012 m=(1)
mn25 (n21 \3\:D \1\:VSS VSS) g45n1lvt w=(2.05e-07) l=4.5e-08 nf=1 \
        as=2.92e-14 ad=7.175e-14 ps=7.3e-07 pd=1.11e-06 nrd=1.16667 \
        nrs=1.16667 sa=2e-06 sb=3.33415e-07 sd=160n sca=10.7727 \
        scb=0.0101457 scc=0.000373012 m=(1)
mp55 (Q qbint \12\:VDD VDD) g45p1lvt w=(3.9e-07) l=4.5e-08 nf=1 \
        as=8.452e-14 ad=7.02e-14 ps=1.5175e-06 pd=1.14e-06 nrd=1.16667 \
        nrs=1.16667 sa=1.8109e-07 sb=1.46949e-06 sd=160n sca=27.3684 \
        scb=0.0203057 scc=0.00278102 m=(4)
mp50 (n41 \16\:qbint \12\:VDD VDD) g45p1lvt w=(3.1e-07) l=4.5e-08 nf=1 \
        as=4.96e-14 ad=7.13e-14 ps=9.4e-07 pd=1.08e-06 nrd=1.16667 \
        nrs=1.16667 sa=9.51532e-07 sb=1.08387e-06 sd=160n sca=11.1346 \
        scb=0.00910425 scc=0.000198662 m=(1)
mp51 (\11\:n30 CKbb n41 VDD) g45p1lvt w=(3.1e-07) l=4.5e-08 nf=1 \
        as=7.13e-14 ad=5.6e-14 ps=1.08e-06 pd=1.26e-06 nrd=1.16667 \
        nrs=1.16667 sa=1.12968e-06 sb=8.08871e-07 sd=160n sca=11.1346 \
        scb=0.00910425 scc=0.000198662 m=(1)
mp40 (\11\:n30 \2\:CKb \5\:mout VDD) g45p1lvt w=(3.1e-07) l=4.5e-08 nf=1 \
        as=1.333e-13 ad=5.6e-14 ps=1.48e-06 pd=1.26e-06 nrd=1.16667 \
        nrs=1.16667 sa=9.01774e-07 sb=1.36e-06 sd=160n sca=22.2698 \
        scb=0.0192893 scc=0.0023049 m=(1)
mp30 (\5\:mout \4\:n20 \10\:VDD VDD) g45p1lvt w=(3.1e-07) l=4.5e-08 nf=1 \
        as=1.4575e-13 ad=1.333e-13 ps=2.02e-06 pd=1.48e-06 nrd=1.16667 \
        nrs=1.16667 sa=1.1929e-06 sb=8.85e-07 sd=160n sca=22.2698 \
        scb=0.0192893 scc=0.0023049 m=(1)
mp35 (\3\:n26 \9\:RN \10\:VDD VDD) g45p1lvt w=(3.1e-07) l=4.5e-08 nf=1 \
        as=1.4575e-13 ad=1.147e-13 ps=2.02e-06 pd=1.36e-06 nrd=1.16667 \
        nrs=1.16667 sa=1.41968e-06 sb=5.15e-07 sd=160n sca=22.2698 \
        scb=0.0192893 scc=0.0023049 m=(1)
mp36 (\3\:n26 mout \6\:VDD VDD) g45p1lvt w=(3.1e-07) l=4.5e-08 nf=1 \
        as=5.815e-14 ad=1.147e-13 ps=1.71e-06 pd=1.36e-06 nrd=1.16667 \
        nrs=1.16667 sa=1.66968e-06 sb=1e-07 sd=160n sca=22.2698 \
        scb=0.0192893 scc=0.0023049 m=(1)
mp37 (\5\:n20 \8\:CKb n26 VDD) g45p1lvt w=(3.1e-07) l=4.5e-08 nf=1 \
        as=4.96e-14 ad=7.595e-14 ps=1.13e-06 pd=1.11e-06 nrd=1.16667 \
        nrs=1.16667 sa=1.6e-07 sb=6.64919e-07 sd=160n sca=20.6412 \
        scb=0.0183899 scc=0.00199566 m=(1)
mp26 (\5\:n20 \7\:CKbb n22 VDD) g45p1lvt w=(3.1e-07) l=4.5e-08 nf=1 \
        as=1.86e-14 ad=7.595e-14 ps=7.4e-07 pd=1.11e-06 nrd=1.16667 \
        nrs=1.16667 sa=4.5e-07 sb=3.74919e-07 sd=160n sca=21.654 \
        scb=0.0189695 scc=0.00199623 m=(1)
mp25 (n22 \1\:D \1\:VDD VDD) g45p1lvt w=(3.1e-07) l=4.5e-08 nf=1 \
        as=4.39e-14 ad=1.86e-14 ps=9.4e-07 pd=7.4e-07 nrd=1.16667 \
        nrs=1.16667 sa=5.55e-07 sb=2.69919e-07 sd=160n sca=22.4306 \
        scb=0.019868 scc=0.00199963 m=(1)
mp46_1__rcx (\20\:qbint n30 \16\:VDD VDD) g45p1lvt w=(3.1e-07) l=4.5e-08 \
        nf=1 as=7.515e-14 ad=6.21e-14 ps=1.87e-06 pd=1.275e-06 nrd=1.16667 \
        nrs=1.16667 sa=1.24605e-06 sb=9.55e-07 sd=160n sca=29.7112 \
        scb=0.0220652 scc=0.00347629 m=(2)
mp45 (\20\:qbint RN \12\:VDD VDD) g45p1lvt w=(3.1e-07) l=4.5e-08 nf=1 \
        as=6.437e-14 ad=6.21e-14 ps=1.405e-06 pd=1.275e-06 nrd=1.16667 \
        nrs=1.16667 sa=1.04105e-06 sb=1.08065e-06 sd=160n sca=29.7112 \
        scb=0.0220652 scc=0.00347629 m=(2)
ends DFFRHQX4
// End of subcircuit definition.
