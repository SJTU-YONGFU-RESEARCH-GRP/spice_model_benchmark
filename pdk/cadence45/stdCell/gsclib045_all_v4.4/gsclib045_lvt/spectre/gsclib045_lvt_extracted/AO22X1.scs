// Generated for: spectre (May  1 09:11:41 2013 )
// Library name: gsclib045_lvt
// Cell name: AO22X1
// View name: extracted

simulator lang=spectre

subckt AO22X1 A0 A1 B0 B1 VDD VSS Y
mp0 (\5\:n3 \3\:A0 \6\:VDD VDD) g45p1lvt w=(2.15e-07) l=4.5e-08 nf=1 \
        as=5.515e-14 ad=3.01e-14 ps=1.45e-06 pd=7.1e-07 nrd=1.16667 \
        nrs=1.16667 sa=1.4e-07 sb=7.45e-07 sd=160n sca=24.7768 \
        scb=0.0281397 scc=0.00159433 m=(1)
mp1 (\3\:n3 \1\:A1 \6\:VDD VDD) g45p1lvt w=(2.15e-07) l=4.5e-08 nf=1 \
        as=5.515e-14 ad=3.44e-14 ps=1.45e-06 pd=7.5e-07 nrd=1.16667 \
        nrs=1.16667 sa=3.35e-07 sb=5.5e-07 sd=160n sca=14.9462 \
        scb=0.0138238 scc=0.000237852 m=(1)
mp3 (\8\:n0 \1\:B1 \3\:n3 VDD) g45p1lvt w=(2.15e-07) l=4.5e-08 nf=1 \
        as=3.44e-14 ad=3.44e-14 ps=7.5e-07 pd=7.5e-07 nrd=1.16667 \
        nrs=1.16667 sa=5.4e-07 sb=3.45e-07 sd=160n sca=12.4379 \
        scb=0.00997048 scc=0.000189166 m=(1)
mp2 (\8\:n0 \4\:B0 n3 VDD) g45p1lvt w=(2.15e-07) l=4.5e-08 nf=1 \
        as=3.01e-14 ad=3.44e-14 ps=7.1e-07 pd=7.5e-07 nrd=1.16667 \
        nrs=1.16667 sa=7.45e-07 sb=1.4e-07 sd=160n sca=11.9066 \
        scb=0.00936839 scc=0.000188025 m=(1)
C1 (B0 VSS) capacitor c=4.76196e-17
C2 (A0 VSS) capacitor c=4.55037e-17
C3 (VDD VSS) capacitor c=1.24273e-16
C4 (B1 VSS) capacitor c=2.61387e-17
C5 (A1 VSS) capacitor c=2.94026e-17
C6 (n0 VSS) capacitor c=3.87009e-17
C7 (n2 VSS) capacitor c=6.05147e-18
C8 (n3 VSS) capacitor c=6.31164e-17
C9 (\4\:B0 VSS) capacitor c=5.18147e-17
C10 (\1\:B1 VSS) capacitor c=5.66909e-17
C11 (\1\:A1 VSS) capacitor c=5.56438e-17
C12 (\3\:A0 VSS) capacitor c=5.40822e-17
C13 (\3\:n0 VSS) capacitor c=4.56462e-17
C14 (\3\:B0 VSS) capacitor c=2.46414e-17
C15 (\3\:B1 VSS) capacitor c=3.48344e-17
C16 (\3\:A1 VSS) capacitor c=6.64302e-17
C17 (\1\:A0 VSS) capacitor c=4.51009e-17
C18 (\2\:n0 VSS) capacitor c=2.91833e-17
C19 (\1\:B0 VSS) capacitor c=1.93955e-17
C20 (\2\:B1 VSS) capacitor c=5.09544e-17
C21 (\2\:A1 VSS) capacitor c=5.73712e-17
C22 (\2\:A0 VSS) capacitor c=5.03071e-17
C23 (\3\:Y VSS) capacitor c=8.75645e-17
C24 (\1\:VDD VSS) capacitor c=9.24865e-17
C25 (\8\:n0 VSS) capacitor c=4.18382e-17
C26 (\3\:n3 VSS) capacitor c=6.9561e-17
C27 (\6\:VDD VSS) capacitor c=1.12592e-17
C28 (\5\:n3 VSS) capacitor c=3.65746e-17
C29 (\1\:Y VSS) capacitor c=6.60863e-17
C30 (\6\:n0 VSS) capacitor c=8.41802e-17
C31 (\2\:B0 VSS) capacitor c=3.29247e-17
C32 (\4\:A0 VSS) capacitor c=5.40388e-17
C33 (\4\:A1 VSS) capacitor c=3.75748e-17
C34 (\4\:B1 VSS) capacitor c=6.5046e-17
C35 (\5\:B0 VSS) capacitor c=6.30741e-17
C36 (\4\:n0 VSS) capacitor c=4.79358e-17
C37 (\5\:n0 VSS) capacitor c=1.10407e-16
C38 (\4\:VDD VSS) capacitor c=4.13917e-17
C39 (\5\:VDD VSS) capacitor c=1.16592e-17
Rk6 (B0 \5\:B0) resistor r=0.1099 c=0
Rk1 (\4\:A0 A0) resistor r=0.2486 c=0
Rk16 (\2\:VSS \4\:VSS) resistor r=0.415 c=0
Rk18 (\5\:VSS VSS) resistor r=0.0446 c=0
Rk17 (\4\:VSS \5\:VSS) resistor r=0.3051 c=0
Rk19 (\5\:VSS \7\:VSS) resistor r=0.2782 c=0
Rk12 (\2\:VDD \4\:VDD) resistor r=0.4733 c=0
Rk14 (\5\:VDD VDD) resistor r=0.1172 c=0
Rk13 (\4\:VDD \5\:VDD) resistor r=0.2325 c=0
Rk15 (\5\:VDD \7\:VDD) resistor r=0.07311 c=0
Rk3 (B1 \4\:B1) resistor r=0.02602 c=0
Rk2 (A1 \4\:A1) resistor r=0.02681 c=0
Rk10 (\2\:Y Y) resistor r=0.5751 c=0
Rk11 (Y \4\:Y) resistor r=0.004834 c=0
Rk7 (\4\:n0 \5\:n0) resistor r=0.2796 c=0
Rk8 (\5\:n0 \7\:n0) resistor r=0.49 c=0
Rk9 (\5\:n0 \9\:n0) resistor r=0.1947 c=0
Rk4 (\2\:n3 \4\:n3) resistor r=0.3951 c=0
Rk5 (\4\:n3 \6\:n3) resistor r=0.2726 c=0
Rl9 (\2\:B0 \4\:B0) resistor r=171.957 c=0
Rl8 (\2\:B0 \3\:B0) resistor r=45.0334 c=0
Rl7 (\1\:B0 \2\:B0) resistor r=5.0163 c=0
Rl2 (\2\:A0 \3\:A0) resistor r=161.333 c=0
Rl1 (\1\:A0 \2\:A0) resistor r=55.7464 c=0
Rl5 (\1\:B1 \2\:B1) resistor r=156.461 c=0
Rl6 (\2\:B1 \3\:B1) resistor r=44.9225 c=0
Rl3 (\1\:A1 \2\:A1) resistor r=91.5405 c=0
Rl4 (\2\:A1 \3\:A1) resistor r=106.925 c=0
Rl10 (n0 \2\:n0) resistor r=35.7713 c=0
Rl11 (\2\:n0 \3\:n0) resistor r=133.848 c=0
Rz4 (\1\:VSS \2\:VSS) resistor r=37.5 c=0
Rz5 (\6\:VSS \7\:VSS) resistor r=75 c=0
Rz2 (\1\:Y \2\:Y) resistor r=37.5 c=0
Rz1 (\6\:n0 \7\:n0) resistor r=75 c=0
Ry6 (\1\:VDD \2\:VDD) resistor r=20.6667 c=0
Ry7 (\6\:VDD \7\:VDD) resistor r=62 c=0
Ry5 (\3\:Y \4\:Y) resistor r=20.6667 c=0
Ry4 (\8\:n0 \9\:n0) resistor r=62 c=0
Ry1 (n3 \2\:n3) resistor r=62 c=0
Ry2 (\3\:n3 \4\:n3) resistor r=62 c=0
Ry3 (\5\:n3 \6\:n3) resistor r=62 c=0
Rx4 (\1\:B0 \5\:B0) resistor r=45 c=0
Rx1 (\2\:A0 \4\:A0) resistor r=45 c=0
Rx3 (\2\:B1 \4\:B1) resistor r=45 c=0
Rx2 (\2\:A1 \4\:A1) resistor r=45 c=0
Rx5 (\2\:n0 \4\:n0) resistor r=45 c=0
mn0 (n1 \1\:A0 \6\:VSS VSS) g45n1lvt w=(1.45e-07) l=4.5e-08 nf=1 \
        as=2.03e-14 ad=8.7e-15 ps=5.7e-07 pd=4.1e-07 nrd=1.16667 \
        nrs=1.16667 sa=1.4e-07 sb=1.06e-06 sd=160n sca=10.9472 \
        scb=0.0104991 scc=0.000356047 m=(1)
mn1 (\6\:n0 \3\:A1 n1 VSS) g45n1lvt w=(1.45e-07) l=4.5e-08 nf=1 \
        as=8.7e-15 ad=2.32e-14 ps=4.1e-07 pd=6.1e-07 nrd=1.16667 \
        nrs=1.16667 sa=2.45e-07 sb=9.55e-07 sd=160n sca=10.9472 \
        scb=0.0104991 scc=0.000356047 m=(1)
mn3 (\6\:n0 \3\:B1 n2 VSS) g45n1lvt w=(1.45e-07) l=4.5e-08 nf=1 \
        as=2.32e-14 ad=2.32e-14 ps=6.1e-07 pd=6.1e-07 nrd=1.16667 \
        nrs=1.16667 sa=4.5e-07 sb=7.5e-07 sd=160n sca=10.9472 \
        scb=0.0104991 scc=0.000356047 m=(1)
mn2 (n2 \3\:B0 \1\:VSS VSS) g45n1lvt w=(1.45e-07) l=4.5e-08 nf=1 \
        as=6.83e-14 ad=2.32e-14 ps=1.24e-06 pd=6.1e-07 nrd=1.16667 \
        nrs=1.16667 sa=6.55e-07 sb=5.45e-07 sd=160n sca=10.9472 \
        scb=0.0104991 scc=0.000356047 m=(1)
mn4 (\1\:Y \3\:n0 \1\:VSS VSS) g45n1lvt w=(2.6e-07) l=4.5e-08 nf=1 \
        as=6.83e-14 ad=3.64e-14 ps=1.24e-06 pd=8e-07 nrd=1.16667 \
        nrs=1.16667 sa=6.53077e-07 sb=1.4e-07 sd=160n sca=9.14564 \
        scb=0.00759168 scc=0.000213449 m=(1)
mp4 (\3\:Y n0 \1\:VDD VDD) g45p1lvt w=(3.9e-07) l=4.5e-08 nf=1 \
        as=5.46e-14 ad=5.46e-14 ps=1.06e-06 pd=1.06e-06 nrd=1.16667 \
        nrs=1.16667 sa=1.4e-07 sb=1.4e-07 sd=160n sca=16.2631 \
        scb=0.0157178 scc=0.000443168 m=(1)
ends AO22X1
// End of subcircuit definition.
