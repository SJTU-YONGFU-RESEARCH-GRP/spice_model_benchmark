// Generated for: spectre (May  1 09:19:38 2013 )
// Library name: gsclib045_lvt
// Cell name: TLATXL
// View name: extracted

simulator lang=spectre

subckt TLATXL D G Q QN VDD VSS
mp1 (\8\:Gbb Gb \13\:VDD VDD) g45p1lvt w=(2.15e-07) l=4.5e-08 nf=1 \
        as=3.655e-14 ad=3.655e-14 ps=7.7e-07 pd=7.7e-07 nrd=1.16667 \
        nrs=1.16667 sa=1.7e-07 sb=1.275e-06 sd=160n sca=16.8928 \
        scb=0.0171325 scc=0.000344283 m=(1)
mp5 (net220 \1\:D \13\:VDD VDD) g45p1lvt w=(2.15e-07) l=4.5e-08 nf=1 \
        as=3.655e-14 ad=3.655e-14 ps=7.7e-07 pd=7.7e-07 nrd=1.16667 \
        nrs=1.16667 sa=3.85e-07 sb=1.06e-06 sd=160n sca=12.2564 \
        scb=0.00923826 scc=8.62349e-05 m=(1)
mp6 (\6\:n0 \4\:Gb net220 VDD) g45p1lvt w=(2.15e-07) l=4.5e-08 nf=1 \
        as=3.655e-14 ad=5.483e-14 ps=7.7e-07 pd=9.4e-07 nrd=1.16667 \
        nrs=1.16667 sa=6e-07 sb=8.45e-07 sd=160n sca=10.8469 \
        scb=0.00772406 scc=8.06202e-05 m=(1)
mp16 (\6\:n0 Gbb net212 VDD) g45p1lvt w=(2.15e-07) l=4.5e-08 nf=1 \
        as=1.935e-14 ad=5.483e-14 ps=6.1e-07 pd=9.4e-07 nrd=1.16667 \
        nrs=1.16667 sa=9e-07 sb=5.45e-07 sd=160n sca=10.2104 \
        scb=0.00747301 scc=8.05149e-05 m=(1)
mp15 (net212 \3\:Qint \9\:VDD VDD) g45p1lvt w=(2.15e-07) l=4.5e-08 nf=1 \
        as=7.537e-14 ad=1.935e-14 ps=1.33e-06 pd=6.1e-07 nrd=1.16667 \
        nrs=1.16667 sa=1.035e-06 sb=4.1e-07 sd=160n sca=10.2104 \
        scb=0.00747301 scc=8.05149e-05 m=(1)
mp10 (\17\:Qint \3\:n0 \9\:VDD VDD) g45p1lvt w=(2.15e-07) l=4.5e-08 nf=1 \
        as=7.537e-14 ad=3.01e-14 ps=1.33e-06 pd=7.1e-07 nrd=1.16667 \
        nrs=1.16667 sa=1.305e-06 sb=1.4e-07 sd=160n sca=10.2104 \
        scb=0.00747301 scc=8.05149e-05 m=(1)
mp0 (\14\:Gb \3\:G \6\:VDD VDD) g45p1lvt w=(2.15e-07) l=4.5e-08 nf=1 \
        as=3.547e-14 ad=3.655e-14 ps=7.6e-07 pd=7.7e-07 nrd=1.16667 \
        nrs=1.16667 sa=1.7e-07 sb=3.5e-07 sd=160n sca=10.3756 \
        scb=0.00778655 scc=9.84544e-05 m=(1)
mp22 (\3\:QN \10\:Qint \6\:VDD VDD) g45p1lvt w=(2.15e-07) l=4.5e-08 nf=1 \
        as=3.547e-14 ad=3.01e-14 ps=7.6e-07 pd=7.1e-07 nrd=1.16667 \
        nrs=1.16667 sa=3.8e-07 sb=1.4e-07 sd=160n sca=10.3756 \
        scb=0.00778655 scc=9.84544e-05 m=(1)
mp20 (\7\:Qbint \8\:Qint \1\:VDD VDD) g45p1lvt w=(2.15e-07) l=4.5e-08 \
        nf=1 as=3.44e-14 ad=3.01e-14 ps=7.5e-07 pd=7.1e-07 nrd=1.16667 \
        nrs=1.16667 sa=1.4e-07 sb=4.15e-07 sd=160n sca=35.6619 \
        scb=0.0280625 scc=0.00428121 m=(1)
mp21 (\1\:Q \4\:Qbint \1\:VDD VDD) g45p1lvt w=(2.15e-07) l=4.5e-08 nf=1 \
        as=3.44e-14 ad=4.515e-14 ps=7.5e-07 pd=8.5e-07 nrd=1.16667 \
        nrs=1.16667 sa=3.45e-07 sb=2.1e-07 sd=160n sca=40.8819 \
        scb=0.0369433 scc=0.00464292 m=(1)
C1 (G VSS) capacitor c=4.84243e-17
C2 (QN VSS) capacitor c=6.73343e-17
C3 (D VSS) capacitor c=1.17282e-16
C4 (VDD VSS) capacitor c=2.20551e-16
C5 (Q VSS) capacitor c=1.62424e-17
C6 (Gb VSS) capacitor c=2.83924e-17
C7 (Gbb VSS) capacitor c=7.30952e-17
C8 (net257 VSS) capacitor c=1.11361e-17
C9 (n0 VSS) capacitor c=3.41733e-17
C10 (Qint VSS) capacitor c=8.82648e-17
C11 (Qbint VSS) capacitor c=3.37146e-17
C12 (net212 VSS) capacitor c=1.45695e-18
C13 (\4\:Qbint VSS) capacitor c=2.93798e-17
C14 (\8\:Qint VSS) capacitor c=4.0536e-17
C15 (\10\:Qint VSS) capacitor c=6.78011e-17
C16 (\3\:G VSS) capacitor c=3.28762e-17
C17 (\3\:n0 VSS) capacitor c=6.34393e-17
C18 (\3\:Qint VSS) capacitor c=6.34648e-17
C19 (\4\:Gb VSS) capacitor c=3.1397e-17
C20 (\1\:D VSS) capacitor c=5.15507e-17
C21 (\4\:Qint VSS) capacitor c=2.11785e-17
C22 (\9\:Qint VSS) capacitor c=2.70883e-17
C23 (\1\:G VSS) capacitor c=7.07554e-17
C24 (\6\:Gb VSS) capacitor c=7.60398e-17
C25 (\4\:Gbb VSS) capacitor c=3.33432e-17
C26 (\3\:D VSS) capacitor c=4.2283e-17
C27 (\3\:Gb VSS) capacitor c=5.11966e-17
C28 (\3\:Qbint VSS) capacitor c=2.14591e-17
C29 (\7\:Qint VSS) capacitor c=5.698e-17
C30 (\2\:G VSS) capacitor c=7.25257e-17
C31 (\2\:n0 VSS) capacitor c=6.3873e-17
C32 (\2\:Qint VSS) capacitor c=8.08445e-17
C33 (\7\:Gb VSS) capacitor c=3.93074e-17
C34 (\5\:Gb VSS) capacitor c=3.5228e-17
C35 (\3\:Gbb VSS) capacitor c=2.72777e-17
C36 (\2\:D VSS) capacitor c=4.86436e-17
C37 (\2\:Gb VSS) capacitor c=4.73361e-17
C38 (\1\:Q VSS) capacitor c=1.57222e-17
C39 (\1\:VDD VSS) capacitor c=3.84945e-17
C40 (\7\:Qbint VSS) capacitor c=2.96348e-17
C41 (\3\:QN VSS) capacitor c=2.34099e-17
C42 (\6\:VDD VSS) capacitor c=3.12592e-17
C43 (\14\:Gb VSS) capacitor c=1.11644e-16
C44 (\17\:Qint VSS) capacitor c=4.36862e-17
C45 (\9\:VDD VSS) capacitor c=2.53087e-17
C46 (\6\:n0 VSS) capacitor c=8.01923e-17
C47 (\13\:VDD VSS) capacitor c=3.46206e-17
C48 (\8\:Gbb VSS) capacitor c=6.20865e-17
C49 (\3\:VDD VSS) capacitor c=5.37689e-17
C50 (\3\:Q VSS) capacitor c=3.00297e-17
C51 (\9\:Qbint VSS) capacitor c=3.53809e-17
C52 (\1\:QN VSS) capacitor c=8.3669e-17
C53 (\8\:Gb VSS) capacitor c=8.2607e-17
C54 (\11\:Qint VSS) capacitor c=2.74014e-17
C55 (\8\:n0 VSS) capacitor c=4.14265e-17
C56 (\6\:Gbb VSS) capacitor c=6.61346e-17
C57 (\2\:Gbb VSS) capacitor c=3.72639e-17
C58 (\5\:Qint VSS) capacitor c=3.42811e-17
C59 (\6\:Qint VSS) capacitor c=1.69205e-17
C60 (\2\:Qbint VSS) capacitor c=1.38948e-17
C61 (\5\:Gbb VSS) capacitor c=8.93721e-17
C62 (\4\:n0 VSS) capacitor c=3.83749e-17
C63 (\5\:n0 VSS) capacitor c=7.61203e-17
C64 (\10\:Gb VSS) capacitor c=1.60751e-16
C65 (\11\:Gb VSS) capacitor c=1.03221e-16
C66 (\12\:Gb VSS) capacitor c=1.28902e-16
C67 (\13\:Gb VSS) capacitor c=6.76728e-17
C68 (\4\:G VSS) capacitor c=3.48497e-17
C69 (\13\:Qint VSS) capacitor c=4.40983e-17
C70 (\14\:Qint VSS) capacitor c=4.84893e-17
C71 (\15\:Qint VSS) capacitor c=2.76015e-17
C72 (\16\:Qint VSS) capacitor c=6.1142e-17
C73 (\5\:Qbint VSS) capacitor c=2.35723e-17
C74 (\6\:Qbint VSS) capacitor c=2.19928e-17
C75 (\5\:VDD VSS) capacitor c=4.33118e-17
C76 (\8\:VDD VSS) capacitor c=1.82256e-17
C77 (\12\:VDD VSS) capacitor c=2.44435e-17
Rk12 (G \4\:G) resistor r=0.1856 c=0
Rk18 (\2\:QN QN) resistor r=0.5789 c=0
Rk19 (QN \4\:QN) resistor r=0.05589 c=0
Rk1 (\4\:D D) resistor r=0.001683 c=0
Rk34 (\2\:VDD \4\:VDD) resistor r=0.451 c=0
Rk35 (\4\:VDD \5\:VDD) resistor r=0.4133 c=0
Rk36 (\5\:VDD \7\:VDD) resistor r=0.1789 c=0
Rk37 (\5\:VDD \8\:VDD) resistor r=0.3369 c=0
Rk38 (\8\:VDD \10\:VDD) resistor r=0.04326 c=0
Rk39 (\8\:VDD \11\:VDD) resistor r=0.04897 c=0
Rk42 (\12\:VDD VDD) resistor r=0.1524 c=0
Rk40 (\11\:VDD \12\:VDD) resistor r=0.3982 c=0
Rk41 (\12\:VDD \14\:VDD) resistor r=0.2226 c=0
Rk23 (Q \2\:Q) resistor r=0.07781 c=0
Rk24 (Q \4\:Q) resistor r=0.1915 c=0
Rk25 (\2\:VSS \4\:VSS) resistor r=0.3555 c=0
Rk26 (\4\:VSS \5\:VSS) resistor r=0.3606 c=0
Rk27 (\5\:VSS \6\:VSS) resistor r=0.3629 c=0
Rk28 (\6\:VSS \7\:VSS) resistor r=0.07748 c=0
Rk30 (\8\:VSS VSS) resistor r=0.1674 c=0
Rk29 (\7\:VSS \8\:VSS) resistor r=0.3832 c=0
Rk31 (\5\:VSS \10\:VSS) resistor r=0.2882 c=0
Rk32 (\6\:VSS \12\:VSS) resistor r=0.07334 c=0
Rk33 (\8\:VSS \14\:VSS) resistor r=0.07334 c=0
Rk7 (\9\:Gb \10\:Gb) resistor r=0.6321 c=0
Rk8 (\10\:Gb \11\:Gb) resistor r=0.7103 c=0
Rk9 (\11\:Gb \12\:Gb) resistor r=0.1302 c=0
Rk10 (\12\:Gb \13\:Gb) resistor r=0.3464 c=0
Rk11 (\12\:Gb \15\:Gb) resistor r=0.9488 c=0
Rk2 (\5\:Gbb \7\:Gbb) resistor r=0.4931 c=0
Rk3 (\7\:Gbb \9\:Gbb) resistor r=0.5303 c=0
Rk4 (\4\:n0 \5\:n0) resistor r=0.2377 c=0
Rk5 (\5\:n0 \7\:n0) resistor r=0.5164 c=0
Rk6 (\5\:n0 \9\:n0) resistor r=0.1271 c=0
Rk13 (\12\:Qint \13\:Qint) resistor r=0.1044 c=0
Rk14 (\13\:Qint \14\:Qint) resistor r=0.3093 c=0
Rk15 (\14\:Qint \15\:Qint) resistor r=0.1899 c=0
Rk16 (\13\:Qint \16\:Qint) resistor r=0.2829 c=0
Rk17 (\14\:Qint \18\:Qint) resistor r=0.1856 c=0
Rk20 (\5\:Qbint \6\:Qbint) resistor r=0.1209 c=0
Rk21 (\6\:Qbint \8\:Qbint) resistor r=0.1268 c=0
Rk22 (\6\:Qbint \10\:Qbint) resistor r=0.2057 c=0
Rl15 (\2\:G \3\:G) resistor r=26.3736 c=0
Rl14 (\1\:G \2\:G) resistor r=239.129 c=0
Rl3 (\1\:D \2\:D) resistor r=117.999 c=0
Rl4 (\2\:D \3\:D) resistor r=102.615 c=0
Rl9 (\6\:Gb \7\:Gb) resistor r=31.0185 c=0
Rl5 (\4\:Gb \5\:Gb) resistor r=66.5405 c=0
Rl1 (Gb \2\:Gb) resistor r=29.5379 c=0
Rl2 (\2\:Gb \3\:Gb) resistor r=191.076 c=0
Rl6 (Gbb \2\:Gbb) resistor r=196.221 c=0
Rl8 (\2\:Gbb \4\:Gbb) resistor r=50.349 c=0
Rl7 (\2\:Gbb \3\:Gbb) resistor r=80.5242 c=0
Rl13 (\2\:n0 \3\:n0) resistor r=191.483 c=0
Rl12 (n0 \2\:n0) resistor r=30.5087 c=0
Rl21 (\7\:Qint \10\:Qint) resistor r=222.253 c=0
Rl11 (\2\:Qint \3\:Qint) resistor r=109.593 c=0
Rl10 (Qint \2\:Qint) resistor r=132.487 c=0
Rl19 (\5\:Qint \8\:Qint) resistor r=82.3738 c=0
Rl16 (\4\:Qint \5\:Qint) resistor r=44.2087 c=0
Rl20 (\6\:Qint \9\:Qint) resistor r=32.1542 c=0
Rl18 (\6\:Qint \7\:Qint) resistor r=6.0041 c=0
Rl17 (\5\:Qint \6\:Qint) resistor r=203.768 c=0
Rl24 (\2\:Qbint \4\:Qbint) resistor r=23.7402 c=0
Rl22 (Qbint \2\:Qbint) resistor r=100.308 c=0
Rl23 (\2\:Qbint \3\:Qbint) resistor r=5.8511 c=0
Rz5 (\1\:QN \2\:QN) resistor r=75 c=0
Rz12 (\3\:VDD \4\:VDD) resistor r=18.75 c=0
Rz13 (\3\:VDD \11\:VDD) resistor r=6.25 c=0
Rz7 (\3\:Q \4\:Q) resistor r=75 c=0
Rz8 (\1\:VSS \2\:VSS) resistor r=75 c=0
Rz9 (\9\:VSS \10\:VSS) resistor r=75 c=0
Rz10 (\11\:VSS \12\:VSS) resistor r=75 c=0
Rz11 (\13\:VSS \14\:VSS) resistor r=75 c=0
Rz3 (\8\:Gb \9\:Gb) resistor r=75 c=0
Rz1 (\6\:Gbb \7\:Gbb) resistor r=75 c=0
Rz2 (\8\:n0 \9\:n0) resistor r=75 c=0
Rz4 (\11\:Qint \12\:Qint) resistor r=75 c=0
Rz6 (\9\:Qbint \10\:Qbint) resistor r=75 c=0
Ry5 (\3\:QN \4\:QN) resistor r=62 c=0
Ry10 (\1\:VDD \2\:VDD) resistor r=62 c=0
Ry11 (\6\:VDD \7\:VDD) resistor r=62 c=0
Ry12 (\9\:VDD \10\:VDD) resistor r=62 c=0
Ry13 (\13\:VDD \14\:VDD) resistor r=62 c=0
Ry7 (\1\:Q \2\:Q) resistor r=62 c=0
Ry8 (\3\:VSS \4\:VSS) resistor r=15.5 c=0
Ry9 (\3\:VSS \7\:VSS) resistor r=5.1667 c=0
Ry3 (\14\:Gb \15\:Gb) resistor r=62 c=0
Ry1 (\8\:Gbb \9\:Gbb) resistor r=62 c=0
Ry2 (\6\:n0 \7\:n0) resistor r=62 c=0
Ry4 (\17\:Qint \18\:Qint) resistor r=62 c=0
Ry6 (\7\:Qbint \8\:Qbint) resistor r=62 c=0
Rx7 (\2\:G \4\:G) resistor r=45 c=0
Rx1 (\2\:D \4\:D) resistor r=45 c=0
Rx4 (\7\:Gb \10\:Gb) resistor r=45 c=0
Rx5 (\5\:Gb \11\:Gb) resistor r=45 c=0
Rx6 (\2\:Gb \13\:Gb) resistor r=45 c=0
Rx2 (\3\:Gbb \5\:Gbb) resistor r=45 c=0
Rx3 (\2\:n0 \4\:n0) resistor r=45 c=0
Rx8 (\2\:Qint \15\:Qint) resistor r=45 c=0
Rx9 (\7\:Qint \16\:Qint) resistor r=45 c=0
Rx10 (\3\:Qbint \5\:Qbint) resistor r=45 c=0
mn1 (\6\:Gbb \3\:Gb \13\:VSS VSS) g45n1lvt w=(1.45e-07) l=4.5e-08 nf=1 \
        as=4.93e-14 ad=2.03e-14 ps=1.42e-06 pd=5.7e-07 nrd=1.16667 \
        nrs=1.16667 sa=1.4e-07 sb=1.41e-06 sd=160n sca=11.7118 \
        scb=0.0116498 scc=0.000458536 m=(1)
mn5 (net257 \3\:D \13\:VSS VSS) g45n1lvt w=(1.45e-07) l=4.5e-08 nf=1 \
        as=4.93e-14 ad=6.598e-14 ps=1.42e-06 pd=1.2e-06 nrd=1.16667 \
        nrs=1.16667 sa=3.55e-07 sb=1.195e-06 sd=160n sca=11.7118 \
        scb=0.0116498 scc=0.000458536 m=(1)
mn6 (\8\:n0 \4\:Gbb net257 VSS) g45n1lvt w=(1.45e-07) l=4.5e-08 nf=1 \
        as=6.598e-14 ad=2.32e-14 ps=1.2e-06 pd=6.1e-07 nrd=1.16667 \
        nrs=1.16667 sa=8.55e-07 sb=6.95e-07 sd=160n sca=11.7118 \
        scb=0.0116498 scc=0.000458536 m=(1)
mn16 (\8\:n0 \6\:Gb net245 VSS) g45n1lvt w=(1.45e-07) l=4.5e-08 nf=1 \
        as=8.7e-15 ad=2.32e-14 ps=4.1e-07 pd=6.1e-07 nrd=1.16667 \
        nrs=1.16667 sa=1.06e-06 sb=4.9e-07 sd=160n sca=11.7118 \
        scb=0.0116498 scc=0.000458536 m=(1)
mn15 (net245 Qint \11\:VSS VSS) g45n1lvt w=(1.45e-07) l=4.5e-08 nf=1 \
        as=5.06e-14 ad=8.7e-15 ps=1.45e-06 pd=4.1e-07 nrd=1.16667 \
        nrs=1.16667 sa=1.165e-06 sb=3.85e-07 sd=160n sca=11.7118 \
        scb=0.0116498 scc=0.000458536 m=(1)
mn10 (\11\:Qint n0 \11\:VSS VSS) g45n1lvt w=(1.45e-07) l=4.5e-08 nf=1 \
        as=5.06e-14 ad=2.755e-14 ps=1.45e-06 pd=6.7e-07 nrd=1.16667 \
        nrs=1.16667 sa=1.36e-06 sb=1.9e-07 sd=160n sca=11.7118 \
        scb=0.0116498 scc=0.000458536 m=(1)
mn0 (\8\:Gb \1\:G \9\:VSS VSS) g45n1lvt w=(1.45e-07) l=4.5e-08 nf=1 \
        as=2.32e-14 ad=2.03e-14 ps=6.1e-07 pd=5.7e-07 nrd=1.16667 \
        nrs=1.16667 sa=1.4e-07 sb=3.6e-07 sd=160n sca=10.4914 \
        scb=0.00978575 scc=0.000300434 m=(1)
mn22 (\1\:QN \9\:Qint \9\:VSS VSS) g45n1lvt w=(1.45e-07) l=4.5e-08 nf=1 \
        as=2.32e-14 ad=2.247e-14 ps=6.1e-07 pd=6e-07 nrd=1.16667 \
        nrs=1.16667 sa=3.45e-07 sb=1.55e-07 sd=160n sca=10.4914 \
        scb=0.00978575 scc=0.000300434 m=(1)
mn20 (\9\:Qbint \4\:Qint \1\:VSS VSS) g45n1lvt w=(1.45e-07) l=4.5e-08 \
        nf=1 as=2.827e-14 ad=2.03e-14 ps=6.8e-07 pd=5.7e-07 nrd=1.16667 \
        nrs=1.16667 sa=1.4e-07 sb=3.8e-07 sd=160n sca=14.7993 \
        scb=0.0157101 scc=0.000964917 m=(1)
mn21 (\3\:Q Qbint \1\:VSS VSS) g45n1lvt w=(1.45e-07) l=4.5e-08 nf=1 \
        as=2.827e-14 ad=2.03e-14 ps=6.8e-07 pd=5.7e-07 nrd=1.16667 \
        nrs=1.16667 sa=3.8e-07 sb=1.4e-07 sd=160n sca=14.7993 \
        scb=0.0157101 scc=0.000964917 m=(1)
ends TLATXL
// End of subcircuit definition.
