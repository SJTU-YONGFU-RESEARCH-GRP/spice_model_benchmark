// Generated for: spectre (May  1 09:17:30 2013 )
// Library name: gsclib045_lvt
// Cell name: NOR4BBX2
// View name: extracted

simulator lang=spectre

subckt NOR4BBX2 AN BN C D VDD VSS Y
mp1 (\9\:n1 \1\:BN \8\:VDD VDD) g45p1lvt w=(2.15e-07) l=4.5e-08 nf=1 \
        as=6.11e-14 ad=3.655e-14 ps=1.1e-06 pd=7.7e-07 nrd=1.16667 \
        nrs=1.16667 sa=1.7e-07 sb=4.20814e-07 sd=160n sca=28.0767 \
        scb=0.0303449 scc=0.00237588 m=(1)
mp0 (\9\:n0 \1\:AN \8\:VDD VDD) g45p1lvt w=(2.15e-07) l=4.5e-08 nf=1 \
        as=6.11e-14 ad=3.35e-14 ps=1.1e-06 pd=8.3e-07 nrd=1.16667 \
        nrs=1.16667 sa=4.35e-07 sb=1.55814e-07 sd=160n sca=22.8052 \
        scb=0.0215313 scc=0.00209094 m=(1)
C1 (BN VSS) capacitor c=5.11761e-17
C2 (D VSS) capacitor c=4.88067e-17
C3 (Y VSS) capacitor c=4.11715e-17
C4 (VDD VSS) capacitor c=1.22067e-16
C5 (C VSS) capacitor c=3.96326e-17
C6 (AN VSS) capacitor c=8.48176e-17
C7 (n1 VSS) capacitor c=1.97461e-16
C8 (n0 VSS) capacitor c=9.2593e-17
C9 (n2 VSS) capacitor c=2.48566e-16
C10 (n3 VSS) capacitor c=1.08436e-16
C11 (n4 VSS) capacitor c=1.83285e-16
C12 (\1\:D VSS) capacitor c=1.67733e-16
C13 (\1\:C VSS) capacitor c=1.97899e-16
C14 (\1\:AN VSS) capacitor c=3.13601e-17
C15 (\1\:BN VSS) capacitor c=4.17992e-17
C16 (\3\:AN VSS) capacitor c=4.49826e-17
C17 (\3\:BN VSS) capacitor c=3.07454e-17
C18 (\3\:n0 VSS) capacitor c=8.413e-17
C19 (\2\:AN VSS) capacitor c=2.78467e-17
C20 (\2\:BN VSS) capacitor c=2.87729e-17
C21 (\9\:Y VSS) capacitor c=6.17728e-17
C22 (\3\:n3 VSS) capacitor c=9.32122e-17
C23 (\6\:VDD VSS) capacitor c=6.30876e-17
C24 (\9\:n0 VSS) capacitor c=5.83608e-17
C25 (\8\:VDD VSS) capacitor c=3.20007e-17
C26 (\9\:n1 VSS) capacitor c=5.39244e-17
C27 (\1\:VDD VSS) capacitor c=7.64431e-17
C28 (\1\:Y VSS) capacitor c=5.6049e-17
C29 (\3\:Y VSS) capacitor c=6.74746e-17
C30 (\5\:Y VSS) capacitor c=6.22757e-17
C31 (\7\:Y VSS) capacitor c=5.64077e-17
C32 (\11\:n0 VSS) capacitor c=5.03123e-17
C33 (\7\:n1 VSS) capacitor c=1.90704e-16
C34 (\4\:AN VSS) capacitor c=3.9233e-17
C35 (\4\:BN VSS) capacitor c=7.44468e-17
C36 (\7\:n0 VSS) capacitor c=6.73098e-17
C37 (\8\:n0 VSS) capacitor c=5.4884e-17
C38 (\6\:n1 VSS) capacitor c=1.76774e-16
C39 (\8\:C VSS) capacitor c=7.74608e-17
C40 (\8\:D VSS) capacitor c=6.02011e-17
C41 (\4\:VDD VSS) capacitor c=1.03707e-17
C42 (\5\:VDD VSS) capacitor c=1.19637e-17
Rk2 (BN \4\:BN) resistor r=0.1085 c=0
Rk12 (\8\:D D) resistor r=0.1691 c=0
Rk16 (\2\:Y Y) resistor r=0.1955 c=0
Rk13 (\2\:Y \4\:Y) resistor r=0.2877 c=0
Rk14 (\4\:Y \6\:Y) resistor r=0.3704 c=0
Rk15 (\6\:Y \8\:Y) resistor r=0.2975 c=0
Rk17 (Y \10\:Y) resistor r=0.2495 c=0
Rk34 (\2\:VDD \3\:VDD) resistor r=0.752 c=0
Rk35 (\3\:VDD \4\:VDD) resistor r=0.0349 c=0
Rk37 (\5\:VDD VDD) resistor r=0.165 c=0
Rk36 (\4\:VDD \5\:VDD) resistor r=0.3505 c=0
Rk38 (\4\:VDD \7\:VDD) resistor r=0.3456 c=0
Rk39 (\5\:VDD \9\:VDD) resistor r=0.2898 c=0
Rk10 (C \8\:C) resistor r=0.06228 c=0
Rk1 (\4\:AN AN) resistor r=0.1266 c=0
Rk28 (\10\:VSS VSS) resistor r=0.165 c=0
Rk27 (\1\:VSS \10\:VSS) resistor r=0.343 c=0
Rk33 (\10\:VSS \20\:VSS) resistor r=0.186 c=0
Rk6 (\6\:n1 \8\:n1) resistor r=1.4337 c=0
Rk7 (\8\:n1 \10\:n1) resistor r=0.3995 c=0
Rk3 (\7\:n0 \8\:n0) resistor r=0.3198 c=0
Rk4 (\8\:n0 \10\:n0) resistor r=0.1901 c=0
Rk5 (\8\:n0 \12\:n0) resistor r=0.1986 c=0
Rk11 (\2\:n3 \4\:n3) resistor r=0.5146 c=0
Rl1 (\1\:BN \2\:BN) resistor r=98.7687 c=0
Rl2 (\2\:BN \3\:BN) resistor r=39.1533 c=0
Rl3 (\1\:AN \2\:AN) resistor r=26.098 c=0
Rl4 (\2\:AN \3\:AN) resistor r=104.944 c=0
Rl6 (\3\:n0 n0) resistor r=7.0216 c=0
Rz3 (\2\:Y \1\:Y) resistor r=75 c=0
Rz4 (\4\:Y \3\:Y) resistor r=75 c=0
Rz5 (\6\:Y \5\:Y) resistor r=75 c=0
Rz6 (\8\:Y \7\:Y) resistor r=75 c=0
Rz13 (\2\:VDD \1\:VDD) resistor r=25 c=0
Rz14 (\3\:VDD \1\:VDD) resistor r=6.25 c=0
Rz12 (\20\:VSS \19\:VSS) resistor r=75 c=0
Rz2 (\8\:n1 \7\:n1) resistor r=75 c=0
Rz1 (\12\:n0 \11\:n0) resistor r=75 c=0
Ry8 (\10\:Y \9\:Y) resistor r=62 c=0
Ry14 (\7\:VDD \6\:VDD) resistor r=62 c=0
Ry15 (\9\:VDD \8\:VDD) resistor r=62 c=0
Ry2 (\10\:n1 \9\:n1) resistor r=62 c=0
Ry1 (\10\:n0 \9\:n0) resistor r=62 c=0
Ry6 (\2\:n3 n3) resistor r=62 c=0
Ry7 (\4\:n3 \3\:n3) resistor r=62 c=0
Rx2 (\2\:BN \4\:BN) resistor r=45 c=0
Rx6 (\8\:D \1\:D) resistor r=45 c=0
Rx5 (\8\:C \1\:C) resistor r=45 c=0
Rx1 (\2\:AN \4\:AN) resistor r=45 c=0
Rx4 (\6\:n1 n1) resistor r=45 c=0
Rx3 (\7\:n0 \3\:n0) resistor r=45 c=0
mn1 (\7\:n1 \3\:BN \19\:VSS VSS) g45n1lvt w=(1.45e-07) l=4.5e-08 nf=1 \
        as=5.11e-14 ad=2.03e-14 ps=1.05e-06 pd=5.7e-07 nrd=1.16667 \
        nrs=1.16667 sa=1.4e-07 sb=4.9e-07 sd=160n sca=11.7118 \
        scb=0.0116498 scc=0.000458536 m=(1)
mn0 (\11\:n0 \3\:AN \19\:VSS VSS) g45n1lvt w=(1.45e-07) l=4.5e-08 nf=1 \
        as=5.11e-14 ad=3.263e-14 ps=1.05e-06 pd=7.4e-07 nrd=1.16667 \
        nrs=1.16667 sa=4.05e-07 sb=2.25e-07 sd=160n sca=11.7118 \
        scb=0.0116498 scc=0.000458536 m=(1)
mn2 (\7\:Y n0 \1\:VSS VSS) g45n1lvt w=(2.6e-07) l=4.5e-08 nf=1 \
        as=4.095e-14 ad=4.16e-14 ps=8.35e-07 pd=8.4e-07 nrd=1.16667 \
        nrs=1.16667 sa=1.4e-07 sb=1.59e-06 sd=160n sca=7.84363 \
        scb=0.00546499 scc=9.84911e-05 m=(2)
mn5_1__rcx (\1\:Y \1\:D \1\:VSS VSS) g45n1lvt w=(2.6e-07) l=4.5e-08 nf=1 \
        as=3.9e-14 ad=4.16e-14 ps=8.2e-07 pd=8.4e-07 nrd=1.16667 \
        nrs=1.16667 sa=1.385e-06 sb=3.45e-07 sd=160n sca=7.84363 \
        scb=0.00546499 scc=9.84911e-05 m=(2)
mn3 (\5\:Y n1 \1\:VSS VSS) g45n1lvt w=(2.6e-07) l=4.5e-08 nf=1 \
        as=4.355e-14 ad=4.16e-14 ps=8.55e-07 pd=8.4e-07 nrd=1.16667 \
        nrs=1.16667 sa=5.65e-07 sb=1.165e-06 sd=160n sca=7.84363 \
        scb=0.00546499 scc=9.84911e-05 m=(2)
mn4_1__rcx (\3\:Y \1\:C \1\:VSS VSS) g45n1lvt w=(2.6e-07) l=4.5e-08 nf=1 \
        as=4.16e-14 ad=4.16e-14 ps=8.4e-07 pd=8.4e-07 nrd=1.16667 \
        nrs=1.16667 sa=9.75e-07 sb=7.55e-07 sd=160n sca=7.84363 \
        scb=0.00546499 scc=9.84911e-05 m=(2)
mp3_1__rcx (\3\:n3 n1 n2 VDD) g45p1lvt w=(3.9e-07) l=4.5e-08 nf=1 \
        as=5.85e-14 ad=6.24e-14 ps=1.08e-06 pd=1.1e-06 nrd=1.16667 \
        nrs=1.16667 sa=5.22308e-07 sb=3.45e-07 sd=160n sca=25.6993 \
        scb=0.0190507 scc=0.00277827 m=(2)
mp4 (n4 \1\:C n3 VDD) g45p1lvt w=(3.9e-07) l=4.5e-08 nf=1 as=6.24e-14 \
        ad=5.85e-14 ps=1.1e-06 pd=1.08e-06 nrd=1.16667 nrs=1.16667 \
        sa=1.4e-07 sb=7.55e-07 sd=160n sca=25.9574 scb=0.019118 \
        scc=0.00277828 m=(2)
mp2_1__rcx (n2 \3\:n0 \6\:VDD VDD) g45p1lvt w=(3.9e-07) l=4.5e-08 nf=1 \
        as=6.24e-14 ad=5.31e-14 ps=1.1e-06 pd=1.08e-06 nrd=1.16667 \
        nrs=1.16667 sa=1.12308e-07 sb=7.55e-07 sd=160n sca=25.6993 \
        scb=0.0190507 scc=0.00277827 m=(2)
mp5 (\9\:Y \1\:D n4 VDD) g45p1lvt w=(3.9e-07) l=4.5e-08 nf=1 as=5.85e-14 \
        ad=6.24e-14 ps=1.08e-06 pd=1.1e-06 nrd=1.16667 nrs=1.16667 \
        sa=5.5e-07 sb=3.45e-07 sd=160n sca=28.791 scb=0.0224678 \
        scc=0.00280266 m=(2)
ends NOR4BBX2
// End of subcircuit definition.
