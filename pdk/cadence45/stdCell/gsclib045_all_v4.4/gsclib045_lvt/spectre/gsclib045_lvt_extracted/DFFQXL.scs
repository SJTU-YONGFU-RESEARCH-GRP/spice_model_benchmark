// Generated for: spectre (May  1 09:13:41 2013 )
// Library name: gsclib045_lvt
// Cell name: DFFQXL
// View name: extracted

simulator lang=spectre

subckt DFFQXL CK D Q VDD VSS
mp55 (\3\:Q \4\:qbint \13\:VDD VDD) g45p1lvt w=(2.15e-07) l=4.5e-08 nf=1 \
        as=4.623e-14 ad=3.01e-14 ps=8.6e-07 pd=7.1e-07 nrd=1.16667 \
        nrs=1.16667 sa=1.4e-07 sb=4.5e-07 sd=160n sca=23.8733 \
        scb=0.0264891 scc=0.00148688 m=(1)
mp20 (\18\:CKb \1\:CK \13\:VDD VDD) g45p1lvt w=(2.15e-07) l=4.5e-08 nf=1 \
        as=4.623e-14 ad=4.085e-14 ps=8.6e-07 pd=8.1e-07 nrd=1.16667 \
        nrs=1.16667 sa=4e-07 sb=1.9e-07 sd=160n sca=12.9231 scb=0.0102616 \
        scc=9.6055e-05 m=(1)
mp45 (\13\:qbint \3\:n30 \11\:VDD VDD) g45p1lvt w=(2.15e-07) l=4.5e-08 \
        nf=1 as=7.43e-14 ad=3.01e-14 ps=1.32e-06 pd=7.1e-07 nrd=1.16667 \
        nrs=1.16667 sa=1.4e-07 sb=2e-06 sd=160n sca=10.3005 scb=0.00749164 \
        scc=8.05168e-05 m=(1)
mp50 (n36 \5\:qbint \11\:VDD VDD) g45p1lvt w=(2.15e-07) l=4.5e-08 nf=1 \
        as=7.43e-14 ad=2.15e-14 ps=1.32e-06 pd=6.3e-07 nrd=1.16667 \
        nrs=1.16667 sa=4.05e-07 sb=1.955e-06 sd=160n sca=10.2104 \
        scb=0.00747301 scc=8.05149e-05 m=(1)
mp51 (\9\:n30 \2\:CKbb n36 VDD) g45p1lvt w=(2.15e-07) l=4.5e-08 nf=1 \
        as=2.15e-14 ad=3.87e-14 ps=6.3e-07 pd=7.9e-07 nrd=1.16667 \
        nrs=1.16667 sa=5.5e-07 sb=1.81e-06 sd=160n sca=10.2104 \
        scb=0.00747301 scc=8.05149e-05 m=(1)
mp40 (\9\:n30 CKb \9\:mout VDD) g45p1lvt w=(2.15e-07) l=4.5e-08 nf=1 \
        as=6.45e-14 ad=3.87e-14 ps=1.03e-06 pd=7.9e-07 nrd=1.16667 \
        nrs=1.16667 sa=7.75e-07 sb=1.585e-06 sd=160n sca=10.2104 \
        scb=0.00747301 scc=8.05149e-05 m=(1)
mp30 (\9\:mout n20 \9\:VDD VDD) g45p1lvt w=(2.15e-07) l=4.5e-08 nf=1 \
        as=7.538e-14 ad=6.45e-14 ps=1.33e-06 pd=1.03e-06 nrd=1.16667 \
        nrs=1.16667 sa=1.12e-06 sb=1.24e-06 sd=160n sca=10.2104 \
        scb=0.00747301 scc=8.05149e-05 m=(1)
mp35 (n26 \4\:mout \9\:VDD VDD) g45p1lvt w=(2.15e-07) l=4.5e-08 nf=1 \
        as=7.538e-14 ad=2.043e-14 ps=1.33e-06 pd=6.2e-07 nrd=1.16667 \
        nrs=1.16667 sa=1.39e-06 sb=9.7e-07 sd=160n sca=10.2104 \
        scb=0.00747301 scc=8.05149e-05 m=(1)
mp36 (\5\:n20 \5\:CKb n26 VDD) g45p1lvt w=(2.15e-07) l=4.5e-08 nf=1 \
        as=2.043e-14 ad=3.44e-14 ps=6.2e-07 pd=7.5e-07 nrd=1.16667 \
        nrs=1.16667 sa=1.53e-06 sb=8.3e-07 sd=160n sca=10.3563 \
        scb=0.00750569 scc=8.05187e-05 m=(1)
mp26 (\5\:n20 \5\:CKbb n22 VDD) g45p1lvt w=(2.15e-07) l=4.5e-08 nf=1 \
        as=4.623e-14 ad=3.44e-14 ps=8.6e-07 pd=7.5e-07 nrd=1.16667 \
        nrs=1.16667 sa=1.735e-06 sb=6.25e-07 sd=160n sca=11.0447 \
        scb=0.00786221 scc=8.0761e-05 m=(1)
mp25 (n22 \1\:D \1\:VDD VDD) g45p1lvt w=(2.15e-07) l=4.5e-08 nf=1 \
        as=3.44e-14 ad=4.623e-14 ps=7.5e-07 pd=8.6e-07 nrd=1.16667 \
        nrs=1.16667 sa=1.995e-06 sb=3.65e-07 sd=160n sca=13.4702 \
        scb=0.0111763 scc=0.0001097 m=(1)
mp21 (\8\:CKbb \8\:CKb \1\:VDD VDD) g45p1lvt w=(2.15e-07) l=4.5e-08 nf=1 \
        as=3.44e-14 ad=3.44e-14 ps=7.5e-07 pd=7.5e-07 nrd=1.16667 \
        nrs=1.16667 sa=2e-06 sb=1.6e-07 sd=160n sca=21.8638 scb=0.0242315 \
        scc=0.00109598 m=(1)
C1 (Q VSS) capacitor c=4.57167e-17
C2 (D VSS) capacitor c=7.02969e-17
C3 (VDD VSS) capacitor c=2.61571e-16
C4 (CK VSS) capacitor c=5.87867e-17
C5 (qbint VSS) capacitor c=1.74067e-17
C6 (CKb VSS) capacitor c=2.36739e-17
C7 (n30 VSS) capacitor c=4.36045e-17
C8 (n35 VSS) capacitor c=1.49475e-18
C9 (mout VSS) capacitor c=3.47679e-17
C10 (CKbb VSS) capacitor c=5.12176e-17
C11 (n20 VSS) capacitor c=5.51364e-17
C12 (n25 VSS) capacitor c=1.70374e-18
C13 (n21 VSS) capacitor c=1.29587e-18
C14 (n36 VSS) capacitor c=1.59823e-18
C15 (n26 VSS) capacitor c=2.23864e-18
C16 (n22 VSS) capacitor c=3.46284e-18
C17 (\8\:CKb VSS) capacitor c=4.92129e-17
C18 (\1\:D VSS) capacitor c=4.03321e-17
C19 (\5\:CKbb VSS) capacitor c=8.09065e-17
C20 (\5\:CKb VSS) capacitor c=4.67115e-17
C21 (\4\:mout VSS) capacitor c=8.68203e-17
C22 (\2\:CKbb VSS) capacitor c=4.63158e-17
C23 (\5\:qbint VSS) capacitor c=8.11339e-17
C24 (\3\:n30 VSS) capacitor c=4.7851e-17
C25 (\1\:CK VSS) capacitor c=3.47766e-17
C26 (\4\:qbint VSS) capacitor c=4.488e-17
C27 (\11\:CKb VSS) capacitor c=3.81159e-17
C28 (\3\:D VSS) capacitor c=8.99021e-17
C29 (\6\:CKb VSS) capacitor c=7.16399e-17
C30 (\6\:CKbb VSS) capacitor c=8.07412e-17
C31 (\3\:n20 VSS) capacitor c=5.25897e-17
C32 (\3\:CKbb VSS) capacitor c=2.46541e-17
C33 (\3\:CKb VSS) capacitor c=9.21043e-17
C34 (\8\:qbint VSS) capacitor c=4.60217e-17
C35 (\3\:CK VSS) capacitor c=4.58515e-17
C36 (\3\:qbint VSS) capacitor c=2.50931e-17
C37 (\10\:CKb VSS) capacitor c=3.05726e-17
C38 (\2\:D VSS) capacitor c=7.63021e-17
C39 (\7\:CKb VSS) capacitor c=5.66139e-17
C40 (\7\:CKbb VSS) capacitor c=3.02187e-17
C41 (\4\:CKb VSS) capacitor c=4.78657e-17
C42 (\3\:mout VSS) capacitor c=3.16856e-17
C43 (\4\:n20 VSS) capacitor c=3.15524e-17
C44 (\4\:CKbb VSS) capacitor c=5.32992e-17
C45 (\2\:CKb VSS) capacitor c=8.40136e-17
C46 (\7\:qbint VSS) capacitor c=2.74598e-17
C47 (\4\:n30 VSS) capacitor c=1.75928e-17
C48 (\2\:CK VSS) capacitor c=3.79036e-17
C49 (\8\:CKbb VSS) capacitor c=6.55304e-17
C50 (\1\:VDD VSS) capacitor c=3.19124e-17
C51 (\5\:n20 VSS) capacitor c=7.62894e-17
C52 (\9\:VDD VSS) capacitor c=2.35555e-17
C53 (\9\:mout VSS) capacitor c=7.32883e-17
C54 (\9\:n30 VSS) capacitor c=7.62039e-17
C55 (\11\:VDD VSS) capacitor c=2.3952e-17
C56 (\13\:qbint VSS) capacitor c=6.50326e-17
C57 (\18\:CKb VSS) capacitor c=1.47711e-16
C58 (\13\:VDD VSS) capacitor c=3.1556e-17
C59 (\3\:Q VSS) capacitor c=6.26179e-17
C60 (\3\:VDD VSS) capacitor c=7.65565e-17
C61 (\14\:CKbb VSS) capacitor c=1.40934e-17
C62 (\8\:n20 VSS) capacitor c=7.64957e-17
C63 (\7\:mout VSS) capacitor c=5.85906e-17
C64 (\5\:n30 VSS) capacitor c=6.42328e-17
C65 (\11\:qbint VSS) capacitor c=8.40884e-17
C66 (\20\:CKb VSS) capacitor c=8.77851e-17
C67 (\1\:Q VSS) capacitor c=2.04527e-17
C68 (\2\:qbint VSS) capacitor c=2.82575e-17
C69 (\2\:n30 VSS) capacitor c=3.98092e-17
C70 (\6\:qbint VSS) capacitor c=5.71319e-17
C71 (\2\:n20 VSS) capacitor c=4.40884e-17
C72 (\2\:mout VSS) capacitor c=5.56009e-17
C73 (\9\:CKb VSS) capacitor c=4.16644e-17
C74 (\4\:CK VSS) capacitor c=6.34944e-17
C75 (\9\:qbint VSS) capacitor c=4.49371e-17
C76 (\10\:qbint VSS) capacitor c=6.29702e-17
C77 (\15\:qbint VSS) capacitor c=1.20646e-16
C78 (\7\:n30 VSS) capacitor c=8.14991e-17
C79 (\8\:n30 VSS) capacitor c=3.94853e-17
C80 (\5\:mout VSS) capacitor c=3.52393e-17
C81 (\6\:mout VSS) capacitor c=6.26898e-17
C82 (\7\:n20 VSS) capacitor c=8.62377e-17
C83 (\10\:n20 VSS) capacitor c=3.6781e-17
C84 (\4\:D VSS) capacitor c=5.84151e-17
C85 (\12\:CKb VSS) capacitor c=4.6938e-17
C86 (\13\:CKb VSS) capacitor c=6.30568e-17
C87 (\14\:CKb VSS) capacitor c=1.33497e-16
C88 (\15\:CKb VSS) capacitor c=3.99857e-17
C89 (\16\:CKb VSS) capacitor c=2.10358e-16
C90 (\17\:CKb VSS) capacitor c=4.82051e-17
C91 (\10\:CKbb VSS) capacitor c=1.18761e-16
C92 (\11\:CKbb VSS) capacitor c=2.22878e-16
C93 (\12\:CKbb VSS) capacitor c=1.41745e-16
C94 (\13\:CKbb VSS) capacitor c=6.02782e-17
C95 (\16\:CKbb VSS) capacitor c=2.32758e-17
C96 (\5\:VDD VSS) capacitor c=4.46234e-17
C97 (\7\:VDD VSS) capacitor c=1.95569e-17
C98 (\8\:VDD VSS) capacitor c=1.8889e-17
Rk1 (Q \2\:Q) resistor r=0.06644 c=0
Rk2 (Q \4\:Q) resistor r=0.3533 c=0
Rk40 (\2\:VSS \3\:VSS) resistor r=0.2338 c=0
Rk41 (\3\:VSS \5\:VSS) resistor r=0.07524 c=0
Rk42 (\5\:VSS \6\:VSS) resistor r=0.4323 c=0
Rk43 (\6\:VSS \7\:VSS) resistor r=0.372 c=0
Rk45 (\8\:VSS VSS) resistor r=0.1026 c=0
Rk44 (\3\:VSS \8\:VSS) resistor r=0.3743 c=0
Rk46 (\6\:VSS \10\:VSS) resistor r=0.1268 c=0
Rk47 (\7\:VSS \12\:VSS) resistor r=0.2645 c=0
Rk48 (\8\:VSS \14\:VSS) resistor r=0.357 c=0
Rk17 (D \4\:D) resistor r=0.04824 c=0
Rk31 (\2\:VDD \4\:VDD) resistor r=0.2655 c=0
Rk32 (\4\:VDD \5\:VDD) resistor r=0.3861 c=0
Rk33 (\5\:VDD \6\:VDD) resistor r=0.4163 c=0
Rk34 (\6\:VDD \7\:VDD) resistor r=0.07429 c=0
Rk36 (\8\:VDD VDD) resistor r=0.1026 c=0
Rk35 (\7\:VDD \8\:VDD) resistor r=0.3733 c=0
Rk37 (\5\:VDD \10\:VDD) resistor r=0.04347 c=0
Rk38 (\7\:VDD \12\:VDD) resistor r=0.04347 c=0
Rk39 (\8\:VDD \14\:VDD) resistor r=0.2273 c=0
Rk3 (\4\:CK CK) resistor r=0.1139 c=0
Rk4 (\9\:qbint \10\:qbint) resistor r=0.1556 c=0
Rk5 (\10\:qbint \12\:qbint) resistor r=0.1738 c=0
Rk6 (\10\:qbint \14\:qbint) resistor r=0.4618 c=0
Rk7 (\12\:qbint \15\:qbint) resistor r=0.6677 c=0
Rk18 (\12\:CKb \13\:CKb) resistor r=0.2242 c=0
Rk19 (\13\:CKb \14\:CKb) resistor r=0.2606 c=0
Rk20 (\14\:CKb \15\:CKb) resistor r=0.1471 c=0
Rk21 (\14\:CKb \16\:CKb) resistor r=1.0145 c=0
Rk22 (\16\:CKb \17\:CKb) resistor r=0.2321 c=0
Rk23 (\16\:CKb \19\:CKb) resistor r=0.9118 c=0
Rk24 (\19\:CKb \21\:CKb) resistor r=0.5318 c=0
Rk8 (\6\:n30 \7\:n30) resistor r=0.4182 c=0
Rk9 (\7\:n30 \8\:n30) resistor r=0.1518 c=0
Rk10 (\7\:n30 \10\:n30) resistor r=0.4062 c=0
Rk11 (\5\:mout \6\:mout) resistor r=0.09664 c=0
Rk12 (\6\:mout \8\:mout) resistor r=0.2571 c=0
Rk13 (\6\:mout \10\:mout) resistor r=0.5103 c=0
Rk25 (\9\:CKbb \10\:CKbb) resistor r=0.5479 c=0
Rk26 (\10\:CKbb \11\:CKbb) resistor r=0.6888 c=0
Rk27 (\11\:CKbb \12\:CKbb) resistor r=1.2013 c=0
Rk28 (\12\:CKbb \13\:CKbb) resistor r=0.3686 c=0
Rk29 (\10\:CKbb \15\:CKbb) resistor r=0.06536 c=0
Rk30 (\12\:CKbb \16\:CKbb) resistor r=0.08203 c=0
Rk14 (\6\:n20 \7\:n20) resistor r=0.4788 c=0
Rk15 (\7\:n20 \9\:n20) resistor r=0.4426 c=0
Rk16 (\7\:n20 \10\:n20) resistor r=0.1181 c=0
Rl26 (\1\:D \2\:D) resistor r=103.365 c=0
Rl27 (\2\:D \3\:D) resistor r=158.414 c=0
Rl4 (\1\:CK \2\:CK) resistor r=94.9225 c=0
Rl5 (\2\:CK \3\:CK) resistor r=100.692 c=0
Rl3 (\2\:qbint \4\:qbint) resistor r=164.264 c=0
Rl2 (\2\:qbint \3\:qbint) resistor r=46.9565 c=0
Rl1 (qbint \2\:qbint) resistor r=2.4834 c=0
Rl9 (\5\:qbint \6\:qbint) resistor r=226.637 c=0
Rl11 (\6\:qbint \8\:qbint) resistor r=47.791 c=0
Rl10 (\6\:qbint \7\:qbint) resistor r=6.708 c=0
Rl25 (\6\:CKb \7\:CKb) resistor r=74.2328 c=0
Rl22 (\4\:CKb \5\:CKb) resistor r=64.0519 c=0
Rl13 (CKb \2\:CKb) resistor r=24.2328 c=0
Rl14 (\2\:CKb \3\:CKb) resistor r=314.183 c=0
Rl28 (\8\:CKb \9\:CKb) resistor r=177.726 c=0
Rl30 (\9\:CKb \11\:CKb) resistor r=95.0334 c=0
Rl29 (\9\:CKb \10\:CKb) resistor r=2.4801 c=0
Rl7 (\2\:n30 \3\:n30) resistor r=151.431 c=0
Rl6 (n30 \2\:n30) resistor r=121.99 c=0
Rl8 (\2\:n30 \4\:n30) resistor r=3.8588 c=0
Rl21 (\2\:mout \4\:mout) resistor r=219.894 c=0
Rl19 (mout \2\:mout) resistor r=50.3084 c=0
Rl20 (\2\:mout \3\:mout) resistor r=16.1277 c=0
Rl23 (\5\:CKbb \6\:CKbb) resistor r=299.934 c=0
Rl24 (\6\:CKbb \7\:CKbb) resistor r=26.1559 c=0
Rl15 (\3\:CKbb \4\:CKbb) resistor r=81.0266 c=0
Rl12 (CKbb \2\:CKbb) resistor r=65.2137 c=0
Rl16 (n20 \2\:n20) resistor r=162.695 c=0
Rl17 (\2\:n20 \3\:n20) resistor r=116.541 c=0
Rl18 (\2\:n20 \4\:n20) resistor r=31.6066 c=0
Rz1 (\1\:Q \2\:Q) resistor r=75 c=0
Rz10 (\1\:VSS \2\:VSS) resistor r=75 c=0
Rz11 (\9\:VSS \10\:VSS) resistor r=75 c=0
Rz12 (\11\:VSS \12\:VSS) resistor r=75 c=0
Rz13 (\13\:VSS \14\:VSS) resistor r=75 c=0
Rz8 (\3\:VDD \4\:VDD) resistor r=18.75 c=0
Rz9 (\3\:VDD \6\:VDD) resistor r=6.25 c=0
Rz2 (\11\:qbint \12\:qbint) resistor r=75 c=0
Rz6 (\20\:CKb \21\:CKb) resistor r=75 c=0
Rz3 (\5\:n30 \6\:n30) resistor r=75 c=0
Rz4 (\7\:mout \8\:mout) resistor r=75 c=0
Rz7 (\14\:CKbb \15\:CKbb) resistor r=75 c=0
Rz5 (\8\:n20 \9\:n20) resistor r=75 c=0
Ry1 (\3\:Q \4\:Q) resistor r=62 c=0
Ry12 (\4\:VSS \5\:VSS) resistor r=5.1667 c=0
Ry13 (\4\:VSS \7\:VSS) resistor r=15.5 c=0
Ry8 (\1\:VDD \2\:VDD) resistor r=62 c=0
Ry9 (\9\:VDD \10\:VDD) resistor r=62 c=0
Ry10 (\11\:VDD \12\:VDD) resistor r=62 c=0
Ry11 (\13\:VDD \14\:VDD) resistor r=62 c=0
Ry2 (\13\:qbint \14\:qbint) resistor r=62 c=0
Ry6 (\18\:CKb \19\:CKb) resistor r=62 c=0
Ry3 (\9\:n30 \10\:n30) resistor r=62 c=0
Ry4 (\9\:mout \10\:mout) resistor r=62 c=0
Ry7 (\8\:CKbb \9\:CKbb) resistor r=62 c=0
Ry5 (\5\:n20 \6\:n20) resistor r=62 c=0
Rx7 (\2\:D \4\:D) resistor r=45 c=0
Rx1 (\2\:CK \4\:CK) resistor r=45 c=0
Rx2 (\7\:qbint \9\:qbint) resistor r=45 c=0
Rx3 (qbint \15\:qbint) resistor r=45 c=0
Rx8 (\10\:CKb \12\:CKb) resistor r=45 c=0
Rx9 (\7\:CKb \13\:CKb) resistor r=45 c=0
Rx10 (\4\:CKb \15\:CKb) resistor r=45 c=0
Rx11 (\2\:CKb \17\:CKb) resistor r=45 c=0
Rx4 (\4\:n30 \8\:n30) resistor r=45 c=0
Rx5 (\3\:mout \5\:mout) resistor r=45 c=0
Rx12 (\7\:CKbb \11\:CKbb) resistor r=45 c=0
Rx13 (CKbb \13\:CKbb) resistor r=45 c=0
Rx14 (\4\:CKbb \16\:CKbb) resistor r=45 c=0
Rx6 (\4\:n20 \10\:n20) resistor r=45 c=0
mn55 (\1\:Q \3\:qbint \13\:VSS VSS) g45n1lvt w=(1.45e-07) l=4.5e-08 nf=1 \
        as=3.118e-14 ad=2.03e-14 ps=7.2e-07 pd=5.7e-07 nrd=1.16667 \
        nrs=1.16667 sa=1.4e-07 sb=4.6e-07 sd=160n sca=16.7245 \
        scb=0.0178071 scc=0.00133148 m=(1)
mn20 (\20\:CKb \3\:CK \13\:VSS VSS) g45n1lvt w=(1.45e-07) l=4.5e-08 nf=1 \
        as=3.118e-14 ad=2.9e-14 ps=7.2e-07 pd=6.9e-07 nrd=1.16667 \
        nrs=1.16667 sa=4e-07 sb=2e-07 sd=160n sca=16.7245 scb=0.0178071 \
        scc=0.00133148 m=(1)
mn45 (\11\:qbint n30 \1\:VSS VSS) g45n1lvt w=(1.45e-07) l=4.5e-08 nf=1 \
        as=2.755e-14 ad=2.03e-14 ps=6.7e-07 pd=5.7e-07 nrd=1.16667 \
        nrs=1.16667 sa=1.4e-07 sb=2e-06 sd=160n sca=8.15925 scb=0.00587019 \
        scc=8.94977e-05 m=(1)
mn50 (n35 \8\:qbint \1\:VSS VSS) g45n1lvt w=(1.45e-07) l=4.5e-08 nf=1 \
        as=2.755e-14 ad=8.7e-15 ps=6.7e-07 pd=4.1e-07 nrd=1.16667 \
        nrs=1.16667 sa=3.75e-07 sb=1.935e-06 sd=160n sca=8.15925 \
        scb=0.00587019 scc=8.94977e-05 m=(1)
mn51 (\5\:n30 \3\:CKb n35 VSS) g45n1lvt w=(1.45e-07) l=4.5e-08 nf=1 \
        as=8.7e-15 ad=4.06e-14 ps=4.1e-07 pd=8.5e-07 nrd=1.16667 \
        nrs=1.16667 sa=4.8e-07 sb=1.83e-06 sd=160n sca=8.15925 \
        scb=0.00587019 scc=8.94977e-05 m=(1)
mn40 (\5\:n30 \3\:CKbb \7\:mout VSS) g45n1lvt w=(1.45e-07) l=4.5e-08 nf=1 \
        as=3.48e-14 ad=4.06e-14 ps=7.7e-07 pd=8.5e-07 nrd=1.16667 \
        nrs=1.16667 sa=8.05e-07 sb=1.505e-06 sd=160n sca=8.15925 \
        scb=0.00587019 scc=8.94977e-05 m=(1)
mn30 (\7\:mout \3\:n20 \9\:VSS VSS) g45n1lvt w=(1.45e-07) l=4.5e-08 nf=1 \
        as=5.86e-14 ad=3.48e-14 ps=1.15e-06 pd=7.7e-07 nrd=1.16667 \
        nrs=1.16667 sa=1.09e-06 sb=1.22e-06 sd=160n sca=8.15925 \
        scb=0.00587019 scc=8.94977e-05 m=(1)
mn35 (n25 mout \9\:VSS VSS) g45n1lvt w=(1.45e-07) l=4.5e-08 nf=1 \
        as=5.86e-14 ad=1.813e-14 ps=1.15e-06 pd=5.4e-07 nrd=1.16667 \
        nrs=1.16667 sa=1.415e-06 sb=8.95e-07 sd=160n sca=8.15925 \
        scb=0.00587019 scc=8.94977e-05 m=(1)
mn36 (\8\:n20 \6\:CKbb n25 VSS) g45n1lvt w=(1.45e-07) l=4.5e-08 nf=1 \
        as=1.813e-14 ad=2.32e-14 ps=5.4e-07 pd=6.1e-07 nrd=1.16667 \
        nrs=1.16667 sa=1.585e-06 sb=7.25e-07 sd=160n sca=8.15925 \
        scb=0.00587019 scc=8.94977e-05 m=(1)
mn26 (\8\:n20 \6\:CKb n21 VSS) g45n1lvt w=(1.45e-07) l=4.5e-08 nf=1 \
        as=1.015e-14 ad=2.32e-14 ps=4.3e-07 pd=6.1e-07 nrd=1.16667 \
        nrs=1.16667 sa=1.79e-06 sb=5.2e-07 sd=160n sca=8.15925 \
        scb=0.00587019 scc=8.94977e-05 m=(1)
mn25 (n21 \3\:D \11\:VSS VSS) g45n1lvt w=(1.45e-07) l=4.5e-08 nf=1 \
        as=3.61e-14 ad=1.015e-14 ps=8e-07 pd=4.3e-07 nrd=1.16667 \
        nrs=1.16667 sa=1.905e-06 sb=4.05e-07 sd=160n sca=8.15925 \
        scb=0.00587019 scc=8.94977e-05 m=(1)
mn21 (\14\:CKbb \11\:CKb \11\:VSS VSS) g45n1lvt w=(1.45e-07) l=4.5e-08 \
        nf=1 as=3.61e-14 ad=2.03e-14 ps=8e-07 pd=5.7e-07 nrd=1.16667 \
        nrs=1.16667 sa=2e-06 sb=1.4e-07 sd=160n sca=8.15925 scb=0.00587019 \
        scc=8.94977e-05 m=(1)
ends DFFQXL
// End of subcircuit definition.
