// Generated for: spectre (May  1 09:17:55 2013 )
// Library name: gsclib045_lvt
// Cell name: OAI211X1
// View name: extracted

simulator lang=spectre

subckt OAI211X1 A0 A1 B0 C0 VDD VSS Y
mp0 (n2 \1\:A0 \5\:VDD VDD) g45p1lvt w=(3.9e-07) l=4.5e-08 nf=1 \
        as=5.46e-14 ad=2.34e-14 ps=1.06e-06 pd=9e-07 nrd=1.16667 \
        nrs=1.16667 sa=1.4e-07 sb=7.3e-07 sd=160n sca=26.0122 \
        scb=0.0294337 scc=0.00173965 m=(1)
mp1 (\4\:Y \3\:A1 n2 VDD) g45p1lvt w=(3.9e-07) l=4.5e-08 nf=1 as=2.34e-14 \
        ad=9.165e-14 ps=9e-07 pd=1.25e-06 nrd=1.16667 nrs=1.16667 \
        sa=2.45e-07 sb=6.25e-07 sd=160n sca=19.2311 scb=0.0199775 \
        scc=0.000575468 m=(1)
mp2 (\4\:Y \3\:B0 \1\:VDD VDD) g45p1lvt w=(3.9e-07) l=4.5e-08 nf=1 \
        as=6.24e-14 ad=9.165e-14 ps=1.1e-06 pd=1.25e-06 nrd=1.16667 \
        nrs=1.16667 sa=5.25e-07 sb=3.45e-07 sd=160n sca=16.9088 \
        scb=0.0154331 scc=0.000373012 m=(1)
mp3 (\6\:Y \1\:C0 \1\:VDD VDD) g45p1lvt w=(3.9e-07) l=4.5e-08 nf=1 \
        as=6.24e-14 ad=5.46e-14 ps=1.1e-06 pd=1.06e-06 nrd=1.16667 \
        nrs=1.16667 sa=7.3e-07 sb=1.4e-07 sd=160n sca=25.4829 \
        scb=0.0288592 scc=0.00163037 m=(1)
C1 (Y VSS) capacitor c=3.34278e-17
C2 (C0 VSS) capacitor c=7.62193e-17
C3 (VDD VSS) capacitor c=9.10361e-17
C4 (n0 VSS) capacitor c=5.96235e-17
C5 (n1 VSS) capacitor c=3.39295e-18
C6 (\1\:C0 VSS) capacitor c=4.93989e-17
C7 (\3\:B0 VSS) capacitor c=5.20473e-17
C8 (\3\:A1 VSS) capacitor c=8.6448e-17
C9 (\1\:A0 VSS) capacitor c=6.29686e-17
C10 (\3\:C0 VSS) capacitor c=4.29072e-17
C11 (\1\:B0 VSS) capacitor c=5.49322e-17
C12 (\1\:A1 VSS) capacitor c=4.73208e-17
C13 (\4\:A0 VSS) capacitor c=5.51383e-17
C14 (\2\:C0 VSS) capacitor c=5.07672e-17
C15 (\2\:B0 VSS) capacitor c=5.81027e-17
C16 (\2\:A1 VSS) capacitor c=6.59008e-17
C17 (\3\:A0 VSS) capacitor c=1.44632e-17
C18 (\1\:VDD VSS) capacitor c=6.32332e-17
C19 (\4\:Y VSS) capacitor c=7.3039e-17
C20 (\5\:VDD VSS) capacitor c=3.82398e-17
C21 (\1\:Y VSS) capacitor c=8.48154e-17
C22 (\3\:n0 VSS) capacitor c=3.8718e-17
C23 (\2\:A0 VSS) capacitor c=4.97519e-17
C24 (\5\:A0 VSS) capacitor c=2.39587e-17
C25 (\7\:A0 VSS) capacitor c=2.71195e-17
C26 (\4\:A1 VSS) capacitor c=3.21236e-17
C27 (\6\:A1 VSS) capacitor c=3.11502e-17
C28 (\4\:B0 VSS) capacitor c=5.03811e-17
C29 (\5\:B0 VSS) capacitor c=5.30536e-17
C30 (\4\:C0 VSS) capacitor c=6.67243e-17
C31 (\3\:Y VSS) capacitor c=6.37622e-17
C32 (\4\:VDD VSS) capacitor c=3.06921e-17
Rk8 (B0 \4\:B0) resistor r=0.0105 c=0
Rk10 (\4\:B0 \5\:B0) resistor r=0.05693 c=0
Rk9 (\5\:B0 \6\:B0) resistor r=0.01062 c=0
Rk14 (\3\:Y Y) resistor r=0.1013 c=0
Rk12 (\2\:Y \3\:Y) resistor r=0.5242 c=0
Rk13 (\3\:Y \5\:Y) resistor r=0.3771 c=0
Rk15 (Y \7\:Y) resistor r=0.01164 c=0
Rk4 (\4\:A1 \5\:A1) resistor r=0.004734 c=0
Rk5 (A1 \6\:A1) resistor r=0.004599 c=0
Rk6 (\4\:A1 \6\:A1) resistor r=0.05081 c=0
Rk20 (\3\:VSS VSS) resistor r=0.1024 c=0
Rk21 (\3\:VSS \5\:VSS) resistor r=0.1814 c=0
Rk11 (\4\:C0 C0) resistor r=0.1732 c=0
Rk1 (\5\:A0 \6\:A0) resistor r=0.002117 c=0
Rk2 (A0 \7\:A0) resistor r=0.001975 c=0
Rk3 (\5\:A0 \7\:A0) resistor r=0.04803 c=0
Rk17 (\4\:VDD VDD) resistor r=0.2007 c=0
Rk16 (\2\:VDD \4\:VDD) resistor r=0.3526 c=0
Rk18 (VDD \6\:VDD) resistor r=0.2435 c=0
Rk7 (\2\:n0 \4\:n0) resistor r=0.2718 c=0
Rl7 (\2\:B0 \3\:B0) resistor r=76.903 c=0
Rl6 (\1\:B0 \2\:B0) resistor r=110.307 c=0
Rl5 (\2\:A1 \3\:A1) resistor r=101.718 c=0
Rl4 (\1\:A1 \2\:A1) resistor r=86.5156 c=0
Rl8 (\1\:C0 \2\:C0) resistor r=89.6174 c=0
Rl9 (\2\:C0 \3\:C0) resistor r=97.3098 c=0
Rl1 (\1\:A0 \2\:A0) resistor r=34.3295 c=0
Rl3 (\2\:A0 \4\:A0) resistor r=172.791 c=0
Rl2 (\2\:A0 \3\:A0) resistor r=5.9102 c=0
Rz3 (\1\:Y \2\:Y) resistor r=37.5 c=0
Rz5 (\4\:VSS \5\:VSS) resistor r=75 c=0
Rz1 (n0 \2\:n0) resistor r=75 c=0
Rz2 (\3\:n0 \4\:n0) resistor r=75 c=0
Ry1 (\4\:Y \5\:Y) resistor r=20.6667 c=0
Ry2 (\6\:Y \7\:Y) resistor r=20.6667 c=0
Ry3 (\1\:VDD \2\:VDD) resistor r=31 c=0
Ry4 (\5\:VDD \6\:VDD) resistor r=31 c=0
Rx3 (\2\:B0 \6\:B0) resistor r=45 c=0
Rx2 (\2\:A1 \5\:A1) resistor r=45 c=0
Rx4 (\2\:C0 \4\:C0) resistor r=45 c=0
Rx1 (\3\:A0 \6\:A0) resistor r=45 c=0
mn0 (\3\:n0 \4\:A0 \4\:VSS VSS) g45n1lvt w=(2.6e-07) l=4.5e-08 nf=1 \
        as=4.16e-14 ad=3.64e-14 ps=8.4e-07 pd=8e-07 nrd=1.16667 \
        nrs=1.16667 sa=1.4e-07 sb=7.3e-07 sd=160n sca=8.09546 \
        scb=0.00588493 scc=0.000117119 m=(1)
mn1 (n0 \1\:A1 \4\:VSS VSS) g45n1lvt w=(2.6e-07) l=4.5e-08 nf=1 \
        as=4.16e-14 ad=4.16e-14 ps=8.4e-07 pd=8.4e-07 nrd=1.16667 \
        nrs=1.16667 sa=3.45e-07 sb=5.25e-07 sd=160n sca=8.09546 \
        scb=0.00588493 scc=0.000117119 m=(1)
mn2 (n1 \1\:B0 n0 VSS) g45n1lvt w=(2.6e-07) l=4.5e-08 nf=1 as=4.16e-14 \
        ad=3.51e-14 ps=8.4e-07 pd=7.9e-07 nrd=1.16667 nrs=1.16667 \
        sa=5.5e-07 sb=3.2e-07 sd=160n sca=8.09546 scb=0.00588493 \
        scc=0.000117119 m=(1)
mn3 (\1\:Y \3\:C0 n1 VSS) g45n1lvt w=(2.6e-07) l=4.5e-08 nf=1 as=3.51e-14 \
        ad=3.64e-14 ps=7.9e-07 pd=8e-07 nrd=1.16667 nrs=1.16667 sa=7.3e-07 \
        sb=1.4e-07 sd=160n sca=8.09546 scb=0.00588493 scc=0.000117119 \
        m=(1)
ends OAI211X1
// End of subcircuit definition.
