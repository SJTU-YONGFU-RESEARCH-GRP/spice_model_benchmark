// Generated for: spectre (May  1 09:13:36 2013 )
// Library name: gsclib045_lvt
// Cell name: DFFNSRXL
// View name: extracted

simulator lang=spectre

subckt DFFNSRXL CKN D Q QN RN SN VDD VSS
mp57 (\1\:QN \4\:qint \25\:VDD VDD) g45p1lvt w=(2.15e-07) l=4.5e-08 nf=1 \
        as=3.44e-14 ad=3.548e-14 ps=7.5e-07 pd=7.6e-07 nrd=1.16667 \
        nrs=1.16667 sa=1.65e-07 sb=3.45e-07 sd=160n sca=49.323 \
        scb=0.0325052 scc=0.00592234 m=(1)
mp56 (\5\:qint \7\:qbint \25\:VDD VDD) g45p1lvt w=(2.15e-07) l=4.5e-08 \
        nf=1 as=3.44e-14 ad=3.01e-14 ps=7.5e-07 pd=7.1e-07 nrd=1.16667 \
        nrs=1.16667 sa=3.7e-07 sb=1.4e-07 sd=160n sca=47.0147 \
        scb=0.0290717 scc=0.00588507 m=(1)
mp55 (\1\:Q qbint \22\:VDD VDD) g45p1lvt w=(2.15e-07) l=4.5e-08 nf=1 \
        as=3.44e-14 ad=3.01e-14 ps=7.5e-07 pd=7.1e-07 nrd=1.16667 \
        nrs=1.16667 sa=1.4e-07 sb=3.45e-07 sd=160n sca=10.1345 \
        scb=0.00732736 scc=7.25592e-05 m=(1)
mp22 (\10\:RNb \1\:RN \22\:VDD VDD) g45p1lvt w=(2.15e-07) l=4.5e-08 nf=1 \
        as=3.44e-14 ad=3.01e-14 ps=7.5e-07 pd=7.1e-07 nrd=1.16667 \
        nrs=1.16667 sa=3.45e-07 sb=1.4e-07 sd=160n sca=10.1345 \
        scb=0.00732736 scc=7.25592e-05 m=(1)
mp45 (\16\:qbint n35 \18\:VDD VDD) g45p1lvt w=(2.15e-07) l=4.5e-08 nf=1 \
        as=9.35e-14 ad=3.01e-14 ps=1.64e-06 pd=7.1e-07 nrd=1.16667 \
        nrs=1.16667 sa=1.4e-07 sb=8.3e-07 sd=160n sca=15.2551 \
        scb=0.0150251 scc=0.000885438 m=(1)
mp50 (\3\:n41 \1\:SN \18\:VDD VDD) g45p1lvt w=(2.15e-07) l=4.5e-08 nf=1 \
        as=9.35e-14 ad=3.44e-14 ps=1.64e-06 pd=7.5e-07 nrd=1.16667 \
        nrs=1.16667 sa=4.05e-07 sb=5.65e-07 sd=160n sca=15.2551 \
        scb=0.0150251 scc=0.000885438 m=(1)
mp52 (\3\:n41 \8\:qbint n43 VDD) g45p1lvt w=(2.15e-07) l=4.5e-08 nf=1 \
        as=1.29e-14 ad=3.44e-14 ps=5.5e-07 pd=7.5e-07 nrd=1.16667 \
        nrs=1.16667 sa=6.1e-07 sb=3.6e-07 sd=160n sca=15.2551 \
        scb=0.0150251 scc=0.000885438 m=(1)
mp51 (n43 \2\:RNb \15\:VDD VDD) g45p1lvt w=(2.15e-07) l=4.5e-08 nf=1 \
        as=1.0103e-13 ad=1.29e-14 ps=1.71e-06 pd=5.5e-07 nrd=1.16667 \
        nrs=1.16667 sa=7.15e-07 sb=2.55e-07 sd=160n sca=15.2551 \
        scb=0.0150251 scc=0.000885438 m=(1)
mp53 (n41 CKNb \7\:n35 VDD) g45p1lvt w=(2.15e-07) l=4.5e-08 nf=1 \
        as=4.115e-14 ad=3.118e-14 ps=8.7e-07 pd=7.2e-07 nrd=1.16667 \
        nrs=1.16667 sa=1.45e-07 sb=3.36628e-07 sd=160n sca=29.9075 \
        scb=0.0247057 scc=0.00372713 m=(1)
mp40 (\7\:n35 \3\:CKNbb \15\:mout VDD) g45p1lvt w=(2.15e-07) l=4.5e-08 \
        nf=1 as=3.01e-14 ad=4.115e-14 ps=7.1e-07 pd=8.7e-07 nrd=1.16667 \
        nrs=1.16667 sa=3.4093e-07 sb=1.4e-07 sd=160n sca=22.8495 \
        scb=0.0214046 scc=0.00242442 m=(1)
mp31 (n26 \5\:RNb \12\:VDD VDD) g45p1lvt w=(2.15e-07) l=4.5e-08 nf=1 \
        as=6.315e-14 ad=1.612e-14 ps=2.1e-06 pd=5.8e-07 nrd=1.16667 \
        nrs=1.16667 sa=1.63953e-07 sb=1.05849e-06 sd=160n sca=15.6338 \
        scb=0.015455 scc=0.000959319 m=(1)
mp32 (\10\:mout n20 n26 VDD) g45p1lvt w=(2.15e-07) l=4.5e-08 nf=1 \
        as=1.612e-14 ad=5.16e-14 ps=5.8e-07 pd=9.1e-07 nrd=1.16667 \
        nrs=1.16667 sa=2.83953e-07 sb=9.38488e-07 sd=160n sca=15.6338 \
        scb=0.015455 scc=0.000959319 m=(1)
mp30 (\10\:mout \5\:SN \10\:VDD VDD) g45p1lvt w=(2.15e-07) l=4.5e-08 \
        nf=1 as=8.905e-14 ad=5.16e-14 ps=1.71e-06 pd=9.1e-07 nrd=1.16667 \
        nrs=1.16667 sa=5.68953e-07 sb=6.53488e-07 sd=160n sca=15.6338 \
        scb=0.015455 scc=0.000959319 m=(1)
mp35 (n31 \4\:mout \10\:VDD VDD) g45p1lvt w=(2.15e-07) l=4.5e-08 nf=1 \
        as=8.905e-14 ad=3.87e-14 ps=1.71e-06 pd=7.9e-07 nrd=1.16667 \
        nrs=1.16667 sa=5.26977e-07 sb=9.95e-07 sd=160n sca=10.8061 \
        scb=0.00857865 scc=0.000148871 m=(1)
mp36 (\7\:n20 \7\:CKNbb n31 VDD) g45p1lvt w=(2.15e-07) l=4.5e-08 nf=1 \
        as=3.87e-14 ad=3.44e-14 ps=7.9e-07 pd=7.5e-07 nrd=1.16667 \
        nrs=1.16667 sa=7.51977e-07 sb=7.7e-07 sd=160n sca=10.8061 \
        scb=0.00857865 scc=0.000148871 m=(1)
mp26 (\7\:n20 \4\:CKNb n22 VDD) g45p1lvt w=(2.15e-07) l=4.5e-08 nf=1 \
        as=3.762e-14 ad=3.44e-14 ps=7.8e-07 pd=7.5e-07 nrd=1.16667 \
        nrs=1.16667 sa=9.56977e-07 sb=5.65e-07 sd=160n sca=10.8061 \
        scb=0.00857865 scc=0.000148871 m=(1)
mp25 (n22 \3\:D \8\:VDD VDD) g45p1lvt w=(2.15e-07) l=4.5e-08 nf=1 \
        as=3.44e-14 ad=3.762e-14 ps=7.5e-07 pd=7.8e-07 nrd=1.16667 \
        nrs=1.16667 sa=1.17698e-06 sb=3.45e-07 sd=160n sca=10.8251 \
        scb=0.00858217 scc=0.000148871 m=(1)
mp21 (\12\:CKNbb \7\:CKNb \8\:VDD VDD) g45p1lvt w=(2.15e-07) l=4.5e-08 \
        nf=1 as=3.44e-14 ad=3.01e-14 ps=7.5e-07 pd=7.1e-07 nrd=1.16667 \
        nrs=1.16667 sa=1.38198e-06 sb=1.4e-07 sd=160n sca=11.384 \
        scb=0.00879424 scc=0.00014895 m=(1)
mp20 (\15\:CKNb \1\:CKN \1\:VDD VDD) g45p1lvt w=(2.15e-07) l=4.5e-08 \
        nf=1 as=3.01e-14 ad=3.01e-14 ps=7.1e-07 pd=7.1e-07 nrd=1.16667 \
        nrs=1.16667 sa=1.4e-07 sb=1.4e-07 sd=160n sca=53.3953 \
        scb=0.0394806 scc=0.00625575 m=(1)
C1 (RN VSS) capacitor c=5.99665e-17
C2 (CKN VSS) capacitor c=4.37051e-17
C3 (QN VSS) capacitor c=2.25228e-17
C4 (D VSS) capacitor c=4.86306e-17
C5 (Q VSS) capacitor c=6.68525e-17
C6 (VDD VSS) capacitor c=4.49608e-16
C7 (SN VSS) capacitor c=2.1546e-17
C8 (qint VSS) capacitor c=2.07337e-17
C9 (qbint VSS) capacitor c=4.97082e-17
C10 (RNb VSS) capacitor c=5.26133e-17
C11 (n35 VSS) capacitor c=4.27349e-17
C12 (n42 VSS) capacitor c=7.71651e-17
C13 (n40 VSS) capacitor c=8.05037e-17
C14 (CKNbb VSS) capacitor c=4.61426e-17
C15 (mout VSS) capacitor c=4.68076e-17
C16 (CKNb VSS) capacitor c=6.68486e-17
C17 (n25 VSS) capacitor c=7.05526e-17
C18 (n20 VSS) capacitor c=6.26341e-17
C19 (n30 VSS) capacitor c=2.45524e-18
C20 (n41 VSS) capacitor c=1.17263e-16
C21 (n43 VSS) capacitor c=1.48145e-18
C22 (n26 VSS) capacitor c=2.97535e-18
C23 (n31 VSS) capacitor c=3.71866e-18
C24 (n22 VSS) capacitor c=2.41226e-18
C25 (\1\:CKN VSS) capacitor c=2.81976e-17
C26 (\7\:CKNb VSS) capacitor c=6.43835e-17
C27 (\3\:D VSS) capacitor c=5.61619e-17
C28 (\4\:CKNb VSS) capacitor c=7.85718e-17
C29 (\7\:CKNbb VSS) capacitor c=3.48266e-17
C30 (\4\:mout VSS) capacitor c=4.63042e-17
C31 (\5\:SN VSS) capacitor c=5.19637e-17
C32 (\5\:RNb VSS) capacitor c=8.14245e-17
C33 (\3\:CKNbb VSS) capacitor c=3.86926e-17
C34 (\2\:RNb VSS) capacitor c=8.85617e-17
C35 (\8\:qbint VSS) capacitor c=9.10944e-17
C36 (\1\:SN VSS) capacitor c=3.68772e-17
C37 (\1\:RN VSS) capacitor c=3.34711e-17
C38 (\7\:qbint VSS) capacitor c=2.47784e-17
C39 (\4\:qint VSS) capacitor c=3.10855e-17
C40 (\3\:CKN VSS) capacitor c=2.48678e-17
C41 (\8\:CKNb VSS) capacitor c=4.50236e-17
C42 (\1\:D VSS) capacitor c=4.65834e-17
C43 (\8\:CKNbb VSS) capacitor c=6.3296e-17
C44 (\5\:CKNb VSS) capacitor c=6.16625e-17
C45 (\4\:SN VSS) capacitor c=6.76747e-17
C46 (\3\:n20 VSS) capacitor c=3.4362e-17
C47 (\4\:RNb VSS) capacitor c=6.75026e-17
C48 (\2\:CKNb VSS) capacitor c=9.53616e-17
C49 (\9\:qbint VSS) capacitor c=4.01149e-17
C50 (\3\:SN VSS) capacitor c=5.61256e-17
C51 (\3\:n35 VSS) capacitor c=3.26003e-17
C52 (\3\:RN VSS) capacitor c=5.5993e-17
C53 (\5\:qbint VSS) capacitor c=2.2886e-17
C54 (\4\:qbint VSS) capacitor c=3.45565e-17
C55 (\3\:qint VSS) capacitor c=3.05607e-17
C56 (\2\:CKN VSS) capacitor c=1.94479e-17
C57 (\9\:CKNb VSS) capacitor c=1.85611e-17
C58 (\4\:D VSS) capacitor c=2.67087e-17
C59 (\9\:CKNbb VSS) capacitor c=5.99482e-17
C60 (\6\:CKNb VSS) capacitor c=2.27164e-17
C61 (\6\:CKNbb VSS) capacitor c=4.73977e-17
C62 (\3\:mout VSS) capacitor c=1.60356e-17
C63 (\6\:SN VSS) capacitor c=2.87457e-17
C64 (\3\:CKNb VSS) capacitor c=6.41676e-17
C65 (\2\:n20 VSS) capacitor c=4.4258e-17
C66 (\5\:CKNbb VSS) capacitor c=3.23559e-17
C67 (\6\:RNb VSS) capacitor c=2.14967e-17
C68 (\4\:CKNbb VSS) capacitor c=3.33024e-17
C69 (\2\:CKNbb VSS) capacitor c=2.65253e-17
C70 (\3\:RNb VSS) capacitor c=2.20985e-17
C71 (\10\:qbint VSS) capacitor c=2.91433e-17
C72 (\2\:SN VSS) capacitor c=4.40917e-17
C73 (\2\:n35 VSS) capacitor c=3.17506e-17
C74 (\2\:RN VSS) capacitor c=4.30052e-17
C75 (\1\:VDD VSS) capacitor c=3.10582e-17
C76 (\15\:CKNb VSS) capacitor c=4.99109e-17
C77 (\12\:CKNbb VSS) capacitor c=1.63472e-17
C78 (\8\:VDD VSS) capacitor c=3.59209e-17
C79 (\7\:n20 VSS) capacitor c=8.31495e-17
C80 (\10\:VDD VSS) capacitor c=1.4028e-17
C81 (\10\:mout VSS) capacitor c=2.80584e-17
C82 (\12\:VDD VSS) capacitor c=2.68294e-17
C83 (\15\:mout VSS) capacitor c=5.2606e-17
C84 (\7\:n35 VSS) capacitor c=2.72696e-17
C85 (\15\:VDD VSS) capacitor c=3.22602e-17
C86 (\3\:n41 VSS) capacitor c=1.11581e-16
C87 (\18\:VDD VSS) capacitor c=3.03752e-17
C88 (\16\:qbint VSS) capacitor c=7.89909e-17
C89 (\10\:RNb VSS) capacitor c=2.50573e-17
C90 (\22\:VDD VSS) capacitor c=2.85842e-17
C91 (\1\:Q VSS) capacitor c=4.54065e-17
C92 (\5\:qint VSS) capacitor c=3.50101e-17
C93 (\25\:VDD VSS) capacitor c=3.98683e-17
C94 (\1\:QN VSS) capacitor c=1.99466e-17
C95 (\3\:VDD VSS) capacitor c=9.56684e-17
C96 (\13\:CKNb VSS) capacitor c=6.48007e-17
C97 (\17\:CKNbb VSS) capacitor c=6.38439e-17
C98 (\4\:n20 VSS) capacitor c=4.85957e-17
C99 (\3\:n25 VSS) capacitor c=8.39093e-17
C100 (\8\:mout VSS) capacitor c=4.30823e-17
C101 (\13\:mout VSS) capacitor c=5.10942e-17
C102 (\4\:n35 VSS) capacitor c=5.47418e-17
C103 (\3\:n40 VSS) capacitor c=8.86744e-17
C104 (\3\:n42 VSS) capacitor c=1.04412e-16
C105 (\13\:qbint VSS) capacitor c=5.75734e-17
C106 (\12\:RNb VSS) capacitor c=1.07864e-16
C107 (\3\:Q VSS) capacitor c=4.92885e-17
C108 (\9\:qint VSS) capacitor c=2.6791e-17
C109 (\3\:QN VSS) capacitor c=3.47746e-17
C110 (\2\:qint VSS) capacitor c=1.26256e-17
C111 (\2\:qbint VSS) capacitor c=5.64516e-17
C112 (\3\:qbint VSS) capacitor c=3.24121e-17
C113 (\2\:mout VSS) capacitor c=3.37287e-17
C114 (\2\:D VSS) capacitor c=4.43413e-17
C115 (\7\:qint VSS) capacitor c=2.67327e-17
C116 (\8\:qint VSS) capacitor c=2.97275e-17
C117 (\4\:RN VSS) capacitor c=6.43938e-17
C118 (\11\:qbint VSS) capacitor c=6.15539e-17
C119 (\12\:qbint VSS) capacitor c=9.03676e-17
C120 (\15\:qbint VSS) capacitor c=1.13107e-16
C121 (\6\:n35 VSS) capacitor c=1.65334e-16
C122 (\9\:n35 VSS) capacitor c=1.50894e-16
C123 (\10\:CKNbb VSS) capacitor c=7.78899e-17
C124 (\11\:CKNbb VSS) capacitor c=1.17838e-16
C125 (\7\:RNb VSS) capacitor c=1.52178e-16
C126 (\8\:RNb VSS) capacitor c=2.30672e-16
C127 (\9\:RNb VSS) capacitor c=1.3176e-16
C128 (\7\:SN VSS) capacitor c=2.89356e-16
C129 (\8\:SN VSS) capacitor c=3.04298e-16
C130 (\9\:SN VSS) capacitor c=2.81025e-17
C131 (\5\:mout VSS) capacitor c=5.05568e-17
C132 (\6\:mout VSS) capacitor c=6.31384e-17
C133 (\7\:mout VSS) capacitor c=7.11582e-17
C134 (\12\:mout VSS) capacitor c=4.88517e-17
C135 (\6\:n20 VSS) capacitor c=1.1046e-16
C136 (\9\:n20 VSS) capacitor c=8.67149e-17
C137 (\5\:D VSS) capacitor c=5.50027e-17
C138 (\14\:CKNbb VSS) capacitor c=6.00384e-17
C139 (\15\:CKNbb VSS) capacitor c=1.63952e-16
C140 (\16\:CKNbb VSS) capacitor c=2.16761e-16
C141 (\19\:CKNbb VSS) capacitor c=1.28566e-17
C142 (\20\:CKNbb VSS) capacitor c=2.26352e-17
C143 (\21\:CKNbb VSS) capacitor c=3.55284e-17
C144 (\10\:CKNb VSS) capacitor c=7.50829e-17
C145 (\11\:CKNb VSS) capacitor c=8.12621e-17
C146 (\12\:CKNb VSS) capacitor c=5.86678e-17
C147 (\4\:CKN VSS) capacitor c=3.31036e-17
C148 (\5\:VDD VSS) capacitor c=2.28582e-17
C149 (\6\:VDD VSS) capacitor c=5.29355e-17
C150 (\14\:VDD VSS) capacitor c=4.52969e-17
C151 (\17\:VDD VSS) capacitor c=3.27455e-17
C152 (\21\:VDD VSS) capacitor c=1.50312e-17
C153 (\24\:VDD VSS) capacitor c=1.20246e-17
Rk8 (\4\:RN RN) resistor r=0.04551 c=0
Rk50 (\4\:CKN CKN) resistor r=0.07373 c=0
Rk2 (\4\:QN QN) resistor r=0.08804 c=0
Rk1 (\2\:QN \4\:QN) resistor r=0.2248 c=0
Rk51 (\2\:VSS \4\:VSS) resistor r=0.3499 c=0
Rk52 (\4\:VSS \5\:VSS) resistor r=0.09009 c=0
Rk53 (\5\:VSS \6\:VSS) resistor r=0.3924 c=0
Rk54 (\6\:VSS \7\:VSS) resistor r=0.4678 c=0
Rk55 (\7\:VSS \8\:VSS) resistor r=0.8515 c=0
Rk56 (\8\:VSS \9\:VSS) resistor r=0.35 c=0
Rk57 (\9\:VSS \10\:VSS) resistor r=0.03742 c=0
Rk59 (\11\:VSS VSS) resistor r=0.2228 c=0
Rk58 (\10\:VSS \11\:VSS) resistor r=0.2905 c=0
Rk60 (\5\:VSS \13\:VSS) resistor r=0.07393 c=0
Rk61 (\6\:VSS \15\:VSS) resistor r=0.04331 c=0
Rk62 (\8\:VSS \17\:VSS) resistor r=0.04331 c=0
Rk63 (\10\:VSS \19\:VSS) resistor r=0.379 c=0
Rk64 (\11\:VSS \21\:VSS) resistor r=0.07393 c=0
Rk38 (\5\:D D) resistor r=0.07439 c=0
Rk6 (\2\:Q Q) resistor r=0.3038 c=0
Rk7 (Q \4\:Q) resistor r=0.1889 c=0
Rk65 (\2\:VDD \4\:VDD) resistor r=0.6791 c=0
Rk66 (\4\:VDD \5\:VDD) resistor r=0.07504 c=0
Rk67 (\5\:VDD \6\:VDD) resistor r=0.4435 c=0
Rk68 (\6\:VDD \7\:VDD) resistor r=0.4337 c=0
Rk69 (\5\:VDD \9\:VDD) resistor r=0.2621 c=0
Rk70 (\6\:VDD \11\:VDD) resistor r=0.07393 c=0
Rk71 (\7\:VDD \13\:VDD) resistor r=0.07147 c=0
Rk72 (\7\:VDD \14\:VDD) resistor r=0.5215 c=0
Rk73 (\14\:VDD \16\:VDD) resistor r=0.04331 c=0
Rk74 (\14\:VDD \17\:VDD) resistor r=0.3287 c=0
Rk75 (\17\:VDD \19\:VDD) resistor r=0.04331 c=0
Rk76 (\17\:VDD \20\:VDD) resistor r=0.35 c=0
Rk77 (\20\:VDD \21\:VDD) resistor r=0.03241 c=0
Rk78 (\21\:VDD \23\:VDD) resistor r=0.2054 c=0
Rk81 (\24\:VDD VDD) resistor r=0.2077 c=0
Rk79 (\21\:VDD \24\:VDD) resistor r=0.3106 c=0
Rk80 (\24\:VDD \26\:VDD) resistor r=0.4181 c=0
Rk26 (\8\:SN SN) resistor r=0.003077 c=0
Rk25 (\7\:SN \8\:SN) resistor r=2.1683 c=0
Rk27 (\8\:SN \9\:SN) resistor r=0.08618 c=0
Rk3 (\6\:qint \7\:qint) resistor r=0.1178 c=0
Rk4 (\7\:qint \8\:qint) resistor r=0.1194 c=0
Rk5 (\7\:qint \10\:qint) resistor r=0.1058 c=0
Rk9 (\11\:qbint \12\:qbint) resistor r=0.3368 c=0
Rk10 (\12\:qbint \14\:qbint) resistor r=0.101 c=0
Rk11 (\12\:qbint \15\:qbint) resistor r=0.6754 c=0
Rk12 (\14\:qbint \17\:qbint) resistor r=0.4463 c=0
Rk20 (\7\:RNb \8\:RNb) resistor r=0.9732 c=0
Rk21 (\8\:RNb \9\:RNb) resistor r=0.669 c=0
Rk22 (\9\:RNb \11\:RNb) resistor r=0.05532 c=0
Rk23 (\9\:RNb \13\:RNb) resistor r=0.5816 c=0
Rk16 (\5\:n35 \6\:n35) resistor r=0.276 c=0
Rk17 (\6\:n35 \8\:n35) resistor r=0.076 c=0
Rk18 (\6\:n35 \9\:n35) resistor r=1.0707 c=0
Rk13 (\2\:n42 \4\:n42) resistor r=0.6107 c=0
Rk14 (\2\:n40 \4\:n40) resistor r=0.5088 c=0
Rk19 (\10\:CKNbb \11\:CKNbb) resistor r=0.51 c=0
Rk39 (\13\:CKNbb \14\:CKNbb) resistor r=0.07429 c=0
Rk40 (\14\:CKNbb \15\:CKNbb) resistor r=0.2756 c=0
Rk41 (\15\:CKNbb \16\:CKNbb) resistor r=1.4921 c=0
Rk42 (\14\:CKNbb \18\:CKNbb) resistor r=0.3929 c=0
Rk43 (\15\:CKNbb \19\:CKNbb) resistor r=0.1018 c=0
Rk44 (\19\:CKNbb \20\:CKNbb) resistor r=0.06586 c=0
Rk45 (\19\:CKNbb \21\:CKNbb) resistor r=0.142 c=0
Rk28 (\5\:mout \6\:mout) resistor r=0.2852 c=0
Rk29 (\6\:mout \7\:mout) resistor r=0.3496 c=0
Rk30 (\7\:mout \9\:mout) resistor r=0.1396 c=0
Rk31 (\6\:mout \11\:mout) resistor r=0.08669 c=0
Rk32 (\7\:mout \12\:mout) resistor r=0.2373 c=0
Rk33 (\12\:mout \14\:mout) resistor r=0.1472 c=0
Rk34 (\12\:mout \16\:mout) resistor r=0.278 c=0
Rk46 (\10\:CKNb \11\:CKNb) resistor r=0.5205 c=0
Rk47 (\11\:CKNb \12\:CKNb) resistor r=0.3998 c=0
Rk48 (\12\:CKNb \14\:CKNb) resistor r=0.1977 c=0
Rk49 (\14\:CKNb \16\:CKNb) resistor r=0.4074 c=0
Rk24 (\2\:n25 \4\:n25) resistor r=0.5039 c=0
Rk35 (\5\:n20 \6\:n20) resistor r=0.3371 c=0
Rk36 (\6\:n20 \8\:n20) resistor r=0.4144 c=0
Rk37 (\6\:n20 \9\:n20) resistor r=0.4839 c=0
Rk15 (\2\:n41 \4\:n41) resistor r=0.6358 c=0
Rl10 (\1\:RN \2\:RN) resistor r=58.3841 c=0
Rl11 (\2\:RN \3\:RN) resistor r=135.307 c=0
Rl43 (\1\:CKN \2\:CKN) resistor r=85.3072 c=0
Rl44 (\2\:CKN \3\:CKN) resistor r=29.5379 c=0
Rl39 (\2\:D \3\:D) resistor r=122.865 c=0
Rl38 (\1\:D \2\:D) resistor r=50.4153 c=0
Rl40 (\2\:D \4\:D) resistor r=5.1011 c=0
Rl29 (\4\:SN \5\:SN) resistor r=161.104 c=0
Rl30 (\5\:SN \6\:SN) resistor r=73.7687 c=0
Rl14 (\1\:SN \2\:SN) resistor r=36.7742 c=0
Rl15 (\2\:SN \3\:SN) resistor r=91.8219 c=0
Rl3 (\2\:qint \4\:qint) resistor r=49.7141 c=0
Rl2 (\2\:qint \3\:qint) resistor r=34.3295 c=0
Rl1 (qint \2\:qint) resistor r=2.0213 c=0
Rl16 (\8\:qbint \9\:qbint) resistor r=142.308 c=0
Rl17 (\9\:qbint \10\:qbint) resistor r=42.0567 c=0
Rl4 (qbint \2\:qbint) resistor r=173.531 c=0
Rl7 (\2\:qbint \5\:qbint) resistor r=38.9161 c=0
Rl8 (\2\:qbint \6\:qbint) resistor r=5.7659 c=0
Rl9 (\3\:qbint \7\:qbint) resistor r=35.772 c=0
Rl6 (\3\:qbint \4\:qbint) resistor r=53.0797 c=0
Rl5 (\2\:qbint \3\:qbint) resistor r=143.992 c=0
Rl23 (\4\:RNb \5\:RNb) resistor r=157.258 c=0
Rl18 (RNb \2\:RNb) resistor r=222.643 c=0
Rl24 (\5\:RNb \6\:RNb) resistor r=124.513 c=0
Rl19 (\2\:RNb \3\:RNb) resistor r=62.2302 c=0
Rl12 (n35 \2\:n35) resistor r=87.2302 c=0
Rl13 (\2\:n35 \3\:n35) resistor r=29.5379 c=0
Rl37 (\8\:CKNbb \9\:CKNbb) resistor r=79.5379 c=0
Rl34 (\6\:CKNbb \7\:CKNbb) resistor r=61.4557 c=0
Rl21 (\3\:CKNbb \4\:CKNbb) resistor r=24.2328 c=0
Rl22 (\4\:CKNbb \5\:CKNbb) resistor r=114.412 c=0
Rl20 (CKNbb \2\:CKNbb) resistor r=93.4636 c=0
Rl33 (\2\:mout \4\:mout) resistor r=78.5603 c=0
Rl31 (mout \2\:mout) resistor r=106.972 c=0
Rl32 (\2\:mout \3\:mout) resistor r=2.0166 c=0
Rl41 (\7\:CKNb \8\:CKNb) resistor r=187.381 c=0
Rl35 (\4\:CKNb \5\:CKNb) resistor r=202.895 c=0
Rl27 (CKNb \2\:CKNb) resistor r=151.054 c=0
Rl42 (\8\:CKNb \9\:CKNb) resistor r=29.5379 c=0
Rl36 (\5\:CKNb \6\:CKNb) resistor r=29.5379 c=0
Rl28 (\2\:CKNb \3\:CKNb) resistor r=451.436 c=0
Rl25 (n20 \2\:n20) resistor r=85.7713 c=0
Rl26 (\2\:n20 \3\:n20) resistor r=26.1559 c=0
Rz1 (\3\:QN \4\:QN) resistor r=75 c=0
Rz18 (\1\:VSS \2\:VSS) resistor r=75 c=0
Rz19 (\12\:VSS \13\:VSS) resistor r=75 c=0
Rz20 (\14\:VSS \15\:VSS) resistor r=75 c=0
Rz21 (\16\:VSS \17\:VSS) resistor r=75 c=0
Rz22 (\18\:VSS \19\:VSS) resistor r=75 c=0
Rz23 (\20\:VSS \21\:VSS) resistor r=75 c=0
Rz3 (\3\:Q \4\:Q) resistor r=75 c=0
Rz24 (\3\:VDD \4\:VDD) resistor r=10.7143 c=0
Rz25 (\3\:VDD \7\:VDD) resistor r=6.25 c=0
Rz26 (\3\:VDD \20\:VDD) resistor r=6.25 c=0
Rz2 (\9\:qint \10\:qint) resistor r=75 c=0
Rz4 (\13\:qbint \14\:qbint) resistor r=75 c=0
Rz10 (\12\:RNb \13\:RNb) resistor r=75 c=0
Rz9 (\4\:n35 \5\:n35) resistor r=75 c=0
Rz5 (n42 \2\:n42) resistor r=75 c=0
Rz6 (\3\:n42 \4\:n42) resistor r=75 c=0
Rz7 (n40 \2\:n40) resistor r=75 c=0
Rz8 (\3\:n40 \4\:n40) resistor r=75 c=0
Rz16 (\17\:CKNbb \18\:CKNbb) resistor r=75 c=0
Rz13 (\8\:mout \9\:mout) resistor r=75 c=0
Rz14 (\13\:mout \14\:mout) resistor r=75 c=0
Rz17 (\13\:CKNb \14\:CKNb) resistor r=75 c=0
Rz11 (n25 \2\:n25) resistor r=75 c=0
Rz12 (\3\:n25 \4\:n25) resistor r=75 c=0
Rz15 (\4\:n20 \5\:n20) resistor r=75 c=0
Ry1 (\1\:QN \2\:QN) resistor r=62 c=0
Ry14 (\3\:VSS \4\:VSS) resistor r=8.8571 c=0
Ry15 (\3\:VSS \7\:VSS) resistor r=5.1667 c=0
Ry16 (\3\:VSS \9\:VSS) resistor r=5.1667 c=0
Ry3 (\1\:Q \2\:Q) resistor r=62 c=0
Ry17 (\1\:VDD \2\:VDD) resistor r=62 c=0
Ry18 (\8\:VDD \9\:VDD) resistor r=62 c=0
Ry19 (\10\:VDD \11\:VDD) resistor r=62 c=0
Ry20 (\12\:VDD \13\:VDD) resistor r=62 c=0
Ry21 (\15\:VDD \16\:VDD) resistor r=62 c=0
Ry22 (\18\:VDD \19\:VDD) resistor r=62 c=0
Ry23 (\22\:VDD \23\:VDD) resistor r=62 c=0
Ry24 (\25\:VDD \26\:VDD) resistor r=62 c=0
Ry2 (\5\:qint \6\:qint) resistor r=62 c=0
Ry4 (\16\:qbint \17\:qbint) resistor r=62 c=0
Ry8 (\10\:RNb \11\:RNb) resistor r=62 c=0
Ry7 (\7\:n35 \8\:n35) resistor r=62 c=0
Ry12 (\12\:CKNbb \13\:CKNbb) resistor r=62 c=0
Ry9 (\10\:mout \11\:mout) resistor r=62 c=0
Ry10 (\15\:mout \16\:mout) resistor r=62 c=0
Ry13 (\15\:CKNb \16\:CKNb) resistor r=62 c=0
Ry11 (\7\:n20 \8\:n20) resistor r=62 c=0
Ry5 (n41 \2\:n41) resistor r=62 c=0
Ry6 (\3\:n41 \4\:n41) resistor r=62 c=0
Rx2 (\2\:RN \4\:RN) resistor r=45 c=0
Rx21 (\2\:CKN \4\:CKN) resistor r=45 c=0
Rx14 (\4\:D \5\:D) resistor r=45 c=0
Rx10 (\6\:SN \7\:SN) resistor r=45 c=0
Rx11 (\2\:SN \9\:SN) resistor r=45 c=0
Rx1 (qint \8\:qint) resistor r=45 c=0
Rx3 (\10\:qbint \11\:qbint) resistor r=45 c=0
Rx4 (\6\:qbint \15\:qbint) resistor r=45 c=0
Rx8 (\6\:RNb \7\:RNb) resistor r=45 c=0
Rx9 (\3\:RNb \8\:RNb) resistor r=45 c=0
Rx5 (\2\:n35 \9\:n35) resistor r=45 c=0
Rx6 (\2\:CKNbb \10\:CKNbb) resistor r=45 c=0
Rx7 (\4\:CKNbb \11\:CKNbb) resistor r=45 c=0
Rx15 (\5\:CKNbb \16\:CKNbb) resistor r=45 c=0
Rx16 (\9\:CKNbb \20\:CKNbb) resistor r=45 c=0
Rx17 (\6\:CKNbb \21\:CKNbb) resistor r=45 c=0
Rx12 (\3\:mout \5\:mout) resistor r=45 c=0
Rx18 (\3\:CKNb \10\:CKNb) resistor r=45 c=0
Rx19 (\6\:CKNb \11\:CKNb) resistor r=45 c=0
Rx20 (\9\:CKNb \12\:CKNb) resistor r=45 c=0
Rx13 (\2\:n20 \9\:n20) resistor r=45 c=0
mn57 (\3\:QN \3\:qint \20\:VSS VSS) g45n1lvt w=(1.45e-07) l=4.5e-08 nf=1 \
        as=5.335e-14 ad=2.393e-14 ps=1.62e-06 pd=6.2e-07 nrd=1.16667 \
        nrs=1.16667 sa=1.65e-07 sb=3.45e-07 sd=160n sca=23.279 \
        scb=0.0230742 scc=0.00267719 m=(1)
mn56 (\9\:qint \4\:qbint \20\:VSS VSS) g45n1lvt w=(1.45e-07) l=4.5e-08 \
        nf=1 as=5.335e-14 ad=2.03e-14 ps=1.62e-06 pd=5.7e-07 nrd=1.16667 \
        nrs=1.16667 sa=3.7e-07 sb=1.4e-07 sd=160n sca=23.279 scb=0.0230742 \
        scc=0.00267719 m=(1)
mn55 (\3\:Q \5\:qbint \18\:VSS VSS) g45n1lvt w=(1.45e-07) l=4.5e-08 nf=1 \
        as=2.465e-14 ad=2.03e-14 ps=6.3e-07 pd=5.7e-07 nrd=1.16667 \
        nrs=1.16667 sa=1.4e-07 sb=4.6e-07 sd=160n sca=22.3376 \
        scb=0.0224607 scc=0.00248252 m=(1)
mn22 (\12\:RNb \3\:RN \18\:VSS VSS) g45n1lvt w=(1.45e-07) l=4.5e-08 nf=1 \
        as=2.465e-14 ad=3.553e-14 ps=6.3e-07 pd=7.8e-07 nrd=1.16667 \
        nrs=1.16667 sa=3.55e-07 sb=2.45e-07 sd=160n sca=22.3376 \
        scb=0.0224607 scc=0.00248252 m=(1)
mn45 (\13\:qbint \3\:n35 \16\:VSS VSS) g45n1lvt w=(1.45e-07) l=4.5e-08 \
        nf=1 as=5.77e-14 ad=2.03e-14 ps=1.68e-06 pd=5.7e-07 nrd=1.16667 \
        nrs=1.16667 sa=1.4e-07 sb=9.7e-07 sd=160n sca=23.279 scb=0.0230742 \
        scc=0.00267719 m=(1)
mn50 (\3\:n42 \3\:SN \16\:VSS VSS) g45n1lvt w=(1.45e-07) l=4.5e-08 nf=1 \
        as=5.77e-14 ad=2.755e-14 ps=1.68e-06 pd=6.7e-07 nrd=1.16667 \
        nrs=1.16667 sa=3.75e-07 sb=7.35e-07 sd=160n sca=23.279 \
        scb=0.0230742 scc=0.00267719 m=(1)
mn52 (n40 \9\:qbint \3\:n42 VSS) g45n1lvt w=(1.45e-07) l=4.5e-08 nf=1 \
        as=2.755e-14 ad=4.568e-14 ps=6.7e-07 pd=9.2e-07 nrd=1.16667 \
        nrs=1.16667 sa=6.1e-07 sb=5e-07 sd=160n sca=23.279 scb=0.0230742 \
        scc=0.00267719 m=(1)
mn51 (n40 RNb n42 VSS) g45n1lvt w=(1.45e-07) l=4.5e-08 nf=1 as=2.03e-14 \
        ad=4.568e-14 ps=5.7e-07 pd=9.2e-07 nrd=1.16667 nrs=1.16667 \
        sa=9.7e-07 sb=1.4e-07 sd=160n sca=23.279 scb=0.0230742 \
        scc=0.00267719 m=(1)
mn53 (\3\:n40 CKNbb \4\:n35 VSS) g45n1lvt w=(1.45e-07) l=4.5e-08 nf=1 \
        as=2.32e-14 ad=2.03e-14 ps=6.1e-07 pd=5.7e-07 nrd=1.16667 \
        nrs=1.16667 sa=1.4e-07 sb=4.8e-07 sd=160n sca=19.1673 \
        scb=0.0200674 scc=0.00182521 m=(1)
mn40 (\4\:n35 \2\:CKNb \13\:mout VSS) g45n1lvt w=(1.45e-07) l=4.5e-08 \
        nf=1 as=3.988e-14 ad=2.32e-14 ps=8.4e-07 pd=6.1e-07 nrd=1.16667 \
        nrs=1.16667 sa=3.45e-07 sb=2.75e-07 sd=160n sca=19.1673 \
        scb=0.0200674 scc=0.00182521 m=(1)
mn31 (n25 \4\:RNb \8\:mout VSS) g45n1lvt w=(1.45e-07) l=4.5e-08 nf=1 \
        as=2.393e-14 ad=2.03e-14 ps=6.2e-07 pd=5.7e-07 nrd=1.16667 \
        nrs=1.16667 sa=1.4e-07 sb=1.815e-06 sd=160n sca=23.279 \
        scb=0.0230742 scc=0.00267719 m=(1)
mn32 (\8\:mout \3\:n20 \3\:n25 VSS) g45n1lvt w=(1.45e-07) l=4.5e-08 nf=1 \
        as=4.93e-14 ad=2.393e-14 ps=9.7e-07 pd=6.2e-07 nrd=1.16667 \
        nrs=1.16667 sa=3.5e-07 sb=1.605e-06 sd=160n sca=23.279 \
        scb=0.0230742 scc=0.00267719 m=(1)
mn30 (\3\:n25 \4\:SN \14\:VSS VSS) g45n1lvt w=(1.45e-07) l=4.5e-08 nf=1 \
        as=8.41e-14 ad=4.93e-14 ps=1.6e-06 pd=9.7e-07 nrd=1.16667 \
        nrs=1.16667 sa=7.35e-07 sb=1.22e-06 sd=160n sca=23.279 \
        scb=0.0230742 scc=0.00267719 m=(1)
mn35 (n30 mout \14\:VSS VSS) g45n1lvt w=(1.45e-07) l=4.5e-08 nf=1 \
        as=8.41e-14 ad=2.973e-14 ps=1.6e-06 pd=7e-07 nrd=1.16667 \
        nrs=1.16667 sa=1e-06 sb=9.55e-07 sd=160n sca=23.279 scb=0.0230742 \
        scc=0.00267719 m=(1)
mn36 (\4\:n20 \5\:CKNb n30 VSS) g45n1lvt w=(1.45e-07) l=4.5e-08 nf=1 \
        as=2.973e-14 ad=2.32e-14 ps=7e-07 pd=6.1e-07 nrd=1.16667 \
        nrs=1.16667 sa=1.25e-06 sb=7.05e-07 sd=160n sca=23.279 \
        scb=0.0230742 scc=0.00267719 m=(1)
mn26 (\4\:n20 \8\:CKNbb n21 VSS) g45n1lvt w=(1.45e-07) l=4.5e-08 nf=1 \
        as=1.305e-14 ad=2.32e-14 ps=4.7e-07 pd=6.1e-07 nrd=1.16667 \
        nrs=1.16667 sa=1.455e-06 sb=5e-07 sd=160n sca=23.279 scb=0.0230742 \
        scc=0.00267719 m=(1)
mn25 (n21 \1\:D \12\:VSS VSS) g45n1lvt w=(1.45e-07) l=4.5e-08 nf=1 \
        as=5.625e-14 ad=1.305e-14 ps=1.66e-06 pd=4.7e-07 nrd=1.16667 \
        nrs=1.16667 sa=1.59e-06 sb=3.65e-07 sd=160n sca=23.279 \
        scb=0.0230742 scc=0.00267719 m=(1)
mn21 (\17\:CKNbb \8\:CKNb \12\:VSS VSS) g45n1lvt w=(1.45e-07) l=4.5e-08 \
        nf=1 as=5.625e-14 ad=2.03e-14 ps=1.66e-06 pd=5.7e-07 nrd=1.16667 \
        nrs=1.16667 sa=1.815e-06 sb=1.4e-07 sd=160n sca=23.279 \
        scb=0.0230742 scc=0.00267719 m=(1)
mn20 (\13\:CKNb \3\:CKN \1\:VSS VSS) g45n1lvt w=(1.45e-07) l=4.5e-08 \
        nf=1 as=3.84e-14 ad=2.465e-14 ps=1.25e-06 pd=6.3e-07 nrd=1.16667 \
        nrs=1.16667 sa=1.7e-07 sb=1e-07 sd=160n sca=10.9472 scb=0.0104991 \
        scc=0.000356047 m=(1)
ends DFFNSRXL
// End of subcircuit definition.
