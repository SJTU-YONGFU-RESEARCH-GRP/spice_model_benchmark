// Generated for: spectre (May  1 09:17:37 2013 )
// Library name: gsclib045_lvt
// Cell name: NOR4BXL
// View name: extracted

simulator lang=spectre

subckt NOR4BXL AN B C D VDD VSS Y
mp4 (\6\:Y \1\:D n3 VDD) g45p1lvt w=(2.15e-07) l=4.5e-08 nf=1 \
        as=1.828e-14 ad=3.01e-14 ps=6e-07 pd=7.1e-07 nrd=1.16667 \
        nrs=1.16667 sa=1.4e-07 sb=9.05e-07 sd=160n sca=34.5672 \
        scb=0.0266035 scc=0.00427242 m=(1)
mp3 (n3 \1\:C n2 VDD) g45p1lvt w=(2.15e-07) l=4.5e-08 nf=1 as=3.44e-14 \
        ad=1.828e-14 ps=7.5e-07 pd=6e-07 nrd=1.16667 nrs=1.16667 \
        sa=2.7e-07 sb=7.75e-07 sd=160n sca=33.8938 scb=0.0260321 \
        scc=0.00427143 m=(1)
mp2 (n2 \1\:B n1 VDD) g45p1lvt w=(2.15e-07) l=4.5e-08 nf=1 as=3.87e-14 \
        ad=3.44e-14 ps=7.9e-07 pd=7.5e-07 nrd=1.16667 nrs=1.16667 \
        sa=4.75e-07 sb=5.7e-07 sd=160n sca=33.5475 scb=0.0258591 \
        scc=0.00427134 m=(1)
mp1 (n1 n0 \1\:VDD VDD) g45p1lvt w=(2.15e-07) l=4.5e-08 nf=1 as=3.44e-14 \
        ad=3.87e-14 ps=7.5e-07 pd=7.9e-07 nrd=1.16667 nrs=1.16667 sa=7e-07 \
        sb=3.45e-07 sd=160n sca=34.4077 scb=0.0264408 scc=0.00427202 m=(1)
mp0 (\8\:n0 \1\:AN \1\:VDD VDD) g45p1lvt w=(2.15e-07) l=4.5e-08 nf=1 \
        as=3.44e-14 ad=3.01e-14 ps=7.5e-07 pd=7.1e-07 nrd=1.16667 \
        nrs=1.16667 sa=9.05e-07 sb=1.4e-07 sd=160n sca=36.537 \
        scb=0.0294967 scc=0.00430052 m=(1)
C1 (B VSS) capacitor c=5.53562e-17
C2 (Y VSS) capacitor c=8.88043e-17
C3 (C VSS) capacitor c=4.5168e-17
C4 (D VSS) capacitor c=4.55476e-17
C5 (AN VSS) capacitor c=7.56629e-17
C6 (VDD VSS) capacitor c=1.03374e-16
C7 (n0 VSS) capacitor c=5.12578e-17
C8 (n3 VSS) capacitor c=3.58718e-18
C9 (n2 VSS) capacitor c=1.31157e-18
C10 (n1 VSS) capacitor c=4.81392e-18
C11 (\1\:AN VSS) capacitor c=3.87347e-17
C12 (\1\:B VSS) capacitor c=3.79516e-17
C13 (\1\:C VSS) capacitor c=4.85632e-17
C14 (\1\:D VSS) capacitor c=4.36981e-17
C15 (\3\:AN VSS) capacitor c=4.05448e-17
C16 (\3\:n0 VSS) capacitor c=3.25921e-17
C17 (\3\:B VSS) capacitor c=4.25595e-17
C18 (\3\:C VSS) capacitor c=4.86018e-17
C19 (\3\:D VSS) capacitor c=4.23202e-17
C20 (\2\:AN VSS) capacitor c=4.08469e-17
C21 (\2\:n0 VSS) capacitor c=5.04891e-17
C22 (\2\:B VSS) capacitor c=5.06059e-17
C23 (\2\:C VSS) capacitor c=5.11645e-17
C24 (\2\:D VSS) capacitor c=4.88854e-17
C25 (\8\:n0 VSS) capacitor c=8.1842e-17
C26 (\1\:VDD VSS) capacitor c=3.29954e-17
C27 (\6\:Y VSS) capacitor c=6.9305e-17
C28 (\4\:n0 VSS) capacitor c=1.93484e-17
C29 (\4\:Y VSS) capacitor c=7.1936e-17
C30 (\1\:Y VSS) capacitor c=2.6436e-17
C31 (\4\:D VSS) capacitor c=6.77864e-17
C32 (\4\:C VSS) capacitor c=5.51588e-17
C33 (\3\:Y VSS) capacitor c=7.86611e-17
C34 (\4\:B VSS) capacitor c=3.68842e-17
C35 (\4\:AN VSS) capacitor c=2.61416e-17
C36 (\6\:n0 VSS) capacitor c=6.44997e-17
C37 (\7\:n0 VSS) capacitor c=3.78861e-17
C38 (\4\:VDD VSS) capacitor c=3.53644e-17
Rk7 (\4\:B B) resistor r=0.1578 c=0
Rk14 (\2\:VSS \4\:VSS) resistor r=0.3651 c=0
Rk15 (\4\:VSS \5\:VSS) resistor r=0.02978 c=0
Rk17 (\6\:VSS VSS) resistor r=0.1644 c=0
Rk16 (\5\:VSS \6\:VSS) resistor r=0.2045 c=0
Rk18 (\5\:VSS \8\:VSS) resistor r=0.1782 c=0
Rk19 (\6\:VSS \10\:VSS) resistor r=0.1777 c=0
Rk4 (\3\:Y Y) resistor r=0.4804 c=0
Rk3 (\2\:Y \3\:Y) resistor r=0.09909 c=0
Rk5 (\3\:Y \5\:Y) resistor r=0.3772 c=0
Rk6 (Y \7\:Y) resistor r=0.535 c=0
Rk2 (\4\:C C) resistor r=0.185 c=0
Rk1 (D \4\:D) resistor r=0.0638 c=0
Rk8 (AN \4\:AN) resistor r=0.1458 c=0
Rk13 (\4\:VDD VDD) resistor r=0.3995 c=0
Rk12 (\2\:VDD \4\:VDD) resistor r=0.5856 c=0
Rk9 (\5\:n0 \6\:n0) resistor r=0.09588 c=0
Rk10 (\6\:n0 \7\:n0) resistor r=0.2001 c=0
Rk11 (\6\:n0 \9\:n0) resistor r=0.6626 c=0
Rl5 (\1\:B \2\:B) resistor r=83.3841 c=0
Rl6 (\2\:B \3\:B) resistor r=100.692 c=0
Rl3 (\1\:C \2\:C) resistor r=64.1533 c=0
Rl4 (\2\:C \3\:C) resistor r=119.922 c=0
Rl1 (\1\:D \2\:D) resistor r=53.8233 c=0
Rl2 (\2\:D \3\:D) resistor r=140.18 c=0
Rl9 (\1\:AN \2\:AN) resistor r=81.9251 c=0
Rl10 (\2\:AN \3\:AN) resistor r=99.2328 c=0
Rl7 (n0 \2\:n0) resistor r=144.923 c=0
Rl8 (\2\:n0 \3\:n0) resistor r=39.1533 c=0
Rz5 (\1\:VSS \2\:VSS) resistor r=75 c=0
Rz6 (\7\:VSS \8\:VSS) resistor r=75 c=0
Rz7 (\9\:VSS \10\:VSS) resistor r=75 c=0
Rz1 (\1\:Y \2\:Y) resistor r=75 c=0
Rz2 (\4\:Y \5\:Y) resistor r=75 c=0
Rz3 (\4\:n0 \5\:n0) resistor r=75 c=0
Ry1 (\6\:Y \7\:Y) resistor r=62 c=0
Ry3 (\1\:VDD \2\:VDD) resistor r=62 c=0
Ry2 (\8\:n0 \9\:n0) resistor r=62 c=0
Rx3 (\2\:B \4\:B) resistor r=45 c=0
Rx2 (\2\:C \4\:C) resistor r=45 c=0
Rx1 (\2\:D \4\:D) resistor r=45 c=0
Rx4 (\2\:AN \4\:AN) resistor r=45 c=0
Rx5 (\2\:n0 \7\:n0) resistor r=45 c=0
mn4 (\1\:Y \3\:D \9\:VSS VSS) g45n1lvt w=(1.45e-07) l=4.5e-08 nf=1 \
        as=2.03e-14 ad=2.32e-14 ps=5.7e-07 pd=6.1e-07 nrd=1.16667 \
        nrs=1.16667 sa=1.4e-07 sb=9.8e-07 sd=160n sca=6.67224 \
        scb=0.00331168 scc=2.36561e-05 m=(1)
mn3 (\1\:Y \3\:C \7\:VSS VSS) g45n1lvt w=(1.45e-07) l=4.5e-08 nf=1 \
        as=2.32e-14 ad=2.32e-14 ps=6.1e-07 pd=6.1e-07 nrd=1.16667 \
        nrs=1.16667 sa=3.45e-07 sb=7.75e-07 sd=160n sca=6.67224 \
        scb=0.00331168 scc=2.36561e-05 m=(1)
mn2 (\4\:Y \3\:B \7\:VSS VSS) g45n1lvt w=(1.45e-07) l=4.5e-08 nf=1 \
        as=2.32e-14 ad=2.61e-14 ps=6.1e-07 pd=6.5e-07 nrd=1.16667 \
        nrs=1.16667 sa=5.5e-07 sb=5.7e-07 sd=160n sca=6.67224 \
        scb=0.00331168 scc=2.36561e-05 m=(1)
mn1 (\4\:Y \3\:n0 \1\:VSS VSS) g45n1lvt w=(1.45e-07) l=4.5e-08 nf=1 \
        as=2.32e-14 ad=2.61e-14 ps=6.1e-07 pd=6.5e-07 nrd=1.16667 \
        nrs=1.16667 sa=7.75e-07 sb=3.45e-07 sd=160n sca=6.67224 \
        scb=0.00331168 scc=2.36561e-05 m=(1)
mn0 (\4\:n0 \3\:AN \1\:VSS VSS) g45n1lvt w=(1.45e-07) l=4.5e-08 nf=1 \
        as=2.32e-14 ad=2.03e-14 ps=6.1e-07 pd=5.7e-07 nrd=1.16667 \
        nrs=1.16667 sa=9.8e-07 sb=1.4e-07 sd=160n sca=6.67224 \
        scb=0.00331168 scc=2.36561e-05 m=(1)
ends NOR4BXL
// End of subcircuit definition.
