// Generated for: spectre (May  1 09:13:59 2013 )
// Library name: gsclib045_lvt
// Cell name: DFFSRX1
// View name: extracted

simulator lang=spectre

subckt DFFSRX1 CK D Q QN RN SN VDD VSS
mp57 (\1\:QN \4\:qint \26\:VDD VDD) g45p1lvt w=(3.9e-07) l=4.5e-08 nf=1 \
        as=7.142e-14 ad=5.46e-14 ps=1.52e-06 pd=1.06e-06 nrd=1.16667 \
        nrs=1.16667 sa=1.4e-07 sb=2.4e-07 sd=160n sca=34.3332 \
        scb=0.0249008 scc=0.00341086 m=(1)
mp55 (\3\:Q qbint \24\:VDD VDD) g45p1lvt w=(3.9e-07) l=4.5e-08 nf=1 \
        as=5.19e-14 ad=4.86e-14 ps=1.1e-06 pd=1.06e-06 nrd=1.16667 \
        nrs=1.16667 sa=1.24615e-07 sb=2.33013e-07 sd=160n sca=30.5009 \
        scb=0.0202006 scc=0.00336097 m=(1)
C1 (RN VSS) capacitor c=7.5286e-17
C2 (CK VSS) capacitor c=5.14835e-17
C3 (D VSS) capacitor c=4.78905e-17
C4 (QN VSS) capacitor c=2.29657e-17
C5 (VDD VSS) capacitor c=4.47426e-16
C6 (SN VSS) capacitor c=1.64835e-17
C7 (Q VSS) capacitor c=8.01254e-17
C8 (qint VSS) capacitor c=2.1329e-17
C9 (qbint VSS) capacitor c=5.52388e-17
C10 (RNb VSS) capacitor c=4.86093e-17
C11 (n35 VSS) capacitor c=3.59062e-17
C12 (n42 VSS) capacitor c=8.10794e-17
C13 (n40 VSS) capacitor c=1.08464e-16
C14 (CKb VSS) capacitor c=7.27769e-17
C15 (mout VSS) capacitor c=6.75092e-17
C16 (CKbb VSS) capacitor c=5.37631e-17
C17 (net426 VSS) capacitor c=1.12367e-16
C18 (n20 VSS) capacitor c=5.85392e-17
C19 (n41 VSS) capacitor c=9.27777e-17
C20 (n43 VSS) capacitor c=1.58142e-18
C21 (net402 VSS) capacitor c=6.80571e-18
C22 (n31 VSS) capacitor c=3.39662e-18
C23 (n22 VSS) capacitor c=2.56124e-18
C24 (\4\:CK VSS) capacitor c=4.31344e-17
C25 (\7\:CKb VSS) capacitor c=3.18967e-17
C26 (\1\:D VSS) capacitor c=7.54601e-17
C27 (\7\:CKbb VSS) capacitor c=6.09541e-17
C28 (\5\:CKb VSS) capacitor c=5.45409e-17
C29 (\4\:SN VSS) capacitor c=4.43625e-17
C30 (\2\:CKb VSS) capacitor c=7.75091e-17
C31 (\4\:RNb VSS) capacitor c=7.0232e-17
C32 (\8\:qbint VSS) capacitor c=7.39365e-17
C33 (\1\:SN VSS) capacitor c=3.77594e-17
C34 (\3\:n35 VSS) capacitor c=3.52511e-17
C35 (\3\:RN VSS) capacitor c=3.52625e-17
C36 (\7\:qbint VSS) capacitor c=3.6557e-17
C37 (\4\:qint VSS) capacitor c=4.73574e-17
C38 (\3\:CK VSS) capacitor c=2.02971e-17
C39 (\8\:CKb VSS) capacitor c=3.67278e-17
C40 (\3\:D VSS) capacitor c=2.60564e-17
C41 (\4\:CKb VSS) capacitor c=5.34412e-17
C42 (\5\:CKbb VSS) capacitor c=6.70931e-17
C43 (\3\:mout VSS) capacitor c=5.68814e-17
C44 (\6\:SN VSS) capacitor c=5.91576e-17
C45 (\2\:n20 VSS) capacitor c=2.85283e-17
C46 (\2\:RNb VSS) capacitor c=1.08328e-16
C47 (\3\:CKbb VSS) capacitor c=4.48782e-17
C48 (\3\:RNb VSS) capacitor c=1.25258e-16
C49 (\11\:qbint VSS) capacitor c=3.23002e-17
C50 (\3\:SN VSS) capacitor c=4.01711e-17
C51 (\1\:RN VSS) capacitor c=4.09463e-17
C52 (\6\:qbint VSS) capacitor c=3.65208e-17
C53 (\4\:qbint VSS) capacitor c=2.65005e-17
C54 (\3\:qint VSS) capacitor c=3.66877e-17
C55 (\1\:CK VSS) capacitor c=1.16957e-17
C56 (\9\:CKb VSS) capacitor c=1.57471e-17
C57 (\2\:D VSS) capacitor c=4.68853e-17
C58 (\8\:CKbb VSS) capacitor c=4.16424e-17
C59 (\6\:CKb VSS) capacitor c=2.57079e-17
C60 (\6\:CKbb VSS) capacitor c=4.60525e-17
C61 (\2\:mout VSS) capacitor c=5.07454e-17
C62 (\5\:SN VSS) capacitor c=4.27768e-17
C63 (\3\:n20 VSS) capacitor c=2.94282e-17
C64 (\3\:CKb VSS) capacitor c=2.13306e-17
C65 (\4\:CKbb VSS) capacitor c=4.37822e-17
C66 (\2\:CKbb VSS) capacitor c=2.53203e-17
C67 (\5\:RNb VSS) capacitor c=2.61851e-17
C68 (\10\:qbint VSS) capacitor c=1.72751e-17
C69 (\2\:SN VSS) capacitor c=4.73915e-17
C70 (\2\:n35 VSS) capacitor c=4.53398e-17
C71 (\2\:RN VSS) capacitor c=2.96285e-17
C72 (\5\:qbint VSS) capacitor c=4.18673e-17
C73 (\1\:VDD VSS) capacitor c=2.68326e-17
C74 (\12\:CKb VSS) capacitor c=4.8745e-17
C75 (\14\:VDD VSS) capacitor c=1.39105e-17
C76 (\7\:n20 VSS) capacitor c=8.56693e-17
C77 (\16\:VDD VSS) capacitor c=2.6063e-17
C78 (\7\:mout VSS) capacitor c=1.54519e-16
C79 (\18\:VDD VSS) capacitor c=2.48879e-17
C80 (\9\:mout VSS) capacitor c=1.71301e-16
C81 (\8\:n35 VSS) capacitor c=2.0483e-17
C82 (\20\:VDD VSS) capacitor c=3.94099e-17
C83 (\3\:n41 VSS) capacitor c=1.17516e-16
C84 (\22\:VDD VSS) capacitor c=2.10735e-17
C85 (\17\:qbint VSS) capacitor c=5.14992e-17
C86 (\7\:RNb VSS) capacitor c=1.43482e-16
C87 (\24\:VDD VSS) capacitor c=5.97892e-17
C88 (\3\:Q VSS) capacitor c=2.8085e-17
C89 (\5\:qint VSS) capacitor c=3.5028e-17
C90 (\26\:VDD VSS) capacitor c=1.47221e-17
C91 (\1\:QN VSS) capacitor c=3.55638e-17
C92 (\4\:VDD VSS) capacitor c=8.28729e-17
C93 (\10\:CKb VSS) capacitor c=8.55964e-17
C94 (\11\:CKbb VSS) capacitor c=5.14088e-17
C95 (\5\:n20 VSS) capacitor c=9.06006e-17
C96 (\4\:mout VSS) capacitor c=1.03592e-16
C97 (\3\:net426 VSS) capacitor c=8.90871e-17
C98 (\11\:mout VSS) capacitor c=6.94944e-17
C99 (\4\:n35 VSS) capacitor c=6.7484e-17
C100 (\3\:n40 VSS) capacitor c=9.01267e-17
C101 (\3\:n42 VSS) capacitor c=7.56466e-17
C102 (\14\:qbint VSS) capacitor c=8.15174e-17
C103 (\9\:RNb VSS) capacitor c=6.55549e-17
C104 (\1\:Q VSS) capacitor c=8.95971e-17
C105 (\9\:qint VSS) capacitor c=2.58045e-17
C106 (\3\:QN VSS) capacitor c=2.73384e-17
C107 (\2\:qint VSS) capacitor c=7.08461e-18
C108 (\3\:qbint VSS) capacitor c=3.33689e-17
C109 (\9\:qbint VSS) capacitor c=4.29577e-17
C110 (\7\:qint VSS) capacitor c=2.85808e-17
C111 (\8\:qint VSS) capacitor c=1.97065e-17
C112 (\4\:RN VSS) capacitor c=4.81421e-17
C113 (\2\:CK VSS) capacitor c=2.41424e-17
C114 (\12\:qbint VSS) capacitor c=7.44823e-17
C115 (\13\:qbint VSS) capacitor c=7.11433e-17
C116 (\16\:qbint VSS) capacitor c=1.55093e-16
C117 (\6\:RNb VSS) capacitor c=1.59017e-16
C118 (\6\:n35 VSS) capacitor c=2.08225e-16
C119 (\7\:n35 VSS) capacitor c=1.61049e-16
C120 (\7\:SN VSS) capacitor c=2.58804e-16
C121 (\8\:SN VSS) capacitor c=3.40561e-16
C122 (\9\:SN VSS) capacitor c=1.51022e-16
C123 (\6\:mout VSS) capacitor c=1.15953e-16
C124 (\4\:n20 VSS) capacitor c=7.00915e-17
C125 (\4\:D VSS) capacitor c=5.79547e-17
C126 (\10\:CKbb VSS) capacitor c=9.53607e-17
C127 (\13\:CKbb VSS) capacitor c=8.71248e-17
C128 (\14\:CKbb VSS) capacitor c=3.20267e-17
C129 (\15\:CKbb VSS) capacitor c=2.41765e-16
C130 (\16\:CKbb VSS) capacitor c=7.54972e-17
C131 (\17\:CKbb VSS) capacitor c=2.05193e-16
C132 (\18\:CKbb VSS) capacitor c=7.03081e-17
C133 (\19\:CKbb VSS) capacitor c=3.03347e-17
C134 (\14\:CKb VSS) capacitor c=9.58625e-17
C135 (\15\:CKb VSS) capacitor c=2.13983e-16
C136 (\16\:CKb VSS) capacitor c=1.72841e-16
C137 (\5\:CK VSS) capacitor c=4.07125e-17
C138 (\3\:VDD VSS) capacitor c=1.67926e-17
C139 (\6\:VDD VSS) capacitor c=3.92476e-17
C140 (\7\:VDD VSS) capacitor c=2.84839e-17
C141 (\9\:VDD VSS) capacitor c=2.56333e-17
C142 (\10\:VDD VSS) capacitor c=3.24486e-17
C143 (\11\:VDD VSS) capacitor c=1.69377e-17
C144 (\13\:VDD VSS) capacitor c=1.16823e-17
Rk8 (\4\:RN RN) resistor r=0.03589 c=0
Rk63 (\2\:VSS \4\:VSS) resistor r=0.4432 c=0
Rk64 (\4\:VSS \5\:VSS) resistor r=0.3674 c=0
Rk65 (\5\:VSS \6\:VSS) resistor r=0.6834 c=0
Rk66 (\6\:VSS \7\:VSS) resistor r=0.6893 c=0
Rk67 (\7\:VSS \8\:VSS) resistor r=0.5144 c=0
Rk69 (\9\:VSS VSS) resistor r=0.2152 c=0
Rk68 (\8\:VSS \9\:VSS) resistor r=0.3358 c=0
Rk70 (\4\:VSS \11\:VSS) resistor r=0.3236 c=0
Rk71 (\5\:VSS \13\:VSS) resistor r=0.0433 c=0
Rk72 (\7\:VSS \15\:VSS) resistor r=0.286 c=0
Rk73 (\8\:VSS \17\:VSS) resistor r=0.2937 c=0
Rk74 (\9\:VSS \19\:VSS) resistor r=0.07381 c=0
Rk44 (CK \5\:CK) resistor r=0.1857 c=0
Rk31 (\4\:D D) resistor r=0.1113 c=0
Rk2 (\4\:QN QN) resistor r=0.09286 c=0
Rk1 (\2\:QN \4\:QN) resistor r=0.3057 c=0
Rk45 (\2\:VDD \3\:VDD) resistor r=0.524 c=0
Rk46 (\3\:VDD \5\:VDD) resistor r=0.08506 c=0
Rk47 (\5\:VDD \6\:VDD) resistor r=0.3674 c=0
Rk48 (\6\:VDD \7\:VDD) resistor r=0.3864 c=0
Rk49 (\7\:VDD \8\:VDD) resistor r=0.2947 c=0
Rk50 (\8\:VDD \9\:VDD) resistor r=0.3258 c=0
Rk51 (\9\:VDD \10\:VDD) resistor r=0.3933 c=0
Rk52 (\10\:VDD \11\:VDD) resistor r=0.4509 c=0
Rk53 (\11\:VDD \12\:VDD) resistor r=0.0324 c=0
Rk55 (\13\:VDD VDD) resistor r=0.2152 c=0
Rk54 (\12\:VDD \13\:VDD) resistor r=0.3358 c=0
Rk56 (\3\:VDD \15\:VDD) resistor r=0.07381 c=0
Rk57 (\6\:VDD \17\:VDD) resistor r=0.0433 c=0
Rk58 (\7\:VDD \19\:VDD) resistor r=0.0433 c=0
Rk59 (\9\:VDD \21\:VDD) resistor r=0.2106 c=0
Rk60 (\10\:VDD \23\:VDD) resistor r=0.1606 c=0
Rk61 (\11\:VDD \25\:VDD) resistor r=0.4377 c=0
Rk62 (\13\:VDD \27\:VDD) resistor r=0.224 c=0
Rk24 (\8\:SN SN) resistor r=0.003075 c=0
Rk22 (\7\:SN \8\:SN) resistor r=1.7566 c=0
Rk23 (\8\:SN \9\:SN) resistor r=0.953 c=0
Rk6 (\2\:Q Q) resistor r=0.516 c=0
Rk7 (Q \4\:Q) resistor r=0.1147 c=0
Rk3 (\6\:qint \7\:qint) resistor r=0.1297 c=0
Rk4 (\7\:qint \8\:qint) resistor r=0.1193 c=0
Rk5 (\7\:qint \10\:qint) resistor r=0.09372 c=0
Rk9 (\12\:qbint \13\:qbint) resistor r=0.442 c=0
Rk10 (\13\:qbint \15\:qbint) resistor r=0.1168 c=0
Rk11 (\15\:qbint \16\:qbint) resistor r=0.8819 c=0
Rk12 (\13\:qbint \18\:qbint) resistor r=0.3615 c=0
Rk13 (\6\:RNb \8\:RNb) resistor r=1.1236 c=0
Rk14 (\8\:RNb \10\:RNb) resistor r=0.3443 c=0
Rk18 (\5\:n35 \6\:n35) resistor r=0.4217 c=0
Rk19 (\6\:n35 \7\:n35) resistor r=1.0999 c=0
Rk20 (\6\:n35 \9\:n35) resistor r=0.02819 c=0
Rk15 (\2\:n42 \4\:n42) resistor r=0.5071 c=0
Rk16 (\2\:n40 \4\:n40) resistor r=0.3825 c=0
Rk40 (\11\:CKb \13\:CKb) resistor r=0.4962 c=0
Rk41 (\13\:CKb \14\:CKb) resistor r=0.1784 c=0
Rk42 (\14\:CKb \15\:CKb) resistor r=0.6457 c=0
Rk43 (\15\:CKb \16\:CKb) resistor r=1.2117 c=0
Rk25 (\5\:mout \6\:mout) resistor r=0.6022 c=0
Rk26 (\6\:mout \8\:mout) resistor r=0.4012 c=0
Rk27 (\8\:mout \10\:mout) resistor r=0.7289 c=0
Rk28 (\10\:mout \12\:mout) resistor r=0.4104 c=0
Rk32 (\10\:CKbb \12\:CKbb) resistor r=0.3313 c=0
Rk33 (\10\:CKbb \13\:CKbb) resistor r=0.3908 c=0
Rk34 (\13\:CKbb \14\:CKbb) resistor r=0.1309 c=0
Rk35 (\13\:CKbb \15\:CKbb) resistor r=0.4364 c=0
Rk36 (\15\:CKbb \16\:CKbb) resistor r=0.3354 c=0
Rk37 (\15\:CKbb \17\:CKbb) resistor r=1.3065 c=0
Rk38 (\17\:CKbb \18\:CKbb) resistor r=0.2507 c=0
Rk39 (\17\:CKbb \19\:CKbb) resistor r=0.3024 c=0
Rk21 (\2\:net426 \4\:net426) resistor r=0.6545 c=0
Rk29 (\4\:n20 \6\:n20) resistor r=0.4771 c=0
Rk30 (\6\:n20 \8\:n20) resistor r=0.4285 c=0
Rk17 (\2\:n41 \4\:n41) resistor r=0.4141 c=0
Rl11 (\2\:RN \3\:RN) resistor r=33.7903 c=0
Rl10 (\1\:RN \2\:RN) resistor r=54.9442 c=0
Rl43 (\2\:CK \4\:CK) resistor r=158.495 c=0
Rl42 (\2\:CK \3\:CK) resistor r=37.3411 c=0
Rl41 (\1\:CK \2\:CK) resistor r=1.2334 c=0
Rl37 (\1\:D \2\:D) resistor r=70.9489 c=0
Rl38 (\2\:D \3\:D) resistor r=57.6695 c=0
Rl29 (\4\:SN \5\:SN) resistor r=24.2328 c=0
Rl30 (\5\:SN \6\:SN) resistor r=76.1559 c=0
Rl14 (\1\:SN \2\:SN) resistor r=50.6918 c=0
Rl15 (\2\:SN \3\:SN) resistor r=96.8456 c=0
Rl3 (\2\:qint \4\:qint) resistor r=49.7141 c=0
Rl2 (\2\:qint \3\:qint) resistor r=34.3295 c=0
Rl1 (qint \2\:qint) resistor r=5.915 c=0
Rl8 (\5\:qbint \6\:qbint) resistor r=24.848 c=0
Rl4 (qbint \2\:qbint) resistor r=64.1498 c=0
Rl7 (\2\:qbint \5\:qbint) resistor r=3.9152 c=0
Rl9 (\3\:qbint \7\:qbint) resistor r=60.772 c=0
Rl6 (\3\:qbint \4\:qbint) resistor r=28.0797 c=0
Rl5 (\2\:qbint \3\:qbint) resistor r=166.451 c=0
Rl16 (\8\:qbint \9\:qbint) resistor r=125.803 c=0
Rl18 (\9\:qbint \11\:qbint) resistor r=37.3411 c=0
Rl17 (\9\:qbint \10\:qbint) resistor r=1.8551 c=0
Rl23 (RNb \2\:RNb) resistor r=143.796 c=0
Rl25 (\3\:RNb \4\:RNb) resistor r=193.796 c=0
Rl24 (\2\:RNb \3\:RNb) resistor r=699.566 c=0
Rl26 (\4\:RNb \5\:RNb) resistor r=31.9251 c=0
Rl13 (\2\:n35 \3\:n35) resistor r=49.5541 c=0
Rl12 (n35 \2\:n35) resistor r=110.771 c=0
Rl39 (\7\:CKb \8\:CKb) resistor r=94.2308 c=0
Rl34 (\4\:CKb \5\:CKb) resistor r=153.412 c=0
Rl21 (CKb \2\:CKb) resistor r=186.104 c=0
Rl40 (\7\:CKb \9\:CKb) resistor r=24.2328 c=0
Rl35 (\5\:CKb \6\:CKb) resistor r=50.6918 c=0
Rl22 (\2\:CKb \3\:CKb) resistor r=126.436 c=0
Rl31 (mout \2\:mout) resistor r=94.4882 c=0
Rl32 (\2\:mout \3\:mout) resistor r=29.5379 c=0
Rl36 (\7\:CKbb \8\:CKbb) resistor r=35.7713 c=0
Rl33 (\5\:CKbb \6\:CKbb) resistor r=37.6944 c=0
Rl20 (\3\:CKbb \4\:CKbb) resistor r=93.4636 c=0
Rl19 (CKbb \2\:CKbb) resistor r=31.9251 c=0
Rl27 (n20 \2\:n20) resistor r=128.846 c=0
Rl28 (\2\:n20 \3\:n20) resistor r=38.5707 c=0
Rz21 (\1\:VSS \2\:VSS) resistor r=75 c=0
Rz22 (\10\:VSS \11\:VSS) resistor r=75 c=0
Rz23 (\12\:VSS \13\:VSS) resistor r=75 c=0
Rz24 (\14\:VSS \15\:VSS) resistor r=75 c=0
Rz25 (\16\:VSS \17\:VSS) resistor r=75 c=0
Rz26 (\18\:VSS \19\:VSS) resistor r=75 c=0
Rz1 (\3\:QN \4\:QN) resistor r=75 c=0
Rz18 (\4\:VDD \5\:VDD) resistor r=8.3333 c=0
Rz19 (\4\:VDD \8\:VDD) resistor r=6.25 c=0
Rz20 (\4\:VDD \12\:VDD) resistor r=6.25 c=0
Rz3 (\1\:Q \2\:Q) resistor r=75 c=0
Rz2 (\9\:qint \10\:qint) resistor r=75 c=0
Rz4 (\14\:qbint \15\:qbint) resistor r=75 c=0
Rz5 (\9\:RNb \10\:RNb) resistor r=75 c=0
Rz10 (\4\:n35 \5\:n35) resistor r=75 c=0
Rz6 (n42 \2\:n42) resistor r=75 c=0
Rz7 (\3\:n42 \4\:n42) resistor r=75 c=0
Rz8 (n40 \2\:n40) resistor r=75 c=0
Rz9 (\3\:n40 \4\:n40) resistor r=75 c=0
Rz17 (\10\:CKb \11\:CKb) resistor r=75 c=0
Rz13 (\4\:mout \5\:mout) resistor r=75 c=0
Rz14 (\11\:mout \12\:mout) resistor r=75 c=0
Rz16 (\11\:CKbb \12\:CKbb) resistor r=75 c=0
Rz11 (net426 \2\:net426) resistor r=75 c=0
Rz12 (\3\:net426 \4\:net426) resistor r=75 c=0
Rz15 (\5\:n20 \6\:n20) resistor r=75 c=0
Ry22 (\3\:VSS \4\:VSS) resistor r=6.8889 c=0
Ry23 (\3\:VSS \6\:VSS) resistor r=5.1667 c=0
Ry24 (\3\:VSS \8\:VSS) resistor r=5.1667 c=0
Ry1 (\1\:QN \2\:QN) resistor r=20.6667 c=0
Ry14 (\1\:VDD \2\:VDD) resistor r=62 c=0
Ry15 (\14\:VDD \15\:VDD) resistor r=62 c=0
Ry16 (\16\:VDD \17\:VDD) resistor r=62 c=0
Ry17 (\18\:VDD \19\:VDD) resistor r=62 c=0
Ry18 (\20\:VDD \21\:VDD) resistor r=62 c=0
Ry19 (\22\:VDD \23\:VDD) resistor r=62 c=0
Ry20 (\24\:VDD \25\:VDD) resistor r=62 c=0
Ry21 (\26\:VDD \27\:VDD) resistor r=62 c=0
Ry3 (\3\:Q \4\:Q) resistor r=62 c=0
Ry2 (\5\:qint \6\:qint) resistor r=62 c=0
Ry4 (\17\:qbint \18\:qbint) resistor r=62 c=0
Ry5 (\7\:RNb \8\:RNb) resistor r=62 c=0
Ry8 (\8\:n35 \9\:n35) resistor r=62 c=0
Ry13 (\12\:CKb \13\:CKb) resistor r=62 c=0
Ry9 (\7\:mout \8\:mout) resistor r=62 c=0
Ry10 (\9\:mout \10\:mout) resistor r=62 c=0
Ry12 (\9\:CKbb \10\:CKbb) resistor r=62 c=0
Ry11 (\7\:n20 \8\:n20) resistor r=62 c=0
Ry6 (n41 \2\:n41) resistor r=62 c=0
Ry7 (\3\:n41 \4\:n41) resistor r=62 c=0
Rx2 (\2\:RN \4\:RN) resistor r=45 c=0
Rx19 (\1\:CK \5\:CK) resistor r=45 c=0
Rx11 (\2\:D \4\:D) resistor r=45 c=0
Rx7 (\5\:SN \7\:SN) resistor r=45 c=0
Rx8 (\2\:SN \9\:SN) resistor r=45 c=0
Rx1 (qint \8\:qint) resistor r=45 c=0
Rx3 (\10\:qbint \12\:qbint) resistor r=45 c=0
Rx4 (\5\:qbint \16\:qbint) resistor r=45 c=0
Rx5 (\5\:RNb \6\:RNb) resistor r=45 c=0
Rx6 (\2\:n35 \7\:n35) resistor r=45 c=0
Rx16 (\9\:CKb \14\:CKb) resistor r=45 c=0
Rx17 (\6\:CKb \15\:CKb) resistor r=45 c=0
Rx18 (\3\:CKb \16\:CKb) resistor r=45 c=0
Rx9 (\2\:mout \6\:mout) resistor r=45 c=0
Rx12 (\8\:CKbb \14\:CKbb) resistor r=45 c=0
Rx13 (\6\:CKbb \16\:CKbb) resistor r=45 c=0
Rx14 (\4\:CKbb \18\:CKbb) resistor r=45 c=0
Rx15 (\2\:CKbb \19\:CKbb) resistor r=45 c=0
Rx10 (\3\:n20 \4\:n20) resistor r=45 c=0
mn57 (\3\:QN \3\:qint \18\:VSS VSS) g45n1lvt w=(2.6e-07) l=4.5e-08 nf=1 \
        as=6.273e-14 ad=3.64e-14 ps=1.67e-06 pd=8e-07 nrd=1.16667 \
        nrs=1.16667 sa=1.4e-07 sb=2.50577e-07 sd=160n sca=17.5885 \
        scb=0.0172826 scc=0.00162584 m=(1)
mn55 (\1\:Q \6\:qbint \16\:VSS VSS) g45n1lvt w=(2.6e-07) l=4.5e-08 nf=1 \
        as=4.365e-14 ad=3.64e-14 ps=9e-07 pd=8e-07 nrd=1.16667 nrs=1.16667 \
        sa=1.4e-07 sb=3.18462e-07 sd=160n sca=11.3041 scb=0.010759 \
        scc=0.000493236 m=(1)
mn56 (\9\:qint \4\:qbint \18\:VSS VSS) g45n1lvt w=(1.45e-07) l=4.5e-08 \
        nf=1 as=6.273e-14 ad=2.03e-14 ps=1.67e-06 pd=5.7e-07 nrd=1.16667 \
        nrs=1.16667 sa=3.7e-07 sb=1.4e-07 sd=160n sca=23.279 scb=0.0230742 \
        scc=0.00267719 m=(1)
mn22 (\9\:RNb \1\:RN \16\:VSS VSS) g45n1lvt w=(1.45e-07) l=4.5e-08 nf=1 \
        as=4.365e-14 ad=3.263e-14 ps=9e-07 pd=7.4e-07 nrd=1.16667 \
        nrs=1.16667 sa=3.75e-07 sb=2.25e-07 sd=160n sca=13.9854 \
        scb=0.014728 scc=0.000819645 m=(1)
mn45 (\14\:qbint n35 \14\:VSS VSS) g45n1lvt w=(1.45e-07) l=4.5e-08 nf=1 \
        as=2.32e-14 ad=2.32e-14 ps=6.1e-07 pd=6.1e-07 nrd=1.16667 \
        nrs=1.16667 sa=1.6e-07 sb=8.7e-07 sd=160n sca=11.7118 \
        scb=0.0116498 scc=0.000458536 m=(1)
mn50 (\3\:n42 \3\:SN \14\:VSS VSS) g45n1lvt w=(1.45e-07) l=4.5e-08 nf=1 \
        as=2.32e-14 ad=3.988e-14 ps=6.1e-07 pd=8.4e-07 nrd=1.16667 \
        nrs=1.16667 sa=3.65e-07 sb=6.65e-07 sd=160n sca=11.7118 \
        scb=0.0116498 scc=0.000458536 m=(1)
mn52 (\3\:n40 \11\:qbint \3\:n42 VSS) g45n1lvt w=(1.45e-07) l=4.5e-08 \
        nf=1 as=3.988e-14 ad=2.32e-14 ps=8.4e-07 pd=6.1e-07 nrd=1.16667 \
        nrs=1.16667 sa=6.85e-07 sb=3.45e-07 sd=160n sca=11.7118 \
        scb=0.0116498 scc=0.000458536 m=(1)
mn51 (\3\:n40 \3\:RNb n42 VSS) g45n1lvt w=(1.45e-07) l=4.5e-08 nf=1 \
        as=2.03e-14 ad=2.32e-14 ps=5.7e-07 pd=6.1e-07 nrd=1.16667 \
        nrs=1.16667 sa=8.9e-07 sb=1.4e-07 sd=160n sca=11.7118 \
        scb=0.0116498 scc=0.000458536 m=(1)
mn53 (\4\:n35 CKb n40 VSS) g45n1lvt w=(1.45e-07) l=4.5e-08 nf=1 \
        as=4.133e-14 ad=2.61e-14 ps=8.6e-07 pd=6.5e-07 nrd=1.16667 \
        nrs=1.16667 sa=2.85e-07 sb=4.6e-07 sd=160n sca=13.6097 \
        scb=0.014254 scc=0.000755054 m=(1)
mn40 (\4\:n35 \3\:CKbb \11\:mout VSS) g45n1lvt w=(1.45e-07) l=4.5e-08 \
        nf=1 as=3.408e-14 ad=2.61e-14 ps=7.6e-07 pd=6.5e-07 nrd=1.16667 \
        nrs=1.16667 sa=5.1e-07 sb=2.35e-07 sd=160n sca=13.6097 \
        scb=0.014254 scc=0.000755054 m=(1)
mn31 (\4\:mout \2\:RNb \3\:net426 VSS) g45n1lvt w=(1.45e-07) l=4.5e-08 \
        nf=1 as=2.03e-14 ad=5.003e-14 ps=5.7e-07 pd=9.8e-07 nrd=1.16667 \
        nrs=1.16667 sa=1.4e-07 sb=1.87e-06 sd=160n sca=22.3376 \
        scb=0.0224607 scc=0.00248252 m=(1)
mn32 (\4\:mout \2\:n20 net426 VSS) g45n1lvt w=(1.45e-07) l=4.5e-08 nf=1 \
        as=2.32e-14 ad=5.003e-14 ps=6.1e-07 pd=9.8e-07 nrd=1.16667 \
        nrs=1.16667 sa=5.3e-07 sb=1.48e-06 sd=160n sca=22.3376 \
        scb=0.0224607 scc=0.00248252 m=(1)
mn30 (net426 \6\:SN \12\:VSS VSS) g45n1lvt w=(1.45e-07) l=4.5e-08 nf=1 \
        as=5.165e-14 ad=2.32e-14 ps=1.59e-06 pd=6.1e-07 nrd=1.16667 \
        nrs=1.16667 sa=7.35e-07 sb=1.275e-06 sd=160n sca=22.3376 \
        scb=0.0224607 scc=0.00248252 m=(1)
mn35 (n30 \3\:mout \12\:VSS VSS) g45n1lvt w=(1.45e-07) l=4.5e-08 nf=1 \
        as=5.165e-14 ad=8.7e-15 ps=1.59e-06 pd=4.1e-07 nrd=1.16667 \
        nrs=1.16667 sa=9.3e-07 sb=1.08e-06 sd=160n sca=22.3376 \
        scb=0.0224607 scc=0.00248252 m=(1)
mn36 (\5\:n20 \5\:CKbb n30 VSS) g45n1lvt w=(1.45e-07) l=4.5e-08 nf=1 \
        as=8.7e-15 ad=2.32e-14 ps=4.1e-07 pd=6.1e-07 nrd=1.16667 \
        nrs=1.16667 sa=1.035e-06 sb=9.75e-07 sd=160n sca=22.3376 \
        scb=0.0224607 scc=0.00248252 m=(1)
mn26 (\5\:n20 \4\:CKb n21 VSS) g45n1lvt w=(1.45e-07) l=4.5e-08 nf=1 \
        as=3.263e-14 ad=2.32e-14 ps=7.4e-07 pd=6.1e-07 nrd=1.16667 \
        nrs=1.16667 sa=1.24e-06 sb=7.7e-07 sd=160n sca=22.3376 \
        scb=0.0224607 scc=0.00248252 m=(1)
mn25 (n21 \3\:D \10\:VSS VSS) g45n1lvt w=(1.45e-07) l=4.5e-08 nf=1 \
        as=6.068e-14 ad=3.263e-14 ps=1.17e-06 pd=7.4e-07 nrd=1.16667 \
        nrs=1.16667 sa=1.51e-06 sb=5e-07 sd=160n sca=22.3376 scb=0.0224607 \
        scc=0.00248252 m=(1)
mn21 (\11\:CKbb \8\:CKb \10\:VSS VSS) g45n1lvt w=(1.45e-07) l=4.5e-08 \
        nf=1 as=6.068e-14 ad=2.03e-14 ps=1.17e-06 pd=5.7e-07 nrd=1.16667 \
        nrs=1.16667 sa=1.87e-06 sb=1.4e-07 sd=160n sca=22.3376 \
        scb=0.0224607 scc=0.00248252 m=(1)
mn20 (\10\:CKb \3\:CK \1\:VSS VSS) g45n1lvt w=(1.45e-07) l=4.5e-08 nf=1 \
        as=4.465e-14 ad=2.03e-14 ps=1.5e-06 pd=5.7e-07 nrd=1.16667 \
        nrs=1.16667 sa=1.4e-07 sb=1e-07 sd=160n sca=23.279 scb=0.0230742 \
        scc=0.00267719 m=(1)
mp56 (\5\:qint \7\:qbint \26\:VDD VDD) g45p1lvt w=(2.15e-07) l=4.5e-08 \
        nf=1 as=7.142e-14 ad=2.63e-14 ps=1.52e-06 pd=7.1e-07 nrd=1.16667 \
        nrs=1.16667 sa=3.7e-07 sb=1.22326e-07 sd=160n sca=46.9517 \
        scb=0.029008 scc=0.00588492 m=(1)
mp22 (\7\:RNb \3\:RN \24\:VDD VDD) g45p1lvt w=(2.15e-07) l=4.5e-08 nf=1 \
        as=5.19e-14 ad=2.93e-14 ps=1.1e-06 pd=7.6e-07 nrd=1.16667 \
        nrs=1.16667 sa=3.17093e-07 sb=1.36279e-07 sd=160n sca=45.7906 \
        scb=0.0283307 scc=0.00588417 m=(1)
mp45 (\17\:qbint \3\:n35 \22\:VDD VDD) g45p1lvt w=(2.15e-07) l=4.5e-08 \
        nf=1 as=8.15e-14 ad=4.838e-14 ps=1.44e-06 pd=8.8e-07 nrd=1.16667 \
        nrs=1.16667 sa=2.25e-07 sb=8.65e-07 sd=160n sca=17.9376 \
        scb=0.0177709 scc=0.00142383 m=(1)
mp50 (\3\:n41 \1\:SN \22\:VDD VDD) g45p1lvt w=(2.15e-07) l=4.5e-08 nf=1 \
        as=8.15e-14 ad=5.913e-14 ps=1.44e-06 pd=9.8e-07 nrd=1.16667 \
        nrs=1.16667 sa=4.9e-07 sb=6e-07 sd=160n sca=17.9376 scb=0.0177709 \
        scc=0.00142383 m=(1)
mp52 (\3\:n41 \8\:qbint n43 VDD) g45p1lvt w=(2.15e-07) l=4.5e-08 nf=1 \
        as=1.29e-14 ad=5.913e-14 ps=5.5e-07 pd=9.8e-07 nrd=1.16667 \
        nrs=1.16667 sa=8.1e-07 sb=2.8e-07 sd=160n sca=17.9376 \
        scb=0.0177709 scc=0.00142383 m=(1)
mp51 (n43 \4\:RNb \20\:VDD VDD) g45p1lvt w=(2.15e-07) l=4.5e-08 nf=1 \
        as=5.893e-14 ad=1.29e-14 ps=1.38e-06 pd=5.5e-07 nrd=1.16667 \
        nrs=1.16667 sa=9.15e-07 sb=1.75e-07 sd=160n sca=17.9376 \
        scb=0.0177709 scc=0.00142383 m=(1)
mp53 (\8\:n35 CKbb n41 VDD) g45p1lvt w=(2.15e-07) l=4.5e-08 nf=1 \
        as=3.01e-14 ad=3.48e-14 ps=7.1e-07 pd=7.7e-07 nrd=1.16667 \
        nrs=1.16667 sa=1.4e-07 sb=5.52907e-07 sd=160n sca=17.9376 \
        scb=0.0177709 scc=0.00142383 m=(1)
mp40 (\8\:n35 \2\:CKb \9\:mout VDD) g45p1lvt w=(2.15e-07) l=4.5e-08 nf=1 \
        as=7.955e-14 ad=3.48e-14 ps=1.17e-06 pd=7.7e-07 nrd=1.16667 \
        nrs=1.16667 sa=3.33605e-07 sb=3.7e-07 sd=160n sca=19.0975 \
        scb=0.0187686 scc=0.00166224 m=(1)
mp31 (net402 RNb \18\:VDD VDD) g45p1lvt w=(2.15e-07) l=4.5e-08 nf=1 \
        as=8.755e-14 ad=5.59e-14 ps=1.62e-06 pd=9.5e-07 nrd=1.16667 \
        nrs=1.16667 sa=1.7e-07 sb=1.50802e-06 sd=160n sca=19.0975 \
        scb=0.0187686 scc=0.00166224 m=(1)
mp32 (\7\:mout n20 net402 VDD) g45p1lvt w=(2.15e-07) l=4.5e-08 nf=1 \
        as=5.59e-14 ad=3.44e-14 ps=9.5e-07 pd=7.5e-07 nrd=1.16667 \
        nrs=1.16667 sa=4.75e-07 sb=1.20302e-06 sd=160n sca=19.0975 \
        scb=0.0187686 scc=0.00166224 m=(1)
mp30 (\7\:mout \4\:SN \16\:VDD VDD) g45p1lvt w=(2.15e-07) l=4.5e-08 nf=1 \
        as=9.62e-14 ad=3.44e-14 ps=1.72e-06 pd=7.5e-07 nrd=1.16667 \
        nrs=1.16667 sa=6.8e-07 sb=9.98023e-07 sd=160n sca=19.0975 \
        scb=0.0187686 scc=0.00166224 m=(1)
mp35 (n31 mout \16\:VDD VDD) g45p1lvt w=(2.15e-07) l=4.5e-08 nf=1 \
        as=9.62e-14 ad=2.473e-14 ps=1.72e-06 pd=6.6e-07 nrd=1.16667 \
        nrs=1.16667 sa=8.3686e-07 sb=8.59302e-07 sd=160n sca=16.037 \
        scb=0.0158964 scc=0.00103899 m=(1)
mp36 (\7\:n20 \5\:CKb n31 VDD) g45p1lvt w=(2.15e-07) l=4.5e-08 nf=1 \
        as=2.473e-14 ad=6.128e-14 ps=6.6e-07 pd=1e-06 nrd=1.16667 \
        nrs=1.16667 sa=9.9686e-07 sb=6.99302e-07 sd=160n sca=16.037 \
        scb=0.0158964 scc=0.00103899 m=(1)
mp26 (\7\:n20 \7\:CKbb n22 VDD) g45p1lvt w=(2.15e-07) l=4.5e-08 nf=1 \
        as=1.29e-14 ad=6.128e-14 ps=5.5e-07 pd=1e-06 nrd=1.16667 \
        nrs=1.16667 sa=1.32686e-06 sb=3.69302e-07 sd=160n sca=16.037 \
        scb=0.0158964 scc=0.00103899 m=(1)
mp25 (n22 \1\:D \14\:VDD VDD) g45p1lvt w=(2.15e-07) l=4.5e-08 nf=1 \
        as=7.94e-14 ad=1.29e-14 ps=2.06e-06 pd=5.5e-07 nrd=1.16667 \
        nrs=1.16667 sa=1.43186e-06 sb=2.64302e-07 sd=160n sca=16.1489 \
        scb=0.0159203 scc=0.00103899 m=(1)
mp21 (\9\:CKbb \7\:CKb \14\:VDD VDD) g45p1lvt w=(2.15e-07) l=4.5e-08 \
        nf=1 as=7.94e-14 ad=3.01e-14 ps=2.06e-06 pd=7.1e-07 nrd=1.16667 \
        nrs=1.16667 sa=8.57791e-07 sb=1.4e-07 sd=160n sca=46.9212 \
        scb=0.0289781 scc=0.00588485 m=(1)
mp20 (\12\:CKb \4\:CK \1\:VDD VDD) g45p1lvt w=(2.15e-07) l=4.5e-08 nf=1 \
        as=3.01e-14 ad=3.01e-14 ps=7.1e-07 pd=7.1e-07 nrd=1.16667 \
        nrs=1.16667 sa=1.4e-07 sb=1.4e-07 sd=160n sca=21.3991 \
        scb=0.0236448 scc=0.00101293 m=(1)
ends DFFSRX1
// End of subcircuit definition.
