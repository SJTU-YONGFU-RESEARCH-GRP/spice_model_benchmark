// Generated for: spectre (May  1 09:19:14 2013 )
// Library name: gsclib045_lvt
// Cell name: TLATNSRX4
// View name: extracted

simulator lang=spectre

subckt TLATNSRX4 D GN Q QN RN SN VDD VSS
mp0 (\7\:GNbp \3\:GN \41\:VDD VDD) g45p1lvt w=(2.15e-07) l=4.5e-08 nf=1 \
        as=6.912e-14 ad=4.408e-14 ps=1.58e-06 pd=8.4e-07 nrd=1.16667 \
        nrs=1.16667 sa=2.05e-07 sb=6.35e-07 sd=160n sca=19.5246 \
        scb=0.021512 scc=0.000667372 m=(1)
mp1 (\15\:GNbb \1\:RN \41\:VDD VDD) g45p1lvt w=(2.15e-07) l=4.5e-08 nf=1 \
        as=6.912e-14 ad=3.44e-14 ps=1.58e-06 pd=7.5e-07 nrd=1.16667 \
        nrs=1.16667 sa=4.65e-07 sb=3.75e-07 sd=160n sca=13.0584 \
        scb=0.0107457 scc=0.000192732 m=(1)
mp2 (\15\:GNbb GNbp \39\:VDD VDD) g45p1lvt w=(2.15e-07) l=4.5e-08 nf=1 \
        as=7.135e-14 ad=3.44e-14 ps=1.35e-06 pd=7.5e-07 nrd=1.16667 \
        nrs=1.16667 sa=6.7e-07 sb=1.7e-07 sd=160n sca=11.7504 \
        scb=0.00937467 scc=0.000188073 m=(1)
mp3 (\4\:GNb GNbb \37\:VDD VDD) g45p1lvt w=(2.15e-07) l=4.5e-08 nf=1 \
        as=9.505e-14 ad=4.73e-14 ps=1.65e-06 pd=8.7e-07 nrd=1.16667 \
        nrs=1.16667 sa=2.2e-07 sb=8.1e-07 sd=160n sca=14.8993 \
        scb=0.0146069 scc=0.000816972 m=(1)
mp5 (net313 \3\:D \37\:VDD VDD) g45p1lvt w=(2.15e-07) l=4.5e-08 nf=1 \
        as=9.505e-14 ad=1.29e-14 ps=1.65e-06 pd=5.5e-07 nrd=1.16667 \
        nrs=1.16667 sa=4.95e-07 sb=5.35e-07 sd=160n sca=14.8993 \
        scb=0.0146069 scc=0.000816972 m=(1)
mp6 (\11\:n5 \4\:GNbb net313 VDD) g45p1lvt w=(2.15e-07) l=4.5e-08 nf=1 \
        as=1.29e-14 ad=5.268e-14 ps=5.5e-07 pd=9.2e-07 nrd=1.16667 \
        nrs=1.16667 sa=6e-07 sb=4.3e-07 sd=160n sca=14.8993 scb=0.0146069 \
        scc=0.000816972 m=(1)
mp17 (\11\:n5 GNb \3\:net270 VDD) g45p1lvt w=(2.15e-07) l=4.5e-08 nf=1 \
        as=3.01e-14 ad=5.268e-14 ps=7.1e-07 pd=9.2e-07 nrd=1.16667 \
        nrs=1.16667 sa=8.9e-07 sb=1.4e-07 sd=160n sca=14.8993 \
        scb=0.0146069 scc=0.000816972 m=(1)
mp16 (net270 \4\:qint \35\:VDD VDD) g45p1lvt w=(2.15e-07) l=4.5e-08 nf=1 \
        as=6.175e-14 ad=4.408e-14 ps=1.19e-06 pd=8.4e-07 nrd=1.16667 \
        nrs=1.16667 sa=1.7e-07 sb=1.88488e-06 sd=160n sca=14.8993 \
        scb=0.0146069 scc=0.000816972 m=(1)
mp15 (net270 \4\:RN \1\:VDD VDD) g45p1lvt w=(2.15e-07) l=4.5e-08 nf=1 \
        as=6.99e-14 ad=4.407e-14 ps=1.85e-06 pd=8.4e-07 nrd=1.16667 \
        nrs=1.16667 sa=4.2e-07 sb=1.86744e-06 sd=160n sca=14.8993 \
        scb=0.0146069 scc=0.000816972 m=(1)
C1 (D VSS) capacitor c=6.70351e-17
C2 (Q VSS) capacitor c=1.49806e-17
C3 (SN VSS) capacitor c=3.59447e-16
C4 (GN VSS) capacitor c=6.72736e-17
C5 (QN VSS) capacitor c=1.74659e-16
C6 (VDD VSS) capacitor c=3.32859e-16
C7 (RN VSS) capacitor c=2.75964e-16
C8 (GNbp VSS) capacitor c=5.50316e-17
C9 (GNbb VSS) capacitor c=3.52285e-17
C10 (GNb VSS) capacitor c=4.23539e-17
C11 (net366 VSS) capacitor c=7.16689e-18
C12 (n5 VSS) capacitor c=4.86835e-17
C13 (net354 VSS) capacitor c=2.44456e-19
C14 (qint VSS) capacitor c=2.90025e-17
C15 (qbint VSS) capacitor c=2.2277e-16
C16 (net270 VSS) capacitor c=6.16321e-17
C17 (\5\:qint VSS) capacitor c=2.00144e-16
C18 (\4\:RN VSS) capacitor c=7.88439e-17
C19 (\4\:qint VSS) capacitor c=3.23777e-17
C20 (\4\:GNbb VSS) capacitor c=5.85618e-17
C21 (\3\:D VSS) capacitor c=7.05194e-17
C22 (\1\:RN VSS) capacitor c=4.75171e-17
C23 (\3\:GN VSS) capacitor c=4.21697e-17
C24 (\6\:SN VSS) capacitor c=6.30922e-17
C25 (\4\:n5 VSS) capacitor c=3.34701e-17
C26 (\1\:SN VSS) capacitor c=5.723e-17
C27 (\5\:RN VSS) capacitor c=4.10744e-17
C28 (\3\:qint VSS) capacitor c=4.95694e-17
C29 (\6\:GNbb VSS) capacitor c=4.44676e-17
C30 (\3\:GNb VSS) capacitor c=2.5384e-17
C31 (\1\:D VSS) capacitor c=3.19838e-17
C32 (\3\:GNbb VSS) capacitor c=2.95116e-17
C33 (\4\:GNbp VSS) capacitor c=2.68304e-17
C34 (\3\:RN VSS) capacitor c=6.29865e-17
C35 (\1\:GN VSS) capacitor c=3.79347e-17
C36 (\6\:RN VSS) capacitor c=2.30554e-17
C37 (\7\:GNbb VSS) capacitor c=4.12858e-17
C38 (\2\:GNb VSS) capacitor c=3.89686e-17
C39 (\5\:GNbb VSS) capacitor c=3.44774e-17
C40 (\2\:D VSS) capacitor c=5.09032e-17
C41 (\2\:GNbb VSS) capacitor c=2.64405e-17
C42 (\3\:GNbp VSS) capacitor c=2.39945e-17
C43 (\2\:RN VSS) capacitor c=5.1797e-17
C44 (\2\:GN VSS) capacitor c=4.60349e-17
C45 (\1\:VDD VSS) capacitor c=5.66454e-16
C46 (\1\:Q VSS) capacitor c=1.66082e-16
C47 (\33\:qint VSS) capacitor c=1.30138e-16
C48 (\31\:VDD VSS) capacitor c=8.89926e-18
C49 (\35\:VDD VSS) capacitor c=2.17628e-17
C50 (\3\:net270 VSS) capacitor c=6.89121e-17
C51 (\11\:n5 VSS) capacitor c=1.35885e-16
C52 (\37\:VDD VSS) capacitor c=2.03045e-17
C53 (\4\:GNb VSS) capacitor c=8.02207e-17
C54 (\39\:VDD VSS) capacitor c=5.55896e-18
C55 (\15\:GNbb VSS) capacitor c=5.65156e-17
C56 (\41\:VDD VSS) capacitor c=7.32727e-18
C57 (\7\:GNbp VSS) capacitor c=5.23403e-17
C58 (\4\:VDD VSS) capacitor c=3.56793e-17
C59 (\6\:QN VSS) capacitor c=8.20067e-17
C60 (\30\:qint VSS) capacitor c=6.25618e-17
C61 (\9\:n5 VSS) capacitor c=6.31183e-17
C62 (\6\:GNb VSS) capacitor c=1.16227e-16
C63 (\13\:GNbb VSS) capacitor c=7.88463e-17
C64 (\9\:GNbp VSS) capacitor c=2.03274e-17
C65 (\2\:GNbp VSS) capacitor c=3.26796e-17
C66 (\2\:qint VSS) capacitor c=2.30969e-17
C67 (\2\:n5 VSS) capacitor c=1.29895e-16
C68 (\4\:GN VSS) capacitor c=2.77732e-17
C69 (\10\:qint VSS) capacitor c=2.19506e-16
C70 (\5\:GNbp VSS) capacitor c=4.50317e-17
C71 (\6\:GNbp VSS) capacitor c=7.84317e-17
C72 (\4\:D VSS) capacitor c=5.31569e-17
C73 (\8\:GNb VSS) capacitor c=9.46955e-17
C74 (\8\:GNbb VSS) capacitor c=7.85822e-17
C75 (\9\:GNbb VSS) capacitor c=1.1143e-16
C76 (\10\:GNbb VSS) capacitor c=1.1922e-16
C77 (\11\:GNbb VSS) capacitor c=6.53855e-17
C78 (\12\:GNbb VSS) capacitor c=1.04352e-16
C79 (\7\:RN VSS) capacitor c=2.21192e-16
C80 (\8\:RN VSS) capacitor c=2.71333e-17
C81 (\7\:n5 VSS) capacitor c=8.49125e-17
C82 (\8\:n5 VSS) capacitor c=1.17929e-16
C83 (\32\:qint VSS) capacitor c=1.16493e-16
C84 (\37\:qint VSS) capacitor c=6.16392e-17
C85 (\15\:qbint VSS) capacitor c=4.25512e-17
C86 (\16\:qbint VSS) capacitor c=2.42977e-16
C87 (\4\:Q VSS) capacitor c=6.68835e-17
C88 (\14\:VDD VSS) capacitor c=2.359e-17
C89 (\15\:VDD VSS) capacitor c=2.82236e-17
C90 (\17\:VDD VSS) capacitor c=1.35636e-17
C91 (\18\:VDD VSS) capacitor c=8.33573e-18
Rk5 (D \4\:D) resistor r=0.1737 c=0
Rk38 (\1\:Q Q) resistor r=0.01968 c=0
Rk39 (Q \4\:Q) resistor r=0.08608 c=0
Rk1 (GN \4\:GN) resistor r=0.0569 c=0
Rk29 (QN \6\:QN) resistor r=0.2591 c=0
Rk53 (\1\:VDD \14\:VDD) resistor r=0.2577 c=0
Rk54 (\14\:VDD \15\:VDD) resistor r=0.4673 c=0
Rk55 (\15\:VDD \16\:VDD) resistor r=0.1968 c=0
Rk56 (\16\:VDD \17\:VDD) resistor r=0.1668 c=0
Rk58 (\18\:VDD VDD) resistor r=0.1148 c=0
Rk57 (\17\:VDD \18\:VDD) resistor r=0.2668 c=0
Rk65 (\1\:VDD \32\:VDD) resistor r=0.07346 c=0
Rk67 (\14\:VDD \36\:VDD) resistor r=0.1864 c=0
Rk68 (\15\:VDD \38\:VDD) resistor r=0.04327 c=0
Rk69 (\17\:VDD \40\:VDD) resistor r=0.04327 c=0
Rk70 (\18\:VDD \42\:VDD) resistor r=0.07346 c=0
Rk15 (\7\:RN RN) resistor r=2.01 c=0
Rk16 (RN \8\:RN) resistor r=0.1354 c=0
Rk78 (\1\:VSS \11\:VSS) resistor r=0.1276 c=0
Rk79 (\11\:VSS \12\:VSS) resistor r=0.2604 c=0
Rk80 (\12\:VSS \13\:VSS) resistor r=0.6337 c=0
Rk81 (\13\:VSS \14\:VSS) resistor r=0.07981 c=0
Rk82 (\14\:VSS \15\:VSS) resistor r=0.2279 c=0
Rk84 (\16\:VSS VSS) resistor r=0.1625 c=0
Rk83 (\15\:VSS \16\:VSS) resistor r=0.3883 c=0
Rk91 (\12\:VSS \30\:VSS) resistor r=0.2905 c=0
Rk92 (\13\:VSS \32\:VSS) resistor r=0.07937 c=0
Rk93 (\14\:VSS \33\:VSS) resistor r=0.07937 c=0
Rk94 (\16\:VSS \35\:VSS) resistor r=0.2355 c=0
Rk2 (\5\:GNbp \6\:GNbp) resistor r=0.3201 c=0
Rk3 (\6\:GNbp \8\:GNbp) resistor r=0.5995 c=0
Rk4 (\6\:GNbp \10\:GNbp) resistor r=0.09668 c=0
Rk8 (\8\:GNbb \9\:GNbb) resistor r=0.3959 c=0
Rk9 (\9\:GNbb \10\:GNbb) resistor r=0.6083 c=0
Rk10 (\10\:GNbb \11\:GNbb) resistor r=0.3361 c=0
Rk11 (\10\:GNbb \12\:GNbb) resistor r=0.5411 c=0
Rk12 (\12\:GNbb \14\:GNbb) resistor r=0.4521 c=0
Rk13 (\12\:GNbb \16\:GNbb) resistor r=0.3661 c=0
Rk6 (\5\:GNb \7\:GNb) resistor r=0.4341 c=0
Rk7 (\7\:GNb \8\:GNb) resistor r=0.6402 c=0
Rk17 (\7\:n5 \8\:n5) resistor r=0.5218 c=0
Rk18 (\8\:n5 \10\:n5) resistor r=0.2596 c=0
Rk19 (\8\:n5 \12\:n5) resistor r=0.7179 c=0
Rk23 (\32\:qint \33\:qint) resistor r=0.4442 c=0
Rk22 (\31\:qint \32\:qint) resistor r=0.4463 c=0
Rk25 (\33\:qint \37\:qint) resistor r=0.3766 c=0
Rk31 (\15\:qbint \16\:qbint) resistor r=0.2653 c=0
Rk14 (\2\:net270 \4\:net270) resistor r=0.3174 c=0
Rl11 (\2\:D \3\:D) resistor r=94.3956 c=0
Rl10 (\1\:D \2\:D) resistor r=49.46 c=0
Rl29 (SN \6\:SN) resistor r=68.4066 c=0
Rl21 (SN \1\:SN) resistor r=73.0769 c=0
Rl2 (\2\:GN \3\:GN) resistor r=128.022 c=0
Rl1 (\1\:GN \2\:GN) resistor r=101.923 c=0
Rl19 (\4\:RN \5\:RN) resistor r=165.385 c=0
Rl20 (\5\:RN \6\:RN) resistor r=35.7713 c=0
Rl3 (\1\:RN \2\:RN) resistor r=94.9225 c=0
Rl4 (\2\:RN \3\:RN) resistor r=133.384 c=0
Rl5 (GNbp \2\:GNbp) resistor r=209.329 c=0
Rl7 (\2\:GNbp \4\:GNbp) resistor r=36.2526 c=0
Rl6 (\2\:GNbp \3\:GNbp) resistor r=2.0166 c=0
Rl15 (\6\:GNbb \7\:GNbb) resistor r=87.6944 c=0
Rl12 (\4\:GNbb \5\:GNbb) resistor r=39.1533 c=0
Rl8 (GNbb \2\:GNbb) resistor r=56.9251 c=0
Rl9 (\2\:GNbb \3\:GNbb) resistor r=80.0021 c=0
Rl13 (GNb \2\:GNb) resistor r=110.771 c=0
Rl14 (\2\:GNb \3\:GNb) resistor r=26.1559 c=0
Rl23 (\2\:n5 n5) resistor r=80.7471 c=0
Rl25 (\2\:n5 \4\:n5) resistor r=24.7951 c=0
Rl18 (\2\:qint \4\:qint) resistor r=34.3295 c=0
Rl17 (\2\:qint \3\:qint) resistor r=122.791 c=0
Rl16 (\2\:qint qint) resistor r=9.1065 c=0
Rl34 (\10\:qint \5\:qint) resistor r=76.1151 c=0
Rz13 (\1\:VDD \4\:VDD) resistor r=3.5714 c=0
Rz14 (\16\:VDD \4\:VDD) resistor r=6.25 c=0
Rz22 (\30\:VSS \29\:VSS) resistor r=75 c=0
Rz23 (\32\:VSS \31\:VSS) resistor r=75 c=0
Rz24 (\33\:VSS \31\:VSS) resistor r=75 c=0
Rz25 (\35\:VSS \34\:VSS) resistor r=75 c=0
Rz1 (\9\:GNbp \10\:GNbp) resistor r=75 c=0
Rz3 (\13\:GNbb \14\:GNbb) resistor r=75 c=0
Rz2 (\6\:GNb \7\:GNb) resistor r=75 c=0
Rz4 (\10\:n5 \9\:n5) resistor r=75 c=0
Rz5 (\31\:qint \30\:qint) resistor r=75 c=0
Ry22 (\32\:VDD \31\:VDD) resistor r=62 c=0
Ry24 (\36\:VDD \35\:VDD) resistor r=62 c=0
Ry25 (\38\:VDD \37\:VDD) resistor r=62 c=0
Ry26 (\40\:VDD \39\:VDD) resistor r=62 c=0
Ry27 (\42\:VDD \41\:VDD) resistor r=62 c=0
Ry28 (\1\:VSS \4\:VSS) resistor r=6.8889 c=0
Ry29 (\11\:VSS \4\:VSS) resistor r=5.1667 c=0
Ry30 (\15\:VSS \4\:VSS) resistor r=5.1667 c=0
Ry1 (\7\:GNbp \8\:GNbp) resistor r=62 c=0
Ry3 (\15\:GNbb \16\:GNbb) resistor r=62 c=0
Ry2 (\4\:GNb \5\:GNb) resistor r=62 c=0
Ry6 (\12\:n5 \11\:n5) resistor r=62 c=0
Ry4 (net270 \2\:net270) resistor r=62 c=0
Ry5 (\3\:net270 \4\:net270) resistor r=62 c=0
Rx3 (\2\:D \4\:D) resistor r=45 c=0
Rx1 (\2\:GN \4\:GN) resistor r=45 c=0
Rx8 (\6\:RN \7\:RN) resistor r=45 c=0
Rx9 (\2\:RN \8\:RN) resistor r=45 c=0
Rx2 (\3\:GNbp \5\:GNbp) resistor r=45 c=0
Rx5 (\7\:GNbb \8\:GNbb) resistor r=45 c=0
Rx6 (\5\:GNbb \9\:GNbb) resistor r=45 c=0
Rx7 (\2\:GNbb \11\:GNbb) resistor r=45 c=0
Rx4 (\2\:GNb \8\:GNb) resistor r=45 c=0
Rx10 (\7\:n5 \2\:n5) resistor r=45 c=0
Rx13 (\32\:qint \10\:qint) resistor r=45 c=0
Rx14 (\37\:qint qint) resistor r=45 c=0
Rx15 (\15\:qbint qbint) resistor r=45 c=0
mn0 (\9\:GNbp \1\:GN \34\:VSS VSS) g45n1lvt w=(1.45e-07) l=4.5e-08 nf=1 \
        as=2.32e-14 ad=2.03e-14 ps=6.1e-07 pd=5.7e-07 nrd=1.16667 \
        nrs=1.16667 sa=1.4e-07 sb=7.65e-07 sd=160n sca=8.42104 \
        scb=0.00632542 scc=0.000106623 m=(1)
mn1 (net326 \3\:RN \34\:VSS VSS) g45n1lvt w=(1.45e-07) l=4.5e-08 nf=1 \
        as=2.32e-14 ad=2.32e-14 ps=6.1e-07 pd=6.1e-07 nrd=1.16667 \
        nrs=1.16667 sa=3.45e-07 sb=5.6e-07 sd=160n sca=8.42104 \
        scb=0.00632542 scc=0.000106623 m=(1)
mn2 (\13\:GNbb \4\:GNbp net326 VSS) g45n1lvt w=(1.45e-07) l=4.5e-08 nf=1 \
        as=2.32e-14 ad=5.147e-14 ps=6.1e-07 pd=1e-06 nrd=1.16667 \
        nrs=1.16667 sa=5.5e-07 sb=3.55e-07 sd=160n sca=8.42104 \
        scb=0.00632542 scc=0.000106623 m=(1)
mn3 (\6\:GNb \3\:GNbb \31\:VSS VSS) g45n1lvt w=(1.45e-07) l=4.5e-08 nf=1 \
        as=9.78e-14 ad=2.03e-14 ps=2.12e-06 pd=5.7e-07 nrd=1.16667 \
        nrs=1.16667 sa=1.4e-07 sb=7.55172e-07 sd=160n sca=15.7071 \
        scb=0.0167369 scc=0.00113434 m=(1)
mn5 (net366 \1\:D \31\:VSS VSS) g45n1lvt w=(1.45e-07) l=4.5e-08 nf=1 \
        as=9.78e-14 ad=4.35e-14 ps=2.12e-06 pd=8.9e-07 nrd=1.16667 \
        nrs=1.16667 sa=2.25862e-07 sb=2e-06 sd=160n sca=15.7071 \
        scb=0.0167369 scc=0.00113434 m=(1)
mn6 (\9\:n5 \3\:GNb net366 VSS) g45n1lvt w=(1.45e-07) l=4.5e-08 nf=1 \
        as=4.35e-14 ad=3.625e-14 ps=8.9e-07 pd=7.9e-07 nrd=1.16667 \
        nrs=1.16667 sa=5.70862e-07 sb=2e-06 sd=160n sca=15.7071 \
        scb=0.0167369 scc=0.00113434 m=(1)
mn17 (\9\:n5 \6\:GNbb net354 VSS) g45n1lvt w=(1.45e-07) l=4.5e-08 nf=1 \
        as=2.755e-14 ad=3.625e-14 ps=6.7e-07 pd=7.9e-07 nrd=1.16667 \
        nrs=1.16667 sa=8.65862e-07 sb=2e-06 sd=160n sca=15.7071 \
        scb=0.0167369 scc=0.00113434 m=(1)
mn16 (net354 \3\:qint net350 VSS) g45n1lvt w=(1.45e-07) l=4.5e-08 nf=1 \
        as=2.973e-14 ad=2.755e-14 ps=7e-07 pd=6.7e-07 nrd=1.16667 \
        nrs=1.16667 sa=1.10086e-06 sb=2e-06 sd=160n sca=15.7071 \
        scb=0.0167369 scc=0.00113434 m=(1)
mn15 (net350 \5\:RN \29\:VSS VSS) g45n1lvt w=(1.45e-07) l=4.5e-08 nf=1 \
        as=4.103e-14 ad=2.973e-14 ps=8.6e-07 pd=7e-07 nrd=1.16667 \
        nrs=1.16667 sa=1.35086e-06 sb=2e-06 sd=160n sca=15.7071 \
        scb=0.0167369 scc=0.00113434 m=(1)
mn10_1__rcx (21 \1\:SN \29\:VSS VSS) g45n1lvt w=(2.05e-07) l=4.5e-08 \
        nf=1 as=4.103e-14 ad=1.64e-14 ps=8.6e-07 pd=5.7e-07 nrd=1.16667 \
        nrs=1.16667 sa=1.18744e-06 sb=2e-06 sd=160n sca=13.8179 \
        scb=0.0141903 scc=0.000851218 m=(1)
mn11_1__rcx (\30\:qint \4\:n5 21 VSS) g45n1lvt w=(2.05e-07) l=4.5e-08 \
        nf=1 as=1.64e-14 ad=5.023e-14 ps=5.7e-07 pd=9e-07 nrd=1.16667 \
        nrs=1.16667 sa=1.31244e-06 sb=2e-06 sd=160n sca=13.8179 \
        scb=0.0141903 scc=0.000851218 m=(1)
mn11 (\30\:qint n5 22 VSS) g45n1lvt w=(2.05e-07) l=4.5e-08 nf=1 \
        as=1.23e-14 ad=5.023e-14 ps=5.3e-07 pd=9e-07 nrd=1.16667 \
        nrs=1.16667 sa=1.53537e-06 sb=2e-06 sd=160n sca=13.8179 \
        scb=0.0141903 scc=0.000851218 m=(1)
mn10 (22 \6\:SN \1\:VSS VSS) g45n1lvt w=(2.05e-07) l=4.5e-08 nf=1 \
        as=4.855e-14 ad=1.23e-14 ps=9.4e-07 pd=5.3e-07 nrd=1.16667 \
        nrs=1.16667 sa=1.6078e-06 sb=2e-06 sd=160n sca=13.8179 \
        scb=0.0141903 scc=0.000851218 m=(1)
mn22_1__rcx (\6\:QN \10\:qint \1\:VSS VSS) g45n1lvt w=(2.6e-07) \
        l=4.5e-08 nf=1 as=4.334e-14 ad=4.42e-14 ps=8.65e-07 pd=8.6e-07 \
        nrd=1.16667 nrs=1.16667 sa=1.34769e-06 sb=2e-06 sd=160n \
        sca=17.5885 scb=0.0172826 scc=0.00162584 m=(4)
mn21_1__rcx (\4\:Q qbint \1\:VSS VSS) g45n1lvt w=(2.6e-07) l=4.5e-08 \
        nf=1 as=4.03e-14 ad=4.16e-14 ps=8.3e-07 pd=8.4e-07 nrd=1.16667 \
        nrs=1.16667 sa=1.94923e-06 sb=7.55e-07 sd=160n sca=17.5885 \
        scb=0.0172826 scc=0.00162584 m=(4)
mn20_1__rcx (\16\:qbint \5\:qint \1\:VSS VSS) g45n1lvt w=(2.6e-07) \
        l=4.5e-08 nf=1 as=4.16e-14 ad=4.16e-14 ps=8.4e-07 pd=8.4e-07 \
        nrd=1.16667 nrs=1.16667 sa=1.71923e-06 sb=1.575e-06 sd=160n \
        sca=17.5885 scb=0.0172826 scc=0.00162584 m=(4)
mp10_1__rcx (\33\:qint SN \1\:VDD VDD) g45p1lvt w=(3.1e-07) l=4.5e-08 \
        nf=1 as=7e-14 ad=5.658e-14 ps=1.505e-06 pd=9.85e-07 nrd=1.16667 \
        nrs=1.16667 sa=4.32258e-07 sb=2e-06 sd=160n sca=26.7199 \
        scb=0.0211429 scc=0.00304348 m=(2)
mp11_1__rcx (\33\:qint \2\:n5 \31\:VDD VDD) g45p1lvt w=(3.1e-07) \
        l=4.5e-08 nf=1 as=7.465e-14 ad=5.658e-14 ps=1.85e-06 pd=9.85e-07 \
        nrd=1.16667 nrs=1.16667 sa=6.37258e-07 sb=2e-06 sd=160n \
        sca=26.7199 scb=0.0211429 scc=0.00304348 m=(2)
mp22_1__rcx (QN \10\:qint \1\:VDD VDD) g45p1lvt w=(3.9e-07) l=4.5e-08 \
        nf=1 as=6.432e-14 ad=6.24e-14 ps=1.115e-06 pd=1.1e-06 nrd=1.16667 \
        nrs=1.16667 sa=1.07577e-06 sb=2e-06 sd=160n sca=23.2995 \
        scb=0.0182724 scc=0.00243236 m=(4)
mp21_1__rcx (\1\:Q qbint \1\:VDD VDD) g45p1lvt w=(3.9e-07) l=4.5e-08 \
        nf=1 as=6.63e-14 ad=6.337e-14 ps=1.12e-06 pd=1.105e-06 nrd=1.16667 \
        nrs=1.16667 sa=1.96718e-06 sb=7.6e-07 sd=160n sca=23.4114 \
        scb=0.0182963 scc=0.00243236 m=(4)
mp20_1__rcx (\16\:qbint \5\:qint \1\:VDD VDD) g45p1lvt w=(3.9e-07) \
        l=4.5e-08 nf=1 as=6.825e-14 ad=6.24e-14 ps=1.13e-06 pd=1.1e-06 \
        nrd=1.16667 nrs=1.16667 sa=1.73167e-06 sb=1.64e-06 sd=160n \
        sca=23.2995 scb=0.0182724 scc=0.00243236 m=(4)
ends TLATNSRX4
// End of subcircuit definition.
