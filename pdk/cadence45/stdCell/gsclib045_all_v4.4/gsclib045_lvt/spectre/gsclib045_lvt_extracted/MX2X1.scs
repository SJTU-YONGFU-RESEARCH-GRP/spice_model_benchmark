// Generated for: spectre (May  1 09:15:56 2013 )
// Library name: gsclib045_lvt
// Cell name: MX2X1
// View name: extracted

simulator lang=spectre

subckt MX2X1 A B S0 VDD VSS Y
mp0 (\10\:S0b \1\:S0 \6\:VDD VDD) g45p1lvt w=(2.15e-07) l=4.5e-08 nf=1 \
        as=3.44e-14 ad=3.01e-14 ps=7.5e-07 pd=7.1e-07 nrd=1.16667 \
        nrs=1.16667 sa=1.4e-07 sb=9.95e-07 sd=160n sca=23.8245 \
        scb=0.0263954 scc=0.00148173 m=(1)
mp1 (n4 \1\:A \6\:VDD VDD) g45p1lvt w=(2.15e-07) l=4.5e-08 nf=1 \
        as=3.44e-14 ad=1.29e-14 ps=7.5e-07 pd=5.5e-07 nrd=1.16667 \
        nrs=1.16667 sa=3.45e-07 sb=7.9e-07 sd=160n sca=13.7907 \
        scb=0.0117228 scc=0.000117112 m=(1)
mp2 (\9\:n0 \6\:S0 n4 VDD) g45p1lvt w=(2.15e-07) l=4.5e-08 nf=1 \
        as=1.29e-14 ad=3.44e-14 ps=5.5e-07 pd=7.5e-07 nrd=1.16667 \
        nrs=1.16667 sa=4.5e-07 sb=6.85e-07 sd=160n sca=12.4179 \
        scb=0.00925643 scc=8.16416e-05 m=(1)
mp4 (\9\:n0 \3\:S0b n6 VDD) g45p1lvt w=(2.15e-07) l=4.5e-08 nf=1 \
        as=1.29e-14 ad=3.44e-14 ps=5.5e-07 pd=7.5e-07 nrd=1.16667 \
        nrs=1.16667 sa=6.55e-07 sb=4.8e-07 sd=160n sca=11.7188 \
        scb=0.00807876 scc=7.57808e-05 m=(1)
mp3 (n6 \4\:B \1\:VDD VDD) g45p1lvt w=(2.15e-07) l=4.5e-08 nf=1 \
        as=7.125e-14 ad=1.29e-14 ps=1.59e-06 pd=5.5e-07 nrd=1.16667 \
        nrs=1.16667 sa=7.6e-07 sb=3.75e-07 sd=160n sca=11.9962 \
        scb=0.00852763 scc=7.72908e-05 m=(1)
C1 (S0 VSS) capacitor c=5.02697e-17
C2 (A VSS) capacitor c=4.19641e-17
C3 (Y VSS) capacitor c=5.40293e-17
C4 (VDD VSS) capacitor c=1.29127e-16
C5 (B VSS) capacitor c=4.09465e-17
C6 (S0b VSS) capacitor c=6.0297e-17
C7 (n0 VSS) capacitor c=5.98209e-17
C8 (n5 VSS) capacitor c=1.32841e-18
C9 (n6 VSS) capacitor c=2.03262e-18
C10 (\4\:B VSS) capacitor c=8.27148e-17
C11 (\3\:S0b VSS) capacitor c=5.70056e-17
C12 (\6\:S0 VSS) capacitor c=7.3222e-17
C13 (\1\:A VSS) capacitor c=7.87573e-17
C14 (\1\:S0 VSS) capacitor c=3.36914e-17
C15 (\4\:n0 VSS) capacitor c=3.50731e-17
C16 (\3\:B VSS) capacitor c=7.57168e-17
C17 (\4\:S0 VSS) capacitor c=1.01326e-16
C18 (\3\:A VSS) capacitor c=8.18254e-17
C19 (\3\:S0 VSS) capacitor c=5.95297e-17
C20 (\3\:n0 VSS) capacitor c=2.70482e-17
C21 (\1\:B VSS) capacitor c=3.09821e-17
C22 (\4\:S0b VSS) capacitor c=5.45625e-17
C23 (\2\:S0b VSS) capacitor c=6.00215e-17
C24 (\5\:S0 VSS) capacitor c=1.16712e-16
C25 (\2\:A VSS) capacitor c=9.2426e-17
C26 (\2\:S0 VSS) capacitor c=5.56737e-17
C27 (\1\:Y VSS) capacitor c=7.81971e-17
C28 (\1\:VDD VSS) capacitor c=6.15178e-17
C29 (\9\:n0 VSS) capacitor c=9.67927e-17
C30 (\6\:VDD VSS) capacitor c=3.94208e-17
C31 (\10\:S0b VSS) capacitor c=7.72516e-17
C32 (\3\:Y VSS) capacitor c=3.72037e-17
C33 (\7\:n0 VSS) capacitor c=6.63793e-17
C34 (\8\:S0b VSS) capacitor c=2.03033e-17
C35 (\2\:B VSS) capacitor c=8.05009e-17
C36 (\2\:n0 VSS) capacitor c=2.93184e-17
C37 (\4\:A VSS) capacitor c=3.12079e-17
C38 (\7\:S0 VSS) capacitor c=5.18622e-17
C39 (\8\:S0 VSS) capacitor c=7.18788e-17
C40 (\5\:S0b VSS) capacitor c=8.37489e-17
C41 (\6\:S0b VSS) capacitor c=1.22859e-16
C42 (\7\:S0b VSS) capacitor c=7.82407e-17
C43 (\5\:n0 VSS) capacitor c=3.30244e-17
C44 (\6\:n0 VSS) capacitor c=1.32284e-16
C45 (\5\:B VSS) capacitor c=6.70242e-17
C46 (\4\:VDD VSS) capacitor c=3.89346e-17
C47 (\5\:VDD VSS) capacitor c=1.0542e-17
Rk2 (\7\:S0 S0) resistor r=0.1251 c=0
Rk3 (S0 \8\:S0) resistor r=0.3191 c=0
Rk1 (A \4\:A) resistor r=0.02702 c=0
Rk12 (\2\:Y Y) resistor r=0.6143 c=0
Rk13 (Y \4\:Y) resistor r=0.04477 c=0
Rk14 (\2\:VDD \4\:VDD) resistor r=0.3994 c=0
Rk16 (\5\:VDD VDD) resistor r=0.1029 c=0
Rk15 (\4\:VDD \5\:VDD) resistor r=0.199 c=0
Rk17 (\5\:VDD \7\:VDD) resistor r=0.2261 c=0
Rk18 (\2\:VSS \4\:VSS) resistor r=0.294 c=0
Rk20 (\5\:VSS VSS) resistor r=0.1029 c=0
Rk19 (\4\:VSS \5\:VSS) resistor r=0.199 c=0
Rk21 (\5\:VSS \7\:VSS) resistor r=0.1819 c=0
Rk11 (B \5\:B) resistor r=0.07529 c=0
Rk4 (\5\:S0b \6\:S0b) resistor r=0.4035 c=0
Rk5 (\6\:S0b \7\:S0b) resistor r=0.387 c=0
Rk6 (\7\:S0b \9\:S0b) resistor r=0.1398 c=0
Rk7 (\7\:S0b \11\:S0b) resistor r=0.6367 c=0
Rk8 (\5\:n0 \6\:n0) resistor r=0.1099 c=0
Rk9 (\6\:n0 \8\:n0) resistor r=0.3304 c=0
Rk10 (\6\:n0 \10\:n0) resistor r=0.7659 c=0
Rl8 (\5\:S0 \6\:S0) resistor r=103.079 c=0
Rl7 (\4\:S0 \5\:S0) resistor r=248.616 c=0
Rl1 (\1\:S0 \2\:S0) resistor r=48.7687 c=0
Rl2 (\2\:S0 \3\:S0) resistor r=243 c=0
Rl3 (\1\:A \2\:A) resistor r=121.846 c=0
Rl4 (\2\:A \3\:A) resistor r=169.923 c=0
Rl11 (\2\:B \4\:B) resistor r=157.406 c=0
Rl10 (\2\:B \3\:B) resistor r=151.637 c=0
Rl9 (\1\:B \2\:B) resistor r=6.7128 c=0
Rl6 (\3\:S0b \4\:S0b) resistor r=35.7134 c=0
Rl5 (S0b \2\:S0b) resistor r=89.5596 c=0
Rl12 (n0 \2\:n0) resistor r=163.176 c=0
Rl14 (\2\:n0 \4\:n0) resistor r=34.3295 c=0
Rl13 (\2\:n0 \3\:n0) resistor r=5.9102 c=0
Rz3 (\3\:Y \4\:Y) resistor r=37.5 c=0
Rz5 (\1\:VSS \2\:VSS) resistor r=75 c=0
Rz6 (\6\:VSS \7\:VSS) resistor r=75 c=0
Rz1 (\8\:S0b \9\:S0b) resistor r=75 c=0
Rz2 (\7\:n0 \8\:n0) resistor r=75 c=0
Ry3 (\1\:Y \2\:Y) resistor r=20.6667 c=0
Ry4 (\1\:VDD \2\:VDD) resistor r=62 c=0
Ry5 (\6\:VDD \7\:VDD) resistor r=62 c=0
Ry1 (\10\:S0b \11\:S0b) resistor r=62 c=0
Ry2 (\9\:n0 \10\:n0) resistor r=62 c=0
Rx2 (\5\:S0 \7\:S0) resistor r=45 c=0
Rx3 (\2\:S0 \8\:S0) resistor r=45 c=0
Rx1 (\2\:A \4\:A) resistor r=45 c=0
Rx7 (\1\:B \5\:B) resistor r=45 c=0
Rx4 (\4\:S0b \5\:S0b) resistor r=45 c=0
Rx5 (\2\:S0b \6\:S0b) resistor r=45 c=0
Rx6 (\3\:n0 \5\:n0) resistor r=45 c=0
mn0 (\8\:S0b \3\:S0 \6\:VSS VSS) g45n1lvt w=(1.45e-07) l=4.5e-08 nf=1 \
        as=2.32e-14 ad=2.03e-14 ps=6.1e-07 pd=5.7e-07 nrd=1.16667 \
        nrs=1.16667 sa=1.4e-07 sb=9.95e-07 sd=160n sca=6.59604 \
        scb=0.00318587 scc=2.16275e-05 m=(1)
mn1 (n3 \3\:A \6\:VSS VSS) g45n1lvt w=(1.45e-07) l=4.5e-08 nf=1 \
        as=2.32e-14 ad=8.7e-15 ps=6.1e-07 pd=4.1e-07 nrd=1.16667 \
        nrs=1.16667 sa=3.45e-07 sb=7.9e-07 sd=160n sca=6.59604 \
        scb=0.00318587 scc=2.16275e-05 m=(1)
mn2 (\7\:n0 S0b n3 VSS) g45n1lvt w=(1.45e-07) l=4.5e-08 nf=1 as=8.7e-15 \
        ad=2.32e-14 ps=4.1e-07 pd=6.1e-07 nrd=1.16667 nrs=1.16667 \
        sa=4.5e-07 sb=6.85e-07 sd=160n sca=6.59604 scb=0.00318587 \
        scc=2.16275e-05 m=(1)
mn4 (\7\:n0 \4\:S0 n5 VSS) g45n1lvt w=(1.45e-07) l=4.5e-08 nf=1 \
        as=8.7e-15 ad=2.32e-14 ps=4.1e-07 pd=6.1e-07 nrd=1.16667 \
        nrs=1.16667 sa=6.55e-07 sb=4.8e-07 sd=160n sca=6.59604 \
        scb=0.00318587 scc=2.16275e-05 m=(1)
mn3 (n5 \3\:B \1\:VSS VSS) g45n1lvt w=(1.45e-07) l=4.5e-08 nf=1 \
        as=4.805e-14 ad=8.7e-15 ps=1.2e-06 pd=4.1e-07 nrd=1.16667 \
        nrs=1.16667 sa=7.6e-07 sb=3.75e-07 sd=160n sca=6.59604 \
        scb=0.00318587 scc=2.16275e-05 m=(1)
mn5 (\3\:Y \4\:n0 \1\:VSS VSS) g45n1lvt w=(2.6e-07) l=4.5e-08 nf=1 \
        as=4.805e-14 ad=3.64e-14 ps=1.2e-06 pd=8e-07 nrd=1.16667 \
        nrs=1.16667 sa=5.99135e-07 sb=1.4e-07 sd=160n sca=7.84363 \
        scb=0.00546499 scc=9.84911e-05 m=(1)
mp5 (\1\:Y n0 \1\:VDD VDD) g45p1lvt w=(3.9e-07) l=4.5e-08 nf=1 \
        as=7.125e-14 ad=5.46e-14 ps=1.59e-06 pd=1.06e-06 nrd=1.16667 \
        nrs=1.16667 sa=5.93397e-07 sb=1.4e-07 sd=160n sca=18.3406 \
        scb=0.0188689 scc=0.000687762 m=(1)
ends MX2X1
// End of subcircuit definition.
