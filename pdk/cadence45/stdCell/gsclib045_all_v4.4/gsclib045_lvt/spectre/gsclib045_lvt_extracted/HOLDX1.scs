// Generated for: spectre (May  1 09:15:42 2013 )
// Library name: gsclib045_lvt
// Cell name: HOLDX1
// View name: extracted

simulator lang=spectre

subckt HOLDX1 VDD VSS Y
mp0 (\13\:n0 \1\:Y \1\:VDD VDD) g45p1lvt w=(3.9e-07) l=4.5e-08 nf=1 \
        as=7.63e-14 ad=6.24e-14 ps=1.55e-06 pd=1.1e-06 nrd=1.16667 \
        nrs=1.16667 sa=1.6e-07 sb=3.8109e-07 sd=160n sca=36.9908 \
        scb=0.0284138 scc=0.00351818 m=(1)
C1 (Y VSS) capacitor c=1.93182e-17
C2 (VDD VSS) capacitor c=5.03748e-17
C3 (n0 VSS) capacitor c=1.75557e-17
C4 (p2 VSS) capacitor c=1.96408e-18
C5 (p1 VSS) capacitor c=1.96408e-18
C6 (\7\:n0 VSS) capacitor c=8.79857e-18
C7 (\9\:n0 VSS) capacitor c=2.59812e-17
C8 (\1\:Y VSS) capacitor c=3.86134e-17
C9 (\5\:n0 VSS) capacitor c=1.29407e-17
C10 (\6\:n0 VSS) capacitor c=5.62188e-18
C11 (\8\:n0 VSS) capacitor c=1.96049e-17
C12 (\3\:Y VSS) capacitor c=3.64698e-17
C13 (\4\:n0 VSS) capacitor c=2.77436e-17
C14 (\2\:Y VSS) capacitor c=3.13957e-17
C15 (\6\:Y VSS) capacitor c=2.41824e-17
C16 (\1\:VDD VSS) capacitor c=2.07303e-17
C17 (\13\:n0 VSS) capacitor c=4.75593e-17
C18 (\4\:Y VSS) capacitor c=1.65152e-17
C19 (\11\:n0 VSS) capacitor c=3.43495e-17
C20 (\2\:n0 VSS) capacitor c=7.10338e-18
C21 (\3\:n0 VSS) capacitor c=2.69776e-18
C22 (\10\:n0 VSS) capacitor c=4.32279e-17
C23 (\8\:Y VSS) capacitor c=7.64111e-17
C24 (\4\:VDD VSS) capacitor c=1.80976e-17
Rk3 (\5\:Y Y) resistor r=0.1558 c=0
Rk4 (Y \7\:Y) resistor r=0.06457 c=0
Rk5 (\7\:Y \8\:Y) resistor r=0.4701 c=0
Rk7 (\4\:VDD VDD) resistor r=0.1979 c=0
Rk6 (\2\:VDD \4\:VDD) resistor r=0.2694 c=0
Rk9 (\4\:VSS VSS) resistor r=0.1979 c=0
Rk8 (\2\:VSS \4\:VSS) resistor r=0.1169 c=0
Rk1 (\10\:n0 \12\:n0) resistor r=0.3069 c=0
Rk2 (\12\:n0 \14\:n0) resistor r=0.352 c=0
Rl1 (\1\:Y \2\:Y) resistor r=24.2328 c=0
Rl2 (\2\:Y \3\:Y) resistor r=39.6174 c=0
Rl10 (\4\:n0 \9\:n0) resistor r=39.6174 c=0
Rl9 (\4\:n0 \8\:n0) resistor r=24.2328 c=0
Rl3 (n0 \2\:n0) resistor r=60.772 c=0
Rl6 (\2\:n0 \5\:n0) resistor r=28.0797 c=0
Rl8 (\3\:n0 \7\:n0) resistor r=59.2509 c=0
Rl7 (\3\:n0 \6\:n0) resistor r=26.5586 c=0
Rl5 (\3\:n0 \4\:n0) resistor r=34.9837 c=0
Rl4 (\2\:n0 \3\:n0) resistor r=30.0863 c=0
Rz2 (\4\:Y \5\:Y) resistor r=75 c=0
Rz4 (\1\:VSS \2\:VSS) resistor r=75 c=0
Rz1 (\11\:n0 \12\:n0) resistor r=75 c=0
Ry2 (\6\:Y \7\:Y) resistor r=62 c=0
Ry3 (\1\:VDD \2\:VDD) resistor r=62 c=0
Ry1 (\13\:n0 \14\:n0) resistor r=20.6667 c=0
Rx2 (\2\:Y \8\:Y) resistor r=45 c=0
Rx1 (\4\:n0 \10\:n0) resistor r=45 c=0
mn0 (\11\:n0 \3\:Y \1\:VSS VSS) g45n1lvt w=(2.6e-07) l=4.5e-08 nf=1 \
        as=6.635e-14 ad=3.64e-14 ps=1.72e-06 pd=8e-07 nrd=1.16667 \
        nrs=1.16667 sa=1.4e-07 sb=3.81635e-07 sd=160n sca=17.5885 \
        scb=0.0172826 scc=0.00162584 m=(1)
mn3 (n2 \8\:n0 \1\:VSS VSS) g45n1lvt w=(1.45e-07) l=4.5e-08 nf=1 \
        as=6.635e-14 ad=8.7e-15 ps=1.72e-06 pd=4.1e-07 nrd=1.16667 \
        nrs=1.16667 sa=3.95e-07 sb=3.5e-07 sd=160n sca=23.279 \
        scb=0.0230742 scc=0.00267719 m=(1)
mn2 (n1 \6\:n0 n2 VSS) g45n1lvt w=(1.45e-07) l=4.5e-08 nf=1 as=8.7e-15 \
        ad=8.7e-15 ps=4.1e-07 pd=4.1e-07 nrd=1.16667 nrs=1.16667 sa=5e-07 \
        sb=2.45e-07 sd=160n sca=23.279 scb=0.0230742 scc=0.00267719 m=(1)
mn1 (\4\:Y \5\:n0 n1 VSS) g45n1lvt w=(1.45e-07) l=4.5e-08 nf=1 as=8.7e-15 \
        ad=2.03e-14 ps=4.1e-07 pd=5.7e-07 nrd=1.16667 nrs=1.16667 \
        sa=6.05e-07 sb=1.4e-07 sd=160n sca=23.279 scb=0.0230742 \
        scc=0.00267719 m=(1)
mp3 (p2 \9\:n0 \1\:VDD VDD) g45p1lvt w=(2.15e-07) l=4.5e-08 nf=1 \
        as=7.63e-14 ad=1.29e-14 ps=1.55e-06 pd=5.5e-07 nrd=1.16667 \
        nrs=1.16667 sa=4.15e-07 sb=3.5e-07 sd=160n sca=50.7542 \
        scb=0.0334718 scc=0.00592392 m=(1)
mp2 (p1 \7\:n0 p2 VDD) g45p1lvt w=(2.15e-07) l=4.5e-08 nf=1 as=1.29e-14 \
        ad=1.29e-14 ps=5.5e-07 pd=5.5e-07 nrd=1.16667 nrs=1.16667 \
        sa=5.2e-07 sb=2.45e-07 sd=160n sca=53.0765 scb=0.0380162 \
        scc=0.00612638 m=(1)
mp1 (\6\:Y n0 p1 VDD) g45p1lvt w=(2.15e-07) l=4.5e-08 nf=1 as=1.29e-14 \
        ad=3.01e-14 ps=5.5e-07 pd=7.1e-07 nrd=1.16667 nrs=1.16667 \
        sa=6.25e-07 sb=1.4e-07 sd=160n sca=59.8576 scb=0.0474724 \
        scc=0.00729056 m=(1)
ends HOLDX1
// End of subcircuit definition.
