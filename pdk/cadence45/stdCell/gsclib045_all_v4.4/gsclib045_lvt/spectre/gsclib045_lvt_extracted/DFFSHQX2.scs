// Generated for: spectre (May  1 09:13:51 2013 )
// Library name: gsclib045_lvt
// Cell name: DFFSHQX2
// View name: extracted

simulator lang=spectre

subckt DFFSHQX2 CK D Q SN VDD VSS
mp55_1__rcx (\3\:Q qbint VDD VDD) g45p1lvt w=(3.9e-07) l=4.5e-08 nf=1 \
        as=5.46e-14 ad=6.24e-14 ps=1.06e-06 pd=1.1e-06 nrd=1.16667 \
        nrs=1.16667 sa=1.4e-07 sb=3.45e-07 sd=160n sca=43.6185 \
        scb=0.0386349 scc=0.00465805 m=(2)
C1 (SN VSS) capacitor c=2.22322e-16
C2 (Q VSS) capacitor c=2.31257e-17
C3 (VDD VSS) capacitor c=4.267e-16
C4 (CK VSS) capacitor c=4.08442e-17
C5 (D VSS) capacitor c=6.00342e-17
C6 (qbint VSS) capacitor c=1.04003e-16
C7 (n35 VSS) capacitor c=2.45539e-17
C8 (n40 VSS) capacitor c=6.0737e-18
C9 (CKb VSS) capacitor c=3.37044e-17
C10 (mout VSS) capacitor c=8.12218e-17
C11 (CKbb VSS) capacitor c=5.57942e-17
C12 (n25 VSS) capacitor c=1.87772e-18
C13 (n20 VSS) capacitor c=3.59049e-17
C14 (n30 VSS) capacitor c=3.33501e-18
C15 (n41 VSS) capacitor c=6.83676e-17
C16 (n31 VSS) capacitor c=1.8118e-18
C17 (n22 VSS) capacitor c=6.51579e-18
C18 (\1\:CK VSS) capacitor c=5.66774e-17
C19 (\3\:D VSS) capacitor c=6.45471e-17
C20 (\5\:CKbb VSS) capacitor c=7.33483e-17
C21 (\10\:CKb VSS) capacitor c=7.21278e-17
C22 (\4\:SN VSS) capacitor c=5.74748e-17
C23 (\7\:CKb VSS) capacitor c=1.87319e-17
C24 (\9\:CKb VSS) capacitor c=3.26182e-17
C25 (\8\:qbint VSS) capacitor c=5.78777e-17
C26 (\1\:SN VSS) capacitor c=5.63304e-17
C27 (\4\:n35 VSS) capacitor c=3.55063e-17
C28 (\3\:CK VSS) capacitor c=4.08701e-17
C29 (\1\:D VSS) capacitor c=7.53921e-17
C30 (\12\:CKb VSS) capacitor c=5.34234e-17
C31 (\7\:CKbb VSS) capacitor c=3.27945e-17
C32 (\4\:mout VSS) capacitor c=4.26051e-17
C33 (\3\:n20 VSS) capacitor c=5.99792e-17
C34 (\7\:SN VSS) capacitor c=4.53385e-17
C35 (\3\:CKb VSS) capacitor c=4.43122e-17
C36 (\3\:CKbb VSS) capacitor c=2.89374e-17
C37 (\11\:qbint VSS) capacitor c=2.86877e-17
C38 (\3\:SN VSS) capacitor c=5.27854e-17
C39 (\3\:n35 VSS) capacitor c=4.72145e-17
C40 (\2\:CK VSS) capacitor c=5.25567e-17
C41 (\2\:D VSS) capacitor c=5.88892e-17
C42 (\13\:CKb VSS) capacitor c=4.48783e-17
C43 (\11\:CKb VSS) capacitor c=3.16144e-17
C44 (\6\:CKbb VSS) capacitor c=8.56551e-17
C45 (\3\:mout VSS) capacitor c=1.104e-17
C46 (\2\:n20 VSS) capacitor c=3.61957e-17
C47 (\6\:SN VSS) capacitor c=2.62333e-17
C48 (\8\:CKb VSS) capacitor c=2.06863e-17
C49 (\4\:CKbb VSS) capacitor c=5.36666e-17
C50 (\6\:CKb VSS) capacitor c=2.71481e-17
C51 (\2\:CKb VSS) capacitor c=3.90961e-17
C52 (\10\:qbint VSS) capacitor c=2.41216e-17
C53 (\2\:SN VSS) capacitor c=6.72018e-17
C54 (\6\:qbint VSS) capacitor c=7.63948e-18
C55 (\16\:CKb VSS) capacitor c=4.41316e-17
C56 (\1\:VDD VSS) capacitor c=5.87226e-17
C57 (\4\:n20 VSS) capacitor c=7.13862e-17
C58 (\5\:VDD VSS) capacitor c=7.17606e-17
C59 (\8\:mout VSS) capacitor c=1.54761e-16
C60 (\8\:VDD VSS) capacitor c=2.52813e-17
C61 (\9\:CKbb VSS) capacitor c=2.11347e-16
C62 (\10\:mout VSS) capacitor c=1.59355e-16
C63 (\5\:n35 VSS) capacitor c=6.75794e-17
C64 (\11\:VDD VSS) capacitor c=3.13227e-17
C65 (\3\:n41 VSS) capacitor c=8.24765e-17
C66 (\15\:VDD VSS) capacitor c=2.90817e-17
C67 (\17\:qbint VSS) capacitor c=7.65758e-17
C68 (\3\:Q VSS) capacitor c=1.00067e-16
C69 (\3\:VDD VSS) capacitor c=5.34849e-17
C70 (\22\:CKb VSS) capacitor c=5.74441e-17
C71 (\8\:n20 VSS) capacitor c=5.08617e-17
C72 (\6\:mout VSS) capacitor c=8.13418e-17
C73 (\13\:CKbb VSS) capacitor c=4.35135e-17
C74 (\12\:mout VSS) capacitor c=1.05131e-16
C75 (\9\:n35 VSS) capacitor c=9.65982e-17
C76 (\15\:qbint VSS) capacitor c=2.30372e-17
C77 (\1\:Q VSS) capacitor c=1.05503e-17
C78 (\2\:n35 VSS) capacitor c=2.68067e-17
C79 (\9\:qbint VSS) capacitor c=3.21948e-17
C80 (\2\:CKbb VSS) capacitor c=5.55516e-17
C81 (\4\:CKb VSS) capacitor c=5.33236e-17
C82 (\5\:CKb VSS) capacitor c=4.70433e-17
C83 (\5\:SN VSS) capacitor c=2.45237e-17
C84 (\2\:mout VSS) capacitor c=4.05393e-17
C85 (\12\:qbint VSS) capacitor c=6.227e-17
C86 (\13\:qbint VSS) capacitor c=5.18693e-17
C87 (\14\:qbint VSS) capacitor c=5.21636e-17
C88 (\7\:n35 VSS) capacitor c=1.31642e-16
C89 (\8\:n35 VSS) capacitor c=8.51515e-17
C90 (\14\:CKb VSS) capacitor c=6.74382e-17
C91 (\15\:CKb VSS) capacitor c=4.54374e-17
C92 (\8\:SN VSS) capacitor c=2.09169e-16
C93 (\9\:SN VSS) capacitor c=6.11839e-17
C94 (\5\:mout VSS) capacitor c=5.6117e-17
C95 (\8\:CKbb VSS) capacitor c=1.66534e-16
C96 (\11\:CKbb VSS) capacitor c=3.30102e-17
C97 (\12\:CKbb VSS) capacitor c=3.08895e-17
C98 (\6\:n20 VSS) capacitor c=8.86009e-17
C99 (\7\:n20 VSS) capacitor c=6.96166e-17
C100 (\4\:D VSS) capacitor c=4.5203e-17
C101 (\18\:CKb VSS) capacitor c=1.17558e-16
C102 (\19\:CKb VSS) capacitor c=1.05535e-16
C103 (\20\:CKb VSS) capacitor c=1.58056e-16
C104 (\21\:CKb VSS) capacitor c=1.64351e-16
C105 (\4\:CK VSS) capacitor c=4.1604e-17
C106 (\7\:VDD VSS) capacitor c=4.24156e-17
C107 (\10\:VDD VSS) capacitor c=3.25543e-17
C108 (\14\:VDD VSS) capacitor c=1.43395e-17
Rk12 (\8\:SN SN) resistor r=1.468 c=0
Rk13 (SN \9\:SN) resistor r=0.3577 c=0
Rk32 (\2\:VSS \4\:VSS) resistor r=0.6363 c=0
Rk33 (\4\:VSS \5\:VSS) resistor r=0.3772 c=0
Rk34 (\5\:VSS \6\:VSS) resistor r=0.8274 c=0
Rk36 (\7\:VSS VSS) resistor r=0.2855 c=0
Rk35 (\6\:VSS \7\:VSS) resistor r=0.05748 c=0
Rk38 (\4\:VSS \10\:VSS) resistor r=0.07147 c=0
Rk39 (\5\:VSS \12\:VSS) resistor r=0.3396 c=0
Rk40 (\7\:VSS \14\:VSS) resistor r=0.2844 c=0
Rk1 (Q \2\:Q) resistor r=0.03903 c=0
Rk2 (Q \4\:Q) resistor r=0.2582 c=0
Rk43 (\2\:VDD \4\:VDD) resistor r=0.5948 c=0
Rk44 (\4\:VDD \6\:VDD) resistor r=0.3898 c=0
Rk45 (\4\:VDD \7\:VDD) resistor r=0.323 c=0
Rk46 (\7\:VDD \9\:VDD) resistor r=0.04331 c=0
Rk47 (\7\:VDD \10\:VDD) resistor r=0.746 c=0
Rk48 (\10\:VDD \12\:VDD) resistor r=0.2029 c=0
Rk49 (\10\:VDD \13\:VDD) resistor r=0.1327 c=0
Rk52 (\14\:VDD VDD) resistor r=0.2855 c=0
Rk50 (\13\:VDD \14\:VDD) resistor r=0.05748 c=0
Rk51 (\14\:VDD \16\:VDD) resistor r=0.212 c=0
Rk31 (CK \4\:CK) resistor r=0.1342 c=0
Rk25 (D \4\:D) resistor r=0.05565 c=0
Rk3 (\12\:qbint \13\:qbint) resistor r=0.3187 c=0
Rk4 (\13\:qbint \14\:qbint) resistor r=0.2851 c=0
Rk5 (\13\:qbint \16\:qbint) resistor r=0.1395 c=0
Rk6 (\13\:qbint \18\:qbint) resistor r=0.3789 c=0
Rk8 (\6\:n35 \7\:n35) resistor r=0.3675 c=0
Rk9 (\7\:n35 \8\:n35) resistor r=0.4861 c=0
Rk10 (\7\:n35 \10\:n35) resistor r=0.4425 c=0
Rk11 (\14\:CKb \15\:CKb) resistor r=0.2033 c=0
Rk26 (\17\:CKb \18\:CKb) resistor r=0.3836 c=0
Rk27 (\18\:CKb \19\:CKb) resistor r=0.492 c=0
Rk28 (\18\:CKb \20\:CKb) resistor r=0.3508 c=0
Rk29 (\20\:CKb \21\:CKb) resistor r=1.2153 c=0
Rk30 (\19\:CKb \23\:CKb) resistor r=0.4329 c=0
Rk14 (\5\:mout \7\:mout) resistor r=0.2862 c=0
Rk15 (\7\:mout \9\:mout) resistor r=0.3329 c=0
Rk16 (\9\:mout \11\:mout) resistor r=0.8615 c=0
Rk17 (\11\:mout \13\:mout) resistor r=0.5787 c=0
Rk18 (\8\:CKbb \10\:CKbb) resistor r=1.3833 c=0
Rk19 (\10\:CKbb \11\:CKbb) resistor r=0.3115 c=0
Rk20 (\11\:CKbb \12\:CKbb) resistor r=0.03537 c=0
Rk21 (\11\:CKbb \14\:CKbb) resistor r=0.1502 c=0
Rk22 (\5\:n20 \6\:n20) resistor r=0.3158 c=0
Rk23 (\6\:n20 \7\:n20) resistor r=0.3777 c=0
Rk24 (\6\:n20 \9\:n20) resistor r=0.2958 c=0
Rk7 (\2\:n41 \4\:n41) resistor r=0.4205 c=0
Rl10 (\1\:SN \2\:SN) resistor r=72.2519 c=0
Rl11 (\2\:SN \3\:SN) resistor r=95.3288 c=0
Rl25 (\4\:SN \5\:SN) resistor r=95.4336 c=0
Rl27 (\5\:SN \7\:SN) resistor r=34.3295 c=0
Rl26 (\5\:SN \6\:SN) resistor r=3.5166 c=0
Rl39 (\1\:CK \2\:CK) resistor r=166.483 c=0
Rl40 (\2\:CK \3\:CK) resistor r=85.7134 c=0
Rl38 (\2\:D \3\:D) resistor r=129.944 c=0
Rl37 (\1\:D \2\:D) resistor r=85.7134 c=0
Rl5 (qbint \6\:qbint) resistor r=4.3693 c=0
Rl12 (\9\:qbint \8\:qbint) resistor r=157.406 c=0
Rl14 (\9\:qbint \11\:qbint) resistor r=34.3295 c=0
Rl13 (\9\:qbint \10\:qbint) resistor r=2.0166 c=0
Rl9 (\2\:n35 \4\:n35) resistor r=34.3295 c=0
Rl8 (\2\:n35 \3\:n35) resistor r=157.406 c=0
Rl7 (n35 \2\:n35) resistor r=1.2713 c=0
Rl36 (\12\:CKb \13\:CKb) resistor r=26.1559 c=0
Rl33 (\10\:CKb \11\:CKb) resistor r=24.2328 c=0
Rl23 (\7\:CKb \8\:CKb) resistor r=50.6918 c=0
Rl15 (CKb \2\:CKb) resistor r=61.5157 c=0
Rl22 (\4\:CKb \7\:CKb) resistor r=35.772 c=0
Rl19 (\3\:CKb \4\:CKb) resistor r=99.2335 c=0
Rl24 (\5\:CKb \9\:CKb) resistor r=40.4702 c=0
Rl21 (\5\:CKb \6\:CKb) resistor r=3.203 c=0
Rl20 (\4\:CKb \5\:CKb) resistor r=223.952 c=0
Rl30 (mout \2\:mout) resistor r=121.957 c=0
Rl32 (\2\:mout \4\:mout) resistor r=54.6488 c=0
Rl31 (\2\:mout \3\:mout) resistor r=1.2301 c=0
Rl34 (\5\:CKbb \6\:CKbb) resistor r=251.466 c=0
Rl35 (\6\:CKbb \7\:CKbb) resistor r=24.7951 c=0
Rl16 (CKbb \2\:CKbb) resistor r=108.849 c=0
Rl17 (\2\:CKbb \3\:CKbb) resistor r=37.6951 c=0
Rl18 (\2\:CKbb \4\:CKbb) resistor r=159.989 c=0
Rl28 (n20 \2\:n20) resistor r=52.251 c=0
Rl29 (\2\:n20 \3\:n20) resistor r=128.766 c=0
Rz9 (\2\:VSS \1\:VSS) resistor r=75 c=0
Rz10 (\10\:VSS \9\:VSS) resistor r=75 c=0
Rz11 (\12\:VSS \11\:VSS) resistor r=75 c=0
Rz12 (\14\:VSS \13\:VSS) resistor r=75 c=0
Rz1 (\2\:Q \1\:Q) resistor r=75 c=0
Rz15 (\4\:VDD \3\:VDD) resistor r=6.25 c=0
Rz16 (\13\:VDD \3\:VDD) resistor r=6.25 c=0
Rz2 (\16\:qbint \15\:qbint) resistor r=75 c=0
Rz3 (\9\:n35 \10\:n35) resistor r=75 c=0
Rz8 (\22\:CKb \23\:CKb) resistor r=75 c=0
Rz4 (\6\:mout \7\:mout) resistor r=75 c=0
Rz5 (\12\:mout \13\:mout) resistor r=75 c=0
Rz6 (\13\:CKbb \14\:CKbb) resistor r=75 c=0
Rz7 (\8\:n20 \9\:n20) resistor r=75 c=0
Ry11 (\4\:VSS \3\:VSS) resistor r=5.1667 c=0
Ry12 (\6\:VSS \3\:VSS) resistor r=5.1667 c=0
Ry1 (\4\:Q \3\:Q) resistor r=20.6667 c=0
Ry13 (\2\:VDD \1\:VDD) resistor r=62 c=0
Ry14 (\6\:VDD \5\:VDD) resistor r=62 c=0
Ry15 (\9\:VDD \8\:VDD) resistor r=62 c=0
Ry16 (\12\:VDD \11\:VDD) resistor r=62 c=0
Ry17 (\16\:VDD \15\:VDD) resistor r=62 c=0
Ry2 (\18\:qbint \17\:qbint) resistor r=31 c=0
Ry5 (\5\:n35 \6\:n35) resistor r=31 c=0
Ry10 (\16\:CKb \17\:CKb) resistor r=62 c=0
Ry6 (\8\:mout \9\:mout) resistor r=62 c=0
Ry7 (\10\:mout \11\:mout) resistor r=31 c=0
Ry8 (\9\:CKbb \10\:CKbb) resistor r=62 c=0
Ry9 (\4\:n20 \5\:n20) resistor r=62 c=0
Ry3 (n41 \2\:n41) resistor r=62 c=0
Ry4 (\3\:n41 \4\:n41) resistor r=62 c=0
Rx6 (\6\:SN \8\:SN) resistor r=45 c=0
Rx7 (\2\:SN \9\:SN) resistor r=45 c=0
Rx16 (\2\:CK \4\:CK) resistor r=45 c=0
Rx12 (\2\:D \4\:D) resistor r=45 c=0
Rx1 (\12\:qbint \10\:qbint) resistor r=45 c=0
Rx2 (\14\:qbint \6\:qbint) resistor r=45 c=0
Rx3 (n35 \8\:n35) resistor r=45 c=0
Rx4 (\6\:CKb \14\:CKb) resistor r=45 c=0
Rx5 (\2\:CKb \15\:CKb) resistor r=45 c=0
Rx13 (\13\:CKb \19\:CKb) resistor r=45 c=0
Rx14 (\11\:CKb \20\:CKb) resistor r=45 c=0
Rx15 (\8\:CKb \21\:CKb) resistor r=45 c=0
Rx8 (\3\:mout \5\:mout) resistor r=45 c=0
Rx9 (\6\:CKbb \8\:CKbb) resistor r=45 c=0
Rx10 (\4\:CKbb \12\:CKbb) resistor r=45 c=0
Rx11 (\2\:n20 \7\:n20) resistor r=45 c=0
mn55_1__rcx (\1\:Q qbint VSS VSS) g45n1lvt w=(2.6e-07) l=4.5e-08 nf=1 \
        as=3.64e-14 ad=4.16e-14 ps=8e-07 pd=8.4e-07 nrd=1.16667 \
        nrs=1.16667 sa=1.4e-07 sb=3.45e-07 sd=160n sca=17.5885 \
        scb=0.0172826 scc=0.00162584 m=(2)
mn45 (\15\:qbint \3\:n35 \13\:VSS VSS) g45n1lvt w=(2.05e-07) l=4.5e-08 \
        nf=1 as=3.28e-14 ad=2.87e-14 ps=7.3e-07 pd=6.9e-07 nrd=1.16667 \
        nrs=1.16667 sa=1.4e-07 sb=1.12e-06 sd=160n sca=13.4389 \
        scb=0.0137383 scc=0.000784938 m=(1)
mn50 (n42 \3\:SN \13\:VSS VSS) g45n1lvt w=(2.05e-07) l=4.5e-08 nf=1 \
        as=3.28e-14 ad=3.28e-14 ps=7.3e-07 pd=7.3e-07 nrd=1.16667 \
        nrs=1.16667 sa=3.45e-07 sb=9.15e-07 sd=160n sca=13.4389 \
        scb=0.0137383 scc=0.000784938 m=(1)
mn51 (n40 \11\:qbint n42 VSS) g45n1lvt w=(2.05e-07) l=4.5e-08 nf=1 \
        as=3.28e-14 ad=5.638e-14 ps=7.3e-07 pd=9.6e-07 nrd=1.16667 \
        nrs=1.16667 sa=5.5e-07 sb=7.1e-07 sd=160n sca=13.4389 \
        scb=0.0137383 scc=0.000784938 m=(1)
mn52 (\9\:n35 CKb n40 VSS) g45n1lvt w=(2.05e-07) l=4.5e-08 nf=1 \
        as=5.638e-14 ad=4.202e-14 ps=9.6e-07 pd=8.2e-07 nrd=1.16667 \
        nrs=1.16667 sa=8.7e-07 sb=3.9e-07 sd=160n sca=13.4389 \
        scb=0.0137383 scc=0.000784938 m=(1)
mn40 (\9\:n35 \3\:CKbb \12\:mout VSS) g45n1lvt w=(2.05e-07) l=4.5e-08 \
        nf=1 as=2.87e-14 ad=4.202e-14 ps=6.9e-07 pd=8.2e-07 nrd=1.16667 \
        nrs=1.16667 sa=1.12e-06 sb=1.4e-07 sd=160n sca=13.4389 \
        scb=0.0137383 scc=0.000784938 m=(1)
mn30 (n25 \7\:SN \11\:VSS VSS) g45n1lvt w=(2.05e-07) l=4.5e-08 nf=1 \
        as=3.065e-14 ad=2.05e-14 ps=7.5e-07 pd=6.1e-07 nrd=1.16667 \
        nrs=1.16667 sa=3.97073e-07 sb=2.85e-07 sd=160n sca=19.867 \
        scb=0.0198061 scc=0.00201945 m=(1)
mn31 (\6\:mout \3\:n20 n25 VSS) g45n1lvt w=(2.05e-07) l=4.5e-08 nf=1 \
        as=2.05e-14 ad=2.87e-14 ps=6.1e-07 pd=6.9e-07 nrd=1.16667 \
        nrs=1.16667 sa=5.42073e-07 sb=1.4e-07 sd=160n sca=19.867 \
        scb=0.0198061 scc=0.00201945 m=(1)
mn36 (n30 \4\:mout \9\:VSS VSS) g45n1lvt w=(2.05e-07) l=4.5e-08 nf=1 \
        as=5.765e-14 ad=2.358e-14 ps=1.13e-06 pd=6.4e-07 nrd=1.16667 \
        nrs=1.16667 sa=1.7e-07 sb=8.98293e-07 sd=160n sca=8.01384 \
        scb=0.0056906 scc=9.46507e-05 m=(1)
mn35 (\8\:n20 \7\:CKbb n30 VSS) g45n1lvt w=(2.05e-07) l=4.5e-08 nf=1 \
        as=2.358e-14 ad=6.458e-14 ps=6.4e-07 pd=1.04e-06 nrd=1.16667 \
        nrs=1.16667 sa=3.3e-07 sb=7.38293e-07 sd=160n sca=8.01384 \
        scb=0.0056906 scc=9.46507e-05 m=(1)
mn26 (\8\:n20 \12\:CKb n21 VSS) g45n1lvt w=(2.05e-07) l=4.5e-08 nf=1 \
        as=1.23e-14 ad=6.458e-14 ps=5.3e-07 pd=1.04e-06 nrd=1.16667 \
        nrs=1.16667 sa=6.9e-07 sb=3.78293e-07 sd=160n sca=8.01384 \
        scb=0.0056906 scc=9.46507e-05 m=(1)
mn25 (n21 \1\:D \1\:VSS VSS) g45n1lvt w=(2.05e-07) l=4.5e-08 nf=1 \
        as=2.92e-14 ad=1.23e-14 ps=7.3e-07 pd=5.3e-07 nrd=1.16667 \
        nrs=1.16667 sa=7.95e-07 sb=2.73293e-07 sd=160n sca=8.01384 \
        scb=0.0056906 scc=9.46507e-05 m=(1)
mn21 (\13\:CKbb \3\:CKb \11\:VSS VSS) g45n1lvt w=(1.45e-07) l=4.5e-08 \
        nf=1 as=3.065e-14 ad=4.422e-14 ps=7.5e-07 pd=9e-07 nrd=1.16667 \
        nrs=1.16667 sa=3.05e-07 sb=5e-07 sd=160n sca=15.2405 scb=0.016218 \
        scc=0.00104639 m=(1)
mn20 (\22\:CKb \3\:CK \1\:VSS VSS) g45n1lvt w=(1.45e-07) l=4.5e-08 nf=1 \
        as=2.92e-14 ad=2.03e-14 ps=7.3e-07 pd=5.7e-07 nrd=1.16667 \
        nrs=1.16667 sa=1e-06 sb=1.4e-07 sd=160n sca=8.70265 scb=0.00681258 \
        scc=0.000126945 m=(1)
mp45 (\17\:qbint \4\:n35 \15\:VDD VDD) g45p1lvt w=(3.1e-07) l=4.5e-08 \
        nf=1 as=4.96e-14 ad=4.34e-14 ps=9.4e-07 pd=9e-07 nrd=1.16667 \
        nrs=1.16667 sa=1.4e-07 sb=5.5e-07 sd=160n sca=10.8995 \
        scb=0.00872363 scc=0.000163661 m=(1)
mp50 (\3\:n41 \1\:SN \15\:VDD VDD) g45p1lvt w=(3.1e-07) l=4.5e-08 nf=1 \
        as=4.96e-14 ad=4.96e-14 ps=9.4e-07 pd=9.4e-07 nrd=1.16667 \
        nrs=1.16667 sa=3.45e-07 sb=3.45e-07 sd=160n sca=10.8995 \
        scb=0.00872363 scc=0.000163661 m=(1)
mp51 (\3\:n41 \8\:qbint \11\:VDD VDD) g45p1lvt w=(3.1e-07) l=4.5e-08 \
        nf=1 as=4.34e-14 ad=4.96e-14 ps=9e-07 pd=9.4e-07 nrd=1.16667 \
        nrs=1.16667 sa=5.5e-07 sb=1.4e-07 sd=160n sca=10.8995 \
        scb=0.00872363 scc=0.000163661 m=(1)
mp52 (\5\:n35 CKbb n41 VDD) g45p1lvt w=(3.1e-07) l=4.5e-08 nf=1 \
        as=4.34e-14 ad=4.96e-14 ps=9e-07 pd=9.4e-07 nrd=1.16667 \
        nrs=1.16667 sa=1.4e-07 sb=3.45e-07 sd=160n sca=16.415 \
        scb=0.0153923 scc=0.00118075 m=(1)
mp40 (\5\:n35 \9\:CKb \10\:mout VDD) g45p1lvt w=(3.1e-07) l=4.5e-08 nf=1 \
        as=4.34e-14 ad=4.96e-14 ps=9e-07 pd=9.4e-07 nrd=1.16667 \
        nrs=1.16667 sa=3.45e-07 sb=1.4e-07 sd=160n sca=16.415 \
        scb=0.0153923 scc=0.00118075 m=(1)
mp30 (\8\:mout \4\:SN \8\:VDD VDD) g45p1lvt w=(3.1e-07) l=4.5e-08 nf=1 \
        as=1.1848e-13 ad=7.75e-14 ps=1.89e-06 pd=1.12e-06 nrd=1.16667 \
        nrs=1.16667 sa=3.71129e-07 sb=1.06202e-06 sd=160n sca=19.8394 \
        scb=0.0179302 scc=0.00185493 m=(1)
mp31 (\8\:mout n20 \5\:VDD VDD) g45p1lvt w=(3.1e-07) l=4.5e-08 nf=1 \
        as=6.975e-14 ad=7.75e-14 ps=1.07e-06 pd=1.12e-06 nrd=1.16667 \
        nrs=1.16667 sa=6.66129e-07 sb=7.67016e-07 sd=160n sca=19.8394 \
        scb=0.0179302 scc=0.00185493 m=(1)
mp35 (n31 mout \5\:VDD VDD) g45p1lvt w=(3.1e-07) l=4.5e-08 nf=1 \
        as=6.975e-14 ad=1.86e-14 ps=1.07e-06 pd=7.4e-07 nrd=1.16667 \
        nrs=1.16667 sa=9.36129e-07 sb=4.97016e-07 sd=160n sca=19.8394 \
        scb=0.0179302 scc=0.00185493 m=(1)
mp36 (\4\:n20 \10\:CKb n31 VDD) g45p1lvt w=(3.1e-07) l=4.5e-08 nf=1 \
        as=1.86e-14 ad=6.875e-14 ps=7.4e-07 pd=1.43e-06 nrd=1.16667 \
        nrs=1.16667 sa=1.04113e-06 sb=3.92016e-07 sd=160n sca=19.8394 \
        scb=0.0179302 scc=0.00185493 m=(1)
mp26 (\4\:n20 \5\:CKbb n22 VDD) g45p1lvt w=(3.1e-07) l=4.5e-08 nf=1 \
        as=5.425e-14 ad=6.875e-14 ps=9.7e-07 pd=1.43e-06 nrd=1.16667 \
        nrs=1.16667 sa=6.49839e-07 sb=4.96855e-07 sd=160n sca=11.4585 \
        scb=0.00892838 scc=0.000163733 m=(1)
mp25 (n22 \3\:D \1\:VDD VDD) g45p1lvt w=(3.1e-07) l=4.5e-08 nf=1 \
        as=4.605e-14 ad=5.425e-14 ps=9.6e-07 pd=9.7e-07 nrd=1.16667 \
        nrs=1.16667 sa=8.69839e-07 sb=2.76855e-07 sd=160n sca=12.7952 \
        scb=0.0102782 scc=0.000168009 m=(1)
mp21 (\9\:CKbb \7\:CKb \8\:VDD VDD) g45p1lvt w=(2.15e-07) l=4.5e-08 nf=1 \
        as=1.1848e-13 ad=3.01e-14 ps=1.89e-06 pd=7.1e-07 nrd=1.16667 \
        nrs=1.16667 sa=1.4e-07 sb=1.22047e-06 sd=160n sca=23.7894 \
        scb=0.0219499 scc=0.00260958 m=(1)
mp20 (\16\:CKb \1\:CK \1\:VDD VDD) g45p1lvt w=(2.15e-07) l=4.5e-08 nf=1 \
        as=4.605e-14 ad=3.01e-14 ps=9.6e-07 pd=7.1e-07 nrd=1.16667 \
        nrs=1.16667 sa=7.98488e-07 sb=1.4e-07 sd=160n sca=16.2145 \
        scb=0.0159727 scc=0.000275565 m=(1)
ends DFFSHQX2
// End of subcircuit definition.
