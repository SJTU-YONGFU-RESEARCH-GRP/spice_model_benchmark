// Generated for: spectre (May  1 09:11:46 2013 )
// Library name: gsclib045_lvt
// Cell name: AOI211X4
// View name: extracted

simulator lang=spectre

subckt AOI211X4 A0 A1 B0 C0 VDD VSS Y
mp3_1__rcx (\1\:Y C0 net82 VDD) g45p1lvt w=(3.9e-07) l=4.5e-08 nf=1 \
        as=6.045e-14 ad=6.24e-14 ps=1.09e-06 pd=1.1e-06 nrd=1.16667 \
        nrs=1.16667 sa=9.59487e-07 sb=7.55e-07 sd=160n sca=12.5232 \
        scb=0.0108581 scc=0.000412418 m=(4)
mp2_1__rcx (net82 \1\:B0 \8\:net91 VDD) g45p1lvt w=(3.9e-07) l=4.5e-08 \
        nf=1 as=6.24e-14 ad=6.04e-14 ps=1.1e-06 pd=1.09e-06 nrd=1.16667 \
        nrs=1.16667 sa=1.39487e-07 sb=1.575e-06 sd=160n sca=12.3656 \
        scb=0.0108222 scc=0.000412413 m=(4)
mp0_1__rcx (net91 A0 \3\:VDD VDD) g45p1lvt w=(3.9e-07) l=4.5e-08 nf=1 \
        as=5.914e-14 ad=6.24e-14 ps=1.1925e-06 pd=1.1e-06 nrd=1.16667 \
        nrs=1.16667 sa=1.4e-07 sb=1.535e-06 sd=160n sca=21.0705 \
        scb=0.0236471 scc=0.000934065 m=(4)
mp1_1__rcx (net91 A1 \3\:VDD VDD) g45p1lvt w=(3.9e-07) l=4.5e-08 nf=1 \
        as=6.24e-14 ad=6.24e-14 ps=1.1e-06 pd=1.1e-06 nrd=1.16667 \
        nrs=1.16667 sa=3.45e-07 sb=1.33e-06 sd=160n sca=15.0091 \
        scb=0.0134988 scc=0.00042661 m=(4)
C1 (C0 VSS) capacitor c=3.537e-16
C2 (A1 VSS) capacitor c=3.82381e-16
C3 (B0 VSS) capacitor c=2.06237e-17
C4 (Y VSS) capacitor c=1.29517e-17
C5 (VDD VSS) capacitor c=2.10804e-16
C6 (A0 VSS) capacitor c=6.37095e-16
C7 (11 VSS) capacitor c=1.7621e-18
C8 (12 VSS) capacitor c=1.7621e-18
C9 (13 VSS) capacitor c=1.7621e-18
C10 (net91 VSS) capacitor c=3.13515e-16
C11 (net82 VSS) capacitor c=3.50214e-16
C12 (\1\:B0 VSS) capacitor c=4.05906e-16
C13 (\12\:A0 VSS) capacitor c=5.82035e-17
C14 (\8\:A1 VSS) capacitor c=6.30801e-17
C15 (\11\:A1 VSS) capacitor c=5.57214e-17
C16 (\4\:A0 VSS) capacitor c=6.69829e-17
C17 (\6\:A0 VSS) capacitor c=4.79154e-17
C18 (\1\:A1 VSS) capacitor c=6.5802e-17
C19 (\4\:A1 VSS) capacitor c=4.62066e-17
C20 (\1\:A0 VSS) capacitor c=7.72677e-17
C21 (\1\:Y VSS) capacitor c=2.42865e-16
C22 (\8\:net91 VSS) capacitor c=2.03492e-16
C23 (\1\:VDD VSS) capacitor c=1.175e-16
C24 (\16\:Y VSS) capacitor c=1.23795e-16
C25 (\12\:Y VSS) capacitor c=6.14418e-17
C26 (\6\:Y VSS) capacitor c=9.86673e-17
C27 (\8\:Y VSS) capacitor c=6.95681e-17
C28 (\2\:A1 VSS) capacitor c=3.18911e-17
C29 (\9\:A1 VSS) capacitor c=3.50276e-17
C30 (\4\:Y VSS) capacitor c=1.36565e-16
C31 (\5\:Y VSS) capacitor c=6.75743e-17
C32 (\3\:VDD VSS) capacitor c=2.59681e-16
Rk6 (B0 \1\:B0) resistor r=0.03619 c=0
Rk27 (\12\:Y \16\:Y) resistor r=0.3006 c=0
Rk24 (\4\:Y Y) resistor r=0.003066 c=0
Rk19 (\1\:Y \4\:Y) resistor r=1.1187 c=0
Rk25 (\5\:Y \12\:Y) resistor r=0.05823 c=0
Rk20 (\4\:Y \5\:Y) resistor r=0.1072 c=0
Rk21 (\5\:Y \7\:Y) resistor r=0.3845 c=0
Rk22 (\7\:Y \9\:Y) resistor r=0.4656 c=0
Rk55 (\3\:VDD VDD) resistor r=0.02961 c=0
Rk49 (\2\:VDD \3\:VDD) resistor r=0.6359 c=0
Rk39 (\1\:VSS \8\:VSS) resistor r=0.2603 c=0
Rk40 (\8\:VSS \9\:VSS) resistor r=0.04989 c=0
Rk42 (\10\:VSS VSS) resistor r=0.2049 c=0
Rk41 (\9\:VSS \10\:VSS) resistor r=0.2951 c=0
Rk47 (\9\:VSS \20\:VSS) resistor r=0.1979 c=0
Rk48 (\10\:VSS \22\:VSS) resistor r=0.2024 c=0
Rk12 (net91 \8\:net91) resistor r=0.4445 c=0
Rl4 (\2\:A1 A1) resistor r=29.4415 c=0
Rl3 (\2\:A1 \1\:A1) resistor r=82.1768 c=0
Rl5 (\2\:A1 \4\:A1) resistor r=32.7557 c=0
Rl15 (\9\:A1 A1) resistor r=6.3032 c=0
Rl14 (\9\:A1 \8\:A1) resistor r=137.946 c=0
Rl16 (\9\:A1 \11\:A1) resistor r=88.5249 c=0
Rl20 (A0 \12\:A0) resistor r=41.4835 c=0
Rl9 (A0 \4\:A0) resistor r=85.3597 c=0
Rl10 (A0 \6\:A0) resistor r=39.5284 c=0
Rl1 (A0 \1\:A0) resistor r=140.362 c=0
Rz1 (\7\:Y \6\:Y) resistor r=75 c=0
Rz2 (\9\:Y \8\:Y) resistor r=75 c=0
Rz14 (\2\:VDD \1\:VDD) resistor r=10.7143 c=0
Rz15 (\3\:VDD \1\:VDD) resistor r=6.25 c=0
Rz12 (\20\:VSS \19\:VSS) resistor r=75 c=0
Rz13 (\22\:VSS \21\:VSS) resistor r=75 c=0
Ry14 (\1\:VSS \3\:VSS) resistor r=8.8571 c=0
Ry15 (\8\:VSS \3\:VSS) resistor r=5.1667 c=0
mn0_1__rcx (10 \1\:A0 \21\:VSS VSS) g45n1lvt w=(2.6e-07) l=4.5e-08 nf=1 \
        as=3.64e-14 ad=1.56e-14 ps=8e-07 pd=6.4e-07 nrd=1.16667 \
        nrs=1.16667 sa=1.4e-07 sb=2e-06 sd=160n sca=9.14564 scb=0.00759168 \
        scc=0.000213449 m=(1)
mn1_1__rcx (\8\:Y \4\:A1 10 VSS) g45n1lvt w=(2.6e-07) l=4.5e-08 nf=1 \
        as=1.56e-14 ad=4.16e-14 ps=6.4e-07 pd=8.4e-07 nrd=1.16667 \
        nrs=1.16667 sa=2.45e-07 sb=2e-06 sd=160n sca=9.14564 \
        scb=0.00759168 scc=0.000213449 m=(1)
mn1_2__rcx (\8\:Y \1\:A1 11 VSS) g45n1lvt w=(2.6e-07) l=4.5e-08 nf=1 \
        as=1.56e-14 ad=4.16e-14 ps=6.4e-07 pd=8.4e-07 nrd=1.16667 \
        nrs=1.16667 sa=4.5e-07 sb=2e-06 sd=160n sca=9.14564 scb=0.00759168 \
        scc=0.000213449 m=(1)
mn0_2__rcx (11 \6\:A0 \19\:VSS VSS) g45n1lvt w=(2.6e-07) l=4.5e-08 nf=1 \
        as=4.16e-14 ad=1.56e-14 ps=8.4e-07 pd=6.4e-07 nrd=1.16667 \
        nrs=1.16667 sa=5.55e-07 sb=2e-06 sd=160n sca=9.14564 \
        scb=0.00759168 scc=0.000213449 m=(1)
mn0_3__rcx (12 \4\:A0 \19\:VSS VSS) g45n1lvt w=(2.6e-07) l=4.5e-08 nf=1 \
        as=4.16e-14 ad=1.56e-14 ps=8.4e-07 pd=6.4e-07 nrd=1.16667 \
        nrs=1.16667 sa=7.6e-07 sb=2e-06 sd=160n sca=9.14564 scb=0.00759168 \
        scc=0.000213449 m=(1)
mn1_3__rcx (\6\:Y \11\:A1 12 VSS) g45n1lvt w=(2.6e-07) l=4.5e-08 nf=1 \
        as=1.56e-14 ad=4.16e-14 ps=6.4e-07 pd=8.4e-07 nrd=1.16667 \
        nrs=1.16667 sa=8.65e-07 sb=2e-06 sd=160n sca=9.14564 \
        scb=0.00759168 scc=0.000213449 m=(1)
mn1 (\6\:Y \8\:A1 13 VSS) g45n1lvt w=(2.6e-07) l=4.5e-08 nf=1 as=1.56e-14 \
        ad=4.16e-14 ps=6.4e-07 pd=8.4e-07 nrd=1.16667 nrs=1.16667 \
        sa=1.07e-06 sb=2e-06 sd=160n sca=9.14564 scb=0.00759168 \
        scc=0.000213449 m=(1)
mn0 (13 \12\:A0 \1\:VSS VSS) g45n1lvt w=(2.6e-07) l=4.5e-08 nf=1 \
        as=5.2e-14 ad=1.56e-14 ps=9.2e-07 pd=6.4e-07 nrd=1.16667 \
        nrs=1.16667 sa=1.175e-06 sb=1.95e-06 sd=160n sca=9.14564 \
        scb=0.00759168 scc=0.000213449 m=(1)
mn3_1__rcx (\16\:Y C0 \1\:VSS VSS) g45n1lvt w=(2.6e-07) l=4.5e-08 nf=1 \
        as=4.582e-14 ad=4.16e-14 ps=8.725e-07 pd=8.4e-07 nrd=1.16667 \
        nrs=1.16667 sa=2e-06 sb=7.85e-07 sd=160n sca=9.14564 \
        scb=0.00759168 scc=0.000213449 m=(4)
mn2_1__rcx (\12\:Y \1\:B0 \1\:VSS VSS) g45n1lvt w=(2.6e-07) l=4.5e-08 \
        nf=1 as=5.492e-14 ad=4.225e-14 ps=9.425e-07 pd=8.45e-07 \
        nrd=1.16667 nrs=1.16667 sa=1.42e-06 sb=1.705e-06 sd=160n \
        sca=9.14564 scb=0.00759168 scc=0.000213449 m=(4)
ends AOI211X4
// End of subcircuit definition.
