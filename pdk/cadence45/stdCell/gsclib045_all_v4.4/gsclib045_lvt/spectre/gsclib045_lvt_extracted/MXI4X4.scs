// Generated for: spectre (May  1 09:16:23 2013 )
// Library name: gsclib045_lvt
// Cell name: MXI4X4
// View name: extracted

simulator lang=spectre

subckt MXI4X4 A B C D S0 S1 VDD VSS Y
mp0 (\15\:S0b \1\:S0 \21\:VDD VDD) g45p1lvt w=(2.15e-07) l=4.5e-08 nf=1 \
        as=3.44e-14 ad=3.01e-14 ps=7.5e-07 pd=7.1e-07 nrd=1.16667 \
        nrs=1.16667 sa=1.4e-07 sb=1.9686e-06 sd=160n sca=15.5268 \
        scb=0.0147861 scc=0.000216306 m=(1)
mp2 (net296 \1\:A \21\:VDD VDD) g45p1lvt w=(2.15e-07) l=4.5e-08 nf=1 \
        as=3.44e-14 ad=6.45e-14 ps=7.5e-07 pd=1.03e-06 nrd=1.16667 \
        nrs=1.16667 sa=3.45e-07 sb=1.96384e-06 sd=160n sca=11.9362 \
        scb=0.00875484 scc=7.61791e-05 m=(1)
mp3 (\5\:n0 \7\:S0 net296 VDD) g45p1lvt w=(2.15e-07) l=4.5e-08 nf=1 \
        as=6.45e-14 ad=5.875e-14 ps=1.03e-06 pd=9.9e-07 nrd=1.16667 \
        nrs=1.16667 sa=6.9e-07 sb=1.74093e-06 sd=160n sca=10.2921 \
        scb=0.00736325 scc=7.25636e-05 m=(1)
mp5 (\5\:n0 \3\:S0b net304 VDD) g45p1lvt w=(2.15e-07) l=4.5e-08 nf=1 \
        as=3.118e-14 ad=5.875e-14 ps=7.2e-07 pd=9.9e-07 nrd=1.16667 \
        nrs=1.16667 sa=9.88837e-07 sb=1.53953e-06 sd=160n sca=10.1453 \
        scb=0.00734814 scc=7.36798e-05 m=(1)
mp4 (net304 \3\:B \19\:VDD VDD) g45p1lvt w=(2.15e-07) l=4.5e-08 nf=1 \
        as=8.117e-14 ad=3.117e-14 ps=1.3e-06 pd=7.2e-07 nrd=1.16667 \
        nrs=1.16667 sa=1.17884e-06 sb=1.39372e-06 sd=160n sca=10.1453 \
        scb=0.00734814 scc=7.36798e-05 m=(1)
mp6 (net312 \1\:C \19\:VDD VDD) g45p1lvt w=(2.15e-07) l=4.5e-08 nf=1 \
        as=8.117e-14 ad=1.505e-14 ps=1.3e-06 pd=5.7e-07 nrd=1.16667 \
        nrs=1.16667 sa=1.52884e-06 sb=1.12512e-06 sd=160n sca=10.1453 \
        scb=0.00734814 scc=7.36798e-05 m=(1)
mp7 (\6\:n1 \8\:S0 net312 VDD) g45p1lvt w=(2.15e-07) l=4.5e-08 nf=1 \
        as=1.505e-14 ad=3.44e-14 ps=5.7e-07 pd=7.5e-07 nrd=1.16667 \
        nrs=1.16667 sa=1.64384e-06 sb=1.03686e-06 sd=160n sca=10.1453 \
        scb=0.00734814 scc=7.36798e-05 m=(1)
mp9 (\6\:n1 \5\:S0b net320 VDD) g45p1lvt w=(2.15e-07) l=4.5e-08 nf=1 \
        as=6.988e-14 ad=3.44e-14 ps=1.08e-06 pd=7.5e-07 nrd=1.16667 \
        nrs=1.16667 sa=1.84884e-06 sb=8.79535e-07 sd=160n sca=10.1453 \
        scb=0.00734814 scc=7.36798e-05 m=(1)
mp8 (net320 \1\:D \17\:VDD VDD) g45p1lvt w=(2.15e-07) l=4.5e-08 nf=1 \
        as=8.215e-14 ad=6.988e-14 ps=1.71e-06 pd=1.08e-06 nrd=1.16667 \
        nrs=1.16667 sa=1.98442e-06 sb=5.95581e-07 sd=160n sca=10.1453 \
        scb=0.00734814 scc=7.36798e-05 m=(1)
mp1 (\5\:S1b \5\:S1 \3\:VDD VDD) g45p1lvt w=(2.15e-07) l=4.5e-08 nf=1 \
        as=1.3438e-13 ad=3.01e-14 ps=1.83e-06 pd=7.1e-07 nrd=1.16667 \
        nrs=1.16667 sa=2e-06 sb=1.4e-07 sd=160n sca=29.3395 scb=0.0284356 \
        scc=0.00289177 m=(1)
C1 (C VSS) capacitor c=1.30527e-16
C2 (S1 VSS) capacitor c=1.79584e-17
C3 (B VSS) capacitor c=1.1154e-16
C4 (S0 VSS) capacitor c=1.07769e-16
C5 (Y VSS) capacitor c=3.85591e-16
C6 (VDD VSS) capacitor c=3.45412e-16
C7 (S0b VSS) capacitor c=6.57292e-17
C8 (n0 VSS) capacitor c=4.03626e-17
C9 (net361 VSS) capacitor c=9.03112e-19
C10 (n1 VSS) capacitor c=5.4593e-17
C11 (net377 VSS) capacitor c=5.06927e-18
C12 (net329 VSS) capacitor c=2.28165e-18
C13 (n2 VSS) capacitor c=3.08504e-16
C14 (S1b VSS) capacitor c=3.96832e-17
C15 (net345 VSS) capacitor c=3.53517e-18
C16 (net304 VSS) capacitor c=3.79836e-18
C17 (net312 VSS) capacitor c=1.37987e-18
C18 (net320 VSS) capacitor c=9.18287e-18
C19 (net280 VSS) capacitor c=4.85195e-18
C20 (net284 VSS) capacitor c=7.74883e-18
C21 (\5\:S1 VSS) capacitor c=2.11617e-17
C22 (\3\:S1b VSS) capacitor c=3.10508e-17
C23 (\4\:S1 VSS) capacitor c=2.61166e-17
C24 (\1\:D VSS) capacitor c=2.89429e-17
C25 (\5\:S0b VSS) capacitor c=6.68372e-17
C26 (\8\:S0 VSS) capacitor c=6.15482e-17
C27 (\1\:C VSS) capacitor c=5.57462e-17
C28 (\3\:B VSS) capacitor c=4.42859e-17
C29 (\3\:S0b VSS) capacitor c=4.26035e-17
C30 (\7\:S0 VSS) capacitor c=3.99617e-17
C31 (\1\:A VSS) capacitor c=3.56921e-17
C32 (\1\:S0 VSS) capacitor c=4.36244e-17
C33 (\8\:S1 VSS) capacitor c=3.61249e-17
C34 (\3\:n1 VSS) capacitor c=2.66793e-17
C35 (\1\:S1 VSS) capacitor c=5.75278e-17
C36 (\3\:n0 VSS) capacitor c=4.71229e-17
C37 (\3\:D VSS) capacitor c=5.59132e-17
C38 (\10\:S0 VSS) capacitor c=4.59616e-17
C39 (\6\:S0b VSS) capacitor c=8.0519e-17
C40 (\3\:C VSS) capacitor c=7.24446e-17
C41 (\1\:B VSS) capacitor c=7.98744e-17
C42 (\4\:S0 VSS) capacitor c=2.90116e-17
C43 (\3\:A VSS) capacitor c=8.58798e-17
C44 (\3\:S0 VSS) capacitor c=4.10533e-17
C45 (\7\:S1 VSS) capacitor c=1.69661e-17
C46 (\8\:n2 VSS) capacitor c=1.91023e-17
C47 (\2\:n1 VSS) capacitor c=4.43775e-17
C48 (\4\:S1b VSS) capacitor c=3.3087e-17
C49 (\2\:S1b VSS) capacitor c=5.92797e-17
C50 (\3\:S1 VSS) capacitor c=3.47474e-17
C51 (\2\:n0 VSS) capacitor c=4.73311e-17
C52 (\2\:D VSS) capacitor c=4.19812e-17
C53 (\11\:S0 VSS) capacitor c=3.81858e-17
C54 (\9\:S0 VSS) capacitor c=4.86572e-17
C55 (\7\:S0b VSS) capacitor c=3.47051e-17
C56 (\2\:C VSS) capacitor c=6.10283e-17
C57 (\2\:B VSS) capacitor c=5.83685e-17
C58 (\5\:S0 VSS) capacitor c=6.21095e-17
C59 (\4\:S0b VSS) capacitor c=4.32816e-17
C60 (\6\:S0 VSS) capacitor c=5.23097e-17
C61 (\2\:S0b VSS) capacitor c=2.59252e-17
C62 (\2\:A VSS) capacitor c=5.94505e-17
C63 (\2\:S0 VSS) capacitor c=5.31097e-17
C64 (\5\:S1b VSS) capacitor c=2.60694e-17
C65 (\20\:n2 VSS) capacitor c=1.93384e-16
C66 (\17\:VDD VSS) capacitor c=2.97481e-17
C67 (\6\:n1 VSS) capacitor c=9.32785e-17
C68 (\19\:VDD VSS) capacitor c=3.5412e-17
C69 (\5\:n0 VSS) capacitor c=2.37567e-16
C70 (\21\:VDD VSS) capacitor c=2.84276e-17
C71 (\15\:S0b VSS) capacitor c=6.84063e-17
C72 (\1\:VDD VSS) capacitor c=6.8555e-17
C73 (\10\:S1b VSS) capacitor c=1.91661e-17
C74 (\17\:n2 VSS) capacitor c=1.08085e-16
C75 (\8\:n1 VSS) capacitor c=4.28016e-17
C76 (\7\:n0 VSS) capacitor c=1.23769e-16
C77 (\12\:S0b VSS) capacitor c=1.78552e-17
C78 (\2\:S1 VSS) capacitor c=5.63965e-17
C79 (\6\:S1 VSS) capacitor c=1.81264e-17
C80 (\4\:A VSS) capacitor c=4.14106e-17
C81 (\6\:A VSS) capacitor c=3.32526e-17
C82 (\12\:S0 VSS) capacitor c=8.31967e-17
C83 (\8\:S0b VSS) capacitor c=7.57435e-17
C84 (\9\:S0b VSS) capacitor c=1.38995e-16
C85 (\10\:S0b VSS) capacitor c=1.0002e-16
C86 (\11\:S0b VSS) capacitor c=1.155e-16
C87 (\14\:S0b VSS) capacitor c=7.27443e-17
C88 (\14\:S0 VSS) capacitor c=4.83079e-17
C89 (\15\:S0 VSS) capacitor c=6.87463e-17
C90 (\16\:S0 VSS) capacitor c=5.12109e-17
C91 (\17\:S0 VSS) capacitor c=5.56038e-17
C92 (\4\:D VSS) capacitor c=1.22401e-16
C93 (\4\:n0 VSS) capacitor c=2.4392e-16
C94 (\4\:n1 VSS) capacitor c=1.75228e-16
C95 (\5\:n1 VSS) capacitor c=2.39831e-16
C96 (\16\:n2 VSS) capacitor c=1.17641e-16
C97 (\19\:n2 VSS) capacitor c=1.75648e-16
C98 (\9\:S1 VSS) capacitor c=2.12928e-17
C99 (\10\:S1 VSS) capacitor c=2.38739e-16
C100 (\11\:S1 VSS) capacitor c=2.52861e-16
C101 (\7\:S1b VSS) capacitor c=3.33503e-16
C102 (\8\:S1b VSS) capacitor c=3.62456e-16
C103 (\9\:S1b VSS) capacitor c=4.83038e-17
C104 (\3\:VDD VSS) capacitor c=1.36423e-16
C105 (\7\:VDD VSS) capacitor c=5.47212e-17
C106 (\8\:VDD VSS) capacitor c=3.46913e-17
C107 (\10\:VDD VSS) capacitor c=1.57277e-17
Rk38 (\2\:VSS \3\:VSS) resistor r=0.03493 c=0
Rk41 (\3\:VSS \6\:VSS) resistor r=0.0851 c=0
Rk42 (\6\:VSS \7\:VSS) resistor r=0.5316 c=0
Rk43 (\7\:VSS \8\:VSS) resistor r=0.4537 c=0
Rk44 (\8\:VSS \9\:VSS) resistor r=0.2181 c=0
Rk46 (\10\:VSS VSS) resistor r=0.1551 c=0
Rk45 (\9\:VSS \10\:VSS) resistor r=0.3962 c=0
Rk50 (\7\:VSS \18\:VSS) resistor r=0.2704 c=0
Rk51 (\8\:VSS \20\:VSS) resistor r=0.07416 c=0
Rk52 (\10\:VSS \22\:VSS) resistor r=0.2425 c=0
Rk7 (\4\:C C) resistor r=0.002443 c=0
Rk33 (\10\:S1 S1) resistor r=0.02569 c=0
Rk31 (\9\:S1 \10\:S1) resistor r=0.1493 c=0
Rk32 (\10\:S1 \11\:S1) resistor r=2.0957 c=0
Rk17 (D \4\:D) resistor r=0.006814 c=0
Rk6 (B \4\:B) resistor r=0.003983 c=0
Rk5 (\13\:S0 S0) resistor r=0.003006 c=0
Rk4 (\12\:S0 \13\:S0) resistor r=0.4711 c=0
Rk14 (\14\:S0 \15\:S0) resistor r=0.2491 c=0
Rk15 (\15\:S0 \16\:S0) resistor r=0.3712 c=0
Rk16 (\15\:S0 \17\:S0) resistor r=0.2689 c=0
Rk1 (\4\:A \5\:A) resistor r=0.001415 c=0
Rk2 (A \6\:A) resistor r=0.001321 c=0
Rk3 (\4\:A \6\:A) resistor r=0.0301 c=0
Rk53 (\2\:VDD \3\:VDD) resistor r=0.193 c=0
Rk56 (\3\:VDD \6\:VDD) resistor r=0.05154 c=0
Rk57 (\6\:VDD \7\:VDD) resistor r=0.5316 c=0
Rk58 (\7\:VDD \8\:VDD) resistor r=0.5214 c=0
Rk59 (\8\:VDD \9\:VDD) resistor r=0.1503 c=0
Rk61 (\10\:VDD VDD) resistor r=0.1701 c=0
Rk60 (\9\:VDD \10\:VDD) resistor r=0.3811 c=0
Rk65 (\7\:VDD \18\:VDD) resistor r=0.123 c=0
Rk66 (\8\:VDD \20\:VDD) resistor r=0.123 c=0
Rk67 (\10\:VDD \22\:VDD) resistor r=0.2115 c=0
Rk8 (\8\:S0b \9\:S0b) resistor r=0.5022 c=0
Rk9 (\9\:S0b \10\:S0b) resistor r=0.4435 c=0
Rk10 (\10\:S0b \11\:S0b) resistor r=0.5528 c=0
Rk11 (\11\:S0b \13\:S0b) resistor r=0.07531 c=0
Rk12 (\9\:S0b \14\:S0b) resistor r=0.4543 c=0
Rk13 (\11\:S0b \16\:S0b) resistor r=0.647 c=0
Rk18 (\4\:n0 \6\:n0) resistor r=1.7103 c=0
Rk19 (\6\:n0 \8\:n0) resistor r=0.6765 c=0
Rk20 (\4\:n1 \5\:n1) resistor r=1.4011 c=0
Rk21 (\5\:n1 \7\:n1) resistor r=0.7032 c=0
Rk22 (\5\:n1 \9\:n1) resistor r=0.3068 c=0
Rk23 (\16\:n2 \18\:n2) resistor r=0.7155 c=0
Rk24 (\19\:n2 \21\:n2) resistor r=1.207 c=0
Rk34 (\6\:S1b \7\:S1b) resistor r=0.2934 c=0
Rk35 (\7\:S1b \8\:S1b) resistor r=2.7243 c=0
Rk36 (\8\:S1b \9\:S1b) resistor r=0.2807 c=0
Rk37 (\7\:S1b \11\:S1b) resistor r=0.124 c=0
Rl12 (\1\:C \2\:C) resistor r=50.6918 c=0
Rl13 (\2\:C \3\:C) resistor r=189.153 c=0
Rl25 (\2\:S1 \4\:S1) resistor r=32.3738 c=0
Rl23 (\1\:S1 \2\:S1) resistor r=176.901 c=0
Rl24 (\2\:S1 \3\:S1) resistor r=35.0048 c=0
Rl43 (\5\:S1 \6\:S1) resistor r=37.3411 c=0
Rl45 (\6\:S1 \8\:S1) resistor r=129.649 c=0
Rl44 (\6\:S1 \7\:S1) resistor r=5.013 c=0
Rl18 (\1\:D \2\:D) resistor r=49.2328 c=0
Rl19 (\2\:D \3\:D) resistor r=187.694 c=0
Rl11 (\2\:B \3\:B) resistor r=76.9003 c=0
Rl10 (\1\:B \2\:B) resistor r=197.872 c=0
Rl17 (\10\:S0 \11\:S0) resistor r=44.9225 c=0
Rl14 (\8\:S0 \9\:S0) resistor r=71.8456 c=0
Rl7 (\4\:S0 \5\:S0) resistor r=24.7951 c=0
Rl9 (\6\:S0 \7\:S0) resistor r=109.41 c=0
Rl8 (\5\:S0 \6\:S0) resistor r=232.647 c=0
Rl1 (\1\:S0 \2\:S0) resistor r=125.692 c=0
Rl2 (\2\:S0 \3\:S0) resistor r=129.538 c=0
Rl3 (\1\:A \2\:A) resistor r=73.7687 c=0
Rl4 (\2\:A \3\:A) resistor r=181.461 c=0
Rl15 (\5\:S0b \6\:S0b) resistor r=283.747 c=0
Rl16 (\6\:S0b \7\:S0b) resistor r=24.2328 c=0
Rl6 (\3\:S0b \4\:S0b) resistor r=71.8456 c=0
Rl5 (S0b \2\:S0b) resistor r=31.9251 c=0
Rl20 (n0 \2\:n0) resistor r=29.5379 c=0
Rl21 (\2\:n0 \3\:n0) resistor r=110.307 c=0
Rl27 (n1 \2\:n1) resistor r=112.694 c=0
Rl28 (\2\:n1 \3\:n1) resistor r=78.4003 c=0
Rl35 (\8\:n2 n2) resistor r=10.9879 c=0
Rl26 (\3\:S1b \4\:S1b) resistor r=35.3072 c=0
Rl22 (S1b \2\:S1b) resistor r=61.5157 c=0
Rz11 (\18\:VSS \17\:VSS) resistor r=75 c=0
Rz12 (\20\:VSS \19\:VSS) resistor r=75 c=0
Rz13 (\22\:VSS \21\:VSS) resistor r=75 c=0
Rz14 (\2\:VDD \1\:VDD) resistor r=18.75 c=0
Rz15 (\6\:VDD \1\:VDD) resistor r=6.25 c=0
Rz16 (\9\:VDD \1\:VDD) resistor r=6.25 c=0
Rz1 (\12\:S0b \13\:S0b) resistor r=75 c=0
Rz2 (\7\:n0 \8\:n0) resistor r=75 c=0
Rz3 (\8\:n1 \9\:n1) resistor r=75 c=0
Rz4 (\18\:n2 \17\:n2) resistor r=75 c=0
Rz7 (\10\:S1b \11\:S1b) resistor r=75 c=0
Ry8 (\2\:VSS \1\:VSS) resistor r=15.5 c=0
Ry9 (\6\:VSS \1\:VSS) resistor r=5.1667 c=0
Ry10 (\9\:VSS \1\:VSS) resistor r=5.1667 c=0
Ry14 (\18\:VDD \17\:VDD) resistor r=62 c=0
Ry15 (\20\:VDD \19\:VDD) resistor r=62 c=0
Ry16 (\22\:VDD \21\:VDD) resistor r=62 c=0
Ry1 (\15\:S0b \16\:S0b) resistor r=62 c=0
Ry2 (\5\:n0 \6\:n0) resistor r=62 c=0
Ry3 (\6\:n1 \7\:n1) resistor r=62 c=0
Ry4 (\21\:n2 \20\:n2) resistor r=62 c=0
Ry7 (\5\:S1b \6\:S1b) resistor r=62 c=0
Rx5 (\2\:C \4\:C) resistor r=45 c=0
Rx17 (\7\:S1 \9\:S1) resistor r=45 c=0
Rx18 (\3\:S1 \11\:S1) resistor r=45 c=0
Rx12 (\2\:D \4\:D) resistor r=45 c=0
Rx4 (\2\:B \4\:B) resistor r=45 c=0
Rx2 (\6\:S0 \12\:S0) resistor r=45 c=0
Rx3 (\2\:S0 \13\:S0) resistor r=45 c=0
Rx9 (\11\:S0 \14\:S0) resistor r=45 c=0
Rx10 (\5\:S0 \16\:S0) resistor r=45 c=0
Rx11 (\9\:S0 \17\:S0) resistor r=45 c=0
Rx1 (\2\:A \5\:A) resistor r=45 c=0
Rx6 (\7\:S0b \8\:S0b) resistor r=45 c=0
Rx7 (\2\:S0b \10\:S0b) resistor r=45 c=0
Rx8 (\4\:S0b \14\:S0b) resistor r=45 c=0
Rx13 (\2\:n0 \4\:n0) resistor r=45 c=0
Rx14 (\2\:n1 \4\:n1) resistor r=45 c=0
Rx15 (\16\:n2 \8\:n2) resistor r=45 c=0
Rx16 (\19\:n2 n2) resistor r=45 c=0
Rx19 (\4\:S1b \8\:S1b) resistor r=45 c=0
Rx20 (\2\:S1b \9\:S1b) resistor r=45 c=0
mn0 (\12\:S0b \3\:S0 \21\:VSS VSS) g45n1lvt w=(1.45e-07) l=4.5e-08 nf=1 \
        as=2.32e-14 ad=2.03e-14 ps=6.1e-07 pd=5.7e-07 nrd=1.16667 \
        nrs=1.16667 sa=1.4e-07 sb=1.82259e-06 sd=160n sca=8.85152 \
        scb=0.00706865 scc=0.000138481 m=(1)
mn2 (net349 \3\:A \21\:VSS VSS) g45n1lvt w=(1.45e-07) l=4.5e-08 nf=1 \
        as=2.32e-14 ad=8.7e-15 ps=6.1e-07 pd=4.1e-07 nrd=1.16667 \
        nrs=1.16667 sa=3.45e-07 sb=1.7731e-06 sd=160n sca=8.85152 \
        scb=0.00706865 scc=0.000138481 m=(1)
mn3 (\7\:n0 S0b net349 VSS) g45n1lvt w=(1.45e-07) l=4.5e-08 nf=1 \
        as=8.7e-15 ad=9.425e-14 ps=4.1e-07 pd=1.59e-06 nrd=1.16667 \
        nrs=1.16667 sa=4.5e-07 sb=1.74776e-06 sd=160n sca=8.85152 \
        scb=0.00706865 scc=0.000138481 m=(1)
mn5 (\7\:n0 \4\:S0 net361 VSS) g45n1lvt w=(1.45e-07) l=4.5e-08 nf=1 \
        as=1.668e-14 ad=9.425e-14 ps=5.2e-07 pd=1.59e-06 nrd=1.16667 \
        nrs=1.16667 sa=1.145e-06 sb=1.58e-06 sd=160n sca=8.85152 \
        scb=0.00706865 scc=0.000138481 m=(1)
mn4 (net361 \1\:B \19\:VSS VSS) g45n1lvt w=(1.45e-07) l=4.5e-08 nf=1 \
        as=5.015e-14 ad=1.667e-14 ps=1.41e-06 pd=5.2e-07 nrd=1.16667 \
        nrs=1.16667 sa=1.305e-06 sb=1.54138e-06 sd=160n sca=8.85152 \
        scb=0.00706865 scc=0.000138481 m=(1)
mn6 (net369 \3\:C \19\:VSS VSS) g45n1lvt w=(1.45e-07) l=4.5e-08 nf=1 \
        as=5.015e-14 ad=1.957e-14 ps=1.41e-06 pd=5.6e-07 nrd=1.16667 \
        nrs=1.16667 sa=1.2e-06 sb=2e-06 sd=160n sca=10.0732 scb=0.00911402 \
        scc=0.000253284 m=(1)
mn7 (\8\:n1 \6\:S0b net369 VSS) g45n1lvt w=(1.45e-07) l=4.5e-08 nf=1 \
        as=1.957e-14 ad=3.045e-14 ps=5.6e-07 pd=7.1e-07 nrd=1.16667 \
        nrs=1.16667 sa=1.38e-06 sb=2e-06 sd=160n sca=10.0732 \
        scb=0.00911402 scc=0.000253284 m=(1)
mn9 (\8\:n1 \10\:S0 net377 VSS) g45n1lvt w=(1.45e-07) l=4.5e-08 nf=1 \
        as=3.045e-14 ad=3.045e-14 ps=7.1e-07 pd=7.1e-07 nrd=1.16667 \
        nrs=1.16667 sa=1.635e-06 sb=1.97103e-06 sd=160n sca=10.0732 \
        scb=0.00911402 scc=0.000253284 m=(1)
mn8 (net377 \3\:D \17\:VSS VSS) g45n1lvt w=(1.45e-07) l=4.5e-08 nf=1 \
        as=4.225e-14 ad=3.045e-14 ps=9.1e-07 pd=7.1e-07 nrd=1.16667 \
        nrs=1.16667 sa=1.70793e-06 sb=1.93586e-06 sd=160n sca=10.0732 \
        scb=0.00911402 scc=0.000253284 m=(1)
mn1 (\10\:S1b \8\:S1 \3\:VSS VSS) g45n1lvt w=(1.45e-07) l=4.5e-08 nf=1 \
        as=5.137e-14 ad=2.03e-14 ps=1.07e-06 pd=5.7e-07 nrd=1.16667 \
        nrs=1.16667 sa=2e-06 sb=1.4e-07 sd=160n sca=9.33388 scb=0.00788941 \
        scc=0.00017958 m=(1)
mn10 (net329 \3\:n0 \17\:VSS VSS) g45n1lvt w=(2.05e-07) l=4.5e-08 nf=1 \
        as=4.225e-14 ad=3.588e-14 ps=9.1e-07 pd=7.6e-07 nrd=1.16667 \
        nrs=1.16667 sa=1.28768e-06 sb=1.92585e-06 sd=160n sca=9.17255 \
        scb=0.0076374 scc=0.000189126 m=(1)
mn11 (\17\:n2 S1b net329 VSS) g45n1lvt w=(2.05e-07) l=4.5e-08 nf=1 \
        as=3.588e-14 ad=3.28e-14 ps=7.6e-07 pd=7.3e-07 nrd=1.16667 \
        nrs=1.16667 sa=1.38963e-06 sb=1.90439e-06 sd=160n sca=9.17255 \
        scb=0.0076374 scc=0.000189126 m=(1)
mn13 (\17\:n2 \1\:S1 net345 VSS) g45n1lvt w=(2.05e-07) l=4.5e-08 nf=1 \
        as=5.432e-14 ad=3.28e-14 ps=9.4e-07 pd=7.3e-07 nrd=1.16667 \
        nrs=1.16667 sa=1.48463e-06 sb=1.8561e-06 sd=160n sca=9.17255 \
        scb=0.0076374 scc=0.000189126 m=(1)
mn12 (net345 \3\:n1 \3\:VSS VSS) g45n1lvt w=(2.05e-07) l=4.5e-08 nf=1 \
        as=7.93e-14 ad=5.432e-14 ps=1.24e-06 pd=9.4e-07 nrd=1.16667 \
        nrs=1.16667 sa=1.62829e-06 sb=1.69817e-06 sd=160n sca=9.17255 \
        scb=0.0076374 scc=0.000189126 m=(1)
mn14_1__rcx (Y n2 \3\:VSS VSS) g45n1lvt w=(2.6e-07) l=4.5e-08 nf=1 \
        as=8.077e-14 ad=6.78e-14 ps=1.2075e-06 pd=1.075e-06 nrd=1.16667 \
        nrs=1.16667 sa=1.42269e-06 sb=1.26077e-06 sd=160n sca=8.51051 \
        scb=0.00656948 scc=0.000151659 m=(4)
mp10 (net280 n0 \17\:VDD VDD) g45p1lvt w=(3.1e-07) l=4.5e-08 nf=1 \
        as=8.215e-14 ad=6.82e-14 ps=1.71e-06 pd=1.06e-06 nrd=1.16667 \
        nrs=1.16667 sa=4.00403e-07 sb=2e-06 sd=160n sca=22.2698 \
        scb=0.0192893 scc=0.0023049 m=(1)
mp11 (\20\:n2 \4\:S1 net280 VDD) g45p1lvt w=(3.1e-07) l=4.5e-08 nf=1 \
        as=6.82e-14 ad=8.525e-14 ps=1.06e-06 pd=1.17e-06 nrd=1.16667 \
        nrs=1.16667 sa=6.26935e-07 sb=1.9625e-06 sd=160n sca=22.2698 \
        scb=0.0192893 scc=0.0023049 m=(1)
mp13 (\20\:n2 \3\:S1b net284 VDD) g45p1lvt w=(3.1e-07) l=4.5e-08 nf=1 \
        as=6.51e-14 ad=8.525e-14 ps=1.04e-06 pd=1.17e-06 nrd=1.16667 \
        nrs=1.16667 sa=8.97097e-07 sb=1.86444e-06 sd=160n sca=22.2698 \
        scb=0.0192893 scc=0.0023049 m=(1)
mp12 (net284 n1 \3\:VDD VDD) g45p1lvt w=(3.1e-07) l=4.5e-08 nf=1 \
        as=1.892e-13 ad=6.51e-14 ps=2.29e-06 pd=1.04e-06 nrd=1.16667 \
        nrs=1.16667 sa=1.11097e-06 sb=1.64758e-06 sd=160n sca=22.2698 \
        scb=0.0192893 scc=0.0023049 m=(1)
mp14_1__rcx (Y n2 \3\:VDD VDD) g45p1lvt w=(3.9e-07) l=4.5e-08 nf=1 \
        as=1.4389e-13 ad=6.24e-14 ps=1.975e-06 pd=1.1e-06 nrd=1.16667 \
        nrs=1.16667 sa=1.24128e-06 sb=1.10615e-06 sd=160n sca=28.7024 \
        scb=0.0198217 scc=0.00315848 m=(4)
ends MXI4X4
// End of subcircuit definition.
