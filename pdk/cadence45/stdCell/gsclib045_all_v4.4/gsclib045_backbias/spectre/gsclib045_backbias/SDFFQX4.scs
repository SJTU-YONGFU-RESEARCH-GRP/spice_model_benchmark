// gsclib045_backbias/SDFFQX4/schematic

simulator lang=spectre

subckt SDFFQX4 CK D Q SE SI NW VDD VSS
mn13 (n3 SI VSS VSS) g45n1svt w=(145n) l=45n nf=1 m=(1)
mn14 (Db SE n3 VSS) g45n1svt w=(145n) l=45n nf=1 m=(1)
mn12 (Db SEb n1 VSS) g45n1svt w=(145n) l=45n nf=1 m=(1)
mn11 (n1 D VSS VSS) g45n1svt w=(145n) l=45n nf=1 m=(1)
mn55 (Q qbint VSS VSS) g45n1svt w=(1.04u) l=45n nf=1 m=(1)
mn50 (n7 qbint VSS VSS) g45n1svt w=(145n) l=45n nf=1 m=(1)
mn10 (SEb SE VSS VSS) g45n1svt w=(145n) l=45n nf=1 m=(1)
mn40 (mout CKbb n30 VSS) g45n1svt w=(145n) l=45n nf=1 m=(1)
mn35 (n20 CKbb n5 VSS) g45n1svt w=(145n) l=45n nf=1 m=(1)
mn36 (n5 mout VSS VSS) g45n1svt w=(145n) l=45n nf=1 m=(1)
mn20 (CKb CK VSS VSS) g45n1svt w=(145n) l=45n nf=1 m=(1)
mn51 (n30 CKb n7 VSS) g45n1svt w=(145n) l=45n nf=1 m=(1)
mn21 (CKbb CKb VSS VSS) g45n1svt w=(145n) l=45n nf=1 m=(1)
mn45 (qbint n30 VSS VSS) g45n1svt w=(410n) l=45n nf=1 m=(1)
mn25 (Db CKb n20 VSS) g45n1svt w=(145n) l=45n nf=1 m=(1)
mn30 (mout n20 VSS VSS) g45n1svt w=(145n) l=45n nf=1 m=(1)
mp14 (Db SEb n4 NW) g45p1svt w=(215n) l=45n nf=1 m=(1)
mp13 (n4 SI VDD NW) g45p1svt w=(215n) l=45n nf=1 m=(1)
mp12 (Db SE n2 NW) g45p1svt w=(215n) l=45n nf=1 m=(1)
mp11 (n2 D VDD NW) g45p1svt w=(215n) l=45n nf=1 m=(1)
mp51 (n30 CKbb n8 NW) g45p1svt w=(215n) l=45n nf=1 m=(1)
mp50 (n8 qbint VDD NW) g45p1svt w=(215n) l=45n nf=1 m=(1)
mp55 (Q qbint VDD NW) g45p1svt w=(1.56u) l=45n nf=1 m=(1)
mp35 (n6 mout VDD NW) g45p1svt w=(215n) l=45n nf=1 m=(1)
mp25 (n20 CKbb Db NW) g45p1svt w=(215n) l=45n nf=1 m=(1)
mp21 (CKbb CKb VDD NW) g45p1svt w=(215n) l=45n nf=1 m=(1)
mp30 (mout n20 VDD NW) g45p1svt w=(215n) l=45n nf=1 m=(1)
mp36 (n20 CKb n6 NW) g45p1svt w=(215n) l=45n nf=1 m=(1)
mp40 (n30 CKb mout NW) g45p1svt w=(215n) l=45n nf=1 m=(1)
mp10 (SEb SE VDD NW) g45p1svt w=(215n) l=45n nf=1 m=(1)
mp45 (qbint n30 VDD NW) g45p1svt w=(620n) l=45n nf=1 m=(1)
mp20 (CKb CK VDD NW) g45p1svt w=(215n) l=45n nf=1 m=(1)
ends SDFFQX4
