// gsclib045_backbias/NAND3BX4/schematic

simulator lang=spectre

subckt NAND3BX4 AN B C Y VDD VSS NW
mn3 (Y C n1 VSS) g45n1svt w=(1.04u) l=45n nf=1 m=(1)
mn0 (n0 AN VSS VSS) g45n1svt w=(260n) l=45n nf=1 m=(1)
mn2 (n1 B n2 VSS) g45n1svt w=(1.04u) l=45n nf=1 m=(1)
mn1 (n2 n0 VSS VSS) g45n1svt w=(1.04u) l=45n nf=1 m=(1)
mp1 (Y n0 VDD NW) g45p1svt w=(1.56u) l=45n nf=1 m=(1)
mp3 (Y C VDD NW) g45p1svt w=(1.56u) l=45n nf=1 m=(1)
mp0 (n0 AN VDD NW) g45p1svt w=(390n) l=45n nf=1 m=(1)
mp2 (Y B VDD NW) g45p1svt w=(1.56u) l=45n nf=1 m=(1)
ends NAND3BX4
