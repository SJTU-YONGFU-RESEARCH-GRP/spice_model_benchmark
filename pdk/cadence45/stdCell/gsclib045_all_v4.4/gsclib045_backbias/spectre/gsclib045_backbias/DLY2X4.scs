// gsclib045_backbias/DLY2X4/schematic

simulator lang=spectre

subckt DLY2X4 A Y VDD NW VSS
mn6 (n3 VDD n10 VSS) g45n1svt w=(145n) l=45n nf=1 m=(1)
mn5 (n10 n2 VSS VSS) g45n1svt w=(145n) l=45n nf=1 m=(1)
mn8 (Y n4 VSS VSS) g45n1svt w=(1.04u) l=45n nf=1 m=(1)
mn4 (n2 VDD n8 VSS) g45n1svt w=(145n) l=45n nf=1 m=(1)
mn3 (n8 n1 VSS VSS) g45n1svt w=(145n) l=45n nf=1 m=(1)
mn2 (n1 VDD n6 VSS) g45n1svt w=(145n) l=45n nf=1 m=(1)
mn1 (n6 n0 VSS VSS) g45n1svt w=(145n) l=45n nf=1 m=(1)
mn7 (n4 n3 VSS VSS) g45n1svt w=(260n) l=45n nf=1 m=(1)
mn0 (n0 A VSS VSS) g45n1svt w=(145n) l=45n nf=1 m=(1)
mp6 (n3 VSS n11 NW) g45p1svt w=(215n) l=45n nf=1 m=(1)
mp5 (n11 n2 VDD NW) g45p1svt w=(215n) l=45n nf=1 m=(1)
mp8 (Y n4 VDD NW) g45p1svt w=(1.56u) l=45n nf=1 m=(1)
mp4 (n2 VSS n9 NW) g45p1svt w=(215n) l=45n nf=1 m=(1)
mp3 (n9 n1 VDD NW) g45p1svt w=(215n) l=45n nf=1 m=(1)
mp2 (n1 VSS n7 NW) g45p1svt w=(215n) l=45n nf=1 m=(1)
mp1 (n7 n0 VDD NW) g45p1svt w=(215n) l=45n nf=1 m=(1)
mp7 (n4 n3 VDD NW) g45p1svt w=(390n) l=45n nf=1 m=(1)
mp0 (n0 A VDD NW) g45p1svt w=(215n) l=45n nf=1 m=(1)
ends DLY2X4
