// gsclib045_backbias/NOR3BX4/schematic

simulator lang=spectre

subckt NOR3BX4 AN B C Y VDD VSS NW
mn1 (Y net91 VSS VSS) g45n1svt w=(1.04u) l=45n nf=1 m=(1)
mn3 (Y C VSS VSS) g45n1svt w=(1.04u) l=45n nf=1 m=(1)
mn0 (net91 AN VSS VSS) g45n1svt w=(260n) l=45n nf=1 m=(1)
mn2 (Y B VSS VSS) g45n1svt w=(1.04u) l=45n nf=1 m=(1)
mp3 (Y C net90 NW) g45p1svt w=(1.56u) l=45n nf=1 m=(1)
mp0 (net91 AN VDD NW) g45p1svt w=(390n) l=45n nf=1 m=(1)
mp1 (net86 net91 VDD NW) g45p1svt w=(1.56u) l=45n nf=1 m=(1)
mp2 (net90 B net86 NW) g45p1svt w=(1.56u) l=45n nf=1 m=(1)
ends NOR3BX4
