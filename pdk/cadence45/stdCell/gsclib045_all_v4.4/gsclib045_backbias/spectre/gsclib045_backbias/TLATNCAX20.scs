// gsclib045_backbias/TLATNCAX20/schematic

simulator lang=spectre

subckt TLATNCAX20 CK E ECK VSS VDD NW
mn5 (net254 E VSS VSS) g45n1svt w=(145n) l=45n nf=1 m=(1)
mn6 (n0 CKb net254 VSS) g45n1svt w=(145n) l=45n nf=1 m=(1)
mn22 (ECK ECKb VSS VSS) g45n1svt w=(5.185u) l=45n nf=1 m=(1)
mn21 (ECKb CKbb net238 VSS) g45n1svt w=(1.3u) l=45n nf=1 m=(1)
mn20 (net238 Eint VSS VSS) g45n1svt w=(1.3u) l=45n nf=1 m=(1)
mn16 (n0 CKbb net230 VSS) g45n1svt w=(145n) l=45n nf=1 m=(1)
mn15 (net230 Eint VSS VSS) g45n1svt w=(145n) l=45n nf=1 m=(1)
mn0 (CKb CK VSS VSS) g45n1svt w=(145n) l=45n nf=1 m=(1)
mn10 (Eint n0 VSS VSS) g45n1svt w=(520n) l=45n nf=1 m=(1)
mn1 (CKbb CKb VSS VSS) g45n1svt w=(145n) l=45n nf=1 m=(1)
mp6 (n0 CKbb net217 NW) g45p1svt w=(215n) l=45n nf=1 m=(1)
mp5 (net217 E VDD NW) g45p1svt w=(215n) l=45n nf=1 m=(1)
mp22 (ECK ECKb VDD NW) g45p1svt w=(7.815u) l=45n nf=1 m=(1)
mp16 (n0 CKb net205 NW) g45p1svt w=(215n) l=45n nf=1 m=(1)
mp15 (net205 Eint VDD NW) g45p1svt w=(215n) l=45n nf=1 m=(1)
mp0 (CKb CK VDD NW) g45p1svt w=(215n) l=45n nf=1 m=(1)
mp1 (CKbb CKb VDD NW) g45p1svt w=(215n) l=45n nf=1 m=(1)
mp20 (ECKb Eint VDD NW) g45p1svt w=(1.95u) l=45n nf=1 m=(1)
mp21 (ECKb CKbb VDD NW) g45p1svt w=(1.95u) l=45n nf=1 m=(1)
mp10 (Eint n0 VDD NW) g45p1svt w=(780n) l=45n nf=1 m=(1)
ends TLATNCAX20
