// gsclib045_backbias/EDFFTRX4/schematic

simulator lang=spectre

subckt EDFFTRX4 CK D E Q QN RN NW VDD VSS
mn35 (net516 mout VSS VSS) g45n1svt w=(145n) l=45n nf=1 m=(1)
mn36 (n20 CKbb net516 VSS) g45n1svt w=(145n) l=45n nf=1 m=(1)
mn26 (n20 CKb n21 VSS) g45n1svt w=(145n) l=45n nf=1 m=(1)
mn25 (n21 Dp VSS VSS) g45n1svt w=(145n) l=45n nf=1 m=(1)
mn51 (n30 CKb net496 VSS) g45n1svt w=(145n) l=45n nf=1 m=(1)
mn50 (net496 qbint VSS VSS) g45n1svt w=(145n) l=45n nf=1 m=(1)
mn57 (QN qint VSS VSS) g45n1svt w=(1.04u) l=45n nf=1 m=(1)
mn55 (Q qbint VSS VSS) g45n1svt w=(1.04u) l=45n nf=1 m=(1)
mn5 (Dp qbint n0 VSS) g45n1svt w=(145n) l=45n nf=1 m=(1)
mn4 (n0 Eb VSS VSS) g45n1svt w=(145n) l=45n nf=1 m=(1)
mn6 (n1 E VSS VSS) g45n1svt w=(145n) l=45n nf=1 m=(1)
mn7 (Dp Db n1 VSS) g45n1svt w=(145n) l=45n nf=1 m=(1)
mn20 (CKb CK VSS VSS) g45n1svt w=(145n) l=45n nf=1 m=(1)
mn2 (RNb RN VSS VSS) g45n1svt w=(145n) l=45n nf=1 m=(1)
mn1 (Db D VSS VSS) g45n1svt w=(145n) l=45n nf=1 m=(1)
mn30 (mout n20 VSS VSS) g45n1svt w=(145n) l=45n nf=1 m=(1)
mn21 (CKbb CKb VSS VSS) g45n1svt w=(145n) l=45n nf=1 m=(1)
mn40 (n30 CKbb mout VSS) g45n1svt w=(145n) l=45n nf=1 m=(1)
mn45 (qbint n30 VSS VSS) g45n1svt w=(410n) l=45n nf=1 m=(1)
mn56 (qint qbint VSS VSS) g45n1svt w=(260n) l=45n nf=1 m=(1)
mn3 (Dp RNb VSS VSS) g45n1svt w=(145n) l=45n nf=1 m=(1)
mn0 (Eb E VSS VSS) g45n1svt w=(145n) l=45n nf=1 m=(1)
mp25 (n22 Dp VDD NW) g45p1svt w=(215n) l=45n nf=1 m=(1)
mp26 (n20 CKbb n22 NW) g45p1svt w=(215n) l=45n nf=1 m=(1)
mp35 (net427 mout VDD NW) g45p1svt w=(215n) l=45n nf=1 m=(1)
mp36 (n20 CKb net427 NW) g45p1svt w=(215n) l=45n nf=1 m=(1)
mp51 (n30 CKbb net411 NW) g45p1svt w=(215n) l=45n nf=1 m=(1)
mp50 (net411 qbint VDD NW) g45p1svt w=(215n) l=45n nf=1 m=(1)
mp57 (QN qint VDD NW) g45p1svt w=(1.56u) l=45n nf=1 m=(1)
mp55 (Q qbint VDD NW) g45p1svt w=(1.56u) l=45n nf=1 m=(1)
mp20 (CKb CK VDD NW) g45p1svt w=(215n) l=45n nf=1 m=(1)
mp2 (RNb RN VDD NW) g45p1svt w=(215n) l=45n nf=1 m=(1)
mp1 (Db D VDD NW) g45p1svt w=(215n) l=45n nf=1 m=(1)
mp7 (Dp Db n3 NW) g45p1svt w=(215n) l=45n nf=1 m=(1)
mp6 (Dp E n3 NW) g45p1svt w=(215n) l=45n nf=1 m=(1)
mp30 (mout n20 VDD NW) g45p1svt w=(215n) l=45n nf=1 m=(1)
mp21 (CKbb CKb VDD NW) g45p1svt w=(215n) l=45n nf=1 m=(1)
mp40 (n30 CKb mout NW) g45p1svt w=(215n) l=45n nf=1 m=(1)
mp45 (qbint n30 VDD NW) g45p1svt w=(620n) l=45n nf=1 m=(1)
mp56 (qint qbint VDD NW) g45p1svt w=(390n) l=45n nf=1 m=(1)
mp5 (n3 qbint n2 NW) g45p1svt w=(215n) l=45n nf=1 m=(1)
mp0 (Eb E VDD NW) g45p1svt w=(215n) l=45n nf=1 m=(1)
mp4 (n3 Eb n2 NW) g45p1svt w=(215n) l=45n nf=1 m=(1)
mp3 (n2 RNb VDD NW) g45p1svt w=(215n) l=45n nf=1 m=(1)
ends EDFFTRX4
