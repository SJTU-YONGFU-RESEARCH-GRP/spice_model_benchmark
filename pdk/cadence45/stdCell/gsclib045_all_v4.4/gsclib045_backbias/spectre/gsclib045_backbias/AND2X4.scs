// gsclib045_backbias/AND2X4/schematic

simulator lang=spectre

subckt AND2X4 A B Y NW VSS VDD
mn2 (Y net61 VSS VSS) g45n1svt w=(1.04u) l=45n nf=1 m=(1)
mn0 (net69 A VSS VSS) g45n1svt w=(260n) l=45n nf=1 m=(1)
mn1 (net61 B net69 VSS) g45n1svt w=(260n) l=45n nf=1 m=(1)
mp1 (net61 B VDD NW) g45p1svt w=(390n) l=45n nf=1 m=(1)
mp0 (net61 A VDD NW) g45p1svt w=(390n) l=45n nf=1 m=(1)
mp2 (Y net61 VDD NW) g45p1svt w=(1.56u) l=45n nf=1 m=(1)
ends AND2X4
