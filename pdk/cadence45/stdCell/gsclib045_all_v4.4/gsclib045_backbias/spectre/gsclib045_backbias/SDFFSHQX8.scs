// gsclib045_backbias/SDFFSHQX8/schematic

simulator lang=spectre

subckt SDFFSHQX8 CK D Q SE SI SN VDD VSS NW
mn51 (net467 qbint net459 VSS) g45n1svt w=(205n) l=45n nf=1 m=(1)
mn52 (n30 CKb net467 VSS) g45n1svt w=(205n) l=45n nf=1 m=(1)
mn50 (net459 SN VSS VSS) g45n1svt w=(205n) l=45n nf=1 m=(1)
mn13 (net455 SI VSS VSS) g45n1svt w=(260n) l=45n nf=1 m=(1)
mn14 (Db SE net455 VSS) g45n1svt w=(260n) l=45n nf=1 m=(1)
mn12 (Db SEb net443 VSS) g45n1svt w=(260n) l=45n nf=1 m=(1)
mn11 (net443 D VSS VSS) g45n1svt w=(260n) l=45n nf=1 m=(1)
mn55 (Q qbint VSS VSS) g45n1svt w=(2.065u) l=45n nf=1 m=(1)
mn30 (net435 SN VSS VSS) g45n1svt w=(205n) l=45n nf=1 m=(1)
mn31 (mout n20 net435 VSS) g45n1svt w=(205n) l=45n nf=1 m=(1)
mn35 (net427 mout VSS VSS) g45n1svt w=(205n) l=45n nf=1 m=(1)
mn36 (n20 CKbb net427 VSS) g45n1svt w=(205n) l=45n nf=1 m=(1)
mn20 (CKb CK VSS VSS) g45n1svt w=(145n) l=45n nf=1 m=(1)
mn10 (SEb SE VSS VSS) g45n1svt w=(145n) l=45n nf=1 m=(1)
mn25 (n20 CKb Db VSS) g45n1svt w=(205n) l=45n nf=1 m=(1)
mn40 (n30 CKbb mout VSS) g45n1svt w=(205n) l=45n nf=1 m=(1)
mn45 (qbint n30 VSS VSS) g45n1svt w=(780n) l=45n nf=1 m=(1)
mn21 (CKbb CKb VSS VSS) g45n1svt w=(145n) l=45n nf=1 m=(1)
mp14 (Db SEb net398 NW) g45p1svt w=(390n) l=45n nf=1 m=(1)
mp13 (net398 SI VDD NW) g45p1svt w=(390n) l=45n nf=1 m=(1)
mp12 (Db SE net390 NW) g45p1svt w=(390n) l=45n nf=1 m=(1)
mp11 (net390 D VDD NW) g45p1svt w=(390n) l=45n nf=1 m=(1)
mp55 (Q qbint VDD NW) g45p1svt w=(3.115u) l=45n nf=1 m=(1)
mp36 (n20 CKb net378 NW) g45p1svt w=(310n) l=45n nf=1 m=(1)
mp35 (net378 mout VDD NW) g45p1svt w=(310n) l=45n nf=1 m=(1)
mp20 (CKb CK VDD NW) g45p1svt w=(215n) l=45n nf=1 m=(1)
mp52 (n30 CKbb net355 NW) g45p1svt w=(310n) l=45n nf=1 m=(1)
mp51 (net355 qbint VDD NW) g45p1svt w=(310n) l=45n nf=1 m=(1)
mp50 (net355 SN VDD NW) g45p1svt w=(310n) l=45n nf=1 m=(1)
mp21 (CKbb CKb VDD NW) g45p1svt w=(215n) l=45n nf=1 m=(1)
mp31 (mout n20 VDD NW) g45p1svt w=(310n) l=45n nf=1 m=(1)
mp45 (qbint n30 VDD NW) g45p1svt w=(1.17u) l=45n nf=1 m=(1)
mp30 (mout SN VDD NW) g45p1svt w=(310n) l=45n nf=1 m=(1)
mp25 (n20 CKbb Db NW) g45p1svt w=(310n) l=45n nf=1 m=(1)
mp40 (n30 CKb mout NW) g45p1svt w=(310n) l=45n nf=1 m=(1)
mp10 (SEb SE VDD NW) g45p1svt w=(215n) l=45n nf=1 m=(1)
ends SDFFSHQX8
