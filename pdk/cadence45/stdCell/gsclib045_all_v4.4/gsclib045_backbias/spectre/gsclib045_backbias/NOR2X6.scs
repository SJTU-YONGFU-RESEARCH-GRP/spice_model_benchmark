// gsclib045_backbias/NOR2X6/schematic

simulator lang=spectre

subckt NOR2X6 A B Y NW VSS VDD
mn1 (Y B VSS VSS) g45n1svt w=(1.55u) l=45n nf=1 m=(1)
mn0 (Y A VSS VSS) g45n1svt w=(1.55u) l=45n nf=1 m=(1)
mp1 (Y B net41 NW) g45p1svt w=(2.34u) l=45n nf=1 m=(1)
mp0 (net41 A VDD NW) g45p1svt w=(2.34u) l=45n nf=1 m=(1)
ends NOR2X6
