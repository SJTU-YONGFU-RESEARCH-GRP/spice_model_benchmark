// gsclib045_backbias/AOI33X4/schematic

simulator lang=spectre

subckt AOI33X4 A0 A1 A2 B0 B1 B2 Y VSS VDD NW
mn1 (net153 A1 net149 VSS) g45n1svt w=(1.04u) l=45n nf=1 m=(1)
mn4 (net141 B1 net137 VSS) g45n1svt w=(1.04u) l=45n nf=1 m=(1)
mn3 (net137 B0 VSS VSS) g45n1svt w=(1.04u) l=45n nf=1 m=(1)
mn5 (Y B2 net141 VSS) g45n1svt w=(1.04u) l=45n nf=1 m=(1)
mn0 (net149 A0 VSS VSS) g45n1svt w=(1.04u) l=45n nf=1 m=(1)
mn2 (Y A2 net153 VSS) g45n1svt w=(1.04u) l=45n nf=1 m=(1)
mp0 (net124 A0 VDD NW) g45p1svt w=(1.56u) l=45n nf=1 m=(1)
mp1 (net124 A1 VDD NW) g45p1svt w=(1.56u) l=45n nf=1 m=(1)
mp4 (Y B1 net124 NW) g45p1svt w=(1.56u) l=45n nf=1 m=(1)
mp5 (Y B2 net124 NW) g45p1svt w=(1.56u) l=45n nf=1 m=(1)
mp2 (net124 A2 VDD NW) g45p1svt w=(1.56u) l=45n nf=1 m=(1)
mp3 (Y B0 net124 NW) g45p1svt w=(1.56u) l=45n nf=1 m=(1)
ends AOI33X4
