// gsclib045_backbias/NAND4X8/schematic

simulator lang=spectre

subckt NAND4X8 A B C D Y NW VDD VSS
mn1 (n1 B n2 VSS) g45n1svt w=(2.065u) l=45n nf=1 m=(1)
mn3 (Y D n0 VSS) g45n1svt w=(2.065u) l=45n nf=1 m=(1)
mn2 (n0 C n1 VSS) g45n1svt w=(2.065u) l=45n nf=1 m=(1)
mn0 (n2 A VSS VSS) g45n1svt w=(2.065u) l=45n nf=1 m=(1)
mp3 (Y D VDD NW) g45p1svt w=(3.115u) l=45n nf=1 m=(1)
mp2 (Y C VDD NW) g45p1svt w=(3.115u) l=45n nf=1 m=(1)
mp1 (Y B VDD NW) g45p1svt w=(3.115u) l=45n nf=1 m=(1)
mp0 (Y A VDD NW) g45p1svt w=(3.115u) l=45n nf=1 m=(1)
ends NAND4X8
