// gsclib045_backbias/AOI222X1/schematic

simulator lang=spectre

subckt AOI222X1 A0 A1 B0 B1 C0 C1 Y VDD VSS NW
mn5 (Y C1 net155 VSS) g45n1svt w=(260n) l=45n nf=1 m=(1)
mn4 (net155 C0 VSS VSS) g45n1svt w=(260n) l=45n nf=1 m=(1)
mn2 (net147 B0 VSS VSS) g45n1svt w=(260n) l=45n nf=1 m=(1)
mn0 (net139 A0 VSS VSS) g45n1svt w=(260n) l=45n nf=1 m=(1)
mn1 (Y A1 net139 VSS) g45n1svt w=(260n) l=45n nf=1 m=(1)
mn3 (Y B1 net147 VSS) g45n1svt w=(260n) l=45n nf=1 m=(1)
mp5 (Y C1 net118 NW) g45p1svt w=(390n) l=45n nf=1 m=(1)
mp4 (Y C0 net118 NW) g45p1svt w=(390n) l=45n nf=1 m=(1)
mp3 (net118 B1 net122 NW) g45p1svt w=(390n) l=45n nf=1 m=(1)
mp2 (net118 B0 net122 NW) g45p1svt w=(390n) l=45n nf=1 m=(1)
mp0 (net122 A0 VDD NW) g45p1svt w=(390n) l=45n nf=1 m=(1)
mp1 (net122 A1 VDD NW) g45p1svt w=(390n) l=45n nf=1 m=(1)
ends AOI222X1
