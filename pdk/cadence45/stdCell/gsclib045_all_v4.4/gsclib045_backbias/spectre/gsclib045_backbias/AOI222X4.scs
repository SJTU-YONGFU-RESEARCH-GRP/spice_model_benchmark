// gsclib045_backbias/AOI222X4/schematic

simulator lang=spectre

subckt AOI222X4 A0 A1 B0 B1 C0 C1 Y VSS NW VDD
mn5 (Y C1 net139 VSS) g45n1svt w=(1.04u) l=45n nf=1 m=(1)
mn4 (net139 C0 VSS VSS) g45n1svt w=(1.04u) l=45n nf=1 m=(1)
mn2 (net143 B0 VSS VSS) g45n1svt w=(1.04u) l=45n nf=1 m=(1)
mn0 (net147 A0 VSS VSS) g45n1svt w=(1.04u) l=45n nf=1 m=(1)
mn1 (Y A1 net147 VSS) g45n1svt w=(1.04u) l=45n nf=1 m=(1)
mn3 (Y B1 net143 VSS) g45n1svt w=(1.04u) l=45n nf=1 m=(1)
mp5 (Y C1 net122 NW) g45p1svt w=(1.56u) l=45n nf=1 m=(1)
mp4 (Y C0 net122 NW) g45p1svt w=(1.56u) l=45n nf=1 m=(1)
mp3 (net122 B1 net130 NW) g45p1svt w=(1.56u) l=45n nf=1 m=(1)
mp2 (net122 B0 net130 NW) g45p1svt w=(1.56u) l=45n nf=1 m=(1)
mp0 (net130 A0 VDD NW) g45p1svt w=(1.56u) l=45n nf=1 m=(1)
mp1 (net130 A1 VDD NW) g45p1svt w=(1.56u) l=45n nf=1 m=(1)
ends AOI222X4
