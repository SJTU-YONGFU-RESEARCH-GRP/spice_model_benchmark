// gsclib045_backbias/AND4X8/schematic

simulator lang=spectre

subckt AND4X8 A B C D Y VDD VSS NW
mn3 (net116 D net132 VSS) g45n1svt w=(520n) l=45n nf=1 m=(1)
mn2 (net132 C net128 VSS) g45n1svt w=(520n) l=45n nf=1 m=(1)
mn4 (Y net116 VSS VSS) g45n1svt w=(2.065u) l=45n nf=1 m=(1)
mn1 (net128 B net124 VSS) g45n1svt w=(520n) l=45n nf=1 m=(1)
mn0 (net124 A VSS VSS) g45n1svt w=(520n) l=45n nf=1 m=(1)
mp3 (net116 D VDD NW) g45p1svt w=(780n) l=45n nf=1 m=(1)
mp2 (net116 C VDD NW) g45p1svt w=(780n) l=45n nf=1 m=(1)
mp1 (net116 B VDD NW) g45p1svt w=(780n) l=45n nf=1 m=(1)
mp4 (Y net116 VDD NW) g45p1svt w=(3.115u) l=45n nf=1 m=(1)
mp0 (net116 A VDD NW) g45p1svt w=(780n) l=45n nf=1 m=(1)
ends AND4X8
