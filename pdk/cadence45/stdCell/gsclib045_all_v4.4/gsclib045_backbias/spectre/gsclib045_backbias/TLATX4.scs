// gsclib045_backbias/TLATX4/schematic

simulator lang=spectre

subckt TLATX4 D G Q QN VDD NW VSS
mn5 (net257 D VSS VSS) g45n1svt w=(145n) l=45n nf=1 m=(1)
mn6 (n0 Gbb net257 VSS) g45n1svt w=(145n) l=45n nf=1 m=(1)
mn16 (n0 Gb net245 VSS) g45n1svt w=(145n) l=45n nf=1 m=(1)
mn15 (net245 Qint VSS VSS) g45n1svt w=(145n) l=45n nf=1 m=(1)
mn22 (QN Qint VSS VSS) g45n1svt w=(1.04u) l=45n nf=1 m=(1)
mn21 (Q Qbint VSS VSS) g45n1svt w=(1.04u) l=45n nf=1 m=(1)
mn0 (Gb G VSS VSS) g45n1svt w=(145n) l=45n nf=1 m=(1)
mn10 (Qint n0 VSS VSS) g45n1svt w=(410n) l=45n nf=1 m=(1)
mn20 (Qbint Qint VSS VSS) g45n1svt w=(1.04u) l=45n nf=1 m=(1)
mn1 (Gbb Gb VSS VSS) g45n1svt w=(145n) l=45n nf=1 m=(1)
mp6 (n0 Gb net220 NW) g45p1svt w=(215n) l=45n nf=1 m=(1)
mp5 (net220 D VDD NW) g45p1svt w=(215n) l=45n nf=1 m=(1)
mp16 (n0 Gbb net212 NW) g45p1svt w=(215n) l=45n nf=1 m=(1)
mp15 (net212 Qint VDD NW) g45p1svt w=(215n) l=45n nf=1 m=(1)
mp22 (QN Qint VDD NW) g45p1svt w=(1.56u) l=45n nf=1 m=(1)
mp21 (Q Qbint VDD NW) g45p1svt w=(1.56u) l=45n nf=1 m=(1)
mp0 (Gb G VDD NW) g45p1svt w=(215n) l=45n nf=1 m=(1)
mp1 (Gbb Gb VDD NW) g45p1svt w=(215n) l=45n nf=1 m=(1)
mp10 (Qint n0 VDD NW) g45p1svt w=(620n) l=45n nf=1 m=(1)
mp20 (Qbint Qint VDD NW) g45p1svt w=(1.56u) l=45n nf=1 m=(1)
ends TLATX4
