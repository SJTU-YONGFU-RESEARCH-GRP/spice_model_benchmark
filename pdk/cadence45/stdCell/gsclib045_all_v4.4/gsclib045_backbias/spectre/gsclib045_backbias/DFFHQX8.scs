// gsclib045_backbias/DFFHQX8/schematic

simulator lang=spectre

subckt DFFHQX8 CK D Q VSS NW VDD
mn26 (n20 CKb n21 VSS) g45n1svt w=(205n) l=45n nf=1 m=(1)
mn25 (n21 D VSS VSS) g45n1svt w=(205n) l=45n nf=1 m=(1)
mn55 (Q qbint VSS VSS) g45n1svt w=(2.065u) l=45n nf=1 m=(1)
mn50 (net172 qbint VSS VSS) g45n1svt w=(205n) l=45n nf=1 m=(1)
mn51 (n30 CKb net172 VSS) g45n1svt w=(205n) l=45n nf=1 m=(1)
mn30 (mout n20 VSS VSS) g45n1svt w=(205n) l=45n nf=1 m=(1)
mn36 (n20 CKbb net192 VSS) g45n1svt w=(205n) l=45n nf=1 m=(1)
mn20 (CKb CK VSS VSS) g45n1svt w=(145n) l=45n nf=1 m=(1)
mn45 (qbint n30 VSS VSS) g45n1svt w=(780n) l=45n nf=1 m=(1)
mn40 (mout CKbb n30 VSS) g45n1svt w=(205n) l=45n nf=1 m=(1)
mn21 (CKbb CKb VSS VSS) g45n1svt w=(145n) l=45n nf=1 m=(1)
mn35 (net192 mout VSS VSS) g45n1svt w=(205n) l=45n nf=1 m=(1)
mp26 (n20 CKbb n22 NW) g45p1svt w=(310n) l=45n nf=1 m=(1)
mp25 (n22 D VDD NW) g45p1svt w=(310n) l=45n nf=1 m=(1)
mp51 (n30 CKbb net123 NW) g45p1svt w=(310n) l=45n nf=1 m=(1)
mp50 (net123 qbint VDD NW) g45p1svt w=(310n) l=45n nf=1 m=(1)
mp55 (Q qbint VDD NW) g45p1svt w=(3.115u) l=45n nf=1 m=(1)
mp35 (net147 mout VDD NW) g45p1svt w=(310n) l=45n nf=1 m=(1)
mp36 (n20 CKb net147 NW) g45p1svt w=(310n) l=45n nf=1 m=(1)
mp45 (qbint n30 VDD NW) g45p1svt w=(1.17u) l=45n nf=1 m=(1)
mp20 (CKb CK VDD NW) g45p1svt w=(215n) l=45n nf=1 m=(1)
mp40 (mout CKb n30 NW) g45p1svt w=(310n) l=45n nf=1 m=(1)
mp30 (mout n20 VDD NW) g45p1svt w=(310n) l=45n nf=1 m=(1)
mp21 (CKbb CKb VDD NW) g45p1svt w=(215n) l=45n nf=1 m=(1)
ends DFFHQX8
