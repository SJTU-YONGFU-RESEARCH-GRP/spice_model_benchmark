// gsclib045_backbias/AND3X4/schematic

simulator lang=spectre

subckt AND3X4 A B C Y VDD VSS NW
mn3 (Y net95 VSS VSS) g45n1svt w=(1.04u) l=45n nf=1 m=(1)
mn1 (net111 B net107 VSS) g45n1svt w=(260n) l=45n nf=1 m=(1)
mn0 (net107 A VSS VSS) g45n1svt w=(260n) l=45n nf=1 m=(1)
mn2 (net95 C net111 VSS) g45n1svt w=(260n) l=45n nf=1 m=(1)
mp1 (net95 B VDD NW) g45p1svt w=(390n) l=45n nf=1 m=(1)
mp2 (net95 C VDD NW) g45p1svt w=(390n) l=45n nf=1 m=(1)
mp0 (net95 A VDD NW) g45p1svt w=(390n) l=45n nf=1 m=(1)
mp3 (Y net95 VDD NW) g45p1svt w=(1.56u) l=45n nf=1 m=(1)
ends AND3X4
