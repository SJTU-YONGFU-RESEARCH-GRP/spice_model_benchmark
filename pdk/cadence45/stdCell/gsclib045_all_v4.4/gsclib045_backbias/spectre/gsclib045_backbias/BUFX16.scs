// gsclib045_backbias/BUFX16/schematic

simulator lang=spectre

subckt BUFX16 A Y VSS VDD NW
mn1 (VSS n0 Y VSS) g45n1svt w=(4.13u) l=45n nf=1 m=(1)
mn0 (VSS A n0 VSS) g45n1svt w=(1.04u) l=45n nf=1 m=(1)
mp1 (Y n0 VDD NW) g45p1svt w=(6.23u) l=45n nf=1 m=(1)
mp0 (n0 A VDD NW) g45p1svt w=(1.56u) l=45n nf=1 m=(1)
ends BUFX16
