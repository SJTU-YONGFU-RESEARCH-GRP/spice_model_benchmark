// gsclib045_backbias/AOI2BB2X1/schematic

simulator lang=spectre

subckt AOI2BB2X1 A0N A1N B0 B1 Y NW VSS VDD
mn5 (n3 B1 VSS VSS) g45n1svt w=(260n) l=45n nf=1 m=(1)
mn4 (Y B0 n3 VSS) g45n1svt w=(260n) l=45n nf=1 m=(1)
mn3 (Y n1 n2 VSS) g45n1svt w=(260n) l=45n nf=1 m=(1)
mn2 (n2 n0 VSS VSS) g45n1svt w=(260n) l=45n nf=1 m=(1)
mn0 (n0 A0N VSS VSS) g45n1svt w=(145n) l=45n nf=1 m=(1)
mn1 (n1 A1N VSS VSS) g45n1svt w=(145n) l=45n nf=1 m=(1)
mp5 (Y B1 n4 NW) g45p1svt w=(390n) l=45n nf=1 m=(1)
mp4 (Y B0 n4 NW) g45p1svt w=(390n) l=45n nf=1 m=(1)
mp2 (n4 n0 VDD NW) g45p1svt w=(390n) l=45n nf=1 m=(1)
mp0 (n0 A0N VDD NW) g45p1svt w=(215n) l=45n nf=1 m=(1)
mp1 (n1 A1N VDD NW) g45p1svt w=(215n) l=45n nf=1 m=(1)
mp3 (n4 n1 VDD NW) g45p1svt w=(390n) l=45n nf=1 m=(1)
ends AOI2BB2X1
