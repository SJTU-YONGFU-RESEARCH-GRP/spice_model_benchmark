// gsclib045_backbias/ADDFHX1/schematic

simulator lang=spectre

subckt ADDFHX1 A B CI CO S VDD VSS NW
mn5 (n4 A VSS VSS) g45n1svt w=(205n) l=45n nf=1 m=(1)
mn6 (n4 B VSS VSS) g45n1svt w=(205n) l=45n nf=1 m=(1)
mn4 (COb CI n2 VSS) g45n1svt w=(205n) l=45n nf=1 m=(1)
mn3 (n2 B VSS VSS) g45n1svt w=(205n) l=45n nf=1 m=(1)
mn2 (n2 A VSS VSS) g45n1svt w=(205n) l=45n nf=1 m=(1)
mn7 (n4 CI VSS VSS) g45n1svt w=(205n) l=45n nf=1 m=(1)
mn8 (Sb COb n4 VSS) g45n1svt w=(205n) l=45n nf=1 m=(1)
mn0 (n0 A VSS VSS) g45n1svt w=(205n) l=45n nf=1 m=(1)
mn1 (COb B n0 VSS) g45n1svt w=(205n) l=45n nf=1 m=(1)
mn12 (CO COb VSS VSS) g45n1svt w=(260n) l=45n nf=1 m=(1)
mn13 (S Sb VSS VSS) g45n1svt w=(260n) l=45n nf=1 m=(1)
mn11 (Sb CI n7 VSS) g45n1svt w=(205n) l=45n nf=1 m=(1)
mn10 (n7 B n6 VSS) g45n1svt w=(205n) l=45n nf=1 m=(1)
mn9 (n6 A VSS VSS) g45n1svt w=(205n) l=45n nf=1 m=(1)
mp2 (n3 A VDD NW) g45p1svt w=(310n) l=45n nf=1 m=(1)
mp3 (n3 B VDD NW) g45p1svt w=(310n) l=45n nf=1 m=(1)
mp4 (COb CI n3 NW) g45p1svt w=(310n) l=45n nf=1 m=(1)
mp5 (n5 A VDD NW) g45p1svt w=(310n) l=45n nf=1 m=(1)
mp6 (n5 B VDD NW) g45p1svt w=(310n) l=45n nf=1 m=(1)
mp7 (n5 CI VDD NW) g45p1svt w=(310n) l=45n nf=1 m=(1)
mp8 (Sb COb n5 NW) g45p1svt w=(310n) l=45n nf=1 m=(1)
mp0 (n1 A VDD NW) g45p1svt w=(310n) l=45n nf=1 m=(1)
mp1 (COb B n1 NW) g45p1svt w=(310n) l=45n nf=1 m=(1)
mp12 (CO COb VDD NW) g45p1svt w=(390n) l=45n nf=1 m=(1)
mp13 (S Sb VDD NW) g45p1svt w=(390n) l=45n nf=1 m=(1)
mp11 (Sb CI n9 NW) g45p1svt w=(310n) l=45n nf=1 m=(1)
mp10 (n9 B n8 NW) g45p1svt w=(310n) l=45n nf=1 m=(1)
mp9 (n8 A VDD NW) g45p1svt w=(310n) l=45n nf=1 m=(1)
ends ADDFHX1

// gsclib045_backbias/ADDFHX2/schematic

simulator lang=spectre

subckt ADDFHX2 A B CI CO S NW VDD VSS
mn5 (n4 A VSS VSS) g45n1svt w=(205n) l=45n nf=1 m=(1)
mn6 (n4 B VSS VSS) g45n1svt w=(205n) l=45n nf=1 m=(1)
mn4 (COb CI n2 VSS) g45n1svt w=(205n) l=45n nf=1 m=(1)
mn3 (n2 B VSS VSS) g45n1svt w=(205n) l=45n nf=1 m=(1)
mn2 (n2 A VSS VSS) g45n1svt w=(205n) l=45n nf=1 m=(1)
mn7 (n4 CI VSS VSS) g45n1svt w=(205n) l=45n nf=1 m=(1)
mn8 (Sb COb n4 VSS) g45n1svt w=(205n) l=45n nf=1 m=(1)
mn0 (n0 A VSS VSS) g45n1svt w=(205n) l=45n nf=1 m=(1)
mn1 (COb B n0 VSS) g45n1svt w=(205n) l=45n nf=1 m=(1)
mn12 (CO COb VSS VSS) g45n1svt w=(520n) l=45n nf=1 m=(1)
mn13 (S Sb VSS VSS) g45n1svt w=(520n) l=45n nf=1 m=(1)
mn11 (Sb CI n7 VSS) g45n1svt w=(205n) l=45n nf=1 m=(1)
mn10 (n7 B n6 VSS) g45n1svt w=(205n) l=45n nf=1 m=(1)
mn9 (n6 A VSS VSS) g45n1svt w=(205n) l=45n nf=1 m=(1)
mp2 (n3 A VDD NW) g45p1svt w=(310n) l=45n nf=1 m=(1)
mp3 (n3 B VDD NW) g45p1svt w=(310n) l=45n nf=1 m=(1)
mp4 (COb CI n3 NW) g45p1svt w=(310n) l=45n nf=1 m=(1)
mp5 (n5 A VDD NW) g45p1svt w=(310n) l=45n nf=1 m=(1)
mp6 (n5 B VDD NW) g45p1svt w=(310n) l=45n nf=1 m=(1)
mp7 (n5 CI VDD NW) g45p1svt w=(310n) l=45n nf=1 m=(1)
mp8 (Sb COb n5 NW) g45p1svt w=(310n) l=45n nf=1 m=(1)
mp0 (n1 A VDD NW) g45p1svt w=(310n) l=45n nf=1 m=(1)
mp1 (COb B n1 NW) g45p1svt w=(310n) l=45n nf=1 m=(1)
mp12 (CO COb VDD NW) g45p1svt w=(780n) l=45n nf=1 m=(1)
mp13 (S Sb VDD NW) g45p1svt w=(780n) l=45n nf=1 m=(1)
mp11 (Sb CI n9 NW) g45p1svt w=(310n) l=45n nf=1 m=(1)
mp10 (n9 B n8 NW) g45p1svt w=(310n) l=45n nf=1 m=(1)
mp9 (n8 A VDD NW) g45p1svt w=(310n) l=45n nf=1 m=(1)
ends ADDFHX2

// gsclib045_backbias/ADDFHX4/schematic

simulator lang=spectre

subckt ADDFHX4 A B CI CO S VDD NW VSS
mn5 (n4 A VSS VSS) g45n1svt w=(260n) l=45n nf=1 m=(1)
mn6 (n4 B VSS VSS) g45n1svt w=(260n) l=45n nf=1 m=(1)
mn4 (COb CI n2 VSS) g45n1svt w=(260n) l=45n nf=1 m=(1)
mn3 (n2 B VSS VSS) g45n1svt w=(260n) l=45n nf=1 m=(1)
mn2 (n2 A VSS VSS) g45n1svt w=(260n) l=45n nf=1 m=(1)
mn7 (n4 CI VSS VSS) g45n1svt w=(260n) l=45n nf=1 m=(1)
mn8 (Sb COb n4 VSS) g45n1svt w=(260n) l=45n nf=1 m=(1)
mn0 (n0 A VSS VSS) g45n1svt w=(260n) l=45n nf=1 m=(1)
mn1 (COb B n0 VSS) g45n1svt w=(260n) l=45n nf=1 m=(1)
mn12 (CO COb VSS VSS) g45n1svt w=(1.04u) l=45n nf=1 m=(1)
mn13 (S Sb VSS VSS) g45n1svt w=(1.04u) l=45n nf=1 m=(1)
mn11 (Sb CI n7 VSS) g45n1svt w=(260n) l=45n nf=1 m=(1)
mn10 (n7 B n6 VSS) g45n1svt w=(260n) l=45n nf=1 m=(1)
mn9 (n6 A VSS VSS) g45n1svt w=(260n) l=45n nf=1 m=(1)
mp2 (n3 A VDD NW) g45p1svt w=(390n) l=45n nf=1 m=(1)
mp3 (n3 B VDD NW) g45p1svt w=(390n) l=45n nf=1 m=(1)
mp4 (COb CI n3 NW) g45p1svt w=(390n) l=45n nf=1 m=(1)
mp5 (n5 A VDD NW) g45p1svt w=(390n) l=45n nf=1 m=(1)
mp6 (n5 B VDD NW) g45p1svt w=(390n) l=45n nf=1 m=(1)
mp7 (n5 CI VDD NW) g45p1svt w=(390n) l=45n nf=1 m=(1)
mp8 (Sb COb n5 NW) g45p1svt w=(390n) l=45n nf=1 m=(1)
mp0 (n1 A VDD NW) g45p1svt w=(390n) l=45n nf=1 m=(1)
mp1 (COb B n1 NW) g45p1svt w=(390n) l=45n nf=1 m=(1)
mp12 (CO COb VDD NW) g45p1svt w=(1.56u) l=45n nf=1 m=(1)
mp13 (S Sb VDD NW) g45p1svt w=(1.56u) l=45n nf=1 m=(1)
mp11 (Sb CI n9 NW) g45p1svt w=(390n) l=45n nf=1 m=(1)
mp10 (n9 B n8 NW) g45p1svt w=(390n) l=45n nf=1 m=(1)
mp9 (n8 A VDD NW) g45p1svt w=(390n) l=45n nf=1 m=(1)
ends ADDFHX4

// gsclib045_backbias/ADDFHXL/schematic

simulator lang=spectre

subckt ADDFHXL A B CI CO S VDD NW VSS
mn5 (n4 A VSS VSS) g45n1svt w=(205n) l=45n nf=1 m=(1)
mn6 (n4 B VSS VSS) g45n1svt w=(205n) l=45n nf=1 m=(1)
mn4 (COb CI n2 VSS) g45n1svt w=(205n) l=45n nf=1 m=(1)
mn3 (n2 B VSS VSS) g45n1svt w=(205n) l=45n nf=1 m=(1)
mn2 (n2 A VSS VSS) g45n1svt w=(205n) l=45n nf=1 m=(1)
mn7 (n4 CI VSS VSS) g45n1svt w=(205n) l=45n nf=1 m=(1)
mn8 (Sb COb n4 VSS) g45n1svt w=(205n) l=45n nf=1 m=(1)
mn0 (n0 A VSS VSS) g45n1svt w=(205n) l=45n nf=1 m=(1)
mn1 (COb B n0 VSS) g45n1svt w=(205n) l=45n nf=1 m=(1)
mn12 (CO COb VSS VSS) g45n1svt w=(205n) l=45n nf=1 m=(1)
mn13 (S Sb VSS VSS) g45n1svt w=(205n) l=45n nf=1 m=(1)
mn11 (Sb CI n7 VSS) g45n1svt w=(205n) l=45n nf=1 m=(1)
mn10 (n7 B n6 VSS) g45n1svt w=(205n) l=45n nf=1 m=(1)
mn9 (n6 A VSS VSS) g45n1svt w=(205n) l=45n nf=1 m=(1)
mp2 (n3 A VDD NW) g45p1svt w=(310n) l=45n nf=1 m=(1)
mp3 (n3 B VDD NW) g45p1svt w=(310n) l=45n nf=1 m=(1)
mp4 (COb CI n3 NW) g45p1svt w=(310n) l=45n nf=1 m=(1)
mp5 (n5 A VDD NW) g45p1svt w=(310n) l=45n nf=1 m=(1)
mp6 (n5 B VDD NW) g45p1svt w=(310n) l=45n nf=1 m=(1)
mp7 (n5 CI VDD NW) g45p1svt w=(310n) l=45n nf=1 m=(1)
mp8 (Sb COb n5 NW) g45p1svt w=(310n) l=45n nf=1 m=(1)
mp0 (n1 A VDD NW) g45p1svt w=(310n) l=45n nf=1 m=(1)
mp1 (COb B n1 NW) g45p1svt w=(310n) l=45n nf=1 m=(1)
mp12 (CO COb VDD NW) g45p1svt w=(310n) l=45n nf=1 m=(1)
mp13 (S Sb VDD NW) g45p1svt w=(310n) l=45n nf=1 m=(1)
mp11 (Sb CI n9 NW) g45p1svt w=(310n) l=45n nf=1 m=(1)
mp10 (n9 B n8 NW) g45p1svt w=(310n) l=45n nf=1 m=(1)
mp9 (n8 A VDD NW) g45p1svt w=(310n) l=45n nf=1 m=(1)
ends ADDFHXL

// gsclib045_backbias/ADDFX1/schematic

simulator lang=spectre

subckt ADDFX1 A B CI CO S NW VSS VDD
mn9 (n6 A VSS VSS) g45n1svt w=(145n) l=45n nf=1 m=(1)
mn10 (n7 B n6 VSS) g45n1svt w=(145n) l=45n nf=1 m=(1)
mn11 (Sb CI n7 VSS) g45n1svt w=(145n) l=45n nf=1 m=(1)
mn13 (S Sb VSS VSS) g45n1svt w=(260n) l=45n nf=1 m=(1)
mn12 (CO COb VSS VSS) g45n1svt w=(260n) l=45n nf=1 m=(1)
mn1 (COb B n0 VSS) g45n1svt w=(145n) l=45n nf=1 m=(1)
mn2 (n2 A VSS VSS) g45n1svt w=(145n) l=45n nf=1 m=(1)
mn0 (n0 A VSS VSS) g45n1svt w=(145n) l=45n nf=1 m=(1)
mn7 (n4 CI VSS VSS) g45n1svt w=(145n) l=45n nf=1 m=(1)
mn8 (Sb COb n4 VSS) g45n1svt w=(145n) l=45n nf=1 m=(1)
mn3 (n2 B VSS VSS) g45n1svt w=(145n) l=45n nf=1 m=(1)
mn6 (n4 B VSS VSS) g45n1svt w=(145n) l=45n nf=1 m=(1)
mn5 (n4 A VSS VSS) g45n1svt w=(145n) l=45n nf=1 m=(1)
mn4 (COb CI n2 VSS) g45n1svt w=(145n) l=45n nf=1 m=(1)
mp9 (n8 A VDD NW) g45p1svt w=(215n) l=45n nf=1 m=(1)
mp10 (n9 B n8 NW) g45p1svt w=(215n) l=45n nf=1 m=(1)
mp11 (Sb CI n9 NW) g45p1svt w=(215n) l=45n nf=1 m=(1)
mp13 (S Sb VDD NW) g45p1svt w=(390n) l=45n nf=1 m=(1)
mp12 (CO COb VDD NW) g45p1svt w=(390n) l=45n nf=1 m=(1)
mp1 (COb B n1 NW) g45p1svt w=(215n) l=45n nf=1 m=(1)
mp0 (n1 A VDD NW) g45p1svt w=(215n) l=45n nf=1 m=(1)
mp2 (n3 A VDD NW) g45p1svt w=(215n) l=45n nf=1 m=(1)
mp4 (COb CI n3 NW) g45p1svt w=(215n) l=45n nf=1 m=(1)
mp5 (n5 A VDD NW) g45p1svt w=(215n) l=45n nf=1 m=(1)
mp6 (n5 B VDD NW) g45p1svt w=(215n) l=45n nf=1 m=(1)
mp7 (n5 CI VDD NW) g45p1svt w=(215n) l=45n nf=1 m=(1)
mp3 (n3 B VDD NW) g45p1svt w=(215n) l=45n nf=1 m=(1)
mp8 (Sb COb n5 NW) g45p1svt w=(215n) l=45n nf=1 m=(1)
ends ADDFX1

// gsclib045_backbias/ADDFX2/schematic

simulator lang=spectre

subckt ADDFX2 A B CI CO S NW VSS VDD
mn9 (n6 A VSS VSS) g45n1svt w=(145n) l=45n nf=1 m=(1)
mn10 (n7 B n6 VSS) g45n1svt w=(145n) l=45n nf=1 m=(1)
mn11 (Sb CI n7 VSS) g45n1svt w=(145n) l=45n nf=1 m=(1)
mn13 (S Sb VSS VSS) g45n1svt w=(520n) l=45n nf=1 m=(1)
mn12 (CO COb VSS VSS) g45n1svt w=(520n) l=45n nf=1 m=(1)
mn1 (COb B n0 VSS) g45n1svt w=(145n) l=45n nf=1 m=(1)
mn2 (n2 A VSS VSS) g45n1svt w=(145n) l=45n nf=1 m=(1)
mn0 (n0 A VSS VSS) g45n1svt w=(145n) l=45n nf=1 m=(1)
mn7 (n4 CI VSS VSS) g45n1svt w=(145n) l=45n nf=1 m=(1)
mn8 (Sb COb n4 VSS) g45n1svt w=(145n) l=45n nf=1 m=(1)
mn3 (n2 B VSS VSS) g45n1svt w=(145n) l=45n nf=1 m=(1)
mn6 (n4 B VSS VSS) g45n1svt w=(145n) l=45n nf=1 m=(1)
mn5 (n4 A VSS VSS) g45n1svt w=(145n) l=45n nf=1 m=(1)
mn4 (COb CI n2 VSS) g45n1svt w=(145n) l=45n nf=1 m=(1)
mp9 (n8 A VDD NW) g45p1svt w=(215n) l=45n nf=1 m=(1)
mp10 (n9 B n8 NW) g45p1svt w=(215n) l=45n nf=1 m=(1)
mp11 (Sb CI n9 NW) g45p1svt w=(215n) l=45n nf=1 m=(1)
mp13 (S Sb VDD NW) g45p1svt w=(780n) l=45n nf=1 m=(1)
mp12 (CO COb VDD NW) g45p1svt w=(780n) l=45n nf=1 m=(1)
mp1 (COb B n1 NW) g45p1svt w=(215n) l=45n nf=1 m=(1)
mp0 (n1 A VDD NW) g45p1svt w=(215n) l=45n nf=1 m=(1)
mp2 (n3 A VDD NW) g45p1svt w=(215n) l=45n nf=1 m=(1)
mp4 (COb CI n3 NW) g45p1svt w=(215n) l=45n nf=1 m=(1)
mp5 (n5 A VDD NW) g45p1svt w=(215n) l=45n nf=1 m=(1)
mp6 (n5 B VDD NW) g45p1svt w=(215n) l=45n nf=1 m=(1)
mp7 (n5 CI VDD NW) g45p1svt w=(215n) l=45n nf=1 m=(1)
mp3 (n3 B VDD NW) g45p1svt w=(215n) l=45n nf=1 m=(1)
mp8 (Sb COb n5 NW) g45p1svt w=(215n) l=45n nf=1 m=(1)
ends ADDFX2

// gsclib045_backbias/ADDFX4/schematic

simulator lang=spectre

subckt ADDFX4 A B CI CO S NW VSS VDD
mn9 (n6 A VSS VSS) g45n1svt w=(260n) l=45n nf=1 m=(1)
mn10 (n7 B n6 VSS) g45n1svt w=(260n) l=45n nf=1 m=(1)
mn11 (Sb CI n7 VSS) g45n1svt w=(260n) l=45n nf=1 m=(1)
mn13 (S Sb VSS VSS) g45n1svt w=(1.04u) l=45n nf=1 m=(1)
mn12 (CO COb VSS VSS) g45n1svt w=(1.04u) l=45n nf=1 m=(1)
mn1 (COb B n0 VSS) g45n1svt w=(260n) l=45n nf=1 m=(1)
mn2 (n2 A VSS VSS) g45n1svt w=(260n) l=45n nf=1 m=(1)
mn0 (n0 A VSS VSS) g45n1svt w=(260n) l=45n nf=1 m=(1)
mn7 (n4 CI VSS VSS) g45n1svt w=(260n) l=45n nf=1 m=(1)
mn8 (Sb COb n4 VSS) g45n1svt w=(260n) l=45n nf=1 m=(1)
mn3 (n2 B VSS VSS) g45n1svt w=(260n) l=45n nf=1 m=(1)
mn6 (n4 B VSS VSS) g45n1svt w=(260n) l=45n nf=1 m=(1)
mn5 (n4 A VSS VSS) g45n1svt w=(260n) l=45n nf=1 m=(1)
mn4 (COb CI n2 VSS) g45n1svt w=(260n) l=45n nf=1 m=(1)
mp9 (n8 A VDD NW) g45p1svt w=(390n) l=45n nf=1 m=(1)
mp10 (n9 B n8 NW) g45p1svt w=(390n) l=45n nf=1 m=(1)
mp11 (Sb CI n9 NW) g45p1svt w=(390n) l=45n nf=1 m=(1)
mp13 (S Sb VDD NW) g45p1svt w=(1.56u) l=45n nf=1 m=(1)
mp12 (CO COb VDD NW) g45p1svt w=(1.56u) l=45n nf=1 m=(1)
mp1 (COb B n1 NW) g45p1svt w=(390n) l=45n nf=1 m=(1)
mp0 (n1 A VDD NW) g45p1svt w=(390n) l=45n nf=1 m=(1)
mp2 (n3 A VDD NW) g45p1svt w=(390n) l=45n nf=1 m=(1)
mp4 (COb CI n3 NW) g45p1svt w=(390n) l=45n nf=1 m=(1)
mp5 (n5 A VDD NW) g45p1svt w=(390n) l=45n nf=1 m=(1)
mp6 (n5 B VDD NW) g45p1svt w=(390n) l=45n nf=1 m=(1)
mp7 (n5 CI VDD NW) g45p1svt w=(390n) l=45n nf=1 m=(1)
mp3 (n3 B VDD NW) g45p1svt w=(390n) l=45n nf=1 m=(1)
mp8 (Sb COb n5 NW) g45p1svt w=(390n) l=45n nf=1 m=(1)
ends ADDFX4

// gsclib045_backbias/ADDFXL/schematic

simulator lang=spectre

subckt ADDFXL A B CI CO S NW VSS VDD
mn9 (n6 A VSS VSS) g45n1svt w=(145n) l=45n nf=1 m=(1)
mn10 (n7 B n6 VSS) g45n1svt w=(145n) l=45n nf=1 m=(1)
mn11 (Sb CI n7 VSS) g45n1svt w=(145n) l=45n nf=1 m=(1)
mn13 (S Sb VSS VSS) g45n1svt w=(145n) l=45n nf=1 m=(1)
mn12 (CO COb VSS VSS) g45n1svt w=(145n) l=45n nf=1 m=(1)
mn1 (COb B n0 VSS) g45n1svt w=(145n) l=45n nf=1 m=(1)
mn2 (n2 A VSS VSS) g45n1svt w=(145n) l=45n nf=1 m=(1)
mn0 (n0 A VSS VSS) g45n1svt w=(145n) l=45n nf=1 m=(1)
mn7 (n4 CI VSS VSS) g45n1svt w=(145n) l=45n nf=1 m=(1)
mn8 (Sb COb n4 VSS) g45n1svt w=(145n) l=45n nf=1 m=(1)
mn3 (n2 B VSS VSS) g45n1svt w=(145n) l=45n nf=1 m=(1)
mn6 (n4 B VSS VSS) g45n1svt w=(145n) l=45n nf=1 m=(1)
mn5 (n4 A VSS VSS) g45n1svt w=(145n) l=45n nf=1 m=(1)
mn4 (COb CI n2 VSS) g45n1svt w=(145n) l=45n nf=1 m=(1)
mp9 (n8 A VDD NW) g45p1svt w=(215n) l=45n nf=1 m=(1)
mp10 (n9 B n8 NW) g45p1svt w=(215n) l=45n nf=1 m=(1)
mp11 (Sb CI n9 NW) g45p1svt w=(215n) l=45n nf=1 m=(1)
mp13 (S Sb VDD NW) g45p1svt w=(215n) l=45n nf=1 m=(1)
mp12 (CO COb VDD NW) g45p1svt w=(215n) l=45n nf=1 m=(1)
mp1 (COb B n1 NW) g45p1svt w=(215n) l=45n nf=1 m=(1)
mp0 (n1 A VDD NW) g45p1svt w=(215n) l=45n nf=1 m=(1)
mp2 (n3 A VDD NW) g45p1svt w=(215n) l=45n nf=1 m=(1)
mp4 (COb CI n3 NW) g45p1svt w=(215n) l=45n nf=1 m=(1)
mp5 (n5 A VDD NW) g45p1svt w=(215n) l=45n nf=1 m=(1)
mp6 (n5 B VDD NW) g45p1svt w=(215n) l=45n nf=1 m=(1)
mp7 (n5 CI VDD NW) g45p1svt w=(215n) l=45n nf=1 m=(1)
mp3 (n3 B VDD NW) g45p1svt w=(215n) l=45n nf=1 m=(1)
mp8 (Sb COb n5 NW) g45p1svt w=(215n) l=45n nf=1 m=(1)
ends ADDFXL

// gsclib045_backbias/ADDHX1/schematic

simulator lang=spectre

subckt ADDHX1 A B CO S VDD VSS NW
mn8 (CO COb VSS VSS) g45n1svt w=(260n) l=45n nf=1 m=(1)
mn7 (COb B n4 VSS) g45n1svt w=(145n) l=45n nf=1 m=(1)
mn6 (n4 A VSS VSS) g45n1svt w=(145n) l=45n nf=1 m=(1)
mn5 (S Sb VSS VSS) g45n1svt w=(260n) l=45n nf=1 m=(1)
mn3 (Sb B n2 VSS) g45n1svt w=(145n) l=45n nf=1 m=(1)
mn2 (n2 n0 VSS VSS) g45n1svt w=(145n) l=45n nf=1 m=(1)
mn1 (n1 B VSS VSS) g45n1svt w=(145n) l=45n nf=1 m=(1)
mn4 (Sb n1 n0 VSS) g45n1svt w=(145n) l=45n nf=1 m=(1)
mn0 (n0 A VSS VSS) g45n1svt w=(145n) l=45n nf=1 m=(1)
mp8 (CO COb VDD NW) g45p1svt w=(390n) l=45n nf=1 m=(1)
mp5 (S Sb VDD NW) g45p1svt w=(390n) l=45n nf=1 m=(1)
mp2 (n3 n0 VDD NW) g45p1svt w=(215n) l=45n nf=1 m=(1)
mp3 (Sb n1 n3 NW) g45p1svt w=(215n) l=45n nf=1 m=(1)
mp4 (Sb B n0 NW) g45p1svt w=(215n) l=45n nf=1 m=(1)
mp1 (n1 B VDD NW) g45p1svt w=(215n) l=45n nf=1 m=(1)
mp7 (COb B VDD NW) g45p1svt w=(215n) l=45n nf=1 m=(1)
mp0 (n0 A VDD NW) g45p1svt w=(215n) l=45n nf=1 m=(1)
mp6 (COb A VDD NW) g45p1svt w=(215n) l=45n nf=1 m=(1)
ends ADDHX1

// gsclib045_backbias/ADDHX2/schematic

simulator lang=spectre

subckt ADDHX2 A B CO S NW VDD VSS
mn8 (CO COb VSS VSS) g45n1svt w=(520n) l=45n nf=1 m=(1)
mn7 (COb B n4 VSS) g45n1svt w=(145n) l=45n nf=1 m=(1)
mn6 (n4 A VSS VSS) g45n1svt w=(145n) l=45n nf=1 m=(1)
mn5 (S Sb VSS VSS) g45n1svt w=(520n) l=45n nf=1 m=(1)
mn3 (Sb B n2 VSS) g45n1svt w=(145n) l=45n nf=1 m=(1)
mn2 (n2 n0 VSS VSS) g45n1svt w=(145n) l=45n nf=1 m=(1)
mn1 (n1 B VSS VSS) g45n1svt w=(145n) l=45n nf=1 m=(1)
mn4 (Sb n1 n0 VSS) g45n1svt w=(145n) l=45n nf=1 m=(1)
mn0 (n0 A VSS VSS) g45n1svt w=(145n) l=45n nf=1 m=(1)
mp8 (CO COb VDD NW) g45p1svt w=(780n) l=45n nf=1 m=(1)
mp5 (S Sb VDD NW) g45p1svt w=(780n) l=45n nf=1 m=(1)
mp2 (n3 n0 VDD NW) g45p1svt w=(215n) l=45n nf=1 m=(1)
mp3 (Sb n1 n3 NW) g45p1svt w=(215n) l=45n nf=1 m=(1)
mp4 (Sb B n0 NW) g45p1svt w=(215n) l=45n nf=1 m=(1)
mp1 (n1 B VDD NW) g45p1svt w=(215n) l=45n nf=1 m=(1)
mp7 (COb B VDD NW) g45p1svt w=(215n) l=45n nf=1 m=(1)
mp0 (n0 A VDD NW) g45p1svt w=(215n) l=45n nf=1 m=(1)
mp6 (COb A VDD NW) g45p1svt w=(215n) l=45n nf=1 m=(1)
ends ADDHX2

// gsclib045_backbias/ADDHX4/schematic

simulator lang=spectre

subckt ADDHX4 A B CO S NW VSS VDD
mn8 (CO COb VSS VSS) g45n1svt w=(1.04u) l=45n nf=1 m=(1)
mn7 (COb B n4 VSS) g45n1svt w=(260n) l=45n nf=1 m=(1)
mn6 (n4 A VSS VSS) g45n1svt w=(260n) l=45n nf=1 m=(1)
mn5 (S Sb VSS VSS) g45n1svt w=(1.04u) l=45n nf=1 m=(1)
mn3 (Sb B n2 VSS) g45n1svt w=(260n) l=45n nf=1 m=(1)
mn2 (n2 n0 VSS VSS) g45n1svt w=(260n) l=45n nf=1 m=(1)
mn1 (n1 B VSS VSS) g45n1svt w=(145n) l=45n nf=1 m=(1)
mn4 (Sb n1 n0 VSS) g45n1svt w=(260n) l=45n nf=1 m=(1)
mn0 (n0 A VSS VSS) g45n1svt w=(145n) l=45n nf=1 m=(1)
mp8 (CO COb VDD NW) g45p1svt w=(1.56u) l=45n nf=1 m=(1)
mp5 (S Sb VDD NW) g45p1svt w=(1.56u) l=45n nf=1 m=(1)
mp2 (n3 n0 VDD NW) g45p1svt w=(390n) l=45n nf=1 m=(1)
mp3 (Sb n1 n3 NW) g45p1svt w=(390n) l=45n nf=1 m=(1)
mp4 (Sb B n0 NW) g45p1svt w=(390n) l=45n nf=1 m=(1)
mp1 (n1 B VDD NW) g45p1svt w=(215n) l=45n nf=1 m=(1)
mp7 (COb B VDD NW) g45p1svt w=(390n) l=45n nf=1 m=(1)
mp0 (n0 A VDD NW) g45p1svt w=(215n) l=45n nf=1 m=(1)
mp6 (COb A VDD NW) g45p1svt w=(390n) l=45n nf=1 m=(1)
ends ADDHX4

// gsclib045_backbias/ADDHXL/schematic

simulator lang=spectre

subckt ADDHXL A B CO S NW VSS VDD
mn8 (CO COb VSS VSS) g45n1svt w=(145n) l=45n nf=1 m=(1)
mn7 (COb B n4 VSS) g45n1svt w=(145n) l=45n nf=1 m=(1)
mn6 (n4 A VSS VSS) g45n1svt w=(145n) l=45n nf=1 m=(1)
mn5 (S Sb VSS VSS) g45n1svt w=(145n) l=45n nf=1 m=(1)
mn3 (Sb B n2 VSS) g45n1svt w=(145n) l=45n nf=1 m=(1)
mn2 (n2 n0 VSS VSS) g45n1svt w=(145n) l=45n nf=1 m=(1)
mn1 (n1 B VSS VSS) g45n1svt w=(145n) l=45n nf=1 m=(1)
mn4 (Sb n1 n0 VSS) g45n1svt w=(145n) l=45n nf=1 m=(1)
mn0 (n0 A VSS VSS) g45n1svt w=(145n) l=45n nf=1 m=(1)
mp8 (CO COb VDD NW) g45p1svt w=(215n) l=45n nf=1 m=(1)
mp5 (S Sb VDD NW) g45p1svt w=(215n) l=45n nf=1 m=(1)
mp2 (n3 n0 VDD NW) g45p1svt w=(215n) l=45n nf=1 m=(1)
mp3 (Sb n1 n3 NW) g45p1svt w=(215n) l=45n nf=1 m=(1)
mp4 (Sb B n0 NW) g45p1svt w=(215n) l=45n nf=1 m=(1)
mp1 (n1 B VDD NW) g45p1svt w=(215n) l=45n nf=1 m=(1)
mp7 (COb B VDD NW) g45p1svt w=(215n) l=45n nf=1 m=(1)
mp0 (n0 A VDD NW) g45p1svt w=(215n) l=45n nf=1 m=(1)
mp6 (COb A VDD NW) g45p1svt w=(215n) l=45n nf=1 m=(1)
ends ADDHXL

// gsclib045_backbias/AND2X1/schematic

simulator lang=spectre

subckt AND2X1 A B Y VDD VSS NW
mn2 (Y n0 VSS VSS) g45n1svt w=(260n) l=45n nf=1 m=(1)
mn0 (net127 B VSS VSS) g45n1svt w=(145n) l=45n nf=1 m=(1)
mn1 (n0 A net127 VSS) g45n1svt w=(145n) l=45n nf=1 m=(1)
mp1 (n0 B VDD NW) g45p1svt w=(215n) l=45n nf=1 m=(1)
mp0 (n0 A VDD NW) g45p1svt w=(215n) l=45n nf=1 m=(1)
mp2 (Y n0 VDD NW) g45p1svt w=(390n) l=45n nf=1 m=(1)
ends AND2X1

// gsclib045_backbias/AND2X2/schematic

simulator lang=spectre

subckt AND2X2 A B Y NW VSS VDD
mn2 (Y n0 VSS VSS) g45n1svt w=(520n) l=45n nf=1 m=(1)
mn0 (net73 A VSS VSS) g45n1svt w=(145n) l=45n nf=1 m=(1)
mn1 (n0 B net73 VSS) g45n1svt w=(145n) l=45n nf=1 m=(1)
mp1 (n0 B VDD NW) g45p1svt w=(215n) l=45n nf=1 m=(1)
mp0 (n0 A VDD NW) g45p1svt w=(215n) l=45n nf=1 m=(1)
mp2 (Y n0 VDD NW) g45p1svt w=(780n) l=45n nf=1 m=(1)
ends AND2X2

// gsclib045_backbias/AND2X4/schematic

simulator lang=spectre

subckt AND2X4 A B Y NW VSS VDD
mn2 (Y net61 VSS VSS) g45n1svt w=(1.04u) l=45n nf=1 m=(1)
mn0 (net69 A VSS VSS) g45n1svt w=(260n) l=45n nf=1 m=(1)
mn1 (net61 B net69 VSS) g45n1svt w=(260n) l=45n nf=1 m=(1)
mp1 (net61 B VDD NW) g45p1svt w=(390n) l=45n nf=1 m=(1)
mp0 (net61 A VDD NW) g45p1svt w=(390n) l=45n nf=1 m=(1)
mp2 (Y net61 VDD NW) g45p1svt w=(1.56u) l=45n nf=1 m=(1)
ends AND2X4

// gsclib045_backbias/AND2X6/schematic

simulator lang=spectre

subckt AND2X6 A B Y VDD VSS NW
mn2 (Y net61 VSS VSS) g45n1svt w=(1.55u) l=45n nf=1 m=(1)
mn0 (net61 B net69 VSS) g45n1svt w=(520n) l=45n nf=1 m=(1)
mn1 (net69 A VSS VSS) g45n1svt w=(520n) l=45n nf=1 m=(1)
mp1 (net61 B VDD NW) g45p1svt w=(780n) l=45n nf=1 m=(1)
mp0 (net61 A VDD NW) g45p1svt w=(780n) l=45n nf=1 m=(1)
mp2 (Y net61 VDD NW) g45p1svt w=(2.35u) l=45n nf=1 m=(1)
ends AND2X6

// gsclib045_backbias/AND2X8/schematic

simulator lang=spectre

subckt AND2X8 A B Y NW VSS VDD
mn2 (Y n0 VSS VSS) g45n1svt w=(2.065u) l=45n nf=1 m=(1)
mn0 (net69 A VSS VSS) g45n1svt w=(520n) l=45n nf=1 m=(1)
mn1 (n0 B net69 VSS) g45n1svt w=(520n) l=45n nf=1 m=(1)
mp1 (n0 B VDD NW) g45p1svt w=(780n) l=45n nf=1 m=(1)
mp0 (n0 A VDD NW) g45p1svt w=(780n) l=45n nf=1 m=(1)
mp2 (Y n0 VDD NW) g45p1svt w=(3.115u) l=45n nf=1 m=(1)
ends AND2X8

// gsclib045_backbias/AND2XL/schematic

simulator lang=spectre

subckt AND2XL A B Y VSS NW VDD
mn2 (Y net57 VSS VSS) g45n1svt w=(145n) l=45n nf=1 m=(1)
mn0 (net73 A VSS VSS) g45n1svt w=(145n) l=45n nf=1 m=(1)
mn1 (net57 B net73 VSS) g45n1svt w=(145n) l=45n nf=1 m=(1)
mp1 (net57 B VDD NW) g45p1svt w=(215n) l=45n nf=1 m=(1)
mp0 (net57 A VDD NW) g45p1svt w=(215n) l=45n nf=1 m=(1)
mp2 (Y net57 VDD NW) g45p1svt w=(215n) l=45n nf=1 m=(1)
ends AND2XL

// gsclib045_backbias/AND3X1/schematic

simulator lang=spectre

subckt AND3X1 A B C Y VDD VSS NW
mn3 (Y net086 VSS VSS) g45n1svt w=(260n) l=45n nf=1 m=(1)
mn1 (net0106 B net0102 VSS) g45n1svt w=(145n) l=45n nf=1 m=(1)
mn0 (net0102 A VSS VSS) g45n1svt w=(145n) l=45n nf=1 m=(1)
mn2 (net086 C net0106 VSS) g45n1svt w=(145n) l=45n nf=1 m=(1)
mp1 (net086 B VDD NW) g45p1svt w=(215n) l=45n nf=1 m=(1)
mp2 (net086 C VDD NW) g45p1svt w=(215n) l=45n nf=1 m=(1)
mp0 (net086 A VDD NW) g45p1svt w=(215n) l=45n nf=1 m=(1)
mp3 (Y net086 VDD NW) g45p1svt w=(390n) l=45n nf=1 m=(1)
ends AND3X1

// gsclib045_backbias/AND3X2/schematic

simulator lang=spectre

subckt AND3X2 A B C Y VDD VSS NW
mn3 (Y net95 VSS VSS) g45n1svt w=(520n) l=45n nf=1 m=(1)
mn1 (net111 B net103 VSS) g45n1svt w=(145n) l=45n nf=1 m=(1)
mn0 (net103 A VSS VSS) g45n1svt w=(145n) l=45n nf=1 m=(1)
mn2 (net95 C net111 VSS) g45n1svt w=(145n) l=45n nf=1 m=(1)
mp1 (net95 B VDD NW) g45p1svt w=(215n) l=45n nf=1 m=(1)
mp2 (net95 C VDD NW) g45p1svt w=(215n) l=45n nf=1 m=(1)
mp0 (net95 A VDD NW) g45p1svt w=(215n) l=45n nf=1 m=(1)
mp3 (Y net95 VDD NW) g45p1svt w=(780n) l=45n nf=1 m=(1)
ends AND3X2

// gsclib045_backbias/AND3X4/schematic

simulator lang=spectre

subckt AND3X4 A B C Y VDD VSS NW
mn3 (Y net95 VSS VSS) g45n1svt w=(1.04u) l=45n nf=1 m=(1)
mn1 (net111 B net107 VSS) g45n1svt w=(260n) l=45n nf=1 m=(1)
mn0 (net107 A VSS VSS) g45n1svt w=(260n) l=45n nf=1 m=(1)
mn2 (net95 C net111 VSS) g45n1svt w=(260n) l=45n nf=1 m=(1)
mp1 (net95 B VDD NW) g45p1svt w=(390n) l=45n nf=1 m=(1)
mp2 (net95 C VDD NW) g45p1svt w=(390n) l=45n nf=1 m=(1)
mp0 (net95 A VDD NW) g45p1svt w=(390n) l=45n nf=1 m=(1)
mp3 (Y net95 VDD NW) g45p1svt w=(1.56u) l=45n nf=1 m=(1)
ends AND3X4

// gsclib045_backbias/AND3X6/schematic

simulator lang=spectre

subckt AND3X6 A B C Y VDD NW VSS
mn3 (Y net95 VSS VSS) g45n1svt w=(1.55u) l=45n nf=1 m=(1)
mn1 (net107 B net103 VSS) g45n1svt w=(520n) l=45n nf=1 m=(1)
mn0 (net103 A VSS VSS) g45n1svt w=(520n) l=45n nf=1 m=(1)
mn2 (net95 C net107 VSS) g45n1svt w=(520n) l=45n nf=1 m=(1)
mp1 (net95 B VDD NW) g45p1svt w=(780n) l=45n nf=1 m=(1)
mp2 (net95 C VDD NW) g45p1svt w=(780n) l=45n nf=1 m=(1)
mp0 (net95 A VDD NW) g45p1svt w=(780n) l=45n nf=1 m=(1)
mp3 (Y net95 VDD NW) g45p1svt w=(2.35u) l=45n nf=1 m=(1)
ends AND3X6

// gsclib045_backbias/AND3X8/schematic

simulator lang=spectre

subckt AND3X8 A B C Y VDD VSS NW
mn3 (Y net95 VSS VSS) g45n1svt w=(2.065u) l=45n nf=1 m=(1)
mn1 (net107 B net103 VSS) g45n1svt w=(520n) l=45n nf=1 m=(1)
mn0 (net103 A VSS VSS) g45n1svt w=(520n) l=45n nf=1 m=(1)
mn2 (net95 C net107 VSS) g45n1svt w=(520n) l=45n nf=1 m=(1)
mp1 (net95 B VDD NW) g45p1svt w=(780n) l=45n nf=1 m=(1)
mp2 (net95 C VDD NW) g45p1svt w=(780n) l=45n nf=1 m=(1)
mp0 (net95 A VDD NW) g45p1svt w=(780n) l=45n nf=1 m=(1)
mp3 (Y net95 VDD NW) g45p1svt w=(3.115u) l=45n nf=1 m=(1)
ends AND3X8

// gsclib045_backbias/AND3XL/schematic

simulator lang=spectre

subckt AND3XL A B C Y VDD VSS NW
mn3 (Y net87 VSS VSS) g45n1svt w=(145n) l=45n nf=1 m=(1)
mn1 (net107 B net103 VSS) g45n1svt w=(145n) l=45n nf=1 m=(1)
mn0 (net103 A VSS VSS) g45n1svt w=(145n) l=45n nf=1 m=(1)
mn2 (net87 C net107 VSS) g45n1svt w=(145n) l=45n nf=1 m=(1)
mp1 (net87 B VDD NW) g45p1svt w=(215n) l=45n nf=1 m=(1)
mp2 (net87 C VDD NW) g45p1svt w=(215n) l=45n nf=1 m=(1)
mp0 (net87 A VDD NW) g45p1svt w=(215n) l=45n nf=1 m=(1)
mp3 (Y net87 VDD NW) g45p1svt w=(215n) l=45n nf=1 m=(1)
ends AND3XL

// gsclib045_backbias/AND4X1/schematic

simulator lang=spectre

subckt AND4X1 A B C D Y VDD VSS NW
mn3 (net116 D net132 VSS) g45n1svt w=(145n) l=45n nf=1 m=(1)
mn2 (net132 C net128 VSS) g45n1svt w=(145n) l=45n nf=1 m=(1)
mn4 (Y net116 VSS VSS) g45n1svt w=(260n) l=45n nf=1 m=(1)
mn1 (net128 B net124 VSS) g45n1svt w=(145n) l=45n nf=1 m=(1)
mn0 (net124 A VSS VSS) g45n1svt w=(145n) l=45n nf=1 m=(1)
mp3 (net116 D VDD NW) g45p1svt w=(215n) l=45n nf=1 m=(1)
mp2 (net116 C VDD NW) g45p1svt w=(215n) l=45n nf=1 m=(1)
mp1 (net116 B VDD NW) g45p1svt w=(215n) l=45n nf=1 m=(1)
mp4 (Y net116 VDD NW) g45p1svt w=(390n) l=45n nf=1 m=(1)
mp0 (net116 A VDD NW) g45p1svt w=(215n) l=45n nf=1 m=(1)
ends AND4X1

// gsclib045_backbias/AND4X2/schematic

simulator lang=spectre

subckt AND4X2 A B C D Y VSS VDD NW
mn3 (net100 D net132 VSS) g45n1svt w=(145n) l=45n nf=1 m=(1)
mn2 (net132 C net124 VSS) g45n1svt w=(145n) l=45n nf=1 m=(1)
mn4 (Y net100 VSS VSS) g45n1svt w=(520n) l=45n nf=1 m=(1)
mn1 (net124 B net120 VSS) g45n1svt w=(145n) l=45n nf=1 m=(1)
mn0 (net120 A VSS VSS) g45n1svt w=(145n) l=45n nf=1 m=(1)
mp3 (net100 D VDD NW) g45p1svt w=(215n) l=45n nf=1 m=(1)
mp2 (net100 C VDD NW) g45p1svt w=(215n) l=45n nf=1 m=(1)
mp1 (net100 B VDD NW) g45p1svt w=(215n) l=45n nf=1 m=(1)
mp4 (Y net100 VDD NW) g45p1svt w=(780n) l=45n nf=1 m=(1)
mp0 (net100 A VDD NW) g45p1svt w=(215n) l=45n nf=1 m=(1)
ends AND4X2

// gsclib045_backbias/AND4X4/schematic

simulator lang=spectre

subckt AND4X4 A B C D Y NW VDD VSS
mn3 (net100 D net132 VSS) g45n1svt w=(260n) l=45n nf=1 m=(1)
mn2 (net132 C net124 VSS) g45n1svt w=(260n) l=45n nf=1 m=(1)
mn4 (Y net100 VSS VSS) g45n1svt w=(1.04u) l=45n nf=1 m=(1)
mn1 (net124 B net120 VSS) g45n1svt w=(260n) l=45n nf=1 m=(1)
mn0 (net120 A VSS VSS) g45n1svt w=(260n) l=45n nf=1 m=(1)
mp3 (net100 D VDD NW) g45p1svt w=(390n) l=45n nf=1 m=(1)
mp2 (net100 C VDD NW) g45p1svt w=(390n) l=45n nf=1 m=(1)
mp1 (net100 B VDD NW) g45p1svt w=(390n) l=45n nf=1 m=(1)
mp4 (Y net100 VDD NW) g45p1svt w=(1.56u) l=45n nf=1 m=(1)
mp0 (net100 A VDD NW) g45p1svt w=(390n) l=45n nf=1 m=(1)
ends AND4X4

// gsclib045_backbias/AND4X6/schematic

simulator lang=spectre

subckt AND4X6 A B C D Y VDD VSS NW
mn3 (net116 D net132 VSS) g45n1svt w=(520n) l=45n nf=1 m=(1)
mn2 (net132 C net128 VSS) g45n1svt w=(520n) l=45n nf=1 m=(1)
mn4 (Y net116 VSS VSS) g45n1svt w=(1.55u) l=45n nf=1 m=(1)
mn1 (net128 B net124 VSS) g45n1svt w=(520n) l=45n nf=1 m=(1)
mn0 (net124 A VSS VSS) g45n1svt w=(520n) l=45n nf=1 m=(1)
mp3 (net116 D VDD NW) g45p1svt w=(780n) l=45n nf=1 m=(1)
mp2 (net116 C VDD NW) g45p1svt w=(780n) l=45n nf=1 m=(1)
mp1 (net116 B VDD NW) g45p1svt w=(780n) l=45n nf=1 m=(1)
mp4 (Y net116 VDD NW) g45p1svt w=(2.35u) l=45n nf=1 m=(1)
mp0 (net116 A VDD NW) g45p1svt w=(780n) l=45n nf=1 m=(1)
ends AND4X6

// gsclib045_backbias/AND4X8/schematic

simulator lang=spectre

subckt AND4X8 A B C D Y VDD VSS NW
mn3 (net116 D net132 VSS) g45n1svt w=(520n) l=45n nf=1 m=(1)
mn2 (net132 C net128 VSS) g45n1svt w=(520n) l=45n nf=1 m=(1)
mn4 (Y net116 VSS VSS) g45n1svt w=(2.065u) l=45n nf=1 m=(1)
mn1 (net128 B net124 VSS) g45n1svt w=(520n) l=45n nf=1 m=(1)
mn0 (net124 A VSS VSS) g45n1svt w=(520n) l=45n nf=1 m=(1)
mp3 (net116 D VDD NW) g45p1svt w=(780n) l=45n nf=1 m=(1)
mp2 (net116 C VDD NW) g45p1svt w=(780n) l=45n nf=1 m=(1)
mp1 (net116 B VDD NW) g45p1svt w=(780n) l=45n nf=1 m=(1)
mp4 (Y net116 VDD NW) g45p1svt w=(3.115u) l=45n nf=1 m=(1)
mp0 (net116 A VDD NW) g45p1svt w=(780n) l=45n nf=1 m=(1)
ends AND4X8

// gsclib045_backbias/AND4XL/schematic

simulator lang=spectre

subckt AND4XL A B C D Y NW VDD VSS
mn3 (net100 D net136 VSS) g45n1svt w=(145n) l=45n nf=1 m=(1)
mn2 (net136 C net128 VSS) g45n1svt w=(145n) l=45n nf=1 m=(1)
mn4 (Y net100 VSS VSS) g45n1svt w=(145n) l=45n nf=1 m=(1)
mn1 (net128 B net124 VSS) g45n1svt w=(145n) l=45n nf=1 m=(1)
mn0 (net124 A VSS VSS) g45n1svt w=(145n) l=45n nf=1 m=(1)
mp3 (net100 D VDD NW) g45p1svt w=(215n) l=45n nf=1 m=(1)
mp2 (net100 C VDD NW) g45p1svt w=(215n) l=45n nf=1 m=(1)
mp1 (net100 B VDD NW) g45p1svt w=(215n) l=45n nf=1 m=(1)
mp4 (Y net100 VDD NW) g45p1svt w=(215n) l=45n nf=1 m=(1)
mp0 (net100 A VDD NW) g45p1svt w=(215n) l=45n nf=1 m=(1)
ends AND4XL

// gsclib045_backbias/ANTENNA/schematic

simulator lang=spectre

subckt ANTENNA A VSS VDD
D1 (A VDD) g45pd1svt area=188.8f pj=1.82u m=1
D0 (VSS A) g45nd1svt area=155.1f pj=1.6u m=1
ends ANTENNA

// gsclib045_backbias/AO21X1/schematic

simulator lang=spectre

subckt AO21X1 A0 A1 B0 Y NW VSS VDD
mn1 (net049 A1 net104 VSS) g45n1svt w=(145n) l=45n nf=1 m=(1)
mn0 (net104 A0 VSS VSS) g45n1svt w=(145n) l=45n nf=1 m=(1)
mn3 (Y net049 VSS VSS) g45n1svt w=(260n) l=45n nf=1 m=(1)
mn2 (net049 B0 VSS VSS) g45n1svt w=(145n) l=45n nf=1 m=(1)
mp1 (net96 A1 VDD NW) g45p1svt w=(215n) l=45n nf=1 m=(1)
mp0 (net96 A0 VDD NW) g45p1svt w=(215n) l=45n nf=1 m=(1)
mp3 (Y net049 VDD NW) g45p1svt w=(390n) l=45n nf=1 m=(1)
mp2 (net049 B0 net96 NW) g45p1svt w=(215n) l=45n nf=1 m=(1)
ends AO21X1

// gsclib045_backbias/AO21X2/schematic

simulator lang=spectre

subckt AO21X2 A0 A1 B0 Y NW VDD VSS
mn1 (net100 A1 net104 VSS) g45n1svt w=(145n) l=45n nf=1 m=(1)
mn0 (net104 A0 VSS VSS) g45n1svt w=(145n) l=45n nf=1 m=(1)
mn3 (Y net100 VSS VSS) g45n1svt w=(520n) l=45n nf=1 m=(1)
mn2 (net100 B0 VSS VSS) g45n1svt w=(145n) l=45n nf=1 m=(1)
mp1 (net84 A1 VDD NW) g45p1svt w=(215n) l=45n nf=1 m=(1)
mp0 (net84 A0 VDD NW) g45p1svt w=(215n) l=45n nf=1 m=(1)
mp3 (Y net100 VDD NW) g45p1svt w=(780n) l=45n nf=1 m=(1)
mp2 (net100 B0 net84 NW) g45p1svt w=(215n) l=45n nf=1 m=(1)
ends AO21X2

// gsclib045_backbias/AO21X4/schematic

simulator lang=spectre

subckt AO21X4 A0 A1 B0 Y VDD VSS NW
mn1 (net100 A1 net104 VSS) g45n1svt w=(260n) l=45n nf=1 m=(1)
mn0 (net104 A0 VSS VSS) g45n1svt w=(260n) l=45n nf=1 m=(1)
mn3 (Y net100 VSS VSS) g45n1svt w=(1.04u) l=45n nf=1 m=(1)
mn2 (net100 B0 VSS VSS) g45n1svt w=(260n) l=45n nf=1 m=(1)
mp1 (net88 A1 VDD NW) g45p1svt w=(390n) l=45n nf=1 m=(1)
mp0 (net88 A0 VDD NW) g45p1svt w=(390n) l=45n nf=1 m=(1)
mp3 (Y net100 VDD NW) g45p1svt w=(1.56u) l=45n nf=1 m=(1)
mp2 (net100 B0 net88 NW) g45p1svt w=(390n) l=45n nf=1 m=(1)
ends AO21X4

// gsclib045_backbias/AO21XL/schematic

simulator lang=spectre

subckt AO21XL A0 A1 B0 Y VDD VSS NW
mn1 (n0 A1 n1 VSS) g45n1svt w=(145n) l=45n nf=1 m=(1)
mn0 (n1 A0 VSS VSS) g45n1svt w=(145n) l=45n nf=1 m=(1)
mn3 (Y n0 VSS VSS) g45n1svt w=(145n) l=45n nf=1 m=(1)
mn2 (n0 B0 VSS VSS) g45n1svt w=(145n) l=45n nf=1 m=(1)
mp1 (n2 A1 VDD NW) g45p1svt w=(215n) l=45n nf=1 m=(1)
mp0 (n2 A0 VDD NW) g45p1svt w=(215n) l=45n nf=1 m=(1)
mp3 (Y n0 VDD NW) g45p1svt w=(215n) l=45n nf=1 m=(1)
mp2 (n0 B0 n2 NW) g45p1svt w=(215n) l=45n nf=1 m=(1)
ends AO21XL

// gsclib045_backbias/AO22X1/schematic

simulator lang=spectre

subckt AO22X1 A0 A1 B0 B1 Y NW VDD VSS
mn3 (n0 B1 n2 VSS) g45n1svt w=(145n) l=45n nf=1 m=(1)
mn2 (n2 B0 VSS VSS) g45n1svt w=(145n) l=45n nf=1 m=(1)
mn1 (n0 A1 n1 VSS) g45n1svt w=(145n) l=45n nf=1 m=(1)
mn0 (n1 A0 VSS VSS) g45n1svt w=(145n) l=45n nf=1 m=(1)
mn4 (Y n0 VSS VSS) g45n1svt w=(260n) l=45n nf=1 m=(1)
mp3 (n0 B1 n3 NW) g45p1svt w=(215n) l=45n nf=1 m=(1)
mp2 (n0 B0 n3 NW) g45p1svt w=(215n) l=45n nf=1 m=(1)
mp1 (n3 A1 VDD NW) g45p1svt w=(215n) l=45n nf=1 m=(1)
mp0 (n3 A0 VDD NW) g45p1svt w=(215n) l=45n nf=1 m=(1)
mp4 (Y n0 VDD NW) g45p1svt w=(390n) l=45n nf=1 m=(1)
ends AO22X1

// gsclib045_backbias/AO22X2/schematic

simulator lang=spectre

subckt AO22X2 A0 A1 B0 B1 Y VSS VDD NW
mn3 (net128 B1 net132 VSS) g45n1svt w=(145n) l=45n nf=1 m=(1)
mn2 (net132 B0 VSS VSS) g45n1svt w=(145n) l=45n nf=1 m=(1)
mn1 (net128 A1 net124 VSS) g45n1svt w=(145n) l=45n nf=1 m=(1)
mn0 (net124 A0 VSS VSS) g45n1svt w=(145n) l=45n nf=1 m=(1)
mn4 (Y net128 VSS VSS) g45n1svt w=(520n) l=45n nf=1 m=(1)
mp3 (net128 B1 net111 NW) g45p1svt w=(215n) l=45n nf=1 m=(1)
mp2 (net128 B0 net111 NW) g45p1svt w=(215n) l=45n nf=1 m=(1)
mp1 (net111 A1 VDD NW) g45p1svt w=(215n) l=45n nf=1 m=(1)
mp0 (net111 A0 VDD NW) g45p1svt w=(215n) l=45n nf=1 m=(1)
mp4 (Y net128 VDD NW) g45p1svt w=(780n) l=45n nf=1 m=(1)
ends AO22X2

// gsclib045_backbias/AO22X4/schematic

simulator lang=spectre

subckt AO22X4 A0 A1 B0 B1 Y VDD NW VSS
mn3 (n0 B1 n2 VSS) g45n1svt w=(260n) l=45n nf=1 m=(1)
mn2 (n2 B0 VSS VSS) g45n1svt w=(260n) l=45n nf=1 m=(1)
mn1 (n0 A1 n1 VSS) g45n1svt w=(260n) l=45n nf=1 m=(1)
mn0 (n1 A0 VSS VSS) g45n1svt w=(260n) l=45n nf=1 m=(1)
mn4 (Y n0 VSS VSS) g45n1svt w=(1.04u) l=45n nf=1 m=(1)
mp3 (n0 B1 n3 NW) g45p1svt w=(390n) l=45n nf=1 m=(1)
mp2 (n0 B0 n3 NW) g45p1svt w=(390n) l=45n nf=1 m=(1)
mp1 (n3 A1 VDD NW) g45p1svt w=(390n) l=45n nf=1 m=(1)
mp0 (n3 A0 VDD NW) g45p1svt w=(390n) l=45n nf=1 m=(1)
mp4 (Y n0 VDD NW) g45p1svt w=(1.56u) l=45n nf=1 m=(1)
ends AO22X4

// gsclib045_backbias/AO22XL/schematic

simulator lang=spectre

subckt AO22XL A0 A1 B0 B1 Y NW VDD VSS
mn3 (n0 B1 n2 VSS) g45n1svt w=(145n) l=45n nf=1 m=(1)
mn2 (n2 B0 VSS VSS) g45n1svt w=(145n) l=45n nf=1 m=(1)
mn1 (n0 A1 n1 VSS) g45n1svt w=(145n) l=45n nf=1 m=(1)
mn0 (n1 A0 VSS VSS) g45n1svt w=(145n) l=45n nf=1 m=(1)
mn4 (Y n0 VSS VSS) g45n1svt w=(145n) l=45n nf=1 m=(1)
mp3 (n0 B1 n3 NW) g45p1svt w=(215n) l=45n nf=1 m=(1)
mp2 (n0 B0 n3 NW) g45p1svt w=(215n) l=45n nf=1 m=(1)
mp1 (n3 A1 VDD NW) g45p1svt w=(215n) l=45n nf=1 m=(1)
mp0 (n3 A0 VDD NW) g45p1svt w=(215n) l=45n nf=1 m=(1)
mp4 (Y n0 VDD NW) g45p1svt w=(215n) l=45n nf=1 m=(1)
ends AO22XL

// gsclib045_backbias/AOI211X1/schematic

simulator lang=spectre

subckt AOI211X1 A0 A1 B0 C0 Y VSS VDD NW
mn2 (Y B0 VSS VSS) g45n1svt w=(260n) l=45n nf=1 m=(1)
mn3 (Y C0 VSS VSS) g45n1svt w=(260n) l=45n nf=1 m=(1)
mn1 (Y A1 net95 VSS) g45n1svt w=(260n) l=45n nf=1 m=(1)
mn0 (net95 A0 VSS VSS) g45n1svt w=(260n) l=45n nf=1 m=(1)
mp3 (Y C0 net82 NW) g45p1svt w=(390n) l=45n nf=1 m=(1)
mp2 (net82 B0 net91 NW) g45p1svt w=(390n) l=45n nf=1 m=(1)
mp1 (net91 A1 VDD NW) g45p1svt w=(390n) l=45n nf=1 m=(1)
mp0 (net91 A0 VDD NW) g45p1svt w=(390n) l=45n nf=1 m=(1)
ends AOI211X1

// gsclib045_backbias/AOI211X2/schematic

simulator lang=spectre

subckt AOI211X2 A0 A1 B0 C0 Y VSS VDD NW
mn2 (Y B0 VSS VSS) g45n1svt w=(520n) l=45n nf=1 m=(1)
mn3 (Y C0 VSS VSS) g45n1svt w=(520n) l=45n nf=1 m=(1)
mn1 (Y A1 net95 VSS) g45n1svt w=(520n) l=45n nf=1 m=(1)
mn0 (net95 A0 VSS VSS) g45n1svt w=(520n) l=45n nf=1 m=(1)
mp3 (Y C0 net82 NW) g45p1svt w=(780n) l=45n nf=1 m=(1)
mp2 (net82 B0 net91 NW) g45p1svt w=(780n) l=45n nf=1 m=(1)
mp1 (net91 A1 VDD NW) g45p1svt w=(780n) l=45n nf=1 m=(1)
mp0 (net91 A0 VDD NW) g45p1svt w=(780n) l=45n nf=1 m=(1)
ends AOI211X2

// gsclib045_backbias/AOI211X4/schematic

simulator lang=spectre

subckt AOI211X4 A0 A1 B0 C0 Y VSS NW VDD
mn2 (Y B0 VSS VSS) g45n1svt w=(1.04u) l=45n nf=1 m=(1)
mn3 (Y C0 VSS VSS) g45n1svt w=(1.04u) l=45n nf=1 m=(1)
mn1 (Y A1 net99 VSS) g45n1svt w=(1.04u) l=45n nf=1 m=(1)
mn0 (net99 A0 VSS VSS) g45n1svt w=(1.04u) l=45n nf=1 m=(1)
mp3 (Y C0 net82 NW) g45p1svt w=(1.56u) l=45n nf=1 m=(1)
mp2 (net82 B0 net91 NW) g45p1svt w=(1.56u) l=45n nf=1 m=(1)
mp1 (net91 A1 VDD NW) g45p1svt w=(1.56u) l=45n nf=1 m=(1)
mp0 (net91 A0 VDD NW) g45p1svt w=(1.56u) l=45n nf=1 m=(1)
ends AOI211X4

// gsclib045_backbias/AOI211XL/schematic

simulator lang=spectre

subckt AOI211XL A0 A1 B0 C0 Y VSS VDD NW
mn2 (Y B0 VSS VSS) g45n1svt w=(145n) l=45n nf=1 m=(1)
mn3 (Y C0 VSS VSS) g45n1svt w=(145n) l=45n nf=1 m=(1)
mn1 (Y A1 net95 VSS) g45n1svt w=(145n) l=45n nf=1 m=(1)
mn0 (net95 A0 VSS VSS) g45n1svt w=(145n) l=45n nf=1 m=(1)
mp3 (Y C0 net82 NW) g45p1svt w=(215n) l=45n nf=1 m=(1)
mp2 (net82 B0 net91 NW) g45p1svt w=(215n) l=45n nf=1 m=(1)
mp1 (net91 A1 VDD NW) g45p1svt w=(215n) l=45n nf=1 m=(1)
mp0 (net91 A0 VDD NW) g45p1svt w=(215n) l=45n nf=1 m=(1)
ends AOI211XL

// gsclib045_backbias/AOI21X1/schematic

simulator lang=spectre

subckt AOI21X1 A0 A1 B0 Y VDD VSS NW
mn2 (Y B0 VSS VSS) g45n1svt w=(260n) l=45n nf=1 m=(1)
mn0 (net78 A0 VSS VSS) g45n1svt w=(260n) l=45n nf=1 m=(1)
mn1 (Y A1 net78 VSS) g45n1svt w=(260n) l=45n nf=1 m=(1)
mp2 (Y B0 net62 NW) g45p1svt w=(390n) l=45n nf=1 m=(1)
mp1 (net62 A1 VDD NW) g45p1svt w=(390n) l=45n nf=1 m=(1)
mp0 (net62 A0 VDD NW) g45p1svt w=(390n) l=45n nf=1 m=(1)
ends AOI21X1

// gsclib045_backbias/AOI21X2/schematic

simulator lang=spectre

subckt AOI21X2 A0 A1 B0 Y VSS NW VDD
mn2 (Y B0 VSS VSS) g45n1svt w=(520n) l=45n nf=1 m=(1)
mn0 (net74 A0 VSS VSS) g45n1svt w=(520n) l=45n nf=1 m=(1)
mn1 (Y A1 net74 VSS) g45n1svt w=(520n) l=45n nf=1 m=(1)
mp2 (Y B0 net70 NW) g45p1svt w=(780n) l=45n nf=1 m=(1)
mp1 (net70 A1 VDD NW) g45p1svt w=(780n) l=45n nf=1 m=(1)
mp0 (net70 A0 VDD NW) g45p1svt w=(780n) l=45n nf=1 m=(1)
ends AOI21X2

// gsclib045_backbias/AOI21X4/schematic

simulator lang=spectre

subckt AOI21X4 A0 A1 B0 Y VDD NW VSS
mn2 (Y B0 VSS VSS) g45n1svt w=(1.04u) l=45n nf=1 m=(1)
mn0 (net82 A0 VSS VSS) g45n1svt w=(1.04u) l=45n nf=1 m=(1)
mn1 (Y A1 net82 VSS) g45n1svt w=(1.04u) l=45n nf=1 m=(1)
mp2 (Y B0 net70 NW) g45p1svt w=(1.56u) l=45n nf=1 m=(1)
mp1 (net70 A1 VDD NW) g45p1svt w=(1.56u) l=45n nf=1 m=(1)
mp0 (net70 A0 VDD NW) g45p1svt w=(1.56u) l=45n nf=1 m=(1)
ends AOI21X4

// gsclib045_backbias/AOI21XL/schematic

simulator lang=spectre

subckt AOI21XL A0 A1 B0 Y VDD NW VSS
mn2 (Y B0 VSS VSS) g45n1svt w=(145n) l=45n nf=1 m=(1)
mn0 (net74 A0 VSS VSS) g45n1svt w=(145n) l=45n nf=1 m=(1)
mn1 (Y A1 net74 VSS) g45n1svt w=(145n) l=45n nf=1 m=(1)
mp2 (Y B0 net70 NW) g45p1svt w=(215n) l=45n nf=1 m=(1)
mp1 (net70 A1 VDD NW) g45p1svt w=(215n) l=45n nf=1 m=(1)
mp0 (net70 A0 VDD NW) g45p1svt w=(215n) l=45n nf=1 m=(1)
ends AOI21XL

// gsclib045_backbias/AOI221X1/schematic

simulator lang=spectre

subckt AOI221X1 A0 A1 B0 B1 C0 Y VSS VDD NW
mn2 (net120 B0 VSS VSS) g45n1svt w=(260n) l=45n nf=1 m=(1)
mn3 (Y B1 net120 VSS) g45n1svt w=(260n) l=45n nf=1 m=(1)
mn4 (Y C0 VSS VSS) g45n1svt w=(260n) l=45n nf=1 m=(1)
mn1 (Y A1 net128 VSS) g45n1svt w=(260n) l=45n nf=1 m=(1)
mn0 (net128 A0 VSS VSS) g45n1svt w=(260n) l=45n nf=1 m=(1)
mp3 (net108 B1 net111 NW) g45p1svt w=(390n) l=45n nf=1 m=(1)
mp2 (net108 B0 net111 NW) g45p1svt w=(390n) l=45n nf=1 m=(1)
mp0 (net111 A0 VDD NW) g45p1svt w=(390n) l=45n nf=1 m=(1)
mp1 (net111 A1 VDD NW) g45p1svt w=(390n) l=45n nf=1 m=(1)
mp4 (Y C0 net108 NW) g45p1svt w=(390n) l=45n nf=1 m=(1)
ends AOI221X1

// gsclib045_backbias/AOI221X2/schematic

simulator lang=spectre

subckt AOI221X2 A0 A1 B0 B1 C0 Y NW VSS VDD
mn2 (Y B0 net116 VSS) g45n1svt w=(520n) l=45n nf=1 m=(1)
mn3 (net116 B1 VSS VSS) g45n1svt w=(520n) l=45n nf=1 m=(1)
mn4 (Y C0 VSS VSS) g45n1svt w=(520n) l=45n nf=1 m=(1)
mn1 (Y A1 net124 VSS) g45n1svt w=(520n) l=45n nf=1 m=(1)
mn0 (net124 A0 VSS VSS) g45n1svt w=(520n) l=45n nf=1 m=(1)
mp3 (net104 B1 net103 NW) g45p1svt w=(780n) l=45n nf=1 m=(1)
mp2 (net104 B0 net103 NW) g45p1svt w=(780n) l=45n nf=1 m=(1)
mp0 (net103 A0 VDD NW) g45p1svt w=(780n) l=45n nf=1 m=(1)
mp1 (net103 A1 VDD NW) g45p1svt w=(780n) l=45n nf=1 m=(1)
mp4 (Y C0 net104 NW) g45p1svt w=(780n) l=45n nf=1 m=(1)
ends AOI221X2

// gsclib045_backbias/AOI221X4/schematic

simulator lang=spectre

subckt AOI221X4 A0 A1 B0 B1 C0 Y VSS VDD NW
mn2 (net116 B0 VSS VSS) g45n1svt w=(1.04u) l=45n nf=1 m=(1)
mn3 (Y B1 net116 VSS) g45n1svt w=(1.04u) l=45n nf=1 m=(1)
mn4 (Y C0 VSS VSS) g45n1svt w=(1.04u) l=45n nf=1 m=(1)
mn1 (Y A1 net120 VSS) g45n1svt w=(1.04u) l=45n nf=1 m=(1)
mn0 (net120 A0 VSS VSS) g45n1svt w=(1.04u) l=45n nf=1 m=(1)
mp3 (net104 B1 net107 NW) g45p1svt w=(1.56u) l=45n nf=1 m=(1)
mp2 (net104 B0 net107 NW) g45p1svt w=(1.56u) l=45n nf=1 m=(1)
mp0 (net107 A0 VDD NW) g45p1svt w=(1.56u) l=45n nf=1 m=(1)
mp1 (net107 A1 VDD NW) g45p1svt w=(1.56u) l=45n nf=1 m=(1)
mp4 (Y C0 net104 NW) g45p1svt w=(1.56u) l=45n nf=1 m=(1)
ends AOI221X4

// gsclib045_backbias/AOI221XL/schematic

simulator lang=spectre

subckt AOI221XL A0 A1 B0 B1 C0 Y NW VSS VDD
mn2 (net116 B0 VSS VSS) g45n1svt w=(145n) l=45n nf=1 m=(1)
mn3 (Y B1 net116 VSS) g45n1svt w=(145n) l=45n nf=1 m=(1)
mn4 (Y C0 VSS VSS) g45n1svt w=(145n) l=45n nf=1 m=(1)
mn1 (Y A1 net124 VSS) g45n1svt w=(145n) l=45n nf=1 m=(1)
mn0 (net124 A0 VSS VSS) g45n1svt w=(145n) l=45n nf=1 m=(1)
mp3 (net104 B1 net107 NW) g45p1svt w=(215n) l=45n nf=1 m=(1)
mp2 (net104 B0 net107 NW) g45p1svt w=(215n) l=45n nf=1 m=(1)
mp0 (net107 A0 VDD NW) g45p1svt w=(215n) l=45n nf=1 m=(1)
mp1 (net107 A1 VDD NW) g45p1svt w=(215n) l=45n nf=1 m=(1)
mp4 (Y C0 net104 NW) g45p1svt w=(215n) l=45n nf=1 m=(1)
ends AOI221XL

// gsclib045_backbias/AOI222X1/schematic

simulator lang=spectre

subckt AOI222X1 A0 A1 B0 B1 C0 C1 Y VDD VSS NW
mn5 (Y C1 net155 VSS) g45n1svt w=(260n) l=45n nf=1 m=(1)
mn4 (net155 C0 VSS VSS) g45n1svt w=(260n) l=45n nf=1 m=(1)
mn2 (net147 B0 VSS VSS) g45n1svt w=(260n) l=45n nf=1 m=(1)
mn0 (net139 A0 VSS VSS) g45n1svt w=(260n) l=45n nf=1 m=(1)
mn1 (Y A1 net139 VSS) g45n1svt w=(260n) l=45n nf=1 m=(1)
mn3 (Y B1 net147 VSS) g45n1svt w=(260n) l=45n nf=1 m=(1)
mp5 (Y C1 net118 NW) g45p1svt w=(390n) l=45n nf=1 m=(1)
mp4 (Y C0 net118 NW) g45p1svt w=(390n) l=45n nf=1 m=(1)
mp3 (net118 B1 net122 NW) g45p1svt w=(390n) l=45n nf=1 m=(1)
mp2 (net118 B0 net122 NW) g45p1svt w=(390n) l=45n nf=1 m=(1)
mp0 (net122 A0 VDD NW) g45p1svt w=(390n) l=45n nf=1 m=(1)
mp1 (net122 A1 VDD NW) g45p1svt w=(390n) l=45n nf=1 m=(1)
ends AOI222X1

// gsclib045_backbias/AOI222X2/schematic

simulator lang=spectre

subckt AOI222X2 A0 A1 B0 B1 C0 C1 Y NW VSS VDD
mn5 (Y C1 net155 VSS) g45n1svt w=(520n) l=45n nf=1 m=(1)
mn4 (net155 C0 VSS VSS) g45n1svt w=(520n) l=45n nf=1 m=(1)
mn2 (net151 B0 VSS VSS) g45n1svt w=(520n) l=45n nf=1 m=(1)
mn0 (net147 A0 VSS VSS) g45n1svt w=(520n) l=45n nf=1 m=(1)
mn1 (Y A1 net147 VSS) g45n1svt w=(520n) l=45n nf=1 m=(1)
mn3 (Y B1 net151 VSS) g45n1svt w=(520n) l=45n nf=1 m=(1)
mp5 (Y C1 net134 NW) g45p1svt w=(780n) l=45n nf=1 m=(1)
mp4 (Y C0 net134 NW) g45p1svt w=(780n) l=45n nf=1 m=(1)
mp3 (net134 B1 net126 NW) g45p1svt w=(780n) l=45n nf=1 m=(1)
mp2 (net134 B0 net126 NW) g45p1svt w=(780n) l=45n nf=1 m=(1)
mp0 (net126 A0 VDD NW) g45p1svt w=(780n) l=45n nf=1 m=(1)
mp1 (net126 A1 VDD NW) g45p1svt w=(780n) l=45n nf=1 m=(1)
ends AOI222X2

// gsclib045_backbias/AOI222X4/schematic

simulator lang=spectre

subckt AOI222X4 A0 A1 B0 B1 C0 C1 Y VSS NW VDD
mn5 (Y C1 net139 VSS) g45n1svt w=(1.04u) l=45n nf=1 m=(1)
mn4 (net139 C0 VSS VSS) g45n1svt w=(1.04u) l=45n nf=1 m=(1)
mn2 (net143 B0 VSS VSS) g45n1svt w=(1.04u) l=45n nf=1 m=(1)
mn0 (net147 A0 VSS VSS) g45n1svt w=(1.04u) l=45n nf=1 m=(1)
mn1 (Y A1 net147 VSS) g45n1svt w=(1.04u) l=45n nf=1 m=(1)
mn3 (Y B1 net143 VSS) g45n1svt w=(1.04u) l=45n nf=1 m=(1)
mp5 (Y C1 net122 NW) g45p1svt w=(1.56u) l=45n nf=1 m=(1)
mp4 (Y C0 net122 NW) g45p1svt w=(1.56u) l=45n nf=1 m=(1)
mp3 (net122 B1 net130 NW) g45p1svt w=(1.56u) l=45n nf=1 m=(1)
mp2 (net122 B0 net130 NW) g45p1svt w=(1.56u) l=45n nf=1 m=(1)
mp0 (net130 A0 VDD NW) g45p1svt w=(1.56u) l=45n nf=1 m=(1)
mp1 (net130 A1 VDD NW) g45p1svt w=(1.56u) l=45n nf=1 m=(1)
ends AOI222X4

// gsclib045_backbias/AOI222XL/schematic

simulator lang=spectre

subckt AOI222XL A0 A1 B0 B1 C0 C1 Y VSS VDD NW
mn5 (Y C1 net155 VSS) g45n1svt w=(145n) l=45n nf=1 m=(1)
mn4 (net155 C0 VSS VSS) g45n1svt w=(145n) l=45n nf=1 m=(1)
mn2 (net147 B0 VSS VSS) g45n1svt w=(145n) l=45n nf=1 m=(1)
mn0 (net139 A0 VSS VSS) g45n1svt w=(145n) l=45n nf=1 m=(1)
mn1 (Y A1 net139 VSS) g45n1svt w=(145n) l=45n nf=1 m=(1)
mn3 (Y B1 net147 VSS) g45n1svt w=(145n) l=45n nf=1 m=(1)
mp5 (Y C1 net122 NW) g45p1svt w=(215n) l=45n nf=1 m=(1)
mp4 (Y C0 net122 NW) g45p1svt w=(215n) l=45n nf=1 m=(1)
mp3 (net122 B1 net134 NW) g45p1svt w=(215n) l=45n nf=1 m=(1)
mp2 (net122 B0 net134 NW) g45p1svt w=(215n) l=45n nf=1 m=(1)
mp0 (net134 A0 VDD NW) g45p1svt w=(215n) l=45n nf=1 m=(1)
mp1 (net134 A1 VDD NW) g45p1svt w=(215n) l=45n nf=1 m=(1)
ends AOI222XL

// gsclib045_backbias/AOI22X1/schematic

simulator lang=spectre

subckt AOI22X1 A0 A1 B0 B1 Y VSS NW VDD
mn3 (Y B1 net98 VSS) g45n1svt w=(260n) l=45n nf=1 m=(1)
mn0 (net102 A0 VSS VSS) g45n1svt w=(260n) l=45n nf=1 m=(1)
mn2 (net98 B0 VSS VSS) g45n1svt w=(260n) l=45n nf=1 m=(1)
mn1 (Y A1 net102 VSS) g45n1svt w=(260n) l=45n nf=1 m=(1)
mp3 (Y B1 net89 NW) g45p1svt w=(390n) l=45n nf=1 m=(1)
mp0 (net89 A0 VDD NW) g45p1svt w=(390n) l=45n nf=1 m=(1)
mp1 (net89 A1 VDD NW) g45p1svt w=(390n) l=45n nf=1 m=(1)
mp2 (Y B0 net89 NW) g45p1svt w=(390n) l=45n nf=1 m=(1)
ends AOI22X1

// gsclib045_backbias/AOI22X2/schematic

simulator lang=spectre

subckt AOI22X2 A0 A1 B0 B1 Y NW VSS VDD
mn3 (Y B1 net106 VSS) g45n1svt w=(520n) l=45n nf=1 m=(1)
mn0 (net98 A0 VSS VSS) g45n1svt w=(520n) l=45n nf=1 m=(1)
mn2 (net106 B0 VSS VSS) g45n1svt w=(520n) l=45n nf=1 m=(1)
mn1 (Y A1 net98 VSS) g45n1svt w=(520n) l=45n nf=1 m=(1)
mp3 (Y B1 net89 NW) g45p1svt w=(780n) l=45n nf=1 m=(1)
mp0 (net89 A0 VDD NW) g45p1svt w=(780n) l=45n nf=1 m=(1)
mp1 (net89 A1 VDD NW) g45p1svt w=(780n) l=45n nf=1 m=(1)
mp2 (Y B0 net89 NW) g45p1svt w=(780n) l=45n nf=1 m=(1)
ends AOI22X2

// gsclib045_backbias/AOI22X4/schematic

simulator lang=spectre

subckt AOI22X4 A0 A1 B0 B1 Y VSS NW VDD
mn3 (Y B1 net102 VSS) g45n1svt w=(1.04u) l=45n nf=1 m=(1)
mn0 (net98 A0 VSS VSS) g45n1svt w=(1.04u) l=45n nf=1 m=(1)
mn2 (net102 B0 VSS VSS) g45n1svt w=(1.04u) l=45n nf=1 m=(1)
mn1 (Y A1 net98 VSS) g45n1svt w=(1.04u) l=45n nf=1 m=(1)
mp3 (Y B1 net89 NW) g45p1svt w=(1.56u) l=45n nf=1 m=(1)
mp0 (net89 A0 VDD NW) g45p1svt w=(1.56u) l=45n nf=1 m=(1)
mp1 (net89 A1 VDD NW) g45p1svt w=(1.56u) l=45n nf=1 m=(1)
mp2 (Y B0 net89 NW) g45p1svt w=(1.56u) l=45n nf=1 m=(1)
ends AOI22X4

// gsclib045_backbias/AOI22XL/schematic

simulator lang=spectre

subckt AOI22XL A0 A1 B0 B1 Y VSS NW VDD
mn3 (Y B1 net98 VSS) g45n1svt w=(145n) l=45n nf=1 m=(1)
mn0 (net106 A0 VSS VSS) g45n1svt w=(145n) l=45n nf=1 m=(1)
mn2 (net98 B0 VSS VSS) g45n1svt w=(145n) l=45n nf=1 m=(1)
mn1 (Y A1 net106 VSS) g45n1svt w=(145n) l=45n nf=1 m=(1)
mp3 (Y B1 net89 NW) g45p1svt w=(215n) l=45n nf=1 m=(1)
mp0 (net89 A0 VDD NW) g45p1svt w=(215n) l=45n nf=1 m=(1)
mp1 (net89 A1 VDD NW) g45p1svt w=(215n) l=45n nf=1 m=(1)
mp2 (Y B0 net89 NW) g45p1svt w=(215n) l=45n nf=1 m=(1)
ends AOI22XL

// gsclib045_backbias/AOI2BB1X1/schematic

simulator lang=spectre

subckt AOI2BB1X1 A0N A1N B0 Y VDD VSS NW
mn2 (Y B0 VSS VSS) g45n1svt w=(260n) l=45n nf=1 m=(1)
mn1 (n0 A1N VSS VSS) g45n1svt w=(145n) l=45n nf=1 m=(1)
mn3 (Y n0 VSS VSS) g45n1svt w=(260n) l=45n nf=1 m=(1)
mn0 (n0 A0N VSS VSS) g45n1svt w=(145n) l=45n nf=1 m=(1)
mp3 (Y n0 n2 NW) g45p1svt w=(390n) l=45n nf=1 m=(1)
mp2 (n2 B0 VDD NW) g45p1svt w=(390n) l=45n nf=1 m=(1)
mp1 (n0 A1N n1 NW) g45p1svt w=(215n) l=45n nf=1 m=(1)
mp0 (n1 A0N VDD NW) g45p1svt w=(215n) l=45n nf=1 m=(1)
ends AOI2BB1X1

// gsclib045_backbias/AOI2BB1X2/schematic

simulator lang=spectre

subckt AOI2BB1X2 A0N A1N B0 Y VDD NW VSS
mn2 (Y B0 VSS VSS) g45n1svt w=(520n) l=45n nf=1 m=(1)
mn1 (net104 A1N VSS VSS) g45n1svt w=(145n) l=45n nf=1 m=(1)
mn3 (Y net104 VSS VSS) g45n1svt w=(520n) l=45n nf=1 m=(1)
mn0 (net104 A0N VSS VSS) g45n1svt w=(145n) l=45n nf=1 m=(1)
mp3 (Y net104 net79 NW) g45p1svt w=(780n) l=45n nf=1 m=(1)
mp2 (net79 B0 VDD NW) g45p1svt w=(780n) l=45n nf=1 m=(1)
mp1 (net104 A1N net87 NW) g45p1svt w=(215n) l=45n nf=1 m=(1)
mp0 (net87 A0N VDD NW) g45p1svt w=(215n) l=45n nf=1 m=(1)
ends AOI2BB1X2

// gsclib045_backbias/AOI2BB1X4/schematic

simulator lang=spectre

subckt AOI2BB1X4 A0N A1N B0 Y NW VDD VSS
mn2 (Y B0 VSS VSS) g45n1svt w=(1.04u) l=45n nf=1 m=(1)
mn1 (net104 A1N VSS VSS) g45n1svt w=(260n) l=45n nf=1 m=(1)
mn3 (Y net104 VSS VSS) g45n1svt w=(1.04u) l=45n nf=1 m=(1)
mn0 (net104 A0N VSS VSS) g45n1svt w=(260n) l=45n nf=1 m=(1)
mp3 (Y net104 net79 NW) g45p1svt w=(1.56u) l=45n nf=1 m=(1)
mp2 (net79 B0 VDD NW) g45p1svt w=(1.56u) l=45n nf=1 m=(1)
mp1 (net104 A1N net87 NW) g45p1svt w=(390n) l=45n nf=1 m=(1)
mp0 (net87 A0N VDD NW) g45p1svt w=(390n) l=45n nf=1 m=(1)
ends AOI2BB1X4

// gsclib045_backbias/AOI2BB1XL/schematic

simulator lang=spectre

subckt AOI2BB1XL A0N A1N B0 Y NW VDD VSS
mn2 (Y B0 VSS VSS) g45n1svt w=(145n) l=45n nf=1 m=(1)
mn1 (net100 A1N VSS VSS) g45n1svt w=(145n) l=45n nf=1 m=(1)
mn3 (Y net100 VSS VSS) g45n1svt w=(145n) l=45n nf=1 m=(1)
mn0 (net100 A0N VSS VSS) g45n1svt w=(145n) l=45n nf=1 m=(1)
mp3 (Y net100 net79 NW) g45p1svt w=(215n) l=45n nf=1 m=(1)
mp2 (net79 B0 VDD NW) g45p1svt w=(215n) l=45n nf=1 m=(1)
mp1 (net100 A1N net87 NW) g45p1svt w=(215n) l=45n nf=1 m=(1)
mp0 (net87 A0N VDD NW) g45p1svt w=(215n) l=45n nf=1 m=(1)
ends AOI2BB1XL

// gsclib045_backbias/AOI2BB2X1/schematic

simulator lang=spectre

subckt AOI2BB2X1 A0N A1N B0 B1 Y NW VSS VDD
mn5 (n3 B1 VSS VSS) g45n1svt w=(260n) l=45n nf=1 m=(1)
mn4 (Y B0 n3 VSS) g45n1svt w=(260n) l=45n nf=1 m=(1)
mn3 (Y n1 n2 VSS) g45n1svt w=(260n) l=45n nf=1 m=(1)
mn2 (n2 n0 VSS VSS) g45n1svt w=(260n) l=45n nf=1 m=(1)
mn0 (n0 A0N VSS VSS) g45n1svt w=(145n) l=45n nf=1 m=(1)
mn1 (n1 A1N VSS VSS) g45n1svt w=(145n) l=45n nf=1 m=(1)
mp5 (Y B1 n4 NW) g45p1svt w=(390n) l=45n nf=1 m=(1)
mp4 (Y B0 n4 NW) g45p1svt w=(390n) l=45n nf=1 m=(1)
mp2 (n4 n0 VDD NW) g45p1svt w=(390n) l=45n nf=1 m=(1)
mp0 (n0 A0N VDD NW) g45p1svt w=(215n) l=45n nf=1 m=(1)
mp1 (n1 A1N VDD NW) g45p1svt w=(215n) l=45n nf=1 m=(1)
mp3 (n4 n1 VDD NW) g45p1svt w=(390n) l=45n nf=1 m=(1)
ends AOI2BB2X1

// gsclib045_backbias/AOI2BB2X2/schematic

simulator lang=spectre

subckt AOI2BB2X2 A0N A1N B0 B1 Y NW VSS VDD
mn5 (n3 B1 VSS VSS) g45n1svt w=(520n) l=45n nf=1 m=(1)
mn4 (Y B0 n3 VSS) g45n1svt w=(520n) l=45n nf=1 m=(1)
mn3 (Y n1 n2 VSS) g45n1svt w=(520n) l=45n nf=1 m=(1)
mn2 (n2 n0 VSS VSS) g45n1svt w=(520n) l=45n nf=1 m=(1)
mn0 (n0 A0N VSS VSS) g45n1svt w=(145n) l=45n nf=1 m=(1)
mn1 (n1 A1N VSS VSS) g45n1svt w=(145n) l=45n nf=1 m=(1)
mp5 (Y B1 n4 NW) g45p1svt w=(780n) l=45n nf=1 m=(1)
mp4 (Y B0 n4 NW) g45p1svt w=(780n) l=45n nf=1 m=(1)
mp2 (n4 n0 VDD NW) g45p1svt w=(780n) l=45n nf=1 m=(1)
mp0 (n0 A0N VDD NW) g45p1svt w=(215n) l=45n nf=1 m=(1)
mp1 (n1 A1N VDD NW) g45p1svt w=(215n) l=45n nf=1 m=(1)
mp3 (n4 n1 VDD NW) g45p1svt w=(780n) l=45n nf=1 m=(1)
ends AOI2BB2X2

// gsclib045_backbias/AOI2BB2X4/schematic

simulator lang=spectre

subckt AOI2BB2X4 A0N A1N B0 B1 Y VSS NW VDD
mn5 (net152 B1 VSS VSS) g45n1svt w=(1.04u) l=45n nf=1 m=(1)
mn4 (Y B0 net152 VSS) g45n1svt w=(1.04u) l=45n nf=1 m=(1)
mn3 (Y net144 net160 VSS) g45n1svt w=(1.04u) l=45n nf=1 m=(1)
mn2 (net160 net148 VSS VSS) g45n1svt w=(1.04u) l=45n nf=1 m=(1)
mn0 (net148 A0N VSS VSS) g45n1svt w=(260n) l=45n nf=1 m=(1)
mn1 (net144 A1N VSS VSS) g45n1svt w=(260n) l=45n nf=1 m=(1)
mp5 (Y B1 net127 NW) g45p1svt w=(1.56u) l=45n nf=1 m=(1)
mp4 (Y B0 net127 NW) g45p1svt w=(1.56u) l=45n nf=1 m=(1)
mp2 (net127 net148 VDD NW) g45p1svt w=(1.56u) l=45n nf=1 m=(1)
mp0 (net148 A0N VDD NW) g45p1svt w=(390n) l=45n nf=1 m=(1)
mp1 (net144 A1N VDD NW) g45p1svt w=(390n) l=45n nf=1 m=(1)
mp3 (net127 net144 VDD NW) g45p1svt w=(1.56u) l=45n nf=1 m=(1)
ends AOI2BB2X4

// gsclib045_backbias/AOI2BB2XL/schematic

simulator lang=spectre

subckt AOI2BB2XL A0N A1N B0 B1 Y VDD VSS NW
mn5 (net156 B1 VSS VSS) g45n1svt w=(145n) l=45n nf=1 m=(1)
mn4 (Y B0 net156 VSS) g45n1svt w=(145n) l=45n nf=1 m=(1)
mn3 (Y net164 net144 VSS) g45n1svt w=(145n) l=45n nf=1 m=(1)
mn2 (net144 net146 VSS VSS) g45n1svt w=(145n) l=45n nf=1 m=(1)
mn0 (net146 A0N VSS VSS) g45n1svt w=(145n) l=45n nf=1 m=(1)
mn1 (net164 A1N VSS VSS) g45n1svt w=(145n) l=45n nf=1 m=(1)
mp5 (Y B1 net124 NW) g45p1svt w=(215n) l=45n nf=1 m=(1)
mp4 (Y B0 net124 NW) g45p1svt w=(215n) l=45n nf=1 m=(1)
mp2 (net124 net146 VDD NW) g45p1svt w=(215n) l=45n nf=1 m=(1)
mp0 (net146 A0N VDD NW) g45p1svt w=(215n) l=45n nf=1 m=(1)
mp1 (net164 A1N VDD NW) g45p1svt w=(215n) l=45n nf=1 m=(1)
mp3 (net124 net164 VDD NW) g45p1svt w=(215n) l=45n nf=1 m=(1)
ends AOI2BB2XL

// gsclib045_backbias/AOI31X1/schematic

simulator lang=spectre

subckt AOI31X1 A0 A1 A2 B0 Y VDD VSS NW
mn3 (Y B0 VSS VSS) g45n1svt w=(260n) l=45n nf=1 m=(1)
mn1 (net97 A1 net93 VSS) g45n1svt w=(260n) l=45n nf=1 m=(1)
mn2 (Y A2 net97 VSS) g45n1svt w=(260n) l=45n nf=1 m=(1)
mn0 (net93 A0 VSS VSS) g45n1svt w=(260n) l=45n nf=1 m=(1)
mp2 (net81 A2 VDD NW) g45p1svt w=(390n) l=45n nf=1 m=(1)
mp3 (Y B0 net81 NW) g45p1svt w=(390n) l=45n nf=1 m=(1)
mp1 (net81 A1 VDD NW) g45p1svt w=(390n) l=45n nf=1 m=(1)
mp0 (net81 A0 VDD NW) g45p1svt w=(390n) l=45n nf=1 m=(1)
ends AOI31X1

// gsclib045_backbias/AOI31X2/schematic

simulator lang=spectre

subckt AOI31X2 A0 A1 A2 B0 Y VSS NW VDD
mn3 (Y B0 VSS VSS) g45n1svt w=(520n) l=45n nf=1 m=(1)
mn1 (net100 A1 net104 VSS) g45n1svt w=(520n) l=45n nf=1 m=(1)
mn2 (Y A2 net100 VSS) g45n1svt w=(520n) l=45n nf=1 m=(1)
mn0 (net104 A0 VSS VSS) g45n1svt w=(520n) l=45n nf=1 m=(1)
mp2 (net81 A2 VDD NW) g45p1svt w=(780n) l=45n nf=1 m=(1)
mp3 (Y B0 net81 NW) g45p1svt w=(780n) l=45n nf=1 m=(1)
mp1 (net81 A1 VDD NW) g45p1svt w=(780n) l=45n nf=1 m=(1)
mp0 (net81 A0 VDD NW) g45p1svt w=(780n) l=45n nf=1 m=(1)
ends AOI31X2

// gsclib045_backbias/AOI31X4/schematic

simulator lang=spectre

subckt AOI31X4 A0 A1 A2 B0 Y VSS VDD NW
mn3 (Y B0 VSS VSS) g45n1svt w=(1.04u) l=45n nf=1 m=(1)
mn1 (net101 A1 net97 VSS) g45n1svt w=(1.04u) l=45n nf=1 m=(1)
mn2 (Y A2 net101 VSS) g45n1svt w=(1.04u) l=45n nf=1 m=(1)
mn0 (net97 A0 VSS VSS) g45n1svt w=(1.04u) l=45n nf=1 m=(1)
mp2 (net89 A2 VDD NW) g45p1svt w=(1.56u) l=45n nf=1 m=(1)
mp3 (Y B0 net89 NW) g45p1svt w=(1.56u) l=45n nf=1 m=(1)
mp1 (net89 A1 VDD NW) g45p1svt w=(1.56u) l=45n nf=1 m=(1)
mp0 (net89 A0 VDD NW) g45p1svt w=(1.56u) l=45n nf=1 m=(1)
ends AOI31X4

// gsclib045_backbias/AOI31XL/schematic

simulator lang=spectre

subckt AOI31XL A0 A1 A2 B0 Y VSS NW VDD
mn3 (Y B0 VSS VSS) g45n1svt w=(145n) l=45n nf=1 m=(1)
mn1 (net101 A1 net97 VSS) g45n1svt w=(145n) l=45n nf=1 m=(1)
mn2 (Y A2 net101 VSS) g45n1svt w=(145n) l=45n nf=1 m=(1)
mn0 (net97 A0 VSS VSS) g45n1svt w=(145n) l=45n nf=1 m=(1)
mp2 (net89 A2 VDD NW) g45p1svt w=(215n) l=45n nf=1 m=(1)
mp3 (Y B0 net89 NW) g45p1svt w=(215n) l=45n nf=1 m=(1)
mp1 (net89 A1 VDD NW) g45p1svt w=(215n) l=45n nf=1 m=(1)
mp0 (net89 A0 VDD NW) g45p1svt w=(215n) l=45n nf=1 m=(1)
ends AOI31XL

// gsclib045_backbias/AOI32X1/schematic

simulator lang=spectre

subckt AOI32X1 A0 A1 A2 B0 B1 Y VSS NW VDD
mn3 (net118 B0 VSS VSS) g45n1svt w=(260n) l=45n nf=1 m=(1)
mn2 (Y A2 net126 VSS) g45n1svt w=(260n) l=45n nf=1 m=(1)
mn0 (net122 A0 VSS VSS) g45n1svt w=(260n) l=45n nf=1 m=(1)
mn1 (net126 A1 net122 VSS) g45n1svt w=(260n) l=45n nf=1 m=(1)
mn4 (Y B1 net118 VSS) g45n1svt w=(260n) l=45n nf=1 m=(1)
mp3 (Y B0 net114 NW) g45p1svt w=(390n) l=45n nf=1 m=(1)
mp4 (Y B1 net114 NW) g45p1svt w=(390n) l=45n nf=1 m=(1)
mp2 (net114 A2 VDD NW) g45p1svt w=(390n) l=45n nf=1 m=(1)
mp1 (net114 A1 VDD NW) g45p1svt w=(390n) l=45n nf=1 m=(1)
mp0 (net114 A0 VDD NW) g45p1svt w=(390n) l=45n nf=1 m=(1)
ends AOI32X1

// gsclib045_backbias/AOI32X2/schematic

simulator lang=spectre

subckt AOI32X2 A0 A1 A2 B0 B1 Y VDD NW VSS
mn3 (net83 B0 VSS VSS) g45n1svt w=(520n) l=45n nf=1 m=(1)
mn2 (Y A2 net71 VSS) g45n1svt w=(520n) l=45n nf=1 m=(1)
mn0 (net75 A0 VSS VSS) g45n1svt w=(520n) l=45n nf=1 m=(1)
mn1 (net71 A1 net75 VSS) g45n1svt w=(520n) l=45n nf=1 m=(1)
mn4 (Y B1 net83 VSS) g45n1svt w=(520n) l=45n nf=1 m=(1)
mp3 (Y B0 net47 NW) g45p1svt w=(780n) l=45n nf=1 m=(1)
mp4 (Y B1 net47 NW) g45p1svt w=(780n) l=45n nf=1 m=(1)
mp2 (net47 A2 VDD NW) g45p1svt w=(780n) l=45n nf=1 m=(1)
mp1 (net47 A1 VDD NW) g45p1svt w=(780n) l=45n nf=1 m=(1)
mp0 (net47 A0 VDD NW) g45p1svt w=(780n) l=45n nf=1 m=(1)
ends AOI32X2

// gsclib045_backbias/AOI32X4/schematic

simulator lang=spectre

subckt AOI32X4 A0 A1 A2 B0 B1 Y VDD NW VSS
mn3 (net118 B0 VSS VSS) g45n1svt w=(1.04u) l=45n nf=1 m=(1)
mn2 (Y A2 net126 VSS) g45n1svt w=(1.04u) l=45n nf=1 m=(1)
mn0 (net122 A0 VSS VSS) g45n1svt w=(1.04u) l=45n nf=1 m=(1)
mn1 (net126 A1 net122 VSS) g45n1svt w=(1.04u) l=45n nf=1 m=(1)
mn4 (Y B1 net118 VSS) g45n1svt w=(1.04u) l=45n nf=1 m=(1)
mp3 (Y B0 net106 NW) g45p1svt w=(1.56u) l=45n nf=1 m=(1)
mp4 (Y B1 net106 NW) g45p1svt w=(1.56u) l=45n nf=1 m=(1)
mp2 (net106 A2 VDD NW) g45p1svt w=(1.56u) l=45n nf=1 m=(1)
mp1 (net106 A1 VDD NW) g45p1svt w=(1.56u) l=45n nf=1 m=(1)
mp0 (net106 A0 VDD NW) g45p1svt w=(1.56u) l=45n nf=1 m=(1)
ends AOI32X4

// gsclib045_backbias/AOI32XL/schematic

simulator lang=spectre

subckt AOI32XL A0 A1 A2 B0 B1 Y NW VSS VDD
mn3 (net118 B0 VSS VSS) g45n1svt w=(145n) l=45n nf=1 m=(1)
mn2 (Y A2 net130 VSS) g45n1svt w=(145n) l=45n nf=1 m=(1)
mn0 (net126 A0 VSS VSS) g45n1svt w=(145n) l=45n nf=1 m=(1)
mn1 (net130 A1 net126 VSS) g45n1svt w=(145n) l=45n nf=1 m=(1)
mn4 (Y B1 net118 VSS) g45n1svt w=(145n) l=45n nf=1 m=(1)
mp3 (Y B0 net114 NW) g45p1svt w=(215n) l=45n nf=1 m=(1)
mp4 (Y B1 net114 NW) g45p1svt w=(215n) l=45n nf=1 m=(1)
mp2 (net114 A2 VDD NW) g45p1svt w=(215n) l=45n nf=1 m=(1)
mp1 (net114 A1 VDD NW) g45p1svt w=(215n) l=45n nf=1 m=(1)
mp0 (net114 A0 VDD NW) g45p1svt w=(215n) l=45n nf=1 m=(1)
ends AOI32XL

// gsclib045_backbias/AOI33X1/schematic

simulator lang=spectre

subckt AOI33X1 A0 A1 A2 B0 B1 B2 Y VSS VDD NW
mn1 (net157 A1 net149 VSS) g45n1svt w=(260n) l=45n nf=1 m=(1)
mn4 (net141 B1 net137 VSS) g45n1svt w=(260n) l=45n nf=1 m=(1)
mn3 (net137 B0 VSS VSS) g45n1svt w=(260n) l=45n nf=1 m=(1)
mn5 (Y B2 net141 VSS) g45n1svt w=(260n) l=45n nf=1 m=(1)
mn0 (net149 A0 VSS VSS) g45n1svt w=(260n) l=45n nf=1 m=(1)
mn2 (Y A2 net157 VSS) g45n1svt w=(260n) l=45n nf=1 m=(1)
mp0 (net059 A0 VDD NW) g45p1svt w=(390n) l=45n nf=1 m=(1)
mp1 (net059 A1 VDD NW) g45p1svt w=(390n) l=45n nf=1 m=(1)
mp4 (Y B1 net059 NW) g45p1svt w=(390n) l=45n nf=1 m=(1)
mp5 (Y B2 net059 NW) g45p1svt w=(390n) l=45n nf=1 m=(1)
mp2 (net059 A2 VDD NW) g45p1svt w=(390n) l=45n nf=1 m=(1)
mp3 (Y B0 net059 NW) g45p1svt w=(390n) l=45n nf=1 m=(1)
ends AOI33X1

// gsclib045_backbias/AOI33X2/schematic

simulator lang=spectre

subckt AOI33X2 A0 A1 A2 B0 B1 B2 Y VSS VDD NW
mn1 (net153 A1 net149 VSS) g45n1svt w=(520n) l=45n nf=1 m=(1)
mn4 (net141 B1 net137 VSS) g45n1svt w=(520n) l=45n nf=1 m=(1)
mn3 (net137 B0 VSS VSS) g45n1svt w=(520n) l=45n nf=1 m=(1)
mn5 (Y B2 net141 VSS) g45n1svt w=(520n) l=45n nf=1 m=(1)
mn0 (net149 A0 VSS VSS) g45n1svt w=(520n) l=45n nf=1 m=(1)
mn2 (Y A2 net153 VSS) g45n1svt w=(520n) l=45n nf=1 m=(1)
mp0 (net124 A0 VDD NW) g45p1svt w=(780n) l=45n nf=1 m=(1)
mp1 (net124 A1 VDD NW) g45p1svt w=(780n) l=45n nf=1 m=(1)
mp4 (Y B1 net124 NW) g45p1svt w=(780n) l=45n nf=1 m=(1)
mp5 (Y B2 net124 NW) g45p1svt w=(780n) l=45n nf=1 m=(1)
mp2 (net124 A2 VDD NW) g45p1svt w=(780n) l=45n nf=1 m=(1)
mp3 (Y B0 net124 NW) g45p1svt w=(780n) l=45n nf=1 m=(1)
ends AOI33X2

// gsclib045_backbias/AOI33X4/schematic

simulator lang=spectre

subckt AOI33X4 A0 A1 A2 B0 B1 B2 Y VSS VDD NW
mn1 (net153 A1 net149 VSS) g45n1svt w=(1.04u) l=45n nf=1 m=(1)
mn4 (net141 B1 net137 VSS) g45n1svt w=(1.04u) l=45n nf=1 m=(1)
mn3 (net137 B0 VSS VSS) g45n1svt w=(1.04u) l=45n nf=1 m=(1)
mn5 (Y B2 net141 VSS) g45n1svt w=(1.04u) l=45n nf=1 m=(1)
mn0 (net149 A0 VSS VSS) g45n1svt w=(1.04u) l=45n nf=1 m=(1)
mn2 (Y A2 net153 VSS) g45n1svt w=(1.04u) l=45n nf=1 m=(1)
mp0 (net124 A0 VDD NW) g45p1svt w=(1.56u) l=45n nf=1 m=(1)
mp1 (net124 A1 VDD NW) g45p1svt w=(1.56u) l=45n nf=1 m=(1)
mp4 (Y B1 net124 NW) g45p1svt w=(1.56u) l=45n nf=1 m=(1)
mp5 (Y B2 net124 NW) g45p1svt w=(1.56u) l=45n nf=1 m=(1)
mp2 (net124 A2 VDD NW) g45p1svt w=(1.56u) l=45n nf=1 m=(1)
mp3 (Y B0 net124 NW) g45p1svt w=(1.56u) l=45n nf=1 m=(1)
ends AOI33X4

// gsclib045_backbias/AOI33XL/schematic

simulator lang=spectre

subckt AOI33XL A0 A1 A2 B0 B1 B2 Y VSS VDD NW
mn1 (net153 A1 net149 VSS) g45n1svt w=(145n) l=45n nf=1 m=(1)
mn4 (net137 B1 VSS VSS) g45n1svt w=(145n) l=45n nf=1 m=(1)
mn3 (net141 B0 net137 VSS) g45n1svt w=(145n) l=45n nf=1 m=(1)
mn5 (Y B2 net141 VSS) g45n1svt w=(145n) l=45n nf=1 m=(1)
mn0 (net149 A0 VSS VSS) g45n1svt w=(145n) l=45n nf=1 m=(1)
mn2 (Y A2 net153 VSS) g45n1svt w=(145n) l=45n nf=1 m=(1)
mp0 (net124 A0 VDD NW) g45p1svt w=(215n) l=45n nf=1 m=(1)
mp1 (net124 A1 VDD NW) g45p1svt w=(215n) l=45n nf=1 m=(1)
mp4 (Y B1 net124 NW) g45p1svt w=(215n) l=45n nf=1 m=(1)
mp5 (Y B2 net124 NW) g45p1svt w=(215n) l=45n nf=1 m=(1)
mp2 (net124 A2 VDD NW) g45p1svt w=(215n) l=45n nf=1 m=(1)
mp3 (Y B0 net124 NW) g45p1svt w=(215n) l=45n nf=1 m=(1)
ends AOI33XL

// gsclib045_backbias/BUFX12/schematic

simulator lang=spectre

subckt BUFX12 A Y NW VSS VDD
mn1 (VSS n0 Y VSS) g45n1svt w=(3.1u) l=45n nf=1 m=(1)
mn0 (VSS A n0 VSS) g45n1svt w=(780n) l=45n nf=1 m=(1)
mp1 (Y n0 VDD NW) g45p1svt w=(4.7u) l=45n nf=1 m=(1)
mp0 (n0 A VDD NW) g45p1svt w=(1.17u) l=45n nf=1 m=(1)
ends BUFX12

// gsclib045_backbias/BUFX16/schematic

simulator lang=spectre

subckt BUFX16 A Y VSS VDD NW
mn1 (VSS n0 Y VSS) g45n1svt w=(4.13u) l=45n nf=1 m=(1)
mn0 (VSS A n0 VSS) g45n1svt w=(1.04u) l=45n nf=1 m=(1)
mp1 (Y n0 VDD NW) g45p1svt w=(6.23u) l=45n nf=1 m=(1)
mp0 (n0 A VDD NW) g45p1svt w=(1.56u) l=45n nf=1 m=(1)
ends BUFX16

// gsclib045_backbias/BUFX2/schematic

simulator lang=spectre

subckt BUFX2 A Y VSS NW VDD
mn1 (VSS n0 Y VSS) g45n1svt w=(520n) l=45n nf=1 m=(1)
mn0 (VSS A n0 VSS) g45n1svt w=(145n) l=45n nf=1 m=(1)
mp1 (Y n0 VDD NW) g45p1svt w=(780n) l=45n nf=1 m=(1)
mp0 (n0 A VDD NW) g45p1svt w=(215n) l=45n nf=1 m=(1)
ends BUFX2

// gsclib045_backbias/BUFX20/schematic

simulator lang=spectre

subckt BUFX20 A Y NW VDD VSS
mn1 (VSS n0 Y VSS) g45n1svt w=(5.185u) l=45n nf=1 m=(1)
mn0 (VSS A n0 VSS) g45n1svt w=(1.3u) l=45n nf=1 m=(1)
mp1 (Y n0 VDD NW) g45p1svt w=(7.82u) l=45n nf=1 m=(1)
mp0 (n0 A VDD NW) g45p1svt w=(1.95u) l=45n nf=1 m=(1)
ends BUFX20

// gsclib045_backbias/BUFX3/schematic

simulator lang=spectre

subckt BUFX3 A Y VSS VDD NW
mn1 (VSS n0 Y VSS) g45n1svt w=(780n) l=45n nf=1 m=(1)
mn0 (VSS A n0 VSS) g45n1svt w=(260n) l=45n nf=1 m=(1)
mp1 (Y n0 VDD NW) g45p1svt w=(1.17u) l=45n nf=1 m=(1)
mp0 (n0 A VDD NW) g45p1svt w=(390n) l=45n nf=1 m=(1)
ends BUFX3

// gsclib045_backbias/BUFX4/schematic

simulator lang=spectre

subckt BUFX4 A Y NW VSS VDD
mn1 (VSS n0 Y VSS) g45n1svt w=(1.04u) l=45n nf=1 m=(1)
mn0 (VSS A n0 VSS) g45n1svt w=(260n) l=45n nf=1 m=(1)
mp1 (Y n0 VDD NW) g45p1svt w=(1.56u) l=45n nf=1 m=(1)
mp0 (n0 A VDD NW) g45p1svt w=(390n) l=45n nf=1 m=(1)
ends BUFX4

// gsclib045_backbias/BUFX6/schematic

simulator lang=spectre

subckt BUFX6 A Y VSS NW VDD
mn1 (VSS n0 Y VSS) g45n1svt w=(1.55u) l=45n nf=1 m=(1)
mn0 (VSS A n0 VSS) g45n1svt w=(520n) l=45n nf=1 m=(1)
mp1 (Y n0 VDD NW) g45p1svt w=(2.35u) l=45n nf=1 m=(1)
mp0 (n0 A VDD NW) g45p1svt w=(780n) l=45n nf=1 m=(1)
ends BUFX6

// gsclib045_backbias/BUFX8/schematic

simulator lang=spectre

subckt BUFX8 A Y NW VSS VDD
mn1 (VSS n0 Y VSS) g45n1svt w=(2.065u) l=45n nf=1 m=(1)
mn0 (VSS A n0 VSS) g45n1svt w=(520n) l=45n nf=1 m=(1)
mp1 (Y n0 VDD NW) g45p1svt w=(3.115u) l=45n nf=1 m=(1)
mp0 (n0 A VDD NW) g45p1svt w=(780n) l=45n nf=1 m=(1)
ends BUFX8

// gsclib045_backbias/TBUFX1/schematic

simulator lang=spectre

subckt TBUFX1 A OE Y NW VSS VDD
mn5 (Y non VSS VSS) g45n1svt w=(260n) l=45n nf=1 m=(1)
mn3 (net144 A VSS VSS) g45n1svt w=(145n) l=45n nf=1 m=(1)
mn0 (OEb OE VSS VSS) g45n1svt w=(145n) l=45n nf=1 m=(1)
mn4 (pon OE net144 VSS) g45n1svt w=(145n) l=45n nf=1 m=(1)
mn2 (non OEb VSS VSS) g45n1svt w=(145n) l=45n nf=1 m=(1)
mn1 (non A VSS VSS) g45n1svt w=(145n) l=45n nf=1 m=(1)
mp2 (non OEb net127 NW) g45p1svt w=(215n) l=45n nf=1 m=(1)
mp1 (net127 A VDD NW) g45p1svt w=(215n) l=45n nf=1 m=(1)
mp5 (Y pon VDD NW) g45p1svt w=(390n) l=45n nf=1 m=(1)
mp3 (pon A VDD NW) g45p1svt w=(215n) l=45n nf=1 m=(1)
mp4 (pon OE VDD NW) g45p1svt w=(215n) l=45n nf=1 m=(1)
mp0 (OEb OE VDD NW) g45p1svt w=(215n) l=45n nf=1 m=(1)
ends TBUFX1

// gsclib045_backbias/TBUFX12/schematic

simulator lang=spectre

subckt TBUFX12 A OE Y VDD VSS NW
mn5 (Y non VSS VSS) g45n1svt w=(3.12u) l=45n nf=1 m=(1)
mn3 (net144 A VSS VSS) g45n1svt w=(770n) l=45n nf=1 m=(1)
mn0 (OEb OE VSS VSS) g45n1svt w=(260n) l=45n nf=1 m=(1)
mn4 (pon OE net144 VSS) g45n1svt w=(770n) l=45n nf=1 m=(1)
mn2 (non OEb VSS VSS) g45n1svt w=(770n) l=45n nf=1 m=(1)
mn1 (non A VSS VSS) g45n1svt w=(770n) l=45n nf=1 m=(1)
mp2 (non OEb net127 NW) g45p1svt w=(1.17u) l=45n nf=1 m=(1)
mp1 (net127 A VDD NW) g45p1svt w=(1.17u) l=45n nf=1 m=(1)
mp5 (Y pon VDD NW) g45p1svt w=(4.68u) l=45n nf=1 m=(1)
mp3 (pon A VDD NW) g45p1svt w=(1.17u) l=45n nf=1 m=(1)
mp4 (pon OE VDD NW) g45p1svt w=(1.17u) l=45n nf=1 m=(1)
mp0 (OEb OE VDD NW) g45p1svt w=(390n) l=45n nf=1 m=(1)
ends TBUFX12

// gsclib045_backbias/TBUFX16/schematic

simulator lang=spectre

subckt TBUFX16 A OE Y VDD VSS NW
mn5 (Y non VSS VSS) g45n1svt w=(4.16u) l=45n nf=1 m=(1)
mn3 (net144 A VSS VSS) g45n1svt w=(1.025u) l=45n nf=1 m=(1)
mn0 (OEb OE VSS VSS) g45n1svt w=(260n) l=45n nf=1 m=(1)
mn4 (pon OE net144 VSS) g45n1svt w=(1.025u) l=45n nf=1 m=(1)
mn2 (non OEb VSS VSS) g45n1svt w=(1.025u) l=45n nf=1 m=(1)
mn1 (non A VSS VSS) g45n1svt w=(1.025u) l=45n nf=1 m=(1)
mp2 (non OEb net127 NW) g45p1svt w=(1.55u) l=45n nf=1 m=(1)
mp1 (net127 A VDD NW) g45p1svt w=(1.55u) l=45n nf=1 m=(1)
mp5 (Y pon VDD NW) g45p1svt w=(6.24u) l=45n nf=1 m=(1)
mp3 (pon A VDD NW) g45p1svt w=(1.55u) l=45n nf=1 m=(1)
mp4 (pon OE VDD NW) g45p1svt w=(1.55u) l=45n nf=1 m=(1)
mp0 (OEb OE VDD NW) g45p1svt w=(390n) l=45n nf=1 m=(1)
ends TBUFX16

// gsclib045_backbias/TBUFX2/schematic

simulator lang=spectre

subckt TBUFX2 A OE Y NW VDD VSS
mn5 (Y non VSS VSS) g45n1svt w=(520n) l=45n nf=1 m=(1)
mn3 (net144 A VSS VSS) g45n1svt w=(145n) l=45n nf=1 m=(1)
mn0 (OEb OE VSS VSS) g45n1svt w=(145n) l=45n nf=1 m=(1)
mn4 (pon OE net144 VSS) g45n1svt w=(145n) l=45n nf=1 m=(1)
mn2 (non OEb VSS VSS) g45n1svt w=(145n) l=45n nf=1 m=(1)
mn1 (non A VSS VSS) g45n1svt w=(145n) l=45n nf=1 m=(1)
mp2 (non OEb net127 NW) g45p1svt w=(215n) l=45n nf=1 m=(1)
mp1 (net127 A VDD NW) g45p1svt w=(215n) l=45n nf=1 m=(1)
mp5 (Y pon VDD NW) g45p1svt w=(780n) l=45n nf=1 m=(1)
mp3 (pon A VDD NW) g45p1svt w=(215n) l=45n nf=1 m=(1)
mp4 (pon OE VDD NW) g45p1svt w=(215n) l=45n nf=1 m=(1)
mp0 (OEb OE VDD NW) g45p1svt w=(215n) l=45n nf=1 m=(1)
ends TBUFX2

// gsclib045_backbias/TBUFX20/schematic

simulator lang=spectre

subckt TBUFX20 A OE Y VDD VSS NW
mn5 (Y non VSS VSS) g45n1svt w=(5.2u) l=45n nf=1 m=(1)
mn3 (net144 A VSS VSS) g45n1svt w=(1.29u) l=45n nf=1 m=(1)
mn0 (OEb OE VSS VSS) g45n1svt w=(520n) l=45n nf=1 m=(1)
mn4 (pon OE net144 VSS) g45n1svt w=(1.29u) l=45n nf=1 m=(1)
mn2 (non OEb VSS VSS) g45n1svt w=(1.29u) l=45n nf=1 m=(1)
mn1 (non A VSS VSS) g45n1svt w=(1.29u) l=45n nf=1 m=(1)
mp2 (non OEb net127 NW) g45p1svt w=(1.95u) l=45n nf=1 m=(1)
mp1 (net127 A VDD NW) g45p1svt w=(1.95u) l=45n nf=1 m=(1)
mp5 (Y pon VDD NW) g45p1svt w=(7.8u) l=45n nf=1 m=(1)
mp3 (pon A VDD NW) g45p1svt w=(1.95u) l=45n nf=1 m=(1)
mp4 (pon OE VDD NW) g45p1svt w=(1.95u) l=45n nf=1 m=(1)
mp0 (OEb OE VDD NW) g45p1svt w=(780n) l=45n nf=1 m=(1)
ends TBUFX20

// gsclib045_backbias/TBUFX3/schematic

simulator lang=spectre

subckt TBUFX3 A OE Y NW VDD VSS
mn5 (Y non VSS VSS) g45n1svt w=(780n) l=45n nf=1 m=(1)
mn3 (net144 A VSS VSS) g45n1svt w=(260n) l=45n nf=1 m=(1)
mn0 (OEb OE VSS VSS) g45n1svt w=(145n) l=45n nf=1 m=(1)
mn4 (pon OE net144 VSS) g45n1svt w=(260n) l=45n nf=1 m=(1)
mn2 (non OEb VSS VSS) g45n1svt w=(260n) l=45n nf=1 m=(1)
mn1 (non A VSS VSS) g45n1svt w=(260n) l=45n nf=1 m=(1)
mp2 (non OEb net127 NW) g45p1svt w=(390n) l=45n nf=1 m=(1)
mp1 (net127 A VDD NW) g45p1svt w=(390n) l=45n nf=1 m=(1)
mp5 (Y pon VDD NW) g45p1svt w=(1.17u) l=45n nf=1 m=(1)
mp3 (pon A VDD NW) g45p1svt w=(390n) l=45n nf=1 m=(1)
mp4 (pon OE VDD NW) g45p1svt w=(390n) l=45n nf=1 m=(1)
mp0 (OEb OE VDD NW) g45p1svt w=(215n) l=45n nf=1 m=(1)
ends TBUFX3

// gsclib045_backbias/TBUFX4/schematic

simulator lang=spectre

subckt TBUFX4 A OE Y NW VDD VSS
mn5 (Y non VSS VSS) g45n1svt w=(1.04u) l=45n nf=1 m=(1)
mn3 (net144 A VSS VSS) g45n1svt w=(260n) l=45n nf=1 m=(1)
mn0 (OEb OE VSS VSS) g45n1svt w=(145n) l=45n nf=1 m=(1)
mn4 (pon OE net144 VSS) g45n1svt w=(260n) l=45n nf=1 m=(1)
mn2 (non OEb VSS VSS) g45n1svt w=(260n) l=45n nf=1 m=(1)
mn1 (non A VSS VSS) g45n1svt w=(260n) l=45n nf=1 m=(1)
mp2 (non OEb net127 NW) g45p1svt w=(390n) l=45n nf=1 m=(1)
mp1 (net127 A VDD NW) g45p1svt w=(390n) l=45n nf=1 m=(1)
mp5 (Y pon VDD NW) g45p1svt w=(1.56u) l=45n nf=1 m=(1)
mp3 (pon A VDD NW) g45p1svt w=(390n) l=45n nf=1 m=(1)
mp4 (pon OE VDD NW) g45p1svt w=(390n) l=45n nf=1 m=(1)
mp0 (OEb OE VDD NW) g45p1svt w=(215n) l=45n nf=1 m=(1)
ends TBUFX4

// gsclib045_backbias/TBUFX6/schematic

simulator lang=spectre

subckt TBUFX6 A OE Y VDD VSS NW
mn5 (Y non VSS VSS) g45n1svt w=(1.56u) l=45n nf=1 m=(1)
mn3 (net144 A VSS VSS) g45n1svt w=(515n) l=45n nf=1 m=(1)
mn0 (OEb OE VSS VSS) g45n1svt w=(145n) l=45n nf=1 m=(1)
mn4 (pon OE net144 VSS) g45n1svt w=(515n) l=45n nf=1 m=(1)
mn2 (non OEb VSS VSS) g45n1svt w=(515n) l=45n nf=1 m=(1)
mn1 (non A VSS VSS) g45n1svt w=(515n) l=45n nf=1 m=(1)
mp2 (non OEb net127 NW) g45p1svt w=(780n) l=45n nf=1 m=(1)
mp1 (net127 A VDD NW) g45p1svt w=(780n) l=45n nf=1 m=(1)
mp5 (Y pon VDD NW) g45p1svt w=(2.34u) l=45n nf=1 m=(1)
mp3 (pon A VDD NW) g45p1svt w=(780n) l=45n nf=1 m=(1)
mp4 (pon OE VDD NW) g45p1svt w=(780n) l=45n nf=1 m=(1)
mp0 (OEb OE VDD NW) g45p1svt w=(215n) l=45n nf=1 m=(1)
ends TBUFX6

// gsclib045_backbias/TBUFX8/schematic

simulator lang=spectre

subckt TBUFX8 A OE Y VDD VSS NW
mn5 (Y non VSS VSS) g45n1svt w=(2.08u) l=45n nf=1 m=(1)
mn3 (net144 A VSS VSS) g45n1svt w=(515n) l=45n nf=1 m=(1)
mn0 (OEb OE VSS VSS) g45n1svt w=(145n) l=45n nf=1 m=(1)
mn4 (pon OE net144 VSS) g45n1svt w=(515n) l=45n nf=1 m=(1)
mn2 (non OEb VSS VSS) g45n1svt w=(515n) l=45n nf=1 m=(1)
mn1 (non A VSS VSS) g45n1svt w=(515n) l=45n nf=1 m=(1)
mp2 (non OEb net127 NW) g45p1svt w=(780n) l=45n nf=1 m=(1)
mp1 (net127 A VDD NW) g45p1svt w=(780n) l=45n nf=1 m=(1)
mp5 (Y pon VDD NW) g45p1svt w=(3.12u) l=45n nf=1 m=(1)
mp3 (pon A VDD NW) g45p1svt w=(780n) l=45n nf=1 m=(1)
mp4 (pon OE VDD NW) g45p1svt w=(780n) l=45n nf=1 m=(1)
mp0 (OEb OE VDD NW) g45p1svt w=(215n) l=45n nf=1 m=(1)
ends TBUFX8

// gsclib045_backbias/TBUFXL/schematic

simulator lang=spectre

subckt TBUFXL A OE Y NW VDD VSS
mn5 (Y non VSS VSS) g45n1svt w=(145n) l=45n nf=1 m=(1)
mn3 (net144 A VSS VSS) g45n1svt w=(145n) l=45n nf=1 m=(1)
mn0 (OEb OE VSS VSS) g45n1svt w=(145n) l=45n nf=1 m=(1)
mn4 (pon OE net144 VSS) g45n1svt w=(145n) l=45n nf=1 m=(1)
mn2 (non OEb VSS VSS) g45n1svt w=(145n) l=45n nf=1 m=(1)
mn1 (non A VSS VSS) g45n1svt w=(145n) l=45n nf=1 m=(1)
mp2 (non OEb net127 NW) g45p1svt w=(215n) l=45n nf=1 m=(1)
mp1 (net127 A VDD NW) g45p1svt w=(215n) l=45n nf=1 m=(1)
mp5 (Y pon VDD NW) g45p1svt w=(215n) l=45n nf=1 m=(1)
mp3 (pon A VDD NW) g45p1svt w=(215n) l=45n nf=1 m=(1)
mp4 (pon OE VDD NW) g45p1svt w=(215n) l=45n nf=1 m=(1)
mp0 (OEb OE VDD NW) g45p1svt w=(215n) l=45n nf=1 m=(1)
ends TBUFXL

// gsclib045_backbias/CLKAND2X12/schematic

simulator lang=spectre

subckt CLKAND2X12 A B Y VDD VSS NW
mn2 (Y net61 VSS VSS) g45n1svt w=(3.1u) l=45n nf=1 m=(1)
mn0 (net69 A VSS VSS) g45n1svt w=(1.55u) l=45n nf=1 m=(1)
mn1 (net61 B net69 VSS) g45n1svt w=(1.55u) l=45n nf=1 m=(1)
mp1 (net61 B VDD NW) g45p1svt w=(1.175u) l=45n nf=1 m=(1)
mp0 (net61 A VDD NW) g45p1svt w=(1.175u) l=45n nf=1 m=(1)
mp2 (Y net61 VDD NW) g45p1svt w=(4.7u) l=45n nf=1 m=(1)
ends CLKAND2X12

// gsclib045_backbias/CLKAND2X2/schematic

simulator lang=spectre

subckt CLKAND2X2 A B Y NW VDD VSS
mn2 (Y net61 VSS VSS) g45n1svt w=(520n) l=45n nf=1 m=(1)
mn0 (net69 A VSS VSS) g45n1svt w=(290n) l=45n nf=1 m=(1)
mn1 (net61 B net69 VSS) g45n1svt w=(290n) l=45n nf=1 m=(1)
mp1 (net61 B VDD NW) g45p1svt w=(215n) l=45n nf=1 m=(1)
mp0 (net61 A VDD NW) g45p1svt w=(215n) l=45n nf=1 m=(1)
mp2 (Y net61 VDD NW) g45p1svt w=(780n) l=45n nf=1 m=(1)
ends CLKAND2X2

// gsclib045_backbias/CLKAND2X3/schematic

simulator lang=spectre

subckt CLKAND2X3 A B Y NW VDD VSS
mn2 (Y net61 VSS VSS) g45n1svt w=(780n) l=45n nf=1 m=(1)
mn0 (net69 A VSS VSS) g45n1svt w=(520n) l=45n nf=1 m=(1)
mn1 (net61 B net69 VSS) g45n1svt w=(520n) l=45n nf=1 m=(1)
mp1 (net61 B VDD NW) g45p1svt w=(390n) l=45n nf=1 m=(1)
mp0 (net61 A VDD NW) g45p1svt w=(390n) l=45n nf=1 m=(1)
mp2 (Y net61 VDD NW) g45p1svt w=(1.17u) l=45n nf=1 m=(1)
ends CLKAND2X3

// gsclib045_backbias/CLKAND2X4/schematic

simulator lang=spectre

subckt CLKAND2X4 A B Y NW VDD VSS
mn2 (Y net61 VSS VSS) g45n1svt w=(1.04u) l=45n nf=1 m=(1)
mn0 (net69 A VSS VSS) g45n1svt w=(520n) l=45n nf=1 m=(1)
mn1 (net61 B net69 VSS) g45n1svt w=(520n) l=45n nf=1 m=(1)
mp1 (net61 B VDD NW) g45p1svt w=(390n) l=45n nf=1 m=(1)
mp0 (net61 A VDD NW) g45p1svt w=(390n) l=45n nf=1 m=(1)
mp2 (Y net61 VDD NW) g45p1svt w=(1.56u) l=45n nf=1 m=(1)
ends CLKAND2X4

// gsclib045_backbias/CLKAND2X6/schematic

simulator lang=spectre

subckt CLKAND2X6 A B Y NW VDD VSS
mn2 (Y net61 VSS VSS) g45n1svt w=(1.55u) l=45n nf=1 m=(1)
mn0 (net69 A VSS VSS) g45n1svt w=(1.04u) l=45n nf=1 m=(1)
mn1 (net61 B net69 VSS) g45n1svt w=(1.04u) l=45n nf=1 m=(1)
mp1 (net61 B VDD NW) g45p1svt w=(780n) l=45n nf=1 m=(1)
mp0 (net61 A VDD NW) g45p1svt w=(780n) l=45n nf=1 m=(1)
mp2 (Y net61 VDD NW) g45p1svt w=(2.35u) l=45n nf=1 m=(1)
ends CLKAND2X6

// gsclib045_backbias/CLKAND2X8/schematic

simulator lang=spectre

subckt CLKAND2X8 A B Y NW VDD VSS
mn2 (Y net61 VSS VSS) g45n1svt w=(2.065u) l=45n nf=1 m=(1)
mn0 (net69 A VSS VSS) g45n1svt w=(1.04u) l=45n nf=1 m=(1)
mn1 (net61 B net69 VSS) g45n1svt w=(1.04u) l=45n nf=1 m=(1)
mp1 (net61 B VDD NW) g45p1svt w=(780n) l=45n nf=1 m=(1)
mp0 (net61 A VDD NW) g45p1svt w=(780n) l=45n nf=1 m=(1)
mp2 (Y net61 VDD NW) g45p1svt w=(3.115u) l=45n nf=1 m=(1)
ends CLKAND2X8

// gsclib045_backbias/CLKBUFX12/schematic

simulator lang=spectre

subckt CLKBUFX12 A Y NW VDD VSS
mn1 (Y net44 VSS VSS) g45n1svt w=(3.1u) l=45n nf=1 m=(1)
mn0 (net44 A VSS VSS) g45n1svt w=(780n) l=45n nf=1 m=(1)
mp1 (Y net44 VDD NW) g45p1svt w=(4.7u) l=45n nf=1 m=(1)
mp0 (net44 A VDD NW) g45p1svt w=(1.17u) l=45n nf=1 m=(1)
ends CLKBUFX12

// gsclib045_backbias/CLKBUFX16/schematic

simulator lang=spectre

subckt CLKBUFX16 A Y VSS NW VDD
mn1 (Y net44 VSS VSS) g45n1svt w=(4.13u) l=45n nf=1 m=(1)
mn0 (net44 A VSS VSS) g45n1svt w=(1.04u) l=45n nf=1 m=(1)
mp1 (Y net44 VDD NW) g45p1svt w=(6.23u) l=45n nf=1 m=(1)
mp0 (net44 A VDD NW) g45p1svt w=(1.56u) l=45n nf=1 m=(1)
ends CLKBUFX16

// gsclib045_backbias/CLKBUFX2/schematic

simulator lang=spectre

subckt CLKBUFX2 A Y VSS VDD NW
mn1 (Y net44 VSS VSS) g45n1svt w=(520n) l=45n nf=1 m=(1)
mn0 (net44 A VSS VSS) g45n1svt w=(145n) l=45n nf=1 m=(1)
mp1 (Y net44 VDD NW) g45p1svt w=(780n) l=45n nf=1 m=(1)
mp0 (net44 A VDD NW) g45p1svt w=(215n) l=45n nf=1 m=(1)
ends CLKBUFX2

// gsclib045_backbias/CLKBUFX20/schematic

simulator lang=spectre

subckt CLKBUFX20 A Y NW VDD VSS
mn1 (Y net44 VSS VSS) g45n1svt w=(5.185u) l=45n nf=1 m=(1)
mn0 (net44 A VSS VSS) g45n1svt w=(1.3u) l=45n nf=1 m=(1)
mp1 (Y net44 VDD NW) g45p1svt w=(7.815u) l=45n nf=1 m=(1)
mp0 (net44 A VDD NW) g45p1svt w=(1.95u) l=45n nf=1 m=(1)
ends CLKBUFX20

// gsclib045_backbias/CLKBUFX3/schematic

simulator lang=spectre

subckt CLKBUFX3 A Y VSS NW VDD
mn1 (Y net44 VSS VSS) g45n1svt w=(780n) l=45n nf=1 m=(1)
mn0 (net44 A VSS VSS) g45n1svt w=(260n) l=45n nf=1 m=(1)
mp1 (Y net44 VDD NW) g45p1svt w=(1.17u) l=45n nf=1 m=(1)
mp0 (net44 A VDD NW) g45p1svt w=(390n) l=45n nf=1 m=(1)
ends CLKBUFX3

// gsclib045_backbias/CLKBUFX4/schematic

simulator lang=spectre

subckt CLKBUFX4 A Y NW VDD VSS
mn1 (Y net44 VSS VSS) g45n1svt w=(1.04u) l=45n nf=1 m=(1)
mn0 (net44 A VSS VSS) g45n1svt w=(260n) l=45n nf=1 m=(1)
mp1 (Y net44 VDD NW) g45p1svt w=(1.56u) l=45n nf=1 m=(1)
mp0 (net44 A VDD NW) g45p1svt w=(390n) l=45n nf=1 m=(1)
ends CLKBUFX4

// gsclib045_backbias/CLKBUFX6/schematic

simulator lang=spectre

subckt CLKBUFX6 A Y NW VDD VSS
mn1 (Y net44 VSS VSS) g45n1svt w=(1.55u) l=45n nf=1 m=(1)
mn0 (net44 A VSS VSS) g45n1svt w=(520n) l=45n nf=1 m=(1)
mp1 (Y net44 VDD NW) g45p1svt w=(2.35u) l=45n nf=1 m=(1)
mp0 (net44 A VDD NW) g45p1svt w=(780n) l=45n nf=1 m=(1)
ends CLKBUFX6

// gsclib045_backbias/CLKBUFX8/schematic

simulator lang=spectre

subckt CLKBUFX8 A Y NW VDD VSS
mn1 (Y net44 VSS VSS) g45n1svt w=(2.065u) l=45n nf=1 m=(1)
mn0 (net44 A VSS VSS) g45n1svt w=(520n) l=45n nf=1 m=(1)
mp1 (Y net44 VDD NW) g45p1svt w=(3.115u) l=45n nf=1 m=(1)
mp0 (net44 A VDD NW) g45p1svt w=(780n) l=45n nf=1 m=(1)
ends CLKBUFX8

// gsclib045_backbias/CLKINVX1/schematic

simulator lang=spectre

subckt CLKINVX1 A Y VDD NW VSS
mp0 (Y A VDD NW) g45p1svt w=(390n) l=45n nf=1 m=(1)
mn0 (Y A VSS VSS) g45n1svt w=(260n) l=45n nf=1 m=(1)
ends CLKINVX1

// gsclib045_backbias/CLKINVX12/schematic

simulator lang=spectre

subckt CLKINVX12 A Y VDD VSS NW
mp0 (Y A VDD NW) g45p1svt w=(4.7u) l=45n nf=1 m=(1)
mn0 (Y A VSS VSS) g45n1svt w=(3.1u) l=45n nf=1 m=(1)
ends CLKINVX12

// gsclib045_backbias/CLKINVX16/schematic

simulator lang=spectre

subckt CLKINVX16 A Y VDD VSS NW
mp0 (Y A VDD NW) g45p1svt w=(6.23u) l=45n nf=1 m=(1)
mn0 (Y A VSS VSS) g45n1svt w=(4.13u) l=45n nf=1 m=(1)
ends CLKINVX16

// gsclib045_backbias/CLKINVX2/schematic

simulator lang=spectre

subckt CLKINVX2 A Y VDD VSS NW
mp0 (Y A VDD NW) g45p1svt w=(780n) l=45n nf=1 m=(1)
mn0 (Y A VSS VSS) g45n1svt w=(520n) l=45n nf=1 m=(1)
ends CLKINVX2

// gsclib045_backbias/CLKINVX20/schematic

simulator lang=spectre

subckt CLKINVX20 A Y VDD VSS NW
mp0 (Y A VDD NW) g45p1svt w=(7.815u) l=45n nf=1 m=(1)
mn0 (Y A VSS VSS) g45n1svt w=(5.185u) l=45n nf=1 m=(1)
ends CLKINVX20

// gsclib045_backbias/CLKINVX3/schematic

simulator lang=spectre

subckt CLKINVX3 A Y VDD VSS NW
mp0 (Y A VDD NW) g45p1svt w=(1.17u) l=45n nf=1 m=(1)
mn0 (Y A VSS VSS) g45n1svt w=(780n) l=45n nf=1 m=(1)
ends CLKINVX3

// gsclib045_backbias/CLKINVX4/schematic

simulator lang=spectre

subckt CLKINVX4 A Y NW VDD VSS
mp0 (Y A VDD NW) g45p1svt w=(1.56u) l=45n nf=1 m=(1)
mn0 (Y A VSS VSS) g45n1svt w=(1.04u) l=45n nf=1 m=(1)
ends CLKINVX4

// gsclib045_backbias/CLKINVX6/schematic

simulator lang=spectre

subckt CLKINVX6 A Y VDD VSS NW
mp0 (Y A VDD NW) g45p1svt w=(2.35u) l=45n nf=1 m=(1)
mn0 (Y A VSS VSS) g45n1svt w=(1.55u) l=45n nf=1 m=(1)
ends CLKINVX6

// gsclib045_backbias/CLKINVX8/schematic

simulator lang=spectre

subckt CLKINVX8 A Y VDD VSS NW
mp0 (Y A VDD NW) g45p1svt w=(3.115u) l=45n nf=1 m=(1)
mn0 (Y A VSS VSS) g45n1svt w=(2.065u) l=45n nf=1 m=(1)
ends CLKINVX8

// gsclib045_backbias/CLKMX2X12/schematic

simulator lang=spectre

subckt CLKMX2X12 A B S0 Y VDD NW VSS
mn3 (net140 B VSS VSS) g45n1svt w=(205n) l=45n nf=1 m=(1)
mn0 (S0b S0 VSS VSS) g45n1svt w=(260n) l=45n nf=1 m=(1)
mn2 (n0 S0b net148 VSS) g45n1svt w=(205n) l=45n nf=1 m=(1)
mn1 (net148 A VSS VSS) g45n1svt w=(205n) l=45n nf=1 m=(1)
mn5 (Y n0 VSS VSS) g45n1svt w=(3.1u) l=45n nf=1 m=(1)
mn4 (n0 S0 net140 VSS) g45n1svt w=(205n) l=45n nf=1 m=(1)
mp4 (n0 S0b net115 NW) g45p1svt w=(310n) l=45n nf=1 m=(1)
mp3 (net115 B VDD NW) g45p1svt w=(310n) l=45n nf=1 m=(1)
mp5 (Y n0 VDD NW) g45p1svt w=(4.7u) l=45n nf=1 m=(1)
mp2 (n0 S0 net123 NW) g45p1svt w=(310n) l=45n nf=1 m=(1)
mp0 (S0b S0 VDD NW) g45p1svt w=(390n) l=45n nf=1 m=(1)
mp1 (net123 A VDD NW) g45p1svt w=(310n) l=45n nf=1 m=(1)
ends CLKMX2X12

// gsclib045_backbias/CLKMX2X2/schematic

simulator lang=spectre

subckt CLKMX2X2 A B S0 Y VDD NW VSS
mn3 (net140 B VSS VSS) g45n1svt w=(145n) l=45n nf=1 m=(1)
mn0 (S0b S0 VSS VSS) g45n1svt w=(145n) l=45n nf=1 m=(1)
mn2 (n0 S0b net148 VSS) g45n1svt w=(145n) l=45n nf=1 m=(1)
mn1 (net148 A VSS VSS) g45n1svt w=(145n) l=45n nf=1 m=(1)
mn5 (Y n0 VSS VSS) g45n1svt w=(520n) l=45n nf=1 m=(1)
mn4 (n0 S0 net140 VSS) g45n1svt w=(145n) l=45n nf=1 m=(1)
mp4 (n0 S0b net115 NW) g45p1svt w=(215n) l=45n nf=1 m=(1)
mp3 (net115 B VDD NW) g45p1svt w=(215n) l=45n nf=1 m=(1)
mp5 (Y n0 VDD NW) g45p1svt w=(780n) l=45n nf=1 m=(1)
mp2 (n0 S0 net123 NW) g45p1svt w=(215n) l=45n nf=1 m=(1)
mp0 (S0b S0 VDD NW) g45p1svt w=(215n) l=45n nf=1 m=(1)
mp1 (net123 A VDD NW) g45p1svt w=(215n) l=45n nf=1 m=(1)
ends CLKMX2X2

// gsclib045_backbias/CLKMX2X3/schematic

simulator lang=spectre

subckt CLKMX2X3 A B S0 Y VDD NW VSS
mn3 (net140 B VSS VSS) g45n1svt w=(260n) l=45n nf=1 m=(1)
mn0 (S0b S0 VSS VSS) g45n1svt w=(145n) l=45n nf=1 m=(1)
mn2 (n0 S0b net148 VSS) g45n1svt w=(260n) l=45n nf=1 m=(1)
mn1 (net148 A VSS VSS) g45n1svt w=(260n) l=45n nf=1 m=(1)
mn5 (Y n0 VSS VSS) g45n1svt w=(780n) l=45n nf=1 m=(1)
mn4 (n0 S0 net140 VSS) g45n1svt w=(260n) l=45n nf=1 m=(1)
mp4 (n0 S0b net115 NW) g45p1svt w=(390n) l=45n nf=1 m=(1)
mp3 (net115 B VDD NW) g45p1svt w=(390n) l=45n nf=1 m=(1)
mp5 (Y n0 VDD NW) g45p1svt w=(1.17u) l=45n nf=1 m=(1)
mp2 (n0 S0 net123 NW) g45p1svt w=(390n) l=45n nf=1 m=(1)
mp0 (S0b S0 VDD NW) g45p1svt w=(215n) l=45n nf=1 m=(1)
mp1 (net123 A VDD NW) g45p1svt w=(390n) l=45n nf=1 m=(1)
ends CLKMX2X3

// gsclib045_backbias/CLKMX2X4/schematic

simulator lang=spectre

subckt CLKMX2X4 A B S0 Y VDD NW VSS
mn3 (net140 B VSS VSS) g45n1svt w=(205n) l=45n nf=1 m=(1)
mn0 (S0b S0 VSS VSS) g45n1svt w=(145n) l=45n nf=1 m=(1)
mn2 (n0 S0b net148 VSS) g45n1svt w=(205n) l=45n nf=1 m=(1)
mn1 (net148 A VSS VSS) g45n1svt w=(205n) l=45n nf=1 m=(1)
mn5 (Y n0 VSS VSS) g45n1svt w=(1.04u) l=45n nf=1 m=(1)
mn4 (n0 S0 net140 VSS) g45n1svt w=(205n) l=45n nf=1 m=(1)
mp4 (n0 S0b net115 NW) g45p1svt w=(310n) l=45n nf=1 m=(1)
mp3 (net115 B VDD NW) g45p1svt w=(310n) l=45n nf=1 m=(1)
mp5 (Y n0 VDD NW) g45p1svt w=(1.56u) l=45n nf=1 m=(1)
mp2 (n0 S0 net123 NW) g45p1svt w=(310n) l=45n nf=1 m=(1)
mp0 (S0b S0 VDD NW) g45p1svt w=(215n) l=45n nf=1 m=(1)
mp1 (net123 A VDD NW) g45p1svt w=(310n) l=45n nf=1 m=(1)
ends CLKMX2X4

// gsclib045_backbias/CLKMX2X6/schematic

simulator lang=spectre

subckt CLKMX2X6 A B S0 Y VDD NW VSS
mn3 (net140 B VSS VSS) g45n1svt w=(205n) l=45n nf=1 m=(1)
mn0 (S0b S0 VSS VSS) g45n1svt w=(145n) l=45n nf=1 m=(1)
mn2 (n0 S0b net148 VSS) g45n1svt w=(205n) l=45n nf=1 m=(1)
mn1 (net148 A VSS VSS) g45n1svt w=(205n) l=45n nf=1 m=(1)
mn5 (Y n0 VSS VSS) g45n1svt w=(1.55u) l=45n nf=1 m=(1)
mn4 (n0 S0 net140 VSS) g45n1svt w=(205n) l=45n nf=1 m=(1)
mp4 (n0 S0b net115 NW) g45p1svt w=(310n) l=45n nf=1 m=(1)
mp3 (net115 B VDD NW) g45p1svt w=(310n) l=45n nf=1 m=(1)
mp5 (Y n0 VDD NW) g45p1svt w=(2.35u) l=45n nf=1 m=(1)
mp2 (n0 S0 net123 NW) g45p1svt w=(310n) l=45n nf=1 m=(1)
mp0 (S0b S0 VDD NW) g45p1svt w=(215n) l=45n nf=1 m=(1)
mp1 (net123 A VDD NW) g45p1svt w=(310n) l=45n nf=1 m=(1)
ends CLKMX2X6

// gsclib045_backbias/CLKMX2X8/schematic

simulator lang=spectre

subckt CLKMX2X8 A B S0 Y VDD NW VSS
mn3 (net140 B VSS VSS) g45n1svt w=(205n) l=45n nf=1 m=(1)
mn0 (S0b S0 VSS VSS) g45n1svt w=(145n) l=45n nf=1 m=(1)
mn2 (n0 S0b net148 VSS) g45n1svt w=(205n) l=45n nf=1 m=(1)
mn1 (net148 A VSS VSS) g45n1svt w=(205n) l=45n nf=1 m=(1)
mn5 (Y n0 VSS VSS) g45n1svt w=(2.065u) l=45n nf=1 m=(1)
mn4 (n0 S0 net140 VSS) g45n1svt w=(205n) l=45n nf=1 m=(1)
mp4 (n0 S0b net115 NW) g45p1svt w=(310n) l=45n nf=1 m=(1)
mp3 (net115 B VDD NW) g45p1svt w=(310n) l=45n nf=1 m=(1)
mp5 (Y n0 VDD NW) g45p1svt w=(3.115u) l=45n nf=1 m=(1)
mp2 (n0 S0 net123 NW) g45p1svt w=(310n) l=45n nf=1 m=(1)
mp0 (S0b S0 VDD NW) g45p1svt w=(215n) l=45n nf=1 m=(1)
mp1 (net123 A VDD NW) g45p1svt w=(310n) l=45n nf=1 m=(1)
ends CLKMX2X8

// gsclib045_backbias/CLKXOR2X1/schematic

simulator lang=spectre

subckt CLKXOR2X1 A B Y NW VSS VDD
mn1 (n2 B VSS VSS) g45n1svt w=(145n) l=45n nf=1 m=(1)
mn0 (n1 A VSS VSS) g45n1svt w=(145n) l=45n nf=1 m=(1)
mn5 (Y n0 VSS VSS) g45n1svt w=(260n) l=45n nf=1 m=(1)
mn3 (n0 B net139 VSS) g45n1svt w=(145n) l=45n nf=1 m=(1)
mn4 (n0 n2 n1 VSS) g45n1svt w=(145n) l=45n nf=1 m=(1)
mn2 (net139 n1 VSS VSS) g45n1svt w=(145n) l=45n nf=1 m=(1)
mp3 (n0 n2 net130 NW) g45p1svt w=(215n) l=45n nf=1 m=(1)
mp1 (n2 B VDD NW) g45p1svt w=(215n) l=45n nf=1 m=(1)
mp4 (n0 B n1 NW) g45p1svt w=(215n) l=45n nf=1 m=(1)
mp0 (n1 A VDD NW) g45p1svt w=(215n) l=45n nf=1 m=(1)
mp5 (Y n0 VDD NW) g45p1svt w=(390n) l=45n nf=1 m=(1)
mp2 (net130 n1 VDD NW) g45p1svt w=(215n) l=45n nf=1 m=(1)
ends CLKXOR2X1

// gsclib045_backbias/CLKXOR2X2/schematic

simulator lang=spectre

subckt CLKXOR2X2 A B Y VDD VSS NW
mn1 (n2 B VSS VSS) g45n1svt w=(145n) l=45n nf=1 m=(1)
mn0 (n1 A VSS VSS) g45n1svt w=(145n) l=45n nf=1 m=(1)
mn5 (Y n0 VSS VSS) g45n1svt w=(520n) l=45n nf=1 m=(1)
mn3 (n0 B net139 VSS) g45n1svt w=(145n) l=45n nf=1 m=(1)
mn4 (n0 n2 n1 VSS) g45n1svt w=(145n) l=45n nf=1 m=(1)
mn2 (net139 n1 VSS VSS) g45n1svt w=(145n) l=45n nf=1 m=(1)
mp3 (n0 n2 net130 NW) g45p1svt w=(215n) l=45n nf=1 m=(1)
mp1 (n2 B VDD NW) g45p1svt w=(215n) l=45n nf=1 m=(1)
mp4 (n0 B n1 NW) g45p1svt w=(215n) l=45n nf=1 m=(1)
mp0 (n1 A VDD NW) g45p1svt w=(215n) l=45n nf=1 m=(1)
mp5 (Y n0 VDD NW) g45p1svt w=(780n) l=45n nf=1 m=(1)
mp2 (net130 n1 VDD NW) g45p1svt w=(215n) l=45n nf=1 m=(1)
ends CLKXOR2X2

// gsclib045_backbias/CLKXOR2X4/schematic

simulator lang=spectre

subckt CLKXOR2X4 A B Y VDD NW VSS
mn1 (n2 B VSS VSS) g45n1svt w=(145n) l=45n nf=1 m=(1)
mn0 (n1 A VSS VSS) g45n1svt w=(145n) l=45n nf=1 m=(1)
mn5 (Y n0 VSS VSS) g45n1svt w=(1.04u) l=45n nf=1 m=(1)
mn3 (n0 B net139 VSS) g45n1svt w=(205n) l=45n nf=1 m=(1)
mn4 (n0 n2 n1 VSS) g45n1svt w=(205n) l=45n nf=1 m=(1)
mn2 (net139 n1 VSS VSS) g45n1svt w=(205n) l=45n nf=1 m=(1)
mp3 (n0 n2 net130 NW) g45p1svt w=(310n) l=45n nf=1 m=(1)
mp1 (n2 B VDD NW) g45p1svt w=(215n) l=45n nf=1 m=(1)
mp4 (n0 B n1 NW) g45p1svt w=(310n) l=45n nf=1 m=(1)
mp0 (n1 A VDD NW) g45p1svt w=(215n) l=45n nf=1 m=(1)
mp5 (Y n0 VDD NW) g45p1svt w=(1.56u) l=45n nf=1 m=(1)
mp2 (net130 n1 VDD NW) g45p1svt w=(310n) l=45n nf=1 m=(1)
ends CLKXOR2X4

// gsclib045_backbias/CLKXOR2X8/schematic

simulator lang=spectre

subckt CLKXOR2X8 A B Y NW VDD VSS
mn1 (n2 B VSS VSS) g45n1svt w=(145n) l=45n nf=1 m=(1)
mn0 (n1 A VSS VSS) g45n1svt w=(145n) l=45n nf=1 m=(1)
mn5 (Y n0 VSS VSS) g45n1svt w=(2.065u) l=45n nf=1 m=(1)
mn3 (n0 B net139 VSS) g45n1svt w=(205n) l=45n nf=1 m=(1)
mn4 (n0 n2 n1 VSS) g45n1svt w=(205n) l=45n nf=1 m=(1)
mn2 (net139 n1 VSS VSS) g45n1svt w=(205n) l=45n nf=1 m=(1)
mp3 (n0 n2 net130 NW) g45p1svt w=(310n) l=45n nf=1 m=(1)
mp1 (n2 B VDD NW) g45p1svt w=(215n) l=45n nf=1 m=(1)
mp4 (n0 B n1 NW) g45p1svt w=(310n) l=45n nf=1 m=(1)
mp0 (n1 A VDD NW) g45p1svt w=(215n) l=45n nf=1 m=(1)
mp5 (Y n0 VDD NW) g45p1svt w=(3.115u) l=45n nf=1 m=(1)
mp2 (net130 n1 VDD NW) g45p1svt w=(310n) l=45n nf=1 m=(1)
ends CLKXOR2X8

// gsclib045_backbias/DLY1X1/schematic

simulator lang=spectre

subckt DLY1X1 A Y NW VDD VSS
mn2 (n1 VDD n4 VSS) g45n1svt w=(145n) l=45n nf=1 m=(1)
mn1 (n4 n0 VSS VSS) g45n1svt w=(145n) l=45n nf=1 m=(1)
mn4 (Y n2 VSS VSS) g45n1svt w=(260n) l=45n nf=1 m=(1)
mn0 (n0 A VSS VSS) g45n1svt w=(145n) l=45n nf=1 m=(1)
mn3 (n2 n1 VSS VSS) g45n1svt w=(145n) l=45n nf=1 m=(1)
mp2 (n1 VSS n5 NW) g45p1svt w=(215n) l=45n nf=1 m=(1)
mp1 (n5 n0 VDD NW) g45p1svt w=(215n) l=45n nf=1 m=(1)
mp4 (Y n2 VDD NW) g45p1svt w=(390n) l=45n nf=1 m=(1)
mp0 (n0 A VDD NW) g45p1svt w=(215n) l=45n nf=1 m=(1)
mp3 (n2 n1 VDD NW) g45p1svt w=(215n) l=45n nf=1 m=(1)
ends DLY1X1

// gsclib045_backbias/DLY1X4/schematic

simulator lang=spectre

subckt DLY1X4 A Y NW VDD VSS
mn2 (n1 VDD n4 VSS) g45n1svt w=(145n) l=45n nf=1 m=(1)
mn1 (n4 n0 VSS VSS) g45n1svt w=(145n) l=45n nf=1 m=(1)
mn4 (Y n2 VSS VSS) g45n1svt w=(1.04u) l=45n nf=1 m=(1)
mn0 (n0 A VSS VSS) g45n1svt w=(145n) l=45n nf=1 m=(1)
mn3 (n2 n1 VSS VSS) g45n1svt w=(260n) l=45n nf=1 m=(1)
mp2 (n1 VSS n5 NW) g45p1svt w=(215n) l=45n nf=1 m=(1)
mp1 (n5 n0 VDD NW) g45p1svt w=(215n) l=45n nf=1 m=(1)
mp4 (Y n2 VDD NW) g45p1svt w=(1.56u) l=45n nf=1 m=(1)
mp0 (n0 A VDD NW) g45p1svt w=(215n) l=45n nf=1 m=(1)
mp3 (n2 n1 VDD NW) g45p1svt w=(390n) l=45n nf=1 m=(1)
ends DLY1X4

// gsclib045_backbias/DLY2X1/schematic

simulator lang=spectre

subckt DLY2X1 A Y NW VSS VDD
mn6 (n3 VDD n10 VSS) g45n1svt w=(145n) l=45n nf=1 m=(1)
mn5 (n10 n2 VSS VSS) g45n1svt w=(145n) l=45n nf=1 m=(1)
mn8 (Y n4 VSS VSS) g45n1svt w=(260n) l=45n nf=1 m=(1)
mn4 (n2 VDD n8 VSS) g45n1svt w=(145n) l=45n nf=1 m=(1)
mn3 (n8 n1 VSS VSS) g45n1svt w=(145n) l=45n nf=1 m=(1)
mn2 (n1 VDD n6 VSS) g45n1svt w=(145n) l=45n nf=1 m=(1)
mn1 (n6 n0 VSS VSS) g45n1svt w=(145n) l=45n nf=1 m=(1)
mn7 (n4 n3 VSS VSS) g45n1svt w=(145n) l=45n nf=1 m=(1)
mn0 (n0 A VSS VSS) g45n1svt w=(145n) l=45n nf=1 m=(1)
mp6 (n3 VSS n11 NW) g45p1svt w=(215n) l=45n nf=1 m=(1)
mp5 (n11 n2 VDD NW) g45p1svt w=(215n) l=45n nf=1 m=(1)
mp8 (Y n4 VDD NW) g45p1svt w=(390n) l=45n nf=1 m=(1)
mp4 (n2 VSS n9 NW) g45p1svt w=(215n) l=45n nf=1 m=(1)
mp3 (n9 n1 VDD NW) g45p1svt w=(215n) l=45n nf=1 m=(1)
mp2 (n1 VSS n7 NW) g45p1svt w=(215n) l=45n nf=1 m=(1)
mp1 (n7 n0 VDD NW) g45p1svt w=(215n) l=45n nf=1 m=(1)
mp7 (n4 n3 VDD NW) g45p1svt w=(215n) l=45n nf=1 m=(1)
mp0 (n0 A VDD NW) g45p1svt w=(215n) l=45n nf=1 m=(1)
ends DLY2X1

// gsclib045_backbias/DLY2X4/schematic

simulator lang=spectre

subckt DLY2X4 A Y VDD NW VSS
mn6 (n3 VDD n10 VSS) g45n1svt w=(145n) l=45n nf=1 m=(1)
mn5 (n10 n2 VSS VSS) g45n1svt w=(145n) l=45n nf=1 m=(1)
mn8 (Y n4 VSS VSS) g45n1svt w=(1.04u) l=45n nf=1 m=(1)
mn4 (n2 VDD n8 VSS) g45n1svt w=(145n) l=45n nf=1 m=(1)
mn3 (n8 n1 VSS VSS) g45n1svt w=(145n) l=45n nf=1 m=(1)
mn2 (n1 VDD n6 VSS) g45n1svt w=(145n) l=45n nf=1 m=(1)
mn1 (n6 n0 VSS VSS) g45n1svt w=(145n) l=45n nf=1 m=(1)
mn7 (n4 n3 VSS VSS) g45n1svt w=(260n) l=45n nf=1 m=(1)
mn0 (n0 A VSS VSS) g45n1svt w=(145n) l=45n nf=1 m=(1)
mp6 (n3 VSS n11 NW) g45p1svt w=(215n) l=45n nf=1 m=(1)
mp5 (n11 n2 VDD NW) g45p1svt w=(215n) l=45n nf=1 m=(1)
mp8 (Y n4 VDD NW) g45p1svt w=(1.56u) l=45n nf=1 m=(1)
mp4 (n2 VSS n9 NW) g45p1svt w=(215n) l=45n nf=1 m=(1)
mp3 (n9 n1 VDD NW) g45p1svt w=(215n) l=45n nf=1 m=(1)
mp2 (n1 VSS n7 NW) g45p1svt w=(215n) l=45n nf=1 m=(1)
mp1 (n7 n0 VDD NW) g45p1svt w=(215n) l=45n nf=1 m=(1)
mp7 (n4 n3 VDD NW) g45p1svt w=(390n) l=45n nf=1 m=(1)
mp0 (n0 A VDD NW) g45p1svt w=(215n) l=45n nf=1 m=(1)
ends DLY2X4

// gsclib045_backbias/DLY3X1/schematic

simulator lang=spectre

subckt DLY3X1 A Y VSS NW VDD
mn10 (n5 VDD n15 VSS) g45n1svt w=(145n) l=45n nf=1 m=(1)
mn9 (n15 n4 VSS VSS) g45n1svt w=(145n) l=45n nf=1 m=(1)
mn8 (n4 VDD n13 VSS) g45n1svt w=(145n) l=45n nf=1 m=(1)
mn7 (n13 n3 VSS VSS) g45n1svt w=(145n) l=45n nf=1 m=(1)
mn6 (n3 VDD n11 VSS) g45n1svt w=(145n) l=45n nf=1 m=(1)
mn5 (n11 n2 VSS VSS) g45n1svt w=(145n) l=45n nf=1 m=(1)
mn4 (n2 VDD n9 VSS) g45n1svt w=(145n) l=45n nf=1 m=(1)
mn3 (n9 n1 VSS VSS) g45n1svt w=(145n) l=45n nf=1 m=(1)
mn2 (n1 VDD n7 VSS) g45n1svt w=(145n) l=45n nf=1 m=(1)
mn1 (n7 n0 VSS VSS) g45n1svt w=(145n) l=45n nf=1 m=(1)
mn11 (n6 n5 VSS VSS) g45n1svt w=(145n) l=45n nf=1 m=(1)
mn12 (Y n6 VSS VSS) g45n1svt w=(260n) l=45n nf=1 m=(1)
mn0 (n0 A VSS VSS) g45n1svt w=(145n) l=45n nf=1 m=(1)
mp8 (n4 VSS n14 NW) g45p1svt w=(215n) l=45n nf=1 m=(1)
mp7 (n14 n3 VDD NW) g45p1svt w=(215n) l=45n nf=1 m=(1)
mp9 (n16 n4 VDD NW) g45p1svt w=(215n) l=45n nf=1 m=(1)
mp10 (n5 VSS n16 NW) g45p1svt w=(215n) l=45n nf=1 m=(1)
mp6 (n3 VSS n12 NW) g45p1svt w=(215n) l=45n nf=1 m=(1)
mp5 (n12 n2 VDD NW) g45p1svt w=(215n) l=45n nf=1 m=(1)
mp4 (n2 VSS n10 NW) g45p1svt w=(215n) l=45n nf=1 m=(1)
mp3 (n10 n1 VDD NW) g45p1svt w=(215n) l=45n nf=1 m=(1)
mp2 (n1 VSS n8 NW) g45p1svt w=(215n) l=45n nf=1 m=(1)
mp1 (n8 n0 VDD NW) g45p1svt w=(215n) l=45n nf=1 m=(1)
mp12 (Y n6 VDD NW) g45p1svt w=(390n) l=45n nf=1 m=(1)
mp0 (n0 A VDD NW) g45p1svt w=(215n) l=45n nf=1 m=(1)
mp11 (n6 n5 VDD NW) g45p1svt w=(215n) l=45n nf=1 m=(1)
ends DLY3X1

// gsclib045_backbias/DLY3X4/schematic

simulator lang=spectre

subckt DLY3X4 A Y VSS NW VDD
mn10 (n5 VDD n15 VSS) g45n1svt w=(145n) l=45n nf=1 m=(1)
mn9 (n15 n4 VSS VSS) g45n1svt w=(145n) l=45n nf=1 m=(1)
mn8 (n4 VDD n13 VSS) g45n1svt w=(145n) l=45n nf=1 m=(1)
mn7 (n13 n3 VSS VSS) g45n1svt w=(145n) l=45n nf=1 m=(1)
mn6 (n3 VDD n11 VSS) g45n1svt w=(145n) l=45n nf=1 m=(1)
mn5 (n11 n2 VSS VSS) g45n1svt w=(145n) l=45n nf=1 m=(1)
mn4 (n2 VDD n9 VSS) g45n1svt w=(145n) l=45n nf=1 m=(1)
mn3 (n9 n1 VSS VSS) g45n1svt w=(145n) l=45n nf=1 m=(1)
mn2 (n1 VDD n7 VSS) g45n1svt w=(145n) l=45n nf=1 m=(1)
mn1 (n7 n0 VSS VSS) g45n1svt w=(145n) l=45n nf=1 m=(1)
mn11 (n6 n5 VSS VSS) g45n1svt w=(260n) l=45n nf=1 m=(1)
mn12 (Y n6 VSS VSS) g45n1svt w=(1.04u) l=45n nf=1 m=(1)
mn0 (n0 A VSS VSS) g45n1svt w=(145n) l=45n nf=1 m=(1)
mp8 (n4 VSS n14 NW) g45p1svt w=(215n) l=45n nf=1 m=(1)
mp7 (n14 n3 VDD NW) g45p1svt w=(215n) l=45n nf=1 m=(1)
mp9 (n16 n4 VDD NW) g45p1svt w=(215n) l=45n nf=1 m=(1)
mp10 (n5 VSS n16 NW) g45p1svt w=(215n) l=45n nf=1 m=(1)
mp6 (n3 VSS n12 NW) g45p1svt w=(215n) l=45n nf=1 m=(1)
mp5 (n12 n2 VDD NW) g45p1svt w=(215n) l=45n nf=1 m=(1)
mp4 (n2 VSS n10 NW) g45p1svt w=(215n) l=45n nf=1 m=(1)
mp3 (n10 n1 VDD NW) g45p1svt w=(215n) l=45n nf=1 m=(1)
mp2 (n1 VSS n8 NW) g45p1svt w=(215n) l=45n nf=1 m=(1)
mp1 (n8 n0 VDD NW) g45p1svt w=(215n) l=45n nf=1 m=(1)
mp12 (Y n6 VDD NW) g45p1svt w=(1.56u) l=45n nf=1 m=(1)
mp0 (n0 A VDD NW) g45p1svt w=(215n) l=45n nf=1 m=(1)
mp11 (n6 n5 VDD NW) g45p1svt w=(390n) l=45n nf=1 m=(1)
ends DLY3X4

// gsclib045_backbias/DLY4X1/schematic

simulator lang=spectre

subckt DLY4X1 A Y VDD VSS NW
mn14 (net345 VDD net341 VSS) g45n1svt w=(145n) l=45n nf=1 m=(1)
mn13 (net341 net353 VSS VSS) g45n1svt w=(145n) l=45n nf=1 m=(1)
mn12 (net353 VDD net349 VSS) g45n1svt w=(145n) l=45n nf=1 m=(1)
mn11 (net349 net361 VSS VSS) g45n1svt w=(145n) l=45n nf=1 m=(1)
mn10 (net361 VDD net357 VSS) g45n1svt w=(145n) l=45n nf=1 m=(1)
mn9 (net357 net369 VSS VSS) g45n1svt w=(145n) l=45n nf=1 m=(1)
mn15 (net333 net345 VSS VSS) g45n1svt w=(145n) l=45n nf=1 m=(1)
mn6 (net377 VDD net373 VSS) g45n1svt w=(145n) l=45n nf=1 m=(1)
mn0 (net397 A VSS VSS) g45n1svt w=(145n) l=45n nf=1 m=(1)
mn4 (net385 VDD net381 VSS) g45n1svt w=(145n) l=45n nf=1 m=(1)
mn1 (net389 net397 VSS VSS) g45n1svt w=(145n) l=45n nf=1 m=(1)
mn7 (net365 net377 VSS VSS) g45n1svt w=(145n) l=45n nf=1 m=(1)
mn16 (Y net333 VSS VSS) g45n1svt w=(260n) l=45n nf=1 m=(1)
mn3 (net381 net393 VSS VSS) g45n1svt w=(145n) l=45n nf=1 m=(1)
mn2 (net393 VDD net389 VSS) g45n1svt w=(145n) l=45n nf=1 m=(1)
mn8 (net369 VDD net365 VSS) g45n1svt w=(145n) l=45n nf=1 m=(1)
mn5 (net373 net385 VSS VSS) g45n1svt w=(145n) l=45n nf=1 m=(1)
mp8 (net369 VSS net300 NW) g45p1svt w=(215n) l=45n nf=1 m=(1)
mp7 (net300 net377 VDD NW) g45p1svt w=(215n) l=45n nf=1 m=(1)
mp9 (net292 net369 VDD NW) g45p1svt w=(215n) l=45n nf=1 m=(1)
mp10 (net361 VSS net292 NW) g45p1svt w=(215n) l=45n nf=1 m=(1)
mp6 (net377 VSS net308 NW) g45p1svt w=(215n) l=45n nf=1 m=(1)
mp5 (net308 net385 VDD NW) g45p1svt w=(215n) l=45n nf=1 m=(1)
mp4 (net385 VSS net316 NW) g45p1svt w=(215n) l=45n nf=1 m=(1)
mp3 (net316 net393 VDD NW) g45p1svt w=(215n) l=45n nf=1 m=(1)
mp2 (net393 VSS net324 NW) g45p1svt w=(215n) l=45n nf=1 m=(1)
mp1 (net324 net397 VDD NW) g45p1svt w=(215n) l=45n nf=1 m=(1)
mp11 (net284 net361 VDD NW) g45p1svt w=(215n) l=45n nf=1 m=(1)
mp12 (net353 VSS net284 NW) g45p1svt w=(215n) l=45n nf=1 m=(1)
mp13 (net276 net353 VDD NW) g45p1svt w=(215n) l=45n nf=1 m=(1)
mp14 (net345 VSS net276 NW) g45p1svt w=(215n) l=45n nf=1 m=(1)
mp15 (net333 net345 VDD NW) g45p1svt w=(215n) l=45n nf=1 m=(1)
mp0 (net397 A VDD NW) g45p1svt w=(215n) l=45n nf=1 m=(1)
mp16 (Y net333 VDD NW) g45p1svt w=(390n) l=45n nf=1 m=(1)
ends DLY4X1

// gsclib045_backbias/DLY4X4/schematic

simulator lang=spectre

subckt DLY4X4 A Y VDD VSS NW
mn14 (net345 VDD net341 VSS) g45n1svt w=(145n) l=45n nf=1 m=(1)
mn13 (net341 net353 VSS VSS) g45n1svt w=(145n) l=45n nf=1 m=(1)
mn12 (net353 VDD net349 VSS) g45n1svt w=(145n) l=45n nf=1 m=(1)
mn11 (net349 net361 VSS VSS) g45n1svt w=(145n) l=45n nf=1 m=(1)
mn10 (net361 VDD net357 VSS) g45n1svt w=(145n) l=45n nf=1 m=(1)
mn9 (net357 net369 VSS VSS) g45n1svt w=(145n) l=45n nf=1 m=(1)
mn15 (net333 net345 VSS VSS) g45n1svt w=(260n) l=45n nf=1 m=(1)
mn6 (net377 VDD net373 VSS) g45n1svt w=(145n) l=45n nf=1 m=(1)
mn0 (net397 A VSS VSS) g45n1svt w=(145n) l=45n nf=1 m=(1)
mn4 (net385 VDD net381 VSS) g45n1svt w=(145n) l=45n nf=1 m=(1)
mn1 (net389 net397 VSS VSS) g45n1svt w=(145n) l=45n nf=1 m=(1)
mn7 (net365 net377 VSS VSS) g45n1svt w=(145n) l=45n nf=1 m=(1)
mn16 (Y net333 VSS VSS) g45n1svt w=(1.04u) l=45n nf=1 m=(1)
mn3 (net381 net393 VSS VSS) g45n1svt w=(145n) l=45n nf=1 m=(1)
mn2 (net393 VDD net389 VSS) g45n1svt w=(145n) l=45n nf=1 m=(1)
mn8 (net369 VDD net365 VSS) g45n1svt w=(145n) l=45n nf=1 m=(1)
mn5 (net373 net385 VSS VSS) g45n1svt w=(145n) l=45n nf=1 m=(1)
mp8 (net369 VSS net300 NW) g45p1svt w=(215n) l=45n nf=1 m=(1)
mp7 (net300 net377 VDD NW) g45p1svt w=(215n) l=45n nf=1 m=(1)
mp9 (net292 net369 VDD NW) g45p1svt w=(215n) l=45n nf=1 m=(1)
mp10 (net361 VSS net292 NW) g45p1svt w=(215n) l=45n nf=1 m=(1)
mp6 (net377 VSS net308 NW) g45p1svt w=(215n) l=45n nf=1 m=(1)
mp5 (net308 net385 VDD NW) g45p1svt w=(215n) l=45n nf=1 m=(1)
mp4 (net385 VSS net316 NW) g45p1svt w=(215n) l=45n nf=1 m=(1)
mp3 (net316 net393 VDD NW) g45p1svt w=(215n) l=45n nf=1 m=(1)
mp2 (net393 VSS net324 NW) g45p1svt w=(215n) l=45n nf=1 m=(1)
mp1 (net324 net397 VDD NW) g45p1svt w=(215n) l=45n nf=1 m=(1)
mp11 (net284 net361 VDD NW) g45p1svt w=(215n) l=45n nf=1 m=(1)
mp12 (net353 VSS net284 NW) g45p1svt w=(215n) l=45n nf=1 m=(1)
mp13 (net276 net353 VDD NW) g45p1svt w=(215n) l=45n nf=1 m=(1)
mp14 (net345 VSS net276 NW) g45p1svt w=(215n) l=45n nf=1 m=(1)
mp15 (net333 net345 VDD NW) g45p1svt w=(390n) l=45n nf=1 m=(1)
mp0 (net397 A VDD NW) g45p1svt w=(215n) l=45n nf=1 m=(1)
mp16 (Y net333 VDD NW) g45p1svt w=(1.56u) l=45n nf=1 m=(1)
ends DLY4X4

// gsclib045_backbias/DFFHQX1/schematic

simulator lang=spectre

subckt DFFHQX1 CK D Q VSS NW VDD
mn26 (n20 CKb n21 VSS) g45n1svt w=(205n) l=45n nf=1 m=(1)
mn25 (n21 D VSS VSS) g45n1svt w=(205n) l=45n nf=1 m=(1)
mn55 (Q qbint VSS VSS) g45n1svt w=(260n) l=45n nf=1 m=(1)
mn50 (net172 qbint VSS VSS) g45n1svt w=(205n) l=45n nf=1 m=(1)
mn51 (n30 CKb net172 VSS) g45n1svt w=(205n) l=45n nf=1 m=(1)
mn30 (mout n20 VSS VSS) g45n1svt w=(205n) l=45n nf=1 m=(1)
mn36 (n20 CKbb net192 VSS) g45n1svt w=(205n) l=45n nf=1 m=(1)
mn20 (CKb CK VSS VSS) g45n1svt w=(145n) l=45n nf=1 m=(1)
mn45 (qbint n30 VSS VSS) g45n1svt w=(205n) l=45n nf=1 m=(1)
mn40 (mout CKbb n30 VSS) g45n1svt w=(205n) l=45n nf=1 m=(1)
mn21 (CKbb CKb VSS VSS) g45n1svt w=(145n) l=45n nf=1 m=(1)
mn35 (net192 mout VSS VSS) g45n1svt w=(205n) l=45n nf=1 m=(1)
mp26 (n20 CKbb n22 NW) g45p1svt w=(310n) l=45n nf=1 m=(1)
mp25 (n22 D VDD NW) g45p1svt w=(310n) l=45n nf=1 m=(1)
mp51 (n30 CKbb net123 NW) g45p1svt w=(310n) l=45n nf=1 m=(1)
mp50 (net123 qbint VDD NW) g45p1svt w=(310n) l=45n nf=1 m=(1)
mp55 (Q qbint VDD NW) g45p1svt w=(390n) l=45n nf=1 m=(1)
mp35 (net147 mout VDD NW) g45p1svt w=(310n) l=45n nf=1 m=(1)
mp36 (n20 CKb net147 NW) g45p1svt w=(310n) l=45n nf=1 m=(1)
mp45 (qbint n30 VDD NW) g45p1svt w=(310n) l=45n nf=1 m=(1)
mp20 (CKb CK VDD NW) g45p1svt w=(215n) l=45n nf=1 m=(1)
mp40 (mout CKb n30 NW) g45p1svt w=(310n) l=45n nf=1 m=(1)
mp30 (mout n20 VDD NW) g45p1svt w=(310n) l=45n nf=1 m=(1)
mp21 (CKbb CKb VDD NW) g45p1svt w=(215n) l=45n nf=1 m=(1)
ends DFFHQX1

// gsclib045_backbias/DFFHQX2/schematic

simulator lang=spectre

subckt DFFHQX2 CK D Q VSS NW VDD
mn26 (n20 CKb n21 VSS) g45n1svt w=(205n) l=45n nf=1 m=(1)
mn25 (n21 D VSS VSS) g45n1svt w=(205n) l=45n nf=1 m=(1)
mn55 (Q qbint VSS VSS) g45n1svt w=(520n) l=45n nf=1 m=(1)
mn50 (net172 qbint VSS VSS) g45n1svt w=(205n) l=45n nf=1 m=(1)
mn51 (n30 CKb net172 VSS) g45n1svt w=(205n) l=45n nf=1 m=(1)
mn30 (mout n20 VSS VSS) g45n1svt w=(205n) l=45n nf=1 m=(1)
mn36 (n20 CKbb net192 VSS) g45n1svt w=(205n) l=45n nf=1 m=(1)
mn20 (CKb CK VSS VSS) g45n1svt w=(145n) l=45n nf=1 m=(1)
mn45 (qbint n30 VSS VSS) g45n1svt w=(205n) l=45n nf=1 m=(1)
mn40 (mout CKbb n30 VSS) g45n1svt w=(205n) l=45n nf=1 m=(1)
mn21 (CKbb CKb VSS VSS) g45n1svt w=(145n) l=45n nf=1 m=(1)
mn35 (net192 mout VSS VSS) g45n1svt w=(205n) l=45n nf=1 m=(1)
mp26 (n20 CKbb n22 NW) g45p1svt w=(310n) l=45n nf=1 m=(1)
mp25 (n22 D VDD NW) g45p1svt w=(310n) l=45n nf=1 m=(1)
mp51 (n30 CKbb net123 NW) g45p1svt w=(310n) l=45n nf=1 m=(1)
mp50 (net123 qbint VDD NW) g45p1svt w=(310n) l=45n nf=1 m=(1)
mp55 (Q qbint VDD NW) g45p1svt w=(780n) l=45n nf=1 m=(1)
mp35 (net147 mout VDD NW) g45p1svt w=(310n) l=45n nf=1 m=(1)
mp36 (n20 CKb net147 NW) g45p1svt w=(310n) l=45n nf=1 m=(1)
mp45 (qbint n30 VDD NW) g45p1svt w=(310n) l=45n nf=1 m=(1)
mp20 (CKb CK VDD NW) g45p1svt w=(215n) l=45n nf=1 m=(1)
mp40 (mout CKb n30 NW) g45p1svt w=(310n) l=45n nf=1 m=(1)
mp30 (mout n20 VDD NW) g45p1svt w=(310n) l=45n nf=1 m=(1)
mp21 (CKbb CKb VDD NW) g45p1svt w=(215n) l=45n nf=1 m=(1)
ends DFFHQX2

// gsclib045_backbias/DFFHQX4/schematic

simulator lang=spectre

subckt DFFHQX4 CK D Q VSS NW VDD
mn26 (n20 CKb n21 VSS) g45n1svt w=(205n) l=45n nf=1 m=(1)
mn25 (n21 D VSS VSS) g45n1svt w=(205n) l=45n nf=1 m=(1)
mn55 (Q qbint VSS VSS) g45n1svt w=(1.04u) l=45n nf=1 m=(1)
mn50 (net172 qbint VSS VSS) g45n1svt w=(205n) l=45n nf=1 m=(1)
mn51 (n30 CKb net172 VSS) g45n1svt w=(205n) l=45n nf=1 m=(1)
mn30 (mout n20 VSS VSS) g45n1svt w=(205n) l=45n nf=1 m=(1)
mn36 (n20 CKbb net192 VSS) g45n1svt w=(205n) l=45n nf=1 m=(1)
mn20 (CKb CK VSS VSS) g45n1svt w=(145n) l=45n nf=1 m=(1)
mn45 (qbint n30 VSS VSS) g45n1svt w=(410n) l=45n nf=1 m=(1)
mn40 (mout CKbb n30 VSS) g45n1svt w=(205n) l=45n nf=1 m=(1)
mn21 (CKbb CKb VSS VSS) g45n1svt w=(145n) l=45n nf=1 m=(1)
mn35 (net192 mout VSS VSS) g45n1svt w=(205n) l=45n nf=1 m=(1)
mp26 (n20 CKbb n22 NW) g45p1svt w=(310n) l=45n nf=1 m=(1)
mp25 (n22 D VDD NW) g45p1svt w=(310n) l=45n nf=1 m=(1)
mp51 (n30 CKbb net123 NW) g45p1svt w=(310n) l=45n nf=1 m=(1)
mp50 (net123 qbint VDD NW) g45p1svt w=(310n) l=45n nf=1 m=(1)
mp55 (Q qbint VDD NW) g45p1svt w=(1.56u) l=45n nf=1 m=(1)
mp35 (net147 mout VDD NW) g45p1svt w=(310n) l=45n nf=1 m=(1)
mp36 (n20 CKb net147 NW) g45p1svt w=(310n) l=45n nf=1 m=(1)
mp45 (qbint n30 VDD NW) g45p1svt w=(620n) l=45n nf=1 m=(1)
mp20 (CKb CK VDD NW) g45p1svt w=(215n) l=45n nf=1 m=(1)
mp40 (mout CKb n30 NW) g45p1svt w=(310n) l=45n nf=1 m=(1)
mp30 (mout n20 VDD NW) g45p1svt w=(310n) l=45n nf=1 m=(1)
mp21 (CKbb CKb VDD NW) g45p1svt w=(215n) l=45n nf=1 m=(1)
ends DFFHQX4

// gsclib045_backbias/DFFHQX8/schematic

simulator lang=spectre

subckt DFFHQX8 CK D Q VSS NW VDD
mn26 (n20 CKb n21 VSS) g45n1svt w=(205n) l=45n nf=1 m=(1)
mn25 (n21 D VSS VSS) g45n1svt w=(205n) l=45n nf=1 m=(1)
mn55 (Q qbint VSS VSS) g45n1svt w=(2.065u) l=45n nf=1 m=(1)
mn50 (net172 qbint VSS VSS) g45n1svt w=(205n) l=45n nf=1 m=(1)
mn51 (n30 CKb net172 VSS) g45n1svt w=(205n) l=45n nf=1 m=(1)
mn30 (mout n20 VSS VSS) g45n1svt w=(205n) l=45n nf=1 m=(1)
mn36 (n20 CKbb net192 VSS) g45n1svt w=(205n) l=45n nf=1 m=(1)
mn20 (CKb CK VSS VSS) g45n1svt w=(145n) l=45n nf=1 m=(1)
mn45 (qbint n30 VSS VSS) g45n1svt w=(780n) l=45n nf=1 m=(1)
mn40 (mout CKbb n30 VSS) g45n1svt w=(205n) l=45n nf=1 m=(1)
mn21 (CKbb CKb VSS VSS) g45n1svt w=(145n) l=45n nf=1 m=(1)
mn35 (net192 mout VSS VSS) g45n1svt w=(205n) l=45n nf=1 m=(1)
mp26 (n20 CKbb n22 NW) g45p1svt w=(310n) l=45n nf=1 m=(1)
mp25 (n22 D VDD NW) g45p1svt w=(310n) l=45n nf=1 m=(1)
mp51 (n30 CKbb net123 NW) g45p1svt w=(310n) l=45n nf=1 m=(1)
mp50 (net123 qbint VDD NW) g45p1svt w=(310n) l=45n nf=1 m=(1)
mp55 (Q qbint VDD NW) g45p1svt w=(3.115u) l=45n nf=1 m=(1)
mp35 (net147 mout VDD NW) g45p1svt w=(310n) l=45n nf=1 m=(1)
mp36 (n20 CKb net147 NW) g45p1svt w=(310n) l=45n nf=1 m=(1)
mp45 (qbint n30 VDD NW) g45p1svt w=(1.17u) l=45n nf=1 m=(1)
mp20 (CKb CK VDD NW) g45p1svt w=(215n) l=45n nf=1 m=(1)
mp40 (mout CKb n30 NW) g45p1svt w=(310n) l=45n nf=1 m=(1)
mp30 (mout n20 VDD NW) g45p1svt w=(310n) l=45n nf=1 m=(1)
mp21 (CKbb CKb VDD NW) g45p1svt w=(215n) l=45n nf=1 m=(1)
ends DFFHQX8

// gsclib045_backbias/DFFNSRX1/schematic

simulator lang=spectre

subckt DFFNSRX1 CKN D Q QN RN SN VSS NW VDD
mn26 (n20 CKNbb n21 VSS) g45n1svt w=(145n) l=45n nf=1 m=(1)
mn25 (n21 D VSS VSS) g45n1svt w=(145n) l=45n nf=1 m=(1)
mn57 (QN qint VSS VSS) g45n1svt w=(260n) l=45n nf=1 m=(1)
mn55 (Q qbint VSS VSS) g45n1svt w=(260n) l=45n nf=1 m=(1)
mn36 (n20 CKNb n30 VSS) g45n1svt w=(145n) l=45n nf=1 m=(1)
mn35 (n30 mout VSS VSS) g45n1svt w=(145n) l=45n nf=1 m=(1)
mn22 (RNb RN VSS VSS) g45n1svt w=(145n) l=45n nf=1 m=(1)
mn20 (CKNb CKN VSS VSS) g45n1svt w=(145n) l=45n nf=1 m=(1)
mn45 (qbint n35 VSS VSS) g45n1svt w=(145n) l=45n nf=1 m=(1)
mn56 (qint qbint VSS VSS) g45n1svt w=(145n) l=45n nf=1 m=(1)
mn52 (n40 qbint n42 VSS) g45n1svt w=(145n) l=45n nf=1 m=(1)
mn51 (n40 RNb n42 VSS) g45n1svt w=(145n) l=45n nf=1 m=(1)
mn50 (n42 SN VSS VSS) g45n1svt w=(145n) l=45n nf=1 m=(1)
mn53 (n40 CKNbb n35 VSS) g45n1svt w=(145n) l=45n nf=1 m=(1)
mn21 (CKNbb CKNb VSS VSS) g45n1svt w=(145n) l=45n nf=1 m=(1)
mn32 (mout n20 n25 VSS) g45n1svt w=(145n) l=45n nf=1 m=(1)
mn31 (n25 RNb mout VSS) g45n1svt w=(145n) l=45n nf=1 m=(1)
mn30 (n25 SN VSS VSS) g45n1svt w=(145n) l=45n nf=1 m=(1)
mn40 (n35 CKNb mout VSS) g45n1svt w=(145n) l=45n nf=1 m=(1)
mp25 (n22 D VDD NW) g45p1svt w=(215n) l=45n nf=1 m=(1)
mp26 (n20 CKNb n22 NW) g45p1svt w=(215n) l=45n nf=1 m=(1)
mp51 (n43 RNb VDD NW) g45p1svt w=(215n) l=45n nf=1 m=(1)
mp57 (QN qint VDD NW) g45p1svt w=(390n) l=45n nf=1 m=(1)
mp55 (Q qbint VDD NW) g45p1svt w=(390n) l=45n nf=1 m=(1)
mp36 (n20 CKNbb n31 NW) g45p1svt w=(215n) l=45n nf=1 m=(1)
mp35 (n31 mout VDD NW) g45p1svt w=(215n) l=45n nf=1 m=(1)
mp32 (mout n20 n26 NW) g45p1svt w=(215n) l=45n nf=1 m=(1)
mp31 (n26 RNb VDD NW) g45p1svt w=(215n) l=45n nf=1 m=(1)
mp22 (RNb RN VDD NW) g45p1svt w=(215n) l=45n nf=1 m=(1)
mp20 (CKNb CKN VDD NW) g45p1svt w=(215n) l=45n nf=1 m=(1)
mp53 (n41 CKNb n35 NW) g45p1svt w=(215n) l=45n nf=1 m=(1)
mp50 (n41 SN VDD NW) g45p1svt w=(215n) l=45n nf=1 m=(1)
mp45 (qbint n35 VDD NW) g45p1svt w=(215n) l=45n nf=1 m=(1)
mp56 (qint qbint VDD NW) g45p1svt w=(215n) l=45n nf=1 m=(1)
mp21 (CKNbb CKNb VDD NW) g45p1svt w=(215n) l=45n nf=1 m=(1)
mp40 (n35 CKNbb mout NW) g45p1svt w=(215n) l=45n nf=1 m=(1)
mp52 (n41 qbint n43 NW) g45p1svt w=(215n) l=45n nf=1 m=(1)
mp30 (mout SN VDD NW) g45p1svt w=(215n) l=45n nf=1 m=(1)
ends DFFNSRX1

// gsclib045_backbias/DFFNSRX2/schematic

simulator lang=spectre

subckt DFFNSRX2 CKN D Q QN RN SN NW VSS VDD
mn26 (n20 CKNbb n21 VSS) g45n1svt w=(145n) l=45n nf=1 m=(1)
mn25 (n21 D VSS VSS) g45n1svt w=(145n) l=45n nf=1 m=(1)
mn57 (QN qint VSS VSS) g45n1svt w=(520n) l=45n nf=1 m=(1)
mn55 (Q qbint VSS VSS) g45n1svt w=(520n) l=45n nf=1 m=(1)
mn36 (n20 CKNb n30 VSS) g45n1svt w=(145n) l=45n nf=1 m=(1)
mn35 (n30 mout VSS VSS) g45n1svt w=(145n) l=45n nf=1 m=(1)
mn22 (RNb RN VSS VSS) g45n1svt w=(145n) l=45n nf=1 m=(1)
mn20 (CKNb CKN VSS VSS) g45n1svt w=(145n) l=45n nf=1 m=(1)
mn45 (qbint n35 VSS VSS) g45n1svt w=(205n) l=45n nf=1 m=(1)
mn56 (qint qbint VSS VSS) g45n1svt w=(145n) l=45n nf=1 m=(1)
mn52 (n40 qbint n42 VSS) g45n1svt w=(145n) l=45n nf=1 m=(1)
mn51 (n40 RNb n42 VSS) g45n1svt w=(145n) l=45n nf=1 m=(1)
mn50 (n42 SN VSS VSS) g45n1svt w=(145n) l=45n nf=1 m=(1)
mn53 (n40 CKNbb n35 VSS) g45n1svt w=(145n) l=45n nf=1 m=(1)
mn21 (CKNbb CKNb VSS VSS) g45n1svt w=(145n) l=45n nf=1 m=(1)
mn32 (mout n20 n25 VSS) g45n1svt w=(145n) l=45n nf=1 m=(1)
mn31 (n25 RNb mout VSS) g45n1svt w=(145n) l=45n nf=1 m=(1)
mn30 (n25 SN VSS VSS) g45n1svt w=(145n) l=45n nf=1 m=(1)
mn40 (n35 CKNb mout VSS) g45n1svt w=(145n) l=45n nf=1 m=(1)
mp25 (n22 D VDD NW) g45p1svt w=(215n) l=45n nf=1 m=(1)
mp26 (n20 CKNb n22 NW) g45p1svt w=(215n) l=45n nf=1 m=(1)
mp51 (n43 RNb VDD NW) g45p1svt w=(215n) l=45n nf=1 m=(1)
mp57 (QN qint VDD NW) g45p1svt w=(780n) l=45n nf=1 m=(1)
mp55 (Q qbint VDD NW) g45p1svt w=(780n) l=45n nf=1 m=(1)
mp36 (n20 CKNbb n31 NW) g45p1svt w=(215n) l=45n nf=1 m=(1)
mp35 (n31 mout VDD NW) g45p1svt w=(215n) l=45n nf=1 m=(1)
mp32 (mout n20 n26 NW) g45p1svt w=(215n) l=45n nf=1 m=(1)
mp31 (n26 RNb VDD NW) g45p1svt w=(215n) l=45n nf=1 m=(1)
mp22 (RNb RN VDD NW) g45p1svt w=(215n) l=45n nf=1 m=(1)
mp20 (CKNb CKN VDD NW) g45p1svt w=(215n) l=45n nf=1 m=(1)
mp53 (n41 CKNb n35 NW) g45p1svt w=(215n) l=45n nf=1 m=(1)
mp50 (n41 SN VDD NW) g45p1svt w=(215n) l=45n nf=1 m=(1)
mp45 (qbint n35 VDD NW) g45p1svt w=(310n) l=45n nf=1 m=(1)
mp56 (qint qbint VDD NW) g45p1svt w=(215n) l=45n nf=1 m=(1)
mp21 (CKNbb CKNb VDD NW) g45p1svt w=(215n) l=45n nf=1 m=(1)
mp40 (n35 CKNbb mout NW) g45p1svt w=(215n) l=45n nf=1 m=(1)
mp52 (n41 qbint n43 NW) g45p1svt w=(215n) l=45n nf=1 m=(1)
mp30 (mout SN VDD NW) g45p1svt w=(215n) l=45n nf=1 m=(1)
ends DFFNSRX2

// gsclib045_backbias/DFFNSRX4/schematic

simulator lang=spectre

subckt DFFNSRX4 CKN D Q QN RN SN NW VSS VDD
mn26 (n20 CKNbb n21 VSS) g45n1svt w=(145n) l=45n nf=1 m=(1)
mn25 (n21 D VSS VSS) g45n1svt w=(145n) l=45n nf=1 m=(1)
mn57 (QN qint VSS VSS) g45n1svt w=(1.04u) l=45n nf=1 m=(1)
mn55 (Q qbint VSS VSS) g45n1svt w=(1.04u) l=45n nf=1 m=(1)
mn36 (n20 CKNb n30 VSS) g45n1svt w=(145n) l=45n nf=1 m=(1)
mn35 (n30 mout VSS VSS) g45n1svt w=(145n) l=45n nf=1 m=(1)
mn22 (RNb RN VSS VSS) g45n1svt w=(145n) l=45n nf=1 m=(1)
mn20 (CKNb CKN VSS VSS) g45n1svt w=(145n) l=45n nf=1 m=(1)
mn45 (qbint n35 VSS VSS) g45n1svt w=(410n) l=45n nf=1 m=(1)
mn56 (qint qbint VSS VSS) g45n1svt w=(260n) l=45n nf=1 m=(1)
mn52 (n40 qbint n42 VSS) g45n1svt w=(145n) l=45n nf=1 m=(1)
mn51 (n40 RNb n42 VSS) g45n1svt w=(145n) l=45n nf=1 m=(1)
mn50 (n42 SN VSS VSS) g45n1svt w=(145n) l=45n nf=1 m=(1)
mn53 (n40 CKNbb n35 VSS) g45n1svt w=(145n) l=45n nf=1 m=(1)
mn21 (CKNbb CKNb VSS VSS) g45n1svt w=(145n) l=45n nf=1 m=(1)
mn32 (mout n20 n25 VSS) g45n1svt w=(145n) l=45n nf=1 m=(1)
mn31 (n25 RNb mout VSS) g45n1svt w=(145n) l=45n nf=1 m=(1)
mn30 (n25 SN VSS VSS) g45n1svt w=(145n) l=45n nf=1 m=(1)
mn40 (n35 CKNb mout VSS) g45n1svt w=(145n) l=45n nf=1 m=(1)
mp25 (n22 D VDD NW) g45p1svt w=(215n) l=45n nf=1 m=(1)
mp26 (n20 CKNb n22 NW) g45p1svt w=(215n) l=45n nf=1 m=(1)
mp51 (n43 RNb VDD NW) g45p1svt w=(215n) l=45n nf=1 m=(1)
mp57 (QN qint VDD NW) g45p1svt w=(1.56u) l=45n nf=1 m=(1)
mp55 (Q qbint VDD NW) g45p1svt w=(1.56u) l=45n nf=1 m=(1)
mp36 (n20 CKNbb n31 NW) g45p1svt w=(215n) l=45n nf=1 m=(1)
mp35 (n31 mout VDD NW) g45p1svt w=(215n) l=45n nf=1 m=(1)
mp32 (mout n20 n26 NW) g45p1svt w=(215n) l=45n nf=1 m=(1)
mp31 (n26 RNb VDD NW) g45p1svt w=(215n) l=45n nf=1 m=(1)
mp22 (RNb RN VDD NW) g45p1svt w=(215n) l=45n nf=1 m=(1)
mp20 (CKNb CKN VDD NW) g45p1svt w=(215n) l=45n nf=1 m=(1)
mp53 (n41 CKNb n35 NW) g45p1svt w=(215n) l=45n nf=1 m=(1)
mp50 (n41 SN VDD NW) g45p1svt w=(215n) l=45n nf=1 m=(1)
mp45 (qbint n35 VDD NW) g45p1svt w=(620n) l=45n nf=1 m=(1)
mp56 (qint qbint VDD NW) g45p1svt w=(390n) l=45n nf=1 m=(1)
mp21 (CKNbb CKNb VDD NW) g45p1svt w=(215n) l=45n nf=1 m=(1)
mp40 (n35 CKNbb mout NW) g45p1svt w=(215n) l=45n nf=1 m=(1)
mp52 (n41 qbint n43 NW) g45p1svt w=(215n) l=45n nf=1 m=(1)
mp30 (mout SN VDD NW) g45p1svt w=(215n) l=45n nf=1 m=(1)
ends DFFNSRX4

// gsclib045_backbias/DFFNSRXL/schematic

simulator lang=spectre

subckt DFFNSRXL CKN D Q QN RN SN NW VSS VDD
mn26 (n20 CKNbb n21 VSS) g45n1svt w=(145n) l=45n nf=1 m=(1)
mn25 (n21 D VSS VSS) g45n1svt w=(145n) l=45n nf=1 m=(1)
mn57 (QN qint VSS VSS) g45n1svt w=(145n) l=45n nf=1 m=(1)
mn55 (Q qbint VSS VSS) g45n1svt w=(145n) l=45n nf=1 m=(1)
mn36 (n20 CKNb n30 VSS) g45n1svt w=(145n) l=45n nf=1 m=(1)
mn35 (n30 mout VSS VSS) g45n1svt w=(145n) l=45n nf=1 m=(1)
mn22 (RNb RN VSS VSS) g45n1svt w=(145n) l=45n nf=1 m=(1)
mn20 (CKNb CKN VSS VSS) g45n1svt w=(145n) l=45n nf=1 m=(1)
mn45 (qbint n35 VSS VSS) g45n1svt w=(145n) l=45n nf=1 m=(1)
mn56 (qint qbint VSS VSS) g45n1svt w=(145n) l=45n nf=1 m=(1)
mn52 (n40 qbint n42 VSS) g45n1svt w=(145n) l=45n nf=1 m=(1)
mn51 (n40 RNb n42 VSS) g45n1svt w=(145n) l=45n nf=1 m=(1)
mn50 (n42 SN VSS VSS) g45n1svt w=(145n) l=45n nf=1 m=(1)
mn53 (n40 CKNbb n35 VSS) g45n1svt w=(145n) l=45n nf=1 m=(1)
mn21 (CKNbb CKNb VSS VSS) g45n1svt w=(145n) l=45n nf=1 m=(1)
mn32 (mout n20 n25 VSS) g45n1svt w=(145n) l=45n nf=1 m=(1)
mn31 (n25 RNb mout VSS) g45n1svt w=(145n) l=45n nf=1 m=(1)
mn30 (n25 SN VSS VSS) g45n1svt w=(145n) l=45n nf=1 m=(1)
mn40 (n35 CKNb mout VSS) g45n1svt w=(145n) l=45n nf=1 m=(1)
mp25 (n22 D VDD NW) g45p1svt w=(215n) l=45n nf=1 m=(1)
mp26 (n20 CKNb n22 NW) g45p1svt w=(215n) l=45n nf=1 m=(1)
mp51 (n43 RNb VDD NW) g45p1svt w=(215n) l=45n nf=1 m=(1)
mp57 (QN qint VDD NW) g45p1svt w=(215n) l=45n nf=1 m=(1)
mp55 (Q qbint VDD NW) g45p1svt w=(215n) l=45n nf=1 m=(1)
mp36 (n20 CKNbb n31 NW) g45p1svt w=(215n) l=45n nf=1 m=(1)
mp35 (n31 mout VDD NW) g45p1svt w=(215n) l=45n nf=1 m=(1)
mp32 (mout n20 n26 NW) g45p1svt w=(215n) l=45n nf=1 m=(1)
mp31 (n26 RNb VDD NW) g45p1svt w=(215n) l=45n nf=1 m=(1)
mp22 (RNb RN VDD NW) g45p1svt w=(215n) l=45n nf=1 m=(1)
mp20 (CKNb CKN VDD NW) g45p1svt w=(215n) l=45n nf=1 m=(1)
mp53 (n41 CKNb n35 NW) g45p1svt w=(215n) l=45n nf=1 m=(1)
mp50 (n41 SN VDD NW) g45p1svt w=(215n) l=45n nf=1 m=(1)
mp45 (qbint n35 VDD NW) g45p1svt w=(215n) l=45n nf=1 m=(1)
mp56 (qint qbint VDD NW) g45p1svt w=(215n) l=45n nf=1 m=(1)
mp21 (CKNbb CKNb VDD NW) g45p1svt w=(215n) l=45n nf=1 m=(1)
mp40 (n35 CKNbb mout NW) g45p1svt w=(215n) l=45n nf=1 m=(1)
mp52 (n41 qbint n43 NW) g45p1svt w=(215n) l=45n nf=1 m=(1)
mp30 (mout SN VDD NW) g45p1svt w=(215n) l=45n nf=1 m=(1)
ends DFFNSRXL

// gsclib045_backbias/DFFQX1/schematic

simulator lang=spectre

subckt DFFQX1 CK D Q VSS VDD NW
mn26 (n20 CKb n21 VSS) g45n1svt w=(145n) l=45n nf=1 m=(1)
mn25 (n21 D VSS VSS) g45n1svt w=(145n) l=45n nf=1 m=(1)
mn55 (Q qbint VSS VSS) g45n1svt w=(260n) l=45n nf=1 m=(1)
mn50 (n35 qbint VSS VSS) g45n1svt w=(145n) l=45n nf=1 m=(1)
mn51 (n30 CKb n35 VSS) g45n1svt w=(145n) l=45n nf=1 m=(1)
mn35 (n25 mout VSS VSS) g45n1svt w=(145n) l=45n nf=1 m=(1)
mn30 (mout n20 VSS VSS) g45n1svt w=(145n) l=45n nf=1 m=(1)
mn40 (n30 CKbb mout VSS) g45n1svt w=(145n) l=45n nf=1 m=(1)
mn45 (qbint n30 VSS VSS) g45n1svt w=(145n) l=45n nf=1 m=(1)
mn21 (CKbb CKb VSS VSS) g45n1svt w=(145n) l=45n nf=1 m=(1)
mn36 (n20 CKbb n25 VSS) g45n1svt w=(145n) l=45n nf=1 m=(1)
mn20 (CKb CK VSS VSS) g45n1svt w=(145n) l=45n nf=1 m=(1)
mp26 (n20 CKbb n22 NW) g45p1svt w=(215n) l=45n nf=1 m=(1)
mp25 (n22 D VDD NW) g45p1svt w=(215n) l=45n nf=1 m=(1)
mp51 (n30 CKbb n36 NW) g45p1svt w=(215n) l=45n nf=1 m=(1)
mp50 (n36 qbint VDD NW) g45p1svt w=(215n) l=45n nf=1 m=(1)
mp55 (Q qbint VDD NW) g45p1svt w=(390n) l=45n nf=1 m=(1)
mp35 (n26 mout VDD NW) g45p1svt w=(215n) l=45n nf=1 m=(1)
mp36 (n20 CKb n26 NW) g45p1svt w=(215n) l=45n nf=1 m=(1)
mp21 (CKbb CKb VDD NW) g45p1svt w=(215n) l=45n nf=1 m=(1)
mp20 (CKb CK VDD NW) g45p1svt w=(215n) l=45n nf=1 m=(1)
mp45 (qbint n30 VDD NW) g45p1svt w=(215n) l=45n nf=1 m=(1)
mp40 (n30 CKb mout NW) g45p1svt w=(215n) l=45n nf=1 m=(1)
mp30 (mout n20 VDD NW) g45p1svt w=(215n) l=45n nf=1 m=(1)
ends DFFQX1

// gsclib045_backbias/DFFQX2/schematic

simulator lang=spectre

subckt DFFQX2 CK D Q VSS NW VDD
mn26 (n20 CKb n21 VSS) g45n1svt w=(145n) l=45n nf=1 m=(1)
mn25 (n21 D VSS VSS) g45n1svt w=(145n) l=45n nf=1 m=(1)
mn55 (Q qbint VSS VSS) g45n1svt w=(520n) l=45n nf=1 m=(1)
mn50 (n35 qbint VSS VSS) g45n1svt w=(145n) l=45n nf=1 m=(1)
mn51 (n30 CKb n35 VSS) g45n1svt w=(145n) l=45n nf=1 m=(1)
mn35 (n25 mout VSS VSS) g45n1svt w=(145n) l=45n nf=1 m=(1)
mn30 (mout n20 VSS VSS) g45n1svt w=(145n) l=45n nf=1 m=(1)
mn40 (n30 CKbb mout VSS) g45n1svt w=(145n) l=45n nf=1 m=(1)
mn45 (qbint n30 VSS VSS) g45n1svt w=(205n) l=45n nf=1 m=(1)
mn21 (CKbb CKb VSS VSS) g45n1svt w=(145n) l=45n nf=1 m=(1)
mn36 (n20 CKbb n25 VSS) g45n1svt w=(145n) l=45n nf=1 m=(1)
mn20 (CKb CK VSS VSS) g45n1svt w=(145n) l=45n nf=1 m=(1)
mp26 (n20 CKbb n22 NW) g45p1svt w=(215n) l=45n nf=1 m=(1)
mp25 (n22 D VDD NW) g45p1svt w=(215n) l=45n nf=1 m=(1)
mp51 (n30 CKbb n36 NW) g45p1svt w=(215n) l=45n nf=1 m=(1)
mp50 (n36 qbint VDD NW) g45p1svt w=(215n) l=45n nf=1 m=(1)
mp55 (Q qbint VDD NW) g45p1svt w=(780n) l=45n nf=1 m=(1)
mp35 (n26 mout VDD NW) g45p1svt w=(215n) l=45n nf=1 m=(1)
mp36 (n20 CKb n26 NW) g45p1svt w=(215n) l=45n nf=1 m=(1)
mp21 (CKbb CKb VDD NW) g45p1svt w=(215n) l=45n nf=1 m=(1)
mp20 (CKb CK VDD NW) g45p1svt w=(215n) l=45n nf=1 m=(1)
mp45 (qbint n30 VDD NW) g45p1svt w=(310n) l=45n nf=1 m=(1)
mp40 (n30 CKb mout NW) g45p1svt w=(215n) l=45n nf=1 m=(1)
mp30 (mout n20 VDD NW) g45p1svt w=(215n) l=45n nf=1 m=(1)
ends DFFQX2

// gsclib045_backbias/DFFQX4/schematic

simulator lang=spectre

subckt DFFQX4 CK D Q VSS NW VDD
mn26 (n20 CKb n21 VSS) g45n1svt w=(145n) l=45n nf=1 m=(1)
mn25 (n21 D VSS VSS) g45n1svt w=(145n) l=45n nf=1 m=(1)
mn55 (Q qbint VSS VSS) g45n1svt w=(1.04u) l=45n nf=1 m=(1)
mn50 (n35 qbint VSS VSS) g45n1svt w=(145n) l=45n nf=1 m=(1)
mn51 (n30 CKb n35 VSS) g45n1svt w=(145n) l=45n nf=1 m=(1)
mn35 (n25 mout VSS VSS) g45n1svt w=(145n) l=45n nf=1 m=(1)
mn30 (mout n20 VSS VSS) g45n1svt w=(145n) l=45n nf=1 m=(1)
mn40 (n30 CKbb mout VSS) g45n1svt w=(145n) l=45n nf=1 m=(1)
mn45 (qbint n30 VSS VSS) g45n1svt w=(410n) l=45n nf=1 m=(1)
mn21 (CKbb CKb VSS VSS) g45n1svt w=(145n) l=45n nf=1 m=(1)
mn36 (n20 CKbb n25 VSS) g45n1svt w=(145n) l=45n nf=1 m=(1)
mn20 (CKb CK VSS VSS) g45n1svt w=(145n) l=45n nf=1 m=(1)
mp26 (n20 CKbb n22 NW) g45p1svt w=(215n) l=45n nf=1 m=(1)
mp25 (n22 D VDD NW) g45p1svt w=(215n) l=45n nf=1 m=(1)
mp51 (n30 CKbb n36 NW) g45p1svt w=(215n) l=45n nf=1 m=(1)
mp50 (n36 qbint VDD NW) g45p1svt w=(215n) l=45n nf=1 m=(1)
mp55 (Q qbint VDD NW) g45p1svt w=(1.56u) l=45n nf=1 m=(1)
mp35 (n26 mout VDD NW) g45p1svt w=(215n) l=45n nf=1 m=(1)
mp36 (n20 CKb n26 NW) g45p1svt w=(215n) l=45n nf=1 m=(1)
mp21 (CKbb CKb VDD NW) g45p1svt w=(215n) l=45n nf=1 m=(1)
mp20 (CKb CK VDD NW) g45p1svt w=(215n) l=45n nf=1 m=(1)
mp45 (qbint n30 VDD NW) g45p1svt w=(620n) l=45n nf=1 m=(1)
mp40 (n30 CKb mout NW) g45p1svt w=(215n) l=45n nf=1 m=(1)
mp30 (mout n20 VDD NW) g45p1svt w=(215n) l=45n nf=1 m=(1)
ends DFFQX4

// gsclib045_backbias/DFFQXL/schematic

simulator lang=spectre

subckt DFFQXL CK D Q VSS NW VDD
mn26 (n20 CKb n21 VSS) g45n1svt w=(145n) l=45n nf=1 m=(1)
mn25 (n21 D VSS VSS) g45n1svt w=(145n) l=45n nf=1 m=(1)
mn55 (Q qbint VSS VSS) g45n1svt w=(145n) l=45n nf=1 m=(1)
mn50 (n35 qbint VSS VSS) g45n1svt w=(145n) l=45n nf=1 m=(1)
mn51 (n30 CKb n35 VSS) g45n1svt w=(145n) l=45n nf=1 m=(1)
mn35 (n25 mout VSS VSS) g45n1svt w=(145n) l=45n nf=1 m=(1)
mn30 (mout n20 VSS VSS) g45n1svt w=(145n) l=45n nf=1 m=(1)
mn40 (n30 CKbb mout VSS) g45n1svt w=(145n) l=45n nf=1 m=(1)
mn45 (qbint n30 VSS VSS) g45n1svt w=(145n) l=45n nf=1 m=(1)
mn21 (CKbb CKb VSS VSS) g45n1svt w=(145n) l=45n nf=1 m=(1)
mn36 (n20 CKbb n25 VSS) g45n1svt w=(145n) l=45n nf=1 m=(1)
mn20 (CKb CK VSS VSS) g45n1svt w=(145n) l=45n nf=1 m=(1)
mp26 (n20 CKbb n22 NW) g45p1svt w=(215n) l=45n nf=1 m=(1)
mp25 (n22 D VDD NW) g45p1svt w=(215n) l=45n nf=1 m=(1)
mp51 (n30 CKbb n36 NW) g45p1svt w=(215n) l=45n nf=1 m=(1)
mp50 (n36 qbint VDD NW) g45p1svt w=(215n) l=45n nf=1 m=(1)
mp55 (Q qbint VDD NW) g45p1svt w=(215n) l=45n nf=1 m=(1)
mp35 (n26 mout VDD NW) g45p1svt w=(215n) l=45n nf=1 m=(1)
mp36 (n20 CKb n26 NW) g45p1svt w=(215n) l=45n nf=1 m=(1)
mp21 (CKbb CKb VDD NW) g45p1svt w=(215n) l=45n nf=1 m=(1)
mp20 (CKb CK VDD NW) g45p1svt w=(215n) l=45n nf=1 m=(1)
mp45 (qbint n30 VDD NW) g45p1svt w=(215n) l=45n nf=1 m=(1)
mp40 (n30 CKb mout NW) g45p1svt w=(215n) l=45n nf=1 m=(1)
mp30 (mout n20 VDD NW) g45p1svt w=(215n) l=45n nf=1 m=(1)
ends DFFQXL

// gsclib045_backbias/DFFRHQX1/schematic

simulator lang=spectre

subckt DFFRHQX1 CK D Q RN NW VSS VDD
mn36 (n25 mout n27 VSS) g45n1svt w=(205n) l=45n nf=1 m=(1)
mn35 (n27 RN VSS VSS) g45n1svt w=(205n) l=45n nf=1 m=(1)
mn37 (n20 CKbb n25 VSS) g45n1svt w=(205n) l=45n nf=1 m=(1)
mn26 (n20 CKb n21 VSS) g45n1svt w=(205n) l=45n nf=1 m=(1)
mn25 (n21 D VSS VSS) g45n1svt w=(205n) l=45n nf=1 m=(1)
mn55 (Q qbint VSS VSS) g45n1svt w=(260n) l=45n nf=1 m=(1)
mn45 (n35 RN VSS VSS) g45n1svt w=(205n) l=45n nf=1 m=(1)
mn46 (qbint n30 n35 VSS) g45n1svt w=(205n) l=45n nf=1 m=(1)
mn51 (n30 CKb n40 VSS) g45n1svt w=(205n) l=45n nf=1 m=(1)
mn50 (n40 qbint VSS VSS) g45n1svt w=(205n) l=45n nf=1 m=(1)
mn20 (CKb CK VSS VSS) g45n1svt w=(145n) l=45n nf=1 m=(1)
mn21 (CKbb CKb VSS VSS) g45n1svt w=(145n) l=45n nf=1 m=(1)
mn40 (n30 CKbb mout VSS) g45n1svt w=(205n) l=45n nf=1 m=(1)
mn30 (mout n20 VSS VSS) g45n1svt w=(205n) l=45n nf=1 m=(1)
mp26 (n20 CKbb n22 NW) g45p1svt w=(310n) l=45n nf=1 m=(1)
mp25 (n22 D VDD NW) g45p1svt w=(310n) l=45n nf=1 m=(1)
mp51 (n30 CKbb n41 NW) g45p1svt w=(310n) l=45n nf=1 m=(1)
mp50 (n41 qbint VDD NW) g45p1svt w=(310n) l=45n nf=1 m=(1)
mp55 (Q qbint VDD NW) g45p1svt w=(390n) l=45n nf=1 m=(1)
mp20 (CKb CK VDD NW) g45p1svt w=(215n) l=45n nf=1 m=(1)
mp46 (qbint n30 VDD NW) g45p1svt w=(310n) l=45n nf=1 m=(1)
mp45 (qbint RN VDD NW) g45p1svt w=(310n) l=45n nf=1 m=(1)
mp35 (n26 RN VDD NW) g45p1svt w=(310n) l=45n nf=1 m=(1)
mp36 (n26 mout VDD NW) g45p1svt w=(310n) l=45n nf=1 m=(1)
mp37 (n20 CKb n26 NW) g45p1svt w=(310n) l=45n nf=1 m=(1)
mp40 (n30 CKb mout NW) g45p1svt w=(310n) l=45n nf=1 m=(1)
mp30 (mout n20 VDD NW) g45p1svt w=(310n) l=45n nf=1 m=(1)
mp21 (CKbb CKb VDD NW) g45p1svt w=(215n) l=45n nf=1 m=(1)
ends DFFRHQX1

// gsclib045_backbias/DFFRHQX2/schematic

simulator lang=spectre

subckt DFFRHQX2 CK D Q RN VDD VSS NW
mn36 (n25 mout n27 VSS) g45n1svt w=(205n) l=45n nf=1 m=(1)
mn35 (n27 RN VSS VSS) g45n1svt w=(205n) l=45n nf=1 m=(1)
mn37 (n20 CKbb n25 VSS) g45n1svt w=(205n) l=45n nf=1 m=(1)
mn26 (n20 CKb n21 VSS) g45n1svt w=(205n) l=45n nf=1 m=(1)
mn25 (n21 D VSS VSS) g45n1svt w=(205n) l=45n nf=1 m=(1)
mn55 (Q qbint VSS VSS) g45n1svt w=(520n) l=45n nf=1 m=(1)
mn45 (n35 RN VSS VSS) g45n1svt w=(205n) l=45n nf=1 m=(1)
mn46 (qbint n30 n35 VSS) g45n1svt w=(205n) l=45n nf=1 m=(1)
mn51 (n30 CKb n40 VSS) g45n1svt w=(205n) l=45n nf=1 m=(1)
mn50 (n40 qbint VSS VSS) g45n1svt w=(205n) l=45n nf=1 m=(1)
mn20 (CKb CK VSS VSS) g45n1svt w=(145n) l=45n nf=1 m=(1)
mn21 (CKbb CKb VSS VSS) g45n1svt w=(145n) l=45n nf=1 m=(1)
mn40 (n30 CKbb mout VSS) g45n1svt w=(205n) l=45n nf=1 m=(1)
mn30 (mout n20 VSS VSS) g45n1svt w=(205n) l=45n nf=1 m=(1)
mp26 (n20 CKbb n22 NW) g45p1svt w=(310n) l=45n nf=1 m=(1)
mp25 (n22 D VDD NW) g45p1svt w=(310n) l=45n nf=1 m=(1)
mp51 (n30 CKbb n41 NW) g45p1svt w=(310n) l=45n nf=1 m=(1)
mp50 (n41 qbint VDD NW) g45p1svt w=(310n) l=45n nf=1 m=(1)
mp55 (Q qbint VDD NW) g45p1svt w=(780n) l=45n nf=1 m=(1)
mp20 (CKb CK VDD NW) g45p1svt w=(215n) l=45n nf=1 m=(1)
mp46 (qbint n30 VDD NW) g45p1svt w=(310n) l=45n nf=1 m=(1)
mp45 (qbint RN VDD NW) g45p1svt w=(310n) l=45n nf=1 m=(1)
mp35 (n26 RN VDD NW) g45p1svt w=(310n) l=45n nf=1 m=(1)
mp36 (n26 mout VDD NW) g45p1svt w=(310n) l=45n nf=1 m=(1)
mp37 (n20 CKb n26 NW) g45p1svt w=(310n) l=45n nf=1 m=(1)
mp40 (n30 CKb mout NW) g45p1svt w=(310n) l=45n nf=1 m=(1)
mp30 (mout n20 VDD NW) g45p1svt w=(310n) l=45n nf=1 m=(1)
mp21 (CKbb CKb VDD NW) g45p1svt w=(215n) l=45n nf=1 m=(1)
ends DFFRHQX2

// gsclib045_backbias/DFFRHQX4/schematic

simulator lang=spectre

subckt DFFRHQX4 CK D Q RN VDD VSS NW
mn36 (n25 mout n27 VSS) g45n1svt w=(205n) l=45n nf=1 m=(1)
mn35 (n27 RN VSS VSS) g45n1svt w=(205n) l=45n nf=1 m=(1)
mn37 (n20 CKbb n25 VSS) g45n1svt w=(205n) l=45n nf=1 m=(1)
mn26 (n20 CKb n21 VSS) g45n1svt w=(205n) l=45n nf=1 m=(1)
mn25 (n21 D VSS VSS) g45n1svt w=(205n) l=45n nf=1 m=(1)
mn55 (Q qbint VSS VSS) g45n1svt w=(1.04u) l=45n nf=1 m=(1)
mn45 (n35 RN VSS VSS) g45n1svt w=(410n) l=45n nf=1 m=(1)
mn46 (qbint n30 n35 VSS) g45n1svt w=(410n) l=45n nf=1 m=(1)
mn51 (n30 CKb n40 VSS) g45n1svt w=(205n) l=45n nf=1 m=(1)
mn50 (n40 qbint VSS VSS) g45n1svt w=(205n) l=45n nf=1 m=(1)
mn20 (CKb CK VSS VSS) g45n1svt w=(145n) l=45n nf=1 m=(1)
mn21 (CKbb CKb VSS VSS) g45n1svt w=(145n) l=45n nf=1 m=(1)
mn40 (n30 CKbb mout VSS) g45n1svt w=(205n) l=45n nf=1 m=(1)
mn30 (mout n20 VSS VSS) g45n1svt w=(205n) l=45n nf=1 m=(1)
mp26 (n20 CKbb n22 NW) g45p1svt w=(310n) l=45n nf=1 m=(1)
mp25 (n22 D VDD NW) g45p1svt w=(310n) l=45n nf=1 m=(1)
mp51 (n30 CKbb n41 NW) g45p1svt w=(310n) l=45n nf=1 m=(1)
mp50 (n41 qbint VDD NW) g45p1svt w=(310n) l=45n nf=1 m=(1)
mp55 (Q qbint VDD NW) g45p1svt w=(1.56u) l=45n nf=1 m=(1)
mp20 (CKb CK VDD NW) g45p1svt w=(215n) l=45n nf=1 m=(1)
mp46 (qbint n30 VDD NW) g45p1svt w=(620n) l=45n nf=1 m=(1)
mp45 (qbint RN VDD NW) g45p1svt w=(620n) l=45n nf=1 m=(1)
mp35 (n26 RN VDD NW) g45p1svt w=(310n) l=45n nf=1 m=(1)
mp36 (n26 mout VDD NW) g45p1svt w=(310n) l=45n nf=1 m=(1)
mp37 (n20 CKb n26 NW) g45p1svt w=(310n) l=45n nf=1 m=(1)
mp40 (n30 CKb mout NW) g45p1svt w=(310n) l=45n nf=1 m=(1)
mp30 (mout n20 VDD NW) g45p1svt w=(310n) l=45n nf=1 m=(1)
mp21 (CKbb CKb VDD NW) g45p1svt w=(215n) l=45n nf=1 m=(1)
ends DFFRHQX4

// gsclib045_backbias/DFFRHQX8/schematic

simulator lang=spectre

subckt DFFRHQX8 CK D Q RN VDD VSS NW
mn36 (n25 mout n27 VSS) g45n1svt w=(205n) l=45n nf=1 m=(1)
mn35 (n27 RN VSS VSS) g45n1svt w=(205n) l=45n nf=1 m=(1)
mn37 (n20 CKbb n25 VSS) g45n1svt w=(205n) l=45n nf=1 m=(1)
mn26 (n20 CKb n21 VSS) g45n1svt w=(205n) l=45n nf=1 m=(1)
mn25 (n21 D VSS VSS) g45n1svt w=(205n) l=45n nf=1 m=(1)
mn55 (Q qbint VSS VSS) g45n1svt w=(2.065u) l=45n nf=1 m=(1)
mn45 (n35 RN VSS VSS) g45n1svt w=(780n) l=45n nf=1 m=(1)
mn46 (qbint n30 n35 VSS) g45n1svt w=(780n) l=45n nf=1 m=(1)
mn51 (n30 CKb n40 VSS) g45n1svt w=(205n) l=45n nf=1 m=(1)
mn50 (n40 qbint VSS VSS) g45n1svt w=(205n) l=45n nf=1 m=(1)
mn20 (CKb CK VSS VSS) g45n1svt w=(145n) l=45n nf=1 m=(1)
mn21 (CKbb CKb VSS VSS) g45n1svt w=(145n) l=45n nf=1 m=(1)
mn40 (n30 CKbb mout VSS) g45n1svt w=(205n) l=45n nf=1 m=(1)
mn30 (mout n20 VSS VSS) g45n1svt w=(205n) l=45n nf=1 m=(1)
mp26 (n20 CKbb n22 NW) g45p1svt w=(310n) l=45n nf=1 m=(1)
mp25 (n22 D VDD NW) g45p1svt w=(310n) l=45n nf=1 m=(1)
mp51 (n30 CKbb n41 NW) g45p1svt w=(310n) l=45n nf=1 m=(1)
mp50 (n41 qbint VDD NW) g45p1svt w=(310n) l=45n nf=1 m=(1)
mp55 (Q qbint VDD NW) g45p1svt w=(3.115u) l=45n nf=1 m=(1)
mp20 (CKb CK VDD NW) g45p1svt w=(215n) l=45n nf=1 m=(1)
mp46 (qbint n30 VDD NW) g45p1svt w=(1.17u) l=45n nf=1 m=(1)
mp45 (qbint RN VDD NW) g45p1svt w=(1.17u) l=45n nf=1 m=(1)
mp35 (n26 RN VDD NW) g45p1svt w=(310n) l=45n nf=1 m=(1)
mp36 (n26 mout VDD NW) g45p1svt w=(310n) l=45n nf=1 m=(1)
mp37 (n20 CKb n26 NW) g45p1svt w=(310n) l=45n nf=1 m=(1)
mp40 (n30 CKb mout NW) g45p1svt w=(310n) l=45n nf=1 m=(1)
mp30 (mout n20 VDD NW) g45p1svt w=(310n) l=45n nf=1 m=(1)
mp21 (CKbb CKb VDD NW) g45p1svt w=(215n) l=45n nf=1 m=(1)
ends DFFRHQX8

// gsclib045_backbias/DFFRX1/schematic

simulator lang=spectre

subckt DFFRX1 CK D Q QN RN VSS NW VDD
mn36 (n25 mout n27 VSS) g45n1svt w=(145n) l=45n nf=1 m=(1)
mn35 (n27 RN VSS VSS) g45n1svt w=(145n) l=45n nf=1 m=(1)
mn37 (n20 CKbb n25 VSS) g45n1svt w=(145n) l=45n nf=1 m=(1)
mn26 (n20 CKb n21 VSS) g45n1svt w=(145n) l=45n nf=1 m=(1)
mn25 (n21 D VSS VSS) g45n1svt w=(145n) l=45n nf=1 m=(1)
mn57 (QN qint VSS VSS) g45n1svt w=(260n) l=45n nf=1 m=(1)
mn55 (Q qbint VSS VSS) g45n1svt w=(260n) l=45n nf=1 m=(1)
mn45 (n35 RN VSS VSS) g45n1svt w=(145n) l=45n nf=1 m=(1)
mn46 (qbint n30 n35 VSS) g45n1svt w=(145n) l=45n nf=1 m=(1)
mn51 (n30 CKb n40 VSS) g45n1svt w=(145n) l=45n nf=1 m=(1)
mn50 (n40 qbint VSS VSS) g45n1svt w=(145n) l=45n nf=1 m=(1)
mn21 (CKbb CKb VSS VSS) g45n1svt w=(145n) l=45n nf=1 m=(1)
mn40 (n30 CKbb mout VSS) g45n1svt w=(145n) l=45n nf=1 m=(1)
mn30 (mout n20 VSS VSS) g45n1svt w=(145n) l=45n nf=1 m=(1)
mn56 (qint qbint VSS VSS) g45n1svt w=(145n) l=45n nf=1 m=(1)
mn20 (CKb CK VSS VSS) g45n1svt w=(145n) l=45n nf=1 m=(1)
mp26 (n20 CKbb n22 NW) g45p1svt w=(215n) l=45n nf=1 m=(1)
mp25 (n22 D VDD NW) g45p1svt w=(215n) l=45n nf=1 m=(1)
mp51 (n30 CKbb n41 NW) g45p1svt w=(215n) l=45n nf=1 m=(1)
mp50 (n41 qbint VDD NW) g45p1svt w=(215n) l=45n nf=1 m=(1)
mp57 (QN qint VDD NW) g45p1svt w=(390n) l=45n nf=1 m=(1)
mp55 (Q qbint VDD NW) g45p1svt w=(390n) l=45n nf=1 m=(1)
mp20 (CKb CK VDD NW) g45p1svt w=(215n) l=45n nf=1 m=(1)
mp21 (CKbb CKb VDD NW) g45p1svt w=(215n) l=45n nf=1 m=(1)
mp36 (n26 mout VDD NW) g45p1svt w=(215n) l=45n nf=1 m=(1)
mp30 (mout n20 VDD NW) g45p1svt w=(215n) l=45n nf=1 m=(1)
mp35 (n26 RN VDD NW) g45p1svt w=(215n) l=45n nf=1 m=(1)
mp37 (n20 CKb n26 NW) g45p1svt w=(215n) l=45n nf=1 m=(1)
mp46 (qbint n30 VDD NW) g45p1svt w=(215n) l=45n nf=1 m=(1)
mp40 (n30 CKb mout NW) g45p1svt w=(215n) l=45n nf=1 m=(1)
mp45 (qbint RN VDD NW) g45p1svt w=(215n) l=45n nf=1 m=(1)
mp56 (qint qbint VDD NW) g45p1svt w=(215n) l=45n nf=1 m=(1)
ends DFFRX1

// gsclib045_backbias/DFFRX2/schematic

simulator lang=spectre

subckt DFFRX2 CK D Q QN RN VSS NW VDD
mn36 (n25 mout n27 VSS) g45n1svt w=(145n) l=45n nf=1 m=(1)
mn35 (n27 RN VSS VSS) g45n1svt w=(145n) l=45n nf=1 m=(1)
mn37 (n20 CKbb n25 VSS) g45n1svt w=(145n) l=45n nf=1 m=(1)
mn26 (n20 CKb n21 VSS) g45n1svt w=(145n) l=45n nf=1 m=(1)
mn25 (n21 D VSS VSS) g45n1svt w=(145n) l=45n nf=1 m=(1)
mn57 (QN qint VSS VSS) g45n1svt w=(520n) l=45n nf=1 m=(1)
mn55 (Q qbint VSS VSS) g45n1svt w=(520n) l=45n nf=1 m=(1)
mn45 (n35 RN VSS VSS) g45n1svt w=(205n) l=45n nf=1 m=(1)
mn46 (qbint n30 n35 VSS) g45n1svt w=(205n) l=45n nf=1 m=(1)
mn51 (n30 CKb n40 VSS) g45n1svt w=(145n) l=45n nf=1 m=(1)
mn50 (n40 qbint VSS VSS) g45n1svt w=(145n) l=45n nf=1 m=(1)
mn21 (CKbb CKb VSS VSS) g45n1svt w=(145n) l=45n nf=1 m=(1)
mn40 (n30 CKbb mout VSS) g45n1svt w=(145n) l=45n nf=1 m=(1)
mn30 (mout n20 VSS VSS) g45n1svt w=(145n) l=45n nf=1 m=(1)
mn56 (qint qbint VSS VSS) g45n1svt w=(145n) l=45n nf=1 m=(1)
mn20 (CKb CK VSS VSS) g45n1svt w=(145n) l=45n nf=1 m=(1)
mp26 (n20 CKbb n22 NW) g45p1svt w=(215n) l=45n nf=1 m=(1)
mp25 (n22 D VDD NW) g45p1svt w=(215n) l=45n nf=1 m=(1)
mp51 (n30 CKbb n41 NW) g45p1svt w=(215n) l=45n nf=1 m=(1)
mp50 (n41 qbint VDD NW) g45p1svt w=(215n) l=45n nf=1 m=(1)
mp57 (QN qint VDD NW) g45p1svt w=(780n) l=45n nf=1 m=(1)
mp55 (Q qbint VDD NW) g45p1svt w=(780n) l=45n nf=1 m=(1)
mp20 (CKb CK VDD NW) g45p1svt w=(215n) l=45n nf=1 m=(1)
mp21 (CKbb CKb VDD NW) g45p1svt w=(215n) l=45n nf=1 m=(1)
mp36 (n26 mout VDD NW) g45p1svt w=(215n) l=45n nf=1 m=(1)
mp30 (mout n20 VDD NW) g45p1svt w=(215n) l=45n nf=1 m=(1)
mp35 (n26 RN VDD NW) g45p1svt w=(215n) l=45n nf=1 m=(1)
mp37 (n20 CKb n26 NW) g45p1svt w=(215n) l=45n nf=1 m=(1)
mp46 (qbint n30 VDD NW) g45p1svt w=(310n) l=45n nf=1 m=(1)
mp40 (n30 CKb mout NW) g45p1svt w=(215n) l=45n nf=1 m=(1)
mp45 (qbint RN VDD NW) g45p1svt w=(310n) l=45n nf=1 m=(1)
mp56 (qint qbint VDD NW) g45p1svt w=(215n) l=45n nf=1 m=(1)
ends DFFRX2

// gsclib045_backbias/DFFRX4/schematic

simulator lang=spectre

subckt DFFRX4 CK D Q QN RN VSS NW VDD
mn36 (n25 mout n27 VSS) g45n1svt w=(145n) l=45n nf=1 m=(1)
mn35 (n27 RN VSS VSS) g45n1svt w=(145n) l=45n nf=1 m=(1)
mn37 (n20 CKbb n25 VSS) g45n1svt w=(145n) l=45n nf=1 m=(1)
mn26 (n20 CKb n21 VSS) g45n1svt w=(145n) l=45n nf=1 m=(1)
mn25 (n21 D VSS VSS) g45n1svt w=(145n) l=45n nf=1 m=(1)
mn57 (QN qint VSS VSS) g45n1svt w=(1.04u) l=45n nf=1 m=(1)
mn55 (Q qbint VSS VSS) g45n1svt w=(1.04u) l=45n nf=1 m=(1)
mn45 (n35 RN VSS VSS) g45n1svt w=(410n) l=45n nf=1 m=(1)
mn46 (qbint n30 n35 VSS) g45n1svt w=(410n) l=45n nf=1 m=(1)
mn51 (n30 CKb n40 VSS) g45n1svt w=(145n) l=45n nf=1 m=(1)
mn50 (n40 qbint VSS VSS) g45n1svt w=(145n) l=45n nf=1 m=(1)
mn21 (CKbb CKb VSS VSS) g45n1svt w=(145n) l=45n nf=1 m=(1)
mn40 (n30 CKbb mout VSS) g45n1svt w=(145n) l=45n nf=1 m=(1)
mn30 (mout n20 VSS VSS) g45n1svt w=(145n) l=45n nf=1 m=(1)
mn56 (qint qbint VSS VSS) g45n1svt w=(260n) l=45n nf=1 m=(1)
mn20 (CKb CK VSS VSS) g45n1svt w=(145n) l=45n nf=1 m=(1)
mp26 (n20 CKbb n22 NW) g45p1svt w=(215n) l=45n nf=1 m=(1)
mp25 (n22 D VDD NW) g45p1svt w=(215n) l=45n nf=1 m=(1)
mp51 (n30 CKbb n41 NW) g45p1svt w=(215n) l=45n nf=1 m=(1)
mp50 (n41 qbint VDD NW) g45p1svt w=(215n) l=45n nf=1 m=(1)
mp57 (QN qint VDD NW) g45p1svt w=(1.56u) l=45n nf=1 m=(1)
mp55 (Q qbint VDD NW) g45p1svt w=(1.56u) l=45n nf=1 m=(1)
mp20 (CKb CK VDD NW) g45p1svt w=(215n) l=45n nf=1 m=(1)
mp21 (CKbb CKb VDD NW) g45p1svt w=(215n) l=45n nf=1 m=(1)
mp36 (n26 mout VDD NW) g45p1svt w=(215n) l=45n nf=1 m=(1)
mp30 (mout n20 VDD NW) g45p1svt w=(215n) l=45n nf=1 m=(1)
mp35 (n26 RN VDD NW) g45p1svt w=(215n) l=45n nf=1 m=(1)
mp37 (n20 CKb n26 NW) g45p1svt w=(215n) l=45n nf=1 m=(1)
mp46 (qbint n30 VDD NW) g45p1svt w=(620n) l=45n nf=1 m=(1)
mp40 (n30 CKb mout NW) g45p1svt w=(215n) l=45n nf=1 m=(1)
mp45 (qbint RN VDD NW) g45p1svt w=(620n) l=45n nf=1 m=(1)
mp56 (qint qbint VDD NW) g45p1svt w=(390n) l=45n nf=1 m=(1)
ends DFFRX4

// gsclib045_backbias/DFFRXL/schematic

simulator lang=spectre

subckt DFFRXL CK D Q QN RN VSS NW VDD
mn36 (n25 mout n27 VSS) g45n1svt w=(145n) l=45n nf=1 m=(1)
mn35 (n27 RN VSS VSS) g45n1svt w=(145n) l=45n nf=1 m=(1)
mn37 (n20 CKbb n25 VSS) g45n1svt w=(145n) l=45n nf=1 m=(1)
mn26 (n20 CKb n21 VSS) g45n1svt w=(145n) l=45n nf=1 m=(1)
mn25 (n21 D VSS VSS) g45n1svt w=(145n) l=45n nf=1 m=(1)
mn57 (QN qint VSS VSS) g45n1svt w=(145n) l=45n nf=1 m=(1)
mn55 (Q qbint VSS VSS) g45n1svt w=(145n) l=45n nf=1 m=(1)
mn45 (n35 RN VSS VSS) g45n1svt w=(145n) l=45n nf=1 m=(1)
mn46 (qbint n30 n35 VSS) g45n1svt w=(145n) l=45n nf=1 m=(1)
mn51 (n30 CKb n40 VSS) g45n1svt w=(145n) l=45n nf=1 m=(1)
mn50 (n40 qbint VSS VSS) g45n1svt w=(145n) l=45n nf=1 m=(1)
mn21 (CKbb CKb VSS VSS) g45n1svt w=(145n) l=45n nf=1 m=(1)
mn40 (n30 CKbb mout VSS) g45n1svt w=(145n) l=45n nf=1 m=(1)
mn30 (mout n20 VSS VSS) g45n1svt w=(145n) l=45n nf=1 m=(1)
mn56 (qint qbint VSS VSS) g45n1svt w=(145n) l=45n nf=1 m=(1)
mn20 (CKb CK VSS VSS) g45n1svt w=(145n) l=45n nf=1 m=(1)
mp26 (n20 CKbb n22 NW) g45p1svt w=(215n) l=45n nf=1 m=(1)
mp25 (n22 D VDD NW) g45p1svt w=(215n) l=45n nf=1 m=(1)
mp51 (n30 CKbb n41 NW) g45p1svt w=(215n) l=45n nf=1 m=(1)
mp50 (n41 qbint VDD NW) g45p1svt w=(215n) l=45n nf=1 m=(1)
mp57 (QN qint VDD NW) g45p1svt w=(215n) l=45n nf=1 m=(1)
mp55 (Q qbint VDD NW) g45p1svt w=(215n) l=45n nf=1 m=(1)
mp20 (CKb CK VDD NW) g45p1svt w=(215n) l=45n nf=1 m=(1)
mp21 (CKbb CKb VDD NW) g45p1svt w=(215n) l=45n nf=1 m=(1)
mp36 (n26 mout VDD NW) g45p1svt w=(215n) l=45n nf=1 m=(1)
mp30 (mout n20 VDD NW) g45p1svt w=(215n) l=45n nf=1 m=(1)
mp35 (n26 RN VDD NW) g45p1svt w=(215n) l=45n nf=1 m=(1)
mp37 (n20 CKb n26 NW) g45p1svt w=(215n) l=45n nf=1 m=(1)
mp46 (qbint n30 VDD NW) g45p1svt w=(215n) l=45n nf=1 m=(1)
mp40 (n30 CKb mout NW) g45p1svt w=(215n) l=45n nf=1 m=(1)
mp45 (qbint RN VDD NW) g45p1svt w=(215n) l=45n nf=1 m=(1)
mp56 (qint qbint VDD NW) g45p1svt w=(215n) l=45n nf=1 m=(1)
ends DFFRXL

// gsclib045_backbias/DFFSHQX1/schematic

simulator lang=spectre

subckt DFFSHQX1 CK D Q SN NW VSS VDD
mn51 (n40 qbint n42 VSS) g45n1svt w=(205n) l=45n nf=1 m=(1)
mn52 (n35 CKb n40 VSS) g45n1svt w=(205n) l=45n nf=1 m=(1)
mn50 (n42 SN VSS VSS) g45n1svt w=(205n) l=45n nf=1 m=(1)
mn26 (n20 CKb n21 VSS) g45n1svt w=(205n) l=45n nf=1 m=(1)
mn25 (n21 D VSS VSS) g45n1svt w=(205n) l=45n nf=1 m=(1)
mn55 (Q qbint VSS VSS) g45n1svt w=(260n) l=45n nf=1 m=(1)
mn30 (n25 SN VSS VSS) g45n1svt w=(205n) l=45n nf=1 m=(1)
mn31 (mout n20 n25 VSS) g45n1svt w=(205n) l=45n nf=1 m=(1)
mn35 (n20 CKbb n30 VSS) g45n1svt w=(205n) l=45n nf=1 m=(1)
mn36 (n30 mout VSS VSS) g45n1svt w=(205n) l=45n nf=1 m=(1)
mn20 (CKb CK VSS VSS) g45n1svt w=(145n) l=45n nf=1 m=(1)
mn40 (n35 CKbb mout VSS) g45n1svt w=(205n) l=45n nf=1 m=(1)
mn45 (qbint n35 VSS VSS) g45n1svt w=(205n) l=45n nf=1 m=(1)
mn21 (CKbb CKb VSS VSS) g45n1svt w=(145n) l=45n nf=1 m=(1)
mp26 (n20 CKbb n22 NW) g45p1svt w=(310n) l=45n nf=1 m=(1)
mp25 (n22 D VDD NW) g45p1svt w=(310n) l=45n nf=1 m=(1)
mp55 (Q qbint VDD NW) g45p1svt w=(390n) l=45n nf=1 m=(1)
mp36 (n20 CKb n31 NW) g45p1svt w=(310n) l=45n nf=1 m=(1)
mp35 (n31 mout VDD NW) g45p1svt w=(310n) l=45n nf=1 m=(1)
mp20 (CKb CK VDD NW) g45p1svt w=(215n) l=45n nf=1 m=(1)
mp52 (n35 CKbb n41 NW) g45p1svt w=(310n) l=45n nf=1 m=(1)
mp31 (mout n20 VDD NW) g45p1svt w=(310n) l=45n nf=1 m=(1)
mp21 (CKbb CKb VDD NW) g45p1svt w=(215n) l=45n nf=1 m=(1)
mp50 (n41 SN VDD NW) g45p1svt w=(310n) l=45n nf=1 m=(1)
mp30 (mout SN VDD NW) g45p1svt w=(310n) l=45n nf=1 m=(1)
mp45 (qbint n35 VDD NW) g45p1svt w=(310n) l=45n nf=1 m=(1)
mp51 (n41 qbint VDD NW) g45p1svt w=(310n) l=45n nf=1 m=(1)
mp40 (n35 CKb mout NW) g45p1svt w=(310n) l=45n nf=1 m=(1)
ends DFFSHQX1

// gsclib045_backbias/DFFSHQX2/schematic

simulator lang=spectre

subckt DFFSHQX2 CK D Q SN NW VSS VDD
mn51 (n40 qbint n42 VSS) g45n1svt w=(205n) l=45n nf=1 m=(1)
mn52 (n35 CKb n40 VSS) g45n1svt w=(205n) l=45n nf=1 m=(1)
mn50 (n42 SN VSS VSS) g45n1svt w=(205n) l=45n nf=1 m=(1)
mn26 (n20 CKb n21 VSS) g45n1svt w=(205n) l=45n nf=1 m=(1)
mn25 (n21 D VSS VSS) g45n1svt w=(205n) l=45n nf=1 m=(1)
mn55 (Q qbint VSS VSS) g45n1svt w=(520n) l=45n nf=1 m=(1)
mn30 (n25 SN VSS VSS) g45n1svt w=(205n) l=45n nf=1 m=(1)
mn31 (mout n20 n25 VSS) g45n1svt w=(205n) l=45n nf=1 m=(1)
mn35 (n20 CKbb n30 VSS) g45n1svt w=(205n) l=45n nf=1 m=(1)
mn36 (n30 mout VSS VSS) g45n1svt w=(205n) l=45n nf=1 m=(1)
mn20 (CKb CK VSS VSS) g45n1svt w=(145n) l=45n nf=1 m=(1)
mn40 (n35 CKbb mout VSS) g45n1svt w=(205n) l=45n nf=1 m=(1)
mn45 (qbint n35 VSS VSS) g45n1svt w=(205n) l=45n nf=1 m=(1)
mn21 (CKbb CKb VSS VSS) g45n1svt w=(145n) l=45n nf=1 m=(1)
mp26 (n20 CKbb n22 NW) g45p1svt w=(310n) l=45n nf=1 m=(1)
mp25 (n22 D VDD NW) g45p1svt w=(310n) l=45n nf=1 m=(1)
mp55 (Q qbint VDD NW) g45p1svt w=(780n) l=45n nf=1 m=(1)
mp36 (n20 CKb n31 NW) g45p1svt w=(310n) l=45n nf=1 m=(1)
mp35 (n31 mout VDD NW) g45p1svt w=(310n) l=45n nf=1 m=(1)
mp20 (CKb CK VDD NW) g45p1svt w=(215n) l=45n nf=1 m=(1)
mp52 (n35 CKbb n41 NW) g45p1svt w=(310n) l=45n nf=1 m=(1)
mp31 (mout n20 VDD NW) g45p1svt w=(310n) l=45n nf=1 m=(1)
mp21 (CKbb CKb VDD NW) g45p1svt w=(215n) l=45n nf=1 m=(1)
mp50 (n41 SN VDD NW) g45p1svt w=(310n) l=45n nf=1 m=(1)
mp30 (mout SN VDD NW) g45p1svt w=(310n) l=45n nf=1 m=(1)
mp45 (qbint n35 VDD NW) g45p1svt w=(310n) l=45n nf=1 m=(1)
mp51 (n41 qbint VDD NW) g45p1svt w=(310n) l=45n nf=1 m=(1)
mp40 (n35 CKb mout NW) g45p1svt w=(310n) l=45n nf=1 m=(1)
ends DFFSHQX2

// gsclib045_backbias/DFFSHQX4/schematic

simulator lang=spectre

subckt DFFSHQX4 CK D Q SN NW VSS VDD
mn51 (n40 qbint n42 VSS) g45n1svt w=(205n) l=45n nf=1 m=(1)
mn52 (n35 CKb n40 VSS) g45n1svt w=(205n) l=45n nf=1 m=(1)
mn50 (n42 SN VSS VSS) g45n1svt w=(205n) l=45n nf=1 m=(1)
mn26 (n20 CKb n21 VSS) g45n1svt w=(205n) l=45n nf=1 m=(1)
mn25 (n21 D VSS VSS) g45n1svt w=(205n) l=45n nf=1 m=(1)
mn55 (Q qbint VSS VSS) g45n1svt w=(1.04u) l=45n nf=1 m=(1)
mn30 (n25 SN VSS VSS) g45n1svt w=(205n) l=45n nf=1 m=(1)
mn31 (mout n20 n25 VSS) g45n1svt w=(205n) l=45n nf=1 m=(1)
mn35 (n20 CKbb n30 VSS) g45n1svt w=(205n) l=45n nf=1 m=(1)
mn36 (n30 mout VSS VSS) g45n1svt w=(205n) l=45n nf=1 m=(1)
mn20 (CKb CK VSS VSS) g45n1svt w=(145n) l=45n nf=1 m=(1)
mn40 (n35 CKbb mout VSS) g45n1svt w=(205n) l=45n nf=1 m=(1)
mn45 (qbint n35 VSS VSS) g45n1svt w=(410n) l=45n nf=1 m=(1)
mn21 (CKbb CKb VSS VSS) g45n1svt w=(145n) l=45n nf=1 m=(1)
mp26 (n20 CKbb n22 NW) g45p1svt w=(310n) l=45n nf=1 m=(1)
mp25 (n22 D VDD NW) g45p1svt w=(310n) l=45n nf=1 m=(1)
mp55 (Q qbint VDD NW) g45p1svt w=(1.56u) l=45n nf=1 m=(1)
mp36 (n20 CKb n31 NW) g45p1svt w=(310n) l=45n nf=1 m=(1)
mp35 (n31 mout VDD NW) g45p1svt w=(310n) l=45n nf=1 m=(1)
mp20 (CKb CK VDD NW) g45p1svt w=(215n) l=45n nf=1 m=(1)
mp52 (n35 CKbb n41 NW) g45p1svt w=(310n) l=45n nf=1 m=(1)
mp31 (mout n20 VDD NW) g45p1svt w=(310n) l=45n nf=1 m=(1)
mp21 (CKbb CKb VDD NW) g45p1svt w=(215n) l=45n nf=1 m=(1)
mp50 (n41 SN VDD NW) g45p1svt w=(310n) l=45n nf=1 m=(1)
mp30 (mout SN VDD NW) g45p1svt w=(310n) l=45n nf=1 m=(1)
mp45 (qbint n35 VDD NW) g45p1svt w=(620n) l=45n nf=1 m=(1)
mp51 (n41 qbint VDD NW) g45p1svt w=(310n) l=45n nf=1 m=(1)
mp40 (n35 CKb mout NW) g45p1svt w=(310n) l=45n nf=1 m=(1)
ends DFFSHQX4

// gsclib045_backbias/DFFSHQX8/schematic

simulator lang=spectre

subckt DFFSHQX8 CK D Q SN NW VSS VDD
mn51 (n40 qbint n42 VSS) g45n1svt w=(205n) l=45n nf=1 m=(1)
mn52 (n35 CKb n40 VSS) g45n1svt w=(205n) l=45n nf=1 m=(1)
mn50 (n42 SN VSS VSS) g45n1svt w=(205n) l=45n nf=1 m=(1)
mn26 (n20 CKb n21 VSS) g45n1svt w=(205n) l=45n nf=1 m=(1)
mn25 (n21 D VSS VSS) g45n1svt w=(205n) l=45n nf=1 m=(1)
mn55 (Q qbint VSS VSS) g45n1svt w=(2.065u) l=45n nf=1 m=(1)
mn30 (n25 SN VSS VSS) g45n1svt w=(205n) l=45n nf=1 m=(1)
mn31 (mout n20 n25 VSS) g45n1svt w=(205n) l=45n nf=1 m=(1)
mn35 (n20 CKbb n30 VSS) g45n1svt w=(205n) l=45n nf=1 m=(1)
mn36 (n30 mout VSS VSS) g45n1svt w=(205n) l=45n nf=1 m=(1)
mn20 (CKb CK VSS VSS) g45n1svt w=(145n) l=45n nf=1 m=(1)
mn40 (n35 CKbb mout VSS) g45n1svt w=(205n) l=45n nf=1 m=(1)
mn45 (qbint n35 VSS VSS) g45n1svt w=(780n) l=45n nf=1 m=(1)
mn21 (CKbb CKb VSS VSS) g45n1svt w=(145n) l=45n nf=1 m=(1)
mp26 (n20 CKbb n22 NW) g45p1svt w=(310n) l=45n nf=1 m=(1)
mp25 (n22 D VDD NW) g45p1svt w=(310n) l=45n nf=1 m=(1)
mp55 (Q qbint VDD NW) g45p1svt w=(3.115u) l=45n nf=1 m=(1)
mp36 (n20 CKb n31 NW) g45p1svt w=(310n) l=45n nf=1 m=(1)
mp35 (n31 mout VDD NW) g45p1svt w=(310n) l=45n nf=1 m=(1)
mp20 (CKb CK VDD NW) g45p1svt w=(215n) l=45n nf=1 m=(1)
mp52 (n35 CKbb n41 NW) g45p1svt w=(310n) l=45n nf=1 m=(1)
mp31 (mout n20 VDD NW) g45p1svt w=(310n) l=45n nf=1 m=(1)
mp21 (CKbb CKb VDD NW) g45p1svt w=(215n) l=45n nf=1 m=(1)
mp50 (n41 SN VDD NW) g45p1svt w=(310n) l=45n nf=1 m=(1)
mp30 (mout SN VDD NW) g45p1svt w=(310n) l=45n nf=1 m=(1)
mp45 (qbint n35 VDD NW) g45p1svt w=(1.17u) l=45n nf=1 m=(1)
mp51 (n41 qbint VDD NW) g45p1svt w=(310n) l=45n nf=1 m=(1)
mp40 (n35 CKb mout NW) g45p1svt w=(310n) l=45n nf=1 m=(1)
ends DFFSHQX8

// gsclib045_backbias/DFFSRHQX1/schematic

simulator lang=spectre

subckt DFFSRHQX1 CK D Q RN SN NW VSS VDD
mn26 (n20 CKb n21 VSS) g45n1svt w=(205n) l=45n nf=1 m=(1)
mn25 (n21 D VSS VSS) g45n1svt w=(205n) l=45n nf=1 m=(1)
mn55 (Q qbint VSS VSS) g45n1svt w=(260n) l=45n nf=1 m=(1)
mn35 (n30 mout VSS VSS) g45n1svt w=(205n) l=45n nf=1 m=(1)
mn36 (n20 CKbb n30 VSS) g45n1svt w=(205n) l=45n nf=1 m=(1)
mn22 (RNb RN VSS VSS) g45n1svt w=(145n) l=45n nf=1 m=(1)
mn20 (CKb CK VSS VSS) g45n1svt w=(145n) l=45n nf=1 m=(1)
mn45 (qbint n35 VSS VSS) g45n1svt w=(205n) l=45n nf=1 m=(1)
mn52 (n40 qbint n42 VSS) g45n1svt w=(205n) l=45n nf=1 m=(1)
mn51 (n40 RNb n42 VSS) g45n1svt w=(205n) l=45n nf=1 m=(1)
mn32 (mout n20 n25 VSS) g45n1svt w=(205n) l=45n nf=1 m=(1)
mn50 (n42 SN VSS VSS) g45n1svt w=(205n) l=45n nf=1 m=(1)
mn30 (n25 SN VSS VSS) g45n1svt w=(205n) l=45n nf=1 m=(1)
mn40 (n35 CKbb mout VSS) g45n1svt w=(205n) l=45n nf=1 m=(1)
mn31 (mout RNb n25 VSS) g45n1svt w=(205n) l=45n nf=1 m=(1)
mn21 (CKbb CKb VSS VSS) g45n1svt w=(145n) l=45n nf=1 m=(1)
mn53 (n35 CKb n40 VSS) g45n1svt w=(205n) l=45n nf=1 m=(1)
mp26 (n20 CKbb n22 NW) g45p1svt w=(310n) l=45n nf=1 m=(1)
mp25 (n22 D VDD NW) g45p1svt w=(310n) l=45n nf=1 m=(1)
mp52 (n43 qbint n41 NW) g45p1svt w=(310n) l=45n nf=1 m=(1)
mp51 (n43 RNb VDD NW) g45p1svt w=(310n) l=45n nf=1 m=(1)
mp55 (Q qbint VDD NW) g45p1svt w=(390n) l=45n nf=1 m=(1)
mp36 (n20 CKb n31 NW) g45p1svt w=(310n) l=45n nf=1 m=(1)
mp35 (n31 mout VDD NW) g45p1svt w=(310n) l=45n nf=1 m=(1)
mp32 (mout n20 n26 NW) g45p1svt w=(310n) l=45n nf=1 m=(1)
mp31 (n26 RNb VDD NW) g45p1svt w=(310n) l=45n nf=1 m=(1)
mp22 (RNb RN VDD NW) g45p1svt w=(215n) l=45n nf=1 m=(1)
mp20 (CKb CK VDD NW) g45p1svt w=(215n) l=45n nf=1 m=(1)
mp53 (n35 CKbb n41 NW) g45p1svt w=(310n) l=45n nf=1 m=(1)
mp50 (n41 SN VDD NW) g45p1svt w=(310n) l=45n nf=1 m=(1)
mp45 (qbint n35 VDD NW) g45p1svt w=(310n) l=45n nf=1 m=(1)
mp21 (CKbb CKb VDD NW) g45p1svt w=(215n) l=45n nf=1 m=(1)
mp30 (mout SN VDD NW) g45p1svt w=(310n) l=45n nf=1 m=(1)
mp40 (n35 CKb mout NW) g45p1svt w=(310n) l=45n nf=1 m=(1)
ends DFFSRHQX1

// gsclib045_backbias/DFFSRHQX2/schematic

simulator lang=spectre

subckt DFFSRHQX2 CK D Q RN SN NW VSS VDD
mn26 (n20 CKb n21 VSS) g45n1svt w=(205n) l=45n nf=1 m=(1)
mn25 (n21 D VSS VSS) g45n1svt w=(205n) l=45n nf=1 m=(1)
mn55 (Q qbint VSS VSS) g45n1svt w=(520n) l=45n nf=1 m=(1)
mn35 (n30 mout VSS VSS) g45n1svt w=(205n) l=45n nf=1 m=(1)
mn36 (n20 CKbb n30 VSS) g45n1svt w=(205n) l=45n nf=1 m=(1)
mn22 (RNb RN VSS VSS) g45n1svt w=(145n) l=45n nf=1 m=(1)
mn20 (CKb CK VSS VSS) g45n1svt w=(145n) l=45n nf=1 m=(1)
mn45 (qbint n35 VSS VSS) g45n1svt w=(205n) l=45n nf=1 m=(1)
mn52 (n40 qbint n42 VSS) g45n1svt w=(205n) l=45n nf=1 m=(1)
mn51 (n40 RNb n42 VSS) g45n1svt w=(205n) l=45n nf=1 m=(1)
mn32 (mout n20 n25 VSS) g45n1svt w=(205n) l=45n nf=1 m=(1)
mn50 (n42 SN VSS VSS) g45n1svt w=(205n) l=45n nf=1 m=(1)
mn30 (n25 SN VSS VSS) g45n1svt w=(205n) l=45n nf=1 m=(1)
mn40 (n35 CKbb mout VSS) g45n1svt w=(205n) l=45n nf=1 m=(1)
mn31 (mout RNb n25 VSS) g45n1svt w=(205n) l=45n nf=1 m=(1)
mn21 (CKbb CKb VSS VSS) g45n1svt w=(145n) l=45n nf=1 m=(1)
mn53 (n35 CKb n40 VSS) g45n1svt w=(205n) l=45n nf=1 m=(1)
mp26 (n20 CKbb n22 NW) g45p1svt w=(310n) l=45n nf=1 m=(1)
mp25 (n22 D VDD NW) g45p1svt w=(310n) l=45n nf=1 m=(1)
mp52 (n43 qbint n41 NW) g45p1svt w=(310n) l=45n nf=1 m=(1)
mp51 (n43 RNb VDD NW) g45p1svt w=(310n) l=45n nf=1 m=(1)
mp55 (Q qbint VDD NW) g45p1svt w=(780n) l=45n nf=1 m=(1)
mp36 (n20 CKb n31 NW) g45p1svt w=(310n) l=45n nf=1 m=(1)
mp35 (n31 mout VDD NW) g45p1svt w=(310n) l=45n nf=1 m=(1)
mp32 (mout n20 n26 NW) g45p1svt w=(310n) l=45n nf=1 m=(1)
mp31 (n26 RNb VDD NW) g45p1svt w=(310n) l=45n nf=1 m=(1)
mp22 (RNb RN VDD NW) g45p1svt w=(215n) l=45n nf=1 m=(1)
mp20 (CKb CK VDD NW) g45p1svt w=(215n) l=45n nf=1 m=(1)
mp53 (n35 CKbb n41 NW) g45p1svt w=(310n) l=45n nf=1 m=(1)
mp50 (n41 SN VDD NW) g45p1svt w=(310n) l=45n nf=1 m=(1)
mp45 (qbint n35 VDD NW) g45p1svt w=(310n) l=45n nf=1 m=(1)
mp21 (CKbb CKb VDD NW) g45p1svt w=(215n) l=45n nf=1 m=(1)
mp30 (mout SN VDD NW) g45p1svt w=(310n) l=45n nf=1 m=(1)
mp40 (n35 CKb mout NW) g45p1svt w=(310n) l=45n nf=1 m=(1)
ends DFFSRHQX2

// gsclib045_backbias/DFFSRHQX4/schematic

simulator lang=spectre

subckt DFFSRHQX4 CK D Q RN SN VSS VDD NW
mn26 (n20 CKb n21 VSS) g45n1svt w=(205n) l=45n nf=1 m=(1)
mn25 (n21 D VSS VSS) g45n1svt w=(205n) l=45n nf=1 m=(1)
mn55 (Q qbint VSS VSS) g45n1svt w=(1.04u) l=45n nf=1 m=(1)
mn35 (n30 mout VSS VSS) g45n1svt w=(205n) l=45n nf=1 m=(1)
mn36 (n20 CKbb n30 VSS) g45n1svt w=(205n) l=45n nf=1 m=(1)
mn22 (RNb RN VSS VSS) g45n1svt w=(145n) l=45n nf=1 m=(1)
mn20 (CKb CK VSS VSS) g45n1svt w=(145n) l=45n nf=1 m=(1)
mn45 (qbint n35 VSS VSS) g45n1svt w=(410n) l=45n nf=1 m=(1)
mn52 (n40 qbint n42 VSS) g45n1svt w=(205n) l=45n nf=1 m=(1)
mn51 (n40 RNb n42 VSS) g45n1svt w=(205n) l=45n nf=1 m=(1)
mn32 (mout n20 n25 VSS) g45n1svt w=(205n) l=45n nf=1 m=(1)
mn50 (n42 SN VSS VSS) g45n1svt w=(205n) l=45n nf=1 m=(1)
mn30 (n25 SN VSS VSS) g45n1svt w=(205n) l=45n nf=1 m=(1)
mn40 (n35 CKbb mout VSS) g45n1svt w=(205n) l=45n nf=1 m=(1)
mn31 (mout RNb n25 VSS) g45n1svt w=(205n) l=45n nf=1 m=(1)
mn21 (CKbb CKb VSS VSS) g45n1svt w=(145n) l=45n nf=1 m=(1)
mn53 (n35 CKb n40 VSS) g45n1svt w=(205n) l=45n nf=1 m=(1)
mp26 (n20 CKbb n22 NW) g45p1svt w=(310n) l=45n nf=1 m=(1)
mp25 (n22 D VDD NW) g45p1svt w=(310n) l=45n nf=1 m=(1)
mp52 (n43 qbint n41 NW) g45p1svt w=(310n) l=45n nf=1 m=(1)
mp51 (n43 RNb VDD NW) g45p1svt w=(310n) l=45n nf=1 m=(1)
mp55 (Q qbint VDD NW) g45p1svt w=(1.56u) l=45n nf=1 m=(1)
mp36 (n20 CKb n31 NW) g45p1svt w=(310n) l=45n nf=1 m=(1)
mp35 (n31 mout VDD NW) g45p1svt w=(310n) l=45n nf=1 m=(1)
mp32 (mout n20 n26 NW) g45p1svt w=(310n) l=45n nf=1 m=(1)
mp31 (n26 RNb VDD NW) g45p1svt w=(310n) l=45n nf=1 m=(1)
mp22 (RNb RN VDD NW) g45p1svt w=(215n) l=45n nf=1 m=(1)
mp20 (CKb CK VDD NW) g45p1svt w=(215n) l=45n nf=1 m=(1)
mp53 (n35 CKbb n41 NW) g45p1svt w=(310n) l=45n nf=1 m=(1)
mp50 (n41 SN VDD NW) g45p1svt w=(310n) l=45n nf=1 m=(1)
mp45 (qbint n35 VDD NW) g45p1svt w=(620n) l=45n nf=1 m=(1)
mp21 (CKbb CKb VDD NW) g45p1svt w=(215n) l=45n nf=1 m=(1)
mp30 (mout SN VDD NW) g45p1svt w=(310n) l=45n nf=1 m=(1)
mp40 (n35 CKb mout NW) g45p1svt w=(310n) l=45n nf=1 m=(1)
ends DFFSRHQX4

// gsclib045_backbias/DFFSRHQX8/schematic

simulator lang=spectre

subckt DFFSRHQX8 CK D Q RN SN NW VSS VDD
mn26 (n20 CKb n21 VSS) g45n1svt w=(205n) l=45n nf=1 m=(1)
mn25 (n21 D VSS VSS) g45n1svt w=(205n) l=45n nf=1 m=(1)
mn55 (Q qbint VSS VSS) g45n1svt w=(2.065u) l=45n nf=1 m=(1)
mn35 (n30 mout VSS VSS) g45n1svt w=(205n) l=45n nf=1 m=(1)
mn36 (n20 CKbb n30 VSS) g45n1svt w=(205n) l=45n nf=1 m=(1)
mn22 (RNb RN VSS VSS) g45n1svt w=(145n) l=45n nf=1 m=(1)
mn20 (CKb CK VSS VSS) g45n1svt w=(145n) l=45n nf=1 m=(1)
mn45 (qbint n35 VSS VSS) g45n1svt w=(780n) l=45n nf=1 m=(1)
mn52 (n40 qbint n42 VSS) g45n1svt w=(205n) l=45n nf=1 m=(1)
mn51 (n40 RNb n42 VSS) g45n1svt w=(205n) l=45n nf=1 m=(1)
mn32 (mout n20 n25 VSS) g45n1svt w=(205n) l=45n nf=1 m=(1)
mn50 (n42 SN VSS VSS) g45n1svt w=(205n) l=45n nf=1 m=(1)
mn30 (n25 SN VSS VSS) g45n1svt w=(205n) l=45n nf=1 m=(1)
mn40 (n35 CKbb mout VSS) g45n1svt w=(205n) l=45n nf=1 m=(1)
mn31 (mout RNb n25 VSS) g45n1svt w=(205n) l=45n nf=1 m=(1)
mn21 (CKbb CKb VSS VSS) g45n1svt w=(145n) l=45n nf=1 m=(1)
mn53 (n35 CKb n40 VSS) g45n1svt w=(205n) l=45n nf=1 m=(1)
mp26 (n20 CKbb n22 NW) g45p1svt w=(310n) l=45n nf=1 m=(1)
mp25 (n22 D VDD NW) g45p1svt w=(310n) l=45n nf=1 m=(1)
mp52 (n43 qbint n41 NW) g45p1svt w=(310n) l=45n nf=1 m=(1)
mp51 (n43 RNb VDD NW) g45p1svt w=(310n) l=45n nf=1 m=(1)
mp55 (Q qbint VDD NW) g45p1svt w=(3.115u) l=45n nf=1 m=(1)
mp36 (n20 CKb n31 NW) g45p1svt w=(310n) l=45n nf=1 m=(1)
mp35 (n31 mout VDD NW) g45p1svt w=(310n) l=45n nf=1 m=(1)
mp32 (mout n20 n26 NW) g45p1svt w=(310n) l=45n nf=1 m=(1)
mp31 (n26 RNb VDD NW) g45p1svt w=(310n) l=45n nf=1 m=(1)
mp22 (RNb RN VDD NW) g45p1svt w=(215n) l=45n nf=1 m=(1)
mp20 (CKb CK VDD NW) g45p1svt w=(215n) l=45n nf=1 m=(1)
mp53 (n35 CKbb n41 NW) g45p1svt w=(310n) l=45n nf=1 m=(1)
mp50 (n41 SN VDD NW) g45p1svt w=(310n) l=45n nf=1 m=(1)
mp45 (qbint n35 VDD NW) g45p1svt w=(1.17u) l=45n nf=1 m=(1)
mp21 (CKbb CKb VDD NW) g45p1svt w=(215n) l=45n nf=1 m=(1)
mp30 (mout SN VDD NW) g45p1svt w=(310n) l=45n nf=1 m=(1)
mp40 (n35 CKb mout NW) g45p1svt w=(310n) l=45n nf=1 m=(1)
ends DFFSRHQX8

// gsclib045_backbias/DFFSRX1/schematic

simulator lang=spectre

subckt DFFSRX1 CK D Q QN RN SN VDD VSS NW
mn26 (n20 CKb n21 VSS) g45n1svt w=(145n) l=45n nf=1 m=(1)
mn25 (n21 D VSS VSS) g45n1svt w=(145n) l=45n nf=1 m=(1)
mn57 (QN qint VSS VSS) g45n1svt w=(260n) l=45n nf=1 m=(1)
mn55 (Q qbint VSS VSS) g45n1svt w=(260n) l=45n nf=1 m=(1)
mn35 (n30 mout VSS VSS) g45n1svt w=(145n) l=45n nf=1 m=(1)
mn36 (n20 CKbb n30 VSS) g45n1svt w=(145n) l=45n nf=1 m=(1)
mn22 (RNb RN VSS VSS) g45n1svt w=(145n) l=45n nf=1 m=(1)
mn20 (CKb CK VSS VSS) g45n1svt w=(145n) l=45n nf=1 m=(1)
mn45 (qbint n35 VSS VSS) g45n1svt w=(145n) l=45n nf=1 m=(1)
mn56 (qint qbint VSS VSS) g45n1svt w=(145n) l=45n nf=1 m=(1)
mn52 (n40 qbint n42 VSS) g45n1svt w=(145n) l=45n nf=1 m=(1)
mn51 (n40 RNb n42 VSS) g45n1svt w=(145n) l=45n nf=1 m=(1)
mn50 (n42 SN VSS VSS) g45n1svt w=(145n) l=45n nf=1 m=(1)
mn53 (n35 CKb n40 VSS) g45n1svt w=(145n) l=45n nf=1 m=(1)
mn21 (CKbb CKb VSS VSS) g45n1svt w=(145n) l=45n nf=1 m=(1)
mn32 (mout n20 net426 VSS) g45n1svt w=(145n) l=45n nf=1 m=(1)
mn31 (mout RNb net426 VSS) g45n1svt w=(145n) l=45n nf=1 m=(1)
mn40 (n35 CKbb mout VSS) g45n1svt w=(145n) l=45n nf=1 m=(1)
mn30 (net426 SN VSS VSS) g45n1svt w=(145n) l=45n nf=1 m=(1)
mp26 (n20 CKbb n22 NW) g45p1svt w=(215n) l=45n nf=1 m=(1)
mp25 (n22 D VDD NW) g45p1svt w=(215n) l=45n nf=1 m=(1)
mp52 (n41 qbint n43 NW) g45p1svt w=(215n) l=45n nf=1 m=(1)
mp51 (n43 RNb VDD NW) g45p1svt w=(215n) l=45n nf=1 m=(1)
mp57 (QN qint VDD NW) g45p1svt w=(390n) l=45n nf=1 m=(1)
mp55 (Q qbint VDD NW) g45p1svt w=(390n) l=45n nf=1 m=(1)
mp36 (n20 CKb n31 NW) g45p1svt w=(215n) l=45n nf=1 m=(1)
mp35 (n31 mout VDD NW) g45p1svt w=(215n) l=45n nf=1 m=(1)
mp32 (mout n20 net402 NW) g45p1svt w=(215n) l=45n nf=1 m=(1)
mp31 (net402 RNb VDD NW) g45p1svt w=(215n) l=45n nf=1 m=(1)
mp22 (RNb RN VDD NW) g45p1svt w=(215n) l=45n nf=1 m=(1)
mp20 (CKb CK VDD NW) g45p1svt w=(215n) l=45n nf=1 m=(1)
mp53 (n35 CKbb n41 NW) g45p1svt w=(215n) l=45n nf=1 m=(1)
mp50 (n41 SN VDD NW) g45p1svt w=(215n) l=45n nf=1 m=(1)
mp45 (qbint n35 VDD NW) g45p1svt w=(215n) l=45n nf=1 m=(1)
mp56 (qint qbint VDD NW) g45p1svt w=(215n) l=45n nf=1 m=(1)
mp21 (CKbb CKb VDD NW) g45p1svt w=(215n) l=45n nf=1 m=(1)
mp30 (mout SN VDD NW) g45p1svt w=(215n) l=45n nf=1 m=(1)
mp40 (n35 CKb mout NW) g45p1svt w=(215n) l=45n nf=1 m=(1)
ends DFFSRX1

// gsclib045_backbias/DFFSRX2/schematic

simulator lang=spectre

subckt DFFSRX2 CK D Q QN RN SN NW VSS VDD
mn26 (n20 CKb n21 VSS) g45n1svt w=(145n) l=45n nf=1 m=(1)
mn25 (n21 D VSS VSS) g45n1svt w=(145n) l=45n nf=1 m=(1)
mn57 (QN qint VSS VSS) g45n1svt w=(520n) l=45n nf=1 m=(1)
mn55 (Q qbint VSS VSS) g45n1svt w=(520n) l=45n nf=1 m=(1)
mn35 (n30 mout VSS VSS) g45n1svt w=(145n) l=45n nf=1 m=(1)
mn36 (n20 CKbb n30 VSS) g45n1svt w=(145n) l=45n nf=1 m=(1)
mn22 (RNb RN VSS VSS) g45n1svt w=(145n) l=45n nf=1 m=(1)
mn20 (CKb CK VSS VSS) g45n1svt w=(145n) l=45n nf=1 m=(1)
mn45 (qbint n35 VSS VSS) g45n1svt w=(205n) l=45n nf=1 m=(1)
mn56 (qint qbint VSS VSS) g45n1svt w=(145n) l=45n nf=1 m=(1)
mn52 (n40 qbint n42 VSS) g45n1svt w=(145n) l=45n nf=1 m=(1)
mn51 (n40 RNb n42 VSS) g45n1svt w=(145n) l=45n nf=1 m=(1)
mn50 (n42 SN VSS VSS) g45n1svt w=(145n) l=45n nf=1 m=(1)
mn53 (n35 CKb n40 VSS) g45n1svt w=(145n) l=45n nf=1 m=(1)
mn21 (CKbb CKb VSS VSS) g45n1svt w=(145n) l=45n nf=1 m=(1)
mn32 (mout n20 net426 VSS) g45n1svt w=(145n) l=45n nf=1 m=(1)
mn31 (mout RNb net426 VSS) g45n1svt w=(145n) l=45n nf=1 m=(1)
mn40 (n35 CKbb mout VSS) g45n1svt w=(145n) l=45n nf=1 m=(1)
mn30 (net426 SN VSS VSS) g45n1svt w=(145n) l=45n nf=1 m=(1)
mp26 (n20 CKbb n22 NW) g45p1svt w=(215n) l=45n nf=1 m=(1)
mp25 (n22 D VDD NW) g45p1svt w=(215n) l=45n nf=1 m=(1)
mp52 (n41 qbint n43 NW) g45p1svt w=(215n) l=45n nf=1 m=(1)
mp51 (n43 RNb VDD NW) g45p1svt w=(215n) l=45n nf=1 m=(1)
mp57 (QN qint VDD NW) g45p1svt w=(780n) l=45n nf=1 m=(1)
mp55 (Q qbint VDD NW) g45p1svt w=(780n) l=45n nf=1 m=(1)
mp36 (n20 CKb n31 NW) g45p1svt w=(215n) l=45n nf=1 m=(1)
mp35 (n31 mout VDD NW) g45p1svt w=(215n) l=45n nf=1 m=(1)
mp32 (mout n20 net402 NW) g45p1svt w=(215n) l=45n nf=1 m=(1)
mp31 (net402 RNb VDD NW) g45p1svt w=(215n) l=45n nf=1 m=(1)
mp22 (RNb RN VDD NW) g45p1svt w=(215n) l=45n nf=1 m=(1)
mp20 (CKb CK VDD NW) g45p1svt w=(215n) l=45n nf=1 m=(1)
mp53 (n35 CKbb n41 NW) g45p1svt w=(215n) l=45n nf=1 m=(1)
mp50 (n41 SN VDD NW) g45p1svt w=(215n) l=45n nf=1 m=(1)
mp45 (qbint n35 VDD NW) g45p1svt w=(310n) l=45n nf=1 m=(1)
mp56 (qint qbint VDD NW) g45p1svt w=(215n) l=45n nf=1 m=(1)
mp21 (CKbb CKb VDD NW) g45p1svt w=(215n) l=45n nf=1 m=(1)
mp30 (mout SN VDD NW) g45p1svt w=(215n) l=45n nf=1 m=(1)
mp40 (n35 CKb mout NW) g45p1svt w=(215n) l=45n nf=1 m=(1)
ends DFFSRX2

// gsclib045_backbias/DFFSRX4/schematic

simulator lang=spectre

subckt DFFSRX4 CK D Q QN RN SN NW VSS VDD
mn26 (n20 CKb n21 VSS) g45n1svt w=(145n) l=45n nf=1 m=(1)
mn25 (n21 D VSS VSS) g45n1svt w=(145n) l=45n nf=1 m=(1)
mn57 (QN qint VSS VSS) g45n1svt w=(1.04u) l=45n nf=1 m=(1)
mn55 (Q qbint VSS VSS) g45n1svt w=(1.04u) l=45n nf=1 m=(1)
mn35 (n30 mout VSS VSS) g45n1svt w=(145n) l=45n nf=1 m=(1)
mn36 (n20 CKbb n30 VSS) g45n1svt w=(145n) l=45n nf=1 m=(1)
mn22 (RNb RN VSS VSS) g45n1svt w=(145n) l=45n nf=1 m=(1)
mn20 (CKb CK VSS VSS) g45n1svt w=(145n) l=45n nf=1 m=(1)
mn45 (qbint n35 VSS VSS) g45n1svt w=(410n) l=45n nf=1 m=(1)
mn56 (qint qbint VSS VSS) g45n1svt w=(260n) l=45n nf=1 m=(1)
mn52 (n40 qbint n42 VSS) g45n1svt w=(145n) l=45n nf=1 m=(1)
mn51 (n40 RNb n42 VSS) g45n1svt w=(145n) l=45n nf=1 m=(1)
mn50 (n42 SN VSS VSS) g45n1svt w=(145n) l=45n nf=1 m=(1)
mn53 (n35 CKb n40 VSS) g45n1svt w=(145n) l=45n nf=1 m=(1)
mn21 (CKbb CKb VSS VSS) g45n1svt w=(145n) l=45n nf=1 m=(1)
mn32 (mout n20 net426 VSS) g45n1svt w=(145n) l=45n nf=1 m=(1)
mn31 (mout RNb net426 VSS) g45n1svt w=(145n) l=45n nf=1 m=(1)
mn40 (n35 CKbb mout VSS) g45n1svt w=(145n) l=45n nf=1 m=(1)
mn30 (net426 SN VSS VSS) g45n1svt w=(145n) l=45n nf=1 m=(1)
mp26 (n20 CKbb n22 NW) g45p1svt w=(215n) l=45n nf=1 m=(1)
mp25 (n22 D VDD NW) g45p1svt w=(215n) l=45n nf=1 m=(1)
mp52 (n41 qbint n43 NW) g45p1svt w=(215n) l=45n nf=1 m=(1)
mp51 (n43 RNb VDD NW) g45p1svt w=(215n) l=45n nf=1 m=(1)
mp57 (QN qint VDD NW) g45p1svt w=(1.56u) l=45n nf=1 m=(1)
mp55 (Q qbint VDD NW) g45p1svt w=(1.56u) l=45n nf=1 m=(1)
mp36 (n20 CKb n31 NW) g45p1svt w=(215n) l=45n nf=1 m=(1)
mp35 (n31 mout VDD NW) g45p1svt w=(215n) l=45n nf=1 m=(1)
mp32 (mout n20 net402 NW) g45p1svt w=(215n) l=45n nf=1 m=(1)
mp31 (net402 RNb VDD NW) g45p1svt w=(215n) l=45n nf=1 m=(1)
mp22 (RNb RN VDD NW) g45p1svt w=(215n) l=45n nf=1 m=(1)
mp20 (CKb CK VDD NW) g45p1svt w=(215n) l=45n nf=1 m=(1)
mp53 (n35 CKbb n41 NW) g45p1svt w=(215n) l=45n nf=1 m=(1)
mp50 (n41 SN VDD NW) g45p1svt w=(215n) l=45n nf=1 m=(1)
mp45 (qbint n35 VDD NW) g45p1svt w=(620n) l=45n nf=1 m=(1)
mp56 (qint qbint VDD NW) g45p1svt w=(390n) l=45n nf=1 m=(1)
mp21 (CKbb CKb VDD NW) g45p1svt w=(215n) l=45n nf=1 m=(1)
mp30 (mout SN VDD NW) g45p1svt w=(215n) l=45n nf=1 m=(1)
mp40 (n35 CKb mout NW) g45p1svt w=(215n) l=45n nf=1 m=(1)
ends DFFSRX4

// gsclib045_backbias/DFFSRXL/schematic

simulator lang=spectre

subckt DFFSRXL CK D Q QN RN SN VSS NW VDD
mn26 (n20 CKb n21 VSS) g45n1svt w=(145n) l=45n nf=1 m=(1)
mn25 (n21 D VSS VSS) g45n1svt w=(145n) l=45n nf=1 m=(1)
mn57 (QN qint VSS VSS) g45n1svt w=(145n) l=45n nf=1 m=(1)
mn55 (Q qbint VSS VSS) g45n1svt w=(145n) l=45n nf=1 m=(1)
mn35 (n30 mout VSS VSS) g45n1svt w=(145n) l=45n nf=1 m=(1)
mn36 (n20 CKbb n30 VSS) g45n1svt w=(145n) l=45n nf=1 m=(1)
mn22 (RNb RN VSS VSS) g45n1svt w=(145n) l=45n nf=1 m=(1)
mn20 (CKb CK VSS VSS) g45n1svt w=(145n) l=45n nf=1 m=(1)
mn45 (qbint n35 VSS VSS) g45n1svt w=(145n) l=45n nf=1 m=(1)
mn56 (qint qbint VSS VSS) g45n1svt w=(145n) l=45n nf=1 m=(1)
mn52 (n40 qbint n42 VSS) g45n1svt w=(145n) l=45n nf=1 m=(1)
mn51 (n40 RNb n42 VSS) g45n1svt w=(145n) l=45n nf=1 m=(1)
mn50 (n42 SN VSS VSS) g45n1svt w=(145n) l=45n nf=1 m=(1)
mn53 (n35 CKb n40 VSS) g45n1svt w=(145n) l=45n nf=1 m=(1)
mn21 (CKbb CKb VSS VSS) g45n1svt w=(145n) l=45n nf=1 m=(1)
mn32 (mout n20 net426 VSS) g45n1svt w=(145n) l=45n nf=1 m=(1)
mn31 (mout RNb net426 VSS) g45n1svt w=(145n) l=45n nf=1 m=(1)
mn40 (n35 CKbb mout VSS) g45n1svt w=(145n) l=45n nf=1 m=(1)
mn30 (net426 SN VSS VSS) g45n1svt w=(145n) l=45n nf=1 m=(1)
mp26 (n20 CKbb n22 NW) g45p1svt w=(215n) l=45n nf=1 m=(1)
mp25 (n22 D VDD NW) g45p1svt w=(215n) l=45n nf=1 m=(1)
mp52 (n41 qbint n43 NW) g45p1svt w=(215n) l=45n nf=1 m=(1)
mp51 (n43 RNb VDD NW) g45p1svt w=(215n) l=45n nf=1 m=(1)
mp57 (QN qint VDD NW) g45p1svt w=(215n) l=45n nf=1 m=(1)
mp55 (Q qbint VDD NW) g45p1svt w=(215n) l=45n nf=1 m=(1)
mp36 (n20 CKb n31 NW) g45p1svt w=(215n) l=45n nf=1 m=(1)
mp35 (n31 mout VDD NW) g45p1svt w=(215n) l=45n nf=1 m=(1)
mp32 (mout n20 net402 NW) g45p1svt w=(215n) l=45n nf=1 m=(1)
mp31 (net402 RNb VDD NW) g45p1svt w=(215n) l=45n nf=1 m=(1)
mp22 (RNb RN VDD NW) g45p1svt w=(215n) l=45n nf=1 m=(1)
mp20 (CKb CK VDD NW) g45p1svt w=(215n) l=45n nf=1 m=(1)
mp53 (n35 CKbb n41 NW) g45p1svt w=(215n) l=45n nf=1 m=(1)
mp50 (n41 SN VDD NW) g45p1svt w=(215n) l=45n nf=1 m=(1)
mp45 (qbint n35 VDD NW) g45p1svt w=(215n) l=45n nf=1 m=(1)
mp56 (qint qbint VDD NW) g45p1svt w=(215n) l=45n nf=1 m=(1)
mp21 (CKbb CKb VDD NW) g45p1svt w=(215n) l=45n nf=1 m=(1)
mp30 (mout SN VDD NW) g45p1svt w=(215n) l=45n nf=1 m=(1)
mp40 (n35 CKb mout NW) g45p1svt w=(215n) l=45n nf=1 m=(1)
ends DFFSRXL

// gsclib045_backbias/DFFSX1/schematic

simulator lang=spectre

subckt DFFSX1 CK D Q QN SN NW VSS VDD
mn51 (n40 qbint n42 VSS) g45n1svt w=(145n) l=45n nf=1 m=(1)
mn52 (n35 CKb n40 VSS) g45n1svt w=(145n) l=45n nf=1 m=(1)
mn50 (n42 SN VSS VSS) g45n1svt w=(145n) l=45n nf=1 m=(1)
mn26 (n20 CKb n21 VSS) g45n1svt w=(145n) l=45n nf=1 m=(1)
mn25 (n21 D VSS VSS) g45n1svt w=(145n) l=45n nf=1 m=(1)
mn57 (QN net331 VSS VSS) g45n1svt w=(260n) l=45n nf=1 m=(1)
mn55 (Q qbint VSS VSS) g45n1svt w=(260n) l=45n nf=1 m=(1)
mn30 (n25 SN VSS VSS) g45n1svt w=(145n) l=45n nf=1 m=(1)
mn31 (mout n20 n25 VSS) g45n1svt w=(145n) l=45n nf=1 m=(1)
mn35 (n20 CKbb n30 VSS) g45n1svt w=(145n) l=45n nf=1 m=(1)
mn36 (n30 mout VSS VSS) g45n1svt w=(145n) l=45n nf=1 m=(1)
mn56 (net331 qbint VSS VSS) g45n1svt w=(145n) l=45n nf=1 m=(1)
mn20 (CKb CK VSS VSS) g45n1svt w=(145n) l=45n nf=1 m=(1)
mn21 (CKbb CKb VSS VSS) g45n1svt w=(145n) l=45n nf=1 m=(1)
mn45 (qbint n35 VSS VSS) g45n1svt w=(145n) l=45n nf=1 m=(1)
mn40 (n35 CKbb mout VSS) g45n1svt w=(145n) l=45n nf=1 m=(1)
mp26 (n20 CKbb n22 NW) g45p1svt w=(215n) l=45n nf=1 m=(1)
mp25 (n22 D VDD NW) g45p1svt w=(215n) l=45n nf=1 m=(1)
mp57 (QN net331 VDD NW) g45p1svt w=(390n) l=45n nf=1 m=(1)
mp55 (Q qbint VDD NW) g45p1svt w=(390n) l=45n nf=1 m=(1)
mp36 (n20 CKb n31 NW) g45p1svt w=(215n) l=45n nf=1 m=(1)
mp35 (n31 mout VDD NW) g45p1svt w=(215n) l=45n nf=1 m=(1)
mp20 (CKb CK VDD NW) g45p1svt w=(215n) l=45n nf=1 m=(1)
mp31 (mout n20 VDD NW) g45p1svt w=(215n) l=45n nf=1 m=(1)
mp40 (n35 CKb mout NW) g45p1svt w=(215n) l=45n nf=1 m=(1)
mp56 (net331 qbint VDD NW) g45p1svt w=(215n) l=45n nf=1 m=(1)
mp45 (qbint n35 VDD NW) g45p1svt w=(215n) l=45n nf=1 m=(1)
mp52 (n35 CKbb n41 NW) g45p1svt w=(215n) l=45n nf=1 m=(1)
mp21 (CKbb CKb VDD NW) g45p1svt w=(215n) l=45n nf=1 m=(1)
mp30 (mout SN VDD NW) g45p1svt w=(215n) l=45n nf=1 m=(1)
mp51 (n41 qbint VDD NW) g45p1svt w=(215n) l=45n nf=1 m=(1)
mp50 (n41 SN VDD NW) g45p1svt w=(215n) l=45n nf=1 m=(1)
ends DFFSX1

// gsclib045_backbias/DFFSX2/schematic

simulator lang=spectre

subckt DFFSX2 CK D Q QN SN NW VSS VDD
mn51 (n40 qbint n42 VSS) g45n1svt w=(145n) l=45n nf=1 m=(1)
mn52 (n35 CKb n40 VSS) g45n1svt w=(145n) l=45n nf=1 m=(1)
mn50 (n42 SN VSS VSS) g45n1svt w=(145n) l=45n nf=1 m=(1)
mn26 (n20 CKb n21 VSS) g45n1svt w=(145n) l=45n nf=1 m=(1)
mn25 (n21 D VSS VSS) g45n1svt w=(145n) l=45n nf=1 m=(1)
mn57 (QN net331 VSS VSS) g45n1svt w=(520n) l=45n nf=1 m=(1)
mn55 (Q qbint VSS VSS) g45n1svt w=(520n) l=45n nf=1 m=(1)
mn30 (n25 SN VSS VSS) g45n1svt w=(145n) l=45n nf=1 m=(1)
mn31 (mout n20 n25 VSS) g45n1svt w=(145n) l=45n nf=1 m=(1)
mn35 (n20 CKbb n30 VSS) g45n1svt w=(145n) l=45n nf=1 m=(1)
mn36 (n30 mout VSS VSS) g45n1svt w=(145n) l=45n nf=1 m=(1)
mn56 (net331 qbint VSS VSS) g45n1svt w=(145n) l=45n nf=1 m=(1)
mn20 (CKb CK VSS VSS) g45n1svt w=(145n) l=45n nf=1 m=(1)
mn21 (CKbb CKb VSS VSS) g45n1svt w=(145n) l=45n nf=1 m=(1)
mn45 (qbint n35 VSS VSS) g45n1svt w=(205n) l=45n nf=1 m=(1)
mn40 (n35 CKbb mout VSS) g45n1svt w=(145n) l=45n nf=1 m=(1)
mp26 (n20 CKbb n22 NW) g45p1svt w=(215n) l=45n nf=1 m=(1)
mp25 (n22 D VDD NW) g45p1svt w=(215n) l=45n nf=1 m=(1)
mp57 (QN net331 VDD NW) g45p1svt w=(780n) l=45n nf=1 m=(1)
mp55 (Q qbint VDD NW) g45p1svt w=(780n) l=45n nf=1 m=(1)
mp36 (n20 CKb n31 NW) g45p1svt w=(215n) l=45n nf=1 m=(1)
mp35 (n31 mout VDD NW) g45p1svt w=(215n) l=45n nf=1 m=(1)
mp20 (CKb CK VDD NW) g45p1svt w=(215n) l=45n nf=1 m=(1)
mp31 (mout n20 VDD NW) g45p1svt w=(215n) l=45n nf=1 m=(1)
mp40 (n35 CKb mout NW) g45p1svt w=(215n) l=45n nf=1 m=(1)
mp56 (net331 qbint VDD NW) g45p1svt w=(215n) l=45n nf=1 m=(1)
mp45 (qbint n35 VDD NW) g45p1svt w=(310n) l=45n nf=1 m=(1)
mp52 (n35 CKbb n41 NW) g45p1svt w=(215n) l=45n nf=1 m=(1)
mp21 (CKbb CKb VDD NW) g45p1svt w=(215n) l=45n nf=1 m=(1)
mp30 (mout SN VDD NW) g45p1svt w=(215n) l=45n nf=1 m=(1)
mp51 (n41 qbint VDD NW) g45p1svt w=(215n) l=45n nf=1 m=(1)
mp50 (n41 SN VDD NW) g45p1svt w=(215n) l=45n nf=1 m=(1)
ends DFFSX2

// gsclib045_backbias/DFFSX4/schematic

simulator lang=spectre

subckt DFFSX4 CK D Q QN SN NW VSS VDD
mn51 (n40 qbint n42 VSS) g45n1svt w=(145n) l=45n nf=1 m=(1)
mn52 (n35 CKb n40 VSS) g45n1svt w=(145n) l=45n nf=1 m=(1)
mn50 (n42 SN VSS VSS) g45n1svt w=(145n) l=45n nf=1 m=(1)
mn26 (n20 CKb n21 VSS) g45n1svt w=(145n) l=45n nf=1 m=(1)
mn25 (n21 D VSS VSS) g45n1svt w=(145n) l=45n nf=1 m=(1)
mn57 (QN net331 VSS VSS) g45n1svt w=(1.04u) l=45n nf=1 m=(1)
mn55 (Q qbint VSS VSS) g45n1svt w=(1.04u) l=45n nf=1 m=(1)
mn30 (n25 SN VSS VSS) g45n1svt w=(145n) l=45n nf=1 m=(1)
mn31 (mout n20 n25 VSS) g45n1svt w=(145n) l=45n nf=1 m=(1)
mn35 (n20 CKbb n30 VSS) g45n1svt w=(145n) l=45n nf=1 m=(1)
mn36 (n30 mout VSS VSS) g45n1svt w=(145n) l=45n nf=1 m=(1)
mn56 (net331 qbint VSS VSS) g45n1svt w=(260n) l=45n nf=1 m=(1)
mn20 (CKb CK VSS VSS) g45n1svt w=(145n) l=45n nf=1 m=(1)
mn21 (CKbb CKb VSS VSS) g45n1svt w=(145n) l=45n nf=1 m=(1)
mn45 (qbint n35 VSS VSS) g45n1svt w=(410n) l=45n nf=1 m=(1)
mn40 (n35 CKbb mout VSS) g45n1svt w=(145n) l=45n nf=1 m=(1)
mp26 (n20 CKbb n22 NW) g45p1svt w=(215n) l=45n nf=1 m=(1)
mp25 (n22 D VDD NW) g45p1svt w=(215n) l=45n nf=1 m=(1)
mp57 (QN net331 VDD NW) g45p1svt w=(1.56u) l=45n nf=1 m=(1)
mp55 (Q qbint VDD NW) g45p1svt w=(1.56u) l=45n nf=1 m=(1)
mp36 (n20 CKb n31 NW) g45p1svt w=(215n) l=45n nf=1 m=(1)
mp35 (n31 mout VDD NW) g45p1svt w=(215n) l=45n nf=1 m=(1)
mp20 (CKb CK VDD NW) g45p1svt w=(215n) l=45n nf=1 m=(1)
mp31 (mout n20 VDD NW) g45p1svt w=(215n) l=45n nf=1 m=(1)
mp40 (n35 CKb mout NW) g45p1svt w=(215n) l=45n nf=1 m=(1)
mp56 (net331 qbint VDD NW) g45p1svt w=(390n) l=45n nf=1 m=(1)
mp45 (qbint n35 VDD NW) g45p1svt w=(620n) l=45n nf=1 m=(1)
mp52 (n35 CKbb n41 NW) g45p1svt w=(215n) l=45n nf=1 m=(1)
mp21 (CKbb CKb VDD NW) g45p1svt w=(215n) l=45n nf=1 m=(1)
mp30 (mout SN VDD NW) g45p1svt w=(215n) l=45n nf=1 m=(1)
mp51 (n41 qbint VDD NW) g45p1svt w=(215n) l=45n nf=1 m=(1)
mp50 (n41 SN VDD NW) g45p1svt w=(215n) l=45n nf=1 m=(1)
ends DFFSX4

// gsclib045_backbias/DFFSXL/schematic

simulator lang=spectre

subckt DFFSXL CK D Q QN SN NW VSS VDD
mn51 (n40 qbint n42 VSS) g45n1svt w=(145n) l=45n nf=1 m=(1)
mn52 (n35 CKb n40 VSS) g45n1svt w=(145n) l=45n nf=1 m=(1)
mn50 (n42 SN VSS VSS) g45n1svt w=(145n) l=45n nf=1 m=(1)
mn26 (n20 CKb n21 VSS) g45n1svt w=(145n) l=45n nf=1 m=(1)
mn25 (n21 D VSS VSS) g45n1svt w=(145n) l=45n nf=1 m=(1)
mn57 (QN net331 VSS VSS) g45n1svt w=(145n) l=45n nf=1 m=(1)
mn55 (Q qbint VSS VSS) g45n1svt w=(145n) l=45n nf=1 m=(1)
mn30 (n25 SN VSS VSS) g45n1svt w=(145n) l=45n nf=1 m=(1)
mn31 (mout n20 n25 VSS) g45n1svt w=(145n) l=45n nf=1 m=(1)
mn35 (n20 CKbb n30 VSS) g45n1svt w=(145n) l=45n nf=1 m=(1)
mn36 (n30 mout VSS VSS) g45n1svt w=(145n) l=45n nf=1 m=(1)
mn56 (net331 qbint VSS VSS) g45n1svt w=(145n) l=45n nf=1 m=(1)
mn20 (CKb CK VSS VSS) g45n1svt w=(145n) l=45n nf=1 m=(1)
mn21 (CKbb CKb VSS VSS) g45n1svt w=(145n) l=45n nf=1 m=(1)
mn45 (qbint n35 VSS VSS) g45n1svt w=(145n) l=45n nf=1 m=(1)
mn40 (n35 CKbb mout VSS) g45n1svt w=(145n) l=45n nf=1 m=(1)
mp26 (n20 CKbb n22 NW) g45p1svt w=(215n) l=45n nf=1 m=(1)
mp25 (n22 D VDD NW) g45p1svt w=(215n) l=45n nf=1 m=(1)
mp57 (QN net331 VDD NW) g45p1svt w=(215n) l=45n nf=1 m=(1)
mp55 (Q qbint VDD NW) g45p1svt w=(215n) l=45n nf=1 m=(1)
mp36 (n20 CKb n31 NW) g45p1svt w=(215n) l=45n nf=1 m=(1)
mp35 (n31 mout VDD NW) g45p1svt w=(215n) l=45n nf=1 m=(1)
mp20 (CKb CK VDD NW) g45p1svt w=(215n) l=45n nf=1 m=(1)
mp31 (mout n20 VDD NW) g45p1svt w=(215n) l=45n nf=1 m=(1)
mp40 (n35 CKb mout NW) g45p1svt w=(215n) l=45n nf=1 m=(1)
mp56 (net331 qbint VDD NW) g45p1svt w=(215n) l=45n nf=1 m=(1)
mp45 (qbint n35 VDD NW) g45p1svt w=(215n) l=45n nf=1 m=(1)
mp52 (n35 CKbb n41 NW) g45p1svt w=(215n) l=45n nf=1 m=(1)
mp21 (CKbb CKb VDD NW) g45p1svt w=(215n) l=45n nf=1 m=(1)
mp30 (mout SN VDD NW) g45p1svt w=(215n) l=45n nf=1 m=(1)
mp51 (n41 qbint VDD NW) g45p1svt w=(215n) l=45n nf=1 m=(1)
mp50 (n41 SN VDD NW) g45p1svt w=(215n) l=45n nf=1 m=(1)
ends DFFSXL

// gsclib045_backbias/DFFTRX1/schematic

simulator lang=spectre

subckt DFFTRX1 CK D Q QN RN VSS NW VDD
mn0 (n0 RN VSS VSS) g45n1svt w=(145n) l=45n nf=1 m=(1)
mn1 (Db D n0 VSS) g45n1svt w=(145n) l=45n nf=1 m=(1)
mn57 (QN qint VSS VSS) g45n1svt w=(260n) l=45n nf=1 m=(1)
mn55 (Q qbint VSS VSS) g45n1svt w=(260n) l=45n nf=1 m=(1)
mn50 (n35 qbint VSS VSS) g45n1svt w=(145n) l=45n nf=1 m=(1)
mn51 (n30 CKb n35 VSS) g45n1svt w=(145n) l=45n nf=1 m=(1)
mn25 (n20 CKb Db VSS) g45n1svt w=(145n) l=45n nf=1 m=(1)
mn20 (CKb CK VSS VSS) g45n1svt w=(145n) l=45n nf=1 m=(1)
mn35 (n25 mout VSS VSS) g45n1svt w=(145n) l=45n nf=1 m=(1)
mn21 (CKbb CKb VSS VSS) g45n1svt w=(145n) l=45n nf=1 m=(1)
mn36 (n20 CKbb n25 VSS) g45n1svt w=(145n) l=45n nf=1 m=(1)
mn40 (n30 CKbb mout VSS) g45n1svt w=(145n) l=45n nf=1 m=(1)
mn30 (mout n20 VSS VSS) g45n1svt w=(145n) l=45n nf=1 m=(1)
mn56 (qint qbint VSS VSS) g45n1svt w=(145n) l=45n nf=1 m=(1)
mn45 (qbint n30 VSS VSS) g45n1svt w=(145n) l=45n nf=1 m=(1)
mp1 (Db D VDD NW) g45p1svt w=(215n) l=45n nf=1 m=(1)
mp0 (Db RN VDD NW) g45p1svt w=(215n) l=45n nf=1 m=(1)
mp51 (n30 CKbb n36 NW) g45p1svt w=(215n) l=45n nf=1 m=(1)
mp50 (n36 qbint VDD NW) g45p1svt w=(215n) l=45n nf=1 m=(1)
mp57 (QN qint VDD NW) g45p1svt w=(390n) l=45n nf=1 m=(1)
mp55 (Q qbint VDD NW) g45p1svt w=(390n) l=45n nf=1 m=(1)
mp35 (n26 mout VDD NW) g45p1svt w=(215n) l=45n nf=1 m=(1)
mp56 (qint qbint VDD NW) g45p1svt w=(215n) l=45n nf=1 m=(1)
mp20 (CKb CK VDD NW) g45p1svt w=(215n) l=45n nf=1 m=(1)
mp36 (n20 CKb n26 NW) g45p1svt w=(215n) l=45n nf=1 m=(1)
mp45 (qbint n30 VDD NW) g45p1svt w=(215n) l=45n nf=1 m=(1)
mp30 (mout n20 VDD NW) g45p1svt w=(215n) l=45n nf=1 m=(1)
mp40 (n30 CKb mout NW) g45p1svt w=(215n) l=45n nf=1 m=(1)
mp21 (CKbb CKb VDD NW) g45p1svt w=(215n) l=45n nf=1 m=(1)
mp25 (n20 CKbb Db NW) g45p1svt w=(215n) l=45n nf=1 m=(1)
ends DFFTRX1

// gsclib045_backbias/DFFTRX2/schematic

simulator lang=spectre

subckt DFFTRX2 CK D Q QN RN VSS NW VDD
mn0 (n0 RN VSS VSS) g45n1svt w=(145n) l=45n nf=1 m=(1)
mn1 (Db D n0 VSS) g45n1svt w=(145n) l=45n nf=1 m=(1)
mn57 (QN qint VSS VSS) g45n1svt w=(520n) l=45n nf=1 m=(1)
mn55 (Q qbint VSS VSS) g45n1svt w=(520n) l=45n nf=1 m=(1)
mn50 (n35 qbint VSS VSS) g45n1svt w=(145n) l=45n nf=1 m=(1)
mn51 (n30 CKb n35 VSS) g45n1svt w=(145n) l=45n nf=1 m=(1)
mn25 (n20 CKb Db VSS) g45n1svt w=(145n) l=45n nf=1 m=(1)
mn20 (CKb CK VSS VSS) g45n1svt w=(145n) l=45n nf=1 m=(1)
mn35 (n25 mout VSS VSS) g45n1svt w=(145n) l=45n nf=1 m=(1)
mn21 (CKbb CKb VSS VSS) g45n1svt w=(145n) l=45n nf=1 m=(1)
mn36 (n20 CKbb n25 VSS) g45n1svt w=(145n) l=45n nf=1 m=(1)
mn40 (n30 CKbb mout VSS) g45n1svt w=(145n) l=45n nf=1 m=(1)
mn30 (mout n20 VSS VSS) g45n1svt w=(145n) l=45n nf=1 m=(1)
mn56 (qint qbint VSS VSS) g45n1svt w=(145n) l=45n nf=1 m=(1)
mn45 (qbint n30 VSS VSS) g45n1svt w=(205n) l=45n nf=1 m=(1)
mp1 (Db D VDD NW) g45p1svt w=(215n) l=45n nf=1 m=(1)
mp0 (Db RN VDD NW) g45p1svt w=(215n) l=45n nf=1 m=(1)
mp51 (n30 CKbb n36 NW) g45p1svt w=(215n) l=45n nf=1 m=(1)
mp50 (n36 qbint VDD NW) g45p1svt w=(215n) l=45n nf=1 m=(1)
mp57 (QN qint VDD NW) g45p1svt w=(780n) l=45n nf=1 m=(1)
mp55 (Q qbint VDD NW) g45p1svt w=(780n) l=45n nf=1 m=(1)
mp35 (n26 mout VDD NW) g45p1svt w=(215n) l=45n nf=1 m=(1)
mp56 (qint qbint VDD NW) g45p1svt w=(215n) l=45n nf=1 m=(1)
mp20 (CKb CK VDD NW) g45p1svt w=(215n) l=45n nf=1 m=(1)
mp36 (n20 CKb n26 NW) g45p1svt w=(215n) l=45n nf=1 m=(1)
mp45 (qbint n30 VDD NW) g45p1svt w=(310n) l=45n nf=1 m=(1)
mp30 (mout n20 VDD NW) g45p1svt w=(215n) l=45n nf=1 m=(1)
mp40 (n30 CKb mout NW) g45p1svt w=(215n) l=45n nf=1 m=(1)
mp21 (CKbb CKb VDD NW) g45p1svt w=(215n) l=45n nf=1 m=(1)
mp25 (n20 CKbb Db NW) g45p1svt w=(215n) l=45n nf=1 m=(1)
ends DFFTRX2

// gsclib045_backbias/DFFTRX4/schematic

simulator lang=spectre

subckt DFFTRX4 CK D Q QN RN VSS NW VDD
mn0 (n0 RN VSS VSS) g45n1svt w=(145n) l=45n nf=1 m=(1)
mn1 (Db D n0 VSS) g45n1svt w=(145n) l=45n nf=1 m=(1)
mn57 (QN qint VSS VSS) g45n1svt w=(1.04u) l=45n nf=1 m=(1)
mn55 (Q qbint VSS VSS) g45n1svt w=(1.04u) l=45n nf=1 m=(1)
mn50 (n35 qbint VSS VSS) g45n1svt w=(145n) l=45n nf=1 m=(1)
mn51 (n30 CKb n35 VSS) g45n1svt w=(145n) l=45n nf=1 m=(1)
mn25 (n20 CKb Db VSS) g45n1svt w=(145n) l=45n nf=1 m=(1)
mn20 (CKb CK VSS VSS) g45n1svt w=(145n) l=45n nf=1 m=(1)
mn35 (n25 mout VSS VSS) g45n1svt w=(145n) l=45n nf=1 m=(1)
mn21 (CKbb CKb VSS VSS) g45n1svt w=(145n) l=45n nf=1 m=(1)
mn36 (n20 CKbb n25 VSS) g45n1svt w=(145n) l=45n nf=1 m=(1)
mn40 (n30 CKbb mout VSS) g45n1svt w=(145n) l=45n nf=1 m=(1)
mn30 (mout n20 VSS VSS) g45n1svt w=(145n) l=45n nf=1 m=(1)
mn56 (qint qbint VSS VSS) g45n1svt w=(260n) l=45n nf=1 m=(1)
mn45 (qbint n30 VSS VSS) g45n1svt w=(410n) l=45n nf=1 m=(1)
mp1 (Db D VDD NW) g45p1svt w=(215n) l=45n nf=1 m=(1)
mp0 (Db RN VDD NW) g45p1svt w=(215n) l=45n nf=1 m=(1)
mp51 (n30 CKbb n36 NW) g45p1svt w=(215n) l=45n nf=1 m=(1)
mp50 (n36 qbint VDD NW) g45p1svt w=(215n) l=45n nf=1 m=(1)
mp57 (QN qint VDD NW) g45p1svt w=(1.56u) l=45n nf=1 m=(1)
mp55 (Q qbint VDD NW) g45p1svt w=(1.56u) l=45n nf=1 m=(1)
mp35 (n26 mout VDD NW) g45p1svt w=(215n) l=45n nf=1 m=(1)
mp56 (qint qbint VDD NW) g45p1svt w=(390n) l=45n nf=1 m=(1)
mp20 (CKb CK VDD NW) g45p1svt w=(215n) l=45n nf=1 m=(1)
mp36 (n20 CKb n26 NW) g45p1svt w=(215n) l=45n nf=1 m=(1)
mp45 (qbint n30 VDD NW) g45p1svt w=(620n) l=45n nf=1 m=(1)
mp30 (mout n20 VDD NW) g45p1svt w=(215n) l=45n nf=1 m=(1)
mp40 (n30 CKb mout NW) g45p1svt w=(215n) l=45n nf=1 m=(1)
mp21 (CKbb CKb VDD NW) g45p1svt w=(215n) l=45n nf=1 m=(1)
mp25 (n20 CKbb Db NW) g45p1svt w=(215n) l=45n nf=1 m=(1)
ends DFFTRX4

// gsclib045_backbias/DFFTRXL/schematic

simulator lang=spectre

subckt DFFTRXL CK D Q QN RN VSS NW VDD
mn0 (n0 RN VSS VSS) g45n1svt w=(145n) l=45n nf=1 m=(1)
mn1 (Db D n0 VSS) g45n1svt w=(145n) l=45n nf=1 m=(1)
mn57 (QN qint VSS VSS) g45n1svt w=(145n) l=45n nf=1 m=(1)
mn55 (Q qbint VSS VSS) g45n1svt w=(145n) l=45n nf=1 m=(1)
mn50 (n35 qbint VSS VSS) g45n1svt w=(145n) l=45n nf=1 m=(1)
mn51 (n30 CKb n35 VSS) g45n1svt w=(145n) l=45n nf=1 m=(1)
mn25 (n20 CKb Db VSS) g45n1svt w=(145n) l=45n nf=1 m=(1)
mn20 (CKb CK VSS VSS) g45n1svt w=(145n) l=45n nf=1 m=(1)
mn35 (n25 mout VSS VSS) g45n1svt w=(145n) l=45n nf=1 m=(1)
mn21 (CKbb CKb VSS VSS) g45n1svt w=(145n) l=45n nf=1 m=(1)
mn36 (n20 CKbb n25 VSS) g45n1svt w=(145n) l=45n nf=1 m=(1)
mn40 (n30 CKbb mout VSS) g45n1svt w=(145n) l=45n nf=1 m=(1)
mn30 (mout n20 VSS VSS) g45n1svt w=(145n) l=45n nf=1 m=(1)
mn56 (qint qbint VSS VSS) g45n1svt w=(145n) l=45n nf=1 m=(1)
mn45 (qbint n30 VSS VSS) g45n1svt w=(145n) l=45n nf=1 m=(1)
mp1 (Db D VDD NW) g45p1svt w=(215n) l=45n nf=1 m=(1)
mp0 (Db RN VDD NW) g45p1svt w=(215n) l=45n nf=1 m=(1)
mp51 (n30 CKbb n36 NW) g45p1svt w=(215n) l=45n nf=1 m=(1)
mp50 (n36 qbint VDD NW) g45p1svt w=(215n) l=45n nf=1 m=(1)
mp57 (QN qint VDD NW) g45p1svt w=(215n) l=45n nf=1 m=(1)
mp55 (Q qbint VDD NW) g45p1svt w=(215n) l=45n nf=1 m=(1)
mp35 (n26 mout VDD NW) g45p1svt w=(215n) l=45n nf=1 m=(1)
mp56 (qint qbint VDD NW) g45p1svt w=(215n) l=45n nf=1 m=(1)
mp20 (CKb CK VDD NW) g45p1svt w=(215n) l=45n nf=1 m=(1)
mp36 (n20 CKb n26 NW) g45p1svt w=(215n) l=45n nf=1 m=(1)
mp45 (qbint n30 VDD NW) g45p1svt w=(215n) l=45n nf=1 m=(1)
mp30 (mout n20 VDD NW) g45p1svt w=(215n) l=45n nf=1 m=(1)
mp40 (n30 CKb mout NW) g45p1svt w=(215n) l=45n nf=1 m=(1)
mp21 (CKbb CKb VDD NW) g45p1svt w=(215n) l=45n nf=1 m=(1)
mp25 (n20 CKbb Db NW) g45p1svt w=(215n) l=45n nf=1 m=(1)
ends DFFTRXL

// gsclib045_backbias/DFFX1/schematic

simulator lang=spectre

subckt DFFX1 CK D Q QN NW VSS VDD
mn26 (n20 CKb n21 VSS) g45n1svt w=(145n) l=45n nf=1 m=(1)
mn25 (n21 D VSS VSS) g45n1svt w=(145n) l=45n nf=1 m=(1)
mn57 (QN qint VSS VSS) g45n1svt w=(260n) l=45n nf=1 m=(1)
mn55 (Q qbint VSS VSS) g45n1svt w=(260n) l=45n nf=1 m=(1)
mn50 (n35 qbint VSS VSS) g45n1svt w=(145n) l=45n nf=1 m=(1)
mn51 (n30 CKb n35 VSS) g45n1svt w=(145n) l=45n nf=1 m=(1)
mn35 (n25 mout VSS VSS) g45n1svt w=(145n) l=45n nf=1 m=(1)
mn36 (n20 CKbb n25 VSS) g45n1svt w=(145n) l=45n nf=1 m=(1)
mn20 (CKb CK VSS VSS) g45n1svt w=(145n) l=45n nf=1 m=(1)
mn45 (qbint n30 VSS VSS) g45n1svt w=(145n) l=45n nf=1 m=(1)
mn56 (qint qbint VSS VSS) g45n1svt w=(145n) l=45n nf=1 m=(1)
mn21 (CKbb CKb VSS VSS) g45n1svt w=(145n) l=45n nf=1 m=(1)
mn30 (mout n20 VSS VSS) g45n1svt w=(145n) l=45n nf=1 m=(1)
mn40 (n30 CKbb mout VSS) g45n1svt w=(145n) l=45n nf=1 m=(1)
mp26 (n20 CKbb n22 NW) g45p1svt w=(215n) l=45n nf=1 m=(1)
mp25 (n22 D VDD NW) g45p1svt w=(215n) l=45n nf=1 m=(1)
mp51 (n30 CKbb n36 NW) g45p1svt w=(215n) l=45n nf=1 m=(1)
mp50 (n36 qbint VDD NW) g45p1svt w=(215n) l=45n nf=1 m=(1)
mp57 (QN qint VDD NW) g45p1svt w=(390n) l=45n nf=1 m=(1)
mp55 (Q qbint VDD NW) g45p1svt w=(390n) l=45n nf=1 m=(1)
mp35 (n26 mout VDD NW) g45p1svt w=(215n) l=45n nf=1 m=(1)
mp36 (n20 CKb n26 NW) g45p1svt w=(215n) l=45n nf=1 m=(1)
mp20 (CKb CK VDD NW) g45p1svt w=(215n) l=45n nf=1 m=(1)
mp45 (qbint n30 VDD NW) g45p1svt w=(215n) l=45n nf=1 m=(1)
mp56 (qint qbint VDD NW) g45p1svt w=(215n) l=45n nf=1 m=(1)
mp21 (CKbb CKb VDD NW) g45p1svt w=(215n) l=45n nf=1 m=(1)
mp40 (n30 CKb mout NW) g45p1svt w=(215n) l=45n nf=1 m=(1)
mp30 (mout n20 VDD NW) g45p1svt w=(215n) l=45n nf=1 m=(1)
ends DFFX1

// gsclib045_backbias/DFFX2/schematic

simulator lang=spectre

subckt DFFX2 CK D Q QN NW VSS VDD
mn26 (n20 CKb n21 VSS) g45n1svt w=(145n) l=45n nf=1 m=(1)
mn25 (n21 D VSS VSS) g45n1svt w=(145n) l=45n nf=1 m=(1)
mn57 (QN qint VSS VSS) g45n1svt w=(520n) l=45n nf=1 m=(1)
mn55 (Q qbint VSS VSS) g45n1svt w=(520n) l=45n nf=1 m=(1)
mn50 (n35 qbint VSS VSS) g45n1svt w=(145n) l=45n nf=1 m=(1)
mn51 (n30 CKb n35 VSS) g45n1svt w=(145n) l=45n nf=1 m=(1)
mn35 (n25 mout VSS VSS) g45n1svt w=(145n) l=45n nf=1 m=(1)
mn36 (n20 CKbb n25 VSS) g45n1svt w=(145n) l=45n nf=1 m=(1)
mn20 (CKb CK VSS VSS) g45n1svt w=(145n) l=45n nf=1 m=(1)
mn45 (qbint n30 VSS VSS) g45n1svt w=(205n) l=45n nf=1 m=(1)
mn56 (qint qbint VSS VSS) g45n1svt w=(145n) l=45n nf=1 m=(1)
mn21 (CKbb CKb VSS VSS) g45n1svt w=(145n) l=45n nf=1 m=(1)
mn30 (mout n20 VSS VSS) g45n1svt w=(145n) l=45n nf=1 m=(1)
mn40 (n30 CKbb mout VSS) g45n1svt w=(145n) l=45n nf=1 m=(1)
mp26 (n20 CKbb n22 NW) g45p1svt w=(215n) l=45n nf=1 m=(1)
mp25 (n22 D VDD NW) g45p1svt w=(215n) l=45n nf=1 m=(1)
mp51 (n30 CKbb n36 NW) g45p1svt w=(215n) l=45n nf=1 m=(1)
mp50 (n36 qbint VDD NW) g45p1svt w=(215n) l=45n nf=1 m=(1)
mp57 (QN qint VDD NW) g45p1svt w=(780n) l=45n nf=1 m=(1)
mp55 (Q qbint VDD NW) g45p1svt w=(780n) l=45n nf=1 m=(1)
mp35 (n26 mout VDD NW) g45p1svt w=(215n) l=45n nf=1 m=(1)
mp36 (n20 CKb n26 NW) g45p1svt w=(215n) l=45n nf=1 m=(1)
mp20 (CKb CK VDD NW) g45p1svt w=(215n) l=45n nf=1 m=(1)
mp45 (qbint n30 VDD NW) g45p1svt w=(310n) l=45n nf=1 m=(1)
mp56 (qint qbint VDD NW) g45p1svt w=(215n) l=45n nf=1 m=(1)
mp21 (CKbb CKb VDD NW) g45p1svt w=(215n) l=45n nf=1 m=(1)
mp40 (n30 CKb mout NW) g45p1svt w=(215n) l=45n nf=1 m=(1)
mp30 (mout n20 VDD NW) g45p1svt w=(215n) l=45n nf=1 m=(1)
ends DFFX2

// gsclib045_backbias/DFFX4/schematic

simulator lang=spectre

subckt DFFX4 CK D Q QN NW VSS VDD
mn26 (n20 CKb n21 VSS) g45n1svt w=(145n) l=45n nf=1 m=(1)
mn25 (n21 D VSS VSS) g45n1svt w=(145n) l=45n nf=1 m=(1)
mn57 (QN qint VSS VSS) g45n1svt w=(1.04u) l=45n nf=1 m=(1)
mn55 (Q qbint VSS VSS) g45n1svt w=(1.04u) l=45n nf=1 m=(1)
mn50 (n35 qbint VSS VSS) g45n1svt w=(145n) l=45n nf=1 m=(1)
mn51 (n30 CKb n35 VSS) g45n1svt w=(145n) l=45n nf=1 m=(1)
mn35 (n25 mout VSS VSS) g45n1svt w=(145n) l=45n nf=1 m=(1)
mn36 (n20 CKbb n25 VSS) g45n1svt w=(145n) l=45n nf=1 m=(1)
mn20 (CKb CK VSS VSS) g45n1svt w=(145n) l=45n nf=1 m=(1)
mn45 (qbint n30 VSS VSS) g45n1svt w=(410n) l=45n nf=1 m=(1)
mn56 (qint qbint VSS VSS) g45n1svt w=(260n) l=45n nf=1 m=(1)
mn21 (CKbb CKb VSS VSS) g45n1svt w=(145n) l=45n nf=1 m=(1)
mn30 (mout n20 VSS VSS) g45n1svt w=(145n) l=45n nf=1 m=(1)
mn40 (n30 CKbb mout VSS) g45n1svt w=(145n) l=45n nf=1 m=(1)
mp26 (n20 CKbb n22 NW) g45p1svt w=(215n) l=45n nf=1 m=(1)
mp25 (n22 D VDD NW) g45p1svt w=(215n) l=45n nf=1 m=(1)
mp51 (n30 CKbb n36 NW) g45p1svt w=(215n) l=45n nf=1 m=(1)
mp50 (n36 qbint VDD NW) g45p1svt w=(215n) l=45n nf=1 m=(1)
mp57 (QN qint VDD NW) g45p1svt w=(1.56u) l=45n nf=1 m=(1)
mp55 (Q qbint VDD NW) g45p1svt w=(1.56u) l=45n nf=1 m=(1)
mp35 (n26 mout VDD NW) g45p1svt w=(215n) l=45n nf=1 m=(1)
mp36 (n20 CKb n26 NW) g45p1svt w=(215n) l=45n nf=1 m=(1)
mp20 (CKb CK VDD NW) g45p1svt w=(215n) l=45n nf=1 m=(1)
mp45 (qbint n30 VDD NW) g45p1svt w=(620n) l=45n nf=1 m=(1)
mp56 (qint qbint VDD NW) g45p1svt w=(390n) l=45n nf=1 m=(1)
mp21 (CKbb CKb VDD NW) g45p1svt w=(215n) l=45n nf=1 m=(1)
mp40 (n30 CKb mout NW) g45p1svt w=(215n) l=45n nf=1 m=(1)
mp30 (mout n20 VDD NW) g45p1svt w=(215n) l=45n nf=1 m=(1)
ends DFFX4

// gsclib045_backbias/DFFXL/schematic

simulator lang=spectre

subckt DFFXL CK D Q QN NW VSS VDD
mn26 (n20 CKb n21 VSS) g45n1svt w=(145n) l=45n nf=1 m=(1)
mn25 (n21 D VSS VSS) g45n1svt w=(145n) l=45n nf=1 m=(1)
mn57 (QN qint VSS VSS) g45n1svt w=(145n) l=45n nf=1 m=(1)
mn55 (Q qbint VSS VSS) g45n1svt w=(145n) l=45n nf=1 m=(1)
mn50 (n35 qbint VSS VSS) g45n1svt w=(145n) l=45n nf=1 m=(1)
mn51 (n30 CKb n35 VSS) g45n1svt w=(145n) l=45n nf=1 m=(1)
mn35 (n25 mout VSS VSS) g45n1svt w=(145n) l=45n nf=1 m=(1)
mn36 (n20 CKbb n25 VSS) g45n1svt w=(145n) l=45n nf=1 m=(1)
mn20 (CKb CK VSS VSS) g45n1svt w=(145n) l=45n nf=1 m=(1)
mn45 (qbint n30 VSS VSS) g45n1svt w=(145n) l=45n nf=1 m=(1)
mn56 (qint qbint VSS VSS) g45n1svt w=(145n) l=45n nf=1 m=(1)
mn21 (CKbb CKb VSS VSS) g45n1svt w=(145n) l=45n nf=1 m=(1)
mn30 (mout n20 VSS VSS) g45n1svt w=(145n) l=45n nf=1 m=(1)
mn40 (n30 CKbb mout VSS) g45n1svt w=(145n) l=45n nf=1 m=(1)
mp26 (n20 CKbb n22 NW) g45p1svt w=(215n) l=45n nf=1 m=(1)
mp25 (n22 D VDD NW) g45p1svt w=(215n) l=45n nf=1 m=(1)
mp51 (n30 CKbb n36 NW) g45p1svt w=(215n) l=45n nf=1 m=(1)
mp50 (n36 qbint VDD NW) g45p1svt w=(215n) l=45n nf=1 m=(1)
mp57 (QN qint VDD NW) g45p1svt w=(215n) l=45n nf=1 m=(1)
mp55 (Q qbint VDD NW) g45p1svt w=(215n) l=45n nf=1 m=(1)
mp35 (n26 mout VDD NW) g45p1svt w=(215n) l=45n nf=1 m=(1)
mp36 (n20 CKb n26 NW) g45p1svt w=(215n) l=45n nf=1 m=(1)
mp20 (CKb CK VDD NW) g45p1svt w=(215n) l=45n nf=1 m=(1)
mp45 (qbint n30 VDD NW) g45p1svt w=(215n) l=45n nf=1 m=(1)
mp56 (qint qbint VDD NW) g45p1svt w=(215n) l=45n nf=1 m=(1)
mp21 (CKbb CKb VDD NW) g45p1svt w=(215n) l=45n nf=1 m=(1)
mp40 (n30 CKb mout NW) g45p1svt w=(215n) l=45n nf=1 m=(1)
mp30 (mout n20 VDD NW) g45p1svt w=(215n) l=45n nf=1 m=(1)
ends DFFXL

// gsclib045_backbias/EDFFHQX1/schematic

simulator lang=spectre

subckt EDFFHQX1 CK D E Q VDD VSS NW
mn3 (Db E net333 VSS) g45n1svt w=(260n) l=45n nf=1 m=(1)
mn2 (net333 D VSS VSS) g45n1svt w=(260n) l=45n nf=1 m=(1)
mn55 (Q qbint VSS VSS) g45n1svt w=(260n) l=45n nf=1 m=(1)
mn51 (n30 CKb net380 VSS) g45n1svt w=(205n) l=45n nf=1 m=(1)
mn50 (net380 qbint VSS VSS) g45n1svt w=(205n) l=45n nf=1 m=(1)
mn35 (net340 mout VSS VSS) g45n1svt w=(205n) l=45n nf=1 m=(1)
mn20 (CKb CK VSS VSS) g45n1svt w=(145n) l=45n nf=1 m=(1)
mn45 (qbint n30 VSS VSS) g45n1svt w=(205n) l=45n nf=1 m=(1)
mn21 (CKbb CKb VSS VSS) g45n1svt w=(145n) l=45n nf=1 m=(1)
mn40 (mout CKbb n30 VSS) g45n1svt w=(205n) l=45n nf=1 m=(1)
mn30 (mout n20 VSS VSS) g45n1svt w=(205n) l=45n nf=1 m=(1)
mn0 (Eb E VSS VSS) g45n1svt w=(145n) l=45n nf=1 m=(1)
mn1 (qbint Eb Db VSS) g45n1svt w=(260n) l=45n nf=1 m=(1)
mn25 (n20 CKb Db VSS) g45n1svt w=(205n) l=45n nf=1 m=(1)
mn36 (n20 CKbb net340 VSS) g45n1svt w=(205n) l=45n nf=1 m=(1)
mp3 (Db Eb net328 NW) g45p1svt w=(390n) l=45n nf=1 m=(1)
mp2 (net328 D VDD NW) g45p1svt w=(390n) l=45n nf=1 m=(1)
mp51 (n30 CKbb net317 NW) g45p1svt w=(310n) l=45n nf=1 m=(1)
mp50 (net317 qbint VDD NW) g45p1svt w=(310n) l=45n nf=1 m=(1)
mp55 (Q qbint VDD NW) g45p1svt w=(390n) l=45n nf=1 m=(1)
mp35 (net309 mout VDD NW) g45p1svt w=(310n) l=45n nf=1 m=(1)
mp36 (n20 CKb net309 NW) g45p1svt w=(310n) l=45n nf=1 m=(1)
mp45 (qbint n30 VDD NW) g45p1svt w=(310n) l=45n nf=1 m=(1)
mp21 (CKbb CKb VDD NW) g45p1svt w=(215n) l=45n nf=1 m=(1)
mp40 (mout CKb n30 NW) g45p1svt w=(310n) l=45n nf=1 m=(1)
mp30 (mout n20 VDD NW) g45p1svt w=(310n) l=45n nf=1 m=(1)
mp1 (qbint E Db NW) g45p1svt w=(390n) l=45n nf=1 m=(1)
mp20 (CKb CK VDD NW) g45p1svt w=(215n) l=45n nf=1 m=(1)
mp25 (n20 CKbb Db NW) g45p1svt w=(310n) l=45n nf=1 m=(1)
mp0 (Eb E VDD NW) g45p1svt w=(215n) l=45n nf=1 m=(1)
ends EDFFHQX1

// gsclib045_backbias/EDFFHQX2/schematic

simulator lang=spectre

subckt EDFFHQX2 CK D E Q VDD VSS NW
mn3 (Db E net333 VSS) g45n1svt w=(260n) l=45n nf=1 m=(1)
mn2 (net333 D VSS VSS) g45n1svt w=(260n) l=45n nf=1 m=(1)
mn55 (Q qbint VSS VSS) g45n1svt w=(520n) l=45n nf=1 m=(1)
mn51 (n30 CKb net380 VSS) g45n1svt w=(205n) l=45n nf=1 m=(1)
mn50 (net380 qbint VSS VSS) g45n1svt w=(205n) l=45n nf=1 m=(1)
mn35 (net340 mout VSS VSS) g45n1svt w=(205n) l=45n nf=1 m=(1)
mn20 (CKb CK VSS VSS) g45n1svt w=(145n) l=45n nf=1 m=(1)
mn45 (qbint n30 VSS VSS) g45n1svt w=(260n) l=45n nf=1 m=(1)
mn21 (CKbb CKb VSS VSS) g45n1svt w=(145n) l=45n nf=1 m=(1)
mn40 (mout CKbb n30 VSS) g45n1svt w=(205n) l=45n nf=1 m=(1)
mn30 (mout n20 VSS VSS) g45n1svt w=(205n) l=45n nf=1 m=(1)
mn0 (Eb E VSS VSS) g45n1svt w=(145n) l=45n nf=1 m=(1)
mn1 (qbint Eb Db VSS) g45n1svt w=(260n) l=45n nf=1 m=(1)
mn25 (n20 CKb Db VSS) g45n1svt w=(205n) l=45n nf=1 m=(1)
mn36 (n20 CKbb net340 VSS) g45n1svt w=(205n) l=45n nf=1 m=(1)
mp3 (Db Eb net328 NW) g45p1svt w=(390n) l=45n nf=1 m=(1)
mp2 (net328 D VDD NW) g45p1svt w=(390n) l=45n nf=1 m=(1)
mp51 (n30 CKbb net317 NW) g45p1svt w=(310n) l=45n nf=1 m=(1)
mp50 (net317 qbint VDD NW) g45p1svt w=(310n) l=45n nf=1 m=(1)
mp55 (Q qbint VDD NW) g45p1svt w=(780n) l=45n nf=1 m=(1)
mp35 (net309 mout VDD NW) g45p1svt w=(310n) l=45n nf=1 m=(1)
mp36 (n20 CKb net309 NW) g45p1svt w=(310n) l=45n nf=1 m=(1)
mp45 (qbint n30 VDD NW) g45p1svt w=(390n) l=45n nf=1 m=(1)
mp21 (CKbb CKb VDD NW) g45p1svt w=(215n) l=45n nf=1 m=(1)
mp40 (mout CKb n30 NW) g45p1svt w=(310n) l=45n nf=1 m=(1)
mp30 (mout n20 VDD NW) g45p1svt w=(310n) l=45n nf=1 m=(1)
mp1 (qbint E Db NW) g45p1svt w=(390n) l=45n nf=1 m=(1)
mp20 (CKb CK VDD NW) g45p1svt w=(215n) l=45n nf=1 m=(1)
mp25 (n20 CKbb Db NW) g45p1svt w=(310n) l=45n nf=1 m=(1)
mp0 (Eb E VDD NW) g45p1svt w=(215n) l=45n nf=1 m=(1)
ends EDFFHQX2

// gsclib045_backbias/EDFFHQX4/schematic

simulator lang=spectre

subckt EDFFHQX4 CK D E Q VDD VSS NW
mn3 (Db E net333 VSS) g45n1svt w=(260n) l=45n nf=1 m=(1)
mn2 (net333 D VSS VSS) g45n1svt w=(260n) l=45n nf=1 m=(1)
mn55 (Q qbint VSS VSS) g45n1svt w=(1.04u) l=45n nf=1 m=(1)
mn51 (n30 CKb net380 VSS) g45n1svt w=(205n) l=45n nf=1 m=(1)
mn50 (net380 qbint VSS VSS) g45n1svt w=(205n) l=45n nf=1 m=(1)
mn35 (net340 mout VSS VSS) g45n1svt w=(205n) l=45n nf=1 m=(1)
mn20 (CKb CK VSS VSS) g45n1svt w=(145n) l=45n nf=1 m=(1)
mn45 (qbint n30 VSS VSS) g45n1svt w=(410n) l=45n nf=1 m=(1)
mn21 (CKbb CKb VSS VSS) g45n1svt w=(145n) l=45n nf=1 m=(1)
mn40 (mout CKbb n30 VSS) g45n1svt w=(205n) l=45n nf=1 m=(1)
mn30 (mout n20 VSS VSS) g45n1svt w=(205n) l=45n nf=1 m=(1)
mn0 (Eb E VSS VSS) g45n1svt w=(145n) l=45n nf=1 m=(1)
mn1 (qbint Eb Db VSS) g45n1svt w=(260n) l=45n nf=1 m=(1)
mn25 (n20 CKb Db VSS) g45n1svt w=(205n) l=45n nf=1 m=(1)
mn36 (n20 CKbb net340 VSS) g45n1svt w=(205n) l=45n nf=1 m=(1)
mp3 (Db Eb net328 NW) g45p1svt w=(390n) l=45n nf=1 m=(1)
mp2 (net328 D VDD NW) g45p1svt w=(390n) l=45n nf=1 m=(1)
mp51 (n30 CKbb net317 NW) g45p1svt w=(310n) l=45n nf=1 m=(1)
mp50 (net317 qbint VDD NW) g45p1svt w=(310n) l=45n nf=1 m=(1)
mp55 (Q qbint VDD NW) g45p1svt w=(1.56u) l=45n nf=1 m=(1)
mp35 (net309 mout VDD NW) g45p1svt w=(310n) l=45n nf=1 m=(1)
mp36 (n20 CKb net309 NW) g45p1svt w=(310n) l=45n nf=1 m=(1)
mp45 (qbint n30 VDD NW) g45p1svt w=(620n) l=45n nf=1 m=(1)
mp21 (CKbb CKb VDD NW) g45p1svt w=(215n) l=45n nf=1 m=(1)
mp40 (mout CKb n30 NW) g45p1svt w=(310n) l=45n nf=1 m=(1)
mp30 (mout n20 VDD NW) g45p1svt w=(310n) l=45n nf=1 m=(1)
mp1 (qbint E Db NW) g45p1svt w=(390n) l=45n nf=1 m=(1)
mp20 (CKb CK VDD NW) g45p1svt w=(215n) l=45n nf=1 m=(1)
mp25 (n20 CKbb Db NW) g45p1svt w=(310n) l=45n nf=1 m=(1)
mp0 (Eb E VDD NW) g45p1svt w=(215n) l=45n nf=1 m=(1)
ends EDFFHQX4

// gsclib045_backbias/EDFFHQX8/schematic

simulator lang=spectre

subckt EDFFHQX8 CK D E Q VDD VSS NW
mn3 (Db E net333 VSS) g45n1svt w=(260n) l=45n nf=1 m=(1)
mn2 (net333 D VSS VSS) g45n1svt w=(260n) l=45n nf=1 m=(1)
mn55 (Q qbint VSS VSS) g45n1svt w=(2.065u) l=45n nf=1 m=(1)
mn51 (n30 CKb net380 VSS) g45n1svt w=(205n) l=45n nf=1 m=(1)
mn50 (net380 qbint VSS VSS) g45n1svt w=(205n) l=45n nf=1 m=(1)
mn35 (net340 mout VSS VSS) g45n1svt w=(205n) l=45n nf=1 m=(1)
mn20 (CKb CK VSS VSS) g45n1svt w=(145n) l=45n nf=1 m=(1)
mn45 (qbint n30 VSS VSS) g45n1svt w=(780n) l=45n nf=1 m=(1)
mn21 (CKbb CKb VSS VSS) g45n1svt w=(145n) l=45n nf=1 m=(1)
mn40 (mout CKbb n30 VSS) g45n1svt w=(205n) l=45n nf=1 m=(1)
mn30 (mout n20 VSS VSS) g45n1svt w=(205n) l=45n nf=1 m=(1)
mn0 (Eb E VSS VSS) g45n1svt w=(145n) l=45n nf=1 m=(1)
mn1 (qbint Eb Db VSS) g45n1svt w=(260n) l=45n nf=1 m=(1)
mn25 (n20 CKb Db VSS) g45n1svt w=(205n) l=45n nf=1 m=(1)
mn36 (n20 CKbb net340 VSS) g45n1svt w=(205n) l=45n nf=1 m=(1)
mp3 (Db Eb net328 NW) g45p1svt w=(390n) l=45n nf=1 m=(1)
mp2 (net328 D VDD NW) g45p1svt w=(390n) l=45n nf=1 m=(1)
mp51 (n30 CKbb net317 NW) g45p1svt w=(310n) l=45n nf=1 m=(1)
mp50 (net317 qbint VDD NW) g45p1svt w=(310n) l=45n nf=1 m=(1)
mp55 (Q qbint VDD NW) g45p1svt w=(3.115u) l=45n nf=1 m=(1)
mp35 (net309 mout VDD NW) g45p1svt w=(310n) l=45n nf=1 m=(1)
mp36 (n20 CKb net309 NW) g45p1svt w=(310n) l=45n nf=1 m=(1)
mp45 (qbint n30 VDD NW) g45p1svt w=(1.17u) l=45n nf=1 m=(1)
mp21 (CKbb CKb VDD NW) g45p1svt w=(215n) l=45n nf=1 m=(1)
mp40 (mout CKb n30 NW) g45p1svt w=(310n) l=45n nf=1 m=(1)
mp30 (mout n20 VDD NW) g45p1svt w=(310n) l=45n nf=1 m=(1)
mp1 (qbint E Db NW) g45p1svt w=(390n) l=45n nf=1 m=(1)
mp20 (CKb CK VDD NW) g45p1svt w=(215n) l=45n nf=1 m=(1)
mp25 (n20 CKbb Db NW) g45p1svt w=(310n) l=45n nf=1 m=(1)
mp0 (Eb E VDD NW) g45p1svt w=(215n) l=45n nf=1 m=(1)
ends EDFFHQX8

// gsclib045_backbias/EDFFTRX1/schematic

simulator lang=spectre

subckt EDFFTRX1 CK D E Q QN RN NW VDD VSS
mn35 (net516 mout VSS VSS) g45n1svt w=(145n) l=45n nf=1 m=(1)
mn36 (n20 CKbb net516 VSS) g45n1svt w=(145n) l=45n nf=1 m=(1)
mn26 (n20 CKb n21 VSS) g45n1svt w=(145n) l=45n nf=1 m=(1)
mn25 (n21 Dp VSS VSS) g45n1svt w=(145n) l=45n nf=1 m=(1)
mn51 (n30 CKb net496 VSS) g45n1svt w=(145n) l=45n nf=1 m=(1)
mn50 (net496 qbint VSS VSS) g45n1svt w=(145n) l=45n nf=1 m=(1)
mn57 (QN qint VSS VSS) g45n1svt w=(260n) l=45n nf=1 m=(1)
mn55 (Q qbint VSS VSS) g45n1svt w=(260n) l=45n nf=1 m=(1)
mn5 (Dp qbint n0 VSS) g45n1svt w=(145n) l=45n nf=1 m=(1)
mn4 (n0 Eb VSS VSS) g45n1svt w=(145n) l=45n nf=1 m=(1)
mn6 (n1 E VSS VSS) g45n1svt w=(145n) l=45n nf=1 m=(1)
mn7 (Dp Db n1 VSS) g45n1svt w=(145n) l=45n nf=1 m=(1)
mn20 (CKb CK VSS VSS) g45n1svt w=(145n) l=45n nf=1 m=(1)
mn2 (RNb RN VSS VSS) g45n1svt w=(145n) l=45n nf=1 m=(1)
mn1 (Db D VSS VSS) g45n1svt w=(145n) l=45n nf=1 m=(1)
mn30 (mout n20 VSS VSS) g45n1svt w=(145n) l=45n nf=1 m=(1)
mn21 (CKbb CKb VSS VSS) g45n1svt w=(145n) l=45n nf=1 m=(1)
mn40 (n30 CKbb mout VSS) g45n1svt w=(145n) l=45n nf=1 m=(1)
mn45 (qbint n30 VSS VSS) g45n1svt w=(205n) l=45n nf=1 m=(1)
mn56 (qint qbint VSS VSS) g45n1svt w=(145n) l=45n nf=1 m=(1)
mn3 (Dp RNb VSS VSS) g45n1svt w=(145n) l=45n nf=1 m=(1)
mn0 (Eb E VSS VSS) g45n1svt w=(145n) l=45n nf=1 m=(1)
mp25 (n22 Dp VDD NW) g45p1svt w=(215n) l=45n nf=1 m=(1)
mp26 (n20 CKbb n22 NW) g45p1svt w=(215n) l=45n nf=1 m=(1)
mp35 (net427 mout VDD NW) g45p1svt w=(215n) l=45n nf=1 m=(1)
mp36 (n20 CKb net427 NW) g45p1svt w=(215n) l=45n nf=1 m=(1)
mp51 (n30 CKbb net411 NW) g45p1svt w=(215n) l=45n nf=1 m=(1)
mp50 (net411 qbint VDD NW) g45p1svt w=(215n) l=45n nf=1 m=(1)
mp57 (QN qint VDD NW) g45p1svt w=(390n) l=45n nf=1 m=(1)
mp55 (Q qbint VDD NW) g45p1svt w=(390n) l=45n nf=1 m=(1)
mp20 (CKb CK VDD NW) g45p1svt w=(215n) l=45n nf=1 m=(1)
mp2 (RNb RN VDD NW) g45p1svt w=(215n) l=45n nf=1 m=(1)
mp1 (Db D VDD NW) g45p1svt w=(215n) l=45n nf=1 m=(1)
mp7 (Dp Db n3 NW) g45p1svt w=(215n) l=45n nf=1 m=(1)
mp6 (Dp E n3 NW) g45p1svt w=(215n) l=45n nf=1 m=(1)
mp30 (mout n20 VDD NW) g45p1svt w=(215n) l=45n nf=1 m=(1)
mp21 (CKbb CKb VDD NW) g45p1svt w=(215n) l=45n nf=1 m=(1)
mp40 (n30 CKb mout NW) g45p1svt w=(215n) l=45n nf=1 m=(1)
mp45 (qbint n30 VDD NW) g45p1svt w=(310n) l=45n nf=1 m=(1)
mp56 (qint qbint VDD NW) g45p1svt w=(215n) l=45n nf=1 m=(1)
mp5 (n3 qbint n2 NW) g45p1svt w=(215n) l=45n nf=1 m=(1)
mp0 (Eb E VDD NW) g45p1svt w=(215n) l=45n nf=1 m=(1)
mp4 (n3 Eb n2 NW) g45p1svt w=(215n) l=45n nf=1 m=(1)
mp3 (n2 RNb VDD NW) g45p1svt w=(215n) l=45n nf=1 m=(1)
ends EDFFTRX1

// gsclib045_backbias/EDFFTRX2/schematic

simulator lang=spectre

subckt EDFFTRX2 CK D E Q QN RN NW VDD VSS
mn35 (net516 mout VSS VSS) g45n1svt w=(145n) l=45n nf=1 m=(1)
mn36 (n20 CKbb net516 VSS) g45n1svt w=(145n) l=45n nf=1 m=(1)
mn26 (n20 CKb n21 VSS) g45n1svt w=(145n) l=45n nf=1 m=(1)
mn25 (n21 Dp VSS VSS) g45n1svt w=(145n) l=45n nf=1 m=(1)
mn51 (n30 CKb net496 VSS) g45n1svt w=(145n) l=45n nf=1 m=(1)
mn50 (net496 qbint VSS VSS) g45n1svt w=(145n) l=45n nf=1 m=(1)
mn57 (QN qint VSS VSS) g45n1svt w=(520n) l=45n nf=1 m=(1)
mn55 (Q qbint VSS VSS) g45n1svt w=(520n) l=45n nf=1 m=(1)
mn5 (Dp qbint n0 VSS) g45n1svt w=(145n) l=45n nf=1 m=(1)
mn4 (n0 Eb VSS VSS) g45n1svt w=(145n) l=45n nf=1 m=(1)
mn6 (n1 E VSS VSS) g45n1svt w=(145n) l=45n nf=1 m=(1)
mn7 (Dp Db n1 VSS) g45n1svt w=(145n) l=45n nf=1 m=(1)
mn20 (CKb CK VSS VSS) g45n1svt w=(145n) l=45n nf=1 m=(1)
mn2 (RNb RN VSS VSS) g45n1svt w=(145n) l=45n nf=1 m=(1)
mn1 (Db D VSS VSS) g45n1svt w=(145n) l=45n nf=1 m=(1)
mn30 (mout n20 VSS VSS) g45n1svt w=(145n) l=45n nf=1 m=(1)
mn21 (CKbb CKb VSS VSS) g45n1svt w=(145n) l=45n nf=1 m=(1)
mn40 (n30 CKbb mout VSS) g45n1svt w=(145n) l=45n nf=1 m=(1)
mn45 (qbint n30 VSS VSS) g45n1svt w=(260n) l=45n nf=1 m=(1)
mn56 (qint qbint VSS VSS) g45n1svt w=(145n) l=45n nf=1 m=(1)
mn3 (Dp RNb VSS VSS) g45n1svt w=(145n) l=45n nf=1 m=(1)
mn0 (Eb E VSS VSS) g45n1svt w=(145n) l=45n nf=1 m=(1)
mp25 (n22 Dp VDD NW) g45p1svt w=(215n) l=45n nf=1 m=(1)
mp26 (n20 CKbb n22 NW) g45p1svt w=(215n) l=45n nf=1 m=(1)
mp35 (net427 mout VDD NW) g45p1svt w=(215n) l=45n nf=1 m=(1)
mp36 (n20 CKb net427 NW) g45p1svt w=(215n) l=45n nf=1 m=(1)
mp51 (n30 CKbb net411 NW) g45p1svt w=(215n) l=45n nf=1 m=(1)
mp50 (net411 qbint VDD NW) g45p1svt w=(215n) l=45n nf=1 m=(1)
mp57 (QN qint VDD NW) g45p1svt w=(780n) l=45n nf=1 m=(1)
mp55 (Q qbint VDD NW) g45p1svt w=(780n) l=45n nf=1 m=(1)
mp20 (CKb CK VDD NW) g45p1svt w=(215n) l=45n nf=1 m=(1)
mp2 (RNb RN VDD NW) g45p1svt w=(215n) l=45n nf=1 m=(1)
mp1 (Db D VDD NW) g45p1svt w=(215n) l=45n nf=1 m=(1)
mp7 (Dp Db n3 NW) g45p1svt w=(215n) l=45n nf=1 m=(1)
mp6 (Dp E n3 NW) g45p1svt w=(215n) l=45n nf=1 m=(1)
mp30 (mout n20 VDD NW) g45p1svt w=(215n) l=45n nf=1 m=(1)
mp21 (CKbb CKb VDD NW) g45p1svt w=(215n) l=45n nf=1 m=(1)
mp40 (n30 CKb mout NW) g45p1svt w=(215n) l=45n nf=1 m=(1)
mp45 (qbint n30 VDD NW) g45p1svt w=(390n) l=45n nf=1 m=(1)
mp56 (qint qbint VDD NW) g45p1svt w=(215n) l=45n nf=1 m=(1)
mp5 (n3 qbint n2 NW) g45p1svt w=(215n) l=45n nf=1 m=(1)
mp0 (Eb E VDD NW) g45p1svt w=(215n) l=45n nf=1 m=(1)
mp4 (n3 Eb n2 NW) g45p1svt w=(215n) l=45n nf=1 m=(1)
mp3 (n2 RNb VDD NW) g45p1svt w=(215n) l=45n nf=1 m=(1)
ends EDFFTRX2

// gsclib045_backbias/EDFFTRX4/schematic

simulator lang=spectre

subckt EDFFTRX4 CK D E Q QN RN NW VDD VSS
mn35 (net516 mout VSS VSS) g45n1svt w=(145n) l=45n nf=1 m=(1)
mn36 (n20 CKbb net516 VSS) g45n1svt w=(145n) l=45n nf=1 m=(1)
mn26 (n20 CKb n21 VSS) g45n1svt w=(145n) l=45n nf=1 m=(1)
mn25 (n21 Dp VSS VSS) g45n1svt w=(145n) l=45n nf=1 m=(1)
mn51 (n30 CKb net496 VSS) g45n1svt w=(145n) l=45n nf=1 m=(1)
mn50 (net496 qbint VSS VSS) g45n1svt w=(145n) l=45n nf=1 m=(1)
mn57 (QN qint VSS VSS) g45n1svt w=(1.04u) l=45n nf=1 m=(1)
mn55 (Q qbint VSS VSS) g45n1svt w=(1.04u) l=45n nf=1 m=(1)
mn5 (Dp qbint n0 VSS) g45n1svt w=(145n) l=45n nf=1 m=(1)
mn4 (n0 Eb VSS VSS) g45n1svt w=(145n) l=45n nf=1 m=(1)
mn6 (n1 E VSS VSS) g45n1svt w=(145n) l=45n nf=1 m=(1)
mn7 (Dp Db n1 VSS) g45n1svt w=(145n) l=45n nf=1 m=(1)
mn20 (CKb CK VSS VSS) g45n1svt w=(145n) l=45n nf=1 m=(1)
mn2 (RNb RN VSS VSS) g45n1svt w=(145n) l=45n nf=1 m=(1)
mn1 (Db D VSS VSS) g45n1svt w=(145n) l=45n nf=1 m=(1)
mn30 (mout n20 VSS VSS) g45n1svt w=(145n) l=45n nf=1 m=(1)
mn21 (CKbb CKb VSS VSS) g45n1svt w=(145n) l=45n nf=1 m=(1)
mn40 (n30 CKbb mout VSS) g45n1svt w=(145n) l=45n nf=1 m=(1)
mn45 (qbint n30 VSS VSS) g45n1svt w=(410n) l=45n nf=1 m=(1)
mn56 (qint qbint VSS VSS) g45n1svt w=(260n) l=45n nf=1 m=(1)
mn3 (Dp RNb VSS VSS) g45n1svt w=(145n) l=45n nf=1 m=(1)
mn0 (Eb E VSS VSS) g45n1svt w=(145n) l=45n nf=1 m=(1)
mp25 (n22 Dp VDD NW) g45p1svt w=(215n) l=45n nf=1 m=(1)
mp26 (n20 CKbb n22 NW) g45p1svt w=(215n) l=45n nf=1 m=(1)
mp35 (net427 mout VDD NW) g45p1svt w=(215n) l=45n nf=1 m=(1)
mp36 (n20 CKb net427 NW) g45p1svt w=(215n) l=45n nf=1 m=(1)
mp51 (n30 CKbb net411 NW) g45p1svt w=(215n) l=45n nf=1 m=(1)
mp50 (net411 qbint VDD NW) g45p1svt w=(215n) l=45n nf=1 m=(1)
mp57 (QN qint VDD NW) g45p1svt w=(1.56u) l=45n nf=1 m=(1)
mp55 (Q qbint VDD NW) g45p1svt w=(1.56u) l=45n nf=1 m=(1)
mp20 (CKb CK VDD NW) g45p1svt w=(215n) l=45n nf=1 m=(1)
mp2 (RNb RN VDD NW) g45p1svt w=(215n) l=45n nf=1 m=(1)
mp1 (Db D VDD NW) g45p1svt w=(215n) l=45n nf=1 m=(1)
mp7 (Dp Db n3 NW) g45p1svt w=(215n) l=45n nf=1 m=(1)
mp6 (Dp E n3 NW) g45p1svt w=(215n) l=45n nf=1 m=(1)
mp30 (mout n20 VDD NW) g45p1svt w=(215n) l=45n nf=1 m=(1)
mp21 (CKbb CKb VDD NW) g45p1svt w=(215n) l=45n nf=1 m=(1)
mp40 (n30 CKb mout NW) g45p1svt w=(215n) l=45n nf=1 m=(1)
mp45 (qbint n30 VDD NW) g45p1svt w=(620n) l=45n nf=1 m=(1)
mp56 (qint qbint VDD NW) g45p1svt w=(390n) l=45n nf=1 m=(1)
mp5 (n3 qbint n2 NW) g45p1svt w=(215n) l=45n nf=1 m=(1)
mp0 (Eb E VDD NW) g45p1svt w=(215n) l=45n nf=1 m=(1)
mp4 (n3 Eb n2 NW) g45p1svt w=(215n) l=45n nf=1 m=(1)
mp3 (n2 RNb VDD NW) g45p1svt w=(215n) l=45n nf=1 m=(1)
ends EDFFTRX4

// gsclib045_backbias/EDFFTRXL/schematic

simulator lang=spectre

subckt EDFFTRXL CK D E Q QN RN NW VDD VSS
mn35 (net516 mout VSS VSS) g45n1svt w=(145n) l=45n nf=1 m=(1)
mn36 (n20 CKbb net516 VSS) g45n1svt w=(145n) l=45n nf=1 m=(1)
mn26 (n20 CKb n21 VSS) g45n1svt w=(145n) l=45n nf=1 m=(1)
mn25 (n21 Dp VSS VSS) g45n1svt w=(145n) l=45n nf=1 m=(1)
mn51 (n30 CKb net496 VSS) g45n1svt w=(145n) l=45n nf=1 m=(1)
mn50 (net496 qbint VSS VSS) g45n1svt w=(145n) l=45n nf=1 m=(1)
mn57 (QN qint VSS VSS) g45n1svt w=(145n) l=45n nf=1 m=(1)
mn55 (Q qbint VSS VSS) g45n1svt w=(145n) l=45n nf=1 m=(1)
mn5 (Dp qbint n0 VSS) g45n1svt w=(145n) l=45n nf=1 m=(1)
mn4 (n0 Eb VSS VSS) g45n1svt w=(145n) l=45n nf=1 m=(1)
mn6 (n1 E VSS VSS) g45n1svt w=(145n) l=45n nf=1 m=(1)
mn7 (Dp Db n1 VSS) g45n1svt w=(145n) l=45n nf=1 m=(1)
mn20 (CKb CK VSS VSS) g45n1svt w=(145n) l=45n nf=1 m=(1)
mn2 (RNb RN VSS VSS) g45n1svt w=(145n) l=45n nf=1 m=(1)
mn1 (Db D VSS VSS) g45n1svt w=(145n) l=45n nf=1 m=(1)
mn30 (mout n20 VSS VSS) g45n1svt w=(145n) l=45n nf=1 m=(1)
mn21 (CKbb CKb VSS VSS) g45n1svt w=(145n) l=45n nf=1 m=(1)
mn40 (n30 CKbb mout VSS) g45n1svt w=(145n) l=45n nf=1 m=(1)
mn45 (qbint n30 VSS VSS) g45n1svt w=(145n) l=45n nf=1 m=(1)
mn56 (qint qbint VSS VSS) g45n1svt w=(145n) l=45n nf=1 m=(1)
mn3 (Dp RNb VSS VSS) g45n1svt w=(145n) l=45n nf=1 m=(1)
mn0 (Eb E VSS VSS) g45n1svt w=(145n) l=45n nf=1 m=(1)
mp25 (n22 Dp VDD NW) g45p1svt w=(215n) l=45n nf=1 m=(1)
mp26 (n20 CKbb n22 NW) g45p1svt w=(215n) l=45n nf=1 m=(1)
mp35 (net427 mout VDD NW) g45p1svt w=(215n) l=45n nf=1 m=(1)
mp36 (n20 CKb net427 NW) g45p1svt w=(215n) l=45n nf=1 m=(1)
mp51 (n30 CKbb net411 NW) g45p1svt w=(215n) l=45n nf=1 m=(1)
mp50 (net411 qbint VDD NW) g45p1svt w=(215n) l=45n nf=1 m=(1)
mp57 (QN qint VDD NW) g45p1svt w=(215n) l=45n nf=1 m=(1)
mp55 (Q qbint VDD NW) g45p1svt w=(215n) l=45n nf=1 m=(1)
mp20 (CKb CK VDD NW) g45p1svt w=(215n) l=45n nf=1 m=(1)
mp2 (RNb RN VDD NW) g45p1svt w=(215n) l=45n nf=1 m=(1)
mp1 (Db D VDD NW) g45p1svt w=(215n) l=45n nf=1 m=(1)
mp7 (Dp Db n3 NW) g45p1svt w=(215n) l=45n nf=1 m=(1)
mp6 (Dp E n3 NW) g45p1svt w=(215n) l=45n nf=1 m=(1)
mp30 (mout n20 VDD NW) g45p1svt w=(215n) l=45n nf=1 m=(1)
mp21 (CKbb CKb VDD NW) g45p1svt w=(215n) l=45n nf=1 m=(1)
mp40 (n30 CKb mout NW) g45p1svt w=(215n) l=45n nf=1 m=(1)
mp45 (qbint n30 VDD NW) g45p1svt w=(215n) l=45n nf=1 m=(1)
mp56 (qint qbint VDD NW) g45p1svt w=(215n) l=45n nf=1 m=(1)
mp5 (n3 qbint n2 NW) g45p1svt w=(215n) l=45n nf=1 m=(1)
mp0 (Eb E VDD NW) g45p1svt w=(215n) l=45n nf=1 m=(1)
mp4 (n3 Eb n2 NW) g45p1svt w=(215n) l=45n nf=1 m=(1)
mp3 (n2 RNb VDD NW) g45p1svt w=(215n) l=45n nf=1 m=(1)
ends EDFFTRXL

// gsclib045_backbias/EDFFX1/schematic

simulator lang=spectre

subckt EDFFX1 CK D E Q QN VDD NW VSS
mn3 (Db E n0 VSS) g45n1svt w=(145n) l=45n nf=1 m=(1)
mn2 (n0 D VSS VSS) g45n1svt w=(145n) l=45n nf=1 m=(1)
mn57 (QN qint VSS VSS) g45n1svt w=(260n) l=45n nf=1 m=(1)
mn55 (Q qbint VSS VSS) g45n1svt w=(260n) l=45n nf=1 m=(1)
mn51 (n30 Ckb net415 VSS) g45n1svt w=(145n) l=45n nf=1 m=(1)
mn50 (net415 qbint VSS VSS) g45n1svt w=(145n) l=45n nf=1 m=(1)
mn35 (net411 mout VSS VSS) g45n1svt w=(145n) l=45n nf=1 m=(1)
mn36 (n20 CKbb net411 VSS) g45n1svt w=(145n) l=45n nf=1 m=(1)
mn20 (Ckb CK VSS VSS) g45n1svt w=(145n) l=45n nf=1 m=(1)
mn45 (qbint n30 VSS VSS) g45n1svt w=(205n) l=45n nf=1 m=(1)
mn56 (qint qbint VSS VSS) g45n1svt w=(145n) l=45n nf=1 m=(1)
mn0 (Eb E VSS VSS) g45n1svt w=(145n) l=45n nf=1 m=(1)
mn30 (mout n20 VSS VSS) g45n1svt w=(145n) l=45n nf=1 m=(1)
mn21 (CKbb Ckb VSS VSS) g45n1svt w=(145n) l=45n nf=1 m=(1)
mn40 (mout CKbb n30 VSS) g45n1svt w=(145n) l=45n nf=1 m=(1)
mn1 (qbint Eb Db VSS) g45n1svt w=(145n) l=45n nf=1 m=(1)
mn25 (Db Ckb n20 VSS) g45n1svt w=(145n) l=45n nf=1 m=(1)
mp3 (Db Eb n1 NW) g45p1svt w=(215n) l=45n nf=1 m=(1)
mp2 (n1 D VDD NW) g45p1svt w=(215n) l=45n nf=1 m=(1)
mp51 (n30 CKbb net362 NW) g45p1svt w=(215n) l=45n nf=1 m=(1)
mp50 (net362 qbint VDD NW) g45p1svt w=(215n) l=45n nf=1 m=(1)
mp57 (QN qint VDD NW) g45p1svt w=(390n) l=45n nf=1 m=(1)
mp55 (Q qbint VDD NW) g45p1svt w=(390n) l=45n nf=1 m=(1)
mp35 (net342 mout VDD NW) g45p1svt w=(215n) l=45n nf=1 m=(1)
mp36 (n20 Ckb net342 NW) g45p1svt w=(215n) l=45n nf=1 m=(1)
mp20 (Ckb CK VDD NW) g45p1svt w=(215n) l=45n nf=1 m=(1)
mp45 (qbint n30 VDD NW) g45p1svt w=(310n) l=45n nf=1 m=(1)
mp56 (qint qbint VDD NW) g45p1svt w=(215n) l=45n nf=1 m=(1)
mp21 (CKbb Ckb VDD NW) g45p1svt w=(215n) l=45n nf=1 m=(1)
mp40 (n30 Ckb mout NW) g45p1svt w=(215n) l=45n nf=1 m=(1)
mp30 (mout n20 VDD NW) g45p1svt w=(215n) l=45n nf=1 m=(1)
mp25 (n20 CKbb Db NW) g45p1svt w=(215n) l=45n nf=1 m=(1)
mp0 (Eb E VDD NW) g45p1svt w=(215n) l=45n nf=1 m=(1)
mp1 (qbint E Db NW) g45p1svt w=(215n) l=45n nf=1 m=(1)
ends EDFFX1

// gsclib045_backbias/EDFFX2/schematic

simulator lang=spectre

subckt EDFFX2 CK D E Q QN NW VSS VDD
mn3 (Db E n0 VSS) g45n1svt w=(145n) l=45n nf=1 m=(1)
mn2 (n0 D VSS VSS) g45n1svt w=(145n) l=45n nf=1 m=(1)
mn57 (QN qint VSS VSS) g45n1svt w=(520n) l=45n nf=1 m=(1)
mn55 (Q qbint VSS VSS) g45n1svt w=(520n) l=45n nf=1 m=(1)
mn51 (n30 Ckb net415 VSS) g45n1svt w=(145n) l=45n nf=1 m=(1)
mn50 (net415 qbint VSS VSS) g45n1svt w=(145n) l=45n nf=1 m=(1)
mn35 (net411 mout VSS VSS) g45n1svt w=(145n) l=45n nf=1 m=(1)
mn36 (n20 CKbb net411 VSS) g45n1svt w=(145n) l=45n nf=1 m=(1)
mn20 (Ckb CK VSS VSS) g45n1svt w=(145n) l=45n nf=1 m=(1)
mn45 (qbint n30 VSS VSS) g45n1svt w=(260n) l=45n nf=1 m=(1)
mn56 (qint qbint VSS VSS) g45n1svt w=(145n) l=45n nf=1 m=(1)
mn0 (Eb E VSS VSS) g45n1svt w=(145n) l=45n nf=1 m=(1)
mn30 (mout n20 VSS VSS) g45n1svt w=(145n) l=45n nf=1 m=(1)
mn21 (CKbb Ckb VSS VSS) g45n1svt w=(145n) l=45n nf=1 m=(1)
mn40 (mout CKbb n30 VSS) g45n1svt w=(145n) l=45n nf=1 m=(1)
mn1 (qbint Eb Db VSS) g45n1svt w=(145n) l=45n nf=1 m=(1)
mn25 (Db Ckb n20 VSS) g45n1svt w=(145n) l=45n nf=1 m=(1)
mp3 (Db Eb n1 NW) g45p1svt w=(215n) l=45n nf=1 m=(1)
mp2 (n1 D VDD NW) g45p1svt w=(215n) l=45n nf=1 m=(1)
mp51 (n30 CKbb net362 NW) g45p1svt w=(215n) l=45n nf=1 m=(1)
mp50 (net362 qbint VDD NW) g45p1svt w=(215n) l=45n nf=1 m=(1)
mp57 (QN qint VDD NW) g45p1svt w=(780n) l=45n nf=1 m=(1)
mp55 (Q qbint VDD NW) g45p1svt w=(780n) l=45n nf=1 m=(1)
mp35 (net342 mout VDD NW) g45p1svt w=(215n) l=45n nf=1 m=(1)
mp36 (n20 Ckb net342 NW) g45p1svt w=(215n) l=45n nf=1 m=(1)
mp20 (Ckb CK VDD NW) g45p1svt w=(215n) l=45n nf=1 m=(1)
mp45 (qbint n30 VDD NW) g45p1svt w=(390n) l=45n nf=1 m=(1)
mp56 (qint qbint VDD NW) g45p1svt w=(215n) l=45n nf=1 m=(1)
mp21 (CKbb Ckb VDD NW) g45p1svt w=(215n) l=45n nf=1 m=(1)
mp40 (n30 Ckb mout NW) g45p1svt w=(215n) l=45n nf=1 m=(1)
mp30 (mout n20 VDD NW) g45p1svt w=(215n) l=45n nf=1 m=(1)
mp25 (n20 CKbb Db NW) g45p1svt w=(215n) l=45n nf=1 m=(1)
mp0 (Eb E VDD NW) g45p1svt w=(215n) l=45n nf=1 m=(1)
mp1 (qbint E Db NW) g45p1svt w=(215n) l=45n nf=1 m=(1)
ends EDFFX2

// gsclib045_backbias/EDFFX4/schematic

simulator lang=spectre

subckt EDFFX4 CK D E Q QN NW VSS VDD
mn3 (Db E n0 VSS) g45n1svt w=(145n) l=45n nf=1 m=(1)
mn2 (n0 D VSS VSS) g45n1svt w=(145n) l=45n nf=1 m=(1)
mn57 (QN qint VSS VSS) g45n1svt w=(1.04u) l=45n nf=1 m=(1)
mn55 (Q qbint VSS VSS) g45n1svt w=(1.04u) l=45n nf=1 m=(1)
mn51 (n30 Ckb net415 VSS) g45n1svt w=(145n) l=45n nf=1 m=(1)
mn50 (net415 qbint VSS VSS) g45n1svt w=(145n) l=45n nf=1 m=(1)
mn35 (net411 mout VSS VSS) g45n1svt w=(145n) l=45n nf=1 m=(1)
mn36 (n20 CKbb net411 VSS) g45n1svt w=(145n) l=45n nf=1 m=(1)
mn20 (Ckb CK VSS VSS) g45n1svt w=(145n) l=45n nf=1 m=(1)
mn45 (qbint n30 VSS VSS) g45n1svt w=(410n) l=45n nf=1 m=(1)
mn56 (qint qbint VSS VSS) g45n1svt w=(260n) l=45n nf=1 m=(1)
mn0 (Eb E VSS VSS) g45n1svt w=(145n) l=45n nf=1 m=(1)
mn30 (mout n20 VSS VSS) g45n1svt w=(145n) l=45n nf=1 m=(1)
mn21 (CKbb Ckb VSS VSS) g45n1svt w=(145n) l=45n nf=1 m=(1)
mn40 (mout CKbb n30 VSS) g45n1svt w=(145n) l=45n nf=1 m=(1)
mn1 (qbint Eb Db VSS) g45n1svt w=(145n) l=45n nf=1 m=(1)
mn25 (Db Ckb n20 VSS) g45n1svt w=(145n) l=45n nf=1 m=(1)
mp3 (Db Eb n1 NW) g45p1svt w=(215n) l=45n nf=1 m=(1)
mp2 (n1 D VDD NW) g45p1svt w=(215n) l=45n nf=1 m=(1)
mp51 (n30 CKbb net362 NW) g45p1svt w=(215n) l=45n nf=1 m=(1)
mp50 (net362 qbint VDD NW) g45p1svt w=(215n) l=45n nf=1 m=(1)
mp57 (QN qint VDD NW) g45p1svt w=(1.56u) l=45n nf=1 m=(1)
mp55 (Q qbint VDD NW) g45p1svt w=(1.56u) l=45n nf=1 m=(1)
mp35 (net342 mout VDD NW) g45p1svt w=(215n) l=45n nf=1 m=(1)
mp36 (n20 Ckb net342 NW) g45p1svt w=(215n) l=45n nf=1 m=(1)
mp20 (Ckb CK VDD NW) g45p1svt w=(215n) l=45n nf=1 m=(1)
mp45 (qbint n30 VDD NW) g45p1svt w=(620n) l=45n nf=1 m=(1)
mp56 (qint qbint VDD NW) g45p1svt w=(390n) l=45n nf=1 m=(1)
mp21 (CKbb Ckb VDD NW) g45p1svt w=(215n) l=45n nf=1 m=(1)
mp40 (n30 Ckb mout NW) g45p1svt w=(215n) l=45n nf=1 m=(1)
mp30 (mout n20 VDD NW) g45p1svt w=(215n) l=45n nf=1 m=(1)
mp25 (n20 CKbb Db NW) g45p1svt w=(215n) l=45n nf=1 m=(1)
mp0 (Eb E VDD NW) g45p1svt w=(215n) l=45n nf=1 m=(1)
mp1 (qbint E Db NW) g45p1svt w=(215n) l=45n nf=1 m=(1)
ends EDFFX4

// gsclib045_backbias/EDFFXL/schematic

simulator lang=spectre

subckt EDFFXL CK D E Q QN NW VSS VDD
mn3 (Db E n0 VSS) g45n1svt w=(145n) l=45n nf=1 m=(1)
mn2 (n0 D VSS VSS) g45n1svt w=(145n) l=45n nf=1 m=(1)
mn57 (QN qint VSS VSS) g45n1svt w=(145n) l=45n nf=1 m=(1)
mn55 (Q qbint VSS VSS) g45n1svt w=(145n) l=45n nf=1 m=(1)
mn51 (n30 Ckb net415 VSS) g45n1svt w=(145n) l=45n nf=1 m=(1)
mn50 (net415 qbint VSS VSS) g45n1svt w=(145n) l=45n nf=1 m=(1)
mn35 (net411 mout VSS VSS) g45n1svt w=(145n) l=45n nf=1 m=(1)
mn36 (n20 CKbb net411 VSS) g45n1svt w=(145n) l=45n nf=1 m=(1)
mn20 (Ckb CK VSS VSS) g45n1svt w=(145n) l=45n nf=1 m=(1)
mn45 (qbint n30 VSS VSS) g45n1svt w=(145n) l=45n nf=1 m=(1)
mn56 (qint qbint VSS VSS) g45n1svt w=(145n) l=45n nf=1 m=(1)
mn0 (Eb E VSS VSS) g45n1svt w=(145n) l=45n nf=1 m=(1)
mn30 (mout n20 VSS VSS) g45n1svt w=(145n) l=45n nf=1 m=(1)
mn21 (CKbb Ckb VSS VSS) g45n1svt w=(145n) l=45n nf=1 m=(1)
mn40 (mout CKbb n30 VSS) g45n1svt w=(145n) l=45n nf=1 m=(1)
mn1 (qbint Eb Db VSS) g45n1svt w=(145n) l=45n nf=1 m=(1)
mn25 (Db Ckb n20 VSS) g45n1svt w=(145n) l=45n nf=1 m=(1)
mp3 (Db Eb n1 NW) g45p1svt w=(215n) l=45n nf=1 m=(1)
mp2 (n1 D VDD NW) g45p1svt w=(215n) l=45n nf=1 m=(1)
mp51 (n30 CKbb net362 NW) g45p1svt w=(215n) l=45n nf=1 m=(1)
mp50 (net362 qbint VDD NW) g45p1svt w=(215n) l=45n nf=1 m=(1)
mp57 (QN qint VDD NW) g45p1svt w=(215n) l=45n nf=1 m=(1)
mp55 (Q qbint VDD NW) g45p1svt w=(215n) l=45n nf=1 m=(1)
mp35 (net342 mout VDD NW) g45p1svt w=(215n) l=45n nf=1 m=(1)
mp36 (n20 Ckb net342 NW) g45p1svt w=(215n) l=45n nf=1 m=(1)
mp20 (Ckb CK VDD NW) g45p1svt w=(215n) l=45n nf=1 m=(1)
mp45 (qbint n30 VDD NW) g45p1svt w=(215n) l=45n nf=1 m=(1)
mp56 (qint qbint VDD NW) g45p1svt w=(215n) l=45n nf=1 m=(1)
mp21 (CKbb Ckb VDD NW) g45p1svt w=(215n) l=45n nf=1 m=(1)
mp40 (n30 Ckb mout NW) g45p1svt w=(215n) l=45n nf=1 m=(1)
mp30 (mout n20 VDD NW) g45p1svt w=(215n) l=45n nf=1 m=(1)
mp25 (n20 CKbb Db NW) g45p1svt w=(215n) l=45n nf=1 m=(1)
mp0 (Eb E VDD NW) g45p1svt w=(215n) l=45n nf=1 m=(1)
mp1 (qbint E Db NW) g45p1svt w=(215n) l=45n nf=1 m=(1)
ends EDFFXL

// gsclib045_backbias/MDFFHQX1/schematic

simulator lang=spectre

subckt MDFFHQX1 CK D0 D1 Q S0 VSS NW VDD
mn13 (n12 D1 VSS VSS) g45n1svt w=(260n) l=45n nf=1 m=(1)
mn14 (D0b S0 n12 VSS) g45n1svt w=(260n) l=45n nf=1 m=(1)
mn12 (D0b S0b n10 VSS) g45n1svt w=(260n) l=45n nf=1 m=(1)
mn11 (n10 D0 VSS VSS) g45n1svt w=(260n) l=45n nf=1 m=(1)
mn55 (Q qbint VSS VSS) g45n1svt w=(260n) l=45n nf=1 m=(1)
mn50 (n35 qbint VSS VSS) g45n1svt w=(205n) l=45n nf=1 m=(1)
mn51 (n30 CKb n35 VSS) g45n1svt w=(205n) l=45n nf=1 m=(1)
mn10 (S0b S0 VSS VSS) g45n1svt w=(145n) l=45n nf=1 m=(1)
mn40 (mout CKbb n30 VSS) g45n1svt w=(205n) l=45n nf=1 m=(1)
mn35 (n25 mout VSS VSS) g45n1svt w=(205n) l=45n nf=1 m=(1)
mn36 (n20 CKbb n25 VSS) g45n1svt w=(205n) l=45n nf=1 m=(1)
mn21 (CKbb CKb VSS VSS) g45n1svt w=(145n) l=45n nf=1 m=(1)
mn45 (qbint n30 VSS VSS) g45n1svt w=(205n) l=45n nf=1 m=(1)
mn25 (D0b CKb n20 VSS) g45n1svt w=(205n) l=45n nf=1 m=(1)
mn30 (mout n20 VSS VSS) g45n1svt w=(205n) l=45n nf=1 m=(1)
mn20 (CKb CK VSS VSS) g45n1svt w=(145n) l=45n nf=1 m=(1)
mp14 (D0b S0b n13 NW) g45p1svt w=(390n) l=45n nf=1 m=(1)
mp13 (n13 D1 VDD NW) g45p1svt w=(390n) l=45n nf=1 m=(1)
mp12 (D0b S0 n11 NW) g45p1svt w=(390n) l=45n nf=1 m=(1)
mp11 (n11 D0 VDD NW) g45p1svt w=(390n) l=45n nf=1 m=(1)
mp51 (n30 CKbb n36 NW) g45p1svt w=(310n) l=45n nf=1 m=(1)
mp50 (n36 qbint VDD NW) g45p1svt w=(310n) l=45n nf=1 m=(1)
mp55 (Q qbint VDD NW) g45p1svt w=(390n) l=45n nf=1 m=(1)
mp35 (n26 mout VDD NW) g45p1svt w=(310n) l=45n nf=1 m=(1)
mp36 (n20 CKb n26 NW) g45p1svt w=(310n) l=45n nf=1 m=(1)
mp25 (n20 CKbb D0b NW) g45p1svt w=(310n) l=45n nf=1 m=(1)
mp21 (CKbb CKb VDD NW) g45p1svt w=(215n) l=45n nf=1 m=(1)
mp30 (mout n20 VDD NW) g45p1svt w=(310n) l=45n nf=1 m=(1)
mp40 (n30 CKb mout NW) g45p1svt w=(310n) l=45n nf=1 m=(1)
mp10 (S0b S0 VDD NW) g45p1svt w=(215n) l=45n nf=1 m=(1)
mp45 (qbint n30 VDD NW) g45p1svt w=(310n) l=45n nf=1 m=(1)
mp20 (CKb CK VDD NW) g45p1svt w=(215n) l=45n nf=1 m=(1)
ends MDFFHQX1

// gsclib045_backbias/MDFFHQX2/schematic

simulator lang=spectre

subckt MDFFHQX2 CK D0 D1 Q S0 NW VSS VDD
mn13 (n12 D1 VSS VSS) g45n1svt w=(260n) l=45n nf=1 m=(1)
mn14 (D0b S0 n12 VSS) g45n1svt w=(260n) l=45n nf=1 m=(1)
mn12 (D0b S0b n10 VSS) g45n1svt w=(260n) l=45n nf=1 m=(1)
mn11 (n10 D0 VSS VSS) g45n1svt w=(260n) l=45n nf=1 m=(1)
mn55 (Q qbint VSS VSS) g45n1svt w=(520n) l=45n nf=1 m=(1)
mn50 (n35 qbint VSS VSS) g45n1svt w=(205n) l=45n nf=1 m=(1)
mn51 (n30 CKb n35 VSS) g45n1svt w=(205n) l=45n nf=1 m=(1)
mn10 (S0b S0 VSS VSS) g45n1svt w=(145n) l=45n nf=1 m=(1)
mn40 (mout CKbb n30 VSS) g45n1svt w=(205n) l=45n nf=1 m=(1)
mn35 (n25 mout VSS VSS) g45n1svt w=(205n) l=45n nf=1 m=(1)
mn36 (n20 CKbb n25 VSS) g45n1svt w=(205n) l=45n nf=1 m=(1)
mn21 (CKbb CKb VSS VSS) g45n1svt w=(145n) l=45n nf=1 m=(1)
mn45 (qbint n30 VSS VSS) g45n1svt w=(205n) l=45n nf=1 m=(1)
mn25 (D0b CKb n20 VSS) g45n1svt w=(205n) l=45n nf=1 m=(1)
mn30 (mout n20 VSS VSS) g45n1svt w=(205n) l=45n nf=1 m=(1)
mn20 (CKb CK VSS VSS) g45n1svt w=(145n) l=45n nf=1 m=(1)
mp14 (D0b S0b n13 NW) g45p1svt w=(390n) l=45n nf=1 m=(1)
mp13 (n13 D1 VDD NW) g45p1svt w=(390n) l=45n nf=1 m=(1)
mp12 (D0b S0 n11 NW) g45p1svt w=(390n) l=45n nf=1 m=(1)
mp11 (n11 D0 VDD NW) g45p1svt w=(390n) l=45n nf=1 m=(1)
mp51 (n30 CKbb n36 NW) g45p1svt w=(310n) l=45n nf=1 m=(1)
mp50 (n36 qbint VDD NW) g45p1svt w=(310n) l=45n nf=1 m=(1)
mp55 (Q qbint VDD NW) g45p1svt w=(780n) l=45n nf=1 m=(1)
mp35 (n26 mout VDD NW) g45p1svt w=(310n) l=45n nf=1 m=(1)
mp36 (n20 CKb n26 NW) g45p1svt w=(310n) l=45n nf=1 m=(1)
mp25 (n20 CKbb D0b NW) g45p1svt w=(310n) l=45n nf=1 m=(1)
mp21 (CKbb CKb VDD NW) g45p1svt w=(215n) l=45n nf=1 m=(1)
mp30 (mout n20 VDD NW) g45p1svt w=(310n) l=45n nf=1 m=(1)
mp40 (n30 CKb mout NW) g45p1svt w=(310n) l=45n nf=1 m=(1)
mp10 (S0b S0 VDD NW) g45p1svt w=(215n) l=45n nf=1 m=(1)
mp45 (qbint n30 VDD NW) g45p1svt w=(310n) l=45n nf=1 m=(1)
mp20 (CKb CK VDD NW) g45p1svt w=(215n) l=45n nf=1 m=(1)
ends MDFFHQX2

// gsclib045_backbias/MDFFHQX4/schematic

simulator lang=spectre

subckt MDFFHQX4 CK D0 D1 Q S0 NW VSS VDD
mn13 (n12 D1 VSS VSS) g45n1svt w=(260n) l=45n nf=1 m=(1)
mn14 (D0b S0 n12 VSS) g45n1svt w=(260n) l=45n nf=1 m=(1)
mn12 (D0b S0b n10 VSS) g45n1svt w=(260n) l=45n nf=1 m=(1)
mn11 (n10 D0 VSS VSS) g45n1svt w=(260n) l=45n nf=1 m=(1)
mn55 (Q qbint VSS VSS) g45n1svt w=(1.04u) l=45n nf=1 m=(1)
mn50 (n35 qbint VSS VSS) g45n1svt w=(205n) l=45n nf=1 m=(1)
mn51 (n30 CKb n35 VSS) g45n1svt w=(205n) l=45n nf=1 m=(1)
mn10 (S0b S0 VSS VSS) g45n1svt w=(145n) l=45n nf=1 m=(1)
mn40 (mout CKbb n30 VSS) g45n1svt w=(205n) l=45n nf=1 m=(1)
mn35 (n25 mout VSS VSS) g45n1svt w=(205n) l=45n nf=1 m=(1)
mn36 (n20 CKbb n25 VSS) g45n1svt w=(205n) l=45n nf=1 m=(1)
mn21 (CKbb CKb VSS VSS) g45n1svt w=(145n) l=45n nf=1 m=(1)
mn45 (qbint n30 VSS VSS) g45n1svt w=(410n) l=45n nf=1 m=(1)
mn25 (D0b CKb n20 VSS) g45n1svt w=(205n) l=45n nf=1 m=(1)
mn30 (mout n20 VSS VSS) g45n1svt w=(205n) l=45n nf=1 m=(1)
mn20 (CKb CK VSS VSS) g45n1svt w=(145n) l=45n nf=1 m=(1)
mp14 (D0b S0b n13 NW) g45p1svt w=(390n) l=45n nf=1 m=(1)
mp13 (n13 D1 VDD NW) g45p1svt w=(390n) l=45n nf=1 m=(1)
mp12 (D0b S0 n11 NW) g45p1svt w=(390n) l=45n nf=1 m=(1)
mp11 (n11 D0 VDD NW) g45p1svt w=(390n) l=45n nf=1 m=(1)
mp51 (n30 CKbb n36 NW) g45p1svt w=(310n) l=45n nf=1 m=(1)
mp50 (n36 qbint VDD NW) g45p1svt w=(310n) l=45n nf=1 m=(1)
mp55 (Q qbint VDD NW) g45p1svt w=(1.56u) l=45n nf=1 m=(1)
mp35 (n26 mout VDD NW) g45p1svt w=(310n) l=45n nf=1 m=(1)
mp36 (n20 CKb n26 NW) g45p1svt w=(310n) l=45n nf=1 m=(1)
mp25 (n20 CKbb D0b NW) g45p1svt w=(310n) l=45n nf=1 m=(1)
mp21 (CKbb CKb VDD NW) g45p1svt w=(215n) l=45n nf=1 m=(1)
mp30 (mout n20 VDD NW) g45p1svt w=(310n) l=45n nf=1 m=(1)
mp40 (n30 CKb mout NW) g45p1svt w=(310n) l=45n nf=1 m=(1)
mp10 (S0b S0 VDD NW) g45p1svt w=(215n) l=45n nf=1 m=(1)
mp45 (qbint n30 VDD NW) g45p1svt w=(620n) l=45n nf=1 m=(1)
mp20 (CKb CK VDD NW) g45p1svt w=(215n) l=45n nf=1 m=(1)
ends MDFFHQX4

// gsclib045_backbias/MDFFHQX8/schematic

simulator lang=spectre

subckt MDFFHQX8 CK D0 D1 Q S0 NW VSS VDD
mn13 (n12 D1 VSS VSS) g45n1svt w=(260n) l=45n nf=1 m=(1)
mn14 (D0b S0 n12 VSS) g45n1svt w=(260n) l=45n nf=1 m=(1)
mn12 (D0b S0b n10 VSS) g45n1svt w=(260n) l=45n nf=1 m=(1)
mn11 (n10 D0 VSS VSS) g45n1svt w=(260n) l=45n nf=1 m=(1)
mn55 (Q qbint VSS VSS) g45n1svt w=(2.065u) l=45n nf=1 m=(1)
mn50 (n35 qbint VSS VSS) g45n1svt w=(205n) l=45n nf=1 m=(1)
mn51 (n30 CKb n35 VSS) g45n1svt w=(205n) l=45n nf=1 m=(1)
mn10 (S0b S0 VSS VSS) g45n1svt w=(145n) l=45n nf=1 m=(1)
mn40 (mout CKbb n30 VSS) g45n1svt w=(205n) l=45n nf=1 m=(1)
mn35 (n25 mout VSS VSS) g45n1svt w=(205n) l=45n nf=1 m=(1)
mn36 (n20 CKbb n25 VSS) g45n1svt w=(205n) l=45n nf=1 m=(1)
mn21 (CKbb CKb VSS VSS) g45n1svt w=(145n) l=45n nf=1 m=(1)
mn45 (qbint n30 VSS VSS) g45n1svt w=(780n) l=45n nf=1 m=(1)
mn25 (D0b CKb n20 VSS) g45n1svt w=(205n) l=45n nf=1 m=(1)
mn30 (mout n20 VSS VSS) g45n1svt w=(205n) l=45n nf=1 m=(1)
mn20 (CKb CK VSS VSS) g45n1svt w=(145n) l=45n nf=1 m=(1)
mp14 (D0b S0b n13 NW) g45p1svt w=(390n) l=45n nf=1 m=(1)
mp13 (n13 D1 VDD NW) g45p1svt w=(390n) l=45n nf=1 m=(1)
mp12 (D0b S0 n11 NW) g45p1svt w=(390n) l=45n nf=1 m=(1)
mp11 (n11 D0 VDD NW) g45p1svt w=(390n) l=45n nf=1 m=(1)
mp51 (n30 CKbb n36 NW) g45p1svt w=(310n) l=45n nf=1 m=(1)
mp50 (n36 qbint VDD NW) g45p1svt w=(310n) l=45n nf=1 m=(1)
mp55 (Q qbint VDD NW) g45p1svt w=(3.115u) l=45n nf=1 m=(1)
mp35 (n26 mout VDD NW) g45p1svt w=(310n) l=45n nf=1 m=(1)
mp36 (n20 CKb n26 NW) g45p1svt w=(310n) l=45n nf=1 m=(1)
mp25 (n20 CKbb D0b NW) g45p1svt w=(310n) l=45n nf=1 m=(1)
mp21 (CKbb CKb VDD NW) g45p1svt w=(215n) l=45n nf=1 m=(1)
mp30 (mout n20 VDD NW) g45p1svt w=(310n) l=45n nf=1 m=(1)
mp40 (n30 CKb mout NW) g45p1svt w=(310n) l=45n nf=1 m=(1)
mp10 (S0b S0 VDD NW) g45p1svt w=(215n) l=45n nf=1 m=(1)
mp45 (qbint n30 VDD NW) g45p1svt w=(1.17u) l=45n nf=1 m=(1)
mp20 (CKb CK VDD NW) g45p1svt w=(215n) l=45n nf=1 m=(1)
ends MDFFHQX8

// gsclib045_backbias/SDFFHQX1/schematic

simulator lang=spectre

subckt SDFFHQX1 CK D Q SE SI VDD NW VSS
mn13 (net411 SI VSS VSS) g45n1svt w=(260n) l=45n nf=1 m=(1)
mn14 (Db SE net411 VSS) g45n1svt w=(260n) l=45n nf=1 m=(1)
mn12 (Db SEb net399 VSS) g45n1svt w=(260n) l=45n nf=1 m=(1)
mn11 (net399 D VSS VSS) g45n1svt w=(260n) l=45n nf=1 m=(1)
mn55 (Q qbint VSS VSS) g45n1svt w=(260n) l=45n nf=1 m=(1)
mn50 (net391 qbint VSS VSS) g45n1svt w=(205n) l=45n nf=1 m=(1)
mn10 (SEb SE VSS VSS) g45n1svt w=(145n) l=45n nf=1 m=(1)
mn40 (mout CKbb n30 VSS) g45n1svt w=(205n) l=45n nf=1 m=(1)
mn35 (net378 mout VSS VSS) g45n1svt w=(205n) l=45n nf=1 m=(1)
mn36 (n20 CKbb net378 VSS) g45n1svt w=(205n) l=45n nf=1 m=(1)
mn20 (CKb CK VSS VSS) g45n1svt w=(145n) l=45n nf=1 m=(1)
mn51 (n30 CKb net391 VSS) g45n1svt w=(205n) l=45n nf=1 m=(1)
mn21 (CKbb CKb VSS VSS) g45n1svt w=(145n) l=45n nf=1 m=(1)
mn45 (qbint n30 VSS VSS) g45n1svt w=(205n) l=45n nf=1 m=(1)
mn25 (n20 CKb Db VSS) g45n1svt w=(205n) l=45n nf=1 m=(1)
mn30 (mout n20 VSS VSS) g45n1svt w=(205n) l=45n nf=1 m=(1)
mp14 (Db SEb net350 NW) g45p1svt w=(390n) l=45n nf=1 m=(1)
mp13 (net350 SI VDD NW) g45p1svt w=(390n) l=45n nf=1 m=(1)
mp12 (Db SE net342 NW) g45p1svt w=(390n) l=45n nf=1 m=(1)
mp11 (net342 D VDD NW) g45p1svt w=(390n) l=45n nf=1 m=(1)
mp51 (n30 CKbb net334 NW) g45p1svt w=(310n) l=45n nf=1 m=(1)
mp50 (net334 qbint VDD NW) g45p1svt w=(310n) l=45n nf=1 m=(1)
mp55 (Q qbint VDD NW) g45p1svt w=(390n) l=45n nf=1 m=(1)
mp35 (net319 mout VDD NW) g45p1svt w=(310n) l=45n nf=1 m=(1)
mp25 (Db CKbb n20 NW) g45p1svt w=(310n) l=45n nf=1 m=(1)
mp21 (CKbb CKb VDD NW) g45p1svt w=(215n) l=45n nf=1 m=(1)
mp30 (mout n20 VDD NW) g45p1svt w=(310n) l=45n nf=1 m=(1)
mp36 (n20 CKb net319 NW) g45p1svt w=(310n) l=45n nf=1 m=(1)
mp40 (n30 CKb mout NW) g45p1svt w=(310n) l=45n nf=1 m=(1)
mp10 (SEb SE VDD NW) g45p1svt w=(215n) l=45n nf=1 m=(1)
mp45 (qbint n30 VDD NW) g45p1svt w=(310n) l=45n nf=1 m=(1)
mp20 (CKb CK VDD NW) g45p1svt w=(215n) l=45n nf=1 m=(1)
ends SDFFHQX1

// gsclib045_backbias/SDFFHQX2/schematic

simulator lang=spectre

subckt SDFFHQX2 CK D Q SE SI VDD VSS NW
mn13 (net411 SI VSS VSS) g45n1svt w=(260n) l=45n nf=1 m=(1)
mn14 (Db SE net411 VSS) g45n1svt w=(260n) l=45n nf=1 m=(1)
mn12 (Db SEb net399 VSS) g45n1svt w=(260n) l=45n nf=1 m=(1)
mn11 (net399 D VSS VSS) g45n1svt w=(260n) l=45n nf=1 m=(1)
mn55 (Q qbint VSS VSS) g45n1svt w=(520n) l=45n nf=1 m=(1)
mn50 (net391 qbint VSS VSS) g45n1svt w=(205n) l=45n nf=1 m=(1)
mn10 (SEb SE VSS VSS) g45n1svt w=(145n) l=45n nf=1 m=(1)
mn40 (mout CKbb n30 VSS) g45n1svt w=(205n) l=45n nf=1 m=(1)
mn35 (net378 mout VSS VSS) g45n1svt w=(205n) l=45n nf=1 m=(1)
mn36 (n20 CKbb net378 VSS) g45n1svt w=(205n) l=45n nf=1 m=(1)
mn20 (CKb CK VSS VSS) g45n1svt w=(145n) l=45n nf=1 m=(1)
mn51 (n30 CKb net391 VSS) g45n1svt w=(205n) l=45n nf=1 m=(1)
mn21 (CKbb CKb VSS VSS) g45n1svt w=(145n) l=45n nf=1 m=(1)
mn45 (qbint n30 VSS VSS) g45n1svt w=(205n) l=45n nf=1 m=(1)
mn25 (n20 CKb Db VSS) g45n1svt w=(205n) l=45n nf=1 m=(1)
mn30 (mout n20 VSS VSS) g45n1svt w=(205n) l=45n nf=1 m=(1)
mp14 (Db SEb net350 NW) g45p1svt w=(390n) l=45n nf=1 m=(1)
mp13 (net350 SI VDD NW) g45p1svt w=(390n) l=45n nf=1 m=(1)
mp12 (Db SE net342 NW) g45p1svt w=(390n) l=45n nf=1 m=(1)
mp11 (net342 D VDD NW) g45p1svt w=(390n) l=45n nf=1 m=(1)
mp51 (n30 CKbb net334 NW) g45p1svt w=(310n) l=45n nf=1 m=(1)
mp50 (net334 qbint VDD NW) g45p1svt w=(310n) l=45n nf=1 m=(1)
mp55 (Q qbint VDD NW) g45p1svt w=(780n) l=45n nf=1 m=(1)
mp35 (net319 mout VDD NW) g45p1svt w=(310n) l=45n nf=1 m=(1)
mp25 (Db CKbb n20 NW) g45p1svt w=(310n) l=45n nf=1 m=(1)
mp21 (CKbb CKb VDD NW) g45p1svt w=(215n) l=45n nf=1 m=(1)
mp30 (mout n20 VDD NW) g45p1svt w=(310n) l=45n nf=1 m=(1)
mp36 (n20 CKb net319 NW) g45p1svt w=(310n) l=45n nf=1 m=(1)
mp40 (n30 CKb mout NW) g45p1svt w=(310n) l=45n nf=1 m=(1)
mp10 (SEb SE VDD NW) g45p1svt w=(215n) l=45n nf=1 m=(1)
mp45 (qbint n30 VDD NW) g45p1svt w=(310n) l=45n nf=1 m=(1)
mp20 (CKb CK VDD NW) g45p1svt w=(215n) l=45n nf=1 m=(1)
ends SDFFHQX2

// gsclib045_backbias/SDFFHQX4/schematic

simulator lang=spectre

subckt SDFFHQX4 CK D Q SE SI VDD VSS NW
mn13 (net411 SI VSS VSS) g45n1svt w=(260n) l=45n nf=1 m=(1)
mn14 (Db SE net411 VSS) g45n1svt w=(260n) l=45n nf=1 m=(1)
mn12 (Db SEb net399 VSS) g45n1svt w=(260n) l=45n nf=1 m=(1)
mn11 (net399 D VSS VSS) g45n1svt w=(260n) l=45n nf=1 m=(1)
mn55 (Q qbint VSS VSS) g45n1svt w=(1.04u) l=45n nf=1 m=(1)
mn50 (net391 qbint VSS VSS) g45n1svt w=(205n) l=45n nf=1 m=(1)
mn10 (SEb SE VSS VSS) g45n1svt w=(145n) l=45n nf=1 m=(1)
mn40 (mout CKbb n30 VSS) g45n1svt w=(205n) l=45n nf=1 m=(1)
mn35 (net378 mout VSS VSS) g45n1svt w=(205n) l=45n nf=1 m=(1)
mn36 (n20 CKbb net378 VSS) g45n1svt w=(205n) l=45n nf=1 m=(1)
mn20 (CKb CK VSS VSS) g45n1svt w=(145n) l=45n nf=1 m=(1)
mn51 (n30 CKb net391 VSS) g45n1svt w=(205n) l=45n nf=1 m=(1)
mn21 (CKbb CKb VSS VSS) g45n1svt w=(145n) l=45n nf=1 m=(1)
mn45 (qbint n30 VSS VSS) g45n1svt w=(410n) l=45n nf=1 m=(1)
mn25 (n20 CKb Db VSS) g45n1svt w=(205n) l=45n nf=1 m=(1)
mn30 (mout n20 VSS VSS) g45n1svt w=(205n) l=45n nf=1 m=(1)
mp14 (Db SEb net350 NW) g45p1svt w=(390n) l=45n nf=1 m=(1)
mp13 (net350 SI VDD NW) g45p1svt w=(390n) l=45n nf=1 m=(1)
mp12 (Db SE net342 NW) g45p1svt w=(390n) l=45n nf=1 m=(1)
mp11 (net342 D VDD NW) g45p1svt w=(390n) l=45n nf=1 m=(1)
mp51 (n30 CKbb net334 NW) g45p1svt w=(310n) l=45n nf=1 m=(1)
mp50 (net334 qbint VDD NW) g45p1svt w=(310n) l=45n nf=1 m=(1)
mp55 (Q qbint VDD NW) g45p1svt w=(1.56u) l=45n nf=1 m=(1)
mp35 (net319 mout VDD NW) g45p1svt w=(310n) l=45n nf=1 m=(1)
mp25 (Db CKbb n20 NW) g45p1svt w=(310n) l=45n nf=1 m=(1)
mp21 (CKbb CKb VDD NW) g45p1svt w=(215n) l=45n nf=1 m=(1)
mp30 (mout n20 VDD NW) g45p1svt w=(310n) l=45n nf=1 m=(1)
mp36 (n20 CKb net319 NW) g45p1svt w=(310n) l=45n nf=1 m=(1)
mp40 (n30 CKb mout NW) g45p1svt w=(310n) l=45n nf=1 m=(1)
mp10 (SEb SE VDD NW) g45p1svt w=(215n) l=45n nf=1 m=(1)
mp45 (qbint n30 VDD NW) g45p1svt w=(620n) l=45n nf=1 m=(1)
mp20 (CKb CK VDD NW) g45p1svt w=(215n) l=45n nf=1 m=(1)
ends SDFFHQX4

// gsclib045_backbias/SDFFHQX8/schematic

simulator lang=spectre

subckt SDFFHQX8 CK D Q SE SI VDD VSS NW
mn13 (net411 SI VSS VSS) g45n1svt w=(260n) l=45n nf=1 m=(1)
mn14 (Db SE net411 VSS) g45n1svt w=(260n) l=45n nf=1 m=(1)
mn12 (Db SEb net399 VSS) g45n1svt w=(260n) l=45n nf=1 m=(1)
mn11 (net399 D VSS VSS) g45n1svt w=(260n) l=45n nf=1 m=(1)
mn55 (Q qbint VSS VSS) g45n1svt w=(2.065u) l=45n nf=1 m=(1)
mn50 (net391 qbint VSS VSS) g45n1svt w=(205n) l=45n nf=1 m=(1)
mn10 (SEb SE VSS VSS) g45n1svt w=(145n) l=45n nf=1 m=(1)
mn40 (mout CKbb n30 VSS) g45n1svt w=(205n) l=45n nf=1 m=(1)
mn35 (net378 mout VSS VSS) g45n1svt w=(205n) l=45n nf=1 m=(1)
mn36 (n20 CKbb net378 VSS) g45n1svt w=(205n) l=45n nf=1 m=(1)
mn20 (CKb CK VSS VSS) g45n1svt w=(145n) l=45n nf=1 m=(1)
mn51 (n30 CKb net391 VSS) g45n1svt w=(205n) l=45n nf=1 m=(1)
mn21 (CKbb CKb VSS VSS) g45n1svt w=(145n) l=45n nf=1 m=(1)
mn45 (qbint n30 VSS VSS) g45n1svt w=(780n) l=45n nf=1 m=(1)
mn25 (n20 CKb Db VSS) g45n1svt w=(205n) l=45n nf=1 m=(1)
mn30 (mout n20 VSS VSS) g45n1svt w=(205n) l=45n nf=1 m=(1)
mp14 (Db SEb net350 NW) g45p1svt w=(390n) l=45n nf=1 m=(1)
mp13 (net350 SI VDD NW) g45p1svt w=(390n) l=45n nf=1 m=(1)
mp12 (Db SE net342 NW) g45p1svt w=(390n) l=45n nf=1 m=(1)
mp11 (net342 D VDD NW) g45p1svt w=(390n) l=45n nf=1 m=(1)
mp51 (n30 CKbb net334 NW) g45p1svt w=(310n) l=45n nf=1 m=(1)
mp50 (net334 qbint VDD NW) g45p1svt w=(310n) l=45n nf=1 m=(1)
mp55 (Q qbint VDD NW) g45p1svt w=(3.115u) l=45n nf=1 m=(1)
mp35 (net319 mout VDD NW) g45p1svt w=(310n) l=45n nf=1 m=(1)
mp25 (Db CKbb n20 NW) g45p1svt w=(310n) l=45n nf=1 m=(1)
mp21 (CKbb CKb VDD NW) g45p1svt w=(215n) l=45n nf=1 m=(1)
mp30 (mout n20 VDD NW) g45p1svt w=(310n) l=45n nf=1 m=(1)
mp36 (n20 CKb net319 NW) g45p1svt w=(310n) l=45n nf=1 m=(1)
mp40 (n30 CKb mout NW) g45p1svt w=(310n) l=45n nf=1 m=(1)
mp10 (SEb SE VDD NW) g45p1svt w=(215n) l=45n nf=1 m=(1)
mp45 (qbint n30 VDD NW) g45p1svt w=(1.17u) l=45n nf=1 m=(1)
mp20 (CKb CK VDD NW) g45p1svt w=(215n) l=45n nf=1 m=(1)
ends SDFFHQX8

// gsclib045_backbias/SDFFNSRX1/schematic

simulator lang=spectre

subckt SDFFNSRX1 CKN D Q QN RN SE SI SN VSS VDD NW
mn13 (net538 SI VSS VSS) g45n1svt w=(145n) l=45n nf=1 m=(1)
mn14 (Db SE net538 VSS) g45n1svt w=(145n) l=45n nf=1 m=(1)
mn12 (Db SEb net546 VSS) g45n1svt w=(145n) l=45n nf=1 m=(1)
mn11 (net546 D VSS VSS) g45n1svt w=(145n) l=45n nf=1 m=(1)
mn57 (QN qint VSS VSS) g45n1svt w=(260n) l=45n nf=1 m=(1)
mn55 (Q qbint VSS VSS) g45n1svt w=(260n) l=45n nf=1 m=(1)
mn36 (n20 CKNb net582 VSS) g45n1svt w=(145n) l=45n nf=1 m=(1)
mn35 (net582 mout VSS VSS) g45n1svt w=(145n) l=45n nf=1 m=(1)
mn22 (RNb RN VSS VSS) g45n1svt w=(145n) l=45n nf=1 m=(1)
mn20 (CKNb CKN VSS VSS) g45n1svt w=(145n) l=45n nf=1 m=(1)
mn10 (SEb SE VSS VSS) g45n1svt w=(145n) l=45n nf=1 m=(1)
mn31 (mout RNb net521 VSS) g45n1svt w=(145n) l=45n nf=1 m=(1)
mn51 (net0363 RNb net498 VSS) g45n1svt w=(145n) l=45n nf=1 m=(1)
mn25 (Db CKNbb n20 VSS) g45n1svt w=(145n) l=45n nf=1 m=(1)
mn30 (net521 SN VSS VSS) g45n1svt w=(145n) l=45n nf=1 m=(1)
mn21 (CKNbb CKNb VSS VSS) g45n1svt w=(145n) l=45n nf=1 m=(1)
mn45 (qbint n35 VSS VSS) g45n1svt w=(145n) l=45n nf=1 m=(1)
mn50 (net498 SN VSS VSS) g45n1svt w=(145n) l=45n nf=1 m=(1)
mn32 (mout n20 net521 VSS) g45n1svt w=(145n) l=45n nf=1 m=(1)
mn56 (qint qbint VSS VSS) g45n1svt w=(145n) l=45n nf=1 m=(1)
mn53 (n35 CKNbb net0363 VSS) g45n1svt w=(145n) l=45n nf=1 m=(1)
mn52 (net0363 qbint net498 VSS) g45n1svt w=(145n) l=45n nf=1 m=(1)
mn40 (mout CKNb n35 VSS) g45n1svt w=(145n) l=45n nf=1 m=(1)
mp14 (Db SEb net453 NW) g45p1svt w=(215n) l=45n nf=1 m=(1)
mp13 (net453 SI VDD NW) g45p1svt w=(215n) l=45n nf=1 m=(1)
mp12 (Db SE net461 NW) g45p1svt w=(215n) l=45n nf=1 m=(1)
mp11 (net461 D VDD NW) g45p1svt w=(215n) l=45n nf=1 m=(1)
mp52 (net566 qbint net414 NW) g45p1svt w=(215n) l=45n nf=1 m=(1)
mp51 (net414 RNb VDD NW) g45p1svt w=(215n) l=45n nf=1 m=(1)
mp57 (QN qint VDD NW) g45p1svt w=(390n) l=45n nf=1 m=(1)
mp55 (Q qbint VDD NW) g45p1svt w=(390n) l=45n nf=1 m=(1)
mp36 (n20 CKNbb net486 NW) g45p1svt w=(215n) l=45n nf=1 m=(1)
mp35 (net486 mout VDD NW) g45p1svt w=(215n) l=45n nf=1 m=(1)
mp32 (mout n20 net478 NW) g45p1svt w=(215n) l=45n nf=1 m=(1)
mp31 (net478 RNb VDD NW) g45p1svt w=(215n) l=45n nf=1 m=(1)
mp22 (RNb RN VDD NW) g45p1svt w=(215n) l=45n nf=1 m=(1)
mp20 (CKNb CKN VDD NW) g45p1svt w=(215n) l=45n nf=1 m=(1)
mp53 (n35 CKNb net566 NW) g45p1svt w=(215n) l=45n nf=1 m=(1)
mp56 (qint qbint VDD NW) g45p1svt w=(215n) l=45n nf=1 m=(1)
mp21 (CKNbb CKNb VDD NW) g45p1svt w=(215n) l=45n nf=1 m=(1)
mp25 (n20 CKNb Db NW) g45p1svt w=(215n) l=45n nf=1 m=(1)
mp50 (net566 SN VDD NW) g45p1svt w=(215n) l=45n nf=1 m=(1)
mp10 (SEb SE VDD NW) g45p1svt w=(215n) l=45n nf=1 m=(1)
mp45 (qbint n35 VDD NW) g45p1svt w=(215n) l=45n nf=1 m=(1)
mp40 (n35 CKNbb mout NW) g45p1svt w=(215n) l=45n nf=1 m=(1)
mp30 (mout SN VDD NW) g45p1svt w=(215n) l=45n nf=1 m=(1)
ends SDFFNSRX1

// gsclib045_backbias/SDFFNSRX2/schematic

simulator lang=spectre

subckt SDFFNSRX2 CKN D Q QN RN SE SI SN VSS VDD NW
mn13 (net538 SI VSS VSS) g45n1svt w=(145n) l=45n nf=1 m=(1)
mn14 (Db SE net538 VSS) g45n1svt w=(145n) l=45n nf=1 m=(1)
mn12 (Db SEb net546 VSS) g45n1svt w=(145n) l=45n nf=1 m=(1)
mn11 (net546 D VSS VSS) g45n1svt w=(145n) l=45n nf=1 m=(1)
mn57 (QN qint VSS VSS) g45n1svt w=(520n) l=45n nf=1 m=(1)
mn55 (Q qbint VSS VSS) g45n1svt w=(520n) l=45n nf=1 m=(1)
mn36 (n20 CKNb net582 VSS) g45n1svt w=(145n) l=45n nf=1 m=(1)
mn35 (net582 mout VSS VSS) g45n1svt w=(145n) l=45n nf=1 m=(1)
mn22 (RNb RN VSS VSS) g45n1svt w=(145n) l=45n nf=1 m=(1)
mn20 (CKNb CKN VSS VSS) g45n1svt w=(145n) l=45n nf=1 m=(1)
mn10 (SEb SE VSS VSS) g45n1svt w=(145n) l=45n nf=1 m=(1)
mn31 (mout RNb net521 VSS) g45n1svt w=(145n) l=45n nf=1 m=(1)
mn51 (net0363 RNb net498 VSS) g45n1svt w=(145n) l=45n nf=1 m=(1)
mn25 (Db CKNbb n20 VSS) g45n1svt w=(145n) l=45n nf=1 m=(1)
mn30 (net521 SN VSS VSS) g45n1svt w=(145n) l=45n nf=1 m=(1)
mn21 (CKNbb CKNb VSS VSS) g45n1svt w=(145n) l=45n nf=1 m=(1)
mn45 (qbint n35 VSS VSS) g45n1svt w=(205n) l=45n nf=1 m=(1)
mn50 (net498 SN VSS VSS) g45n1svt w=(145n) l=45n nf=1 m=(1)
mn32 (mout n20 net521 VSS) g45n1svt w=(145n) l=45n nf=1 m=(1)
mn56 (qint qbint VSS VSS) g45n1svt w=(145n) l=45n nf=1 m=(1)
mn53 (n35 CKNbb net0363 VSS) g45n1svt w=(145n) l=45n nf=1 m=(1)
mn52 (net0363 qbint net498 VSS) g45n1svt w=(145n) l=45n nf=1 m=(1)
mn40 (mout CKNb n35 VSS) g45n1svt w=(145n) l=45n nf=1 m=(1)
mp14 (Db SEb net453 NW) g45p1svt w=(215n) l=45n nf=1 m=(1)
mp13 (net453 SI VDD NW) g45p1svt w=(215n) l=45n nf=1 m=(1)
mp12 (Db SE net461 NW) g45p1svt w=(215n) l=45n nf=1 m=(1)
mp11 (net461 D VDD NW) g45p1svt w=(215n) l=45n nf=1 m=(1)
mp52 (net566 qbint net414 NW) g45p1svt w=(215n) l=45n nf=1 m=(1)
mp51 (net414 RNb VDD NW) g45p1svt w=(215n) l=45n nf=1 m=(1)
mp57 (QN qint VDD NW) g45p1svt w=(780n) l=45n nf=1 m=(1)
mp55 (Q qbint VDD NW) g45p1svt w=(780n) l=45n nf=1 m=(1)
mp36 (n20 CKNbb net486 NW) g45p1svt w=(215n) l=45n nf=1 m=(1)
mp35 (net486 mout VDD NW) g45p1svt w=(215n) l=45n nf=1 m=(1)
mp32 (mout n20 net478 NW) g45p1svt w=(215n) l=45n nf=1 m=(1)
mp31 (net478 RNb VDD NW) g45p1svt w=(215n) l=45n nf=1 m=(1)
mp22 (RNb RN VDD NW) g45p1svt w=(215n) l=45n nf=1 m=(1)
mp20 (CKNb CKN VDD NW) g45p1svt w=(215n) l=45n nf=1 m=(1)
mp53 (n35 CKNb net566 NW) g45p1svt w=(215n) l=45n nf=1 m=(1)
mp56 (qint qbint VDD NW) g45p1svt w=(215n) l=45n nf=1 m=(1)
mp21 (CKNbb CKNb VDD NW) g45p1svt w=(215n) l=45n nf=1 m=(1)
mp25 (n20 CKNb Db NW) g45p1svt w=(215n) l=45n nf=1 m=(1)
mp50 (net566 SN VDD NW) g45p1svt w=(215n) l=45n nf=1 m=(1)
mp10 (SEb SE VDD NW) g45p1svt w=(215n) l=45n nf=1 m=(1)
mp45 (qbint n35 VDD NW) g45p1svt w=(310n) l=45n nf=1 m=(1)
mp40 (n35 CKNbb mout NW) g45p1svt w=(215n) l=45n nf=1 m=(1)
mp30 (mout SN VDD NW) g45p1svt w=(215n) l=45n nf=1 m=(1)
ends SDFFNSRX2

// gsclib045_backbias/SDFFNSRX4/schematic

simulator lang=spectre

subckt SDFFNSRX4 CKN D Q QN RN SE SI SN NW VSS VDD
mn13 (net538 SI VSS VSS) g45n1svt w=(145n) l=45n nf=1 m=(1)
mn14 (Db SE net538 VSS) g45n1svt w=(145n) l=45n nf=1 m=(1)
mn12 (Db SEb net546 VSS) g45n1svt w=(145n) l=45n nf=1 m=(1)
mn11 (net546 D VSS VSS) g45n1svt w=(145n) l=45n nf=1 m=(1)
mn57 (QN qint VSS VSS) g45n1svt w=(1.04u) l=45n nf=1 m=(1)
mn55 (Q qbint VSS VSS) g45n1svt w=(1.04u) l=45n nf=1 m=(1)
mn36 (n20 CKNb net582 VSS) g45n1svt w=(145n) l=45n nf=1 m=(1)
mn35 (net582 mout VSS VSS) g45n1svt w=(145n) l=45n nf=1 m=(1)
mn22 (RNb RN VSS VSS) g45n1svt w=(145n) l=45n nf=1 m=(1)
mn20 (CKNb CKN VSS VSS) g45n1svt w=(145n) l=45n nf=1 m=(1)
mn10 (SEb SE VSS VSS) g45n1svt w=(145n) l=45n nf=1 m=(1)
mn31 (mout RNb net521 VSS) g45n1svt w=(145n) l=45n nf=1 m=(1)
mn51 (net0363 RNb net498 VSS) g45n1svt w=(145n) l=45n nf=1 m=(1)
mn25 (Db CKNbb n20 VSS) g45n1svt w=(145n) l=45n nf=1 m=(1)
mn30 (net521 SN VSS VSS) g45n1svt w=(145n) l=45n nf=1 m=(1)
mn21 (CKNbb CKNb VSS VSS) g45n1svt w=(145n) l=45n nf=1 m=(1)
mn45 (qbint n35 VSS VSS) g45n1svt w=(410n) l=45n nf=1 m=(1)
mn50 (net498 SN VSS VSS) g45n1svt w=(145n) l=45n nf=1 m=(1)
mn32 (mout n20 net521 VSS) g45n1svt w=(145n) l=45n nf=1 m=(1)
mn56 (qint qbint VSS VSS) g45n1svt w=(260n) l=45n nf=1 m=(1)
mn53 (n35 CKNbb net0363 VSS) g45n1svt w=(145n) l=45n nf=1 m=(1)
mn52 (net0363 qbint net498 VSS) g45n1svt w=(145n) l=45n nf=1 m=(1)
mn40 (mout CKNb n35 VSS) g45n1svt w=(145n) l=45n nf=1 m=(1)
mp14 (Db SEb net453 NW) g45p1svt w=(215n) l=45n nf=1 m=(1)
mp13 (net453 SI VDD NW) g45p1svt w=(215n) l=45n nf=1 m=(1)
mp12 (Db SE net461 NW) g45p1svt w=(215n) l=45n nf=1 m=(1)
mp11 (net461 D VDD NW) g45p1svt w=(215n) l=45n nf=1 m=(1)
mp52 (net566 qbint net414 NW) g45p1svt w=(215n) l=45n nf=1 m=(1)
mp51 (net414 RNb VDD NW) g45p1svt w=(215n) l=45n nf=1 m=(1)
mp57 (QN qint VDD NW) g45p1svt w=(1.56u) l=45n nf=1 m=(1)
mp55 (Q qbint VDD NW) g45p1svt w=(1.56u) l=45n nf=1 m=(1)
mp36 (n20 CKNbb net486 NW) g45p1svt w=(215n) l=45n nf=1 m=(1)
mp35 (net486 mout VDD NW) g45p1svt w=(215n) l=45n nf=1 m=(1)
mp32 (mout n20 net478 NW) g45p1svt w=(215n) l=45n nf=1 m=(1)
mp31 (net478 RNb VDD NW) g45p1svt w=(215n) l=45n nf=1 m=(1)
mp22 (RNb RN VDD NW) g45p1svt w=(215n) l=45n nf=1 m=(1)
mp20 (CKNb CKN VDD NW) g45p1svt w=(215n) l=45n nf=1 m=(1)
mp53 (n35 CKNb net566 NW) g45p1svt w=(215n) l=45n nf=1 m=(1)
mp56 (qint qbint VDD NW) g45p1svt w=(390n) l=45n nf=1 m=(1)
mp21 (CKNbb CKNb VDD NW) g45p1svt w=(215n) l=45n nf=1 m=(1)
mp25 (n20 CKNb Db NW) g45p1svt w=(215n) l=45n nf=1 m=(1)
mp50 (net566 SN VDD NW) g45p1svt w=(215n) l=45n nf=1 m=(1)
mp10 (SEb SE VDD NW) g45p1svt w=(215n) l=45n nf=1 m=(1)
mp45 (qbint n35 VDD NW) g45p1svt w=(620n) l=45n nf=1 m=(1)
mp40 (n35 CKNbb mout NW) g45p1svt w=(215n) l=45n nf=1 m=(1)
mp30 (mout SN VDD NW) g45p1svt w=(215n) l=45n nf=1 m=(1)
ends SDFFNSRX4

// gsclib045_backbias/SDFFNSRXL/schematic

simulator lang=spectre

subckt SDFFNSRXL CKN D Q QN RN SE SI SN VSS VDD NW
mn13 (net538 SI VSS VSS) g45n1svt w=(145n) l=45n nf=1 m=(1)
mn14 (Db SE net538 VSS) g45n1svt w=(145n) l=45n nf=1 m=(1)
mn12 (Db SEb net546 VSS) g45n1svt w=(145n) l=45n nf=1 m=(1)
mn11 (net546 D VSS VSS) g45n1svt w=(145n) l=45n nf=1 m=(1)
mn57 (QN qint VSS VSS) g45n1svt w=(145n) l=45n nf=1 m=(1)
mn55 (Q qbint VSS VSS) g45n1svt w=(145n) l=45n nf=1 m=(1)
mn36 (n20 CKNb net582 VSS) g45n1svt w=(145n) l=45n nf=1 m=(1)
mn35 (net582 mout VSS VSS) g45n1svt w=(145n) l=45n nf=1 m=(1)
mn22 (RNb RN VSS VSS) g45n1svt w=(145n) l=45n nf=1 m=(1)
mn20 (CKNb CKN VSS VSS) g45n1svt w=(145n) l=45n nf=1 m=(1)
mn10 (SEb SE VSS VSS) g45n1svt w=(145n) l=45n nf=1 m=(1)
mn31 (mout RNb net521 VSS) g45n1svt w=(145n) l=45n nf=1 m=(1)
mn51 (net0363 RNb net498 VSS) g45n1svt w=(145n) l=45n nf=1 m=(1)
mn25 (Db CKNbb n20 VSS) g45n1svt w=(145n) l=45n nf=1 m=(1)
mn30 (net521 SN VSS VSS) g45n1svt w=(145n) l=45n nf=1 m=(1)
mn21 (CKNbb CKNb VSS VSS) g45n1svt w=(145n) l=45n nf=1 m=(1)
mn45 (qbint n35 VSS VSS) g45n1svt w=(145n) l=45n nf=1 m=(1)
mn50 (net498 SN VSS VSS) g45n1svt w=(145n) l=45n nf=1 m=(1)
mn32 (mout n20 net521 VSS) g45n1svt w=(145n) l=45n nf=1 m=(1)
mn56 (qint qbint VSS VSS) g45n1svt w=(145n) l=45n nf=1 m=(1)
mn53 (n35 CKNbb net0363 VSS) g45n1svt w=(145n) l=45n nf=1 m=(1)
mn52 (net0363 qbint net498 VSS) g45n1svt w=(145n) l=45n nf=1 m=(1)
mn40 (mout CKNb n35 VSS) g45n1svt w=(145n) l=45n nf=1 m=(1)
mp14 (Db SEb net453 NW) g45p1svt w=(215n) l=45n nf=1 m=(1)
mp13 (net453 SI VDD NW) g45p1svt w=(215n) l=45n nf=1 m=(1)
mp12 (Db SE net461 NW) g45p1svt w=(215n) l=45n nf=1 m=(1)
mp11 (net461 D VDD NW) g45p1svt w=(215n) l=45n nf=1 m=(1)
mp52 (net566 qbint net414 NW) g45p1svt w=(215n) l=45n nf=1 m=(1)
mp51 (net414 RNb VDD NW) g45p1svt w=(215n) l=45n nf=1 m=(1)
mp57 (QN qint VDD NW) g45p1svt w=(215n) l=45n nf=1 m=(1)
mp55 (Q qbint VDD NW) g45p1svt w=(215n) l=45n nf=1 m=(1)
mp36 (n20 CKNbb net486 NW) g45p1svt w=(215n) l=45n nf=1 m=(1)
mp35 (net486 mout VDD NW) g45p1svt w=(215n) l=45n nf=1 m=(1)
mp32 (mout n20 net478 NW) g45p1svt w=(215n) l=45n nf=1 m=(1)
mp31 (net478 RNb VDD NW) g45p1svt w=(215n) l=45n nf=1 m=(1)
mp22 (RNb RN VDD NW) g45p1svt w=(215n) l=45n nf=1 m=(1)
mp20 (CKNb CKN VDD NW) g45p1svt w=(215n) l=45n nf=1 m=(1)
mp53 (n35 CKNb net566 NW) g45p1svt w=(215n) l=45n nf=1 m=(1)
mp56 (qint qbint VDD NW) g45p1svt w=(215n) l=45n nf=1 m=(1)
mp21 (CKNbb CKNb VDD NW) g45p1svt w=(215n) l=45n nf=1 m=(1)
mp25 (n20 CKNb Db NW) g45p1svt w=(215n) l=45n nf=1 m=(1)
mp50 (net566 SN VDD NW) g45p1svt w=(215n) l=45n nf=1 m=(1)
mp10 (SEb SE VDD NW) g45p1svt w=(215n) l=45n nf=1 m=(1)
mp45 (qbint n35 VDD NW) g45p1svt w=(215n) l=45n nf=1 m=(1)
mp40 (n35 CKNbb mout NW) g45p1svt w=(215n) l=45n nf=1 m=(1)
mp30 (mout SN VDD NW) g45p1svt w=(215n) l=45n nf=1 m=(1)
ends SDFFNSRXL

// gsclib045_backbias/SDFFQX1/schematic

simulator lang=spectre

subckt SDFFQX1 CK D Q SE SI NW VSS VDD
mn13 (n3 SI VSS VSS) g45n1svt w=(145n) l=45n nf=1 m=(1)
mn14 (Db SE n3 VSS) g45n1svt w=(145n) l=45n nf=1 m=(1)
mn12 (Db SEb n1 VSS) g45n1svt w=(145n) l=45n nf=1 m=(1)
mn11 (n1 D VSS VSS) g45n1svt w=(145n) l=45n nf=1 m=(1)
mn55 (Q qbint VSS VSS) g45n1svt w=(260n) l=45n nf=1 m=(1)
mn50 (n7 qbint VSS VSS) g45n1svt w=(145n) l=45n nf=1 m=(1)
mn10 (SEb SE VSS VSS) g45n1svt w=(145n) l=45n nf=1 m=(1)
mn40 (mout CKbb n30 VSS) g45n1svt w=(145n) l=45n nf=1 m=(1)
mn35 (n20 CKbb n5 VSS) g45n1svt w=(145n) l=45n nf=1 m=(1)
mn36 (n5 mout VSS VSS) g45n1svt w=(145n) l=45n nf=1 m=(1)
mn20 (CKb CK VSS VSS) g45n1svt w=(145n) l=45n nf=1 m=(1)
mn51 (n30 CKb n7 VSS) g45n1svt w=(145n) l=45n nf=1 m=(1)
mn21 (CKbb CKb VSS VSS) g45n1svt w=(145n) l=45n nf=1 m=(1)
mn45 (qbint n30 VSS VSS) g45n1svt w=(145n) l=45n nf=1 m=(1)
mn25 (Db CKb n20 VSS) g45n1svt w=(145n) l=45n nf=1 m=(1)
mn30 (mout n20 VSS VSS) g45n1svt w=(145n) l=45n nf=1 m=(1)
mp14 (Db SEb n4 NW) g45p1svt w=(215n) l=45n nf=1 m=(1)
mp13 (n4 SI VDD NW) g45p1svt w=(215n) l=45n nf=1 m=(1)
mp12 (Db SE n2 NW) g45p1svt w=(215n) l=45n nf=1 m=(1)
mp11 (n2 D VDD NW) g45p1svt w=(215n) l=45n nf=1 m=(1)
mp51 (n30 CKbb n8 NW) g45p1svt w=(215n) l=45n nf=1 m=(1)
mp50 (n8 qbint VDD NW) g45p1svt w=(215n) l=45n nf=1 m=(1)
mp55 (Q qbint VDD NW) g45p1svt w=(390n) l=45n nf=1 m=(1)
mp35 (n6 mout VDD NW) g45p1svt w=(215n) l=45n nf=1 m=(1)
mp25 (n20 CKbb Db NW) g45p1svt w=(215n) l=45n nf=1 m=(1)
mp21 (CKbb CKb VDD NW) g45p1svt w=(215n) l=45n nf=1 m=(1)
mp30 (mout n20 VDD NW) g45p1svt w=(215n) l=45n nf=1 m=(1)
mp36 (n20 CKb n6 NW) g45p1svt w=(215n) l=45n nf=1 m=(1)
mp40 (n30 CKb mout NW) g45p1svt w=(215n) l=45n nf=1 m=(1)
mp10 (SEb SE VDD NW) g45p1svt w=(215n) l=45n nf=1 m=(1)
mp45 (qbint n30 VDD NW) g45p1svt w=(215n) l=45n nf=1 m=(1)
mp20 (CKb CK VDD NW) g45p1svt w=(215n) l=45n nf=1 m=(1)
ends SDFFQX1

// gsclib045_backbias/SDFFQX2/schematic

simulator lang=spectre

subckt SDFFQX2 CK D Q SE SI NW VDD VSS
mn13 (n3 SI VSS VSS) g45n1svt w=(145n) l=45n nf=1 m=(1)
mn14 (Db SE n3 VSS) g45n1svt w=(145n) l=45n nf=1 m=(1)
mn12 (Db SEb n1 VSS) g45n1svt w=(145n) l=45n nf=1 m=(1)
mn11 (n1 D VSS VSS) g45n1svt w=(145n) l=45n nf=1 m=(1)
mn55 (Q qbint VSS VSS) g45n1svt w=(520n) l=45n nf=1 m=(1)
mn50 (n7 qbint VSS VSS) g45n1svt w=(145n) l=45n nf=1 m=(1)
mn10 (SEb SE VSS VSS) g45n1svt w=(145n) l=45n nf=1 m=(1)
mn40 (mout CKbb n30 VSS) g45n1svt w=(145n) l=45n nf=1 m=(1)
mn35 (n20 CKbb n5 VSS) g45n1svt w=(145n) l=45n nf=1 m=(1)
mn36 (n5 mout VSS VSS) g45n1svt w=(145n) l=45n nf=1 m=(1)
mn20 (CKb CK VSS VSS) g45n1svt w=(145n) l=45n nf=1 m=(1)
mn51 (n30 CKb n7 VSS) g45n1svt w=(145n) l=45n nf=1 m=(1)
mn21 (CKbb CKb VSS VSS) g45n1svt w=(145n) l=45n nf=1 m=(1)
mn45 (qbint n30 VSS VSS) g45n1svt w=(205n) l=45n nf=1 m=(1)
mn25 (Db CKb n20 VSS) g45n1svt w=(145n) l=45n nf=1 m=(1)
mn30 (mout n20 VSS VSS) g45n1svt w=(145n) l=45n nf=1 m=(1)
mp14 (Db SEb n4 NW) g45p1svt w=(215n) l=45n nf=1 m=(1)
mp13 (n4 SI VDD NW) g45p1svt w=(215n) l=45n nf=1 m=(1)
mp12 (Db SE n2 NW) g45p1svt w=(215n) l=45n nf=1 m=(1)
mp11 (n2 D VDD NW) g45p1svt w=(215n) l=45n nf=1 m=(1)
mp51 (n30 CKbb n8 NW) g45p1svt w=(215n) l=45n nf=1 m=(1)
mp50 (n8 qbint VDD NW) g45p1svt w=(215n) l=45n nf=1 m=(1)
mp55 (Q qbint VDD NW) g45p1svt w=(780n) l=45n nf=1 m=(1)
mp35 (n6 mout VDD NW) g45p1svt w=(215n) l=45n nf=1 m=(1)
mp25 (n20 CKbb Db NW) g45p1svt w=(215n) l=45n nf=1 m=(1)
mp21 (CKbb CKb VDD NW) g45p1svt w=(215n) l=45n nf=1 m=(1)
mp30 (mout n20 VDD NW) g45p1svt w=(215n) l=45n nf=1 m=(1)
mp36 (n20 CKb n6 NW) g45p1svt w=(215n) l=45n nf=1 m=(1)
mp40 (n30 CKb mout NW) g45p1svt w=(215n) l=45n nf=1 m=(1)
mp10 (SEb SE VDD NW) g45p1svt w=(215n) l=45n nf=1 m=(1)
mp45 (qbint n30 VDD NW) g45p1svt w=(310n) l=45n nf=1 m=(1)
mp20 (CKb CK VDD NW) g45p1svt w=(215n) l=45n nf=1 m=(1)
ends SDFFQX2

// gsclib045_backbias/SDFFQX4/schematic

simulator lang=spectre

subckt SDFFQX4 CK D Q SE SI NW VDD VSS
mn13 (n3 SI VSS VSS) g45n1svt w=(145n) l=45n nf=1 m=(1)
mn14 (Db SE n3 VSS) g45n1svt w=(145n) l=45n nf=1 m=(1)
mn12 (Db SEb n1 VSS) g45n1svt w=(145n) l=45n nf=1 m=(1)
mn11 (n1 D VSS VSS) g45n1svt w=(145n) l=45n nf=1 m=(1)
mn55 (Q qbint VSS VSS) g45n1svt w=(1.04u) l=45n nf=1 m=(1)
mn50 (n7 qbint VSS VSS) g45n1svt w=(145n) l=45n nf=1 m=(1)
mn10 (SEb SE VSS VSS) g45n1svt w=(145n) l=45n nf=1 m=(1)
mn40 (mout CKbb n30 VSS) g45n1svt w=(145n) l=45n nf=1 m=(1)
mn35 (n20 CKbb n5 VSS) g45n1svt w=(145n) l=45n nf=1 m=(1)
mn36 (n5 mout VSS VSS) g45n1svt w=(145n) l=45n nf=1 m=(1)
mn20 (CKb CK VSS VSS) g45n1svt w=(145n) l=45n nf=1 m=(1)
mn51 (n30 CKb n7 VSS) g45n1svt w=(145n) l=45n nf=1 m=(1)
mn21 (CKbb CKb VSS VSS) g45n1svt w=(145n) l=45n nf=1 m=(1)
mn45 (qbint n30 VSS VSS) g45n1svt w=(410n) l=45n nf=1 m=(1)
mn25 (Db CKb n20 VSS) g45n1svt w=(145n) l=45n nf=1 m=(1)
mn30 (mout n20 VSS VSS) g45n1svt w=(145n) l=45n nf=1 m=(1)
mp14 (Db SEb n4 NW) g45p1svt w=(215n) l=45n nf=1 m=(1)
mp13 (n4 SI VDD NW) g45p1svt w=(215n) l=45n nf=1 m=(1)
mp12 (Db SE n2 NW) g45p1svt w=(215n) l=45n nf=1 m=(1)
mp11 (n2 D VDD NW) g45p1svt w=(215n) l=45n nf=1 m=(1)
mp51 (n30 CKbb n8 NW) g45p1svt w=(215n) l=45n nf=1 m=(1)
mp50 (n8 qbint VDD NW) g45p1svt w=(215n) l=45n nf=1 m=(1)
mp55 (Q qbint VDD NW) g45p1svt w=(1.56u) l=45n nf=1 m=(1)
mp35 (n6 mout VDD NW) g45p1svt w=(215n) l=45n nf=1 m=(1)
mp25 (n20 CKbb Db NW) g45p1svt w=(215n) l=45n nf=1 m=(1)
mp21 (CKbb CKb VDD NW) g45p1svt w=(215n) l=45n nf=1 m=(1)
mp30 (mout n20 VDD NW) g45p1svt w=(215n) l=45n nf=1 m=(1)
mp36 (n20 CKb n6 NW) g45p1svt w=(215n) l=45n nf=1 m=(1)
mp40 (n30 CKb mout NW) g45p1svt w=(215n) l=45n nf=1 m=(1)
mp10 (SEb SE VDD NW) g45p1svt w=(215n) l=45n nf=1 m=(1)
mp45 (qbint n30 VDD NW) g45p1svt w=(620n) l=45n nf=1 m=(1)
mp20 (CKb CK VDD NW) g45p1svt w=(215n) l=45n nf=1 m=(1)
ends SDFFQX4

// gsclib045_backbias/SDFFQXL/schematic

simulator lang=spectre

subckt SDFFQXL CK D Q SE SI NW VDD VSS
mn13 (n3 SI VSS VSS) g45n1svt w=(145n) l=45n nf=1 m=(1)
mn14 (Db SE n3 VSS) g45n1svt w=(145n) l=45n nf=1 m=(1)
mn12 (Db SEb n1 VSS) g45n1svt w=(145n) l=45n nf=1 m=(1)
mn11 (n1 D VSS VSS) g45n1svt w=(145n) l=45n nf=1 m=(1)
mn55 (Q qbint VSS VSS) g45n1svt w=(145n) l=45n nf=1 m=(1)
mn50 (n7 qbint VSS VSS) g45n1svt w=(145n) l=45n nf=1 m=(1)
mn10 (SEb SE VSS VSS) g45n1svt w=(145n) l=45n nf=1 m=(1)
mn40 (mout CKbb n30 VSS) g45n1svt w=(145n) l=45n nf=1 m=(1)
mn35 (n20 CKbb n5 VSS) g45n1svt w=(145n) l=45n nf=1 m=(1)
mn36 (n5 mout VSS VSS) g45n1svt w=(145n) l=45n nf=1 m=(1)
mn20 (CKb CK VSS VSS) g45n1svt w=(145n) l=45n nf=1 m=(1)
mn51 (n30 CKb n7 VSS) g45n1svt w=(145n) l=45n nf=1 m=(1)
mn21 (CKbb CKb VSS VSS) g45n1svt w=(145n) l=45n nf=1 m=(1)
mn45 (qbint n30 VSS VSS) g45n1svt w=(145n) l=45n nf=1 m=(1)
mn25 (Db CKb n20 VSS) g45n1svt w=(145n) l=45n nf=1 m=(1)
mn30 (mout n20 VSS VSS) g45n1svt w=(145n) l=45n nf=1 m=(1)
mp14 (Db SEb n4 NW) g45p1svt w=(215n) l=45n nf=1 m=(1)
mp13 (n4 SI VDD NW) g45p1svt w=(215n) l=45n nf=1 m=(1)
mp12 (Db SE n2 NW) g45p1svt w=(215n) l=45n nf=1 m=(1)
mp11 (n2 D VDD NW) g45p1svt w=(215n) l=45n nf=1 m=(1)
mp51 (n30 CKbb n8 NW) g45p1svt w=(215n) l=45n nf=1 m=(1)
mp50 (n8 qbint VDD NW) g45p1svt w=(215n) l=45n nf=1 m=(1)
mp55 (Q qbint VDD NW) g45p1svt w=(215n) l=45n nf=1 m=(1)
mp35 (n6 mout VDD NW) g45p1svt w=(215n) l=45n nf=1 m=(1)
mp25 (n20 CKbb Db NW) g45p1svt w=(215n) l=45n nf=1 m=(1)
mp21 (CKbb CKb VDD NW) g45p1svt w=(215n) l=45n nf=1 m=(1)
mp30 (mout n20 VDD NW) g45p1svt w=(215n) l=45n nf=1 m=(1)
mp36 (n20 CKb n6 NW) g45p1svt w=(215n) l=45n nf=1 m=(1)
mp40 (n30 CKb mout NW) g45p1svt w=(215n) l=45n nf=1 m=(1)
mp10 (SEb SE VDD NW) g45p1svt w=(215n) l=45n nf=1 m=(1)
mp45 (qbint n30 VDD NW) g45p1svt w=(215n) l=45n nf=1 m=(1)
mp20 (CKb CK VDD NW) g45p1svt w=(215n) l=45n nf=1 m=(1)
ends SDFFQXL

// gsclib045_backbias/SDFFRHQX1/schematic

simulator lang=spectre

subckt SDFFRHQX1 CK D Q RN SE SI VDD NW VSS
mn36 (net422 mout net426 VSS) g45n1svt w=(205n) l=45n nf=1 m=(1)
mn35 (net426 RN VSS VSS) g45n1svt w=(205n) l=45n nf=1 m=(1)
mn37 (n20 CKbb net422 VSS) g45n1svt w=(205n) l=45n nf=1 m=(1)
mn13 (net442 SI VSS VSS) g45n1svt w=(260n) l=45n nf=1 m=(1)
mn14 (Db SE net442 VSS) g45n1svt w=(260n) l=45n nf=1 m=(1)
mn12 (Db SEb net450 VSS) g45n1svt w=(260n) l=45n nf=1 m=(1)
mn11 (net450 D VSS VSS) g45n1svt w=(260n) l=45n nf=1 m=(1)
mn55 (Q qbint VSS VSS) g45n1svt w=(260n) l=45n nf=1 m=(1)
mn45 (net337 RN VSS VSS) g45n1svt w=(205n) l=45n nf=1 m=(1)
mn46 (qbint n30 net337 VSS) g45n1svt w=(205n) l=45n nf=1 m=(1)
mn51 (n30 CKb net405 VSS) g45n1svt w=(205n) l=45n nf=1 m=(1)
mn50 (net405 qbint VSS VSS) g45n1svt w=(205n) l=45n nf=1 m=(1)
mn20 (CKb CK VSS VSS) g45n1svt w=(145n) l=45n nf=1 m=(1)
mn40 (n30 CKbb mout VSS) g45n1svt w=(205n) l=45n nf=1 m=(1)
mn30 (mout n20 VSS VSS) g45n1svt w=(205n) l=45n nf=1 m=(1)
mn21 (CKbb CKb VSS VSS) g45n1svt w=(145n) l=45n nf=1 m=(1)
mn10 (SEb SE VSS VSS) g45n1svt w=(145n) l=45n nf=1 m=(1)
mn25 (n20 CKb Db VSS) g45n1svt w=(205n) l=45n nf=1 m=(1)
mp14 (Db SEb net373 NW) g45p1svt w=(390n) l=45n nf=1 m=(1)
mp13 (net373 SI VDD NW) g45p1svt w=(390n) l=45n nf=1 m=(1)
mp12 (Db SE net381 NW) g45p1svt w=(390n) l=45n nf=1 m=(1)
mp11 (net381 D VDD NW) g45p1svt w=(390n) l=45n nf=1 m=(1)
mp51 (n30 CKbb net326 NW) g45p1svt w=(310n) l=45n nf=1 m=(1)
mp50 (net326 qbint VDD NW) g45p1svt w=(310n) l=45n nf=1 m=(1)
mp55 (Q qbint VDD NW) g45p1svt w=(390n) l=45n nf=1 m=(1)
mp20 (CKb CK VDD NW) g45p1svt w=(215n) l=45n nf=1 m=(1)
mp46 (qbint n30 VDD NW) g45p1svt w=(310n) l=45n nf=1 m=(1)
mp45 (VDD RN qbint NW) g45p1svt w=(310n) l=45n nf=1 m=(1)
mp35 (net349 RN VDD NW) g45p1svt w=(310n) l=45n nf=1 m=(1)
mp36 (net349 mout VDD NW) g45p1svt w=(310n) l=45n nf=1 m=(1)
mp37 (n20 CKb net349 NW) g45p1svt w=(310n) l=45n nf=1 m=(1)
mp40 (n30 CKb mout NW) g45p1svt w=(310n) l=45n nf=1 m=(1)
mp30 (mout n20 VDD NW) g45p1svt w=(310n) l=45n nf=1 m=(1)
mp21 (CKbb CKb VDD NW) g45p1svt w=(215n) l=45n nf=1 m=(1)
mp25 (n20 CKbb Db NW) g45p1svt w=(310n) l=45n nf=1 m=(1)
mp10 (SEb SE VDD NW) g45p1svt w=(215n) l=45n nf=1 m=(1)
ends SDFFRHQX1

// gsclib045_backbias/SDFFRHQX2/schematic

simulator lang=spectre

subckt SDFFRHQX2 CK D Q RN SE SI VDD NW VSS
mn36 (net422 mout net426 VSS) g45n1svt w=(205n) l=45n nf=1 m=(1)
mn35 (net426 RN VSS VSS) g45n1svt w=(205n) l=45n nf=1 m=(1)
mn37 (n20 CKbb net422 VSS) g45n1svt w=(205n) l=45n nf=1 m=(1)
mn13 (net442 SI VSS VSS) g45n1svt w=(260n) l=45n nf=1 m=(1)
mn14 (Db SE net442 VSS) g45n1svt w=(260n) l=45n nf=1 m=(1)
mn12 (Db SEb net450 VSS) g45n1svt w=(260n) l=45n nf=1 m=(1)
mn11 (net450 D VSS VSS) g45n1svt w=(260n) l=45n nf=1 m=(1)
mn55 (Q qbint VSS VSS) g45n1svt w=(520n) l=45n nf=1 m=(1)
mn45 (net337 RN VSS VSS) g45n1svt w=(205n) l=45n nf=1 m=(1)
mn46 (qbint n30 net337 VSS) g45n1svt w=(205n) l=45n nf=1 m=(1)
mn51 (n30 CKb net405 VSS) g45n1svt w=(205n) l=45n nf=1 m=(1)
mn50 (net405 qbint VSS VSS) g45n1svt w=(205n) l=45n nf=1 m=(1)
mn20 (CKb CK VSS VSS) g45n1svt w=(145n) l=45n nf=1 m=(1)
mn40 (n30 CKbb mout VSS) g45n1svt w=(205n) l=45n nf=1 m=(1)
mn30 (mout n20 VSS VSS) g45n1svt w=(205n) l=45n nf=1 m=(1)
mn21 (CKbb CKb VSS VSS) g45n1svt w=(145n) l=45n nf=1 m=(1)
mn10 (SEb SE VSS VSS) g45n1svt w=(145n) l=45n nf=1 m=(1)
mn25 (n20 CKb Db VSS) g45n1svt w=(205n) l=45n nf=1 m=(1)
mp14 (Db SEb net373 NW) g45p1svt w=(390n) l=45n nf=1 m=(1)
mp13 (net373 SI VDD NW) g45p1svt w=(390n) l=45n nf=1 m=(1)
mp12 (Db SE net381 NW) g45p1svt w=(390n) l=45n nf=1 m=(1)
mp11 (net381 D VDD NW) g45p1svt w=(390n) l=45n nf=1 m=(1)
mp51 (n30 CKbb net326 NW) g45p1svt w=(310n) l=45n nf=1 m=(1)
mp50 (net326 qbint VDD NW) g45p1svt w=(310n) l=45n nf=1 m=(1)
mp55 (Q qbint VDD NW) g45p1svt w=(780n) l=45n nf=1 m=(1)
mp20 (CKb CK VDD NW) g45p1svt w=(215n) l=45n nf=1 m=(1)
mp46 (qbint n30 VDD NW) g45p1svt w=(310n) l=45n nf=1 m=(1)
mp45 (VDD RN qbint NW) g45p1svt w=(310n) l=45n nf=1 m=(1)
mp35 (net349 RN VDD NW) g45p1svt w=(310n) l=45n nf=1 m=(1)
mp36 (net349 mout VDD NW) g45p1svt w=(310n) l=45n nf=1 m=(1)
mp37 (n20 CKb net349 NW) g45p1svt w=(310n) l=45n nf=1 m=(1)
mp40 (n30 CKb mout NW) g45p1svt w=(310n) l=45n nf=1 m=(1)
mp30 (mout n20 VDD NW) g45p1svt w=(310n) l=45n nf=1 m=(1)
mp21 (CKbb CKb VDD NW) g45p1svt w=(215n) l=45n nf=1 m=(1)
mp25 (n20 CKbb Db NW) g45p1svt w=(310n) l=45n nf=1 m=(1)
mp10 (SEb SE VDD NW) g45p1svt w=(215n) l=45n nf=1 m=(1)
ends SDFFRHQX2

// gsclib045_backbias/SDFFRHQX4/schematic

simulator lang=spectre

subckt SDFFRHQX4 CK D Q RN SE SI VDD NW VSS
mn36 (net422 mout net426 VSS) g45n1svt w=(205n) l=45n nf=1 m=(1)
mn35 (net426 RN VSS VSS) g45n1svt w=(205n) l=45n nf=1 m=(1)
mn37 (n20 CKbb net422 VSS) g45n1svt w=(205n) l=45n nf=1 m=(1)
mn13 (net442 SI VSS VSS) g45n1svt w=(260n) l=45n nf=1 m=(1)
mn14 (Db SE net442 VSS) g45n1svt w=(260n) l=45n nf=1 m=(1)
mn12 (Db SEb net450 VSS) g45n1svt w=(260n) l=45n nf=1 m=(1)
mn11 (net450 D VSS VSS) g45n1svt w=(260n) l=45n nf=1 m=(1)
mn55 (Q qbint VSS VSS) g45n1svt w=(1.04u) l=45n nf=1 m=(1)
mn45 (net337 RN VSS VSS) g45n1svt w=(410n) l=45n nf=1 m=(1)
mn46 (qbint n30 net337 VSS) g45n1svt w=(410n) l=45n nf=1 m=(1)
mn51 (n30 CKb net405 VSS) g45n1svt w=(205n) l=45n nf=1 m=(1)
mn50 (net405 qbint VSS VSS) g45n1svt w=(205n) l=45n nf=1 m=(1)
mn20 (CKb CK VSS VSS) g45n1svt w=(145n) l=45n nf=1 m=(1)
mn40 (n30 CKbb mout VSS) g45n1svt w=(205n) l=45n nf=1 m=(1)
mn30 (mout n20 VSS VSS) g45n1svt w=(205n) l=45n nf=1 m=(1)
mn21 (CKbb CKb VSS VSS) g45n1svt w=(145n) l=45n nf=1 m=(1)
mn10 (SEb SE VSS VSS) g45n1svt w=(145n) l=45n nf=1 m=(1)
mn25 (n20 CKb Db VSS) g45n1svt w=(205n) l=45n nf=1 m=(1)
mp14 (Db SEb net373 NW) g45p1svt w=(390n) l=45n nf=1 m=(1)
mp13 (net373 SI VDD NW) g45p1svt w=(390n) l=45n nf=1 m=(1)
mp12 (Db SE net381 NW) g45p1svt w=(390n) l=45n nf=1 m=(1)
mp11 (net381 D VDD NW) g45p1svt w=(390n) l=45n nf=1 m=(1)
mp51 (n30 CKbb net326 NW) g45p1svt w=(310n) l=45n nf=1 m=(1)
mp50 (net326 qbint VDD NW) g45p1svt w=(310n) l=45n nf=1 m=(1)
mp55 (Q qbint VDD NW) g45p1svt w=(1.56u) l=45n nf=1 m=(1)
mp20 (CKb CK VDD NW) g45p1svt w=(215n) l=45n nf=1 m=(1)
mp46 (qbint n30 VDD NW) g45p1svt w=(620n) l=45n nf=1 m=(1)
mp45 (VDD RN qbint NW) g45p1svt w=(620n) l=45n nf=1 m=(1)
mp35 (net349 RN VDD NW) g45p1svt w=(310n) l=45n nf=1 m=(1)
mp36 (net349 mout VDD NW) g45p1svt w=(310n) l=45n nf=1 m=(1)
mp37 (n20 CKb net349 NW) g45p1svt w=(310n) l=45n nf=1 m=(1)
mp40 (n30 CKb mout NW) g45p1svt w=(310n) l=45n nf=1 m=(1)
mp30 (mout n20 VDD NW) g45p1svt w=(310n) l=45n nf=1 m=(1)
mp21 (CKbb CKb VDD NW) g45p1svt w=(215n) l=45n nf=1 m=(1)
mp25 (n20 CKbb Db NW) g45p1svt w=(310n) l=45n nf=1 m=(1)
mp10 (SEb SE VDD NW) g45p1svt w=(215n) l=45n nf=1 m=(1)
ends SDFFRHQX4

// gsclib045_backbias/SDFFRHQX8/schematic

simulator lang=spectre

subckt SDFFRHQX8 CK D Q RN SE SI VDD NW VSS
mn36 (net422 mout net426 VSS) g45n1svt w=(205n) l=45n nf=1 m=(1)
mn35 (net426 RN VSS VSS) g45n1svt w=(205n) l=45n nf=1 m=(1)
mn37 (n20 CKbb net422 VSS) g45n1svt w=(205n) l=45n nf=1 m=(1)
mn13 (net442 SI VSS VSS) g45n1svt w=(260n) l=45n nf=1 m=(1)
mn14 (Db SE net442 VSS) g45n1svt w=(260n) l=45n nf=1 m=(1)
mn12 (Db SEb net450 VSS) g45n1svt w=(260n) l=45n nf=1 m=(1)
mn11 (net450 D VSS VSS) g45n1svt w=(260n) l=45n nf=1 m=(1)
mn55 (Q qbint VSS VSS) g45n1svt w=(2.065u) l=45n nf=1 m=(1)
mn45 (net337 RN VSS VSS) g45n1svt w=(780n) l=45n nf=1 m=(1)
mn46 (qbint n30 net337 VSS) g45n1svt w=(780n) l=45n nf=1 m=(1)
mn51 (n30 CKb net405 VSS) g45n1svt w=(205n) l=45n nf=1 m=(1)
mn50 (net405 qbint VSS VSS) g45n1svt w=(205n) l=45n nf=1 m=(1)
mn20 (CKb CK VSS VSS) g45n1svt w=(145n) l=45n nf=1 m=(1)
mn40 (n30 CKbb mout VSS) g45n1svt w=(205n) l=45n nf=1 m=(1)
mn30 (mout n20 VSS VSS) g45n1svt w=(205n) l=45n nf=1 m=(1)
mn21 (CKbb CKb VSS VSS) g45n1svt w=(145n) l=45n nf=1 m=(1)
mn10 (SEb SE VSS VSS) g45n1svt w=(145n) l=45n nf=1 m=(1)
mn25 (n20 CKb Db VSS) g45n1svt w=(205n) l=45n nf=1 m=(1)
mp14 (Db SEb net373 NW) g45p1svt w=(390n) l=45n nf=1 m=(1)
mp13 (net373 SI VDD NW) g45p1svt w=(390n) l=45n nf=1 m=(1)
mp12 (Db SE net381 NW) g45p1svt w=(390n) l=45n nf=1 m=(1)
mp11 (net381 D VDD NW) g45p1svt w=(390n) l=45n nf=1 m=(1)
mp51 (n30 CKbb net326 NW) g45p1svt w=(310n) l=45n nf=1 m=(1)
mp50 (net326 qbint VDD NW) g45p1svt w=(310n) l=45n nf=1 m=(1)
mp55 (Q qbint VDD NW) g45p1svt w=(3.115u) l=45n nf=1 m=(1)
mp20 (CKb CK VDD NW) g45p1svt w=(215n) l=45n nf=1 m=(1)
mp46 (qbint n30 VDD NW) g45p1svt w=(1.17u) l=45n nf=1 m=(1)
mp45 (VDD RN qbint NW) g45p1svt w=(1.17u) l=45n nf=1 m=(1)
mp35 (net349 RN VDD NW) g45p1svt w=(310n) l=45n nf=1 m=(1)
mp36 (net349 mout VDD NW) g45p1svt w=(310n) l=45n nf=1 m=(1)
mp37 (n20 CKb net349 NW) g45p1svt w=(310n) l=45n nf=1 m=(1)
mp40 (n30 CKb mout NW) g45p1svt w=(310n) l=45n nf=1 m=(1)
mp30 (mout n20 VDD NW) g45p1svt w=(310n) l=45n nf=1 m=(1)
mp21 (CKbb CKb VDD NW) g45p1svt w=(215n) l=45n nf=1 m=(1)
mp25 (n20 CKbb Db NW) g45p1svt w=(310n) l=45n nf=1 m=(1)
mp10 (SEb SE VDD NW) g45p1svt w=(215n) l=45n nf=1 m=(1)
ends SDFFRHQX8

// gsclib045_backbias/SDFFRX1/schematic

simulator lang=spectre

subckt SDFFRX1 CK D Q QN RN SE SI VSS NW VDD
mn36 (n5 mout n7 VSS) g45n1svt w=(145n) l=45n nf=1 m=(1)
mn35 (n7 RN VSS VSS) g45n1svt w=(145n) l=45n nf=1 m=(1)
mn37 (n20 Ckbb n5 VSS) g45n1svt w=(145n) l=45n nf=1 m=(1)
mn13 (n3 SI VSS VSS) g45n1svt w=(145n) l=45n nf=1 m=(1)
mn14 (Db SE n3 VSS) g45n1svt w=(145n) l=45n nf=1 m=(1)
mn12 (Db SEb n1 VSS) g45n1svt w=(145n) l=45n nf=1 m=(1)
mn11 (n1 D VSS VSS) g45n1svt w=(145n) l=45n nf=1 m=(1)
mn57 (QN qint VSS VSS) g45n1svt w=(260n) l=45n nf=1 m=(1)
mn55 (Q qbint VSS VSS) g45n1svt w=(260n) l=45n nf=1 m=(1)
mn45 (n9 RN VSS VSS) g45n1svt w=(145n) l=45n nf=1 m=(1)
mn46 (qbint n30 n9 VSS) g45n1svt w=(145n) l=45n nf=1 m=(1)
mn51 (n30 CKb n11 VSS) g45n1svt w=(145n) l=45n nf=1 m=(1)
mn50 (n11 qbint VSS VSS) g45n1svt w=(145n) l=45n nf=1 m=(1)
mn20 (CKb CK VSS VSS) g45n1svt w=(145n) l=45n nf=1 m=(1)
mn56 (qint qbint VSS VSS) g45n1svt w=(145n) l=45n nf=1 m=(1)
mn40 (mout Ckbb n30 VSS) g45n1svt w=(145n) l=45n nf=1 m=(1)
mn30 (mout n20 VSS VSS) g45n1svt w=(145n) l=45n nf=1 m=(1)
mn21 (Ckbb CKb VSS VSS) g45n1svt w=(145n) l=45n nf=1 m=(1)
mn10 (SEb SE VSS VSS) g45n1svt w=(145n) l=45n nf=1 m=(1)
mn25 (Db CKb n20 VSS) g45n1svt w=(145n) l=45n nf=1 m=(1)
mp14 (Db SEb n4 NW) g45p1svt w=(215n) l=45n nf=1 m=(1)
mp13 (n4 SI VDD NW) g45p1svt w=(215n) l=45n nf=1 m=(1)
mp12 (Db SE n2 NW) g45p1svt w=(215n) l=45n nf=1 m=(1)
mp11 (n2 D VDD NW) g45p1svt w=(215n) l=45n nf=1 m=(1)
mp51 (n30 Ckbb n8 NW) g45p1svt w=(215n) l=45n nf=1 m=(1)
mp50 (n8 qbint VDD NW) g45p1svt w=(215n) l=45n nf=1 m=(1)
mp55 (Q qbint VDD NW) g45p1svt w=(390n) l=45n nf=1 m=(1)
mp20 (CKb CK VDD NW) g45p1svt w=(215n) l=45n nf=1 m=(1)
mp46 (qbint n30 VDD NW) g45p1svt w=(215n) l=45n nf=1 m=(1)
mp56 (qint qbint VDD NW) g45p1svt w=(215n) l=45n nf=1 m=(1)
mp45 (qbint RN VDD NW) g45p1svt w=(215n) l=45n nf=1 m=(1)
mp35 (n6 RN VDD NW) g45p1svt w=(215n) l=45n nf=1 m=(1)
mp36 (n6 mout VDD NW) g45p1svt w=(215n) l=45n nf=1 m=(1)
mp37 (n20 CKb n6 NW) g45p1svt w=(215n) l=45n nf=1 m=(1)
mp40 (n30 CKb mout NW) g45p1svt w=(215n) l=45n nf=1 m=(1)
mp30 (mout n20 VDD NW) g45p1svt w=(215n) l=45n nf=1 m=(1)
mp21 (Ckbb CKb VDD NW) g45p1svt w=(215n) l=45n nf=1 m=(1)
mp25 (n20 Ckbb Db NW) g45p1svt w=(215n) l=45n nf=1 m=(1)
mp10 (SEb SE VDD NW) g45p1svt w=(215n) l=45n nf=1 m=(1)
mp57 (QN qint VDD NW) g45p1svt w=(390n) l=45n nf=1 m=(1)
ends SDFFRX1

// gsclib045_backbias/SDFFRX2/schematic

simulator lang=spectre

subckt SDFFRX2 CK D Q QN RN SE SI VSS NW VDD
mn36 (n5 mout n7 VSS) g45n1svt w=(145n) l=45n nf=1 m=(1)
mn35 (n7 RN VSS VSS) g45n1svt w=(145n) l=45n nf=1 m=(1)
mn37 (n20 Ckbb n5 VSS) g45n1svt w=(145n) l=45n nf=1 m=(1)
mn13 (n3 SI VSS VSS) g45n1svt w=(145n) l=45n nf=1 m=(1)
mn14 (Db SE n3 VSS) g45n1svt w=(145n) l=45n nf=1 m=(1)
mn12 (Db SEb n1 VSS) g45n1svt w=(145n) l=45n nf=1 m=(1)
mn11 (n1 D VSS VSS) g45n1svt w=(145n) l=45n nf=1 m=(1)
mn57 (QN qint VSS VSS) g45n1svt w=(520n) l=45n nf=1 m=(1)
mn55 (Q qbint VSS VSS) g45n1svt w=(520n) l=45n nf=1 m=(1)
mn45 (n9 RN VSS VSS) g45n1svt w=(205n) l=45n nf=1 m=(1)
mn46 (qbint n30 n9 VSS) g45n1svt w=(205n) l=45n nf=1 m=(1)
mn51 (n30 CKb n11 VSS) g45n1svt w=(145n) l=45n nf=1 m=(1)
mn50 (n11 qbint VSS VSS) g45n1svt w=(145n) l=45n nf=1 m=(1)
mn20 (CKb CK VSS VSS) g45n1svt w=(145n) l=45n nf=1 m=(1)
mn56 (qint qbint VSS VSS) g45n1svt w=(145n) l=45n nf=1 m=(1)
mn40 (mout Ckbb n30 VSS) g45n1svt w=(145n) l=45n nf=1 m=(1)
mn30 (mout n20 VSS VSS) g45n1svt w=(145n) l=45n nf=1 m=(1)
mn21 (Ckbb CKb VSS VSS) g45n1svt w=(145n) l=45n nf=1 m=(1)
mn10 (SEb SE VSS VSS) g45n1svt w=(145n) l=45n nf=1 m=(1)
mn25 (Db CKb n20 VSS) g45n1svt w=(145n) l=45n nf=1 m=(1)
mp14 (Db SEb n4 NW) g45p1svt w=(215n) l=45n nf=1 m=(1)
mp13 (n4 SI VDD NW) g45p1svt w=(215n) l=45n nf=1 m=(1)
mp12 (Db SE n2 NW) g45p1svt w=(215n) l=45n nf=1 m=(1)
mp11 (n2 D VDD NW) g45p1svt w=(215n) l=45n nf=1 m=(1)
mp51 (n30 Ckbb n8 NW) g45p1svt w=(215n) l=45n nf=1 m=(1)
mp50 (n8 qbint VDD NW) g45p1svt w=(215n) l=45n nf=1 m=(1)
mp55 (Q qbint VDD NW) g45p1svt w=(780n) l=45n nf=1 m=(1)
mp20 (CKb CK VDD NW) g45p1svt w=(215n) l=45n nf=1 m=(1)
mp46 (qbint n30 VDD NW) g45p1svt w=(310n) l=45n nf=1 m=(1)
mp56 (qint qbint VDD NW) g45p1svt w=(215n) l=45n nf=1 m=(1)
mp45 (qbint RN VDD NW) g45p1svt w=(310n) l=45n nf=1 m=(1)
mp35 (n6 RN VDD NW) g45p1svt w=(215n) l=45n nf=1 m=(1)
mp36 (n6 mout VDD NW) g45p1svt w=(215n) l=45n nf=1 m=(1)
mp37 (n20 CKb n6 NW) g45p1svt w=(215n) l=45n nf=1 m=(1)
mp40 (n30 CKb mout NW) g45p1svt w=(215n) l=45n nf=1 m=(1)
mp30 (mout n20 VDD NW) g45p1svt w=(215n) l=45n nf=1 m=(1)
mp21 (Ckbb CKb VDD NW) g45p1svt w=(215n) l=45n nf=1 m=(1)
mp25 (n20 Ckbb Db NW) g45p1svt w=(215n) l=45n nf=1 m=(1)
mp10 (SEb SE VDD NW) g45p1svt w=(215n) l=45n nf=1 m=(1)
mp57 (QN qint VDD NW) g45p1svt w=(780n) l=45n nf=1 m=(1)
ends SDFFRX2

// gsclib045_backbias/SDFFRX4/schematic

simulator lang=spectre

subckt SDFFRX4 CK D Q QN RN SE SI VSS NW VDD
mn36 (n5 mout n7 VSS) g45n1svt w=(145n) l=45n nf=1 m=(1)
mn35 (n7 RN VSS VSS) g45n1svt w=(145n) l=45n nf=1 m=(1)
mn37 (n20 Ckbb n5 VSS) g45n1svt w=(145n) l=45n nf=1 m=(1)
mn13 (n3 SI VSS VSS) g45n1svt w=(145n) l=45n nf=1 m=(1)
mn14 (Db SE n3 VSS) g45n1svt w=(145n) l=45n nf=1 m=(1)
mn12 (Db SEb n1 VSS) g45n1svt w=(145n) l=45n nf=1 m=(1)
mn11 (n1 D VSS VSS) g45n1svt w=(145n) l=45n nf=1 m=(1)
mn57 (QN qint VSS VSS) g45n1svt w=(1.04u) l=45n nf=1 m=(1)
mn55 (Q qbint VSS VSS) g45n1svt w=(1.04u) l=45n nf=1 m=(1)
mn45 (n9 RN VSS VSS) g45n1svt w=(410n) l=45n nf=1 m=(1)
mn46 (qbint n30 n9 VSS) g45n1svt w=(410n) l=45n nf=1 m=(1)
mn51 (n30 CKb n11 VSS) g45n1svt w=(145n) l=45n nf=1 m=(1)
mn50 (n11 qbint VSS VSS) g45n1svt w=(145n) l=45n nf=1 m=(1)
mn20 (CKb CK VSS VSS) g45n1svt w=(145n) l=45n nf=1 m=(1)
mn56 (qint qbint VSS VSS) g45n1svt w=(260n) l=45n nf=1 m=(1)
mn40 (mout Ckbb n30 VSS) g45n1svt w=(145n) l=45n nf=1 m=(1)
mn30 (mout n20 VSS VSS) g45n1svt w=(145n) l=45n nf=1 m=(1)
mn21 (Ckbb CKb VSS VSS) g45n1svt w=(145n) l=45n nf=1 m=(1)
mn10 (SEb SE VSS VSS) g45n1svt w=(145n) l=45n nf=1 m=(1)
mn25 (Db CKb n20 VSS) g45n1svt w=(145n) l=45n nf=1 m=(1)
mp14 (Db SEb n4 NW) g45p1svt w=(215n) l=45n nf=1 m=(1)
mp13 (n4 SI VDD NW) g45p1svt w=(215n) l=45n nf=1 m=(1)
mp12 (Db SE n2 NW) g45p1svt w=(215n) l=45n nf=1 m=(1)
mp11 (n2 D VDD NW) g45p1svt w=(215n) l=45n nf=1 m=(1)
mp51 (n30 Ckbb n8 NW) g45p1svt w=(215n) l=45n nf=1 m=(1)
mp50 (n8 qbint VDD NW) g45p1svt w=(215n) l=45n nf=1 m=(1)
mp55 (Q qbint VDD NW) g45p1svt w=(1.56u) l=45n nf=1 m=(1)
mp20 (CKb CK VDD NW) g45p1svt w=(215n) l=45n nf=1 m=(1)
mp46 (qbint n30 VDD NW) g45p1svt w=(620n) l=45n nf=1 m=(1)
mp56 (qint qbint VDD NW) g45p1svt w=(390n) l=45n nf=1 m=(1)
mp45 (qbint RN VDD NW) g45p1svt w=(620n) l=45n nf=1 m=(1)
mp35 (n6 RN VDD NW) g45p1svt w=(215n) l=45n nf=1 m=(1)
mp36 (n6 mout VDD NW) g45p1svt w=(215n) l=45n nf=1 m=(1)
mp37 (n20 CKb n6 NW) g45p1svt w=(215n) l=45n nf=1 m=(1)
mp40 (n30 CKb mout NW) g45p1svt w=(215n) l=45n nf=1 m=(1)
mp30 (mout n20 VDD NW) g45p1svt w=(215n) l=45n nf=1 m=(1)
mp21 (Ckbb CKb VDD NW) g45p1svt w=(215n) l=45n nf=1 m=(1)
mp25 (n20 Ckbb Db NW) g45p1svt w=(215n) l=45n nf=1 m=(1)
mp10 (SEb SE VDD NW) g45p1svt w=(215n) l=45n nf=1 m=(1)
mp57 (QN qint VDD NW) g45p1svt w=(1.56u) l=45n nf=1 m=(1)
ends SDFFRX4

// gsclib045_backbias/SDFFRXL/schematic

simulator lang=spectre

subckt SDFFRXL CK D Q QN RN SE SI VSS NW VDD
mn36 (n5 mout n7 VSS) g45n1svt w=(145n) l=45n nf=1 m=(1)
mn35 (n7 RN VSS VSS) g45n1svt w=(145n) l=45n nf=1 m=(1)
mn37 (n20 Ckbb n5 VSS) g45n1svt w=(145n) l=45n nf=1 m=(1)
mn13 (n3 SI VSS VSS) g45n1svt w=(145n) l=45n nf=1 m=(1)
mn14 (Db SE n3 VSS) g45n1svt w=(145n) l=45n nf=1 m=(1)
mn12 (Db SEb n1 VSS) g45n1svt w=(145n) l=45n nf=1 m=(1)
mn11 (n1 D VSS VSS) g45n1svt w=(145n) l=45n nf=1 m=(1)
mn57 (QN qint VSS VSS) g45n1svt w=(145n) l=45n nf=1 m=(1)
mn55 (Q qbint VSS VSS) g45n1svt w=(145n) l=45n nf=1 m=(1)
mn45 (n9 RN VSS VSS) g45n1svt w=(145n) l=45n nf=1 m=(1)
mn46 (qbint n30 n9 VSS) g45n1svt w=(145n) l=45n nf=1 m=(1)
mn51 (n30 CKb n11 VSS) g45n1svt w=(145n) l=45n nf=1 m=(1)
mn50 (n11 qbint VSS VSS) g45n1svt w=(145n) l=45n nf=1 m=(1)
mn20 (CKb CK VSS VSS) g45n1svt w=(145n) l=45n nf=1 m=(1)
mn56 (qint qbint VSS VSS) g45n1svt w=(145n) l=45n nf=1 m=(1)
mn40 (mout Ckbb n30 VSS) g45n1svt w=(145n) l=45n nf=1 m=(1)
mn30 (mout n20 VSS VSS) g45n1svt w=(145n) l=45n nf=1 m=(1)
mn21 (Ckbb CKb VSS VSS) g45n1svt w=(145n) l=45n nf=1 m=(1)
mn10 (SEb SE VSS VSS) g45n1svt w=(145n) l=45n nf=1 m=(1)
mn25 (Db CKb n20 VSS) g45n1svt w=(145n) l=45n nf=1 m=(1)
mp14 (Db SEb n4 NW) g45p1svt w=(215n) l=45n nf=1 m=(1)
mp13 (n4 SI VDD NW) g45p1svt w=(215n) l=45n nf=1 m=(1)
mp12 (Db SE n2 NW) g45p1svt w=(215n) l=45n nf=1 m=(1)
mp11 (n2 D VDD NW) g45p1svt w=(215n) l=45n nf=1 m=(1)
mp51 (n30 Ckbb n8 NW) g45p1svt w=(215n) l=45n nf=1 m=(1)
mp50 (n8 qbint VDD NW) g45p1svt w=(215n) l=45n nf=1 m=(1)
mp55 (Q qbint VDD NW) g45p1svt w=(215n) l=45n nf=1 m=(1)
mp20 (CKb CK VDD NW) g45p1svt w=(215n) l=45n nf=1 m=(1)
mp46 (qbint n30 VDD NW) g45p1svt w=(215n) l=45n nf=1 m=(1)
mp56 (qint qbint VDD NW) g45p1svt w=(215n) l=45n nf=1 m=(1)
mp45 (qbint RN VDD NW) g45p1svt w=(215n) l=45n nf=1 m=(1)
mp35 (n6 RN VDD NW) g45p1svt w=(215n) l=45n nf=1 m=(1)
mp36 (n6 mout VDD NW) g45p1svt w=(215n) l=45n nf=1 m=(1)
mp37 (n20 CKb n6 NW) g45p1svt w=(215n) l=45n nf=1 m=(1)
mp40 (n30 CKb mout NW) g45p1svt w=(215n) l=45n nf=1 m=(1)
mp30 (mout n20 VDD NW) g45p1svt w=(215n) l=45n nf=1 m=(1)
mp21 (Ckbb CKb VDD NW) g45p1svt w=(215n) l=45n nf=1 m=(1)
mp25 (n20 Ckbb Db NW) g45p1svt w=(215n) l=45n nf=1 m=(1)
mp10 (SEb SE VDD NW) g45p1svt w=(215n) l=45n nf=1 m=(1)
mp57 (QN qint VDD NW) g45p1svt w=(215n) l=45n nf=1 m=(1)
ends SDFFRXL

// gsclib045_backbias/SDFFSHQX1/schematic

simulator lang=spectre

subckt SDFFSHQX1 CK D Q SE SI SN NW VSS VDD
mn51 (net467 qbint net459 VSS) g45n1svt w=(205n) l=45n nf=1 m=(1)
mn52 (n30 CKb net467 VSS) g45n1svt w=(205n) l=45n nf=1 m=(1)
mn50 (net459 SN VSS VSS) g45n1svt w=(205n) l=45n nf=1 m=(1)
mn13 (net455 SI VSS VSS) g45n1svt w=(260n) l=45n nf=1 m=(1)
mn14 (Db SE net455 VSS) g45n1svt w=(260n) l=45n nf=1 m=(1)
mn12 (Db SEb net443 VSS) g45n1svt w=(260n) l=45n nf=1 m=(1)
mn11 (net443 D VSS VSS) g45n1svt w=(260n) l=45n nf=1 m=(1)
mn55 (Q qbint VSS VSS) g45n1svt w=(260n) l=45n nf=1 m=(1)
mn30 (net435 SN VSS VSS) g45n1svt w=(205n) l=45n nf=1 m=(1)
mn31 (mout n20 net435 VSS) g45n1svt w=(205n) l=45n nf=1 m=(1)
mn35 (net427 mout VSS VSS) g45n1svt w=(205n) l=45n nf=1 m=(1)
mn36 (n20 CKbb net427 VSS) g45n1svt w=(205n) l=45n nf=1 m=(1)
mn20 (CKb CK VSS VSS) g45n1svt w=(145n) l=45n nf=1 m=(1)
mn10 (SEb SE VSS VSS) g45n1svt w=(145n) l=45n nf=1 m=(1)
mn25 (n20 CKb Db VSS) g45n1svt w=(205n) l=45n nf=1 m=(1)
mn40 (n30 CKbb mout VSS) g45n1svt w=(205n) l=45n nf=1 m=(1)
mn45 (qbint n30 VSS VSS) g45n1svt w=(205n) l=45n nf=1 m=(1)
mn21 (CKbb CKb VSS VSS) g45n1svt w=(145n) l=45n nf=1 m=(1)
mp14 (Db SEb net398 NW) g45p1svt w=(390n) l=45n nf=1 m=(1)
mp13 (net398 SI VDD NW) g45p1svt w=(390n) l=45n nf=1 m=(1)
mp12 (Db SE net390 NW) g45p1svt w=(390n) l=45n nf=1 m=(1)
mp11 (net390 D VDD NW) g45p1svt w=(390n) l=45n nf=1 m=(1)
mp55 (Q qbint VDD NW) g45p1svt w=(390n) l=45n nf=1 m=(1)
mp36 (n20 CKb net378 NW) g45p1svt w=(310n) l=45n nf=1 m=(1)
mp35 (net378 mout VDD NW) g45p1svt w=(310n) l=45n nf=1 m=(1)
mp20 (CKb CK VDD NW) g45p1svt w=(215n) l=45n nf=1 m=(1)
mp52 (n30 CKbb net355 NW) g45p1svt w=(310n) l=45n nf=1 m=(1)
mp51 (net355 qbint VDD NW) g45p1svt w=(310n) l=45n nf=1 m=(1)
mp50 (net355 SN VDD NW) g45p1svt w=(310n) l=45n nf=1 m=(1)
mp21 (CKbb CKb VDD NW) g45p1svt w=(215n) l=45n nf=1 m=(1)
mp31 (mout n20 VDD NW) g45p1svt w=(310n) l=45n nf=1 m=(1)
mp45 (qbint n30 VDD NW) g45p1svt w=(310n) l=45n nf=1 m=(1)
mp30 (mout SN VDD NW) g45p1svt w=(310n) l=45n nf=1 m=(1)
mp25 (n20 CKbb Db NW) g45p1svt w=(310n) l=45n nf=1 m=(1)
mp40 (n30 CKb mout NW) g45p1svt w=(310n) l=45n nf=1 m=(1)
mp10 (SEb SE VDD NW) g45p1svt w=(215n) l=45n nf=1 m=(1)
ends SDFFSHQX1

// gsclib045_backbias/SDFFSHQX2/schematic

simulator lang=spectre

subckt SDFFSHQX2 CK D Q SE SI SN NW VSS VDD
mn51 (net467 qbint net459 VSS) g45n1svt w=(205n) l=45n nf=1 m=(1)
mn52 (n30 CKb net467 VSS) g45n1svt w=(205n) l=45n nf=1 m=(1)
mn50 (net459 SN VSS VSS) g45n1svt w=(205n) l=45n nf=1 m=(1)
mn13 (net455 SI VSS VSS) g45n1svt w=(260n) l=45n nf=1 m=(1)
mn14 (Db SE net455 VSS) g45n1svt w=(260n) l=45n nf=1 m=(1)
mn12 (Db SEb net443 VSS) g45n1svt w=(260n) l=45n nf=1 m=(1)
mn11 (net443 D VSS VSS) g45n1svt w=(260n) l=45n nf=1 m=(1)
mn55 (Q qbint VSS VSS) g45n1svt w=(520n) l=45n nf=1 m=(1)
mn30 (net435 SN VSS VSS) g45n1svt w=(205n) l=45n nf=1 m=(1)
mn31 (mout n20 net435 VSS) g45n1svt w=(205n) l=45n nf=1 m=(1)
mn35 (net427 mout VSS VSS) g45n1svt w=(205n) l=45n nf=1 m=(1)
mn36 (n20 CKbb net427 VSS) g45n1svt w=(205n) l=45n nf=1 m=(1)
mn20 (CKb CK VSS VSS) g45n1svt w=(145n) l=45n nf=1 m=(1)
mn10 (SEb SE VSS VSS) g45n1svt w=(145n) l=45n nf=1 m=(1)
mn25 (n20 CKb Db VSS) g45n1svt w=(205n) l=45n nf=1 m=(1)
mn40 (n30 CKbb mout VSS) g45n1svt w=(205n) l=45n nf=1 m=(1)
mn45 (qbint n30 VSS VSS) g45n1svt w=(205n) l=45n nf=1 m=(1)
mn21 (CKbb CKb VSS VSS) g45n1svt w=(145n) l=45n nf=1 m=(1)
mp14 (Db SEb net398 NW) g45p1svt w=(390n) l=45n nf=1 m=(1)
mp13 (net398 SI VDD NW) g45p1svt w=(390n) l=45n nf=1 m=(1)
mp12 (Db SE net390 NW) g45p1svt w=(390n) l=45n nf=1 m=(1)
mp11 (net390 D VDD NW) g45p1svt w=(390n) l=45n nf=1 m=(1)
mp55 (Q qbint VDD NW) g45p1svt w=(780n) l=45n nf=1 m=(1)
mp36 (n20 CKb net378 NW) g45p1svt w=(310n) l=45n nf=1 m=(1)
mp35 (net378 mout VDD NW) g45p1svt w=(310n) l=45n nf=1 m=(1)
mp20 (CKb CK VDD NW) g45p1svt w=(215n) l=45n nf=1 m=(1)
mp52 (n30 CKbb net355 NW) g45p1svt w=(310n) l=45n nf=1 m=(1)
mp51 (net355 qbint VDD NW) g45p1svt w=(310n) l=45n nf=1 m=(1)
mp50 (net355 SN VDD NW) g45p1svt w=(310n) l=45n nf=1 m=(1)
mp21 (CKbb CKb VDD NW) g45p1svt w=(215n) l=45n nf=1 m=(1)
mp31 (mout n20 VDD NW) g45p1svt w=(310n) l=45n nf=1 m=(1)
mp45 (qbint n30 VDD NW) g45p1svt w=(310n) l=45n nf=1 m=(1)
mp30 (mout SN VDD NW) g45p1svt w=(310n) l=45n nf=1 m=(1)
mp25 (n20 CKbb Db NW) g45p1svt w=(310n) l=45n nf=1 m=(1)
mp40 (n30 CKb mout NW) g45p1svt w=(310n) l=45n nf=1 m=(1)
mp10 (SEb SE VDD NW) g45p1svt w=(215n) l=45n nf=1 m=(1)
ends SDFFSHQX2

// gsclib045_backbias/SDFFSHQX4/schematic

simulator lang=spectre

subckt SDFFSHQX4 CK D Q SE SI SN VSS VDD NW
mn51 (net467 qbint net459 VSS) g45n1svt w=(205n) l=45n nf=1 m=(1)
mn52 (n30 CKb net467 VSS) g45n1svt w=(205n) l=45n nf=1 m=(1)
mn50 (net459 SN VSS VSS) g45n1svt w=(205n) l=45n nf=1 m=(1)
mn13 (net455 SI VSS VSS) g45n1svt w=(260n) l=45n nf=1 m=(1)
mn14 (Db SE net455 VSS) g45n1svt w=(260n) l=45n nf=1 m=(1)
mn12 (Db SEb net443 VSS) g45n1svt w=(260n) l=45n nf=1 m=(1)
mn11 (net443 D VSS VSS) g45n1svt w=(260n) l=45n nf=1 m=(1)
mn55 (Q qbint VSS VSS) g45n1svt w=(1.04u) l=45n nf=1 m=(1)
mn30 (net435 SN VSS VSS) g45n1svt w=(205n) l=45n nf=1 m=(1)
mn31 (mout n20 net435 VSS) g45n1svt w=(205n) l=45n nf=1 m=(1)
mn35 (net427 mout VSS VSS) g45n1svt w=(205n) l=45n nf=1 m=(1)
mn36 (n20 CKbb net427 VSS) g45n1svt w=(205n) l=45n nf=1 m=(1)
mn20 (CKb CK VSS VSS) g45n1svt w=(145n) l=45n nf=1 m=(1)
mn10 (SEb SE VSS VSS) g45n1svt w=(145n) l=45n nf=1 m=(1)
mn25 (n20 CKb Db VSS) g45n1svt w=(205n) l=45n nf=1 m=(1)
mn40 (n30 CKbb mout VSS) g45n1svt w=(205n) l=45n nf=1 m=(1)
mn45 (qbint n30 VSS VSS) g45n1svt w=(410n) l=45n nf=1 m=(1)
mn21 (CKbb CKb VSS VSS) g45n1svt w=(145n) l=45n nf=1 m=(1)
mp14 (Db SEb net398 NW) g45p1svt w=(390n) l=45n nf=1 m=(1)
mp13 (net398 SI VDD NW) g45p1svt w=(390n) l=45n nf=1 m=(1)
mp12 (Db SE net390 NW) g45p1svt w=(390n) l=45n nf=1 m=(1)
mp11 (net390 D VDD NW) g45p1svt w=(390n) l=45n nf=1 m=(1)
mp55 (Q qbint VDD NW) g45p1svt w=(1.56u) l=45n nf=1 m=(1)
mp36 (n20 CKb net378 NW) g45p1svt w=(310n) l=45n nf=1 m=(1)
mp35 (net378 mout VDD NW) g45p1svt w=(310n) l=45n nf=1 m=(1)
mp20 (CKb CK VDD NW) g45p1svt w=(215n) l=45n nf=1 m=(1)
mp52 (n30 CKbb net355 NW) g45p1svt w=(310n) l=45n nf=1 m=(1)
mp51 (net355 qbint VDD NW) g45p1svt w=(310n) l=45n nf=1 m=(1)
mp50 (net355 SN VDD NW) g45p1svt w=(310n) l=45n nf=1 m=(1)
mp21 (CKbb CKb VDD NW) g45p1svt w=(215n) l=45n nf=1 m=(1)
mp31 (mout n20 VDD NW) g45p1svt w=(310n) l=45n nf=1 m=(1)
mp45 (qbint n30 VDD NW) g45p1svt w=(620n) l=45n nf=1 m=(1)
mp30 (mout SN VDD NW) g45p1svt w=(310n) l=45n nf=1 m=(1)
mp25 (n20 CKbb Db NW) g45p1svt w=(310n) l=45n nf=1 m=(1)
mp40 (n30 CKb mout NW) g45p1svt w=(310n) l=45n nf=1 m=(1)
mp10 (SEb SE VDD NW) g45p1svt w=(215n) l=45n nf=1 m=(1)
ends SDFFSHQX4

// gsclib045_backbias/SDFFSHQX8/schematic

simulator lang=spectre

subckt SDFFSHQX8 CK D Q SE SI SN VDD VSS NW
mn51 (net467 qbint net459 VSS) g45n1svt w=(205n) l=45n nf=1 m=(1)
mn52 (n30 CKb net467 VSS) g45n1svt w=(205n) l=45n nf=1 m=(1)
mn50 (net459 SN VSS VSS) g45n1svt w=(205n) l=45n nf=1 m=(1)
mn13 (net455 SI VSS VSS) g45n1svt w=(260n) l=45n nf=1 m=(1)
mn14 (Db SE net455 VSS) g45n1svt w=(260n) l=45n nf=1 m=(1)
mn12 (Db SEb net443 VSS) g45n1svt w=(260n) l=45n nf=1 m=(1)
mn11 (net443 D VSS VSS) g45n1svt w=(260n) l=45n nf=1 m=(1)
mn55 (Q qbint VSS VSS) g45n1svt w=(2.065u) l=45n nf=1 m=(1)
mn30 (net435 SN VSS VSS) g45n1svt w=(205n) l=45n nf=1 m=(1)
mn31 (mout n20 net435 VSS) g45n1svt w=(205n) l=45n nf=1 m=(1)
mn35 (net427 mout VSS VSS) g45n1svt w=(205n) l=45n nf=1 m=(1)
mn36 (n20 CKbb net427 VSS) g45n1svt w=(205n) l=45n nf=1 m=(1)
mn20 (CKb CK VSS VSS) g45n1svt w=(145n) l=45n nf=1 m=(1)
mn10 (SEb SE VSS VSS) g45n1svt w=(145n) l=45n nf=1 m=(1)
mn25 (n20 CKb Db VSS) g45n1svt w=(205n) l=45n nf=1 m=(1)
mn40 (n30 CKbb mout VSS) g45n1svt w=(205n) l=45n nf=1 m=(1)
mn45 (qbint n30 VSS VSS) g45n1svt w=(780n) l=45n nf=1 m=(1)
mn21 (CKbb CKb VSS VSS) g45n1svt w=(145n) l=45n nf=1 m=(1)
mp14 (Db SEb net398 NW) g45p1svt w=(390n) l=45n nf=1 m=(1)
mp13 (net398 SI VDD NW) g45p1svt w=(390n) l=45n nf=1 m=(1)
mp12 (Db SE net390 NW) g45p1svt w=(390n) l=45n nf=1 m=(1)
mp11 (net390 D VDD NW) g45p1svt w=(390n) l=45n nf=1 m=(1)
mp55 (Q qbint VDD NW) g45p1svt w=(3.115u) l=45n nf=1 m=(1)
mp36 (n20 CKb net378 NW) g45p1svt w=(310n) l=45n nf=1 m=(1)
mp35 (net378 mout VDD NW) g45p1svt w=(310n) l=45n nf=1 m=(1)
mp20 (CKb CK VDD NW) g45p1svt w=(215n) l=45n nf=1 m=(1)
mp52 (n30 CKbb net355 NW) g45p1svt w=(310n) l=45n nf=1 m=(1)
mp51 (net355 qbint VDD NW) g45p1svt w=(310n) l=45n nf=1 m=(1)
mp50 (net355 SN VDD NW) g45p1svt w=(310n) l=45n nf=1 m=(1)
mp21 (CKbb CKb VDD NW) g45p1svt w=(215n) l=45n nf=1 m=(1)
mp31 (mout n20 VDD NW) g45p1svt w=(310n) l=45n nf=1 m=(1)
mp45 (qbint n30 VDD NW) g45p1svt w=(1.17u) l=45n nf=1 m=(1)
mp30 (mout SN VDD NW) g45p1svt w=(310n) l=45n nf=1 m=(1)
mp25 (n20 CKbb Db NW) g45p1svt w=(310n) l=45n nf=1 m=(1)
mp40 (n30 CKb mout NW) g45p1svt w=(310n) l=45n nf=1 m=(1)
mp10 (SEb SE VDD NW) g45p1svt w=(215n) l=45n nf=1 m=(1)
ends SDFFSHQX8

// gsclib045_backbias/SDFFSRHQX1/schematic

simulator lang=spectre

subckt SDFFSRHQX1 CK D Q RN SE SI SN NW VDD VSS
mn13 (net534 SI VSS VSS) g45n1svt w=(260n) l=45n nf=1 m=(1)
mn14 (Db SE net534 VSS) g45n1svt w=(260n) l=45n nf=1 m=(1)
mn12 (Db SEb net522 VSS) g45n1svt w=(260n) l=45n nf=1 m=(1)
mn11 (net522 D VSS VSS) g45n1svt w=(260n) l=45n nf=1 m=(1)
mn55 (Q qbint VSS VSS) g45n1svt w=(260n) l=45n nf=1 m=(1)
mn35 (net514 mout VSS VSS) g45n1svt w=(205n) l=45n nf=1 m=(1)
mn36 (n20 CKbb net514 VSS) g45n1svt w=(205n) l=45n nf=1 m=(1)
mn22 (RNb RN VSS VSS) g45n1svt w=(145n) l=45n nf=1 m=(1)
mn20 (CKb CK VSS VSS) g45n1svt w=(145n) l=45n nf=1 m=(1)
mn45 (qbint n35 VSS VSS) g45n1svt w=(205n) l=45n nf=1 m=(1)
mn52 (net490 qbint net486 VSS) g45n1svt w=(205n) l=45n nf=1 m=(1)
mn51 (net490 RNb net486 VSS) g45n1svt w=(205n) l=45n nf=1 m=(1)
mn50 (net486 SN VSS VSS) g45n1svt w=(205n) l=45n nf=1 m=(1)
mn53 (n35 CKb net490 VSS) g45n1svt w=(205n) l=45n nf=1 m=(1)
mn10 (SEb SE VSS VSS) g45n1svt w=(145n) l=45n nf=1 m=(1)
mn25 (Db CKb n20 VSS) g45n1svt w=(205n) l=45n nf=1 m=(1)
mn30 (net469 SN VSS VSS) g45n1svt w=(205n) l=45n nf=1 m=(1)
mn32 (mout n20 net469 VSS) g45n1svt w=(205n) l=45n nf=1 m=(1)
mn31 (mout RNb net469 VSS) g45n1svt w=(205n) l=45n nf=1 m=(1)
mn40 (n35 CKbb mout VSS) g45n1svt w=(205n) l=45n nf=1 m=(1)
mn21 (CKbb CKb VSS VSS) g45n1svt w=(145n) l=45n nf=1 m=(1)
mp14 (Db SEb net453 NW) g45p1svt w=(390n) l=45n nf=1 m=(1)
mp13 (net453 SI VDD NW) g45p1svt w=(390n) l=45n nf=1 m=(1)
mp12 (Db SE net445 NW) g45p1svt w=(390n) l=45n nf=1 m=(1)
mp11 (net445 D VDD NW) g45p1svt w=(390n) l=45n nf=1 m=(1)
mp52 (net394 qbint net437 NW) g45p1svt w=(310n) l=45n nf=1 m=(1)
mp51 (net437 RNb VDD NW) g45p1svt w=(310n) l=45n nf=1 m=(1)
mp55 (Q qbint VDD NW) g45p1svt w=(390n) l=45n nf=1 m=(1)
mp36 (n20 CKb net425 NW) g45p1svt w=(310n) l=45n nf=1 m=(1)
mp35 (net425 mout VDD NW) g45p1svt w=(310n) l=45n nf=1 m=(1)
mp32 (mout n20 net417 NW) g45p1svt w=(310n) l=45n nf=1 m=(1)
mp31 (net417 RNb VDD NW) g45p1svt w=(310n) l=45n nf=1 m=(1)
mp22 (RNb RN VDD NW) g45p1svt w=(215n) l=45n nf=1 m=(1)
mp20 (CKb CK VDD NW) g45p1svt w=(215n) l=45n nf=1 m=(1)
mp53 (n35 CKbb net394 NW) g45p1svt w=(310n) l=45n nf=1 m=(1)
mp50 (net394 SN VDD NW) g45p1svt w=(310n) l=45n nf=1 m=(1)
mp45 (qbint n35 VDD NW) g45p1svt w=(310n) l=45n nf=1 m=(1)
mp25 (n20 CKbb Db NW) g45p1svt w=(310n) l=45n nf=1 m=(1)
mp30 (mout SN VDD NW) g45p1svt w=(310n) l=45n nf=1 m=(1)
mp40 (n35 CKb mout NW) g45p1svt w=(310n) l=45n nf=1 m=(1)
mp21 (CKbb CKb VDD NW) g45p1svt w=(215n) l=45n nf=1 m=(1)
mp10 (SEb SE VDD NW) g45p1svt w=(215n) l=45n nf=1 m=(1)
ends SDFFSRHQX1

// gsclib045_backbias/SDFFSRHQX2/schematic

simulator lang=spectre

subckt SDFFSRHQX2 CK D Q RN SE SI SN VDD VSS NW
mn13 (net534 SI VSS VSS) g45n1svt w=(260n) l=45n nf=1 m=(1)
mn14 (Db SE net534 VSS) g45n1svt w=(260n) l=45n nf=1 m=(1)
mn12 (Db SEb net522 VSS) g45n1svt w=(260n) l=45n nf=1 m=(1)
mn11 (net522 D VSS VSS) g45n1svt w=(260n) l=45n nf=1 m=(1)
mn55 (Q qbint VSS VSS) g45n1svt w=(520n) l=45n nf=1 m=(1)
mn35 (net514 mout VSS VSS) g45n1svt w=(205n) l=45n nf=1 m=(1)
mn36 (n20 CKbb net514 VSS) g45n1svt w=(205n) l=45n nf=1 m=(1)
mn22 (RNb RN VSS VSS) g45n1svt w=(145n) l=45n nf=1 m=(1)
mn20 (CKb CK VSS VSS) g45n1svt w=(145n) l=45n nf=1 m=(1)
mn45 (qbint n35 VSS VSS) g45n1svt w=(205n) l=45n nf=1 m=(1)
mn52 (net490 qbint net486 VSS) g45n1svt w=(205n) l=45n nf=1 m=(1)
mn51 (net490 RNb net486 VSS) g45n1svt w=(205n) l=45n nf=1 m=(1)
mn50 (net486 SN VSS VSS) g45n1svt w=(205n) l=45n nf=1 m=(1)
mn53 (n35 CKb net490 VSS) g45n1svt w=(205n) l=45n nf=1 m=(1)
mn10 (SEb SE VSS VSS) g45n1svt w=(145n) l=45n nf=1 m=(1)
mn25 (Db CKb n20 VSS) g45n1svt w=(205n) l=45n nf=1 m=(1)
mn30 (net469 SN VSS VSS) g45n1svt w=(205n) l=45n nf=1 m=(1)
mn32 (mout n20 net469 VSS) g45n1svt w=(205n) l=45n nf=1 m=(1)
mn31 (mout RNb net469 VSS) g45n1svt w=(205n) l=45n nf=1 m=(1)
mn40 (n35 CKbb mout VSS) g45n1svt w=(205n) l=45n nf=1 m=(1)
mn21 (CKbb CKb VSS VSS) g45n1svt w=(145n) l=45n nf=1 m=(1)
mp14 (Db SEb net453 NW) g45p1svt w=(390n) l=45n nf=1 m=(1)
mp13 (net453 SI VDD NW) g45p1svt w=(390n) l=45n nf=1 m=(1)
mp12 (Db SE net445 NW) g45p1svt w=(390n) l=45n nf=1 m=(1)
mp11 (net445 D VDD NW) g45p1svt w=(390n) l=45n nf=1 m=(1)
mp52 (net394 qbint net437 NW) g45p1svt w=(310n) l=45n nf=1 m=(1)
mp51 (net437 RNb VDD NW) g45p1svt w=(310n) l=45n nf=1 m=(1)
mp55 (Q qbint VDD NW) g45p1svt w=(780n) l=45n nf=1 m=(1)
mp36 (n20 CKb net425 NW) g45p1svt w=(310n) l=45n nf=1 m=(1)
mp35 (net425 mout VDD NW) g45p1svt w=(310n) l=45n nf=1 m=(1)
mp32 (mout n20 net417 NW) g45p1svt w=(310n) l=45n nf=1 m=(1)
mp31 (net417 RNb VDD NW) g45p1svt w=(310n) l=45n nf=1 m=(1)
mp22 (RNb RN VDD NW) g45p1svt w=(215n) l=45n nf=1 m=(1)
mp20 (CKb CK VDD NW) g45p1svt w=(215n) l=45n nf=1 m=(1)
mp53 (n35 CKbb net394 NW) g45p1svt w=(310n) l=45n nf=1 m=(1)
mp50 (net394 SN VDD NW) g45p1svt w=(310n) l=45n nf=1 m=(1)
mp45 (qbint n35 VDD NW) g45p1svt w=(310n) l=45n nf=1 m=(1)
mp25 (n20 CKbb Db NW) g45p1svt w=(310n) l=45n nf=1 m=(1)
mp30 (mout SN VDD NW) g45p1svt w=(310n) l=45n nf=1 m=(1)
mp40 (n35 CKb mout NW) g45p1svt w=(310n) l=45n nf=1 m=(1)
mp21 (CKbb CKb VDD NW) g45p1svt w=(215n) l=45n nf=1 m=(1)
mp10 (SEb SE VDD NW) g45p1svt w=(215n) l=45n nf=1 m=(1)
ends SDFFSRHQX2

// gsclib045_backbias/SDFFSRHQX4/schematic

simulator lang=spectre

subckt SDFFSRHQX4 CK D Q RN SE SI SN VDD NW VSS
mn13 (net534 SI VSS VSS) g45n1svt w=(260n) l=45n nf=1 m=(1)
mn14 (Db SE net534 VSS) g45n1svt w=(260n) l=45n nf=1 m=(1)
mn12 (Db SEb net522 VSS) g45n1svt w=(260n) l=45n nf=1 m=(1)
mn11 (net522 D VSS VSS) g45n1svt w=(260n) l=45n nf=1 m=(1)
mn55 (Q qbint VSS VSS) g45n1svt w=(1.04u) l=45n nf=1 m=(1)
mn35 (net514 mout VSS VSS) g45n1svt w=(205n) l=45n nf=1 m=(1)
mn36 (n20 CKbb net514 VSS) g45n1svt w=(205n) l=45n nf=1 m=(1)
mn22 (RNb RN VSS VSS) g45n1svt w=(145n) l=45n nf=1 m=(1)
mn20 (CKb CK VSS VSS) g45n1svt w=(145n) l=45n nf=1 m=(1)
mn45 (qbint n35 VSS VSS) g45n1svt w=(410n) l=45n nf=1 m=(1)
mn52 (net490 qbint net486 VSS) g45n1svt w=(205n) l=45n nf=1 m=(1)
mn51 (net490 RNb net486 VSS) g45n1svt w=(205n) l=45n nf=1 m=(1)
mn50 (net486 SN VSS VSS) g45n1svt w=(205n) l=45n nf=1 m=(1)
mn53 (n35 CKb net490 VSS) g45n1svt w=(205n) l=45n nf=1 m=(1)
mn10 (SEb SE VSS VSS) g45n1svt w=(145n) l=45n nf=1 m=(1)
mn25 (Db CKb n20 VSS) g45n1svt w=(205n) l=45n nf=1 m=(1)
mn30 (net469 SN VSS VSS) g45n1svt w=(205n) l=45n nf=1 m=(1)
mn32 (mout n20 net469 VSS) g45n1svt w=(205n) l=45n nf=1 m=(1)
mn31 (mout RNb net469 VSS) g45n1svt w=(205n) l=45n nf=1 m=(1)
mn40 (n35 CKbb mout VSS) g45n1svt w=(205n) l=45n nf=1 m=(1)
mn21 (CKbb CKb VSS VSS) g45n1svt w=(145n) l=45n nf=1 m=(1)
mp14 (Db SEb net453 NW) g45p1svt w=(390n) l=45n nf=1 m=(1)
mp13 (net453 SI VDD NW) g45p1svt w=(390n) l=45n nf=1 m=(1)
mp12 (Db SE net445 NW) g45p1svt w=(390n) l=45n nf=1 m=(1)
mp11 (net445 D VDD NW) g45p1svt w=(390n) l=45n nf=1 m=(1)
mp52 (net394 qbint net437 NW) g45p1svt w=(310n) l=45n nf=1 m=(1)
mp51 (net437 RNb VDD NW) g45p1svt w=(310n) l=45n nf=1 m=(1)
mp55 (Q qbint VDD NW) g45p1svt w=(1.56u) l=45n nf=1 m=(1)
mp36 (n20 CKb net425 NW) g45p1svt w=(310n) l=45n nf=1 m=(1)
mp35 (net425 mout VDD NW) g45p1svt w=(310n) l=45n nf=1 m=(1)
mp32 (mout n20 net417 NW) g45p1svt w=(310n) l=45n nf=1 m=(1)
mp31 (net417 RNb VDD NW) g45p1svt w=(310n) l=45n nf=1 m=(1)
mp22 (RNb RN VDD NW) g45p1svt w=(215n) l=45n nf=1 m=(1)
mp20 (CKb CK VDD NW) g45p1svt w=(215n) l=45n nf=1 m=(1)
mp53 (n35 CKbb net394 NW) g45p1svt w=(310n) l=45n nf=1 m=(1)
mp50 (net394 SN VDD NW) g45p1svt w=(310n) l=45n nf=1 m=(1)
mp45 (qbint n35 VDD NW) g45p1svt w=(620n) l=45n nf=1 m=(1)
mp25 (n20 CKbb Db NW) g45p1svt w=(310n) l=45n nf=1 m=(1)
mp30 (mout SN VDD NW) g45p1svt w=(310n) l=45n nf=1 m=(1)
mp40 (n35 CKb mout NW) g45p1svt w=(310n) l=45n nf=1 m=(1)
mp21 (CKbb CKb VDD NW) g45p1svt w=(215n) l=45n nf=1 m=(1)
mp10 (SEb SE VDD NW) g45p1svt w=(215n) l=45n nf=1 m=(1)
ends SDFFSRHQX4

// gsclib045_backbias/SDFFSRHQX8/schematic

simulator lang=spectre

subckt SDFFSRHQX8 CK D Q RN SE SI SN VDD VSS NW
mn13 (net534 SI VSS VSS) g45n1svt w=(260n) l=45n nf=1 m=(1)
mn14 (Db SE net534 VSS) g45n1svt w=(260n) l=45n nf=1 m=(1)
mn12 (Db SEb net522 VSS) g45n1svt w=(260n) l=45n nf=1 m=(1)
mn11 (net522 D VSS VSS) g45n1svt w=(260n) l=45n nf=1 m=(1)
mn55 (Q qbint VSS VSS) g45n1svt w=(2.065u) l=45n nf=1 m=(1)
mn35 (net514 mout VSS VSS) g45n1svt w=(205n) l=45n nf=1 m=(1)
mn36 (n20 CKbb net514 VSS) g45n1svt w=(205n) l=45n nf=1 m=(1)
mn22 (RNb RN VSS VSS) g45n1svt w=(145n) l=45n nf=1 m=(1)
mn20 (CKb CK VSS VSS) g45n1svt w=(145n) l=45n nf=1 m=(1)
mn45 (qbint n35 VSS VSS) g45n1svt w=(780n) l=45n nf=1 m=(1)
mn52 (net490 qbint net486 VSS) g45n1svt w=(205n) l=45n nf=1 m=(1)
mn51 (net490 RNb net486 VSS) g45n1svt w=(205n) l=45n nf=1 m=(1)
mn50 (net486 SN VSS VSS) g45n1svt w=(205n) l=45n nf=1 m=(1)
mn53 (n35 CKb net490 VSS) g45n1svt w=(205n) l=45n nf=1 m=(1)
mn10 (SEb SE VSS VSS) g45n1svt w=(145n) l=45n nf=1 m=(1)
mn25 (Db CKb n20 VSS) g45n1svt w=(205n) l=45n nf=1 m=(1)
mn30 (net469 SN VSS VSS) g45n1svt w=(205n) l=45n nf=1 m=(1)
mn32 (mout n20 net469 VSS) g45n1svt w=(205n) l=45n nf=1 m=(1)
mn31 (mout RNb net469 VSS) g45n1svt w=(205n) l=45n nf=1 m=(1)
mn40 (n35 CKbb mout VSS) g45n1svt w=(205n) l=45n nf=1 m=(1)
mn21 (CKbb CKb VSS VSS) g45n1svt w=(145n) l=45n nf=1 m=(1)
mp14 (Db SEb net453 NW) g45p1svt w=(390n) l=45n nf=1 m=(1)
mp13 (net453 SI VDD NW) g45p1svt w=(390n) l=45n nf=1 m=(1)
mp12 (Db SE net445 NW) g45p1svt w=(390n) l=45n nf=1 m=(1)
mp11 (net445 D VDD NW) g45p1svt w=(390n) l=45n nf=1 m=(1)
mp52 (net394 qbint net437 NW) g45p1svt w=(310n) l=45n nf=1 m=(1)
mp51 (net437 RNb VDD NW) g45p1svt w=(310n) l=45n nf=1 m=(1)
mp55 (Q qbint VDD NW) g45p1svt w=(3.115u) l=45n nf=1 m=(1)
mp36 (n20 CKb net425 NW) g45p1svt w=(310n) l=45n nf=1 m=(1)
mp35 (net425 mout VDD NW) g45p1svt w=(310n) l=45n nf=1 m=(1)
mp32 (mout n20 net417 NW) g45p1svt w=(310n) l=45n nf=1 m=(1)
mp31 (net417 RNb VDD NW) g45p1svt w=(310n) l=45n nf=1 m=(1)
mp22 (RNb RN VDD NW) g45p1svt w=(215n) l=45n nf=1 m=(1)
mp20 (CKb CK VDD NW) g45p1svt w=(215n) l=45n nf=1 m=(1)
mp53 (n35 CKbb net394 NW) g45p1svt w=(310n) l=45n nf=1 m=(1)
mp50 (net394 SN VDD NW) g45p1svt w=(310n) l=45n nf=1 m=(1)
mp45 (qbint n35 VDD NW) g45p1svt w=(1.17u) l=45n nf=1 m=(1)
mp25 (n20 CKbb Db NW) g45p1svt w=(310n) l=45n nf=1 m=(1)
mp30 (mout SN VDD NW) g45p1svt w=(310n) l=45n nf=1 m=(1)
mp40 (n35 CKb mout NW) g45p1svt w=(310n) l=45n nf=1 m=(1)
mp21 (CKbb CKb VDD NW) g45p1svt w=(215n) l=45n nf=1 m=(1)
mp10 (SEb SE VDD NW) g45p1svt w=(215n) l=45n nf=1 m=(1)
ends SDFFSRHQX8

// gsclib045_backbias/SDFFSRX1/schematic

simulator lang=spectre

subckt SDFFSRX1 CK D Q QN RN SE SI SN VSS VDD NW
mn13 (n2 SI VSS VSS) g45n1svt w=(145n) l=45n nf=1 m=(1)
mn14 (Db SE n2 VSS) g45n1svt w=(145n) l=45n nf=1 m=(1)
mn12 (Db SEb n0 VSS) g45n1svt w=(145n) l=45n nf=1 m=(1)
mn11 (n0 D VSS VSS) g45n1svt w=(145n) l=45n nf=1 m=(1)
mn57 (QN net573 VSS VSS) g45n1svt w=(260n) l=45n nf=1 m=(1)
mn55 (Q qbint VSS VSS) g45n1svt w=(260n) l=45n nf=1 m=(1)
mn35 (n6 mout VSS VSS) g45n1svt w=(145n) l=45n nf=1 m=(1)
mn36 (n20 CKbb n6 VSS) g45n1svt w=(145n) l=45n nf=1 m=(1)
mn22 (RNb RN VSS VSS) g45n1svt w=(145n) l=45n nf=1 m=(1)
mn20 (CKb CK VSS VSS) g45n1svt w=(145n) l=45n nf=1 m=(1)
mn10 (SEb SE VSS VSS) g45n1svt w=(145n) l=45n nf=1 m=(1)
mn56 (net573 qbint VSS VSS) g45n1svt w=(145n) l=45n nf=1 m=(1)
mn25 (Db CKb n20 VSS) g45n1svt w=(145n) l=45n nf=1 m=(1)
mn32 (mout n20 n4 VSS) g45n1svt w=(145n) l=45n nf=1 m=(1)
mn53 (n35 CKb n10 VSS) g45n1svt w=(145n) l=45n nf=1 m=(1)
mn30 (n4 SN VSS VSS) g45n1svt w=(145n) l=45n nf=1 m=(1)
mn50 (n8 SN VSS VSS) g45n1svt w=(145n) l=45n nf=1 m=(1)
mn51 (n10 RNb n8 VSS) g45n1svt w=(145n) l=45n nf=1 m=(1)
mn40 (n35 CKbb mout VSS) g45n1svt w=(145n) l=45n nf=1 m=(1)
mn31 (mout RNb n4 VSS) g45n1svt w=(145n) l=45n nf=1 m=(1)
mn21 (CKbb CKb VSS VSS) g45n1svt w=(145n) l=45n nf=1 m=(1)
mn52 (n10 qbint n8 VSS) g45n1svt w=(145n) l=45n nf=1 m=(1)
mn45 (qbint n35 VSS VSS) g45n1svt w=(145n) l=45n nf=1 m=(1)
mp14 (Db SEb n3 NW) g45p1svt w=(215n) l=45n nf=1 m=(1)
mp13 (n3 SI VDD NW) g45p1svt w=(215n) l=45n nf=1 m=(1)
mp12 (Db SE n1 NW) g45p1svt w=(215n) l=45n nf=1 m=(1)
mp11 (n1 D VDD NW) g45p1svt w=(215n) l=45n nf=1 m=(1)
mp52 (n11 qbint n9 NW) g45p1svt w=(215n) l=45n nf=1 m=(1)
mp51 (n9 RNb VDD NW) g45p1svt w=(215n) l=45n nf=1 m=(1)
mp57 (QN net573 VDD NW) g45p1svt w=(390n) l=45n nf=1 m=(1)
mp55 (Q qbint VDD NW) g45p1svt w=(390n) l=45n nf=1 m=(1)
mp36 (n20 CKb n7 NW) g45p1svt w=(215n) l=45n nf=1 m=(1)
mp35 (n7 mout VDD NW) g45p1svt w=(215n) l=45n nf=1 m=(1)
mp32 (mout n20 n5 NW) g45p1svt w=(215n) l=45n nf=1 m=(1)
mp31 (n5 RNb VDD NW) g45p1svt w=(215n) l=45n nf=1 m=(1)
mp22 (RNb RN VDD NW) g45p1svt w=(215n) l=45n nf=1 m=(1)
mp20 (CKb CK VDD NW) g45p1svt w=(215n) l=45n nf=1 m=(1)
mp21 (CKbb CKb VDD NW) g45p1svt w=(215n) l=45n nf=1 m=(1)
mp45 (qbint n35 VDD NW) g45p1svt w=(215n) l=45n nf=1 m=(1)
mp30 (mout SN VDD NW) g45p1svt w=(215n) l=45n nf=1 m=(1)
mp25 (n20 CKbb Db NW) g45p1svt w=(215n) l=45n nf=1 m=(1)
mp56 (net573 qbint VDD NW) g45p1svt w=(215n) l=45n nf=1 m=(1)
mp40 (n35 CKb mout NW) g45p1svt w=(215n) l=45n nf=1 m=(1)
mp53 (n35 CKbb n11 NW) g45p1svt w=(215n) l=45n nf=1 m=(1)
mp50 (n11 SN VDD NW) g45p1svt w=(215n) l=45n nf=1 m=(1)
mp10 (SEb SE VDD NW) g45p1svt w=(215n) l=45n nf=1 m=(1)
ends SDFFSRX1

// gsclib045_backbias/SDFFSRX2/schematic

simulator lang=spectre

subckt SDFFSRX2 CK D Q QN RN SE SI SN VSS VDD NW
mn13 (n2 SI VSS VSS) g45n1svt w=(145n) l=45n nf=1 m=(1)
mn14 (Db SE n2 VSS) g45n1svt w=(145n) l=45n nf=1 m=(1)
mn12 (Db SEb n0 VSS) g45n1svt w=(145n) l=45n nf=1 m=(1)
mn11 (n0 D VSS VSS) g45n1svt w=(145n) l=45n nf=1 m=(1)
mn57 (QN net573 VSS VSS) g45n1svt w=(520n) l=45n nf=1 m=(1)
mn55 (Q qbint VSS VSS) g45n1svt w=(520n) l=45n nf=1 m=(1)
mn35 (n6 mout VSS VSS) g45n1svt w=(145n) l=45n nf=1 m=(1)
mn36 (n20 CKbb n6 VSS) g45n1svt w=(145n) l=45n nf=1 m=(1)
mn22 (RNb RN VSS VSS) g45n1svt w=(145n) l=45n nf=1 m=(1)
mn20 (CKb CK VSS VSS) g45n1svt w=(145n) l=45n nf=1 m=(1)
mn10 (SEb SE VSS VSS) g45n1svt w=(145n) l=45n nf=1 m=(1)
mn56 (net573 qbint VSS VSS) g45n1svt w=(145n) l=45n nf=1 m=(1)
mn25 (Db CKb n20 VSS) g45n1svt w=(145n) l=45n nf=1 m=(1)
mn32 (mout n20 n4 VSS) g45n1svt w=(145n) l=45n nf=1 m=(1)
mn53 (n35 CKb n10 VSS) g45n1svt w=(145n) l=45n nf=1 m=(1)
mn30 (n4 SN VSS VSS) g45n1svt w=(145n) l=45n nf=1 m=(1)
mn50 (n8 SN VSS VSS) g45n1svt w=(145n) l=45n nf=1 m=(1)
mn51 (n10 RNb n8 VSS) g45n1svt w=(145n) l=45n nf=1 m=(1)
mn40 (n35 CKbb mout VSS) g45n1svt w=(145n) l=45n nf=1 m=(1)
mn31 (mout RNb n4 VSS) g45n1svt w=(145n) l=45n nf=1 m=(1)
mn21 (CKbb CKb VSS VSS) g45n1svt w=(145n) l=45n nf=1 m=(1)
mn52 (n10 qbint n8 VSS) g45n1svt w=(145n) l=45n nf=1 m=(1)
mn45 (qbint n35 VSS VSS) g45n1svt w=(205n) l=45n nf=1 m=(1)
mp14 (Db SEb n3 NW) g45p1svt w=(215n) l=45n nf=1 m=(1)
mp13 (n3 SI VDD NW) g45p1svt w=(215n) l=45n nf=1 m=(1)
mp12 (Db SE n1 NW) g45p1svt w=(215n) l=45n nf=1 m=(1)
mp11 (n1 D VDD NW) g45p1svt w=(215n) l=45n nf=1 m=(1)
mp52 (n11 qbint n9 NW) g45p1svt w=(215n) l=45n nf=1 m=(1)
mp51 (n9 RNb VDD NW) g45p1svt w=(215n) l=45n nf=1 m=(1)
mp57 (QN net573 VDD NW) g45p1svt w=(780n) l=45n nf=1 m=(1)
mp55 (Q qbint VDD NW) g45p1svt w=(780n) l=45n nf=1 m=(1)
mp36 (n20 CKb n7 NW) g45p1svt w=(215n) l=45n nf=1 m=(1)
mp35 (n7 mout VDD NW) g45p1svt w=(215n) l=45n nf=1 m=(1)
mp32 (mout n20 n5 NW) g45p1svt w=(215n) l=45n nf=1 m=(1)
mp31 (n5 RNb VDD NW) g45p1svt w=(215n) l=45n nf=1 m=(1)
mp22 (RNb RN VDD NW) g45p1svt w=(215n) l=45n nf=1 m=(1)
mp20 (CKb CK VDD NW) g45p1svt w=(215n) l=45n nf=1 m=(1)
mp21 (CKbb CKb VDD NW) g45p1svt w=(215n) l=45n nf=1 m=(1)
mp45 (qbint n35 VDD NW) g45p1svt w=(310n) l=45n nf=1 m=(1)
mp30 (mout SN VDD NW) g45p1svt w=(215n) l=45n nf=1 m=(1)
mp25 (n20 CKbb Db NW) g45p1svt w=(215n) l=45n nf=1 m=(1)
mp56 (net573 qbint VDD NW) g45p1svt w=(215n) l=45n nf=1 m=(1)
mp40 (n35 CKb mout NW) g45p1svt w=(215n) l=45n nf=1 m=(1)
mp53 (n35 CKbb n11 NW) g45p1svt w=(215n) l=45n nf=1 m=(1)
mp50 (n11 SN VDD NW) g45p1svt w=(215n) l=45n nf=1 m=(1)
mp10 (SEb SE VDD NW) g45p1svt w=(215n) l=45n nf=1 m=(1)
ends SDFFSRX2

// gsclib045_backbias/SDFFSRX4/schematic

simulator lang=spectre

subckt SDFFSRX4 CK D Q QN RN SE SI SN VSS VDD NW
mn13 (n2 SI VSS VSS) g45n1svt w=(145n) l=45n nf=1 m=(1)
mn14 (Db SE n2 VSS) g45n1svt w=(145n) l=45n nf=1 m=(1)
mn12 (Db SEb n0 VSS) g45n1svt w=(145n) l=45n nf=1 m=(1)
mn11 (n0 D VSS VSS) g45n1svt w=(145n) l=45n nf=1 m=(1)
mn57 (QN net573 VSS VSS) g45n1svt w=(1.04u) l=45n nf=1 m=(1)
mn55 (Q qbint VSS VSS) g45n1svt w=(1.04u) l=45n nf=1 m=(1)
mn35 (n6 mout VSS VSS) g45n1svt w=(145n) l=45n nf=1 m=(1)
mn36 (n20 CKbb n6 VSS) g45n1svt w=(145n) l=45n nf=1 m=(1)
mn22 (RNb RN VSS VSS) g45n1svt w=(145n) l=45n nf=1 m=(1)
mn20 (CKb CK VSS VSS) g45n1svt w=(145n) l=45n nf=1 m=(1)
mn10 (SEb SE VSS VSS) g45n1svt w=(145n) l=45n nf=1 m=(1)
mn56 (net573 qbint VSS VSS) g45n1svt w=(260n) l=45n nf=1 m=(1)
mn25 (Db CKb n20 VSS) g45n1svt w=(145n) l=45n nf=1 m=(1)
mn32 (mout n20 n4 VSS) g45n1svt w=(145n) l=45n nf=1 m=(1)
mn53 (n35 CKb n10 VSS) g45n1svt w=(145n) l=45n nf=1 m=(1)
mn30 (n4 SN VSS VSS) g45n1svt w=(145n) l=45n nf=1 m=(1)
mn50 (n8 SN VSS VSS) g45n1svt w=(145n) l=45n nf=1 m=(1)
mn51 (n10 RNb n8 VSS) g45n1svt w=(145n) l=45n nf=1 m=(1)
mn40 (n35 CKbb mout VSS) g45n1svt w=(145n) l=45n nf=1 m=(1)
mn31 (mout RNb n4 VSS) g45n1svt w=(145n) l=45n nf=1 m=(1)
mn21 (CKbb CKb VSS VSS) g45n1svt w=(145n) l=45n nf=1 m=(1)
mn52 (n10 qbint n8 VSS) g45n1svt w=(145n) l=45n nf=1 m=(1)
mn45 (qbint n35 VSS VSS) g45n1svt w=(410n) l=45n nf=1 m=(1)
mp14 (Db SEb n3 NW) g45p1svt w=(215n) l=45n nf=1 m=(1)
mp13 (n3 SI VDD NW) g45p1svt w=(215n) l=45n nf=1 m=(1)
mp12 (Db SE n1 NW) g45p1svt w=(215n) l=45n nf=1 m=(1)
mp11 (n1 D VDD NW) g45p1svt w=(215n) l=45n nf=1 m=(1)
mp52 (n11 qbint n9 NW) g45p1svt w=(215n) l=45n nf=1 m=(1)
mp51 (n9 RNb VDD NW) g45p1svt w=(215n) l=45n nf=1 m=(1)
mp57 (QN net573 VDD NW) g45p1svt w=(1.56u) l=45n nf=1 m=(1)
mp55 (Q qbint VDD NW) g45p1svt w=(1.56u) l=45n nf=1 m=(1)
mp36 (n20 CKb n7 NW) g45p1svt w=(215n) l=45n nf=1 m=(1)
mp35 (n7 mout VDD NW) g45p1svt w=(215n) l=45n nf=1 m=(1)
mp32 (mout n20 n5 NW) g45p1svt w=(215n) l=45n nf=1 m=(1)
mp31 (n5 RNb VDD NW) g45p1svt w=(215n) l=45n nf=1 m=(1)
mp22 (RNb RN VDD NW) g45p1svt w=(215n) l=45n nf=1 m=(1)
mp20 (CKb CK VDD NW) g45p1svt w=(215n) l=45n nf=1 m=(1)
mp21 (CKbb CKb VDD NW) g45p1svt w=(215n) l=45n nf=1 m=(1)
mp45 (qbint n35 VDD NW) g45p1svt w=(620n) l=45n nf=1 m=(1)
mp30 (mout SN VDD NW) g45p1svt w=(215n) l=45n nf=1 m=(1)
mp25 (n20 CKbb Db NW) g45p1svt w=(215n) l=45n nf=1 m=(1)
mp56 (net573 qbint VDD NW) g45p1svt w=(390n) l=45n nf=1 m=(1)
mp40 (n35 CKb mout NW) g45p1svt w=(215n) l=45n nf=1 m=(1)
mp53 (n35 CKbb n11 NW) g45p1svt w=(215n) l=45n nf=1 m=(1)
mp50 (n11 SN VDD NW) g45p1svt w=(215n) l=45n nf=1 m=(1)
mp10 (SEb SE VDD NW) g45p1svt w=(215n) l=45n nf=1 m=(1)
ends SDFFSRX4

// gsclib045_backbias/SDFFSRXL/schematic

simulator lang=spectre

subckt SDFFSRXL CK D Q QN RN SE SI SN VSS VDD NW
mn13 (n2 SI VSS VSS) g45n1svt w=(145n) l=45n nf=1 m=(1)
mn14 (Db SE n2 VSS) g45n1svt w=(145n) l=45n nf=1 m=(1)
mn12 (Db SEb n0 VSS) g45n1svt w=(145n) l=45n nf=1 m=(1)
mn11 (n0 D VSS VSS) g45n1svt w=(145n) l=45n nf=1 m=(1)
mn57 (QN net573 VSS VSS) g45n1svt w=(145n) l=45n nf=1 m=(1)
mn55 (Q qbint VSS VSS) g45n1svt w=(145n) l=45n nf=1 m=(1)
mn35 (n6 mout VSS VSS) g45n1svt w=(145n) l=45n nf=1 m=(1)
mn36 (n20 CKbb n6 VSS) g45n1svt w=(145n) l=45n nf=1 m=(1)
mn22 (RNb RN VSS VSS) g45n1svt w=(145n) l=45n nf=1 m=(1)
mn20 (CKb CK VSS VSS) g45n1svt w=(145n) l=45n nf=1 m=(1)
mn10 (SEb SE VSS VSS) g45n1svt w=(145n) l=45n nf=1 m=(1)
mn56 (net573 qbint VSS VSS) g45n1svt w=(145n) l=45n nf=1 m=(1)
mn25 (Db CKb n20 VSS) g45n1svt w=(145n) l=45n nf=1 m=(1)
mn32 (mout n20 n4 VSS) g45n1svt w=(145n) l=45n nf=1 m=(1)
mn53 (n35 CKb n10 VSS) g45n1svt w=(145n) l=45n nf=1 m=(1)
mn30 (n4 SN VSS VSS) g45n1svt w=(145n) l=45n nf=1 m=(1)
mn50 (n8 SN VSS VSS) g45n1svt w=(145n) l=45n nf=1 m=(1)
mn51 (n10 RNb n8 VSS) g45n1svt w=(145n) l=45n nf=1 m=(1)
mn40 (n35 CKbb mout VSS) g45n1svt w=(145n) l=45n nf=1 m=(1)
mn31 (mout RNb n4 VSS) g45n1svt w=(145n) l=45n nf=1 m=(1)
mn21 (CKbb CKb VSS VSS) g45n1svt w=(145n) l=45n nf=1 m=(1)
mn52 (n10 qbint n8 VSS) g45n1svt w=(145n) l=45n nf=1 m=(1)
mn45 (qbint n35 VSS VSS) g45n1svt w=(145n) l=45n nf=1 m=(1)
mp14 (Db SEb n3 NW) g45p1svt w=(215n) l=45n nf=1 m=(1)
mp13 (n3 SI VDD NW) g45p1svt w=(215n) l=45n nf=1 m=(1)
mp12 (Db SE n1 NW) g45p1svt w=(215n) l=45n nf=1 m=(1)
mp11 (n1 D VDD NW) g45p1svt w=(215n) l=45n nf=1 m=(1)
mp52 (n11 qbint n9 NW) g45p1svt w=(215n) l=45n nf=1 m=(1)
mp51 (n9 RNb VDD NW) g45p1svt w=(215n) l=45n nf=1 m=(1)
mp57 (QN net573 VDD NW) g45p1svt w=(215n) l=45n nf=1 m=(1)
mp55 (Q qbint VDD NW) g45p1svt w=(215n) l=45n nf=1 m=(1)
mp36 (n20 CKb n7 NW) g45p1svt w=(215n) l=45n nf=1 m=(1)
mp35 (n7 mout VDD NW) g45p1svt w=(215n) l=45n nf=1 m=(1)
mp32 (mout n20 n5 NW) g45p1svt w=(215n) l=45n nf=1 m=(1)
mp31 (n5 RNb VDD NW) g45p1svt w=(215n) l=45n nf=1 m=(1)
mp22 (RNb RN VDD NW) g45p1svt w=(215n) l=45n nf=1 m=(1)
mp20 (CKb CK VDD NW) g45p1svt w=(215n) l=45n nf=1 m=(1)
mp21 (CKbb CKb VDD NW) g45p1svt w=(215n) l=45n nf=1 m=(1)
mp45 (qbint n35 VDD NW) g45p1svt w=(215n) l=45n nf=1 m=(1)
mp30 (mout SN VDD NW) g45p1svt w=(215n) l=45n nf=1 m=(1)
mp25 (n20 CKbb Db NW) g45p1svt w=(215n) l=45n nf=1 m=(1)
mp56 (net573 qbint VDD NW) g45p1svt w=(215n) l=45n nf=1 m=(1)
mp40 (n35 CKb mout NW) g45p1svt w=(215n) l=45n nf=1 m=(1)
mp53 (n35 CKbb n11 NW) g45p1svt w=(215n) l=45n nf=1 m=(1)
mp50 (n11 SN VDD NW) g45p1svt w=(215n) l=45n nf=1 m=(1)
mp10 (SEb SE VDD NW) g45p1svt w=(215n) l=45n nf=1 m=(1)
ends SDFFSRXL

// gsclib045_backbias/SDFFSX1/schematic

simulator lang=spectre

subckt SDFFSX1 CK D Q QN SE SI SN NW VDD VSS
mn51 (net518 qbint net521 VSS) g45n1svt w=(145n) l=45n nf=1 m=(1)
mn52 (n35 CKb net518 VSS) g45n1svt w=(145n) l=45n nf=1 m=(1)
mn50 (net521 SN VSS VSS) g45n1svt w=(145n) l=45n nf=1 m=(1)
mn13 (net506 SI VSS VSS) g45n1svt w=(145n) l=45n nf=1 m=(1)
mn14 (Db SE net506 VSS) g45n1svt w=(145n) l=45n nf=1 m=(1)
mn12 (Db SEb net494 VSS) g45n1svt w=(145n) l=45n nf=1 m=(1)
mn11 (net494 D VSS VSS) g45n1svt w=(145n) l=45n nf=1 m=(1)
mn57 (QN net492 VSS VSS) g45n1svt w=(260n) l=45n nf=1 m=(1)
mn55 (Q qbint VSS VSS) g45n1svt w=(260n) l=45n nf=1 m=(1)
mn31 (mout n20 net442 VSS) g45n1svt w=(145n) l=45n nf=1 m=(1)
mn35 (net478 mout VSS VSS) g45n1svt w=(145n) l=45n nf=1 m=(1)
mn36 (n20 CKbb net478 VSS) g45n1svt w=(145n) l=45n nf=1 m=(1)
mn20 (CKb CK VSS VSS) g45n1svt w=(145n) l=45n nf=1 m=(1)
mn45 (qbint n35 VSS VSS) g45n1svt w=(145n) l=45n nf=1 m=(1)
mn56 (net492 qbint VSS VSS) g45n1svt w=(145n) l=45n nf=1 m=(1)
mn21 (CKbb CKb VSS VSS) g45n1svt w=(145n) l=45n nf=1 m=(1)
mn40 (n35 CKbb mout VSS) g45n1svt w=(145n) l=45n nf=1 m=(1)
mn10 (SEb SE VSS VSS) g45n1svt w=(145n) l=45n nf=1 m=(1)
mn25 (Db CKb n20 VSS) g45n1svt w=(145n) l=45n nf=1 m=(1)
mn30 (net442 SN VSS VSS) g45n1svt w=(145n) l=45n nf=1 m=(1)
mp14 (Db SEb net441 NW) g45p1svt w=(215n) l=45n nf=1 m=(1)
mp13 (net441 SI VDD NW) g45p1svt w=(215n) l=45n nf=1 m=(1)
mp12 (Db SE net433 NW) g45p1svt w=(215n) l=45n nf=1 m=(1)
mp11 (net433 D VDD NW) g45p1svt w=(215n) l=45n nf=1 m=(1)
mp57 (QN net492 VDD NW) g45p1svt w=(390n) l=45n nf=1 m=(1)
mp55 (Q qbint VDD NW) g45p1svt w=(390n) l=45n nf=1 m=(1)
mp36 (n20 CKb net417 NW) g45p1svt w=(215n) l=45n nf=1 m=(1)
mp35 (net417 mout VDD NW) g45p1svt w=(215n) l=45n nf=1 m=(1)
mp20 (CKb CK VDD NW) g45p1svt w=(215n) l=45n nf=1 m=(1)
mp52 (n35 CKbb net405 NW) g45p1svt w=(215n) l=45n nf=1 m=(1)
mp51 (net405 qbint VDD NW) g45p1svt w=(215n) l=45n nf=1 m=(1)
mp50 (net405 SN VDD NW) g45p1svt w=(215n) l=45n nf=1 m=(1)
mp45 (qbint n35 VDD NW) g45p1svt w=(215n) l=45n nf=1 m=(1)
mp56 (net492 qbint VDD NW) g45p1svt w=(215n) l=45n nf=1 m=(1)
mp21 (CKbb CKb VDD NW) g45p1svt w=(215n) l=45n nf=1 m=(1)
mp40 (n35 CKb mout NW) g45p1svt w=(215n) l=45n nf=1 m=(1)
mp30 (mout SN VDD NW) g45p1svt w=(215n) l=45n nf=1 m=(1)
mp31 (mout n20 VDD NW) g45p1svt w=(215n) l=45n nf=1 m=(1)
mp25 (n20 CKbb Db NW) g45p1svt w=(215n) l=45n nf=1 m=(1)
mp10 (SEb SE VDD NW) g45p1svt w=(215n) l=45n nf=1 m=(1)
ends SDFFSX1

// gsclib045_backbias/SDFFSX2/schematic

simulator lang=spectre

subckt SDFFSX2 CK D Q QN SE SI SN VDD VSS NW
mn51 (net518 qbint net521 VSS) g45n1svt w=(145n) l=45n nf=1 m=(1)
mn52 (n35 CKb net518 VSS) g45n1svt w=(145n) l=45n nf=1 m=(1)
mn50 (net521 SN VSS VSS) g45n1svt w=(145n) l=45n nf=1 m=(1)
mn13 (net506 SI VSS VSS) g45n1svt w=(145n) l=45n nf=1 m=(1)
mn14 (Db SE net506 VSS) g45n1svt w=(145n) l=45n nf=1 m=(1)
mn12 (Db SEb net494 VSS) g45n1svt w=(145n) l=45n nf=1 m=(1)
mn11 (net494 D VSS VSS) g45n1svt w=(145n) l=45n nf=1 m=(1)
mn57 (QN net492 VSS VSS) g45n1svt w=(520n) l=45n nf=1 m=(1)
mn55 (Q qbint VSS VSS) g45n1svt w=(520n) l=45n nf=1 m=(1)
mn31 (mout n20 net442 VSS) g45n1svt w=(145n) l=45n nf=1 m=(1)
mn35 (net478 mout VSS VSS) g45n1svt w=(145n) l=45n nf=1 m=(1)
mn36 (n20 CKbb net478 VSS) g45n1svt w=(145n) l=45n nf=1 m=(1)
mn20 (CKb CK VSS VSS) g45n1svt w=(145n) l=45n nf=1 m=(1)
mn45 (qbint n35 VSS VSS) g45n1svt w=(205n) l=45n nf=1 m=(1)
mn56 (net492 qbint VSS VSS) g45n1svt w=(145n) l=45n nf=1 m=(1)
mn21 (CKbb CKb VSS VSS) g45n1svt w=(145n) l=45n nf=1 m=(1)
mn40 (n35 CKbb mout VSS) g45n1svt w=(145n) l=45n nf=1 m=(1)
mn10 (SEb SE VSS VSS) g45n1svt w=(145n) l=45n nf=1 m=(1)
mn25 (Db CKb n20 VSS) g45n1svt w=(145n) l=45n nf=1 m=(1)
mn30 (net442 SN VSS VSS) g45n1svt w=(145n) l=45n nf=1 m=(1)
mp14 (Db SEb net441 NW) g45p1svt w=(215n) l=45n nf=1 m=(1)
mp13 (net441 SI VDD NW) g45p1svt w=(215n) l=45n nf=1 m=(1)
mp12 (Db SE net433 NW) g45p1svt w=(215n) l=45n nf=1 m=(1)
mp11 (net433 D VDD NW) g45p1svt w=(215n) l=45n nf=1 m=(1)
mp57 (QN net492 VDD NW) g45p1svt w=(780n) l=45n nf=1 m=(1)
mp55 (Q qbint VDD NW) g45p1svt w=(780n) l=45n nf=1 m=(1)
mp36 (n20 CKb net417 NW) g45p1svt w=(215n) l=45n nf=1 m=(1)
mp35 (net417 mout VDD NW) g45p1svt w=(215n) l=45n nf=1 m=(1)
mp20 (CKb CK VDD NW) g45p1svt w=(215n) l=45n nf=1 m=(1)
mp52 (n35 CKbb net405 NW) g45p1svt w=(215n) l=45n nf=1 m=(1)
mp51 (net405 qbint VDD NW) g45p1svt w=(215n) l=45n nf=1 m=(1)
mp50 (net405 SN VDD NW) g45p1svt w=(215n) l=45n nf=1 m=(1)
mp45 (qbint n35 VDD NW) g45p1svt w=(310n) l=45n nf=1 m=(1)
mp56 (net492 qbint VDD NW) g45p1svt w=(215n) l=45n nf=1 m=(1)
mp21 (CKbb CKb VDD NW) g45p1svt w=(215n) l=45n nf=1 m=(1)
mp40 (n35 CKb mout NW) g45p1svt w=(215n) l=45n nf=1 m=(1)
mp30 (mout SN VDD NW) g45p1svt w=(215n) l=45n nf=1 m=(1)
mp31 (mout n20 VDD NW) g45p1svt w=(215n) l=45n nf=1 m=(1)
mp25 (n20 CKbb Db NW) g45p1svt w=(215n) l=45n nf=1 m=(1)
mp10 (SEb SE VDD NW) g45p1svt w=(215n) l=45n nf=1 m=(1)
ends SDFFSX2

// gsclib045_backbias/SDFFSX4/schematic

simulator lang=spectre

subckt SDFFSX4 CK D Q QN SE SI SN VDD VSS NW
mn51 (net518 qbint net521 VSS) g45n1svt w=(145n) l=45n nf=1 m=(1)
mn52 (n35 CKb net518 VSS) g45n1svt w=(145n) l=45n nf=1 m=(1)
mn50 (net521 SN VSS VSS) g45n1svt w=(145n) l=45n nf=1 m=(1)
mn13 (net506 SI VSS VSS) g45n1svt w=(145n) l=45n nf=1 m=(1)
mn14 (Db SE net506 VSS) g45n1svt w=(145n) l=45n nf=1 m=(1)
mn12 (Db SEb net494 VSS) g45n1svt w=(145n) l=45n nf=1 m=(1)
mn11 (net494 D VSS VSS) g45n1svt w=(145n) l=45n nf=1 m=(1)
mn57 (QN net492 VSS VSS) g45n1svt w=(1.04u) l=45n nf=1 m=(1)
mn55 (Q qbint VSS VSS) g45n1svt w=(1.04u) l=45n nf=1 m=(1)
mn31 (mout n20 net442 VSS) g45n1svt w=(145n) l=45n nf=1 m=(1)
mn35 (net478 mout VSS VSS) g45n1svt w=(145n) l=45n nf=1 m=(1)
mn36 (n20 CKbb net478 VSS) g45n1svt w=(145n) l=45n nf=1 m=(1)
mn20 (CKb CK VSS VSS) g45n1svt w=(145n) l=45n nf=1 m=(1)
mn45 (qbint n35 VSS VSS) g45n1svt w=(410n) l=45n nf=1 m=(1)
mn56 (net492 qbint VSS VSS) g45n1svt w=(260n) l=45n nf=1 m=(1)
mn21 (CKbb CKb VSS VSS) g45n1svt w=(145n) l=45n nf=1 m=(1)
mn40 (n35 CKbb mout VSS) g45n1svt w=(145n) l=45n nf=1 m=(1)
mn10 (SEb SE VSS VSS) g45n1svt w=(145n) l=45n nf=1 m=(1)
mn25 (Db CKb n20 VSS) g45n1svt w=(145n) l=45n nf=1 m=(1)
mn30 (net442 SN VSS VSS) g45n1svt w=(145n) l=45n nf=1 m=(1)
mp14 (Db SEb net441 NW) g45p1svt w=(215n) l=45n nf=1 m=(1)
mp13 (net441 SI VDD NW) g45p1svt w=(215n) l=45n nf=1 m=(1)
mp12 (Db SE net433 NW) g45p1svt w=(215n) l=45n nf=1 m=(1)
mp11 (net433 D VDD NW) g45p1svt w=(215n) l=45n nf=1 m=(1)
mp57 (QN net492 VDD NW) g45p1svt w=(1.56u) l=45n nf=1 m=(1)
mp55 (Q qbint VDD NW) g45p1svt w=(1.56u) l=45n nf=1 m=(1)
mp36 (n20 CKb net417 NW) g45p1svt w=(215n) l=45n nf=1 m=(1)
mp35 (net417 mout VDD NW) g45p1svt w=(215n) l=45n nf=1 m=(1)
mp20 (CKb CK VDD NW) g45p1svt w=(215n) l=45n nf=1 m=(1)
mp52 (n35 CKbb net405 NW) g45p1svt w=(215n) l=45n nf=1 m=(1)
mp51 (net405 qbint VDD NW) g45p1svt w=(215n) l=45n nf=1 m=(1)
mp50 (net405 SN VDD NW) g45p1svt w=(215n) l=45n nf=1 m=(1)
mp45 (qbint n35 VDD NW) g45p1svt w=(620n) l=45n nf=1 m=(1)
mp56 (net492 qbint VDD NW) g45p1svt w=(390n) l=45n nf=1 m=(1)
mp21 (CKbb CKb VDD NW) g45p1svt w=(215n) l=45n nf=1 m=(1)
mp40 (n35 CKb mout NW) g45p1svt w=(215n) l=45n nf=1 m=(1)
mp30 (mout SN VDD NW) g45p1svt w=(215n) l=45n nf=1 m=(1)
mp31 (mout n20 VDD NW) g45p1svt w=(215n) l=45n nf=1 m=(1)
mp25 (n20 CKbb Db NW) g45p1svt w=(215n) l=45n nf=1 m=(1)
mp10 (SEb SE VDD NW) g45p1svt w=(215n) l=45n nf=1 m=(1)
ends SDFFSX4

// gsclib045_backbias/SDFFSXL/schematic

simulator lang=spectre

subckt SDFFSXL CK D Q QN SE SI SN VDD VSS NW
mn51 (net518 qbint net521 VSS) g45n1svt w=(145n) l=45n nf=1 m=(1)
mn52 (n35 CKb net518 VSS) g45n1svt w=(145n) l=45n nf=1 m=(1)
mn50 (net521 SN VSS VSS) g45n1svt w=(145n) l=45n nf=1 m=(1)
mn13 (net506 SI VSS VSS) g45n1svt w=(145n) l=45n nf=1 m=(1)
mn14 (Db SE net506 VSS) g45n1svt w=(145n) l=45n nf=1 m=(1)
mn12 (Db SEb net494 VSS) g45n1svt w=(145n) l=45n nf=1 m=(1)
mn11 (net494 D VSS VSS) g45n1svt w=(145n) l=45n nf=1 m=(1)
mn57 (QN net492 VSS VSS) g45n1svt w=(145n) l=45n nf=1 m=(1)
mn55 (Q qbint VSS VSS) g45n1svt w=(145n) l=45n nf=1 m=(1)
mn31 (mout n20 net442 VSS) g45n1svt w=(145n) l=45n nf=1 m=(1)
mn35 (net478 mout VSS VSS) g45n1svt w=(145n) l=45n nf=1 m=(1)
mn36 (n20 CKbb net478 VSS) g45n1svt w=(145n) l=45n nf=1 m=(1)
mn20 (CKb CK VSS VSS) g45n1svt w=(145n) l=45n nf=1 m=(1)
mn45 (qbint n35 VSS VSS) g45n1svt w=(145n) l=45n nf=1 m=(1)
mn56 (net492 qbint VSS VSS) g45n1svt w=(145n) l=45n nf=1 m=(1)
mn21 (CKbb CKb VSS VSS) g45n1svt w=(145n) l=45n nf=1 m=(1)
mn40 (n35 CKbb mout VSS) g45n1svt w=(145n) l=45n nf=1 m=(1)
mn10 (SEb SE VSS VSS) g45n1svt w=(145n) l=45n nf=1 m=(1)
mn25 (Db CKb n20 VSS) g45n1svt w=(145n) l=45n nf=1 m=(1)
mn30 (net442 SN VSS VSS) g45n1svt w=(145n) l=45n nf=1 m=(1)
mp14 (Db SEb net441 NW) g45p1svt w=(215n) l=45n nf=1 m=(1)
mp13 (net441 SI VDD NW) g45p1svt w=(215n) l=45n nf=1 m=(1)
mp12 (Db SE net433 NW) g45p1svt w=(215n) l=45n nf=1 m=(1)
mp11 (net433 D VDD NW) g45p1svt w=(215n) l=45n nf=1 m=(1)
mp57 (QN net492 VDD NW) g45p1svt w=(215n) l=45n nf=1 m=(1)
mp55 (Q qbint VDD NW) g45p1svt w=(215n) l=45n nf=1 m=(1)
mp36 (n20 CKb net417 NW) g45p1svt w=(215n) l=45n nf=1 m=(1)
mp35 (net417 mout VDD NW) g45p1svt w=(215n) l=45n nf=1 m=(1)
mp20 (CKb CK VDD NW) g45p1svt w=(215n) l=45n nf=1 m=(1)
mp52 (n35 CKbb net405 NW) g45p1svt w=(215n) l=45n nf=1 m=(1)
mp51 (net405 qbint VDD NW) g45p1svt w=(215n) l=45n nf=1 m=(1)
mp50 (net405 SN VDD NW) g45p1svt w=(215n) l=45n nf=1 m=(1)
mp45 (qbint n35 VDD NW) g45p1svt w=(215n) l=45n nf=1 m=(1)
mp56 (net492 qbint VDD NW) g45p1svt w=(215n) l=45n nf=1 m=(1)
mp21 (CKbb CKb VDD NW) g45p1svt w=(215n) l=45n nf=1 m=(1)
mp40 (n35 CKb mout NW) g45p1svt w=(215n) l=45n nf=1 m=(1)
mp30 (mout SN VDD NW) g45p1svt w=(215n) l=45n nf=1 m=(1)
mp31 (mout n20 VDD NW) g45p1svt w=(215n) l=45n nf=1 m=(1)
mp25 (n20 CKbb Db NW) g45p1svt w=(215n) l=45n nf=1 m=(1)
mp10 (SEb SE VDD NW) g45p1svt w=(215n) l=45n nf=1 m=(1)
ends SDFFSXL

// gsclib045_backbias/SDFFTRX1/schematic

simulator lang=spectre

subckt SDFFTRX1 CK D Q QN RN SE SI VDD VSS NW
mn12 (net484 SI VSS VSS) g45n1svt w=(145n) l=45n nf=1 m=(1)
mn13 (Dbp SE net484 VSS) g45n1svt w=(145n) l=45n nf=1 m=(1)
mn0 (net476 RN VSS VSS) g45n1svt w=(145n) l=45n nf=1 m=(1)
mn1 (Db D net476 VSS) g45n1svt w=(145n) l=45n nf=1 m=(1)
mn57 (QN net436 VSS VSS) g45n1svt w=(260n) l=45n nf=1 m=(1)
mn55 (Q qbint VSS VSS) g45n1svt w=(260n) l=45n nf=1 m=(1)
mn50 (net460 qbint VSS VSS) g45n1svt w=(145n) l=45n nf=1 m=(1)
mn51 (n30 CKb net460 VSS) g45n1svt w=(145n) l=45n nf=1 m=(1)
mn35 (net452 mout VSS VSS) g45n1svt w=(145n) l=45n nf=1 m=(1)
mn36 (n20 CKbb net452 VSS) g45n1svt w=(145n) l=45n nf=1 m=(1)
mn20 (CKb CK VSS VSS) g45n1svt w=(145n) l=45n nf=1 m=(1)
mn45 (qbint n30 VSS VSS) g45n1svt w=(145n) l=45n nf=1 m=(1)
mn56 (net436 qbint VSS VSS) g45n1svt w=(145n) l=45n nf=1 m=(1)
mn11 (Db SEb Dbp VSS) g45n1svt w=(145n) l=45n nf=1 m=(1)
mn21 (CKbb CKb VSS VSS) g45n1svt w=(145n) l=45n nf=1 m=(1)
mn30 (mout n20 VSS VSS) g45n1svt w=(145n) l=45n nf=1 m=(1)
mn10 (SEb SE VSS VSS) g45n1svt w=(145n) l=45n nf=1 m=(1)
mn25 (Dbp CKb n20 VSS) g45n1svt w=(145n) l=45n nf=1 m=(1)
mn40 (n30 CKbb mout VSS) g45n1svt w=(145n) l=45n nf=1 m=(1)
mp13 (Dbp SEb net411 NW) g45p1svt w=(215n) l=45n nf=1 m=(1)
mp12 (net411 SI VDD NW) g45p1svt w=(215n) l=45n nf=1 m=(1)
mp1 (Db D VDD NW) g45p1svt w=(215n) l=45n nf=1 m=(1)
mp0 (Db RN VDD NW) g45p1svt w=(215n) l=45n nf=1 m=(1)
mp51 (n30 CKbb net395 NW) g45p1svt w=(215n) l=45n nf=1 m=(1)
mp50 (net395 qbint VDD NW) g45p1svt w=(215n) l=45n nf=1 m=(1)
mp57 (QN net436 VDD NW) g45p1svt w=(390n) l=45n nf=1 m=(1)
mp55 (Q qbint VDD NW) g45p1svt w=(390n) l=45n nf=1 m=(1)
mp35 (net375 mout VDD NW) g45p1svt w=(215n) l=45n nf=1 m=(1)
mp36 (n20 CKb net375 NW) g45p1svt w=(215n) l=45n nf=1 m=(1)
mp20 (CKb CK VDD NW) g45p1svt w=(215n) l=45n nf=1 m=(1)
mp45 (qbint n30 VDD NW) g45p1svt w=(215n) l=45n nf=1 m=(1)
mp56 (net436 qbint VDD NW) g45p1svt w=(215n) l=45n nf=1 m=(1)
mp25 (n20 CKbb Dbp NW) g45p1svt w=(215n) l=45n nf=1 m=(1)
mp11 (Dbp SE Db NW) g45p1svt w=(215n) l=45n nf=1 m=(1)
mp10 (SEb SE VDD NW) g45p1svt w=(215n) l=45n nf=1 m=(1)
mp21 (CKbb CKb VDD NW) g45p1svt w=(215n) l=45n nf=1 m=(1)
mp30 (mout n20 VDD NW) g45p1svt w=(215n) l=45n nf=1 m=(1)
mp40 (n30 CKb mout NW) g45p1svt w=(215n) l=45n nf=1 m=(1)
ends SDFFTRX1

// gsclib045_backbias/SDFFTRX2/schematic

simulator lang=spectre

subckt SDFFTRX2 CK D Q QN RN SE SI VDD VSS NW
mn12 (net484 SI VSS VSS) g45n1svt w=(145n) l=45n nf=1 m=(1)
mn13 (Dbp SE net484 VSS) g45n1svt w=(145n) l=45n nf=1 m=(1)
mn0 (net476 RN VSS VSS) g45n1svt w=(145n) l=45n nf=1 m=(1)
mn1 (Db D net476 VSS) g45n1svt w=(145n) l=45n nf=1 m=(1)
mn57 (QN net436 VSS VSS) g45n1svt w=(520n) l=45n nf=1 m=(1)
mn55 (Q qbint VSS VSS) g45n1svt w=(520n) l=45n nf=1 m=(1)
mn50 (net460 qbint VSS VSS) g45n1svt w=(145n) l=45n nf=1 m=(1)
mn51 (n30 CKb net460 VSS) g45n1svt w=(145n) l=45n nf=1 m=(1)
mn35 (net452 mout VSS VSS) g45n1svt w=(145n) l=45n nf=1 m=(1)
mn36 (n20 CKbb net452 VSS) g45n1svt w=(145n) l=45n nf=1 m=(1)
mn20 (CKb CK VSS VSS) g45n1svt w=(145n) l=45n nf=1 m=(1)
mn45 (qbint n30 VSS VSS) g45n1svt w=(205n) l=45n nf=1 m=(1)
mn56 (net436 qbint VSS VSS) g45n1svt w=(145n) l=45n nf=1 m=(1)
mn11 (Db SEb Dbp VSS) g45n1svt w=(145n) l=45n nf=1 m=(1)
mn21 (CKbb CKb VSS VSS) g45n1svt w=(145n) l=45n nf=1 m=(1)
mn30 (mout n20 VSS VSS) g45n1svt w=(145n) l=45n nf=1 m=(1)
mn10 (SEb SE VSS VSS) g45n1svt w=(145n) l=45n nf=1 m=(1)
mn25 (Dbp CKb n20 VSS) g45n1svt w=(145n) l=45n nf=1 m=(1)
mn40 (n30 CKbb mout VSS) g45n1svt w=(145n) l=45n nf=1 m=(1)
mp13 (Dbp SEb net411 NW) g45p1svt w=(215n) l=45n nf=1 m=(1)
mp12 (net411 SI VDD NW) g45p1svt w=(215n) l=45n nf=1 m=(1)
mp1 (Db D VDD NW) g45p1svt w=(215n) l=45n nf=1 m=(1)
mp0 (Db RN VDD NW) g45p1svt w=(215n) l=45n nf=1 m=(1)
mp51 (n30 CKbb net395 NW) g45p1svt w=(215n) l=45n nf=1 m=(1)
mp50 (net395 qbint VDD NW) g45p1svt w=(215n) l=45n nf=1 m=(1)
mp57 (QN net436 VDD NW) g45p1svt w=(780n) l=45n nf=1 m=(1)
mp55 (Q qbint VDD NW) g45p1svt w=(780n) l=45n nf=1 m=(1)
mp35 (net375 mout VDD NW) g45p1svt w=(215n) l=45n nf=1 m=(1)
mp36 (n20 CKb net375 NW) g45p1svt w=(215n) l=45n nf=1 m=(1)
mp20 (CKb CK VDD NW) g45p1svt w=(215n) l=45n nf=1 m=(1)
mp45 (qbint n30 VDD NW) g45p1svt w=(310n) l=45n nf=1 m=(1)
mp56 (net436 qbint VDD NW) g45p1svt w=(215n) l=45n nf=1 m=(1)
mp25 (n20 CKbb Dbp NW) g45p1svt w=(215n) l=45n nf=1 m=(1)
mp11 (Dbp SE Db NW) g45p1svt w=(215n) l=45n nf=1 m=(1)
mp10 (SEb SE VDD NW) g45p1svt w=(215n) l=45n nf=1 m=(1)
mp21 (CKbb CKb VDD NW) g45p1svt w=(215n) l=45n nf=1 m=(1)
mp30 (mout n20 VDD NW) g45p1svt w=(215n) l=45n nf=1 m=(1)
mp40 (n30 CKb mout NW) g45p1svt w=(215n) l=45n nf=1 m=(1)
ends SDFFTRX2

// gsclib045_backbias/SDFFTRX4/schematic

simulator lang=spectre

subckt SDFFTRX4 CK D Q QN RN SE SI VDD VSS NW
mn12 (net484 SI VSS VSS) g45n1svt w=(145n) l=45n nf=1 m=(1)
mn13 (Dbp SE net484 VSS) g45n1svt w=(145n) l=45n nf=1 m=(1)
mn0 (net476 RN VSS VSS) g45n1svt w=(145n) l=45n nf=1 m=(1)
mn1 (Db D net476 VSS) g45n1svt w=(145n) l=45n nf=1 m=(1)
mn57 (QN net436 VSS VSS) g45n1svt w=(1.04u) l=45n nf=1 m=(1)
mn55 (Q qbint VSS VSS) g45n1svt w=(1.04u) l=45n nf=1 m=(1)
mn50 (net460 qbint VSS VSS) g45n1svt w=(145n) l=45n nf=1 m=(1)
mn51 (n30 CKb net460 VSS) g45n1svt w=(145n) l=45n nf=1 m=(1)
mn35 (net452 mout VSS VSS) g45n1svt w=(145n) l=45n nf=1 m=(1)
mn36 (n20 CKbb net452 VSS) g45n1svt w=(145n) l=45n nf=1 m=(1)
mn20 (CKb CK VSS VSS) g45n1svt w=(145n) l=45n nf=1 m=(1)
mn45 (qbint n30 VSS VSS) g45n1svt w=(410n) l=45n nf=1 m=(1)
mn56 (net436 qbint VSS VSS) g45n1svt w=(260n) l=45n nf=1 m=(1)
mn11 (Db SEb Dbp VSS) g45n1svt w=(145n) l=45n nf=1 m=(1)
mn21 (CKbb CKb VSS VSS) g45n1svt w=(145n) l=45n nf=1 m=(1)
mn30 (mout n20 VSS VSS) g45n1svt w=(145n) l=45n nf=1 m=(1)
mn10 (SEb SE VSS VSS) g45n1svt w=(145n) l=45n nf=1 m=(1)
mn25 (Dbp CKb n20 VSS) g45n1svt w=(145n) l=45n nf=1 m=(1)
mn40 (n30 CKbb mout VSS) g45n1svt w=(145n) l=45n nf=1 m=(1)
mp13 (Dbp SEb net411 NW) g45p1svt w=(215n) l=45n nf=1 m=(1)
mp12 (net411 SI VDD NW) g45p1svt w=(215n) l=45n nf=1 m=(1)
mp1 (Db D VDD NW) g45p1svt w=(215n) l=45n nf=1 m=(1)
mp0 (Db RN VDD NW) g45p1svt w=(215n) l=45n nf=1 m=(1)
mp51 (n30 CKbb net395 NW) g45p1svt w=(215n) l=45n nf=1 m=(1)
mp50 (net395 qbint VDD NW) g45p1svt w=(215n) l=45n nf=1 m=(1)
mp57 (QN net436 VDD NW) g45p1svt w=(1.56u) l=45n nf=1 m=(1)
mp55 (Q qbint VDD NW) g45p1svt w=(1.56u) l=45n nf=1 m=(1)
mp35 (net375 mout VDD NW) g45p1svt w=(215n) l=45n nf=1 m=(1)
mp36 (n20 CKb net375 NW) g45p1svt w=(215n) l=45n nf=1 m=(1)
mp20 (CKb CK VDD NW) g45p1svt w=(215n) l=45n nf=1 m=(1)
mp45 (qbint n30 VDD NW) g45p1svt w=(620n) l=45n nf=1 m=(1)
mp56 (net436 qbint VDD NW) g45p1svt w=(390n) l=45n nf=1 m=(1)
mp25 (n20 CKbb Dbp NW) g45p1svt w=(215n) l=45n nf=1 m=(1)
mp11 (Dbp SE Db NW) g45p1svt w=(215n) l=45n nf=1 m=(1)
mp10 (SEb SE VDD NW) g45p1svt w=(215n) l=45n nf=1 m=(1)
mp21 (CKbb CKb VDD NW) g45p1svt w=(215n) l=45n nf=1 m=(1)
mp30 (mout n20 VDD NW) g45p1svt w=(215n) l=45n nf=1 m=(1)
mp40 (n30 CKb mout NW) g45p1svt w=(215n) l=45n nf=1 m=(1)
ends SDFFTRX4

// gsclib045_backbias/SDFFTRXL/schematic

simulator lang=spectre

subckt SDFFTRXL CK D Q QN RN SE SI VDD VSS NW
mn12 (net484 SI VSS VSS) g45n1svt w=(145n) l=45n nf=1 m=(1)
mn13 (Dbp SE net484 VSS) g45n1svt w=(145n) l=45n nf=1 m=(1)
mn0 (net476 RN VSS VSS) g45n1svt w=(145n) l=45n nf=1 m=(1)
mn1 (Db D net476 VSS) g45n1svt w=(145n) l=45n nf=1 m=(1)
mn57 (QN net436 VSS VSS) g45n1svt w=(145n) l=45n nf=1 m=(1)
mn55 (Q qbint VSS VSS) g45n1svt w=(145n) l=45n nf=1 m=(1)
mn50 (net460 qbint VSS VSS) g45n1svt w=(145n) l=45n nf=1 m=(1)
mn51 (n30 CKb net460 VSS) g45n1svt w=(145n) l=45n nf=1 m=(1)
mn35 (net452 mout VSS VSS) g45n1svt w=(145n) l=45n nf=1 m=(1)
mn36 (n20 CKbb net452 VSS) g45n1svt w=(145n) l=45n nf=1 m=(1)
mn20 (CKb CK VSS VSS) g45n1svt w=(145n) l=45n nf=1 m=(1)
mn45 (qbint n30 VSS VSS) g45n1svt w=(145n) l=45n nf=1 m=(1)
mn56 (net436 qbint VSS VSS) g45n1svt w=(145n) l=45n nf=1 m=(1)
mn11 (Db SEb Dbp VSS) g45n1svt w=(145n) l=45n nf=1 m=(1)
mn21 (CKbb CKb VSS VSS) g45n1svt w=(145n) l=45n nf=1 m=(1)
mn30 (mout n20 VSS VSS) g45n1svt w=(145n) l=45n nf=1 m=(1)
mn10 (SEb SE VSS VSS) g45n1svt w=(145n) l=45n nf=1 m=(1)
mn25 (Dbp CKb n20 VSS) g45n1svt w=(145n) l=45n nf=1 m=(1)
mn40 (n30 CKbb mout VSS) g45n1svt w=(145n) l=45n nf=1 m=(1)
mp13 (Dbp SEb net411 NW) g45p1svt w=(215n) l=45n nf=1 m=(1)
mp12 (net411 SI VDD NW) g45p1svt w=(215n) l=45n nf=1 m=(1)
mp1 (Db D VDD NW) g45p1svt w=(215n) l=45n nf=1 m=(1)
mp0 (Db RN VDD NW) g45p1svt w=(215n) l=45n nf=1 m=(1)
mp51 (n30 CKbb net395 NW) g45p1svt w=(215n) l=45n nf=1 m=(1)
mp50 (net395 qbint VDD NW) g45p1svt w=(215n) l=45n nf=1 m=(1)
mp57 (QN net436 VDD NW) g45p1svt w=(215n) l=45n nf=1 m=(1)
mp55 (Q qbint VDD NW) g45p1svt w=(215n) l=45n nf=1 m=(1)
mp35 (net375 mout VDD NW) g45p1svt w=(215n) l=45n nf=1 m=(1)
mp36 (n20 CKb net375 NW) g45p1svt w=(215n) l=45n nf=1 m=(1)
mp20 (CKb CK VDD NW) g45p1svt w=(215n) l=45n nf=1 m=(1)
mp45 (qbint n30 VDD NW) g45p1svt w=(215n) l=45n nf=1 m=(1)
mp56 (net436 qbint VDD NW) g45p1svt w=(215n) l=45n nf=1 m=(1)
mp25 (n20 CKbb Dbp NW) g45p1svt w=(215n) l=45n nf=1 m=(1)
mp11 (Dbp SE Db NW) g45p1svt w=(215n) l=45n nf=1 m=(1)
mp10 (SEb SE VDD NW) g45p1svt w=(215n) l=45n nf=1 m=(1)
mp21 (CKbb CKb VDD NW) g45p1svt w=(215n) l=45n nf=1 m=(1)
mp30 (mout n20 VDD NW) g45p1svt w=(215n) l=45n nf=1 m=(1)
mp40 (n30 CKb mout NW) g45p1svt w=(215n) l=45n nf=1 m=(1)
ends SDFFTRXL

// gsclib045_backbias/SDFFX1/schematic

simulator lang=spectre

subckt SDFFX1 CK D Q QN SE SI VDD VSS NW
mn13 (net461 SI VSS VSS) g45n1svt w=(145n) l=45n nf=1 m=(1)
mn14 (Db SE net461 VSS) g45n1svt w=(145n) l=45n nf=1 m=(1)
mn12 (Db SEb net449 VSS) g45n1svt w=(145n) l=45n nf=1 m=(1)
mn11 (net449 D VSS VSS) g45n1svt w=(145n) l=45n nf=1 m=(1)
mn57 (QN net367 VSS VSS) g45n1svt w=(260n) l=45n nf=1 m=(1)
mn55 (Q qbint VSS VSS) g45n1svt w=(260n) l=45n nf=1 m=(1)
mn50 (net436 qbint VSS VSS) g45n1svt w=(145n) l=45n nf=1 m=(1)
mn51 (n30 CKb net436 VSS) g45n1svt w=(145n) l=45n nf=1 m=(1)
mn35 (net429 mout VSS VSS) g45n1svt w=(145n) l=45n nf=1 m=(1)
mn36 (n20 CKbb net429 VSS) g45n1svt w=(145n) l=45n nf=1 m=(1)
mn20 (CKb CK VSS VSS) g45n1svt w=(145n) l=45n nf=1 m=(1)
mn45 (qbint n30 VSS VSS) g45n1svt w=(145n) l=45n nf=1 m=(1)
mn56 (net367 qbint VSS VSS) g45n1svt w=(145n) l=45n nf=1 m=(1)
mn21 (CKbb CKb VSS VSS) g45n1svt w=(145n) l=45n nf=1 m=(1)
mn40 (n30 CKbb mout VSS) g45n1svt w=(145n) l=45n nf=1 m=(1)
mn30 (mout n20 VSS VSS) g45n1svt w=(145n) l=45n nf=1 m=(1)
mn10 (SEb SE VSS VSS) g45n1svt w=(145n) l=45n nf=1 m=(1)
mn25 (n20 CKb Db VSS) g45n1svt w=(145n) l=45n nf=1 m=(1)
mp14 (Db SEb net392 NW) g45p1svt w=(215n) l=45n nf=1 m=(1)
mp13 (net392 SI VDD NW) g45p1svt w=(215n) l=45n nf=1 m=(1)
mp12 (Db SE net384 NW) g45p1svt w=(215n) l=45n nf=1 m=(1)
mp11 (net384 D VDD NW) g45p1svt w=(215n) l=45n nf=1 m=(1)
mp51 (n30 CKbb net376 NW) g45p1svt w=(215n) l=45n nf=1 m=(1)
mp50 (net376 qbint VDD NW) g45p1svt w=(215n) l=45n nf=1 m=(1)
mp57 (QN net367 VDD NW) g45p1svt w=(390n) l=45n nf=1 m=(1)
mp55 (Q qbint VDD NW) g45p1svt w=(390n) l=45n nf=1 m=(1)
mp35 (net356 mout VDD NW) g45p1svt w=(215n) l=45n nf=1 m=(1)
mp36 (n20 CKb net356 NW) g45p1svt w=(215n) l=45n nf=1 m=(1)
mp20 (CKb CK VDD NW) g45p1svt w=(215n) l=45n nf=1 m=(1)
mp45 (qbint n30 VDD NW) g45p1svt w=(215n) l=45n nf=1 m=(1)
mp56 (net367 qbint VDD NW) g45p1svt w=(215n) l=45n nf=1 m=(1)
mp21 (CKbb CKb VDD NW) g45p1svt w=(215n) l=45n nf=1 m=(1)
mp40 (n30 CKb mout NW) g45p1svt w=(215n) l=45n nf=1 m=(1)
mp30 (mout n20 VDD NW) g45p1svt w=(215n) l=45n nf=1 m=(1)
mp25 (n20 CKbb Db NW) g45p1svt w=(215n) l=45n nf=1 m=(1)
mp10 (SEb SE VDD NW) g45p1svt w=(215n) l=45n nf=1 m=(1)
ends SDFFX1

// gsclib045_backbias/SDFFX2/schematic

simulator lang=spectre

subckt SDFFX2 CK D Q QN SE SI VDD VSS NW
mn13 (net461 SI VSS VSS) g45n1svt w=(145n) l=45n nf=1 m=(1)
mn14 (Db SE net461 VSS) g45n1svt w=(145n) l=45n nf=1 m=(1)
mn12 (Db SEb net449 VSS) g45n1svt w=(145n) l=45n nf=1 m=(1)
mn11 (net449 D VSS VSS) g45n1svt w=(145n) l=45n nf=1 m=(1)
mn57 (QN net367 VSS VSS) g45n1svt w=(520n) l=45n nf=1 m=(1)
mn55 (Q qbint VSS VSS) g45n1svt w=(520n) l=45n nf=1 m=(1)
mn50 (net436 qbint VSS VSS) g45n1svt w=(145n) l=45n nf=1 m=(1)
mn51 (n30 CKb net436 VSS) g45n1svt w=(145n) l=45n nf=1 m=(1)
mn35 (net429 mout VSS VSS) g45n1svt w=(145n) l=45n nf=1 m=(1)
mn36 (n20 CKbb net429 VSS) g45n1svt w=(145n) l=45n nf=1 m=(1)
mn20 (CKb CK VSS VSS) g45n1svt w=(145n) l=45n nf=1 m=(1)
mn45 (qbint n30 VSS VSS) g45n1svt w=(205n) l=45n nf=1 m=(1)
mn56 (net367 qbint VSS VSS) g45n1svt w=(145n) l=45n nf=1 m=(1)
mn21 (CKbb CKb VSS VSS) g45n1svt w=(145n) l=45n nf=1 m=(1)
mn40 (n30 CKbb mout VSS) g45n1svt w=(145n) l=45n nf=1 m=(1)
mn30 (mout n20 VSS VSS) g45n1svt w=(145n) l=45n nf=1 m=(1)
mn10 (SEb SE VSS VSS) g45n1svt w=(145n) l=45n nf=1 m=(1)
mn25 (n20 CKb Db VSS) g45n1svt w=(145n) l=45n nf=1 m=(1)
mp14 (Db SEb net392 NW) g45p1svt w=(215n) l=45n nf=1 m=(1)
mp13 (net392 SI VDD NW) g45p1svt w=(215n) l=45n nf=1 m=(1)
mp12 (Db SE net384 NW) g45p1svt w=(215n) l=45n nf=1 m=(1)
mp11 (net384 D VDD NW) g45p1svt w=(215n) l=45n nf=1 m=(1)
mp51 (n30 CKbb net376 NW) g45p1svt w=(215n) l=45n nf=1 m=(1)
mp50 (net376 qbint VDD NW) g45p1svt w=(215n) l=45n nf=1 m=(1)
mp57 (QN net367 VDD NW) g45p1svt w=(780n) l=45n nf=1 m=(1)
mp55 (Q qbint VDD NW) g45p1svt w=(780n) l=45n nf=1 m=(1)
mp35 (net356 mout VDD NW) g45p1svt w=(215n) l=45n nf=1 m=(1)
mp36 (n20 CKb net356 NW) g45p1svt w=(215n) l=45n nf=1 m=(1)
mp20 (CKb CK VDD NW) g45p1svt w=(215n) l=45n nf=1 m=(1)
mp45 (qbint n30 VDD NW) g45p1svt w=(310n) l=45n nf=1 m=(1)
mp56 (net367 qbint VDD NW) g45p1svt w=(215n) l=45n nf=1 m=(1)
mp21 (CKbb CKb VDD NW) g45p1svt w=(215n) l=45n nf=1 m=(1)
mp40 (n30 CKb mout NW) g45p1svt w=(215n) l=45n nf=1 m=(1)
mp30 (mout n20 VDD NW) g45p1svt w=(215n) l=45n nf=1 m=(1)
mp25 (n20 CKbb Db NW) g45p1svt w=(215n) l=45n nf=1 m=(1)
mp10 (SEb SE VDD NW) g45p1svt w=(215n) l=45n nf=1 m=(1)
ends SDFFX2

// gsclib045_backbias/SDFFX4/schematic

simulator lang=spectre

subckt SDFFX4 CK D Q QN SE SI VDD VSS NW
mn13 (net461 SI VSS VSS) g45n1svt w=(145n) l=45n nf=1 m=(1)
mn14 (Db SE net461 VSS) g45n1svt w=(145n) l=45n nf=1 m=(1)
mn12 (Db SEb net449 VSS) g45n1svt w=(145n) l=45n nf=1 m=(1)
mn11 (net449 D VSS VSS) g45n1svt w=(145n) l=45n nf=1 m=(1)
mn57 (QN net367 VSS VSS) g45n1svt w=(1.04u) l=45n nf=1 m=(1)
mn55 (Q qbint VSS VSS) g45n1svt w=(1.04u) l=45n nf=1 m=(1)
mn50 (net436 qbint VSS VSS) g45n1svt w=(145n) l=45n nf=1 m=(1)
mn51 (n30 CKb net436 VSS) g45n1svt w=(145n) l=45n nf=1 m=(1)
mn35 (net429 mout VSS VSS) g45n1svt w=(145n) l=45n nf=1 m=(1)
mn36 (n20 CKbb net429 VSS) g45n1svt w=(145n) l=45n nf=1 m=(1)
mn20 (CKb CK VSS VSS) g45n1svt w=(145n) l=45n nf=1 m=(1)
mn45 (qbint n30 VSS VSS) g45n1svt w=(410n) l=45n nf=1 m=(1)
mn56 (net367 qbint VSS VSS) g45n1svt w=(260n) l=45n nf=1 m=(1)
mn21 (CKbb CKb VSS VSS) g45n1svt w=(145n) l=45n nf=1 m=(1)
mn40 (n30 CKbb mout VSS) g45n1svt w=(145n) l=45n nf=1 m=(1)
mn30 (mout n20 VSS VSS) g45n1svt w=(145n) l=45n nf=1 m=(1)
mn10 (SEb SE VSS VSS) g45n1svt w=(145n) l=45n nf=1 m=(1)
mn25 (n20 CKb Db VSS) g45n1svt w=(145n) l=45n nf=1 m=(1)
mp14 (Db SEb net392 NW) g45p1svt w=(215n) l=45n nf=1 m=(1)
mp13 (net392 SI VDD NW) g45p1svt w=(215n) l=45n nf=1 m=(1)
mp12 (Db SE net384 NW) g45p1svt w=(215n) l=45n nf=1 m=(1)
mp11 (net384 D VDD NW) g45p1svt w=(215n) l=45n nf=1 m=(1)
mp51 (n30 CKbb net376 NW) g45p1svt w=(215n) l=45n nf=1 m=(1)
mp50 (net376 qbint VDD NW) g45p1svt w=(215n) l=45n nf=1 m=(1)
mp57 (QN net367 VDD NW) g45p1svt w=(1.56u) l=45n nf=1 m=(1)
mp55 (Q qbint VDD NW) g45p1svt w=(1.56u) l=45n nf=1 m=(1)
mp35 (net356 mout VDD NW) g45p1svt w=(215n) l=45n nf=1 m=(1)
mp36 (n20 CKb net356 NW) g45p1svt w=(215n) l=45n nf=1 m=(1)
mp20 (CKb CK VDD NW) g45p1svt w=(215n) l=45n nf=1 m=(1)
mp45 (qbint n30 VDD NW) g45p1svt w=(620n) l=45n nf=1 m=(1)
mp56 (net367 qbint VDD NW) g45p1svt w=(390n) l=45n nf=1 m=(1)
mp21 (CKbb CKb VDD NW) g45p1svt w=(215n) l=45n nf=1 m=(1)
mp40 (n30 CKb mout NW) g45p1svt w=(215n) l=45n nf=1 m=(1)
mp30 (mout n20 VDD NW) g45p1svt w=(215n) l=45n nf=1 m=(1)
mp25 (n20 CKbb Db NW) g45p1svt w=(215n) l=45n nf=1 m=(1)
mp10 (SEb SE VDD NW) g45p1svt w=(215n) l=45n nf=1 m=(1)
ends SDFFX4

// gsclib045_backbias/SDFFXL/schematic

simulator lang=spectre

subckt SDFFXL CK D Q QN SE SI VDD NW VSS
mn13 (net461 SI VSS VSS) g45n1svt w=(145n) l=45n nf=1 m=(1)
mn14 (Db SE net461 VSS) g45n1svt w=(145n) l=45n nf=1 m=(1)
mn12 (Db SEb net449 VSS) g45n1svt w=(145n) l=45n nf=1 m=(1)
mn11 (net449 D VSS VSS) g45n1svt w=(145n) l=45n nf=1 m=(1)
mn57 (QN net367 VSS VSS) g45n1svt w=(145n) l=45n nf=1 m=(1)
mn55 (Q qbint VSS VSS) g45n1svt w=(145n) l=45n nf=1 m=(1)
mn50 (net436 qbint VSS VSS) g45n1svt w=(145n) l=45n nf=1 m=(1)
mn51 (n30 CKb net436 VSS) g45n1svt w=(145n) l=45n nf=1 m=(1)
mn35 (net429 mout VSS VSS) g45n1svt w=(145n) l=45n nf=1 m=(1)
mn36 (n20 CKbb net429 VSS) g45n1svt w=(145n) l=45n nf=1 m=(1)
mn20 (CKb CK VSS VSS) g45n1svt w=(145n) l=45n nf=1 m=(1)
mn45 (qbint n30 VSS VSS) g45n1svt w=(145n) l=45n nf=1 m=(1)
mn56 (net367 qbint VSS VSS) g45n1svt w=(145n) l=45n nf=1 m=(1)
mn21 (CKbb CKb VSS VSS) g45n1svt w=(145n) l=45n nf=1 m=(1)
mn40 (n30 CKbb mout VSS) g45n1svt w=(145n) l=45n nf=1 m=(1)
mn30 (mout n20 VSS VSS) g45n1svt w=(145n) l=45n nf=1 m=(1)
mn10 (SEb SE VSS VSS) g45n1svt w=(145n) l=45n nf=1 m=(1)
mn25 (n20 CKb Db VSS) g45n1svt w=(145n) l=45n nf=1 m=(1)
mp14 (Db SEb net392 NW) g45p1svt w=(215n) l=45n nf=1 m=(1)
mp13 (net392 SI VDD NW) g45p1svt w=(215n) l=45n nf=1 m=(1)
mp12 (Db SE net384 NW) g45p1svt w=(215n) l=45n nf=1 m=(1)
mp11 (net384 D VDD NW) g45p1svt w=(215n) l=45n nf=1 m=(1)
mp51 (n30 CKbb net376 NW) g45p1svt w=(215n) l=45n nf=1 m=(1)
mp50 (net376 qbint VDD NW) g45p1svt w=(215n) l=45n nf=1 m=(1)
mp57 (QN net367 VDD NW) g45p1svt w=(215n) l=45n nf=1 m=(1)
mp55 (Q qbint VDD NW) g45p1svt w=(215n) l=45n nf=1 m=(1)
mp35 (net356 mout VDD NW) g45p1svt w=(215n) l=45n nf=1 m=(1)
mp36 (n20 CKb net356 NW) g45p1svt w=(215n) l=45n nf=1 m=(1)
mp20 (CKb CK VDD NW) g45p1svt w=(215n) l=45n nf=1 m=(1)
mp45 (qbint n30 VDD NW) g45p1svt w=(215n) l=45n nf=1 m=(1)
mp56 (net367 qbint VDD NW) g45p1svt w=(215n) l=45n nf=1 m=(1)
mp21 (CKbb CKb VDD NW) g45p1svt w=(215n) l=45n nf=1 m=(1)
mp40 (n30 CKb mout NW) g45p1svt w=(215n) l=45n nf=1 m=(1)
mp30 (mout n20 VDD NW) g45p1svt w=(215n) l=45n nf=1 m=(1)
mp25 (n20 CKbb Db NW) g45p1svt w=(215n) l=45n nf=1 m=(1)
mp10 (SEb SE VDD NW) g45p1svt w=(215n) l=45n nf=1 m=(1)
ends SDFFXL

// gsclib045_backbias/SEDFFHQX1/schematic

simulator lang=spectre

subckt SEDFFHQX1 CK D E Q SE SI VDD VSS NW
mn4 (Db E net526 VSS) g45n1svt w=(260n) l=45n nf=1 m=(1)
mn3 (net526 D VSS VSS) g45n1svt w=(260n) l=45n nf=1 m=(1)
mn13 (Dbp SE net518 VSS) g45n1svt w=(260n) l=45n nf=1 m=(1)
mn12 (net518 SI VSS VSS) g45n1svt w=(260n) l=45n nf=1 m=(1)
mn55 (Q qbint VSS VSS) g45n1svt w=(260n) l=45n nf=1 m=(1)
mn50 (net509 qbint VSS VSS) g45n1svt w=(205n) l=45n nf=1 m=(1)
mn51 (n30 CKb net509 VSS) g45n1svt w=(205n) l=45n nf=1 m=(1)
mn35 (net501 mout VSS VSS) g45n1svt w=(205n) l=45n nf=1 m=(1)
mn36 (n20 Ckbb net501 VSS) g45n1svt w=(205n) l=45n nf=1 m=(1)
mn1 (net494 qint VSS VSS) g45n1svt w=(260n) l=45n nf=1 m=(1)
mn2 (Db Eb net494 VSS) g45n1svt w=(260n) l=45n nf=1 m=(1)
mn45 (qbint n30 VSS VSS) g45n1svt w=(205n) l=45n nf=1 m=(1)
mn56 (qint qbint VSS VSS) g45n1svt w=(205n) l=45n nf=1 m=(1)
mn21 (Ckbb CKb VSS VSS) g45n1svt w=(145n) l=45n nf=1 m=(1)
mn40 (n30 Ckbb mout VSS) g45n1svt w=(205n) l=45n nf=1 m=(1)
mn30 (mout n20 VSS VSS) g45n1svt w=(205n) l=45n nf=1 m=(1)
mn10 (SEb SE VSS VSS) g45n1svt w=(145n) l=45n nf=1 m=(1)
mn0 (Eb E VSS VSS) g45n1svt w=(145n) l=45n nf=1 m=(1)
mn25 (n20 CKb Dbp VSS) g45n1svt w=(205n) l=45n nf=1 m=(1)
mn20 (CKb CK VSS VSS) g45n1svt w=(145n) l=45n nf=1 m=(1)
mn11 (Db SEb Dbp VSS) g45n1svt w=(260n) l=45n nf=1 m=(1)
mp4 (Db Eb net449 NW) g45p1svt w=(390n) l=45n nf=1 m=(1)
mp3 (net449 D VDD NW) g45p1svt w=(390n) l=45n nf=1 m=(1)
mp13 (Dbp SEb net441 NW) g45p1svt w=(390n) l=45n nf=1 m=(1)
mp12 (net441 SI VDD NW) g45p1svt w=(390n) l=45n nf=1 m=(1)
mp51 (n30 Ckbb net426 NW) g45p1svt w=(310n) l=45n nf=1 m=(1)
mp50 (net426 qbint VDD NW) g45p1svt w=(310n) l=45n nf=1 m=(1)
mp55 (Q qbint VDD NW) g45p1svt w=(390n) l=45n nf=1 m=(1)
mp35 (net417 mout VDD NW) g45p1svt w=(310n) l=45n nf=1 m=(1)
mp36 (n20 CKb net417 NW) g45p1svt w=(310n) l=45n nf=1 m=(1)
mp20 (CKb CK VDD NW) g45p1svt w=(215n) l=45n nf=1 m=(1)
mp1 (net405 qint VDD NW) g45p1svt w=(390n) l=45n nf=1 m=(1)
mp2 (Db E net405 NW) g45p1svt w=(390n) l=45n nf=1 m=(1)
mp45 (qbint n30 VDD NW) g45p1svt w=(310n) l=45n nf=1 m=(1)
mp56 (qint qbint VDD NW) g45p1svt w=(310n) l=45n nf=1 m=(1)
mp21 (Ckbb CKb VDD NW) g45p1svt w=(215n) l=45n nf=1 m=(1)
mp40 (n30 CKb mout NW) g45p1svt w=(310n) l=45n nf=1 m=(1)
mp30 (mout n20 VDD NW) g45p1svt w=(310n) l=45n nf=1 m=(1)
mp11 (Db SE Dbp NW) g45p1svt w=(390n) l=45n nf=1 m=(1)
mp10 (SEb SE VDD NW) g45p1svt w=(215n) l=45n nf=1 m=(1)
mp0 (Eb E VDD NW) g45p1svt w=(215n) l=45n nf=1 m=(1)
mp25 (n20 Ckbb Dbp NW) g45p1svt w=(310n) l=45n nf=1 m=(1)
ends SEDFFHQX1

// gsclib045_backbias/SEDFFHQX2/schematic

simulator lang=spectre

subckt SEDFFHQX2 CK D E Q SE SI VDD VSS NW
mn4 (Db E net526 VSS) g45n1svt w=(260n) l=45n nf=1 m=(1)
mn3 (net526 D VSS VSS) g45n1svt w=(260n) l=45n nf=1 m=(1)
mn13 (Dbp SE net518 VSS) g45n1svt w=(260n) l=45n nf=1 m=(1)
mn12 (net518 SI VSS VSS) g45n1svt w=(260n) l=45n nf=1 m=(1)
mn55 (Q qbint VSS VSS) g45n1svt w=(520n) l=45n nf=1 m=(1)
mn50 (net509 qbint VSS VSS) g45n1svt w=(205n) l=45n nf=1 m=(1)
mn51 (n30 CKb net509 VSS) g45n1svt w=(205n) l=45n nf=1 m=(1)
mn35 (net501 mout VSS VSS) g45n1svt w=(205n) l=45n nf=1 m=(1)
mn36 (n20 Ckbb net501 VSS) g45n1svt w=(205n) l=45n nf=1 m=(1)
mn1 (net494 qint VSS VSS) g45n1svt w=(260n) l=45n nf=1 m=(1)
mn2 (Db Eb net494 VSS) g45n1svt w=(260n) l=45n nf=1 m=(1)
mn45 (qbint n30 VSS VSS) g45n1svt w=(260n) l=45n nf=1 m=(1)
mn56 (qint qbint VSS VSS) g45n1svt w=(205n) l=45n nf=1 m=(1)
mn21 (Ckbb CKb VSS VSS) g45n1svt w=(145n) l=45n nf=1 m=(1)
mn40 (n30 Ckbb mout VSS) g45n1svt w=(205n) l=45n nf=1 m=(1)
mn30 (mout n20 VSS VSS) g45n1svt w=(205n) l=45n nf=1 m=(1)
mn10 (SEb SE VSS VSS) g45n1svt w=(145n) l=45n nf=1 m=(1)
mn0 (Eb E VSS VSS) g45n1svt w=(145n) l=45n nf=1 m=(1)
mn25 (n20 CKb Dbp VSS) g45n1svt w=(205n) l=45n nf=1 m=(1)
mn20 (CKb CK VSS VSS) g45n1svt w=(145n) l=45n nf=1 m=(1)
mn11 (Db SEb Dbp VSS) g45n1svt w=(260n) l=45n nf=1 m=(1)
mp4 (Db Eb net449 NW) g45p1svt w=(390n) l=45n nf=1 m=(1)
mp3 (net449 D VDD NW) g45p1svt w=(390n) l=45n nf=1 m=(1)
mp13 (Dbp SEb net441 NW) g45p1svt w=(390n) l=45n nf=1 m=(1)
mp12 (net441 SI VDD NW) g45p1svt w=(390n) l=45n nf=1 m=(1)
mp51 (n30 Ckbb net426 NW) g45p1svt w=(310n) l=45n nf=1 m=(1)
mp50 (net426 qbint VDD NW) g45p1svt w=(310n) l=45n nf=1 m=(1)
mp55 (Q qbint VDD NW) g45p1svt w=(780n) l=45n nf=1 m=(1)
mp35 (net417 mout VDD NW) g45p1svt w=(310n) l=45n nf=1 m=(1)
mp36 (n20 CKb net417 NW) g45p1svt w=(310n) l=45n nf=1 m=(1)
mp20 (CKb CK VDD NW) g45p1svt w=(215n) l=45n nf=1 m=(1)
mp1 (net405 qint VDD NW) g45p1svt w=(390n) l=45n nf=1 m=(1)
mp2 (Db E net405 NW) g45p1svt w=(390n) l=45n nf=1 m=(1)
mp45 (qbint n30 VDD NW) g45p1svt w=(390n) l=45n nf=1 m=(1)
mp56 (qint qbint VDD NW) g45p1svt w=(310n) l=45n nf=1 m=(1)
mp21 (Ckbb CKb VDD NW) g45p1svt w=(215n) l=45n nf=1 m=(1)
mp40 (n30 CKb mout NW) g45p1svt w=(310n) l=45n nf=1 m=(1)
mp30 (mout n20 VDD NW) g45p1svt w=(310n) l=45n nf=1 m=(1)
mp11 (Db SE Dbp NW) g45p1svt w=(390n) l=45n nf=1 m=(1)
mp10 (SEb SE VDD NW) g45p1svt w=(215n) l=45n nf=1 m=(1)
mp0 (Eb E VDD NW) g45p1svt w=(215n) l=45n nf=1 m=(1)
mp25 (n20 Ckbb Dbp NW) g45p1svt w=(310n) l=45n nf=1 m=(1)
ends SEDFFHQX2

// gsclib045_backbias/SEDFFHQX4/schematic

simulator lang=spectre

subckt SEDFFHQX4 CK D E Q SE SI VDD VSS NW
mn4 (Db E net526 VSS) g45n1svt w=(260n) l=45n nf=1 m=(1)
mn3 (net526 D VSS VSS) g45n1svt w=(260n) l=45n nf=1 m=(1)
mn13 (Dbp SE net518 VSS) g45n1svt w=(260n) l=45n nf=1 m=(1)
mn12 (net518 SI VSS VSS) g45n1svt w=(260n) l=45n nf=1 m=(1)
mn55 (Q qbint VSS VSS) g45n1svt w=(1.04u) l=45n nf=1 m=(1)
mn50 (net509 qbint VSS VSS) g45n1svt w=(205n) l=45n nf=1 m=(1)
mn51 (n30 CKb net509 VSS) g45n1svt w=(205n) l=45n nf=1 m=(1)
mn35 (net501 mout VSS VSS) g45n1svt w=(205n) l=45n nf=1 m=(1)
mn36 (n20 Ckbb net501 VSS) g45n1svt w=(205n) l=45n nf=1 m=(1)
mn1 (net494 qint VSS VSS) g45n1svt w=(260n) l=45n nf=1 m=(1)
mn2 (Db Eb net494 VSS) g45n1svt w=(260n) l=45n nf=1 m=(1)
mn45 (qbint n30 VSS VSS) g45n1svt w=(410n) l=45n nf=1 m=(1)
mn56 (qint qbint VSS VSS) g45n1svt w=(260n) l=45n nf=1 m=(1)
mn21 (Ckbb CKb VSS VSS) g45n1svt w=(145n) l=45n nf=1 m=(1)
mn40 (n30 Ckbb mout VSS) g45n1svt w=(205n) l=45n nf=1 m=(1)
mn30 (mout n20 VSS VSS) g45n1svt w=(205n) l=45n nf=1 m=(1)
mn10 (SEb SE VSS VSS) g45n1svt w=(145n) l=45n nf=1 m=(1)
mn0 (Eb E VSS VSS) g45n1svt w=(145n) l=45n nf=1 m=(1)
mn25 (n20 CKb Dbp VSS) g45n1svt w=(205n) l=45n nf=1 m=(1)
mn20 (CKb CK VSS VSS) g45n1svt w=(145n) l=45n nf=1 m=(1)
mn11 (Db SEb Dbp VSS) g45n1svt w=(260n) l=45n nf=1 m=(1)
mp4 (Db Eb net449 NW) g45p1svt w=(390n) l=45n nf=1 m=(1)
mp3 (net449 D VDD NW) g45p1svt w=(390n) l=45n nf=1 m=(1)
mp13 (Dbp SEb net441 NW) g45p1svt w=(390n) l=45n nf=1 m=(1)
mp12 (net441 SI VDD NW) g45p1svt w=(390n) l=45n nf=1 m=(1)
mp51 (n30 Ckbb net426 NW) g45p1svt w=(310n) l=45n nf=1 m=(1)
mp50 (net426 qbint VDD NW) g45p1svt w=(310n) l=45n nf=1 m=(1)
mp55 (Q qbint VDD NW) g45p1svt w=(1.56u) l=45n nf=1 m=(1)
mp35 (net417 mout VDD NW) g45p1svt w=(310n) l=45n nf=1 m=(1)
mp36 (n20 CKb net417 NW) g45p1svt w=(310n) l=45n nf=1 m=(1)
mp20 (CKb CK VDD NW) g45p1svt w=(215n) l=45n nf=1 m=(1)
mp1 (net405 qint VDD NW) g45p1svt w=(390n) l=45n nf=1 m=(1)
mp2 (Db E net405 NW) g45p1svt w=(390n) l=45n nf=1 m=(1)
mp45 (qbint n30 VDD NW) g45p1svt w=(620n) l=45n nf=1 m=(1)
mp56 (qint qbint VDD NW) g45p1svt w=(390n) l=45n nf=1 m=(1)
mp21 (Ckbb CKb VDD NW) g45p1svt w=(215n) l=45n nf=1 m=(1)
mp40 (n30 CKb mout NW) g45p1svt w=(310n) l=45n nf=1 m=(1)
mp30 (mout n20 VDD NW) g45p1svt w=(310n) l=45n nf=1 m=(1)
mp11 (Db SE Dbp NW) g45p1svt w=(390n) l=45n nf=1 m=(1)
mp10 (SEb SE VDD NW) g45p1svt w=(215n) l=45n nf=1 m=(1)
mp0 (Eb E VDD NW) g45p1svt w=(215n) l=45n nf=1 m=(1)
mp25 (n20 Ckbb Dbp NW) g45p1svt w=(310n) l=45n nf=1 m=(1)
ends SEDFFHQX4

// gsclib045_backbias/SEDFFHQX8/schematic

simulator lang=spectre

subckt SEDFFHQX8 CK D E Q SE SI VDD VSS NW
mn4 (Db E net526 VSS) g45n1svt w=(260n) l=45n nf=1 m=(1)
mn3 (net526 D VSS VSS) g45n1svt w=(260n) l=45n nf=1 m=(1)
mn13 (Dbp SE net518 VSS) g45n1svt w=(260n) l=45n nf=1 m=(1)
mn12 (net518 SI VSS VSS) g45n1svt w=(260n) l=45n nf=1 m=(1)
mn55 (Q qbint VSS VSS) g45n1svt w=(2.065u) l=45n nf=1 m=(1)
mn50 (net509 qbint VSS VSS) g45n1svt w=(205n) l=45n nf=1 m=(1)
mn51 (n30 CKb net509 VSS) g45n1svt w=(205n) l=45n nf=1 m=(1)
mn35 (net501 mout VSS VSS) g45n1svt w=(205n) l=45n nf=1 m=(1)
mn36 (n20 Ckbb net501 VSS) g45n1svt w=(205n) l=45n nf=1 m=(1)
mn1 (net494 qint VSS VSS) g45n1svt w=(260n) l=45n nf=1 m=(1)
mn2 (Db Eb net494 VSS) g45n1svt w=(260n) l=45n nf=1 m=(1)
mn45 (qbint n30 VSS VSS) g45n1svt w=(780n) l=45n nf=1 m=(1)
mn56 (qint qbint VSS VSS) g45n1svt w=(520n) l=45n nf=1 m=(1)
mn21 (Ckbb CKb VSS VSS) g45n1svt w=(145n) l=45n nf=1 m=(1)
mn40 (n30 Ckbb mout VSS) g45n1svt w=(205n) l=45n nf=1 m=(1)
mn30 (mout n20 VSS VSS) g45n1svt w=(205n) l=45n nf=1 m=(1)
mn10 (SEb SE VSS VSS) g45n1svt w=(145n) l=45n nf=1 m=(1)
mn0 (Eb E VSS VSS) g45n1svt w=(145n) l=45n nf=1 m=(1)
mn25 (n20 CKb Dbp VSS) g45n1svt w=(205n) l=45n nf=1 m=(1)
mn20 (CKb CK VSS VSS) g45n1svt w=(145n) l=45n nf=1 m=(1)
mn11 (Db SEb Dbp VSS) g45n1svt w=(260n) l=45n nf=1 m=(1)
mp4 (Db Eb net449 NW) g45p1svt w=(390n) l=45n nf=1 m=(1)
mp3 (net449 D VDD NW) g45p1svt w=(390n) l=45n nf=1 m=(1)
mp13 (Dbp SEb net441 NW) g45p1svt w=(390n) l=45n nf=1 m=(1)
mp12 (net441 SI VDD NW) g45p1svt w=(390n) l=45n nf=1 m=(1)
mp51 (n30 Ckbb net426 NW) g45p1svt w=(310n) l=45n nf=1 m=(1)
mp50 (net426 qbint VDD NW) g45p1svt w=(310n) l=45n nf=1 m=(1)
mp55 (Q qbint VDD NW) g45p1svt w=(3.115u) l=45n nf=1 m=(1)
mp35 (net417 mout VDD NW) g45p1svt w=(310n) l=45n nf=1 m=(1)
mp36 (n20 CKb net417 NW) g45p1svt w=(310n) l=45n nf=1 m=(1)
mp20 (CKb CK VDD NW) g45p1svt w=(215n) l=45n nf=1 m=(1)
mp1 (net405 qint VDD NW) g45p1svt w=(390n) l=45n nf=1 m=(1)
mp2 (Db E net405 NW) g45p1svt w=(390n) l=45n nf=1 m=(1)
mp45 (qbint n30 VDD NW) g45p1svt w=(1.17u) l=45n nf=1 m=(1)
mp56 (qint qbint VDD NW) g45p1svt w=(780n) l=45n nf=1 m=(1)
mp21 (Ckbb CKb VDD NW) g45p1svt w=(215n) l=45n nf=1 m=(1)
mp40 (n30 CKb mout NW) g45p1svt w=(310n) l=45n nf=1 m=(1)
mp30 (mout n20 VDD NW) g45p1svt w=(310n) l=45n nf=1 m=(1)
mp11 (Db SE Dbp NW) g45p1svt w=(390n) l=45n nf=1 m=(1)
mp10 (SEb SE VDD NW) g45p1svt w=(215n) l=45n nf=1 m=(1)
mp0 (Eb E VDD NW) g45p1svt w=(215n) l=45n nf=1 m=(1)
mp25 (n20 Ckbb Dbp NW) g45p1svt w=(310n) l=45n nf=1 m=(1)
ends SEDFFHQX8

// gsclib045_backbias/SEDFFTRX1/schematic

simulator lang=spectre

subckt SEDFFTRX1 CK D E Q QN RN SE SI VSS NW VDD
mn14 (Dpb SE net658 VSS) g45n1svt w=(145n) l=45n nf=1 m=(1)
mn13 (net658 SI VSS VSS) g45n1svt w=(145n) l=45n nf=1 m=(1)
mn12 (Dpb SEb net650 VSS) g45n1svt w=(145n) l=45n nf=1 m=(1)
mn11 (net650 Dp VSS VSS) g45n1svt w=(145n) l=45n nf=1 m=(1)
mn1 (Db D VSS VSS) g45n1svt w=(145n) l=45n nf=1 m=(1)
mn7 (Dp Db net638 VSS) g45n1svt w=(145n) l=45n nf=1 m=(1)
mn6 (net638 E VSS VSS) g45n1svt w=(145n) l=45n nf=1 m=(1)
mn4 (net634 Eb VSS VSS) g45n1svt w=(145n) l=45n nf=1 m=(1)
mn5 (Dp qbint net634 VSS) g45n1svt w=(145n) l=45n nf=1 m=(1)
mn57 (QN net582 VSS VSS) g45n1svt w=(260n) l=45n nf=1 m=(1)
mn55 (Q qbint VSS VSS) g45n1svt w=(260n) l=45n nf=1 m=(1)
mn50 (net618 qbint VSS VSS) g45n1svt w=(145n) l=45n nf=1 m=(1)
mn51 (n30 CKb net618 VSS) g45n1svt w=(145n) l=45n nf=1 m=(1)
mn36 (n20 CKbb net606 VSS) g45n1svt w=(145n) l=45n nf=1 m=(1)
mn35 (net606 mout VSS VSS) g45n1svt w=(145n) l=45n nf=1 m=(1)
mn20 (CKb CK VSS VSS) g45n1svt w=(145n) l=45n nf=1 m=(1)
mn2 (RNb RN VSS VSS) g45n1svt w=(145n) l=45n nf=1 m=(1)
mn10 (SEb SE VSS VSS) g45n1svt w=(145n) l=45n nf=1 m=(1)
mn0 (Eb E VSS VSS) g45n1svt w=(145n) l=45n nf=1 m=(1)
mn3 (Dp RNb VSS VSS) g45n1svt w=(145n) l=45n nf=1 m=(1)
mn56 (net582 qbint VSS VSS) g45n1svt w=(145n) l=45n nf=1 m=(1)
mn45 (qbint n30 VSS VSS) g45n1svt w=(145n) l=45n nf=1 m=(1)
mn30 (mout n20 VSS VSS) g45n1svt w=(145n) l=45n nf=1 m=(1)
mn25 (n20 CKb Dpb VSS) g45n1svt w=(145n) l=45n nf=1 m=(1)
mn40 (n30 CKbb mout VSS) g45n1svt w=(145n) l=45n nf=1 m=(1)
mn21 (CKbb CKb VSS VSS) g45n1svt w=(145n) l=45n nf=1 m=(1)
mp13 (net557 SI VDD NW) g45p1svt w=(215n) l=45n nf=1 m=(1)
mp14 (Dpb SEb net557 NW) g45p1svt w=(215n) l=45n nf=1 m=(1)
mp11 (net549 Dp VDD NW) g45p1svt w=(215n) l=45n nf=1 m=(1)
mp12 (Dpb SE net549 NW) g45p1svt w=(215n) l=45n nf=1 m=(1)
mp1 (Db D VDD NW) g45p1svt w=(215n) l=45n nf=1 m=(1)
mp57 (QN net582 VDD NW) g45p1svt w=(390n) l=45n nf=1 m=(1)
mp55 (Q qbint VDD NW) g45p1svt w=(390n) l=45n nf=1 m=(1)
mp50 (net529 qbint VDD NW) g45p1svt w=(215n) l=45n nf=1 m=(1)
mp51 (n30 CKbb net529 NW) g45p1svt w=(215n) l=45n nf=1 m=(1)
mp35 (net521 mout VDD NW) g45p1svt w=(215n) l=45n nf=1 m=(1)
mp36 (n20 CKb net521 NW) g45p1svt w=(215n) l=45n nf=1 m=(1)
mp20 (CKb CK VDD NW) g45p1svt w=(215n) l=45n nf=1 m=(1)
mp2 (RNb RN VDD NW) g45p1svt w=(215n) l=45n nf=1 m=(1)
mp7 (Dp Db net505 NW) g45p1svt w=(215n) l=45n nf=1 m=(1)
mp6 (Dp E net505 NW) g45p1svt w=(215n) l=45n nf=1 m=(1)
mp10 (SEb SE VDD NW) g45p1svt w=(215n) l=45n nf=1 m=(1)
mp0 (Eb E VDD NW) g45p1svt w=(215n) l=45n nf=1 m=(1)
mp4 (net505 Eb net493 NW) g45p1svt w=(215n) l=45n nf=1 m=(1)
mp5 (net505 qbint net493 NW) g45p1svt w=(215n) l=45n nf=1 m=(1)
mp3 (net493 RNb VDD NW) g45p1svt w=(215n) l=45n nf=1 m=(1)
mp56 (net582 qbint VDD NW) g45p1svt w=(215n) l=45n nf=1 m=(1)
mp45 (qbint n30 VDD NW) g45p1svt w=(215n) l=45n nf=1 m=(1)
mp30 (mout n20 VDD NW) g45p1svt w=(215n) l=45n nf=1 m=(1)
mp40 (n30 CKb mout NW) g45p1svt w=(215n) l=45n nf=1 m=(1)
mp21 (CKbb CKb VDD NW) g45p1svt w=(215n) l=45n nf=1 m=(1)
mp25 (n20 CKbb Dpb NW) g45p1svt w=(215n) l=45n nf=1 m=(1)
ends SEDFFTRX1

// gsclib045_backbias/SEDFFTRX2/schematic

simulator lang=spectre

subckt SEDFFTRX2 CK D E Q QN RN SE SI VSS NW VDD
mn14 (Dpb SE net658 VSS) g45n1svt w=(145n) l=45n nf=1 m=(1)
mn13 (net658 SI VSS VSS) g45n1svt w=(145n) l=45n nf=1 m=(1)
mn12 (Dpb SEb net650 VSS) g45n1svt w=(145n) l=45n nf=1 m=(1)
mn11 (net650 Dp VSS VSS) g45n1svt w=(145n) l=45n nf=1 m=(1)
mn1 (Db D VSS VSS) g45n1svt w=(145n) l=45n nf=1 m=(1)
mn7 (Dp Db net638 VSS) g45n1svt w=(145n) l=45n nf=1 m=(1)
mn6 (net638 E VSS VSS) g45n1svt w=(145n) l=45n nf=1 m=(1)
mn4 (net634 Eb VSS VSS) g45n1svt w=(145n) l=45n nf=1 m=(1)
mn5 (Dp qbint net634 VSS) g45n1svt w=(145n) l=45n nf=1 m=(1)
mn57 (QN net582 VSS VSS) g45n1svt w=(520n) l=45n nf=1 m=(1)
mn55 (Q qbint VSS VSS) g45n1svt w=(520n) l=45n nf=1 m=(1)
mn50 (net618 qbint VSS VSS) g45n1svt w=(145n) l=45n nf=1 m=(1)
mn51 (n30 CKb net618 VSS) g45n1svt w=(145n) l=45n nf=1 m=(1)
mn36 (n20 CKbb net606 VSS) g45n1svt w=(145n) l=45n nf=1 m=(1)
mn35 (net606 mout VSS VSS) g45n1svt w=(145n) l=45n nf=1 m=(1)
mn20 (CKb CK VSS VSS) g45n1svt w=(145n) l=45n nf=1 m=(1)
mn2 (RNb RN VSS VSS) g45n1svt w=(145n) l=45n nf=1 m=(1)
mn10 (SEb SE VSS VSS) g45n1svt w=(145n) l=45n nf=1 m=(1)
mn0 (Eb E VSS VSS) g45n1svt w=(145n) l=45n nf=1 m=(1)
mn3 (Dp RNb VSS VSS) g45n1svt w=(145n) l=45n nf=1 m=(1)
mn56 (net582 qbint VSS VSS) g45n1svt w=(145n) l=45n nf=1 m=(1)
mn45 (qbint n30 VSS VSS) g45n1svt w=(205n) l=45n nf=1 m=(1)
mn30 (mout n20 VSS VSS) g45n1svt w=(145n) l=45n nf=1 m=(1)
mn25 (n20 CKb Dpb VSS) g45n1svt w=(145n) l=45n nf=1 m=(1)
mn40 (n30 CKbb mout VSS) g45n1svt w=(145n) l=45n nf=1 m=(1)
mn21 (CKbb CKb VSS VSS) g45n1svt w=(145n) l=45n nf=1 m=(1)
mp13 (net557 SI VDD NW) g45p1svt w=(215n) l=45n nf=1 m=(1)
mp14 (Dpb SEb net557 NW) g45p1svt w=(215n) l=45n nf=1 m=(1)
mp11 (net549 Dp VDD NW) g45p1svt w=(215n) l=45n nf=1 m=(1)
mp12 (Dpb SE net549 NW) g45p1svt w=(215n) l=45n nf=1 m=(1)
mp1 (Db D VDD NW) g45p1svt w=(215n) l=45n nf=1 m=(1)
mp57 (QN net582 VDD NW) g45p1svt w=(780n) l=45n nf=1 m=(1)
mp55 (Q qbint VDD NW) g45p1svt w=(780n) l=45n nf=1 m=(1)
mp50 (net529 qbint VDD NW) g45p1svt w=(215n) l=45n nf=1 m=(1)
mp51 (n30 CKbb net529 NW) g45p1svt w=(215n) l=45n nf=1 m=(1)
mp35 (net521 mout VDD NW) g45p1svt w=(215n) l=45n nf=1 m=(1)
mp36 (n20 CKb net521 NW) g45p1svt w=(215n) l=45n nf=1 m=(1)
mp20 (CKb CK VDD NW) g45p1svt w=(215n) l=45n nf=1 m=(1)
mp2 (RNb RN VDD NW) g45p1svt w=(215n) l=45n nf=1 m=(1)
mp7 (Dp Db net505 NW) g45p1svt w=(215n) l=45n nf=1 m=(1)
mp6 (Dp E net505 NW) g45p1svt w=(215n) l=45n nf=1 m=(1)
mp10 (SEb SE VDD NW) g45p1svt w=(215n) l=45n nf=1 m=(1)
mp0 (Eb E VDD NW) g45p1svt w=(215n) l=45n nf=1 m=(1)
mp4 (net505 Eb net493 NW) g45p1svt w=(215n) l=45n nf=1 m=(1)
mp5 (net505 qbint net493 NW) g45p1svt w=(215n) l=45n nf=1 m=(1)
mp3 (net493 RNb VDD NW) g45p1svt w=(215n) l=45n nf=1 m=(1)
mp56 (net582 qbint VDD NW) g45p1svt w=(215n) l=45n nf=1 m=(1)
mp45 (qbint n30 VDD NW) g45p1svt w=(310n) l=45n nf=1 m=(1)
mp30 (mout n20 VDD NW) g45p1svt w=(215n) l=45n nf=1 m=(1)
mp40 (n30 CKb mout NW) g45p1svt w=(215n) l=45n nf=1 m=(1)
mp21 (CKbb CKb VDD NW) g45p1svt w=(215n) l=45n nf=1 m=(1)
mp25 (n20 CKbb Dpb NW) g45p1svt w=(215n) l=45n nf=1 m=(1)
ends SEDFFTRX2

// gsclib045_backbias/SEDFFTRX4/schematic

simulator lang=spectre

subckt SEDFFTRX4 CK D E Q QN RN SE SI VSS VDD NW
mn14 (Dpb SE net658 VSS) g45n1svt w=(145n) l=45n nf=1 m=(1)
mn13 (net658 SI VSS VSS) g45n1svt w=(145n) l=45n nf=1 m=(1)
mn12 (Dpb SEb net650 VSS) g45n1svt w=(145n) l=45n nf=1 m=(1)
mn11 (net650 Dp VSS VSS) g45n1svt w=(145n) l=45n nf=1 m=(1)
mn1 (Db D VSS VSS) g45n1svt w=(145n) l=45n nf=1 m=(1)
mn7 (Dp Db net638 VSS) g45n1svt w=(145n) l=45n nf=1 m=(1)
mn6 (net638 E VSS VSS) g45n1svt w=(145n) l=45n nf=1 m=(1)
mn4 (net634 Eb VSS VSS) g45n1svt w=(145n) l=45n nf=1 m=(1)
mn5 (Dp qbint net634 VSS) g45n1svt w=(145n) l=45n nf=1 m=(1)
mn57 (QN net582 VSS VSS) g45n1svt w=(1.04u) l=45n nf=1 m=(1)
mn55 (Q qbint VSS VSS) g45n1svt w=(1.04u) l=45n nf=1 m=(1)
mn50 (net618 qbint VSS VSS) g45n1svt w=(145n) l=45n nf=1 m=(1)
mn51 (n30 CKb net618 VSS) g45n1svt w=(145n) l=45n nf=1 m=(1)
mn36 (n20 CKbb net606 VSS) g45n1svt w=(145n) l=45n nf=1 m=(1)
mn35 (net606 mout VSS VSS) g45n1svt w=(145n) l=45n nf=1 m=(1)
mn20 (CKb CK VSS VSS) g45n1svt w=(145n) l=45n nf=1 m=(1)
mn2 (RNb RN VSS VSS) g45n1svt w=(145n) l=45n nf=1 m=(1)
mn10 (SEb SE VSS VSS) g45n1svt w=(145n) l=45n nf=1 m=(1)
mn0 (Eb E VSS VSS) g45n1svt w=(145n) l=45n nf=1 m=(1)
mn3 (Dp RNb VSS VSS) g45n1svt w=(145n) l=45n nf=1 m=(1)
mn56 (net582 qbint VSS VSS) g45n1svt w=(260n) l=45n nf=1 m=(1)
mn45 (qbint n30 VSS VSS) g45n1svt w=(410n) l=45n nf=1 m=(1)
mn30 (mout n20 VSS VSS) g45n1svt w=(145n) l=45n nf=1 m=(1)
mn25 (n20 CKb Dpb VSS) g45n1svt w=(145n) l=45n nf=1 m=(1)
mn40 (n30 CKbb mout VSS) g45n1svt w=(145n) l=45n nf=1 m=(1)
mn21 (CKbb CKb VSS VSS) g45n1svt w=(145n) l=45n nf=1 m=(1)
mp13 (net557 SI VDD NW) g45p1svt w=(215n) l=45n nf=1 m=(1)
mp14 (Dpb SEb net557 NW) g45p1svt w=(215n) l=45n nf=1 m=(1)
mp11 (net549 Dp VDD NW) g45p1svt w=(215n) l=45n nf=1 m=(1)
mp12 (Dpb SE net549 NW) g45p1svt w=(215n) l=45n nf=1 m=(1)
mp1 (Db D VDD NW) g45p1svt w=(215n) l=45n nf=1 m=(1)
mp57 (QN net582 VDD NW) g45p1svt w=(1.56u) l=45n nf=1 m=(1)
mp55 (Q qbint VDD NW) g45p1svt w=(1.56u) l=45n nf=1 m=(1)
mp50 (net529 qbint VDD NW) g45p1svt w=(215n) l=45n nf=1 m=(1)
mp51 (n30 CKbb net529 NW) g45p1svt w=(215n) l=45n nf=1 m=(1)
mp35 (net521 mout VDD NW) g45p1svt w=(215n) l=45n nf=1 m=(1)
mp36 (n20 CKb net521 NW) g45p1svt w=(215n) l=45n nf=1 m=(1)
mp20 (CKb CK VDD NW) g45p1svt w=(215n) l=45n nf=1 m=(1)
mp2 (RNb RN VDD NW) g45p1svt w=(215n) l=45n nf=1 m=(1)
mp7 (Dp Db net505 NW) g45p1svt w=(215n) l=45n nf=1 m=(1)
mp6 (Dp E net505 NW) g45p1svt w=(215n) l=45n nf=1 m=(1)
mp10 (SEb SE VDD NW) g45p1svt w=(215n) l=45n nf=1 m=(1)
mp0 (Eb E VDD NW) g45p1svt w=(215n) l=45n nf=1 m=(1)
mp4 (net505 Eb net493 NW) g45p1svt w=(215n) l=45n nf=1 m=(1)
mp5 (net505 qbint net493 NW) g45p1svt w=(215n) l=45n nf=1 m=(1)
mp3 (net493 RNb VDD NW) g45p1svt w=(215n) l=45n nf=1 m=(1)
mp56 (net582 qbint VDD NW) g45p1svt w=(390n) l=45n nf=1 m=(1)
mp45 (qbint n30 VDD NW) g45p1svt w=(620n) l=45n nf=1 m=(1)
mp30 (mout n20 VDD NW) g45p1svt w=(215n) l=45n nf=1 m=(1)
mp40 (n30 CKb mout NW) g45p1svt w=(215n) l=45n nf=1 m=(1)
mp21 (CKbb CKb VDD NW) g45p1svt w=(215n) l=45n nf=1 m=(1)
mp25 (n20 CKbb Dpb NW) g45p1svt w=(215n) l=45n nf=1 m=(1)
ends SEDFFTRX4

// gsclib045_backbias/SEDFFTRXL/schematic

simulator lang=spectre

subckt SEDFFTRXL CK D E Q QN RN SE SI VSS NW VDD
mn14 (Dpb SE net658 VSS) g45n1svt w=(145n) l=45n nf=1 m=(1)
mn13 (net658 SI VSS VSS) g45n1svt w=(145n) l=45n nf=1 m=(1)
mn12 (Dpb SEb net650 VSS) g45n1svt w=(145n) l=45n nf=1 m=(1)
mn11 (net650 Dp VSS VSS) g45n1svt w=(145n) l=45n nf=1 m=(1)
mn1 (Db D VSS VSS) g45n1svt w=(145n) l=45n nf=1 m=(1)
mn7 (Dp Db net638 VSS) g45n1svt w=(145n) l=45n nf=1 m=(1)
mn6 (net638 E VSS VSS) g45n1svt w=(145n) l=45n nf=1 m=(1)
mn4 (net634 Eb VSS VSS) g45n1svt w=(145n) l=45n nf=1 m=(1)
mn5 (Dp qbint net634 VSS) g45n1svt w=(145n) l=45n nf=1 m=(1)
mn57 (QN net582 VSS VSS) g45n1svt w=(145n) l=45n nf=1 m=(1)
mn55 (Q qbint VSS VSS) g45n1svt w=(145n) l=45n nf=1 m=(1)
mn50 (net618 qbint VSS VSS) g45n1svt w=(145n) l=45n nf=1 m=(1)
mn51 (n30 CKb net618 VSS) g45n1svt w=(145n) l=45n nf=1 m=(1)
mn36 (n20 CKbb net606 VSS) g45n1svt w=(145n) l=45n nf=1 m=(1)
mn35 (net606 mout VSS VSS) g45n1svt w=(145n) l=45n nf=1 m=(1)
mn20 (CKb CK VSS VSS) g45n1svt w=(145n) l=45n nf=1 m=(1)
mn2 (RNb RN VSS VSS) g45n1svt w=(145n) l=45n nf=1 m=(1)
mn10 (SEb SE VSS VSS) g45n1svt w=(145n) l=45n nf=1 m=(1)
mn0 (Eb E VSS VSS) g45n1svt w=(145n) l=45n nf=1 m=(1)
mn3 (Dp RNb VSS VSS) g45n1svt w=(145n) l=45n nf=1 m=(1)
mn56 (net582 qbint VSS VSS) g45n1svt w=(145n) l=45n nf=1 m=(1)
mn45 (qbint n30 VSS VSS) g45n1svt w=(145n) l=45n nf=1 m=(1)
mn30 (mout n20 VSS VSS) g45n1svt w=(145n) l=45n nf=1 m=(1)
mn25 (n20 CKb Dpb VSS) g45n1svt w=(145n) l=45n nf=1 m=(1)
mn40 (n30 CKbb mout VSS) g45n1svt w=(145n) l=45n nf=1 m=(1)
mn21 (CKbb CKb VSS VSS) g45n1svt w=(145n) l=45n nf=1 m=(1)
mp13 (net557 SI VDD NW) g45p1svt w=(215n) l=45n nf=1 m=(1)
mp14 (Dpb SEb net557 NW) g45p1svt w=(215n) l=45n nf=1 m=(1)
mp11 (net549 Dp VDD NW) g45p1svt w=(215n) l=45n nf=1 m=(1)
mp12 (Dpb SE net549 NW) g45p1svt w=(215n) l=45n nf=1 m=(1)
mp1 (Db D VDD NW) g45p1svt w=(215n) l=45n nf=1 m=(1)
mp57 (QN net582 VDD NW) g45p1svt w=(215n) l=45n nf=1 m=(1)
mp55 (Q qbint VDD NW) g45p1svt w=(215n) l=45n nf=1 m=(1)
mp50 (net529 qbint VDD NW) g45p1svt w=(215n) l=45n nf=1 m=(1)
mp51 (n30 CKbb net529 NW) g45p1svt w=(215n) l=45n nf=1 m=(1)
mp35 (net521 mout VDD NW) g45p1svt w=(215n) l=45n nf=1 m=(1)
mp36 (n20 CKb net521 NW) g45p1svt w=(215n) l=45n nf=1 m=(1)
mp20 (CKb CK VDD NW) g45p1svt w=(215n) l=45n nf=1 m=(1)
mp2 (RNb RN VDD NW) g45p1svt w=(215n) l=45n nf=1 m=(1)
mp7 (Dp Db net505 NW) g45p1svt w=(215n) l=45n nf=1 m=(1)
mp6 (Dp E net505 NW) g45p1svt w=(215n) l=45n nf=1 m=(1)
mp10 (SEb SE VDD NW) g45p1svt w=(215n) l=45n nf=1 m=(1)
mp0 (Eb E VDD NW) g45p1svt w=(215n) l=45n nf=1 m=(1)
mp4 (net505 Eb net493 NW) g45p1svt w=(215n) l=45n nf=1 m=(1)
mp5 (net505 qbint net493 NW) g45p1svt w=(215n) l=45n nf=1 m=(1)
mp3 (net493 RNb VDD NW) g45p1svt w=(215n) l=45n nf=1 m=(1)
mp56 (net582 qbint VDD NW) g45p1svt w=(215n) l=45n nf=1 m=(1)
mp45 (qbint n30 VDD NW) g45p1svt w=(215n) l=45n nf=1 m=(1)
mp30 (mout n20 VDD NW) g45p1svt w=(215n) l=45n nf=1 m=(1)
mp40 (n30 CKb mout NW) g45p1svt w=(215n) l=45n nf=1 m=(1)
mp21 (CKbb CKb VDD NW) g45p1svt w=(215n) l=45n nf=1 m=(1)
mp25 (n20 CKbb Dpb NW) g45p1svt w=(215n) l=45n nf=1 m=(1)
ends SEDFFTRXL

// gsclib045_backbias/SEDFFX1/schematic

simulator lang=spectre

subckt SEDFFX1 CK D E Q QN SE SI VSS VDD NW
mn4 (Db E net554 VSS) g45n1svt w=(145n) l=45n nf=1 m=(1)
mn3 (net554 D VSS VSS) g45n1svt w=(145n) l=45n nf=1 m=(1)
mn13 (Dbp SE net546 VSS) g45n1svt w=(145n) l=45n nf=1 m=(1)
mn12 (net546 SI VSS VSS) g45n1svt w=(145n) l=45n nf=1 m=(1)
mn57 (QN net502 VSS VSS) g45n1svt w=(260n) l=45n nf=1 m=(1)
mn55 (Q net536 VSS VSS) g45n1svt w=(260n) l=45n nf=1 m=(1)
mn50 (net534 net536 VSS VSS) g45n1svt w=(145n) l=45n nf=1 m=(1)
mn51 (n30 CKb net534 VSS) g45n1svt w=(145n) l=45n nf=1 m=(1)
mn35 (net526 mout VSS VSS) g45n1svt w=(145n) l=45n nf=1 m=(1)
mn36 (n20 CKbb net526 VSS) g45n1svt w=(145n) l=45n nf=1 m=(1)
mn20 (CKb CK VSS VSS) g45n1svt w=(145n) l=45n nf=1 m=(1)
mn1 (net514 net502 VSS VSS) g45n1svt w=(145n) l=45n nf=1 m=(1)
mn2 (Db Eb net514 VSS) g45n1svt w=(145n) l=45n nf=1 m=(1)
mn45 (net536 n30 VSS VSS) g45n1svt w=(145n) l=45n nf=1 m=(1)
mn56 (net502 net536 VSS VSS) g45n1svt w=(145n) l=45n nf=1 m=(1)
mn21 (CKbb CKb VSS VSS) g45n1svt w=(145n) l=45n nf=1 m=(1)
mn40 (mout CKbb n30 VSS) g45n1svt w=(145n) l=45n nf=1 m=(1)
mn10 (SEb SE VSS VSS) g45n1svt w=(145n) l=45n nf=1 m=(1)
mn30 (mout n20 VSS VSS) g45n1svt w=(145n) l=45n nf=1 m=(1)
mn0 (Eb E VSS VSS) g45n1svt w=(145n) l=45n nf=1 m=(1)
mn25 (Dbp CKb n20 VSS) g45n1svt w=(145n) l=45n nf=1 m=(1)
mn11 (Db SEb Dbp VSS) g45n1svt w=(145n) l=45n nf=1 m=(1)
mp4 (Db Eb net473 NW) g45p1svt w=(215n) l=45n nf=1 m=(1)
mp3 (net473 D VDD NW) g45p1svt w=(215n) l=45n nf=1 m=(1)
mp13 (Dbp SEb net465 NW) g45p1svt w=(215n) l=45n nf=1 m=(1)
mp12 (net465 SI VDD NW) g45p1svt w=(215n) l=45n nf=1 m=(1)
mp51 (n30 CKbb net457 NW) g45p1svt w=(215n) l=45n nf=1 m=(1)
mp50 (net457 net536 VDD NW) g45p1svt w=(215n) l=45n nf=1 m=(1)
mp57 (QN net502 VDD NW) g45p1svt w=(390n) l=45n nf=1 m=(1)
mp55 (Q net536 VDD NW) g45p1svt w=(390n) l=45n nf=1 m=(1)
mp35 (net437 mout VDD NW) g45p1svt w=(215n) l=45n nf=1 m=(1)
mp36 (n20 CKb net437 NW) g45p1svt w=(215n) l=45n nf=1 m=(1)
mp20 (CKb CK VDD NW) g45p1svt w=(215n) l=45n nf=1 m=(1)
mp1 (net425 net502 VDD NW) g45p1svt w=(215n) l=45n nf=1 m=(1)
mp2 (Db E net425 NW) g45p1svt w=(215n) l=45n nf=1 m=(1)
mp45 (net536 n30 VDD NW) g45p1svt w=(215n) l=45n nf=1 m=(1)
mp56 (net502 net536 VDD NW) g45p1svt w=(215n) l=45n nf=1 m=(1)
mp21 (CKbb CKb VDD NW) g45p1svt w=(215n) l=45n nf=1 m=(1)
mp40 (n30 CKb mout NW) g45p1svt w=(215n) l=45n nf=1 m=(1)
mp30 (mout n20 VDD NW) g45p1svt w=(215n) l=45n nf=1 m=(1)
mp0 (Eb E VDD NW) g45p1svt w=(215n) l=45n nf=1 m=(1)
mp25 (n20 CKbb Dbp NW) g45p1svt w=(215n) l=45n nf=1 m=(1)
mp11 (Dbp SE Db NW) g45p1svt w=(215n) l=45n nf=1 m=(1)
mp10 (SEb SE VDD NW) g45p1svt w=(215n) l=45n nf=1 m=(1)
ends SEDFFX1

// gsclib045_backbias/SEDFFX2/schematic

simulator lang=spectre

subckt SEDFFX2 CK D E Q QN SE SI VSS VDD NW
mn4 (Db E net554 VSS) g45n1svt w=(145n) l=45n nf=1 m=(1)
mn3 (net554 D VSS VSS) g45n1svt w=(145n) l=45n nf=1 m=(1)
mn13 (Dbp SE net546 VSS) g45n1svt w=(145n) l=45n nf=1 m=(1)
mn12 (net546 SI VSS VSS) g45n1svt w=(145n) l=45n nf=1 m=(1)
mn57 (QN net502 VSS VSS) g45n1svt w=(520n) l=45n nf=1 m=(1)
mn55 (Q net536 VSS VSS) g45n1svt w=(520n) l=45n nf=1 m=(1)
mn50 (net534 net536 VSS VSS) g45n1svt w=(145n) l=45n nf=1 m=(1)
mn51 (n30 CKb net534 VSS) g45n1svt w=(145n) l=45n nf=1 m=(1)
mn35 (net526 mout VSS VSS) g45n1svt w=(145n) l=45n nf=1 m=(1)
mn36 (n20 CKbb net526 VSS) g45n1svt w=(145n) l=45n nf=1 m=(1)
mn20 (CKb CK VSS VSS) g45n1svt w=(145n) l=45n nf=1 m=(1)
mn1 (net514 net502 VSS VSS) g45n1svt w=(145n) l=45n nf=1 m=(1)
mn2 (Db Eb net514 VSS) g45n1svt w=(145n) l=45n nf=1 m=(1)
mn45 (net536 n30 VSS VSS) g45n1svt w=(205n) l=45n nf=1 m=(1)
mn56 (net502 net536 VSS VSS) g45n1svt w=(145n) l=45n nf=1 m=(1)
mn21 (CKbb CKb VSS VSS) g45n1svt w=(145n) l=45n nf=1 m=(1)
mn40 (mout CKbb n30 VSS) g45n1svt w=(145n) l=45n nf=1 m=(1)
mn10 (SEb SE VSS VSS) g45n1svt w=(145n) l=45n nf=1 m=(1)
mn30 (mout n20 VSS VSS) g45n1svt w=(145n) l=45n nf=1 m=(1)
mn0 (Eb E VSS VSS) g45n1svt w=(145n) l=45n nf=1 m=(1)
mn25 (Dbp CKb n20 VSS) g45n1svt w=(145n) l=45n nf=1 m=(1)
mn11 (Db SEb Dbp VSS) g45n1svt w=(145n) l=45n nf=1 m=(1)
mp4 (Db Eb net473 NW) g45p1svt w=(215n) l=45n nf=1 m=(1)
mp3 (net473 D VDD NW) g45p1svt w=(215n) l=45n nf=1 m=(1)
mp13 (Dbp SEb net465 NW) g45p1svt w=(215n) l=45n nf=1 m=(1)
mp12 (net465 SI VDD NW) g45p1svt w=(215n) l=45n nf=1 m=(1)
mp51 (n30 CKbb net457 NW) g45p1svt w=(215n) l=45n nf=1 m=(1)
mp50 (net457 net536 VDD NW) g45p1svt w=(215n) l=45n nf=1 m=(1)
mp57 (QN net502 VDD NW) g45p1svt w=(780n) l=45n nf=1 m=(1)
mp55 (Q net536 VDD NW) g45p1svt w=(780n) l=45n nf=1 m=(1)
mp35 (net437 mout VDD NW) g45p1svt w=(215n) l=45n nf=1 m=(1)
mp36 (n20 CKb net437 NW) g45p1svt w=(215n) l=45n nf=1 m=(1)
mp20 (CKb CK VDD NW) g45p1svt w=(215n) l=45n nf=1 m=(1)
mp1 (net425 net502 VDD NW) g45p1svt w=(215n) l=45n nf=1 m=(1)
mp2 (Db E net425 NW) g45p1svt w=(215n) l=45n nf=1 m=(1)
mp45 (net536 n30 VDD NW) g45p1svt w=(310n) l=45n nf=1 m=(1)
mp56 (net502 net536 VDD NW) g45p1svt w=(215n) l=45n nf=1 m=(1)
mp21 (CKbb CKb VDD NW) g45p1svt w=(215n) l=45n nf=1 m=(1)
mp40 (n30 CKb mout NW) g45p1svt w=(215n) l=45n nf=1 m=(1)
mp30 (mout n20 VDD NW) g45p1svt w=(215n) l=45n nf=1 m=(1)
mp0 (Eb E VDD NW) g45p1svt w=(215n) l=45n nf=1 m=(1)
mp25 (n20 CKbb Dbp NW) g45p1svt w=(215n) l=45n nf=1 m=(1)
mp11 (Dbp SE Db NW) g45p1svt w=(215n) l=45n nf=1 m=(1)
mp10 (SEb SE VDD NW) g45p1svt w=(215n) l=45n nf=1 m=(1)
ends SEDFFX2

// gsclib045_backbias/SEDFFX4/schematic

simulator lang=spectre

subckt SEDFFX4 CK D E Q QN SE SI NW VSS VDD
mn4 (Db E net554 VSS) g45n1svt w=(145n) l=45n nf=1 m=(1)
mn3 (net554 D VSS VSS) g45n1svt w=(145n) l=45n nf=1 m=(1)
mn13 (Dbp SE net546 VSS) g45n1svt w=(145n) l=45n nf=1 m=(1)
mn12 (net546 SI VSS VSS) g45n1svt w=(145n) l=45n nf=1 m=(1)
mn57 (QN net502 VSS VSS) g45n1svt w=(1.04u) l=45n nf=1 m=(1)
mn55 (Q net536 VSS VSS) g45n1svt w=(1.04u) l=45n nf=1 m=(1)
mn50 (net534 net536 VSS VSS) g45n1svt w=(145n) l=45n nf=1 m=(1)
mn51 (n30 CKb net534 VSS) g45n1svt w=(145n) l=45n nf=1 m=(1)
mn35 (net526 mout VSS VSS) g45n1svt w=(145n) l=45n nf=1 m=(1)
mn36 (n20 CKbb net526 VSS) g45n1svt w=(145n) l=45n nf=1 m=(1)
mn20 (CKb CK VSS VSS) g45n1svt w=(145n) l=45n nf=1 m=(1)
mn1 (net514 net502 VSS VSS) g45n1svt w=(145n) l=45n nf=1 m=(1)
mn2 (Db Eb net514 VSS) g45n1svt w=(145n) l=45n nf=1 m=(1)
mn45 (net536 n30 VSS VSS) g45n1svt w=(410n) l=45n nf=1 m=(1)
mn56 (net502 net536 VSS VSS) g45n1svt w=(260n) l=45n nf=1 m=(1)
mn21 (CKbb CKb VSS VSS) g45n1svt w=(145n) l=45n nf=1 m=(1)
mn40 (mout CKbb n30 VSS) g45n1svt w=(145n) l=45n nf=1 m=(1)
mn10 (SEb SE VSS VSS) g45n1svt w=(145n) l=45n nf=1 m=(1)
mn30 (mout n20 VSS VSS) g45n1svt w=(145n) l=45n nf=1 m=(1)
mn0 (Eb E VSS VSS) g45n1svt w=(145n) l=45n nf=1 m=(1)
mn25 (Dbp CKb n20 VSS) g45n1svt w=(145n) l=45n nf=1 m=(1)
mn11 (Db SEb Dbp VSS) g45n1svt w=(145n) l=45n nf=1 m=(1)
mp4 (Db Eb net473 NW) g45p1svt w=(215n) l=45n nf=1 m=(1)
mp3 (net473 D VDD NW) g45p1svt w=(215n) l=45n nf=1 m=(1)
mp13 (Dbp SEb net465 NW) g45p1svt w=(215n) l=45n nf=1 m=(1)
mp12 (net465 SI VDD NW) g45p1svt w=(215n) l=45n nf=1 m=(1)
mp51 (n30 CKbb net457 NW) g45p1svt w=(215n) l=45n nf=1 m=(1)
mp50 (net457 net536 VDD NW) g45p1svt w=(215n) l=45n nf=1 m=(1)
mp57 (QN net502 VDD NW) g45p1svt w=(1.56u) l=45n nf=1 m=(1)
mp55 (Q net536 VDD NW) g45p1svt w=(1.56u) l=45n nf=1 m=(1)
mp35 (net437 mout VDD NW) g45p1svt w=(215n) l=45n nf=1 m=(1)
mp36 (n20 CKb net437 NW) g45p1svt w=(215n) l=45n nf=1 m=(1)
mp20 (CKb CK VDD NW) g45p1svt w=(215n) l=45n nf=1 m=(1)
mp1 (net425 net502 VDD NW) g45p1svt w=(215n) l=45n nf=1 m=(1)
mp2 (Db E net425 NW) g45p1svt w=(215n) l=45n nf=1 m=(1)
mp45 (net536 n30 VDD NW) g45p1svt w=(620n) l=45n nf=1 m=(1)
mp56 (net502 net536 VDD NW) g45p1svt w=(390n) l=45n nf=1 m=(1)
mp21 (CKbb CKb VDD NW) g45p1svt w=(215n) l=45n nf=1 m=(1)
mp40 (n30 CKb mout NW) g45p1svt w=(215n) l=45n nf=1 m=(1)
mp30 (mout n20 VDD NW) g45p1svt w=(215n) l=45n nf=1 m=(1)
mp0 (Eb E VDD NW) g45p1svt w=(215n) l=45n nf=1 m=(1)
mp25 (n20 CKbb Dbp NW) g45p1svt w=(215n) l=45n nf=1 m=(1)
mp11 (Dbp SE Db NW) g45p1svt w=(215n) l=45n nf=1 m=(1)
mp10 (SEb SE VDD NW) g45p1svt w=(215n) l=45n nf=1 m=(1)
ends SEDFFX4

// gsclib045_backbias/SEDFFXL/schematic

simulator lang=spectre

subckt SEDFFXL CK D E Q QN SE SI VSS NW VDD
mn4 (Db E net554 VSS) g45n1svt w=(145n) l=45n nf=1 m=(1)
mn3 (net554 D VSS VSS) g45n1svt w=(145n) l=45n nf=1 m=(1)
mn13 (Dbp SE net546 VSS) g45n1svt w=(145n) l=45n nf=1 m=(1)
mn12 (net546 SI VSS VSS) g45n1svt w=(145n) l=45n nf=1 m=(1)
mn57 (QN net502 VSS VSS) g45n1svt w=(145n) l=45n nf=1 m=(1)
mn55 (Q net536 VSS VSS) g45n1svt w=(145n) l=45n nf=1 m=(1)
mn50 (net534 net536 VSS VSS) g45n1svt w=(145n) l=45n nf=1 m=(1)
mn51 (n30 CKb net534 VSS) g45n1svt w=(145n) l=45n nf=1 m=(1)
mn35 (net526 mout VSS VSS) g45n1svt w=(145n) l=45n nf=1 m=(1)
mn36 (n20 CKbb net526 VSS) g45n1svt w=(145n) l=45n nf=1 m=(1)
mn20 (CKb CK VSS VSS) g45n1svt w=(145n) l=45n nf=1 m=(1)
mn1 (net514 net502 VSS VSS) g45n1svt w=(145n) l=45n nf=1 m=(1)
mn2 (Db Eb net514 VSS) g45n1svt w=(145n) l=45n nf=1 m=(1)
mn45 (net536 n30 VSS VSS) g45n1svt w=(145n) l=45n nf=1 m=(1)
mn56 (net502 net536 VSS VSS) g45n1svt w=(145n) l=45n nf=1 m=(1)
mn21 (CKbb CKb VSS VSS) g45n1svt w=(145n) l=45n nf=1 m=(1)
mn40 (mout CKbb n30 VSS) g45n1svt w=(145n) l=45n nf=1 m=(1)
mn10 (SEb SE VSS VSS) g45n1svt w=(145n) l=45n nf=1 m=(1)
mn30 (mout n20 VSS VSS) g45n1svt w=(145n) l=45n nf=1 m=(1)
mn0 (Eb E VSS VSS) g45n1svt w=(145n) l=45n nf=1 m=(1)
mn25 (Dbp CKb n20 VSS) g45n1svt w=(145n) l=45n nf=1 m=(1)
mn11 (Db SEb Dbp VSS) g45n1svt w=(145n) l=45n nf=1 m=(1)
mp4 (Db Eb net473 NW) g45p1svt w=(215n) l=45n nf=1 m=(1)
mp3 (net473 D VDD NW) g45p1svt w=(215n) l=45n nf=1 m=(1)
mp13 (Dbp SEb net465 NW) g45p1svt w=(215n) l=45n nf=1 m=(1)
mp12 (net465 SI VDD NW) g45p1svt w=(215n) l=45n nf=1 m=(1)
mp51 (n30 CKbb net457 NW) g45p1svt w=(215n) l=45n nf=1 m=(1)
mp50 (net457 net536 VDD NW) g45p1svt w=(215n) l=45n nf=1 m=(1)
mp57 (QN net502 VDD NW) g45p1svt w=(215n) l=45n nf=1 m=(1)
mp55 (Q net536 VDD NW) g45p1svt w=(215n) l=45n nf=1 m=(1)
mp35 (net437 mout VDD NW) g45p1svt w=(215n) l=45n nf=1 m=(1)
mp36 (n20 CKb net437 NW) g45p1svt w=(215n) l=45n nf=1 m=(1)
mp20 (CKb CK VDD NW) g45p1svt w=(215n) l=45n nf=1 m=(1)
mp1 (net425 net502 VDD NW) g45p1svt w=(215n) l=45n nf=1 m=(1)
mp2 (Db E net425 NW) g45p1svt w=(215n) l=45n nf=1 m=(1)
mp45 (net536 n30 VDD NW) g45p1svt w=(215n) l=45n nf=1 m=(1)
mp56 (net502 net536 VDD NW) g45p1svt w=(215n) l=45n nf=1 m=(1)
mp21 (CKbb CKb VDD NW) g45p1svt w=(215n) l=45n nf=1 m=(1)
mp40 (n30 CKb mout NW) g45p1svt w=(215n) l=45n nf=1 m=(1)
mp30 (mout n20 VDD NW) g45p1svt w=(215n) l=45n nf=1 m=(1)
mp0 (Eb E VDD NW) g45p1svt w=(215n) l=45n nf=1 m=(1)
mp25 (n20 CKbb Dbp NW) g45p1svt w=(215n) l=45n nf=1 m=(1)
mp11 (Dbp SE Db NW) g45p1svt w=(215n) l=45n nf=1 m=(1)
mp10 (SEb SE VDD NW) g45p1svt w=(215n) l=45n nf=1 m=(1)
ends SEDFFXL

// gsclib045_backbias/SMDFFHQX1/schematic

simulator lang=spectre

subckt SMDFFHQX1 CK D0 D1 Q S0 SE SI VDD VSS NW
mn3 (net510 D1 VSS VSS) g45n1svt w=(260n) l=45n nf=1 m=(1)
mn4 (db S0 net510 VSS) g45n1svt w=(260n) l=45n nf=1 m=(1)
mn2 (db S0b net498 VSS) g45n1svt w=(260n) l=45n nf=1 m=(1)
mn1 (net498 D0 VSS VSS) g45n1svt w=(260n) l=45n nf=1 m=(1)
mn13 (dbp SE net490 VSS) g45n1svt w=(260n) l=45n nf=1 m=(1)
mn12 (net490 SI VSS VSS) g45n1svt w=(260n) l=45n nf=1 m=(1)
mn55 (Q qbint VSS VSS) g45n1svt w=(260n) l=45n nf=1 m=(1)
mn50 (net482 qbint VSS VSS) g45n1svt w=(205n) l=45n nf=1 m=(1)
mn51 (n30 CKb net482 VSS) g45n1svt w=(205n) l=45n nf=1 m=(1)
mn35 (net474 mout VSS VSS) g45n1svt w=(205n) l=45n nf=1 m=(1)
mn36 (n20 CKbb net474 VSS) g45n1svt w=(205n) l=45n nf=1 m=(1)
mn20 (CKb CK VSS VSS) g45n1svt w=(145n) l=45n nf=1 m=(1)
mn45 (qbint n30 VSS VSS) g45n1svt w=(205n) l=45n nf=1 m=(1)
mn10 (SEb SE VSS VSS) g45n1svt w=(145n) l=45n nf=1 m=(1)
mn0 (S0b S0 VSS VSS) g45n1svt w=(145n) l=45n nf=1 m=(1)
mn11 (db SEb dbp VSS) g45n1svt w=(260n) l=45n nf=1 m=(1)
mn40 (mout CKbb n30 VSS) g45n1svt w=(205n) l=45n nf=1 m=(1)
mn25 (dbp CKb n20 VSS) g45n1svt w=(205n) l=45n nf=1 m=(1)
mn30 (mout n20 VSS VSS) g45n1svt w=(205n) l=45n nf=1 m=(1)
mn21 (CKbb CKb VSS VSS) g45n1svt w=(145n) l=45n nf=1 m=(1)
mp3 (net429 D1 VDD NW) g45p1svt w=(390n) l=45n nf=1 m=(1)
mp4 (db S0b net429 NW) g45p1svt w=(390n) l=45n nf=1 m=(1)
mp2 (db S0 net425 NW) g45p1svt w=(390n) l=45n nf=1 m=(1)
mp1 (net425 D0 VDD NW) g45p1svt w=(390n) l=45n nf=1 m=(1)
mp13 (dbp SEb net417 NW) g45p1svt w=(390n) l=45n nf=1 m=(1)
mp12 (net417 SI VDD NW) g45p1svt w=(390n) l=45n nf=1 m=(1)
mp51 (n30 CKbb net409 NW) g45p1svt w=(310n) l=45n nf=1 m=(1)
mp50 (net409 qbint VDD NW) g45p1svt w=(310n) l=45n nf=1 m=(1)
mp55 (Q qbint VDD NW) g45p1svt w=(390n) l=45n nf=1 m=(1)
mp35 (net393 mout VDD NW) g45p1svt w=(310n) l=45n nf=1 m=(1)
mp36 (n20 CKb net393 NW) g45p1svt w=(310n) l=45n nf=1 m=(1)
mp20 (CKb CK VDD NW) g45p1svt w=(215n) l=45n nf=1 m=(1)
mp45 (qbint n30 VDD NW) g45p1svt w=(310n) l=45n nf=1 m=(1)
mp0 (S0b S0 VDD NW) g45p1svt w=(215n) l=45n nf=1 m=(1)
mp40 (n30 CKb mout NW) g45p1svt w=(310n) l=45n nf=1 m=(1)
mp21 (CKbb CKb VDD NW) g45p1svt w=(215n) l=45n nf=1 m=(1)
mp30 (mout n20 VDD NW) g45p1svt w=(310n) l=45n nf=1 m=(1)
mp10 (SEb SE VDD NW) g45p1svt w=(215n) l=45n nf=1 m=(1)
mp11 (dbp SE db NW) g45p1svt w=(390n) l=45n nf=1 m=(1)
mp25 (n20 CKbb dbp NW) g45p1svt w=(310n) l=45n nf=1 m=(1)
ends SMDFFHQX1

// gsclib045_backbias/SMDFFHQX2/schematic

simulator lang=spectre

subckt SMDFFHQX2 CK D0 D1 Q S0 SE SI VDD VSS NW
mn3 (net510 D1 VSS VSS) g45n1svt w=(260n) l=45n nf=1 m=(1)
mn4 (db S0 net510 VSS) g45n1svt w=(260n) l=45n nf=1 m=(1)
mn2 (db S0b net498 VSS) g45n1svt w=(260n) l=45n nf=1 m=(1)
mn1 (net498 D0 VSS VSS) g45n1svt w=(260n) l=45n nf=1 m=(1)
mn13 (dbp SE net490 VSS) g45n1svt w=(260n) l=45n nf=1 m=(1)
mn12 (net490 SI VSS VSS) g45n1svt w=(260n) l=45n nf=1 m=(1)
mn55 (Q qbint VSS VSS) g45n1svt w=(520n) l=45n nf=1 m=(1)
mn50 (net482 qbint VSS VSS) g45n1svt w=(205n) l=45n nf=1 m=(1)
mn51 (n30 CKb net482 VSS) g45n1svt w=(205n) l=45n nf=1 m=(1)
mn35 (net474 mout VSS VSS) g45n1svt w=(205n) l=45n nf=1 m=(1)
mn36 (n20 CKbb net474 VSS) g45n1svt w=(205n) l=45n nf=1 m=(1)
mn20 (CKb CK VSS VSS) g45n1svt w=(145n) l=45n nf=1 m=(1)
mn45 (qbint n30 VSS VSS) g45n1svt w=(260n) l=45n nf=1 m=(1)
mn10 (SEb SE VSS VSS) g45n1svt w=(145n) l=45n nf=1 m=(1)
mn0 (S0b S0 VSS VSS) g45n1svt w=(145n) l=45n nf=1 m=(1)
mn11 (db SEb dbp VSS) g45n1svt w=(260n) l=45n nf=1 m=(1)
mn40 (mout CKbb n30 VSS) g45n1svt w=(205n) l=45n nf=1 m=(1)
mn25 (dbp CKb n20 VSS) g45n1svt w=(205n) l=45n nf=1 m=(1)
mn30 (mout n20 VSS VSS) g45n1svt w=(205n) l=45n nf=1 m=(1)
mn21 (CKbb CKb VSS VSS) g45n1svt w=(145n) l=45n nf=1 m=(1)
mp3 (net429 D1 VDD NW) g45p1svt w=(390n) l=45n nf=1 m=(1)
mp4 (db S0b net429 NW) g45p1svt w=(390n) l=45n nf=1 m=(1)
mp2 (db S0 net425 NW) g45p1svt w=(390n) l=45n nf=1 m=(1)
mp1 (net425 D0 VDD NW) g45p1svt w=(390n) l=45n nf=1 m=(1)
mp13 (dbp SEb net417 NW) g45p1svt w=(390n) l=45n nf=1 m=(1)
mp12 (net417 SI VDD NW) g45p1svt w=(390n) l=45n nf=1 m=(1)
mp51 (n30 CKbb net409 NW) g45p1svt w=(310n) l=45n nf=1 m=(1)
mp50 (net409 qbint VDD NW) g45p1svt w=(310n) l=45n nf=1 m=(1)
mp55 (Q qbint VDD NW) g45p1svt w=(780n) l=45n nf=1 m=(1)
mp35 (net393 mout VDD NW) g45p1svt w=(310n) l=45n nf=1 m=(1)
mp36 (n20 CKb net393 NW) g45p1svt w=(310n) l=45n nf=1 m=(1)
mp20 (CKb CK VDD NW) g45p1svt w=(215n) l=45n nf=1 m=(1)
mp45 (qbint n30 VDD NW) g45p1svt w=(390n) l=45n nf=1 m=(1)
mp0 (S0b S0 VDD NW) g45p1svt w=(215n) l=45n nf=1 m=(1)
mp40 (n30 CKb mout NW) g45p1svt w=(310n) l=45n nf=1 m=(1)
mp21 (CKbb CKb VDD NW) g45p1svt w=(215n) l=45n nf=1 m=(1)
mp30 (mout n20 VDD NW) g45p1svt w=(310n) l=45n nf=1 m=(1)
mp10 (SEb SE VDD NW) g45p1svt w=(215n) l=45n nf=1 m=(1)
mp11 (dbp SE db NW) g45p1svt w=(390n) l=45n nf=1 m=(1)
mp25 (n20 CKbb dbp NW) g45p1svt w=(310n) l=45n nf=1 m=(1)
ends SMDFFHQX2

// gsclib045_backbias/SMDFFHQX4/schematic

simulator lang=spectre

subckt SMDFFHQX4 CK D0 D1 Q S0 SE SI VDD VSS NW
mn3 (net510 D1 VSS VSS) g45n1svt w=(260n) l=45n nf=1 m=(1)
mn4 (db S0 net510 VSS) g45n1svt w=(260n) l=45n nf=1 m=(1)
mn2 (db S0b net498 VSS) g45n1svt w=(260n) l=45n nf=1 m=(1)
mn1 (net498 D0 VSS VSS) g45n1svt w=(260n) l=45n nf=1 m=(1)
mn13 (dbp SE net490 VSS) g45n1svt w=(260n) l=45n nf=1 m=(1)
mn12 (net490 SI VSS VSS) g45n1svt w=(260n) l=45n nf=1 m=(1)
mn55 (Q qbint VSS VSS) g45n1svt w=(1.04u) l=45n nf=1 m=(1)
mn50 (net482 qbint VSS VSS) g45n1svt w=(205n) l=45n nf=1 m=(1)
mn51 (n30 CKb net482 VSS) g45n1svt w=(205n) l=45n nf=1 m=(1)
mn35 (net474 mout VSS VSS) g45n1svt w=(205n) l=45n nf=1 m=(1)
mn36 (n20 CKbb net474 VSS) g45n1svt w=(205n) l=45n nf=1 m=(1)
mn20 (CKb CK VSS VSS) g45n1svt w=(145n) l=45n nf=1 m=(1)
mn45 (qbint n30 VSS VSS) g45n1svt w=(410n) l=45n nf=1 m=(1)
mn10 (SEb SE VSS VSS) g45n1svt w=(145n) l=45n nf=1 m=(1)
mn0 (S0b S0 VSS VSS) g45n1svt w=(145n) l=45n nf=1 m=(1)
mn11 (db SEb dbp VSS) g45n1svt w=(260n) l=45n nf=1 m=(1)
mn40 (mout CKbb n30 VSS) g45n1svt w=(205n) l=45n nf=1 m=(1)
mn25 (dbp CKb n20 VSS) g45n1svt w=(205n) l=45n nf=1 m=(1)
mn30 (mout n20 VSS VSS) g45n1svt w=(205n) l=45n nf=1 m=(1)
mn21 (CKbb CKb VSS VSS) g45n1svt w=(145n) l=45n nf=1 m=(1)
mp3 (net429 D1 VDD NW) g45p1svt w=(390n) l=45n nf=1 m=(1)
mp4 (db S0b net429 NW) g45p1svt w=(390n) l=45n nf=1 m=(1)
mp2 (db S0 net425 NW) g45p1svt w=(390n) l=45n nf=1 m=(1)
mp1 (net425 D0 VDD NW) g45p1svt w=(390n) l=45n nf=1 m=(1)
mp13 (dbp SEb net417 NW) g45p1svt w=(390n) l=45n nf=1 m=(1)
mp12 (net417 SI VDD NW) g45p1svt w=(390n) l=45n nf=1 m=(1)
mp51 (n30 CKbb net409 NW) g45p1svt w=(310n) l=45n nf=1 m=(1)
mp50 (net409 qbint VDD NW) g45p1svt w=(310n) l=45n nf=1 m=(1)
mp55 (Q qbint VDD NW) g45p1svt w=(1.56u) l=45n nf=1 m=(1)
mp35 (net393 mout VDD NW) g45p1svt w=(310n) l=45n nf=1 m=(1)
mp36 (n20 CKb net393 NW) g45p1svt w=(310n) l=45n nf=1 m=(1)
mp20 (CKb CK VDD NW) g45p1svt w=(215n) l=45n nf=1 m=(1)
mp45 (qbint n30 VDD NW) g45p1svt w=(620n) l=45n nf=1 m=(1)
mp0 (S0b S0 VDD NW) g45p1svt w=(215n) l=45n nf=1 m=(1)
mp40 (n30 CKb mout NW) g45p1svt w=(310n) l=45n nf=1 m=(1)
mp21 (CKbb CKb VDD NW) g45p1svt w=(215n) l=45n nf=1 m=(1)
mp30 (mout n20 VDD NW) g45p1svt w=(310n) l=45n nf=1 m=(1)
mp10 (SEb SE VDD NW) g45p1svt w=(215n) l=45n nf=1 m=(1)
mp11 (dbp SE db NW) g45p1svt w=(390n) l=45n nf=1 m=(1)
mp25 (n20 CKbb dbp NW) g45p1svt w=(310n) l=45n nf=1 m=(1)
ends SMDFFHQX4

// gsclib045_backbias/SMDFFHQX8/schematic

simulator lang=spectre

subckt SMDFFHQX8 CK D0 D1 Q S0 SE SI VDD VSS NW
mn3 (net510 D1 VSS VSS) g45n1svt w=(260n) l=45n nf=1 m=(1)
mn4 (db S0 net510 VSS) g45n1svt w=(260n) l=45n nf=1 m=(1)
mn2 (db S0b net498 VSS) g45n1svt w=(260n) l=45n nf=1 m=(1)
mn1 (net498 D0 VSS VSS) g45n1svt w=(260n) l=45n nf=1 m=(1)
mn13 (dbp SE net490 VSS) g45n1svt w=(260n) l=45n nf=1 m=(1)
mn12 (net490 SI VSS VSS) g45n1svt w=(260n) l=45n nf=1 m=(1)
mn55 (Q qbint VSS VSS) g45n1svt w=(2.065u) l=45n nf=1 m=(1)
mn50 (net482 qbint VSS VSS) g45n1svt w=(205n) l=45n nf=1 m=(1)
mn51 (n30 CKb net482 VSS) g45n1svt w=(205n) l=45n nf=1 m=(1)
mn35 (net474 mout VSS VSS) g45n1svt w=(205n) l=45n nf=1 m=(1)
mn36 (n20 CKbb net474 VSS) g45n1svt w=(205n) l=45n nf=1 m=(1)
mn20 (CKb CK VSS VSS) g45n1svt w=(145n) l=45n nf=1 m=(1)
mn45 (qbint n30 VSS VSS) g45n1svt w=(780n) l=45n nf=1 m=(1)
mn10 (SEb SE VSS VSS) g45n1svt w=(145n) l=45n nf=1 m=(1)
mn0 (S0b S0 VSS VSS) g45n1svt w=(145n) l=45n nf=1 m=(1)
mn11 (db SEb dbp VSS) g45n1svt w=(260n) l=45n nf=1 m=(1)
mn40 (mout CKbb n30 VSS) g45n1svt w=(205n) l=45n nf=1 m=(1)
mn25 (dbp CKb n20 VSS) g45n1svt w=(205n) l=45n nf=1 m=(1)
mn30 (mout n20 VSS VSS) g45n1svt w=(205n) l=45n nf=1 m=(1)
mn21 (CKbb CKb VSS VSS) g45n1svt w=(145n) l=45n nf=1 m=(1)
mp3 (net429 D1 VDD NW) g45p1svt w=(390n) l=45n nf=1 m=(1)
mp4 (db S0b net429 NW) g45p1svt w=(390n) l=45n nf=1 m=(1)
mp2 (db S0 net425 NW) g45p1svt w=(390n) l=45n nf=1 m=(1)
mp1 (net425 D0 VDD NW) g45p1svt w=(390n) l=45n nf=1 m=(1)
mp13 (dbp SEb net417 NW) g45p1svt w=(390n) l=45n nf=1 m=(1)
mp12 (net417 SI VDD NW) g45p1svt w=(390n) l=45n nf=1 m=(1)
mp51 (n30 CKbb net409 NW) g45p1svt w=(310n) l=45n nf=1 m=(1)
mp50 (net409 qbint VDD NW) g45p1svt w=(310n) l=45n nf=1 m=(1)
mp55 (Q qbint VDD NW) g45p1svt w=(3.115u) l=45n nf=1 m=(1)
mp35 (net393 mout VDD NW) g45p1svt w=(310n) l=45n nf=1 m=(1)
mp36 (n20 CKb net393 NW) g45p1svt w=(310n) l=45n nf=1 m=(1)
mp20 (CKb CK VDD NW) g45p1svt w=(215n) l=45n nf=1 m=(1)
mp45 (qbint n30 VDD NW) g45p1svt w=(1.17u) l=45n nf=1 m=(1)
mp0 (S0b S0 VDD NW) g45p1svt w=(215n) l=45n nf=1 m=(1)
mp40 (n30 CKb mout NW) g45p1svt w=(310n) l=45n nf=1 m=(1)
mp21 (CKbb CKb VDD NW) g45p1svt w=(215n) l=45n nf=1 m=(1)
mp30 (mout n20 VDD NW) g45p1svt w=(310n) l=45n nf=1 m=(1)
mp10 (SEb SE VDD NW) g45p1svt w=(215n) l=45n nf=1 m=(1)
mp11 (dbp SE db NW) g45p1svt w=(390n) l=45n nf=1 m=(1)
mp25 (n20 CKbb dbp NW) g45p1svt w=(310n) l=45n nf=1 m=(1)
ends SMDFFHQX8

// gsclib045_backbias/HOLDX1/schematic

simulator lang=spectre

subckt HOLDX1 Y VDD VSS NW
mn1 (Y n0 n1 VSS) g45n1svt w=(145n) l=45n nf=1 m=(1)
mn0 (n0 Y VSS VSS) g45n1svt w=(260n) l=45n nf=1 m=(1)
mn2 (n1 n0 n2 VSS) g45n1svt w=(145n) l=45n nf=1 m=(1)
mn3 (n2 n0 VSS VSS) g45n1svt w=(145n) l=45n nf=1 m=(1)
mp2 (p1 n0 p2 NW) g45p1svt w=(215n) l=45n nf=1 m=(1)
mp1 (Y n0 p1 NW) g45p1svt w=(215n) l=45n nf=1 m=(1)
mp3 (p2 n0 VDD NW) g45p1svt w=(215n) l=45n nf=1 m=(1)
mp0 (n0 Y VDD NW) g45p1svt w=(390n) l=45n nf=1 m=(1)
ends HOLDX1

// gsclib045_backbias/INVX1/schematic

simulator lang=spectre

subckt INVX1 A Y VSS NW VDD
mp0 (Y A VDD NW) g45p1svt w=(390n) l=45n nf=1 m=(1)
mn0 (Y A VSS VSS) g45n1svt w=(260n) l=45n nf=1 m=(1)
ends INVX1

// gsclib045_backbias/INVX12/schematic

simulator lang=spectre

subckt INVX12 A Y NW VDD VSS
mp0 (Y A VDD NW) g45p1svt w=(4.7u) l=45n nf=1 m=(1)
mn0 (Y A VSS VSS) g45n1svt w=(3.1u) l=45n nf=1 m=(1)
ends INVX12

// gsclib045_backbias/INVX16/schematic

simulator lang=spectre

subckt INVX16 A Y NW VSS VDD
mp0 (Y A VDD NW) g45p1svt w=(6.23u) l=45n nf=1 m=(1)
mn0 (Y A VSS VSS) g45n1svt w=(4.13u) l=45n nf=1 m=(1)
ends INVX16

// gsclib045_backbias/INVX2/schematic

simulator lang=spectre

subckt INVX2 A Y NW VSS VDD
mp0 (Y A VDD NW) g45p1svt w=(780n) l=45n nf=1 m=(1)
mn0 (Y A VSS VSS) g45n1svt w=(520n) l=45n nf=1 m=(1)
ends INVX2

// gsclib045_backbias/INVX20/schematic

simulator lang=spectre

subckt INVX20 A Y NW VSS VDD
mp0 (Y A VDD NW) g45p1svt w=(7.82u) l=45n nf=1 m=(1)
mn0 (Y A VSS VSS) g45n1svt w=(5.185u) l=45n nf=1 m=(1)
ends INVX20

// gsclib045_backbias/INVX3/schematic

simulator lang=spectre

subckt INVX3 A Y NW VSS VDD
mp0 (Y A VDD NW) g45p1svt w=(1.17u) l=45n nf=1 m=(1)
mn0 (Y A VSS VSS) g45n1svt w=(780n) l=45n nf=1 m=(1)
ends INVX3

// gsclib045_backbias/INVX4/schematic

simulator lang=spectre

subckt INVX4 A Y NW VSS VDD
mp0 (Y A VDD NW) g45p1svt w=(1.56u) l=45n nf=1 m=(1)
mn0 (Y A VSS VSS) g45n1svt w=(1.04u) l=45n nf=1 m=(1)
ends INVX4

// gsclib045_backbias/INVX6/schematic

simulator lang=spectre

subckt INVX6 A Y NW VSS VDD
mp0 (Y A VDD NW) g45p1svt w=(2.35u) l=45n nf=1 m=(1)
mn0 (Y A VSS VSS) g45n1svt w=(1.55u) l=45n nf=1 m=(1)
ends INVX6

// gsclib045_backbias/INVX8/schematic

simulator lang=spectre

subckt INVX8 A Y NW VDD VSS
mp0 (Y A VDD NW) g45p1svt w=(3.115u) l=45n nf=1 m=(1)
mn0 (Y A VSS VSS) g45n1svt w=(2.065u) l=45n nf=1 m=(1)
ends INVX8

// gsclib045_backbias/INVXL/schematic

simulator lang=spectre

subckt INVXL A Y NW VDD VSS
mp0 (Y A VDD NW) g45p1svt w=(215n) l=45n nf=1 m=(1)
mn0 (Y A VSS VSS) g45n1svt w=(145n) l=45n nf=1 m=(1)
ends INVXL

// gsclib045_backbias/BMXIX2/schematic

simulator lang=spectre

subckt BMXIX2 A M0 M1 PPN S X2 VSS VDD NW
mn10 (n1 M1 n9 VSS) g45n1svt w=(145n) l=45n nf=1 m=(1)
mn9 (n9 A VSS VSS) g45n1svt w=(145n) l=45n nf=1 m=(1)
mn8 (n1 M1b n7 VSS) g45n1svt w=(145n) l=45n nf=1 m=(1)
mn7 (n7 S VSS VSS) g45n1svt w=(145n) l=45n nf=1 m=(1)
mn3 (n3 S VSS VSS) g45n1svt w=(145n) l=45n nf=1 m=(1)
mn4 (n0 M0b n3 VSS) g45n1svt w=(145n) l=45n nf=1 m=(1)
mn11 (net293 X2 n0 VSS) g45n1svt w=(145n) l=45n nf=1 m=(1)
mn6 (n0 M0 n5 VSS) g45n1svt w=(145n) l=45n nf=1 m=(1)
mn13 (PPN net293 VSS VSS) g45n1svt w=(520n) l=45n nf=1 m=(1)
mn5 (n5 A VSS VSS) g45n1svt w=(145n) l=45n nf=1 m=(1)
mn12 (n1 X2b net293 VSS) g45n1svt w=(145n) l=45n nf=1 m=(1)
mn0 (M0b M0 VSS VSS) g45n1svt w=(145n) l=45n nf=1 m=(1)
mn1 (M1b M1 VSS VSS) g45n1svt w=(145n) l=45n nf=1 m=(1)
mn2 (X2b X2 VSS VSS) g45n1svt w=(145n) l=45n nf=1 m=(1)
mp8 (n1 M1 n8 NW) g45p1svt w=(215n) l=45n nf=1 m=(1)
mp7 (n8 S VDD NW) g45p1svt w=(215n) l=45n nf=1 m=(1)
mp3 (n4 S VDD NW) g45p1svt w=(215n) l=45n nf=1 m=(1)
mp4 (n0 M0 n4 NW) g45p1svt w=(215n) l=45n nf=1 m=(1)
mp9 (n10 A VDD NW) g45p1svt w=(215n) l=45n nf=1 m=(1)
mp10 (n1 M1b n10 NW) g45p1svt w=(215n) l=45n nf=1 m=(1)
mp2 (X2b X2 VDD NW) g45p1svt w=(215n) l=45n nf=1 m=(1)
mp6 (n0 M0b n6 NW) g45p1svt w=(215n) l=45n nf=1 m=(1)
mp0 (M0b M0 VDD NW) g45p1svt w=(215n) l=45n nf=1 m=(1)
mp1 (M1b M1 VDD NW) g45p1svt w=(215n) l=45n nf=1 m=(1)
mp13 (PPN net293 VDD NW) g45p1svt w=(780n) l=45n nf=1 m=(1)
mp12 (n1 X2 net293 NW) g45p1svt w=(215n) l=45n nf=1 m=(1)
mp11 (net293 X2b n0 NW) g45p1svt w=(215n) l=45n nf=1 m=(1)
mp5 (n6 A VDD NW) g45p1svt w=(215n) l=45n nf=1 m=(1)
ends BMXIX2

// gsclib045_backbias/BMXIX4/schematic

simulator lang=spectre

subckt BMXIX4 A M0 M1 PPN S X2 VSS NW VDD
mn10 (n1 M1 n9 VSS) g45n1svt w=(145n) l=45n nf=1 m=(1)
mn9 (n9 A VSS VSS) g45n1svt w=(145n) l=45n nf=1 m=(1)
mn8 (n1 M1b n7 VSS) g45n1svt w=(145n) l=45n nf=1 m=(1)
mn7 (n7 S VSS VSS) g45n1svt w=(145n) l=45n nf=1 m=(1)
mn3 (n3 S VSS VSS) g45n1svt w=(145n) l=45n nf=1 m=(1)
mn4 (n0 M0b n3 VSS) g45n1svt w=(145n) l=45n nf=1 m=(1)
mn11 (net293 X2 n0 VSS) g45n1svt w=(260n) l=45n nf=1 m=(1)
mn6 (n0 M0 n5 VSS) g45n1svt w=(145n) l=45n nf=1 m=(1)
mn13 (PPN net293 VSS VSS) g45n1svt w=(1.04u) l=45n nf=1 m=(1)
mn5 (n5 A VSS VSS) g45n1svt w=(145n) l=45n nf=1 m=(1)
mn12 (n1 X2b net293 VSS) g45n1svt w=(260n) l=45n nf=1 m=(1)
mn0 (M0b M0 VSS VSS) g45n1svt w=(145n) l=45n nf=1 m=(1)
mn1 (M1b M1 VSS VSS) g45n1svt w=(145n) l=45n nf=1 m=(1)
mn2 (X2b X2 VSS VSS) g45n1svt w=(145n) l=45n nf=1 m=(1)
mp8 (n1 M1 n8 NW) g45p1svt w=(215n) l=45n nf=1 m=(1)
mp7 (n8 S VDD NW) g45p1svt w=(215n) l=45n nf=1 m=(1)
mp3 (n4 S VDD NW) g45p1svt w=(215n) l=45n nf=1 m=(1)
mp4 (n0 M0 n4 NW) g45p1svt w=(215n) l=45n nf=1 m=(1)
mp9 (n10 A VDD NW) g45p1svt w=(215n) l=45n nf=1 m=(1)
mp10 (n1 M1b n10 NW) g45p1svt w=(215n) l=45n nf=1 m=(1)
mp2 (X2b X2 VDD NW) g45p1svt w=(215n) l=45n nf=1 m=(1)
mp6 (n0 M0b n6 NW) g45p1svt w=(215n) l=45n nf=1 m=(1)
mp0 (M0b M0 VDD NW) g45p1svt w=(215n) l=45n nf=1 m=(1)
mp1 (M1b M1 VDD NW) g45p1svt w=(215n) l=45n nf=1 m=(1)
mp13 (PPN net293 VDD NW) g45p1svt w=(1.56u) l=45n nf=1 m=(1)
mp12 (n1 X2 net293 NW) g45p1svt w=(390n) l=45n nf=1 m=(1)
mp11 (net293 X2b n0 NW) g45p1svt w=(390n) l=45n nf=1 m=(1)
mp5 (n6 A VDD NW) g45p1svt w=(215n) l=45n nf=1 m=(1)
ends BMXIX4

// gsclib045_backbias/MX2X1/schematic

simulator lang=spectre

subckt MX2X1 A B S0 Y NW VDD VSS
mn3 (n5 B VSS VSS) g45n1svt w=(145n) l=45n nf=1 m=(1)
mn4 (n0 S0 n5 VSS) g45n1svt w=(145n) l=45n nf=1 m=(1)
mn0 (S0b S0 VSS VSS) g45n1svt w=(145n) l=45n nf=1 m=(1)
mn1 (n3 A VSS VSS) g45n1svt w=(145n) l=45n nf=1 m=(1)
mn5 (Y n0 VSS VSS) g45n1svt w=(260n) l=45n nf=1 m=(1)
mn2 (n0 S0b n3 VSS) g45n1svt w=(145n) l=45n nf=1 m=(1)
mp4 (n0 S0b n6 NW) g45p1svt w=(215n) l=45n nf=1 m=(1)
mp3 (n6 B VDD NW) g45p1svt w=(215n) l=45n nf=1 m=(1)
mp5 (Y n0 VDD NW) g45p1svt w=(390n) l=45n nf=1 m=(1)
mp0 (S0b S0 VDD NW) g45p1svt w=(215n) l=45n nf=1 m=(1)
mp2 (n0 S0 n4 NW) g45p1svt w=(215n) l=45n nf=1 m=(1)
mp1 (n4 A VDD NW) g45p1svt w=(215n) l=45n nf=1 m=(1)
ends MX2X1

// gsclib045_backbias/MX2X2/schematic

simulator lang=spectre

subckt MX2X2 A B S0 Y VSS VDD NW
mn3 (n5 B VSS VSS) g45n1svt w=(145n) l=45n nf=1 m=(1)
mn4 (n0 S0 n5 VSS) g45n1svt w=(145n) l=45n nf=1 m=(1)
mn0 (S0b S0 VSS VSS) g45n1svt w=(145n) l=45n nf=1 m=(1)
mn1 (n3 A VSS VSS) g45n1svt w=(145n) l=45n nf=1 m=(1)
mn5 (Y n0 VSS VSS) g45n1svt w=(520n) l=45n nf=1 m=(1)
mn2 (n0 S0b n3 VSS) g45n1svt w=(145n) l=45n nf=1 m=(1)
mp4 (n0 S0b n6 NW) g45p1svt w=(215n) l=45n nf=1 m=(1)
mp3 (n6 B VDD NW) g45p1svt w=(215n) l=45n nf=1 m=(1)
mp5 (Y n0 VDD NW) g45p1svt w=(780n) l=45n nf=1 m=(1)
mp0 (S0b S0 VDD NW) g45p1svt w=(215n) l=45n nf=1 m=(1)
mp2 (n0 S0 n4 NW) g45p1svt w=(215n) l=45n nf=1 m=(1)
mp1 (n4 A VDD NW) g45p1svt w=(215n) l=45n nf=1 m=(1)
ends MX2X2

// gsclib045_backbias/MX2X4/schematic

simulator lang=spectre

subckt MX2X4 A B S0 Y VSS VDD NW
mn3 (n5 B VSS VSS) g45n1svt w=(205n) l=45n nf=1 m=(1)
mn4 (n0 S0 n5 VSS) g45n1svt w=(205n) l=45n nf=1 m=(1)
mn0 (S0b S0 VSS VSS) g45n1svt w=(145n) l=45n nf=1 m=(1)
mn1 (n3 A VSS VSS) g45n1svt w=(205n) l=45n nf=1 m=(1)
mn5 (Y n0 VSS VSS) g45n1svt w=(1.04u) l=45n nf=1 m=(1)
mn2 (n0 S0b n3 VSS) g45n1svt w=(205n) l=45n nf=1 m=(1)
mp4 (n0 S0b n6 NW) g45p1svt w=(310n) l=45n nf=1 m=(1)
mp3 (n6 B VDD NW) g45p1svt w=(310n) l=45n nf=1 m=(1)
mp5 (Y n0 VDD NW) g45p1svt w=(1.56u) l=45n nf=1 m=(1)
mp0 (S0b S0 VDD NW) g45p1svt w=(215n) l=45n nf=1 m=(1)
mp2 (n0 S0 n4 NW) g45p1svt w=(310n) l=45n nf=1 m=(1)
mp1 (n4 A VDD NW) g45p1svt w=(310n) l=45n nf=1 m=(1)
ends MX2X4

// gsclib045_backbias/MX2X6/schematic

simulator lang=spectre

subckt MX2X6 A B S0 Y VSS VDD NW
mn3 (n5 B VSS VSS) g45n1svt w=(205n) l=45n nf=1 m=(1)
mn4 (n0 S0 n5 VSS) g45n1svt w=(205n) l=45n nf=1 m=(1)
mn0 (S0b S0 VSS VSS) g45n1svt w=(145n) l=45n nf=1 m=(1)
mn1 (n3 A VSS VSS) g45n1svt w=(205n) l=45n nf=1 m=(1)
mn5 (Y n0 VSS VSS) g45n1svt w=(1.55u) l=45n nf=1 m=(1)
mn2 (n0 S0b n3 VSS) g45n1svt w=(205n) l=45n nf=1 m=(1)
mp4 (n0 S0b n6 NW) g45p1svt w=(310n) l=45n nf=1 m=(1)
mp3 (n6 B VDD NW) g45p1svt w=(310n) l=45n nf=1 m=(1)
mp5 (Y n0 VDD NW) g45p1svt w=(2.35u) l=45n nf=1 m=(1)
mp0 (S0b S0 VDD NW) g45p1svt w=(215n) l=45n nf=1 m=(1)
mp2 (n0 S0 n4 NW) g45p1svt w=(310n) l=45n nf=1 m=(1)
mp1 (n4 A VDD NW) g45p1svt w=(310n) l=45n nf=1 m=(1)
ends MX2X6

// gsclib045_backbias/MX2X8/schematic

simulator lang=spectre

subckt MX2X8 A B S0 Y VSS VDD NW
mn3 (n5 B VSS VSS) g45n1svt w=(205n) l=45n nf=1 m=(1)
mn4 (n0 S0 n5 VSS) g45n1svt w=(205n) l=45n nf=1 m=(1)
mn0 (S0b S0 VSS VSS) g45n1svt w=(145n) l=45n nf=1 m=(1)
mn1 (n3 A VSS VSS) g45n1svt w=(205n) l=45n nf=1 m=(1)
mn5 (Y n0 VSS VSS) g45n1svt w=(2.065u) l=45n nf=1 m=(1)
mn2 (n0 S0b n3 VSS) g45n1svt w=(205n) l=45n nf=1 m=(1)
mp4 (n0 S0b n6 NW) g45p1svt w=(310n) l=45n nf=1 m=(1)
mp3 (n6 B VDD NW) g45p1svt w=(310n) l=45n nf=1 m=(1)
mp5 (Y n0 VDD NW) g45p1svt w=(3.115u) l=45n nf=1 m=(1)
mp0 (S0b S0 VDD NW) g45p1svt w=(215n) l=45n nf=1 m=(1)
mp2 (n0 S0 n4 NW) g45p1svt w=(310n) l=45n nf=1 m=(1)
mp1 (n4 A VDD NW) g45p1svt w=(310n) l=45n nf=1 m=(1)
ends MX2X8

// gsclib045_backbias/MX2XL/schematic

simulator lang=spectre

subckt MX2XL A B S0 Y VSS VDD NW
mn3 (n5 B VSS VSS) g45n1svt w=(145n) l=45n nf=1 m=(1)
mn4 (n0 S0 n5 VSS) g45n1svt w=(145n) l=45n nf=1 m=(1)
mn0 (S0b S0 VSS VSS) g45n1svt w=(145n) l=45n nf=1 m=(1)
mn1 (n3 A VSS VSS) g45n1svt w=(145n) l=45n nf=1 m=(1)
mn5 (Y n0 VSS VSS) g45n1svt w=(145n) l=45n nf=1 m=(1)
mn2 (n0 S0b n3 VSS) g45n1svt w=(145n) l=45n nf=1 m=(1)
mp4 (n0 S0b n6 NW) g45p1svt w=(215n) l=45n nf=1 m=(1)
mp3 (n6 B VDD NW) g45p1svt w=(215n) l=45n nf=1 m=(1)
mp5 (Y n0 VDD NW) g45p1svt w=(215n) l=45n nf=1 m=(1)
mp0 (S0b S0 VDD NW) g45p1svt w=(215n) l=45n nf=1 m=(1)
mp2 (n0 S0 n4 NW) g45p1svt w=(215n) l=45n nf=1 m=(1)
mp1 (n4 A VDD NW) g45p1svt w=(215n) l=45n nf=1 m=(1)
ends MX2XL

// gsclib045_backbias/MX3X1/schematic

simulator lang=spectre

subckt MX3X1 A B C S0 S1 Y VDD NW VSS
mn7 (net245 C VSS VSS) g45n1svt w=(145n) l=45n nf=1 m=(1)
mn8 (n1 S1 net245 VSS) g45n1svt w=(145n) l=45n nf=1 m=(1)
mn4 (net234 B VSS VSS) g45n1svt w=(145n) l=45n nf=1 m=(1)
mn5 (n0 S0 net234 VSS) g45n1svt w=(145n) l=45n nf=1 m=(1)
mn3 (n0 S0b net229 VSS) g45n1svt w=(145n) l=45n nf=1 m=(1)
mn2 (net229 A VSS VSS) g45n1svt w=(145n) l=45n nf=1 m=(1)
mn9 (Y n1 VSS VSS) g45n1svt w=(260n) l=45n nf=1 m=(1)
mn0 (S0b S0 VSS VSS) g45n1svt w=(145n) l=45n nf=1 m=(1)
mn1 (S1b S1 VSS VSS) g45n1svt w=(145n) l=45n nf=1 m=(1)
mn6 (n1 S1b n0 VSS) g45n1svt w=(145n) l=45n nf=1 m=(1)
mp8 (n1 S1b net202 NW) g45p1svt w=(215n) l=45n nf=1 m=(1)
mp7 (net202 C VDD NW) g45p1svt w=(215n) l=45n nf=1 m=(1)
mp5 (n0 S0b net190 NW) g45p1svt w=(215n) l=45n nf=1 m=(1)
mp4 (net190 B VDD NW) g45p1svt w=(215n) l=45n nf=1 m=(1)
mp3 (n0 S0 net189 NW) g45p1svt w=(215n) l=45n nf=1 m=(1)
mp2 (net189 A VDD NW) g45p1svt w=(215n) l=45n nf=1 m=(1)
mp9 (Y n1 VDD NW) g45p1svt w=(390n) l=45n nf=1 m=(1)
mp1 (S1b S1 VDD NW) g45p1svt w=(215n) l=45n nf=1 m=(1)
mp6 (n0 S1 n1 NW) g45p1svt w=(215n) l=45n nf=1 m=(1)
mp0 (S0b S0 VDD NW) g45p1svt w=(215n) l=45n nf=1 m=(1)
ends MX3X1

// gsclib045_backbias/MX3X2/schematic

simulator lang=spectre

subckt MX3X2 A B C S0 S1 Y VDD NW VSS
mn7 (net245 C VSS VSS) g45n1svt w=(145n) l=45n nf=1 m=(1)
mn8 (n1 S1 net245 VSS) g45n1svt w=(145n) l=45n nf=1 m=(1)
mn4 (net234 B VSS VSS) g45n1svt w=(145n) l=45n nf=1 m=(1)
mn5 (n0 S0 net234 VSS) g45n1svt w=(145n) l=45n nf=1 m=(1)
mn3 (n0 S0b net229 VSS) g45n1svt w=(145n) l=45n nf=1 m=(1)
mn2 (net229 A VSS VSS) g45n1svt w=(145n) l=45n nf=1 m=(1)
mn9 (Y n1 VSS VSS) g45n1svt w=(520n) l=45n nf=1 m=(1)
mn0 (S0b S0 VSS VSS) g45n1svt w=(145n) l=45n nf=1 m=(1)
mn1 (S1b S1 VSS VSS) g45n1svt w=(145n) l=45n nf=1 m=(1)
mn6 (n1 S1b n0 VSS) g45n1svt w=(145n) l=45n nf=1 m=(1)
mp8 (n1 S1b net202 NW) g45p1svt w=(215n) l=45n nf=1 m=(1)
mp7 (net202 C VDD NW) g45p1svt w=(215n) l=45n nf=1 m=(1)
mp5 (n0 S0b net190 NW) g45p1svt w=(215n) l=45n nf=1 m=(1)
mp4 (net190 B VDD NW) g45p1svt w=(215n) l=45n nf=1 m=(1)
mp3 (n0 S0 net189 NW) g45p1svt w=(215n) l=45n nf=1 m=(1)
mp2 (net189 A VDD NW) g45p1svt w=(215n) l=45n nf=1 m=(1)
mp9 (Y n1 VDD NW) g45p1svt w=(780n) l=45n nf=1 m=(1)
mp1 (S1b S1 VDD NW) g45p1svt w=(215n) l=45n nf=1 m=(1)
mp6 (n0 S1 n1 NW) g45p1svt w=(215n) l=45n nf=1 m=(1)
mp0 (S0b S0 VDD NW) g45p1svt w=(215n) l=45n nf=1 m=(1)
ends MX3X2

// gsclib045_backbias/MX3X4/schematic

simulator lang=spectre

subckt MX3X4 A B C S0 S1 Y VDD NW VSS
mn7 (net245 C VSS VSS) g45n1svt w=(260n) l=45n nf=1 m=(1)
mn8 (n1 S1 net245 VSS) g45n1svt w=(260n) l=45n nf=1 m=(1)
mn4 (net234 B VSS VSS) g45n1svt w=(145n) l=45n nf=1 m=(1)
mn5 (n0 S0 net234 VSS) g45n1svt w=(145n) l=45n nf=1 m=(1)
mn3 (n0 S0b net229 VSS) g45n1svt w=(145n) l=45n nf=1 m=(1)
mn2 (net229 A VSS VSS) g45n1svt w=(145n) l=45n nf=1 m=(1)
mn9 (Y n1 VSS VSS) g45n1svt w=(1.04u) l=45n nf=1 m=(1)
mn0 (S0b S0 VSS VSS) g45n1svt w=(145n) l=45n nf=1 m=(1)
mn1 (S1b S1 VSS VSS) g45n1svt w=(145n) l=45n nf=1 m=(1)
mn6 (n1 S1b n0 VSS) g45n1svt w=(260n) l=45n nf=1 m=(1)
mp8 (n1 S1b net202 NW) g45p1svt w=(390n) l=45n nf=1 m=(1)
mp7 (net202 C VDD NW) g45p1svt w=(390n) l=45n nf=1 m=(1)
mp5 (n0 S0b net190 NW) g45p1svt w=(215n) l=45n nf=1 m=(1)
mp4 (net190 B VDD NW) g45p1svt w=(215n) l=45n nf=1 m=(1)
mp3 (n0 S0 net189 NW) g45p1svt w=(215n) l=45n nf=1 m=(1)
mp2 (net189 A VDD NW) g45p1svt w=(215n) l=45n nf=1 m=(1)
mp9 (Y n1 VDD NW) g45p1svt w=(1.56u) l=45n nf=1 m=(1)
mp1 (S1b S1 VDD NW) g45p1svt w=(215n) l=45n nf=1 m=(1)
mp6 (n0 S1 n1 NW) g45p1svt w=(390n) l=45n nf=1 m=(1)
mp0 (S0b S0 VDD NW) g45p1svt w=(215n) l=45n nf=1 m=(1)
ends MX3X4

// gsclib045_backbias/MX3XL/schematic

simulator lang=spectre

subckt MX3XL A B C S0 S1 Y VDD NW VSS
mn7 (net245 C VSS VSS) g45n1svt w=(145n) l=45n nf=1 m=(1)
mn8 (n1 S1 net245 VSS) g45n1svt w=(145n) l=45n nf=1 m=(1)
mn4 (net234 B VSS VSS) g45n1svt w=(145n) l=45n nf=1 m=(1)
mn5 (n0 S0 net234 VSS) g45n1svt w=(145n) l=45n nf=1 m=(1)
mn3 (n0 S0b net229 VSS) g45n1svt w=(145n) l=45n nf=1 m=(1)
mn2 (net229 A VSS VSS) g45n1svt w=(145n) l=45n nf=1 m=(1)
mn9 (Y n1 VSS VSS) g45n1svt w=(145n) l=45n nf=1 m=(1)
mn0 (S0b S0 VSS VSS) g45n1svt w=(145n) l=45n nf=1 m=(1)
mn1 (S1b S1 VSS VSS) g45n1svt w=(145n) l=45n nf=1 m=(1)
mn6 (n1 S1b n0 VSS) g45n1svt w=(145n) l=45n nf=1 m=(1)
mp8 (n1 S1b net202 NW) g45p1svt w=(215n) l=45n nf=1 m=(1)
mp7 (net202 C VDD NW) g45p1svt w=(215n) l=45n nf=1 m=(1)
mp5 (n0 S0b net190 NW) g45p1svt w=(215n) l=45n nf=1 m=(1)
mp4 (net190 B VDD NW) g45p1svt w=(215n) l=45n nf=1 m=(1)
mp3 (n0 S0 net189 NW) g45p1svt w=(215n) l=45n nf=1 m=(1)
mp2 (net189 A VDD NW) g45p1svt w=(215n) l=45n nf=1 m=(1)
mp9 (Y n1 VDD NW) g45p1svt w=(215n) l=45n nf=1 m=(1)
mp1 (S1b S1 VDD NW) g45p1svt w=(215n) l=45n nf=1 m=(1)
mp6 (n0 S1 n1 NW) g45p1svt w=(215n) l=45n nf=1 m=(1)
mp0 (S0b S0 VDD NW) g45p1svt w=(215n) l=45n nf=1 m=(1)
ends MX3XL

// gsclib045_backbias/MX4X1/schematic

simulator lang=spectre

subckt MX4X1 A B C D S0 S1 Y NW VDD VSS
mn9 (n1 S0 n9 VSS) g45n1svt w=(145n) l=45n nf=1 m=(1)
mn6 (n7 C VSS VSS) g45n1svt w=(145n) l=45n nf=1 m=(1)
mn7 (n1 S0b n7 VSS) g45n1svt w=(145n) l=45n nf=1 m=(1)
mn4 (n5 B VSS VSS) g45n1svt w=(145n) l=45n nf=1 m=(1)
mn5 (n0 S0 n5 VSS) g45n1svt w=(145n) l=45n nf=1 m=(1)
mn3 (n0 S0b n3 VSS) g45n1svt w=(145n) l=45n nf=1 m=(1)
mn2 (n3 A VSS VSS) g45n1svt w=(145n) l=45n nf=1 m=(1)
mn12 (Y n2 VSS VSS) g45n1svt w=(260n) l=45n nf=1 m=(1)
mn1 (S1b S1 VSS VSS) g45n1svt w=(145n) l=45n nf=1 m=(1)
mn11 (n2 S1 n1 VSS) g45n1svt w=(145n) l=45n nf=1 m=(1)
mn8 (n9 D VSS VSS) g45n1svt w=(145n) l=45n nf=1 m=(1)
mn10 (n2 S1b n0 VSS) g45n1svt w=(145n) l=45n nf=1 m=(1)
mn0 (S0b S0 VSS VSS) g45n1svt w=(145n) l=45n nf=1 m=(1)
mp9 (n1 S0b n10 NW) g45p1svt w=(215n) l=45n nf=1 m=(1)
mp8 (n10 D VDD NW) g45p1svt w=(215n) l=45n nf=1 m=(1)
mp7 (n1 S0 n8 NW) g45p1svt w=(215n) l=45n nf=1 m=(1)
mp6 (n8 C VDD NW) g45p1svt w=(215n) l=45n nf=1 m=(1)
mp5 (n0 S0b n6 NW) g45p1svt w=(215n) l=45n nf=1 m=(1)
mp4 (n6 B VDD NW) g45p1svt w=(215n) l=45n nf=1 m=(1)
mp3 (n0 S0 n4 NW) g45p1svt w=(215n) l=45n nf=1 m=(1)
mp2 (n4 A VDD NW) g45p1svt w=(215n) l=45n nf=1 m=(1)
mp12 (Y n2 VDD NW) g45p1svt w=(390n) l=45n nf=1 m=(1)
mp0 (S0b S0 VDD NW) g45p1svt w=(215n) l=45n nf=1 m=(1)
mp10 (n2 S1 n0 NW) g45p1svt w=(215n) l=45n nf=1 m=(1)
mp11 (n1 S1b n2 NW) g45p1svt w=(215n) l=45n nf=1 m=(1)
mp1 (S1b S1 VDD NW) g45p1svt w=(215n) l=45n nf=1 m=(1)
ends MX4X1

// gsclib045_backbias/MX4X2/schematic

simulator lang=spectre

subckt MX4X2 A B C D S0 S1 Y NW VSS VDD
mn9 (n1 S0 n9 VSS) g45n1svt w=(145n) l=45n nf=1 m=(1)
mn6 (n7 C VSS VSS) g45n1svt w=(145n) l=45n nf=1 m=(1)
mn7 (n1 S0b n7 VSS) g45n1svt w=(145n) l=45n nf=1 m=(1)
mn4 (n5 B VSS VSS) g45n1svt w=(145n) l=45n nf=1 m=(1)
mn5 (n0 S0 n5 VSS) g45n1svt w=(145n) l=45n nf=1 m=(1)
mn3 (n0 S0b n3 VSS) g45n1svt w=(145n) l=45n nf=1 m=(1)
mn2 (n3 A VSS VSS) g45n1svt w=(145n) l=45n nf=1 m=(1)
mn12 (Y n2 VSS VSS) g45n1svt w=(520n) l=45n nf=1 m=(1)
mn1 (S1b S1 VSS VSS) g45n1svt w=(145n) l=45n nf=1 m=(1)
mn11 (n2 S1 n1 VSS) g45n1svt w=(145n) l=45n nf=1 m=(1)
mn8 (n9 D VSS VSS) g45n1svt w=(145n) l=45n nf=1 m=(1)
mn10 (n2 S1b n0 VSS) g45n1svt w=(145n) l=45n nf=1 m=(1)
mn0 (S0b S0 VSS VSS) g45n1svt w=(145n) l=45n nf=1 m=(1)
mp9 (n1 S0b n10 NW) g45p1svt w=(215n) l=45n nf=1 m=(1)
mp8 (n10 D VDD NW) g45p1svt w=(215n) l=45n nf=1 m=(1)
mp7 (n1 S0 n8 NW) g45p1svt w=(215n) l=45n nf=1 m=(1)
mp6 (n8 C VDD NW) g45p1svt w=(215n) l=45n nf=1 m=(1)
mp5 (n0 S0b n6 NW) g45p1svt w=(215n) l=45n nf=1 m=(1)
mp4 (n6 B VDD NW) g45p1svt w=(215n) l=45n nf=1 m=(1)
mp3 (n0 S0 n4 NW) g45p1svt w=(215n) l=45n nf=1 m=(1)
mp2 (n4 A VDD NW) g45p1svt w=(215n) l=45n nf=1 m=(1)
mp12 (Y n2 VDD NW) g45p1svt w=(780n) l=45n nf=1 m=(1)
mp0 (S0b S0 VDD NW) g45p1svt w=(215n) l=45n nf=1 m=(1)
mp10 (n2 S1 n0 NW) g45p1svt w=(215n) l=45n nf=1 m=(1)
mp11 (n1 S1b n2 NW) g45p1svt w=(215n) l=45n nf=1 m=(1)
mp1 (S1b S1 VDD NW) g45p1svt w=(215n) l=45n nf=1 m=(1)
ends MX4X2

// gsclib045_backbias/MX4X4/schematic

simulator lang=spectre

subckt MX4X4 A B C D S0 S1 Y VSS NW VDD
mn9 (n1 S0 n9 VSS) g45n1svt w=(145n) l=45n nf=1 m=(1)
mn6 (n7 C VSS VSS) g45n1svt w=(145n) l=45n nf=1 m=(1)
mn7 (n1 S0b n7 VSS) g45n1svt w=(145n) l=45n nf=1 m=(1)
mn4 (n5 B VSS VSS) g45n1svt w=(145n) l=45n nf=1 m=(1)
mn5 (n0 S0 n5 VSS) g45n1svt w=(145n) l=45n nf=1 m=(1)
mn3 (n0 S0b n3 VSS) g45n1svt w=(145n) l=45n nf=1 m=(1)
mn2 (n3 A VSS VSS) g45n1svt w=(145n) l=45n nf=1 m=(1)
mn12 (Y n2 VSS VSS) g45n1svt w=(1.04u) l=45n nf=1 m=(1)
mn1 (S1b S1 VSS VSS) g45n1svt w=(145n) l=45n nf=1 m=(1)
mn11 (n2 S1 n1 VSS) g45n1svt w=(260n) l=45n nf=1 m=(1)
mn8 (n9 D VSS VSS) g45n1svt w=(145n) l=45n nf=1 m=(1)
mn10 (n2 S1b n0 VSS) g45n1svt w=(260n) l=45n nf=1 m=(1)
mn0 (S0b S0 VSS VSS) g45n1svt w=(145n) l=45n nf=1 m=(1)
mp9 (n1 S0b n10 NW) g45p1svt w=(215n) l=45n nf=1 m=(1)
mp8 (n10 D VDD NW) g45p1svt w=(215n) l=45n nf=1 m=(1)
mp7 (n1 S0 n8 NW) g45p1svt w=(215n) l=45n nf=1 m=(1)
mp6 (n8 C VDD NW) g45p1svt w=(215n) l=45n nf=1 m=(1)
mp5 (n0 S0b n6 NW) g45p1svt w=(215n) l=45n nf=1 m=(1)
mp4 (n6 B VDD NW) g45p1svt w=(215n) l=45n nf=1 m=(1)
mp3 (n0 S0 n4 NW) g45p1svt w=(215n) l=45n nf=1 m=(1)
mp2 (n4 A VDD NW) g45p1svt w=(215n) l=45n nf=1 m=(1)
mp12 (Y n2 VDD NW) g45p1svt w=(1.56u) l=45n nf=1 m=(1)
mp0 (S0b S0 VDD NW) g45p1svt w=(215n) l=45n nf=1 m=(1)
mp10 (n2 S1 n0 NW) g45p1svt w=(390n) l=45n nf=1 m=(1)
mp11 (n1 S1b n2 NW) g45p1svt w=(390n) l=45n nf=1 m=(1)
mp1 (S1b S1 VDD NW) g45p1svt w=(215n) l=45n nf=1 m=(1)
ends MX4X4

// gsclib045_backbias/MX4XL/schematic

simulator lang=spectre

subckt MX4XL A B C D S0 S1 Y VSS NW VDD
mn9 (n1 S0 n9 VSS) g45n1svt w=(145n) l=45n nf=1 m=(1)
mn6 (n7 C VSS VSS) g45n1svt w=(145n) l=45n nf=1 m=(1)
mn7 (n1 S0b n7 VSS) g45n1svt w=(145n) l=45n nf=1 m=(1)
mn4 (n5 B VSS VSS) g45n1svt w=(145n) l=45n nf=1 m=(1)
mn5 (n0 S0 n5 VSS) g45n1svt w=(145n) l=45n nf=1 m=(1)
mn3 (n0 S0b n3 VSS) g45n1svt w=(145n) l=45n nf=1 m=(1)
mn2 (n3 A VSS VSS) g45n1svt w=(145n) l=45n nf=1 m=(1)
mn12 (Y n2 VSS VSS) g45n1svt w=(145n) l=45n nf=1 m=(1)
mn1 (S1b S1 VSS VSS) g45n1svt w=(145n) l=45n nf=1 m=(1)
mn11 (n2 S1 n1 VSS) g45n1svt w=(145n) l=45n nf=1 m=(1)
mn8 (n9 D VSS VSS) g45n1svt w=(145n) l=45n nf=1 m=(1)
mn10 (n2 S1b n0 VSS) g45n1svt w=(145n) l=45n nf=1 m=(1)
mn0 (S0b S0 VSS VSS) g45n1svt w=(145n) l=45n nf=1 m=(1)
mp9 (n1 S0b n10 NW) g45p1svt w=(215n) l=45n nf=1 m=(1)
mp8 (n10 D VDD NW) g45p1svt w=(215n) l=45n nf=1 m=(1)
mp7 (n1 S0 n8 NW) g45p1svt w=(215n) l=45n nf=1 m=(1)
mp6 (n8 C VDD NW) g45p1svt w=(215n) l=45n nf=1 m=(1)
mp5 (n0 S0b n6 NW) g45p1svt w=(215n) l=45n nf=1 m=(1)
mp4 (n6 B VDD NW) g45p1svt w=(215n) l=45n nf=1 m=(1)
mp3 (n0 S0 n4 NW) g45p1svt w=(215n) l=45n nf=1 m=(1)
mp2 (n4 A VDD NW) g45p1svt w=(215n) l=45n nf=1 m=(1)
mp12 (Y n2 VDD NW) g45p1svt w=(215n) l=45n nf=1 m=(1)
mp0 (S0b S0 VDD NW) g45p1svt w=(215n) l=45n nf=1 m=(1)
mp10 (n2 S1 n0 NW) g45p1svt w=(215n) l=45n nf=1 m=(1)
mp11 (n1 S1b n2 NW) g45p1svt w=(215n) l=45n nf=1 m=(1)
mp1 (S1b S1 VDD NW) g45p1svt w=(215n) l=45n nf=1 m=(1)
ends MX4XL

// gsclib045_backbias/MXI2X1/schematic

simulator lang=spectre

subckt MXI2X1 A B S0 Y NW VSS VDD
mn3 (n5 B VSS VSS) g45n1svt w=(260n) l=45n nf=1 m=(1)
mn4 (Y S0 n5 VSS) g45n1svt w=(260n) l=45n nf=1 m=(1)
mn2 (Y S0b n3 VSS) g45n1svt w=(260n) l=45n nf=1 m=(1)
mn1 (n3 A VSS VSS) g45n1svt w=(260n) l=45n nf=1 m=(1)
mn0 (S0b S0 VSS VSS) g45n1svt w=(145n) l=45n nf=1 m=(1)
mp4 (Y S0b n6 NW) g45p1svt w=(390n) l=45n nf=1 m=(1)
mp3 (n6 B VDD NW) g45p1svt w=(390n) l=45n nf=1 m=(1)
mp2 (Y S0 n4 NW) g45p1svt w=(390n) l=45n nf=1 m=(1)
mp1 (n4 A VDD NW) g45p1svt w=(390n) l=45n nf=1 m=(1)
mp0 (S0b S0 VDD NW) g45p1svt w=(215n) l=45n nf=1 m=(1)
ends MXI2X1

// gsclib045_backbias/MXI2X2/schematic

simulator lang=spectre

subckt MXI2X2 A B S0 Y NW VDD VSS
mn3 (n5 B VSS VSS) g45n1svt w=(145n) l=45n nf=1 m=(1)
mn4 (n0 S0 n5 VSS) g45n1svt w=(145n) l=45n nf=1 m=(1)
mn2 (n0 S0b n3 VSS) g45n1svt w=(145n) l=45n nf=1 m=(1)
mn1 (n3 A VSS VSS) g45n1svt w=(145n) l=45n nf=1 m=(1)
mn5 (n1 n0 VSS VSS) g45n1svt w=(145n) l=45n nf=1 m=(1)
mn6 (Y n1 VSS VSS) g45n1svt w=(520n) l=45n nf=1 m=(1)
mn0 (S0b S0 VSS VSS) g45n1svt w=(145n) l=45n nf=1 m=(1)
mp4 (n0 S0b n6 NW) g45p1svt w=(215n) l=45n nf=1 m=(1)
mp3 (n6 B VDD NW) g45p1svt w=(215n) l=45n nf=1 m=(1)
mp2 (n0 S0 n4 NW) g45p1svt w=(215n) l=45n nf=1 m=(1)
mp1 (n4 A VDD NW) g45p1svt w=(215n) l=45n nf=1 m=(1)
mp6 (Y n1 VDD NW) g45p1svt w=(780n) l=45n nf=1 m=(1)
mp5 (n1 n0 VDD NW) g45p1svt w=(215n) l=45n nf=1 m=(1)
mp0 (S0b S0 VDD NW) g45p1svt w=(215n) l=45n nf=1 m=(1)
ends MXI2X2

// gsclib045_backbias/MXI2X4/schematic

simulator lang=spectre

subckt MXI2X4 A B S0 Y VSS VDD NW
mn3 (n5 B VSS VSS) g45n1svt w=(145n) l=45n nf=1 m=(1)
mn4 (n0 S0 n5 VSS) g45n1svt w=(145n) l=45n nf=1 m=(1)
mn2 (n0 S0b n3 VSS) g45n1svt w=(145n) l=45n nf=1 m=(1)
mn1 (n3 A VSS VSS) g45n1svt w=(145n) l=45n nf=1 m=(1)
mn5 (n1 n0 VSS VSS) g45n1svt w=(260n) l=45n nf=1 m=(1)
mn6 (Y n1 VSS VSS) g45n1svt w=(1.04u) l=45n nf=1 m=(1)
mn0 (S0b S0 VSS VSS) g45n1svt w=(145n) l=45n nf=1 m=(1)
mp4 (n0 S0b n6 NW) g45p1svt w=(215n) l=45n nf=1 m=(1)
mp3 (n6 B VDD NW) g45p1svt w=(215n) l=45n nf=1 m=(1)
mp2 (n0 S0 n4 NW) g45p1svt w=(215n) l=45n nf=1 m=(1)
mp1 (n4 A VDD NW) g45p1svt w=(215n) l=45n nf=1 m=(1)
mp6 (Y n1 VDD NW) g45p1svt w=(1.56u) l=45n nf=1 m=(1)
mp5 (n1 n0 VDD NW) g45p1svt w=(390n) l=45n nf=1 m=(1)
mp0 (S0b S0 VDD NW) g45p1svt w=(215n) l=45n nf=1 m=(1)
ends MXI2X4

// gsclib045_backbias/MXI2X6/schematic

simulator lang=spectre

subckt MXI2X6 A B S0 Y VSS VDD NW
mn3 (n5 B VSS VSS) g45n1svt w=(145n) l=45n nf=1 m=(1)
mn4 (n0 S0 n5 VSS) g45n1svt w=(145n) l=45n nf=1 m=(1)
mn2 (n0 S0b n3 VSS) g45n1svt w=(145n) l=45n nf=1 m=(1)
mn1 (n3 A VSS VSS) g45n1svt w=(145n) l=45n nf=1 m=(1)
mn5 (n1 n0 VSS VSS) g45n1svt w=(520n) l=45n nf=1 m=(1)
mn6 (Y n1 VSS VSS) g45n1svt w=(1.55u) l=45n nf=1 m=(1)
mn0 (S0b S0 VSS VSS) g45n1svt w=(145n) l=45n nf=1 m=(1)
mp4 (n0 S0b n6 NW) g45p1svt w=(215n) l=45n nf=1 m=(1)
mp3 (n6 B VDD NW) g45p1svt w=(215n) l=45n nf=1 m=(1)
mp2 (n0 S0 n4 NW) g45p1svt w=(215n) l=45n nf=1 m=(1)
mp1 (n4 A VDD NW) g45p1svt w=(215n) l=45n nf=1 m=(1)
mp6 (Y n1 VDD NW) g45p1svt w=(2.35u) l=45n nf=1 m=(1)
mp5 (n1 n0 VDD NW) g45p1svt w=(780n) l=45n nf=1 m=(1)
mp0 (S0b S0 VDD NW) g45p1svt w=(215n) l=45n nf=1 m=(1)
ends MXI2X6

// gsclib045_backbias/MXI2X8/schematic

simulator lang=spectre

subckt MXI2X8 A B S0 Y VSS VDD NW
mn3 (n5 B VSS VSS) g45n1svt w=(145n) l=45n nf=1 m=(1)
mn4 (n0 S0 n5 VSS) g45n1svt w=(145n) l=45n nf=1 m=(1)
mn2 (n0 S0b n3 VSS) g45n1svt w=(145n) l=45n nf=1 m=(1)
mn1 (n3 A VSS VSS) g45n1svt w=(145n) l=45n nf=1 m=(1)
mn5 (n1 n0 VSS VSS) g45n1svt w=(520n) l=45n nf=1 m=(1)
mn6 (Y n1 VSS VSS) g45n1svt w=(2.065u) l=45n nf=1 m=(1)
mn0 (S0b S0 VSS VSS) g45n1svt w=(145n) l=45n nf=1 m=(1)
mp4 (n0 S0b n6 NW) g45p1svt w=(215n) l=45n nf=1 m=(1)
mp3 (n6 B VDD NW) g45p1svt w=(215n) l=45n nf=1 m=(1)
mp2 (n0 S0 n4 NW) g45p1svt w=(215n) l=45n nf=1 m=(1)
mp1 (n4 A VDD NW) g45p1svt w=(215n) l=45n nf=1 m=(1)
mp6 (Y n1 VDD NW) g45p1svt w=(3.115u) l=45n nf=1 m=(1)
mp5 (n1 n0 VDD NW) g45p1svt w=(780n) l=45n nf=1 m=(1)
mp0 (S0b S0 VDD NW) g45p1svt w=(215n) l=45n nf=1 m=(1)
ends MXI2X8

// gsclib045_backbias/MXI2XL/schematic

simulator lang=spectre

subckt MXI2XL A B S0 Y VDD VSS NW
mn3 (n5 B VSS VSS) g45n1svt w=(145n) l=45n nf=1 m=(1)
mn4 (Y S0 n5 VSS) g45n1svt w=(145n) l=45n nf=1 m=(1)
mn2 (Y S0b n3 VSS) g45n1svt w=(145n) l=45n nf=1 m=(1)
mn1 (n3 A VSS VSS) g45n1svt w=(145n) l=45n nf=1 m=(1)
mn0 (S0b S0 VSS VSS) g45n1svt w=(145n) l=45n nf=1 m=(1)
mp4 (Y S0b n6 NW) g45p1svt w=(215n) l=45n nf=1 m=(1)
mp3 (n6 B VDD NW) g45p1svt w=(215n) l=45n nf=1 m=(1)
mp2 (Y S0 n4 NW) g45p1svt w=(215n) l=45n nf=1 m=(1)
mp1 (n4 A VDD NW) g45p1svt w=(215n) l=45n nf=1 m=(1)
mp0 (S0b S0 VDD NW) g45p1svt w=(215n) l=45n nf=1 m=(1)
ends MXI2XL

// gsclib045_backbias/MXI3X1/schematic

simulator lang=spectre

subckt MXI3X1 A B C S0 S1 Y VDD VSS NW
mn4 (n4 B VSS VSS) g45n1svt w=(145n) l=45n nf=1 m=(1)
mn5 (n0 S0 n4 VSS) g45n1svt w=(145n) l=45n nf=1 m=(1)
mn3 (n0 S0b n2 VSS) g45n1svt w=(145n) l=45n nf=1 m=(1)
mn2 (n2 A VSS VSS) g45n1svt w=(145n) l=45n nf=1 m=(1)
mn11 (Y n1 VSS VSS) g45n1svt w=(260n) l=45n nf=1 m=(1)
mn10 (n1 S1 n8 VSS) g45n1svt w=(145n) l=45n nf=1 m=(1)
mn9 (n8 Cp VSS VSS) g45n1svt w=(145n) l=45n nf=1 m=(1)
mn8 (n1 S1b n6 VSS) g45n1svt w=(145n) l=45n nf=1 m=(1)
mn7 (n6 n0 VSS VSS) g45n1svt w=(145n) l=45n nf=1 m=(1)
mn6 (Cp C VSS VSS) g45n1svt w=(145n) l=45n nf=1 m=(1)
mn0 (S0b S0 VSS VSS) g45n1svt w=(145n) l=45n nf=1 m=(1)
mn1 (S1b S1 VSS VSS) g45n1svt w=(145n) l=45n nf=1 m=(1)
mp5 (n0 S0b n5 NW) g45p1svt w=(215n) l=45n nf=1 m=(1)
mp4 (n5 B VDD NW) g45p1svt w=(215n) l=45n nf=1 m=(1)
mp3 (n0 S0 n3 NW) g45p1svt w=(215n) l=45n nf=1 m=(1)
mp2 (n3 A VDD NW) g45p1svt w=(215n) l=45n nf=1 m=(1)
mp8 (n1 S1 n7 NW) g45p1svt w=(215n) l=45n nf=1 m=(1)
mp7 (n7 n0 VDD NW) g45p1svt w=(215n) l=45n nf=1 m=(1)
mp11 (Y n1 VDD NW) g45p1svt w=(390n) l=45n nf=1 m=(1)
mp9 (n9 Cp VDD NW) g45p1svt w=(215n) l=45n nf=1 m=(1)
mp10 (n1 S1b n9 NW) g45p1svt w=(215n) l=45n nf=1 m=(1)
mp6 (Cp C VDD NW) g45p1svt w=(215n) l=45n nf=1 m=(1)
mp1 (S1b S1 VDD NW) g45p1svt w=(215n) l=45n nf=1 m=(1)
mp0 (S0b S0 VDD NW) g45p1svt w=(215n) l=45n nf=1 m=(1)
ends MXI3X1

// gsclib045_backbias/MXI3X2/schematic

simulator lang=spectre

subckt MXI3X2 A B C S0 S1 Y NW VDD VSS
mn4 (n4 B VSS VSS) g45n1svt w=(145n) l=45n nf=1 m=(1)
mn5 (n0 S0 n4 VSS) g45n1svt w=(145n) l=45n nf=1 m=(1)
mn3 (n0 S0b n2 VSS) g45n1svt w=(145n) l=45n nf=1 m=(1)
mn2 (n2 A VSS VSS) g45n1svt w=(145n) l=45n nf=1 m=(1)
mn11 (Y n1 VSS VSS) g45n1svt w=(520n) l=45n nf=1 m=(1)
mn10 (n1 S1 n8 VSS) g45n1svt w=(145n) l=45n nf=1 m=(1)
mn9 (n8 Cp VSS VSS) g45n1svt w=(145n) l=45n nf=1 m=(1)
mn8 (n1 S1b n6 VSS) g45n1svt w=(145n) l=45n nf=1 m=(1)
mn7 (n6 n0 VSS VSS) g45n1svt w=(145n) l=45n nf=1 m=(1)
mn6 (Cp C VSS VSS) g45n1svt w=(145n) l=45n nf=1 m=(1)
mn0 (S0b S0 VSS VSS) g45n1svt w=(145n) l=45n nf=1 m=(1)
mn1 (S1b S1 VSS VSS) g45n1svt w=(145n) l=45n nf=1 m=(1)
mp5 (n0 S0b n5 NW) g45p1svt w=(215n) l=45n nf=1 m=(1)
mp4 (n5 B VDD NW) g45p1svt w=(215n) l=45n nf=1 m=(1)
mp3 (n0 S0 n3 NW) g45p1svt w=(215n) l=45n nf=1 m=(1)
mp2 (n3 A VDD NW) g45p1svt w=(215n) l=45n nf=1 m=(1)
mp8 (n1 S1 n7 NW) g45p1svt w=(215n) l=45n nf=1 m=(1)
mp7 (n7 n0 VDD NW) g45p1svt w=(215n) l=45n nf=1 m=(1)
mp11 (Y n1 VDD NW) g45p1svt w=(780n) l=45n nf=1 m=(1)
mp9 (n9 Cp VDD NW) g45p1svt w=(215n) l=45n nf=1 m=(1)
mp10 (n1 S1b n9 NW) g45p1svt w=(215n) l=45n nf=1 m=(1)
mp6 (Cp C VDD NW) g45p1svt w=(215n) l=45n nf=1 m=(1)
mp1 (S1b S1 VDD NW) g45p1svt w=(215n) l=45n nf=1 m=(1)
mp0 (S0b S0 VDD NW) g45p1svt w=(215n) l=45n nf=1 m=(1)
ends MXI3X2

// gsclib045_backbias/MXI3X4/schematic

simulator lang=spectre

subckt MXI3X4 A B C S0 S1 Y NW VDD VSS
mn4 (n4 B VSS VSS) g45n1svt w=(145n) l=45n nf=1 m=(1)
mn5 (n0 S0 n4 VSS) g45n1svt w=(145n) l=45n nf=1 m=(1)
mn3 (n0 S0b n2 VSS) g45n1svt w=(145n) l=45n nf=1 m=(1)
mn2 (n2 A VSS VSS) g45n1svt w=(145n) l=45n nf=1 m=(1)
mn11 (Y n1 VSS VSS) g45n1svt w=(1.04u) l=45n nf=1 m=(1)
mn10 (n1 S1 n8 VSS) g45n1svt w=(205n) l=45n nf=1 m=(1)
mn9 (n8 Cp VSS VSS) g45n1svt w=(205n) l=45n nf=1 m=(1)
mn8 (n1 S1b n6 VSS) g45n1svt w=(205n) l=45n nf=1 m=(1)
mn7 (n6 n0 VSS VSS) g45n1svt w=(205n) l=45n nf=1 m=(1)
mn6 (Cp C VSS VSS) g45n1svt w=(145n) l=45n nf=1 m=(1)
mn0 (S0b S0 VSS VSS) g45n1svt w=(145n) l=45n nf=1 m=(1)
mn1 (S1b S1 VSS VSS) g45n1svt w=(145n) l=45n nf=1 m=(1)
mp5 (n0 S0b n5 NW) g45p1svt w=(215n) l=45n nf=1 m=(1)
mp4 (n5 B VDD NW) g45p1svt w=(215n) l=45n nf=1 m=(1)
mp3 (n0 S0 n3 NW) g45p1svt w=(215n) l=45n nf=1 m=(1)
mp2 (n3 A VDD NW) g45p1svt w=(215n) l=45n nf=1 m=(1)
mp8 (n1 S1 n7 NW) g45p1svt w=(310n) l=45n nf=1 m=(1)
mp7 (n7 n0 VDD NW) g45p1svt w=(310n) l=45n nf=1 m=(1)
mp11 (Y n1 VDD NW) g45p1svt w=(1.56u) l=45n nf=1 m=(1)
mp9 (n9 Cp VDD NW) g45p1svt w=(310n) l=45n nf=1 m=(1)
mp10 (n1 S1b n9 NW) g45p1svt w=(310n) l=45n nf=1 m=(1)
mp6 (Cp C VDD NW) g45p1svt w=(215n) l=45n nf=1 m=(1)
mp1 (S1b S1 VDD NW) g45p1svt w=(215n) l=45n nf=1 m=(1)
mp0 (S0b S0 VDD NW) g45p1svt w=(215n) l=45n nf=1 m=(1)
ends MXI3X4

// gsclib045_backbias/MXI3XL/schematic

simulator lang=spectre

subckt MXI3XL A B C S0 S1 Y NW VDD VSS
mn4 (n4 B VSS VSS) g45n1svt w=(145n) l=45n nf=1 m=(1)
mn5 (n0 S0 n4 VSS) g45n1svt w=(145n) l=45n nf=1 m=(1)
mn3 (n0 S0b n2 VSS) g45n1svt w=(145n) l=45n nf=1 m=(1)
mn2 (n2 A VSS VSS) g45n1svt w=(145n) l=45n nf=1 m=(1)
mn11 (Y n1 VSS VSS) g45n1svt w=(145n) l=45n nf=1 m=(1)
mn10 (n1 S1 n8 VSS) g45n1svt w=(145n) l=45n nf=1 m=(1)
mn9 (n8 Cp VSS VSS) g45n1svt w=(145n) l=45n nf=1 m=(1)
mn8 (n1 S1b n6 VSS) g45n1svt w=(145n) l=45n nf=1 m=(1)
mn7 (n6 n0 VSS VSS) g45n1svt w=(145n) l=45n nf=1 m=(1)
mn6 (Cp C VSS VSS) g45n1svt w=(145n) l=45n nf=1 m=(1)
mn0 (S0b S0 VSS VSS) g45n1svt w=(145n) l=45n nf=1 m=(1)
mn1 (S1b S1 VSS VSS) g45n1svt w=(145n) l=45n nf=1 m=(1)
mp5 (n0 S0b n5 NW) g45p1svt w=(215n) l=45n nf=1 m=(1)
mp4 (n5 B VDD NW) g45p1svt w=(215n) l=45n nf=1 m=(1)
mp3 (n0 S0 n3 NW) g45p1svt w=(215n) l=45n nf=1 m=(1)
mp2 (n3 A VDD NW) g45p1svt w=(215n) l=45n nf=1 m=(1)
mp8 (n1 S1 n7 NW) g45p1svt w=(215n) l=45n nf=1 m=(1)
mp7 (n7 n0 VDD NW) g45p1svt w=(215n) l=45n nf=1 m=(1)
mp11 (Y n1 VDD NW) g45p1svt w=(215n) l=45n nf=1 m=(1)
mp9 (n9 Cp VDD NW) g45p1svt w=(215n) l=45n nf=1 m=(1)
mp10 (n1 S1b n9 NW) g45p1svt w=(215n) l=45n nf=1 m=(1)
mp6 (Cp C VDD NW) g45p1svt w=(215n) l=45n nf=1 m=(1)
mp1 (S1b S1 VDD NW) g45p1svt w=(215n) l=45n nf=1 m=(1)
mp0 (S0b S0 VDD NW) g45p1svt w=(215n) l=45n nf=1 m=(1)
ends MXI3XL

// gsclib045_backbias/MXI4X1/schematic

simulator lang=spectre

subckt MXI4X1 A B C D S0 S1 Y VDD NW VSS
mn8 (net377 D VSS VSS) g45n1svt w=(145n) l=45n nf=1 m=(1)
mn9 (n1 S0 net377 VSS) g45n1svt w=(145n) l=45n nf=1 m=(1)
mn6 (net369 C VSS VSS) g45n1svt w=(145n) l=45n nf=1 m=(1)
mn7 (n1 S0b net369 VSS) g45n1svt w=(145n) l=45n nf=1 m=(1)
mn4 (net361 B VSS VSS) g45n1svt w=(145n) l=45n nf=1 m=(1)
mn5 (n0 S0 net361 VSS) g45n1svt w=(145n) l=45n nf=1 m=(1)
mn3 (n0 S0b net349 VSS) g45n1svt w=(145n) l=45n nf=1 m=(1)
mn2 (net349 A VSS VSS) g45n1svt w=(145n) l=45n nf=1 m=(1)
mn12 (net345 n1 VSS VSS) g45n1svt w=(145n) l=45n nf=1 m=(1)
mn13 (n2 S1 net345 VSS) g45n1svt w=(145n) l=45n nf=1 m=(1)
mn11 (n2 S1b net329 VSS) g45n1svt w=(145n) l=45n nf=1 m=(1)
mn1 (S1b S1 VSS VSS) g45n1svt w=(145n) l=45n nf=1 m=(1)
mn10 (net329 n0 VSS VSS) g45n1svt w=(145n) l=45n nf=1 m=(1)
mn14 (Y n2 VSS VSS) g45n1svt w=(260n) l=45n nf=1 m=(1)
mn0 (S0b S0 VSS VSS) g45n1svt w=(145n) l=45n nf=1 m=(1)
mp9 (n1 S0b net320 NW) g45p1svt w=(215n) l=45n nf=1 m=(1)
mp8 (net320 D VDD NW) g45p1svt w=(215n) l=45n nf=1 m=(1)
mp7 (n1 S0 net312 NW) g45p1svt w=(215n) l=45n nf=1 m=(1)
mp6 (net312 C VDD NW) g45p1svt w=(215n) l=45n nf=1 m=(1)
mp5 (n0 S0b net304 NW) g45p1svt w=(215n) l=45n nf=1 m=(1)
mp4 (net304 B VDD NW) g45p1svt w=(215n) l=45n nf=1 m=(1)
mp3 (n0 S0 net296 NW) g45p1svt w=(215n) l=45n nf=1 m=(1)
mp2 (net296 A VDD NW) g45p1svt w=(215n) l=45n nf=1 m=(1)
mp12 (net284 n1 VDD NW) g45p1svt w=(215n) l=45n nf=1 m=(1)
mp13 (n2 S1b net284 NW) g45p1svt w=(215n) l=45n nf=1 m=(1)
mp11 (n2 S1 net280 NW) g45p1svt w=(215n) l=45n nf=1 m=(1)
mp10 (net280 n0 VDD NW) g45p1svt w=(215n) l=45n nf=1 m=(1)
mp0 (S0b S0 VDD NW) g45p1svt w=(215n) l=45n nf=1 m=(1)
mp14 (Y n2 VDD NW) g45p1svt w=(390n) l=45n nf=1 m=(1)
mp1 (S1b S1 VDD NW) g45p1svt w=(215n) l=45n nf=1 m=(1)
ends MXI4X1

// gsclib045_backbias/MXI4X2/schematic

simulator lang=spectre

subckt MXI4X2 A B C D S0 S1 Y VDD VSS NW
mn8 (net377 D VSS VSS) g45n1svt w=(145n) l=45n nf=1 m=(1)
mn9 (n1 S0 net377 VSS) g45n1svt w=(145n) l=45n nf=1 m=(1)
mn6 (net369 C VSS VSS) g45n1svt w=(145n) l=45n nf=1 m=(1)
mn7 (n1 S0b net369 VSS) g45n1svt w=(145n) l=45n nf=1 m=(1)
mn4 (net361 B VSS VSS) g45n1svt w=(145n) l=45n nf=1 m=(1)
mn5 (n0 S0 net361 VSS) g45n1svt w=(145n) l=45n nf=1 m=(1)
mn3 (n0 S0b net349 VSS) g45n1svt w=(145n) l=45n nf=1 m=(1)
mn2 (net349 A VSS VSS) g45n1svt w=(145n) l=45n nf=1 m=(1)
mn12 (net345 n1 VSS VSS) g45n1svt w=(145n) l=45n nf=1 m=(1)
mn13 (n2 S1 net345 VSS) g45n1svt w=(145n) l=45n nf=1 m=(1)
mn11 (n2 S1b net329 VSS) g45n1svt w=(145n) l=45n nf=1 m=(1)
mn1 (S1b S1 VSS VSS) g45n1svt w=(145n) l=45n nf=1 m=(1)
mn10 (net329 n0 VSS VSS) g45n1svt w=(145n) l=45n nf=1 m=(1)
mn14 (Y n2 VSS VSS) g45n1svt w=(520n) l=45n nf=1 m=(1)
mn0 (S0b S0 VSS VSS) g45n1svt w=(145n) l=45n nf=1 m=(1)
mp9 (n1 S0b net320 NW) g45p1svt w=(215n) l=45n nf=1 m=(1)
mp8 (net320 D VDD NW) g45p1svt w=(215n) l=45n nf=1 m=(1)
mp7 (n1 S0 net312 NW) g45p1svt w=(215n) l=45n nf=1 m=(1)
mp6 (net312 C VDD NW) g45p1svt w=(215n) l=45n nf=1 m=(1)
mp5 (n0 S0b net304 NW) g45p1svt w=(215n) l=45n nf=1 m=(1)
mp4 (net304 B VDD NW) g45p1svt w=(215n) l=45n nf=1 m=(1)
mp3 (n0 S0 net296 NW) g45p1svt w=(215n) l=45n nf=1 m=(1)
mp2 (net296 A VDD NW) g45p1svt w=(215n) l=45n nf=1 m=(1)
mp12 (net284 n1 VDD NW) g45p1svt w=(215n) l=45n nf=1 m=(1)
mp13 (n2 S1b net284 NW) g45p1svt w=(215n) l=45n nf=1 m=(1)
mp11 (n2 S1 net280 NW) g45p1svt w=(215n) l=45n nf=1 m=(1)
mp10 (net280 n0 VDD NW) g45p1svt w=(215n) l=45n nf=1 m=(1)
mp0 (S0b S0 VDD NW) g45p1svt w=(215n) l=45n nf=1 m=(1)
mp14 (Y n2 VDD NW) g45p1svt w=(780n) l=45n nf=1 m=(1)
mp1 (S1b S1 VDD NW) g45p1svt w=(215n) l=45n nf=1 m=(1)
ends MXI4X2

// gsclib045_backbias/MXI4X4/schematic

simulator lang=spectre

subckt MXI4X4 A B C D S0 S1 Y VDD VSS NW
mn8 (net377 D VSS VSS) g45n1svt w=(145n) l=45n nf=1 m=(1)
mn9 (n1 S0 net377 VSS) g45n1svt w=(145n) l=45n nf=1 m=(1)
mn6 (net369 C VSS VSS) g45n1svt w=(145n) l=45n nf=1 m=(1)
mn7 (n1 S0b net369 VSS) g45n1svt w=(145n) l=45n nf=1 m=(1)
mn4 (net361 B VSS VSS) g45n1svt w=(145n) l=45n nf=1 m=(1)
mn5 (n0 S0 net361 VSS) g45n1svt w=(145n) l=45n nf=1 m=(1)
mn3 (n0 S0b net349 VSS) g45n1svt w=(145n) l=45n nf=1 m=(1)
mn2 (net349 A VSS VSS) g45n1svt w=(145n) l=45n nf=1 m=(1)
mn12 (net345 n1 VSS VSS) g45n1svt w=(205n) l=45n nf=1 m=(1)
mn13 (n2 S1 net345 VSS) g45n1svt w=(205n) l=45n nf=1 m=(1)
mn11 (n2 S1b net329 VSS) g45n1svt w=(205n) l=45n nf=1 m=(1)
mn1 (S1b S1 VSS VSS) g45n1svt w=(145n) l=45n nf=1 m=(1)
mn10 (net329 n0 VSS VSS) g45n1svt w=(205n) l=45n nf=1 m=(1)
mn14 (Y n2 VSS VSS) g45n1svt w=(1.04u) l=45n nf=1 m=(1)
mn0 (S0b S0 VSS VSS) g45n1svt w=(145n) l=45n nf=1 m=(1)
mp9 (n1 S0b net320 NW) g45p1svt w=(215n) l=45n nf=1 m=(1)
mp8 (net320 D VDD NW) g45p1svt w=(215n) l=45n nf=1 m=(1)
mp7 (n1 S0 net312 NW) g45p1svt w=(215n) l=45n nf=1 m=(1)
mp6 (net312 C VDD NW) g45p1svt w=(215n) l=45n nf=1 m=(1)
mp5 (n0 S0b net304 NW) g45p1svt w=(215n) l=45n nf=1 m=(1)
mp4 (net304 B VDD NW) g45p1svt w=(215n) l=45n nf=1 m=(1)
mp3 (n0 S0 net296 NW) g45p1svt w=(215n) l=45n nf=1 m=(1)
mp2 (net296 A VDD NW) g45p1svt w=(215n) l=45n nf=1 m=(1)
mp12 (net284 n1 VDD NW) g45p1svt w=(310n) l=45n nf=1 m=(1)
mp13 (n2 S1b net284 NW) g45p1svt w=(310n) l=45n nf=1 m=(1)
mp11 (n2 S1 net280 NW) g45p1svt w=(310n) l=45n nf=1 m=(1)
mp10 (net280 n0 VDD NW) g45p1svt w=(310n) l=45n nf=1 m=(1)
mp0 (S0b S0 VDD NW) g45p1svt w=(215n) l=45n nf=1 m=(1)
mp14 (Y n2 VDD NW) g45p1svt w=(1.56u) l=45n nf=1 m=(1)
mp1 (S1b S1 VDD NW) g45p1svt w=(215n) l=45n nf=1 m=(1)
ends MXI4X4

// gsclib045_backbias/MXI4XL/schematic

simulator lang=spectre

subckt MXI4XL A B C D S0 S1 Y VDD VSS NW
mn8 (net377 D VSS VSS) g45n1svt w=(145n) l=45n nf=1 m=(1)
mn9 (n1 S0 net377 VSS) g45n1svt w=(145n) l=45n nf=1 m=(1)
mn6 (net369 C VSS VSS) g45n1svt w=(145n) l=45n nf=1 m=(1)
mn7 (n1 S0b net369 VSS) g45n1svt w=(145n) l=45n nf=1 m=(1)
mn4 (net361 B VSS VSS) g45n1svt w=(145n) l=45n nf=1 m=(1)
mn5 (n0 S0 net361 VSS) g45n1svt w=(145n) l=45n nf=1 m=(1)
mn3 (n0 S0b net349 VSS) g45n1svt w=(145n) l=45n nf=1 m=(1)
mn2 (net349 A VSS VSS) g45n1svt w=(145n) l=45n nf=1 m=(1)
mn12 (net345 n1 VSS VSS) g45n1svt w=(145n) l=45n nf=1 m=(1)
mn13 (n2 S1 net345 VSS) g45n1svt w=(145n) l=45n nf=1 m=(1)
mn11 (n2 S1b net329 VSS) g45n1svt w=(145n) l=45n nf=1 m=(1)
mn1 (S1b S1 VSS VSS) g45n1svt w=(145n) l=45n nf=1 m=(1)
mn10 (net329 n0 VSS VSS) g45n1svt w=(145n) l=45n nf=1 m=(1)
mn14 (Y n2 VSS VSS) g45n1svt w=(145n) l=45n nf=1 m=(1)
mn0 (S0b S0 VSS VSS) g45n1svt w=(145n) l=45n nf=1 m=(1)
mp9 (n1 S0b net320 NW) g45p1svt w=(215n) l=45n nf=1 m=(1)
mp8 (net320 D VDD NW) g45p1svt w=(215n) l=45n nf=1 m=(1)
mp7 (n1 S0 net312 NW) g45p1svt w=(215n) l=45n nf=1 m=(1)
mp6 (net312 C VDD NW) g45p1svt w=(215n) l=45n nf=1 m=(1)
mp5 (n0 S0b net304 NW) g45p1svt w=(215n) l=45n nf=1 m=(1)
mp4 (net304 B VDD NW) g45p1svt w=(215n) l=45n nf=1 m=(1)
mp3 (n0 S0 net296 NW) g45p1svt w=(215n) l=45n nf=1 m=(1)
mp2 (net296 A VDD NW) g45p1svt w=(215n) l=45n nf=1 m=(1)
mp12 (net284 n1 VDD NW) g45p1svt w=(215n) l=45n nf=1 m=(1)
mp13 (n2 S1b net284 NW) g45p1svt w=(215n) l=45n nf=1 m=(1)
mp11 (n2 S1 net280 NW) g45p1svt w=(215n) l=45n nf=1 m=(1)
mp10 (net280 n0 VDD NW) g45p1svt w=(215n) l=45n nf=1 m=(1)
mp0 (S0b S0 VDD NW) g45p1svt w=(215n) l=45n nf=1 m=(1)
mp14 (Y n2 VDD NW) g45p1svt w=(215n) l=45n nf=1 m=(1)
mp1 (S1b S1 VDD NW) g45p1svt w=(215n) l=45n nf=1 m=(1)
ends MXI4XL

// gsclib045_backbias/ACHCONX2/schematic

simulator lang=spectre

subckt ACHCONX2 A B CI CON NW VSS VDD
mn6 (n15 A VSS VSS) g45n1svt w=(390n) l=45n nf=1 m=(1)
mn10 (net0370 CI VSS VSS) g45n1svt w=(390n) l=45n nf=1 m=(1)
mn11 (n13 B VSS VSS) g45n1svt w=(390n) l=45n nf=1 m=(1)
mn7 (n12 B VSS VSS) g45n1svt w=(390n) l=45n nf=1 m=(1)
mn8 (net0370 n10 CON VSS) g45n1svt w=(390n) l=45n nf=1 m=(1)
mn3 (n9 n13 n15 VSS) g45n1svt w=(390n) l=45n nf=1 m=(1)
mn1 (n10 n13 n11 VSS) g45n1svt w=(310n) l=45n nf=1 m=(1)
mn4 (n11 B n9 VSS) g45n1svt w=(310n) l=45n nf=1 m=(1)
mn5 (n11 n15 VSS VSS) g45n1svt w=(310n) l=45n nf=1 m=(1)
mn2 (n15 B n10 VSS) g45n1svt w=(390n) l=45n nf=1 m=(1)
mn9 (n12 n9 CON VSS) g45n1svt w=(390n) l=45n nf=1 m=(1)
mp6 (n15 A VDD NW) g45p1svt w=(770n) l=45n nf=1 m=(1)
mp10 (net0370 CI VDD NW) g45p1svt w=(770n) l=45n nf=1 m=(1)
mp8 (net0370 n9 CON NW) g45p1svt w=(770n) l=45n nf=1 m=(1)
mp7 (n12 B VDD NW) g45p1svt w=(770n) l=45n nf=1 m=(1)
mp5 (n11 n15 VDD NW) g45p1svt w=(520n) l=45n nf=1 m=(1)
mp1 (n10 B n11 NW) g45p1svt w=(520n) l=45n nf=1 m=(1)
mp2 (n15 n13 n10 NW) g45p1svt w=(770n) l=45n nf=1 m=(1)
mp11 (n13 B VDD NW) g45p1svt w=(770n) l=45n nf=1 m=(1)
mp4 (n11 n13 n9 NW) g45p1svt w=(520n) l=45n nf=1 m=(1)
mp3 (n9 B n15 NW) g45p1svt w=(770n) l=45n nf=1 m=(1)
mp9 (n12 n10 CON NW) g45p1svt w=(770n) l=45n nf=1 m=(1)
ends ACHCONX2

// gsclib045_backbias/NAND2BX1/schematic

simulator lang=spectre

subckt NAND2BX1 AN B Y NW VSS VDD
mn2 (Y B n1 VSS) g45n1svt w=(260n) l=45n nf=1 m=(1)
mn0 (n0 AN VSS VSS) g45n1svt w=(145n) l=45n nf=1 m=(1)
mn1 (n1 n0 VSS VSS) g45n1svt w=(260n) l=45n nf=1 m=(1)
mp1 (Y n0 VDD NW) g45p1svt w=(390n) l=45n nf=1 m=(1)
mp2 (Y B VDD NW) g45p1svt w=(390n) l=45n nf=1 m=(1)
mp0 (n0 AN VDD NW) g45p1svt w=(215n) l=45n nf=1 m=(1)
ends NAND2BX1

// gsclib045_backbias/NAND2BX2/schematic

simulator lang=spectre

subckt NAND2BX2 AN B Y NW VDD VSS
mn2 (Y B n1 VSS) g45n1svt w=(520n) l=45n nf=1 m=(1)
mn0 (n0 AN VSS VSS) g45n1svt w=(145n) l=45n nf=1 m=(1)
mn1 (n1 n0 VSS VSS) g45n1svt w=(520n) l=45n nf=1 m=(1)
mp1 (Y n0 VDD NW) g45p1svt w=(780n) l=45n nf=1 m=(1)
mp2 (Y B VDD NW) g45p1svt w=(780n) l=45n nf=1 m=(1)
mp0 (n0 AN VDD NW) g45p1svt w=(215n) l=45n nf=1 m=(1)
ends NAND2BX2

// gsclib045_backbias/NAND2BX4/schematic

simulator lang=spectre

subckt NAND2BX4 AN B Y NW VDD VSS
mn2 (Y B n1 VSS) g45n1svt w=(1.04u) l=45n nf=1 m=(1)
mn0 (n0 AN VSS VSS) g45n1svt w=(260n) l=45n nf=1 m=(1)
mn1 (n1 n0 VSS VSS) g45n1svt w=(1.04u) l=45n nf=1 m=(1)
mp1 (Y n0 VDD NW) g45p1svt w=(1.56u) l=45n nf=1 m=(1)
mp2 (Y B VDD NW) g45p1svt w=(1.56u) l=45n nf=1 m=(1)
mp0 (n0 AN VDD NW) g45p1svt w=(390n) l=45n nf=1 m=(1)
ends NAND2BX4

// gsclib045_backbias/NAND2BXL/schematic

simulator lang=spectre

subckt NAND2BXL AN B Y NW VDD VSS
mn2 (Y B n1 VSS) g45n1svt w=(145n) l=45n nf=1 m=(1)
mn0 (n0 AN VSS VSS) g45n1svt w=(145n) l=45n nf=1 m=(1)
mn1 (n1 n0 VSS VSS) g45n1svt w=(145n) l=45n nf=1 m=(1)
mp1 (Y n0 VDD NW) g45p1svt w=(215n) l=45n nf=1 m=(1)
mp2 (Y B VDD NW) g45p1svt w=(215n) l=45n nf=1 m=(1)
mp0 (n0 AN VDD NW) g45p1svt w=(215n) l=45n nf=1 m=(1)
ends NAND2BXL

// gsclib045_backbias/NAND2X1/schematic

simulator lang=spectre

subckt NAND2X1 A B Y VSS NW VDD
mn1 (Y B n0 VSS) g45n1svt w=(260n) l=45n nf=1 m=(1)
mn0 (n0 A VSS VSS) g45n1svt w=(260n) l=45n nf=1 m=(1)
mp1 (Y B VDD NW) g45p1svt w=(390n) l=45n nf=1 m=(1)
mp0 (Y A VDD NW) g45p1svt w=(390n) l=45n nf=1 m=(1)
ends NAND2X1

// gsclib045_backbias/NAND2X2/schematic

simulator lang=spectre

subckt NAND2X2 A B Y NW VSS VDD
mn1 (Y B n0 VSS) g45n1svt w=(520n) l=45n nf=1 m=(1)
mn0 (n0 A VSS VSS) g45n1svt w=(520n) l=45n nf=1 m=(1)
mp1 (Y B VDD NW) g45p1svt w=(780n) l=45n nf=1 m=(1)
mp0 (Y A VDD NW) g45p1svt w=(780n) l=45n nf=1 m=(1)
ends NAND2X2

// gsclib045_backbias/NAND2X4/schematic

simulator lang=spectre

subckt NAND2X4 A B Y VSS NW VDD
mn1 (Y B n0 VSS) g45n1svt w=(1.04u) l=45n nf=1 m=(1)
mn0 (n0 A VSS VSS) g45n1svt w=(1.04u) l=45n nf=1 m=(1)
mp1 (Y B VDD NW) g45p1svt w=(1.56u) l=45n nf=1 m=(1)
mp0 (Y A VDD NW) g45p1svt w=(1.56u) l=45n nf=1 m=(1)
ends NAND2X4

// gsclib045_backbias/NAND2X6/schematic

simulator lang=spectre

subckt NAND2X6 A B Y VSS NW VDD
mn1 (Y B n0 VSS) g45n1svt w=(1.55u) l=45n nf=1 m=(1)
mn0 (n0 A VSS VSS) g45n1svt w=(1.55u) l=45n nf=1 m=(1)
mp1 (Y B VDD NW) g45p1svt w=(2.34u) l=45n nf=1 m=(1)
mp0 (Y A VDD NW) g45p1svt w=(2.34u) l=45n nf=1 m=(1)
ends NAND2X6

// gsclib045_backbias/NAND2X8/schematic

simulator lang=spectre

subckt NAND2X8 A B Y VSS NW VDD
mn1 (Y B n0 VSS) g45n1svt w=(2.065u) l=45n nf=1 m=(1)
mn0 (n0 A VSS VSS) g45n1svt w=(2.065u) l=45n nf=1 m=(1)
mp1 (Y B VDD NW) g45p1svt w=(3.115u) l=45n nf=1 m=(1)
mp0 (Y A VDD NW) g45p1svt w=(3.115u) l=45n nf=1 m=(1)
ends NAND2X8

// gsclib045_backbias/NAND2XL/schematic

simulator lang=spectre

subckt NAND2XL A B Y VSS NW VDD
mn1 (Y B n0 VSS) g45n1svt w=(145n) l=45n nf=1 m=(1)
mn0 (n0 A VSS VSS) g45n1svt w=(145n) l=45n nf=1 m=(1)
mp1 (Y B VDD NW) g45p1svt w=(215n) l=45n nf=1 m=(1)
mp0 (Y A VDD NW) g45p1svt w=(215n) l=45n nf=1 m=(1)
ends NAND2XL

// gsclib045_backbias/NAND3BX1/schematic

simulator lang=spectre

subckt NAND3BX1 AN B C Y NW VDD VSS
mn3 (Y C n1 VSS) g45n1svt w=(260n) l=45n nf=1 m=(1)
mn0 (n0 AN VSS VSS) g45n1svt w=(145n) l=45n nf=1 m=(1)
mn2 (n1 B n2 VSS) g45n1svt w=(260n) l=45n nf=1 m=(1)
mn1 (n2 n0 VSS VSS) g45n1svt w=(260n) l=45n nf=1 m=(1)
mp1 (Y n0 VDD NW) g45p1svt w=(390n) l=45n nf=1 m=(1)
mp3 (Y C VDD NW) g45p1svt w=(390n) l=45n nf=1 m=(1)
mp0 (n0 AN VDD NW) g45p1svt w=(215n) l=45n nf=1 m=(1)
mp2 (Y B VDD NW) g45p1svt w=(390n) l=45n nf=1 m=(1)
ends NAND3BX1

// gsclib045_backbias/NAND3BX2/schematic

simulator lang=spectre

subckt NAND3BX2 AN B C Y VDD NW VSS
mn3 (Y C n1 VSS) g45n1svt w=(520n) l=45n nf=1 m=(1)
mn0 (n0 AN VSS VSS) g45n1svt w=(145n) l=45n nf=1 m=(1)
mn2 (n1 B n2 VSS) g45n1svt w=(520n) l=45n nf=1 m=(1)
mn1 (n2 n0 VSS VSS) g45n1svt w=(520n) l=45n nf=1 m=(1)
mp1 (Y n0 VDD NW) g45p1svt w=(780n) l=45n nf=1 m=(1)
mp3 (Y C VDD NW) g45p1svt w=(780n) l=45n nf=1 m=(1)
mp0 (n0 AN VDD NW) g45p1svt w=(215n) l=45n nf=1 m=(1)
mp2 (Y B VDD NW) g45p1svt w=(780n) l=45n nf=1 m=(1)
ends NAND3BX2

// gsclib045_backbias/NAND3BX4/schematic

simulator lang=spectre

subckt NAND3BX4 AN B C Y VDD VSS NW
mn3 (Y C n1 VSS) g45n1svt w=(1.04u) l=45n nf=1 m=(1)
mn0 (n0 AN VSS VSS) g45n1svt w=(260n) l=45n nf=1 m=(1)
mn2 (n1 B n2 VSS) g45n1svt w=(1.04u) l=45n nf=1 m=(1)
mn1 (n2 n0 VSS VSS) g45n1svt w=(1.04u) l=45n nf=1 m=(1)
mp1 (Y n0 VDD NW) g45p1svt w=(1.56u) l=45n nf=1 m=(1)
mp3 (Y C VDD NW) g45p1svt w=(1.56u) l=45n nf=1 m=(1)
mp0 (n0 AN VDD NW) g45p1svt w=(390n) l=45n nf=1 m=(1)
mp2 (Y B VDD NW) g45p1svt w=(1.56u) l=45n nf=1 m=(1)
ends NAND3BX4

// gsclib045_backbias/NAND3BXL/schematic

simulator lang=spectre

subckt NAND3BXL AN B C Y NW VSS VDD
mn3 (Y C n1 VSS) g45n1svt w=(145n) l=45n nf=1 m=(1)
mn0 (n0 AN VSS VSS) g45n1svt w=(145n) l=45n nf=1 m=(1)
mn2 (n1 B n2 VSS) g45n1svt w=(145n) l=45n nf=1 m=(1)
mn1 (n2 n0 VSS VSS) g45n1svt w=(145n) l=45n nf=1 m=(1)
mp1 (Y n0 VDD NW) g45p1svt w=(215n) l=45n nf=1 m=(1)
mp3 (Y C VDD NW) g45p1svt w=(215n) l=45n nf=1 m=(1)
mp0 (n0 AN VDD NW) g45p1svt w=(215n) l=45n nf=1 m=(1)
mp2 (Y B VDD NW) g45p1svt w=(215n) l=45n nf=1 m=(1)
ends NAND3BXL

// gsclib045_backbias/NAND3X1/schematic

simulator lang=spectre

subckt NAND3X1 A B C Y NW VDD VSS
mn1 (n0 B n1 VSS) g45n1svt w=(260n) l=45n nf=1 m=(1)
mn2 (Y C n0 VSS) g45n1svt w=(260n) l=45n nf=1 m=(1)
mn0 (n1 A VSS VSS) g45n1svt w=(260n) l=45n nf=1 m=(1)
mp0 (Y A VDD NW) g45p1svt w=(390n) l=45n nf=1 m=(1)
mp1 (Y B VDD NW) g45p1svt w=(390n) l=45n nf=1 m=(1)
mp2 (Y C VDD NW) g45p1svt w=(390n) l=45n nf=1 m=(1)
ends NAND3X1

// gsclib045_backbias/NAND3X2/schematic

simulator lang=spectre

subckt NAND3X2 A B C Y VDD VSS NW
mn1 (n0 B n1 VSS) g45n1svt w=(520n) l=45n nf=1 m=(1)
mn2 (Y C n0 VSS) g45n1svt w=(520n) l=45n nf=1 m=(1)
mn0 (n1 A VSS VSS) g45n1svt w=(520n) l=45n nf=1 m=(1)
mp0 (Y A VDD NW) g45p1svt w=(780n) l=45n nf=1 m=(1)
mp1 (Y B VDD NW) g45p1svt w=(780n) l=45n nf=1 m=(1)
mp2 (Y C VDD NW) g45p1svt w=(780n) l=45n nf=1 m=(1)
ends NAND3X2

// gsclib045_backbias/NAND3X4/schematic

simulator lang=spectre

subckt NAND3X4 A B C Y VDD VSS NW
mn1 (n0 B n1 VSS) g45n1svt w=(1.04u) l=45n nf=1 m=(1)
mn2 (Y C n0 VSS) g45n1svt w=(1.04u) l=45n nf=1 m=(1)
mn0 (n1 A VSS VSS) g45n1svt w=(1.04u) l=45n nf=1 m=(1)
mp0 (Y A VDD NW) g45p1svt w=(1.56u) l=45n nf=1 m=(1)
mp1 (Y B VDD NW) g45p1svt w=(1.56u) l=45n nf=1 m=(1)
mp2 (Y C VDD NW) g45p1svt w=(1.56u) l=45n nf=1 m=(1)
ends NAND3X4

// gsclib045_backbias/NAND3X6/schematic

simulator lang=spectre

subckt NAND3X6 A B C Y VDD VSS NW
mn1 (n0 B n1 VSS) g45n1svt w=(1.55u) l=45n nf=1 m=(1)
mn2 (Y C n0 VSS) g45n1svt w=(1.55u) l=45n nf=1 m=(1)
mn0 (n1 A VSS VSS) g45n1svt w=(1.55u) l=45n nf=1 m=(1)
mp0 (Y A VDD NW) g45p1svt w=(2.34u) l=45n nf=1 m=(1)
mp1 (Y B VDD NW) g45p1svt w=(2.34u) l=45n nf=1 m=(1)
mp2 (Y C VDD NW) g45p1svt w=(2.34u) l=45n nf=1 m=(1)
ends NAND3X6

// gsclib045_backbias/NAND3X8/schematic

simulator lang=spectre

subckt NAND3X8 A B C Y VDD VSS NW
mn1 (n0 B n1 VSS) g45n1svt w=(2.065u) l=45n nf=1 m=(1)
mn2 (Y C n0 VSS) g45n1svt w=(2.065u) l=45n nf=1 m=(1)
mn0 (n1 A VSS VSS) g45n1svt w=(2.065u) l=45n nf=1 m=(1)
mp0 (Y A VDD NW) g45p1svt w=(3.115u) l=45n nf=1 m=(1)
mp1 (Y B VDD NW) g45p1svt w=(3.115u) l=45n nf=1 m=(1)
mp2 (Y C VDD NW) g45p1svt w=(3.115u) l=45n nf=1 m=(1)
ends NAND3X8

// gsclib045_backbias/NAND3XL/schematic

simulator lang=spectre

subckt NAND3XL A B C Y VDD VSS NW
mn1 (n0 B n1 VSS) g45n1svt w=(145n) l=45n nf=1 m=(1)
mn2 (Y C n0 VSS) g45n1svt w=(145n) l=45n nf=1 m=(1)
mn0 (n1 A VSS VSS) g45n1svt w=(145n) l=45n nf=1 m=(1)
mp0 (Y A VDD NW) g45p1svt w=(215n) l=45n nf=1 m=(1)
mp1 (Y B VDD NW) g45p1svt w=(215n) l=45n nf=1 m=(1)
mp2 (Y C VDD NW) g45p1svt w=(215n) l=45n nf=1 m=(1)
ends NAND3XL

// gsclib045_backbias/NAND4BBX1/schematic

simulator lang=spectre

subckt NAND4BBX1 AN BN C D Y NW VSS VDD
mn1 (n1 BN VSS VSS) g45n1svt w=(145n) l=45n nf=1 m=(1)
mn2 (n4 n0 VSS VSS) g45n1svt w=(260n) l=45n nf=1 m=(1)
mn4 (n2 C n3 VSS) g45n1svt w=(260n) l=45n nf=1 m=(1)
mn5 (Y D n2 VSS) g45n1svt w=(260n) l=45n nf=1 m=(1)
mn0 (n0 AN VSS VSS) g45n1svt w=(145n) l=45n nf=1 m=(1)
mn3 (n3 n1 n4 VSS) g45n1svt w=(260n) l=45n nf=1 m=(1)
mp2 (Y n0 VDD NW) g45p1svt w=(390n) l=45n nf=1 m=(1)
mp0 (n0 AN VDD NW) g45p1svt w=(215n) l=45n nf=1 m=(1)
mp5 (Y D VDD NW) g45p1svt w=(390n) l=45n nf=1 m=(1)
mp4 (Y C VDD NW) g45p1svt w=(390n) l=45n nf=1 m=(1)
mp1 (n1 BN VDD NW) g45p1svt w=(215n) l=45n nf=1 m=(1)
mp3 (Y n1 VDD NW) g45p1svt w=(390n) l=45n nf=1 m=(1)
ends NAND4BBX1

// gsclib045_backbias/NAND4BBX2/schematic

simulator lang=spectre

subckt NAND4BBX2 AN BN C D Y VSS NW VDD
mn1 (n1 BN VSS VSS) g45n1svt w=(145n) l=45n nf=1 m=(1)
mn2 (n4 n0 VSS VSS) g45n1svt w=(520n) l=45n nf=1 m=(1)
mn4 (n2 C n3 VSS) g45n1svt w=(520n) l=45n nf=1 m=(1)
mn5 (Y D n2 VSS) g45n1svt w=(520n) l=45n nf=1 m=(1)
mn0 (n0 AN VSS VSS) g45n1svt w=(145n) l=45n nf=1 m=(1)
mn3 (n3 n1 n4 VSS) g45n1svt w=(520n) l=45n nf=1 m=(1)
mp2 (Y n0 VDD NW) g45p1svt w=(780n) l=45n nf=1 m=(1)
mp0 (n0 AN VDD NW) g45p1svt w=(215n) l=45n nf=1 m=(1)
mp5 (Y D VDD NW) g45p1svt w=(780n) l=45n nf=1 m=(1)
mp4 (Y C VDD NW) g45p1svt w=(780n) l=45n nf=1 m=(1)
mp1 (n1 BN VDD NW) g45p1svt w=(215n) l=45n nf=1 m=(1)
mp3 (Y n1 VDD NW) g45p1svt w=(780n) l=45n nf=1 m=(1)
ends NAND4BBX2

// gsclib045_backbias/NAND4BBX4/schematic

simulator lang=spectre

subckt NAND4BBX4 AN BN C D Y VSS NW VDD
mn1 (n1 BN VSS VSS) g45n1svt w=(260n) l=45n nf=1 m=(1)
mn2 (n4 n0 VSS VSS) g45n1svt w=(1.04u) l=45n nf=1 m=(1)
mn4 (n2 C n3 VSS) g45n1svt w=(1.04u) l=45n nf=1 m=(1)
mn5 (Y D n2 VSS) g45n1svt w=(1.04u) l=45n nf=1 m=(1)
mn0 (n0 AN VSS VSS) g45n1svt w=(260n) l=45n nf=1 m=(1)
mn3 (n3 n1 n4 VSS) g45n1svt w=(1.04u) l=45n nf=1 m=(1)
mp2 (Y n0 VDD NW) g45p1svt w=(1.56u) l=45n nf=1 m=(1)
mp0 (n0 AN VDD NW) g45p1svt w=(390n) l=45n nf=1 m=(1)
mp5 (Y D VDD NW) g45p1svt w=(1.56u) l=45n nf=1 m=(1)
mp4 (Y C VDD NW) g45p1svt w=(1.56u) l=45n nf=1 m=(1)
mp1 (n1 BN VDD NW) g45p1svt w=(390n) l=45n nf=1 m=(1)
mp3 (Y n1 VDD NW) g45p1svt w=(1.56u) l=45n nf=1 m=(1)
ends NAND4BBX4

// gsclib045_backbias/NAND4BBXL/schematic

simulator lang=spectre

subckt NAND4BBXL AN BN C D Y VSS NW VDD
mn1 (n1 BN VSS VSS) g45n1svt w=(145n) l=45n nf=1 m=(1)
mn2 (n4 n0 VSS VSS) g45n1svt w=(145n) l=45n nf=1 m=(1)
mn4 (n2 C n3 VSS) g45n1svt w=(145n) l=45n nf=1 m=(1)
mn5 (Y D n2 VSS) g45n1svt w=(145n) l=45n nf=1 m=(1)
mn0 (n0 AN VSS VSS) g45n1svt w=(145n) l=45n nf=1 m=(1)
mn3 (n3 n1 n4 VSS) g45n1svt w=(145n) l=45n nf=1 m=(1)
mp2 (Y n0 VDD NW) g45p1svt w=(215n) l=45n nf=1 m=(1)
mp0 (n0 AN VDD NW) g45p1svt w=(215n) l=45n nf=1 m=(1)
mp5 (Y D VDD NW) g45p1svt w=(215n) l=45n nf=1 m=(1)
mp4 (Y C VDD NW) g45p1svt w=(215n) l=45n nf=1 m=(1)
mp1 (n1 BN VDD NW) g45p1svt w=(215n) l=45n nf=1 m=(1)
mp3 (Y n1 VDD NW) g45p1svt w=(215n) l=45n nf=1 m=(1)
ends NAND4BBXL

// gsclib045_backbias/NAND4BX1/schematic

simulator lang=spectre

subckt NAND4BX1 AN B C D Y VDD VSS NW
mn4 (Y D net130 VSS) g45n1svt w=(260n) l=45n nf=1 m=(1)
mn2 (net126 B net122 VSS) g45n1svt w=(260n) l=45n nf=1 m=(1)
mn1 (net122 net118 VSS VSS) g45n1svt w=(260n) l=45n nf=1 m=(1)
mn0 (net118 AN VSS VSS) g45n1svt w=(145n) l=45n nf=1 m=(1)
mn3 (net130 C net126 VSS) g45n1svt w=(260n) l=45n nf=1 m=(1)
mp4 (Y D VDD NW) g45p1svt w=(390n) l=45n nf=1 m=(1)
mp1 (Y net118 VDD NW) g45p1svt w=(390n) l=45n nf=1 m=(1)
mp2 (Y B VDD NW) g45p1svt w=(390n) l=45n nf=1 m=(1)
mp0 (net118 AN VDD NW) g45p1svt w=(215n) l=45n nf=1 m=(1)
mp3 (Y C VDD NW) g45p1svt w=(390n) l=45n nf=1 m=(1)
ends NAND4BX1

// gsclib045_backbias/NAND4BX2/schematic

simulator lang=spectre

subckt NAND4BX2 AN B C D Y NW VSS VDD
mn4 (Y D net130 VSS) g45n1svt w=(520n) l=45n nf=1 m=(1)
mn2 (net126 B net122 VSS) g45n1svt w=(520n) l=45n nf=1 m=(1)
mn1 (net122 net118 VSS VSS) g45n1svt w=(520n) l=45n nf=1 m=(1)
mn0 (net118 AN VSS VSS) g45n1svt w=(145n) l=45n nf=1 m=(1)
mn3 (net130 C net126 VSS) g45n1svt w=(520n) l=45n nf=1 m=(1)
mp4 (Y D VDD NW) g45p1svt w=(780n) l=45n nf=1 m=(1)
mp1 (Y net118 VDD NW) g45p1svt w=(780n) l=45n nf=1 m=(1)
mp2 (Y B VDD NW) g45p1svt w=(780n) l=45n nf=1 m=(1)
mp0 (net118 AN VDD NW) g45p1svt w=(215n) l=45n nf=1 m=(1)
mp3 (Y C VDD NW) g45p1svt w=(780n) l=45n nf=1 m=(1)
ends NAND4BX2

// gsclib045_backbias/NAND4BX4/schematic

simulator lang=spectre

subckt NAND4BX4 AN B C D Y NW VSS VDD
mn4 (Y D net130 VSS) g45n1svt w=(1.04u) l=45n nf=1 m=(1)
mn2 (net126 B net122 VSS) g45n1svt w=(1.04u) l=45n nf=1 m=(1)
mn1 (net122 net118 VSS VSS) g45n1svt w=(1.04u) l=45n nf=1 m=(1)
mn0 (net118 AN VSS VSS) g45n1svt w=(260n) l=45n nf=1 m=(1)
mn3 (net130 C net126 VSS) g45n1svt w=(1.04u) l=45n nf=1 m=(1)
mp4 (Y D VDD NW) g45p1svt w=(1.56u) l=45n nf=1 m=(1)
mp1 (Y net118 VDD NW) g45p1svt w=(1.56u) l=45n nf=1 m=(1)
mp2 (Y B VDD NW) g45p1svt w=(1.56u) l=45n nf=1 m=(1)
mp0 (net118 AN VDD NW) g45p1svt w=(390n) l=45n nf=1 m=(1)
mp3 (Y C VDD NW) g45p1svt w=(1.56u) l=45n nf=1 m=(1)
ends NAND4BX4

// gsclib045_backbias/NAND4BXL/schematic

simulator lang=spectre

subckt NAND4BXL AN B C D Y NW VSS VDD
mn4 (Y D net130 VSS) g45n1svt w=(145n) l=45n nf=1 m=(1)
mn2 (net126 B net122 VSS) g45n1svt w=(145n) l=45n nf=1 m=(1)
mn1 (net122 net118 VSS VSS) g45n1svt w=(145n) l=45n nf=1 m=(1)
mn0 (net118 AN VSS VSS) g45n1svt w=(145n) l=45n nf=1 m=(1)
mn3 (net130 C net126 VSS) g45n1svt w=(145n) l=45n nf=1 m=(1)
mp4 (Y D VDD NW) g45p1svt w=(215n) l=45n nf=1 m=(1)
mp1 (Y net118 VDD NW) g45p1svt w=(215n) l=45n nf=1 m=(1)
mp2 (Y B VDD NW) g45p1svt w=(215n) l=45n nf=1 m=(1)
mp0 (net118 AN VDD NW) g45p1svt w=(215n) l=45n nf=1 m=(1)
mp3 (Y C VDD NW) g45p1svt w=(215n) l=45n nf=1 m=(1)
ends NAND4BXL

// gsclib045_backbias/NAND4X1/schematic

simulator lang=spectre

subckt NAND4X1 A B C D Y NW VDD VSS
mn1 (n1 B n2 VSS) g45n1svt w=(260n) l=45n nf=1 m=(1)
mn3 (Y D n0 VSS) g45n1svt w=(260n) l=45n nf=1 m=(1)
mn2 (n0 C n1 VSS) g45n1svt w=(260n) l=45n nf=1 m=(1)
mn0 (n2 A VSS VSS) g45n1svt w=(260n) l=45n nf=1 m=(1)
mp3 (Y D VDD NW) g45p1svt w=(390n) l=45n nf=1 m=(1)
mp2 (Y C VDD NW) g45p1svt w=(390n) l=45n nf=1 m=(1)
mp1 (Y B VDD NW) g45p1svt w=(390n) l=45n nf=1 m=(1)
mp0 (Y A VDD NW) g45p1svt w=(390n) l=45n nf=1 m=(1)
ends NAND4X1

// gsclib045_backbias/NAND4X2/schematic

simulator lang=spectre

subckt NAND4X2 A B C D Y NW VDD VSS
mn1 (n1 B n2 VSS) g45n1svt w=(520n) l=45n nf=1 m=(1)
mn3 (Y D n0 VSS) g45n1svt w=(520n) l=45n nf=1 m=(1)
mn2 (n0 C n1 VSS) g45n1svt w=(520n) l=45n nf=1 m=(1)
mn0 (n2 A VSS VSS) g45n1svt w=(520n) l=45n nf=1 m=(1)
mp3 (Y D VDD NW) g45p1svt w=(780n) l=45n nf=1 m=(1)
mp2 (Y C VDD NW) g45p1svt w=(780n) l=45n nf=1 m=(1)
mp1 (Y B VDD NW) g45p1svt w=(780n) l=45n nf=1 m=(1)
mp0 (Y A VDD NW) g45p1svt w=(780n) l=45n nf=1 m=(1)
ends NAND4X2

// gsclib045_backbias/NAND4X4/schematic

simulator lang=spectre

subckt NAND4X4 A B C D Y NW VDD VSS
mn1 (n1 B n2 VSS) g45n1svt w=(1.04u) l=45n nf=1 m=(1)
mn3 (Y D n0 VSS) g45n1svt w=(1.04u) l=45n nf=1 m=(1)
mn2 (n0 C n1 VSS) g45n1svt w=(1.04u) l=45n nf=1 m=(1)
mn0 (n2 A VSS VSS) g45n1svt w=(1.04u) l=45n nf=1 m=(1)
mp3 (Y D VDD NW) g45p1svt w=(1.56u) l=45n nf=1 m=(1)
mp2 (Y C VDD NW) g45p1svt w=(1.56u) l=45n nf=1 m=(1)
mp1 (Y B VDD NW) g45p1svt w=(1.56u) l=45n nf=1 m=(1)
mp0 (Y A VDD NW) g45p1svt w=(1.56u) l=45n nf=1 m=(1)
ends NAND4X4

// gsclib045_backbias/NAND4X6/schematic

simulator lang=spectre

subckt NAND4X6 A B C D Y NW VDD VSS
mn1 (n1 B n2 VSS) g45n1svt w=(1.55u) l=45n nf=1 m=(1)
mn3 (Y D n0 VSS) g45n1svt w=(1.55u) l=45n nf=1 m=(1)
mn2 (n0 C n1 VSS) g45n1svt w=(1.55u) l=45n nf=1 m=(1)
mn0 (n2 A VSS VSS) g45n1svt w=(1.55u) l=45n nf=1 m=(1)
mp3 (Y D VDD NW) g45p1svt w=(2.35u) l=45n nf=1 m=(1)
mp2 (Y C VDD NW) g45p1svt w=(2.35u) l=45n nf=1 m=(1)
mp1 (Y B VDD NW) g45p1svt w=(2.35u) l=45n nf=1 m=(1)
mp0 (Y A VDD NW) g45p1svt w=(2.35u) l=45n nf=1 m=(1)
ends NAND4X6

// gsclib045_backbias/NAND4X8/schematic

simulator lang=spectre

subckt NAND4X8 A B C D Y NW VDD VSS
mn1 (n1 B n2 VSS) g45n1svt w=(2.065u) l=45n nf=1 m=(1)
mn3 (Y D n0 VSS) g45n1svt w=(2.065u) l=45n nf=1 m=(1)
mn2 (n0 C n1 VSS) g45n1svt w=(2.065u) l=45n nf=1 m=(1)
mn0 (n2 A VSS VSS) g45n1svt w=(2.065u) l=45n nf=1 m=(1)
mp3 (Y D VDD NW) g45p1svt w=(3.115u) l=45n nf=1 m=(1)
mp2 (Y C VDD NW) g45p1svt w=(3.115u) l=45n nf=1 m=(1)
mp1 (Y B VDD NW) g45p1svt w=(3.115u) l=45n nf=1 m=(1)
mp0 (Y A VDD NW) g45p1svt w=(3.115u) l=45n nf=1 m=(1)
ends NAND4X8

// gsclib045_backbias/NAND4XL/schematic

simulator lang=spectre

subckt NAND4XL A B C D Y NW VDD VSS
mn1 (n1 B n2 VSS) g45n1svt w=(145n) l=45n nf=1 m=(1)
mn3 (Y D n0 VSS) g45n1svt w=(145n) l=45n nf=1 m=(1)
mn2 (n0 C n1 VSS) g45n1svt w=(145n) l=45n nf=1 m=(1)
mn0 (n2 A VSS VSS) g45n1svt w=(145n) l=45n nf=1 m=(1)
mp3 (Y D VDD NW) g45p1svt w=(215n) l=45n nf=1 m=(1)
mp2 (Y C VDD NW) g45p1svt w=(215n) l=45n nf=1 m=(1)
mp1 (Y B VDD NW) g45p1svt w=(215n) l=45n nf=1 m=(1)
mp0 (Y A VDD NW) g45p1svt w=(215n) l=45n nf=1 m=(1)
ends NAND4XL

// gsclib045_backbias/NOR2BX1/schematic

simulator lang=spectre

subckt NOR2BX1 AN B Y NW VDD VSS
mn1 (Y net76 VSS VSS) g45n1svt w=(260n) l=45n nf=1 m=(1)
mn2 (Y B VSS VSS) g45n1svt w=(260n) l=45n nf=1 m=(1)
mn0 (net76 AN VSS VSS) g45n1svt w=(145n) l=45n nf=1 m=(1)
mp2 (Y B net59 NW) g45p1svt w=(390n) l=45n nf=1 m=(1)
mp1 (net59 net76 VDD NW) g45p1svt w=(390n) l=45n nf=1 m=(1)
mp0 (net76 AN VDD NW) g45p1svt w=(215n) l=45n nf=1 m=(1)
ends NOR2BX1

// gsclib045_backbias/NOR2BX2/schematic

simulator lang=spectre

subckt NOR2BX2 AN B Y VDD NW VSS
mn1 (Y net76 VSS VSS) g45n1svt w=(520n) l=45n nf=1 m=(1)
mn2 (Y B VSS VSS) g45n1svt w=(520n) l=45n nf=1 m=(1)
mn0 (net76 AN VSS VSS) g45n1svt w=(145n) l=45n nf=1 m=(1)
mp2 (Y B net59 NW) g45p1svt w=(780n) l=45n nf=1 m=(1)
mp1 (net59 net76 VDD NW) g45p1svt w=(780n) l=45n nf=1 m=(1)
mp0 (net76 AN VDD NW) g45p1svt w=(215n) l=45n nf=1 m=(1)
ends NOR2BX2

// gsclib045_backbias/NOR2BX4/schematic

simulator lang=spectre

subckt NOR2BX4 AN B Y VDD NW VSS
mn1 (Y net76 VSS VSS) g45n1svt w=(1.04u) l=45n nf=1 m=(1)
mn2 (Y B VSS VSS) g45n1svt w=(1.04u) l=45n nf=1 m=(1)
mn0 (net76 AN VSS VSS) g45n1svt w=(145n) l=45n nf=1 m=(1)
mp2 (Y B net59 NW) g45p1svt w=(1.56u) l=45n nf=1 m=(1)
mp1 (net59 net76 VDD NW) g45p1svt w=(1.56u) l=45n nf=1 m=(1)
mp0 (net76 AN VDD NW) g45p1svt w=(215n) l=45n nf=1 m=(1)
ends NOR2BX4

// gsclib045_backbias/NOR2BXL/schematic

simulator lang=spectre

subckt NOR2BXL AN B Y VDD NW VSS
mn1 (Y net76 VSS VSS) g45n1svt w=(145n) l=45n nf=1 m=(1)
mn2 (Y B VSS VSS) g45n1svt w=(145n) l=45n nf=1 m=(1)
mn0 (net76 AN VSS VSS) g45n1svt w=(145n) l=45n nf=1 m=(1)
mp2 (Y B net59 NW) g45p1svt w=(215n) l=45n nf=1 m=(1)
mp1 (net59 net76 VDD NW) g45p1svt w=(215n) l=45n nf=1 m=(1)
mp0 (net76 AN VDD NW) g45p1svt w=(215n) l=45n nf=1 m=(1)
ends NOR2BXL

// gsclib045_backbias/NOR2X1/schematic

simulator lang=spectre

subckt NOR2X1 A B Y NW VDD VSS
mn1 (Y B VSS VSS) g45n1svt w=(260n) l=45n nf=1 m=(1)
mn0 (Y A VSS VSS) g45n1svt w=(260n) l=45n nf=1 m=(1)
mp1 (Y B net41 NW) g45p1svt w=(390n) l=45n nf=1 m=(1)
mp0 (net41 A VDD NW) g45p1svt w=(390n) l=45n nf=1 m=(1)
ends NOR2X1

// gsclib045_backbias/NOR2X2/schematic

simulator lang=spectre

subckt NOR2X2 A B Y NW VDD VSS
mn1 (Y B VSS VSS) g45n1svt w=(520n) l=45n nf=1 m=(1)
mn0 (Y A VSS VSS) g45n1svt w=(520n) l=45n nf=1 m=(1)
mp1 (Y B net41 NW) g45p1svt w=(780n) l=45n nf=1 m=(1)
mp0 (net41 A VDD NW) g45p1svt w=(780n) l=45n nf=1 m=(1)
ends NOR2X2

// gsclib045_backbias/NOR2X4/schematic

simulator lang=spectre

subckt NOR2X4 A B Y NW VSS VDD
mn1 (Y B VSS VSS) g45n1svt w=(1.04u) l=45n nf=1 m=(1)
mn0 (Y A VSS VSS) g45n1svt w=(1.04u) l=45n nf=1 m=(1)
mp1 (Y B net41 NW) g45p1svt w=(1.56u) l=45n nf=1 m=(1)
mp0 (net41 A VDD NW) g45p1svt w=(1.56u) l=45n nf=1 m=(1)
ends NOR2X4

// gsclib045_backbias/NOR2X6/schematic

simulator lang=spectre

subckt NOR2X6 A B Y NW VSS VDD
mn1 (Y B VSS VSS) g45n1svt w=(1.55u) l=45n nf=1 m=(1)
mn0 (Y A VSS VSS) g45n1svt w=(1.55u) l=45n nf=1 m=(1)
mp1 (Y B net41 NW) g45p1svt w=(2.34u) l=45n nf=1 m=(1)
mp0 (net41 A VDD NW) g45p1svt w=(2.34u) l=45n nf=1 m=(1)
ends NOR2X6

// gsclib045_backbias/NOR2X8/schematic

simulator lang=spectre

subckt NOR2X8 A B Y VSS NW VDD
mn1 (Y B VSS VSS) g45n1svt w=(2.065u) l=45n nf=1 m=(1)
mn0 (Y A VSS VSS) g45n1svt w=(2.065u) l=45n nf=1 m=(1)
mp1 (Y B net41 NW) g45p1svt w=(3.115u) l=45n nf=1 m=(1)
mp0 (net41 A VDD NW) g45p1svt w=(3.115u) l=45n nf=1 m=(1)
ends NOR2X8

// gsclib045_backbias/NOR2XL/schematic

simulator lang=spectre

subckt NOR2XL A B Y NW VSS VDD
mn1 (Y B VSS VSS) g45n1svt w=(145n) l=45n nf=1 m=(1)
mn0 (Y A VSS VSS) g45n1svt w=(145n) l=45n nf=1 m=(1)
mp1 (Y B net41 NW) g45p1svt w=(215n) l=45n nf=1 m=(1)
mp0 (net41 A VDD NW) g45p1svt w=(215n) l=45n nf=1 m=(1)
ends NOR2XL

// gsclib045_backbias/NOR3BX1/schematic

simulator lang=spectre

subckt NOR3BX1 AN B C Y VDD NW VSS
mn1 (Y net91 VSS VSS) g45n1svt w=(260n) l=45n nf=1 m=(1)
mn3 (Y C VSS VSS) g45n1svt w=(260n) l=45n nf=1 m=(1)
mn0 (net91 AN VSS VSS) g45n1svt w=(145n) l=45n nf=1 m=(1)
mn2 (Y B VSS VSS) g45n1svt w=(260n) l=45n nf=1 m=(1)
mp3 (Y C net90 NW) g45p1svt w=(390n) l=45n nf=1 m=(1)
mp0 (net91 AN VDD NW) g45p1svt w=(215n) l=45n nf=1 m=(1)
mp1 (net86 net91 VDD NW) g45p1svt w=(390n) l=45n nf=1 m=(1)
mp2 (net90 B net86 NW) g45p1svt w=(390n) l=45n nf=1 m=(1)
ends NOR3BX1

// gsclib045_backbias/NOR3BX2/schematic

simulator lang=spectre

subckt NOR3BX2 AN B C Y VDD VSS NW
mn1 (Y net91 VSS VSS) g45n1svt w=(520n) l=45n nf=1 m=(1)
mn3 (Y C VSS VSS) g45n1svt w=(520n) l=45n nf=1 m=(1)
mn0 (net91 AN VSS VSS) g45n1svt w=(145n) l=45n nf=1 m=(1)
mn2 (Y B VSS VSS) g45n1svt w=(520n) l=45n nf=1 m=(1)
mp3 (Y C net90 NW) g45p1svt w=(780n) l=45n nf=1 m=(1)
mp0 (net91 AN VDD NW) g45p1svt w=(215n) l=45n nf=1 m=(1)
mp1 (net86 net91 VDD NW) g45p1svt w=(780n) l=45n nf=1 m=(1)
mp2 (net90 B net86 NW) g45p1svt w=(780n) l=45n nf=1 m=(1)
ends NOR3BX2

// gsclib045_backbias/NOR3BX4/schematic

simulator lang=spectre

subckt NOR3BX4 AN B C Y VDD VSS NW
mn1 (Y net91 VSS VSS) g45n1svt w=(1.04u) l=45n nf=1 m=(1)
mn3 (Y C VSS VSS) g45n1svt w=(1.04u) l=45n nf=1 m=(1)
mn0 (net91 AN VSS VSS) g45n1svt w=(260n) l=45n nf=1 m=(1)
mn2 (Y B VSS VSS) g45n1svt w=(1.04u) l=45n nf=1 m=(1)
mp3 (Y C net90 NW) g45p1svt w=(1.56u) l=45n nf=1 m=(1)
mp0 (net91 AN VDD NW) g45p1svt w=(390n) l=45n nf=1 m=(1)
mp1 (net86 net91 VDD NW) g45p1svt w=(1.56u) l=45n nf=1 m=(1)
mp2 (net90 B net86 NW) g45p1svt w=(1.56u) l=45n nf=1 m=(1)
ends NOR3BX4

// gsclib045_backbias/NOR3BXL/schematic

simulator lang=spectre

subckt NOR3BXL AN B C Y VDD VSS NW
mn1 (Y net91 VSS VSS) g45n1svt w=(145n) l=45n nf=1 m=(1)
mn3 (Y C VSS VSS) g45n1svt w=(145n) l=45n nf=1 m=(1)
mn0 (net91 AN VSS VSS) g45n1svt w=(145n) l=45n nf=1 m=(1)
mn2 (Y B VSS VSS) g45n1svt w=(145n) l=45n nf=1 m=(1)
mp3 (Y C net90 NW) g45p1svt w=(215n) l=45n nf=1 m=(1)
mp0 (net91 AN VDD NW) g45p1svt w=(215n) l=45n nf=1 m=(1)
mp1 (net86 net91 VDD NW) g45p1svt w=(215n) l=45n nf=1 m=(1)
mp2 (net90 B net86 NW) g45p1svt w=(215n) l=45n nf=1 m=(1)
ends NOR3BXL

// gsclib045_backbias/NOR3X1/schematic

simulator lang=spectre

subckt NOR3X1 A B C Y VSS VDD NW
mn0 (Y A VSS VSS) g45n1svt w=(260n) l=45n nf=1 m=(1)
mn1 (Y B VSS VSS) g45n1svt w=(260n) l=45n nf=1 m=(1)
mn2 (Y C VSS VSS) g45n1svt w=(260n) l=45n nf=1 m=(1)
mp1 (n1 B n0 NW) g45p1svt w=(390n) l=45n nf=1 m=(1)
mp2 (Y C n1 NW) g45p1svt w=(390n) l=45n nf=1 m=(1)
mp0 (n0 A VDD NW) g45p1svt w=(390n) l=45n nf=1 m=(1)
ends NOR3X1

// gsclib045_backbias/NOR3X2/schematic

simulator lang=spectre

subckt NOR3X2 A B C Y VSS VDD NW
mn0 (Y A VSS VSS) g45n1svt w=(520n) l=45n nf=1 m=(1)
mn1 (Y B VSS VSS) g45n1svt w=(520n) l=45n nf=1 m=(1)
mn2 (Y C VSS VSS) g45n1svt w=(520n) l=45n nf=1 m=(1)
mp1 (n1 B n0 NW) g45p1svt w=(780n) l=45n nf=1 m=(1)
mp2 (Y C n1 NW) g45p1svt w=(780n) l=45n nf=1 m=(1)
mp0 (n0 A VDD NW) g45p1svt w=(780n) l=45n nf=1 m=(1)
ends NOR3X2

// gsclib045_backbias/NOR3X4/schematic

simulator lang=spectre

subckt NOR3X4 A B C Y VSS VDD NW
mn0 (Y A VSS VSS) g45n1svt w=(1.04u) l=45n nf=1 m=(1)
mn1 (Y B VSS VSS) g45n1svt w=(1.04u) l=45n nf=1 m=(1)
mn2 (Y C VSS VSS) g45n1svt w=(1.04u) l=45n nf=1 m=(1)
mp1 (n1 B n0 NW) g45p1svt w=(1.56u) l=45n nf=1 m=(1)
mp2 (Y C n1 NW) g45p1svt w=(1.56u) l=45n nf=1 m=(1)
mp0 (n0 A VDD NW) g45p1svt w=(1.56u) l=45n nf=1 m=(1)
ends NOR3X4

// gsclib045_backbias/NOR3X6/schematic

simulator lang=spectre

subckt NOR3X6 A B C Y VSS VDD NW
mn0 (Y A VSS VSS) g45n1svt w=(1.55u) l=45n nf=1 m=(1)
mn1 (Y B VSS VSS) g45n1svt w=(1.55u) l=45n nf=1 m=(1)
mn2 (Y C VSS VSS) g45n1svt w=(1.55u) l=45n nf=1 m=(1)
mp1 (n1 B n0 NW) g45p1svt w=(2.34u) l=45n nf=1 m=(1)
mp2 (Y C n1 NW) g45p1svt w=(2.34u) l=45n nf=1 m=(1)
mp0 (n0 A VDD NW) g45p1svt w=(2.34u) l=45n nf=1 m=(1)
ends NOR3X6

// gsclib045_backbias/NOR3X8/schematic

simulator lang=spectre

subckt NOR3X8 A B C Y VSS VDD NW
mn0 (Y A VSS VSS) g45n1svt w=(2.065u) l=45n nf=1 m=(1)
mn1 (Y B VSS VSS) g45n1svt w=(2.065u) l=45n nf=1 m=(1)
mn2 (Y C VSS VSS) g45n1svt w=(2.065u) l=45n nf=1 m=(1)
mp1 (n1 B n0 NW) g45p1svt w=(3.115u) l=45n nf=1 m=(1)
mp2 (Y C n1 NW) g45p1svt w=(3.115u) l=45n nf=1 m=(1)
mp0 (n0 A VDD NW) g45p1svt w=(3.115u) l=45n nf=1 m=(1)
ends NOR3X8

// gsclib045_backbias/NOR3XL/schematic

simulator lang=spectre

subckt NOR3XL A B C Y VSS VDD NW
mn0 (Y A VSS VSS) g45n1svt w=(145n) l=45n nf=1 m=(1)
mn1 (Y B VSS VSS) g45n1svt w=(145n) l=45n nf=1 m=(1)
mn2 (Y C VSS VSS) g45n1svt w=(145n) l=45n nf=1 m=(1)
mp1 (n1 B n0 NW) g45p1svt w=(215n) l=45n nf=1 m=(1)
mp2 (Y C n1 NW) g45p1svt w=(215n) l=45n nf=1 m=(1)
mp0 (n0 A VDD NW) g45p1svt w=(215n) l=45n nf=1 m=(1)
ends NOR3XL

// gsclib045_backbias/NOR4BBX1/schematic

simulator lang=spectre

subckt NOR4BBX1 AN BN C D Y VSS NW VDD
mn2 (Y n0 VSS VSS) g45n1svt w=(260n) l=45n nf=1 m=(1)
mn1 (n1 BN VSS VSS) g45n1svt w=(145n) l=45n nf=1 m=(1)
mn3 (Y n1 VSS VSS) g45n1svt w=(260n) l=45n nf=1 m=(1)
mn5 (Y D VSS VSS) g45n1svt w=(260n) l=45n nf=1 m=(1)
mn4 (Y C VSS VSS) g45n1svt w=(260n) l=45n nf=1 m=(1)
mn0 (n0 AN VSS VSS) g45n1svt w=(145n) l=45n nf=1 m=(1)
mp0 (n0 AN VDD NW) g45p1svt w=(215n) l=45n nf=1 m=(1)
mp5 (Y D n4 NW) g45p1svt w=(390n) l=45n nf=1 m=(1)
mp4 (n4 C n3 NW) g45p1svt w=(390n) l=45n nf=1 m=(1)
mp1 (n1 BN VDD NW) g45p1svt w=(215n) l=45n nf=1 m=(1)
mp3 (n3 n1 n2 NW) g45p1svt w=(390n) l=45n nf=1 m=(1)
mp2 (n2 n0 VDD NW) g45p1svt w=(390n) l=45n nf=1 m=(1)
ends NOR4BBX1

// gsclib045_backbias/NOR4BBX2/schematic

simulator lang=spectre

subckt NOR4BBX2 AN BN C D Y NW VSS VDD
mn2 (Y n0 VSS VSS) g45n1svt w=(520n) l=45n nf=1 m=(1)
mn1 (n1 BN VSS VSS) g45n1svt w=(145n) l=45n nf=1 m=(1)
mn3 (Y n1 VSS VSS) g45n1svt w=(520n) l=45n nf=1 m=(1)
mn5 (Y D VSS VSS) g45n1svt w=(520n) l=45n nf=1 m=(1)
mn4 (Y C VSS VSS) g45n1svt w=(520n) l=45n nf=1 m=(1)
mn0 (n0 AN VSS VSS) g45n1svt w=(145n) l=45n nf=1 m=(1)
mp0 (n0 AN VDD NW) g45p1svt w=(215n) l=45n nf=1 m=(1)
mp5 (Y D n4 NW) g45p1svt w=(780n) l=45n nf=1 m=(1)
mp4 (n4 C n3 NW) g45p1svt w=(780n) l=45n nf=1 m=(1)
mp1 (n1 BN VDD NW) g45p1svt w=(215n) l=45n nf=1 m=(1)
mp3 (n3 n1 n2 NW) g45p1svt w=(780n) l=45n nf=1 m=(1)
mp2 (n2 n0 VDD NW) g45p1svt w=(780n) l=45n nf=1 m=(1)
ends NOR4BBX2

// gsclib045_backbias/NOR4BBX4/schematic

simulator lang=spectre

subckt NOR4BBX4 AN BN C D Y NW VSS VDD
mn2 (Y n0 VSS VSS) g45n1svt w=(1.04u) l=45n nf=1 m=(1)
mn1 (n1 BN VSS VSS) g45n1svt w=(260n) l=45n nf=1 m=(1)
mn3 (Y n1 VSS VSS) g45n1svt w=(1.04u) l=45n nf=1 m=(1)
mn5 (Y D VSS VSS) g45n1svt w=(1.04u) l=45n nf=1 m=(1)
mn4 (Y C VSS VSS) g45n1svt w=(1.04u) l=45n nf=1 m=(1)
mn0 (n0 AN VSS VSS) g45n1svt w=(260n) l=45n nf=1 m=(1)
mp0 (n0 AN VDD NW) g45p1svt w=(390n) l=45n nf=1 m=(1)
mp5 (Y D n4 NW) g45p1svt w=(1.56u) l=45n nf=1 m=(1)
mp4 (n4 C n3 NW) g45p1svt w=(1.56u) l=45n nf=1 m=(1)
mp1 (n1 BN VDD NW) g45p1svt w=(390n) l=45n nf=1 m=(1)
mp3 (n3 n1 n2 NW) g45p1svt w=(1.56u) l=45n nf=1 m=(1)
mp2 (n2 n0 VDD NW) g45p1svt w=(1.56u) l=45n nf=1 m=(1)
ends NOR4BBX4

// gsclib045_backbias/NOR4BBXL/schematic

simulator lang=spectre

subckt NOR4BBXL AN BN C D Y NW VSS VDD
mn2 (Y n0 VSS VSS) g45n1svt w=(145n) l=45n nf=1 m=(1)
mn1 (n1 BN VSS VSS) g45n1svt w=(145n) l=45n nf=1 m=(1)
mn3 (Y n1 VSS VSS) g45n1svt w=(145n) l=45n nf=1 m=(1)
mn5 (Y D VSS VSS) g45n1svt w=(145n) l=45n nf=1 m=(1)
mn4 (Y C VSS VSS) g45n1svt w=(145n) l=45n nf=1 m=(1)
mn0 (n0 AN VSS VSS) g45n1svt w=(145n) l=45n nf=1 m=(1)
mp0 (n0 AN VDD NW) g45p1svt w=(215n) l=45n nf=1 m=(1)
mp5 (Y D n4 NW) g45p1svt w=(215n) l=45n nf=1 m=(1)
mp4 (n4 C n3 NW) g45p1svt w=(215n) l=45n nf=1 m=(1)
mp1 (n1 BN VDD NW) g45p1svt w=(215n) l=45n nf=1 m=(1)
mp3 (n3 n1 n2 NW) g45p1svt w=(215n) l=45n nf=1 m=(1)
mp2 (n2 n0 VDD NW) g45p1svt w=(215n) l=45n nf=1 m=(1)
ends NOR4BBXL

// gsclib045_backbias/NOR4BX1/schematic

simulator lang=spectre

subckt NOR4BX1 AN B C D Y NW VSS VDD
mn4 (Y D VSS VSS) g45n1svt w=(260n) l=45n nf=1 m=(1)
mn1 (Y n0 VSS VSS) g45n1svt w=(260n) l=45n nf=1 m=(1)
mn3 (Y C VSS VSS) g45n1svt w=(260n) l=45n nf=1 m=(1)
mn0 (n0 AN VSS VSS) g45n1svt w=(145n) l=45n nf=1 m=(1)
mn2 (Y B VSS VSS) g45n1svt w=(260n) l=45n nf=1 m=(1)
mp4 (Y D n3 NW) g45p1svt w=(390n) l=45n nf=1 m=(1)
mp0 (n0 AN VDD NW) g45p1svt w=(215n) l=45n nf=1 m=(1)
mp3 (n3 C n2 NW) g45p1svt w=(390n) l=45n nf=1 m=(1)
mp2 (n2 B n1 NW) g45p1svt w=(390n) l=45n nf=1 m=(1)
mp1 (n1 n0 VDD NW) g45p1svt w=(390n) l=45n nf=1 m=(1)
ends NOR4BX1

// gsclib045_backbias/NOR4BX2/schematic

simulator lang=spectre

subckt NOR4BX2 AN B C D Y NW VDD VSS
mn4 (Y D VSS VSS) g45n1svt w=(520n) l=45n nf=1 m=(1)
mn1 (Y n0 VSS VSS) g45n1svt w=(520n) l=45n nf=1 m=(1)
mn3 (Y C VSS VSS) g45n1svt w=(520n) l=45n nf=1 m=(1)
mn0 (n0 AN VSS VSS) g45n1svt w=(145n) l=45n nf=1 m=(1)
mn2 (Y B VSS VSS) g45n1svt w=(520n) l=45n nf=1 m=(1)
mp4 (Y D n3 NW) g45p1svt w=(780n) l=45n nf=1 m=(1)
mp0 (n0 AN VDD NW) g45p1svt w=(215n) l=45n nf=1 m=(1)
mp3 (n3 C n2 NW) g45p1svt w=(780n) l=45n nf=1 m=(1)
mp2 (n2 B n1 NW) g45p1svt w=(780n) l=45n nf=1 m=(1)
mp1 (n1 n0 VDD NW) g45p1svt w=(780n) l=45n nf=1 m=(1)
ends NOR4BX2

// gsclib045_backbias/NOR4BX4/schematic

simulator lang=spectre

subckt NOR4BX4 AN B C D Y NW VDD VSS
mn4 (Y D VSS VSS) g45n1svt w=(1.04u) l=45n nf=1 m=(1)
mn1 (Y n0 VSS VSS) g45n1svt w=(1.04u) l=45n nf=1 m=(1)
mn3 (Y C VSS VSS) g45n1svt w=(1.04u) l=45n nf=1 m=(1)
mn0 (n0 AN VSS VSS) g45n1svt w=(260n) l=45n nf=1 m=(1)
mn2 (Y B VSS VSS) g45n1svt w=(1.04u) l=45n nf=1 m=(1)
mp4 (Y D n3 NW) g45p1svt w=(1.56u) l=45n nf=1 m=(1)
mp0 (n0 AN VDD NW) g45p1svt w=(390n) l=45n nf=1 m=(1)
mp3 (n3 C n2 NW) g45p1svt w=(1.56u) l=45n nf=1 m=(1)
mp2 (n2 B n1 NW) g45p1svt w=(1.56u) l=45n nf=1 m=(1)
mp1 (n1 n0 VDD NW) g45p1svt w=(1.56u) l=45n nf=1 m=(1)
ends NOR4BX4

// gsclib045_backbias/NOR4BXL/schematic

simulator lang=spectre

subckt NOR4BXL AN B C D Y NW VDD VSS
mn4 (Y D VSS VSS) g45n1svt w=(145n) l=45n nf=1 m=(1)
mn1 (Y n0 VSS VSS) g45n1svt w=(145n) l=45n nf=1 m=(1)
mn3 (Y C VSS VSS) g45n1svt w=(145n) l=45n nf=1 m=(1)
mn0 (n0 AN VSS VSS) g45n1svt w=(145n) l=45n nf=1 m=(1)
mn2 (Y B VSS VSS) g45n1svt w=(145n) l=45n nf=1 m=(1)
mp4 (Y D n3 NW) g45p1svt w=(215n) l=45n nf=1 m=(1)
mp0 (n0 AN VDD NW) g45p1svt w=(215n) l=45n nf=1 m=(1)
mp3 (n3 C n2 NW) g45p1svt w=(215n) l=45n nf=1 m=(1)
mp2 (n2 B n1 NW) g45p1svt w=(215n) l=45n nf=1 m=(1)
mp1 (n1 n0 VDD NW) g45p1svt w=(215n) l=45n nf=1 m=(1)
ends NOR4BXL

// gsclib045_backbias/NOR4X1/schematic

simulator lang=spectre

subckt NOR4X1 A B C D Y NW VSS VDD
mn2 (Y C VSS VSS) g45n1svt w=(260n) l=45n nf=1 m=(1)
mn3 (Y D VSS VSS) g45n1svt w=(260n) l=45n nf=1 m=(1)
mn0 (Y A VSS VSS) g45n1svt w=(260n) l=45n nf=1 m=(1)
mn1 (Y B VSS VSS) g45n1svt w=(260n) l=45n nf=1 m=(1)
mp1 (n1 B n0 NW) g45p1svt w=(390n) l=45n nf=1 m=(1)
mp3 (Y D n2 NW) g45p1svt w=(390n) l=45n nf=1 m=(1)
mp2 (n2 C n1 NW) g45p1svt w=(390n) l=45n nf=1 m=(1)
mp0 (n0 A VDD NW) g45p1svt w=(390n) l=45n nf=1 m=(1)
ends NOR4X1

// gsclib045_backbias/NOR4X2/schematic

simulator lang=spectre

subckt NOR4X2 A B C D Y NW VSS VDD
mn2 (Y C VSS VSS) g45n1svt w=(520n) l=45n nf=1 m=(1)
mn3 (Y D VSS VSS) g45n1svt w=(520n) l=45n nf=1 m=(1)
mn0 (Y A VSS VSS) g45n1svt w=(520n) l=45n nf=1 m=(1)
mn1 (Y B VSS VSS) g45n1svt w=(520n) l=45n nf=1 m=(1)
mp1 (n1 B n0 NW) g45p1svt w=(780n) l=45n nf=1 m=(1)
mp3 (Y D n2 NW) g45p1svt w=(780n) l=45n nf=1 m=(1)
mp2 (n2 C n1 NW) g45p1svt w=(780n) l=45n nf=1 m=(1)
mp0 (n0 A VDD NW) g45p1svt w=(780n) l=45n nf=1 m=(1)
ends NOR4X2

// gsclib045_backbias/NOR4X4/schematic

simulator lang=spectre

subckt NOR4X4 A B C D Y NW VSS VDD
mn2 (Y C VSS VSS) g45n1svt w=(1.04u) l=45n nf=1 m=(1)
mn3 (Y D VSS VSS) g45n1svt w=(1.04u) l=45n nf=1 m=(1)
mn0 (Y A VSS VSS) g45n1svt w=(1.04u) l=45n nf=1 m=(1)
mn1 (Y B VSS VSS) g45n1svt w=(1.04u) l=45n nf=1 m=(1)
mp1 (n1 B n0 NW) g45p1svt w=(1.56u) l=45n nf=1 m=(1)
mp3 (Y D n2 NW) g45p1svt w=(1.56u) l=45n nf=1 m=(1)
mp2 (n2 C n1 NW) g45p1svt w=(1.56u) l=45n nf=1 m=(1)
mp0 (n0 A VDD NW) g45p1svt w=(1.56u) l=45n nf=1 m=(1)
ends NOR4X4

// gsclib045_backbias/NOR4X6/schematic

simulator lang=spectre

subckt NOR4X6 A B C D Y NW VSS VDD
mn2 (Y C VSS VSS) g45n1svt w=(1.55u) l=45n nf=1 m=(1)
mn3 (Y D VSS VSS) g45n1svt w=(1.55u) l=45n nf=1 m=(1)
mn0 (Y A VSS VSS) g45n1svt w=(1.55u) l=45n nf=1 m=(1)
mn1 (Y B VSS VSS) g45n1svt w=(1.55u) l=45n nf=1 m=(1)
mp1 (n1 B n0 NW) g45p1svt w=(2.35u) l=45n nf=1 m=(1)
mp3 (Y D n2 NW) g45p1svt w=(2.35u) l=45n nf=1 m=(1)
mp2 (n2 C n1 NW) g45p1svt w=(2.35u) l=45n nf=1 m=(1)
mp0 (n0 A VDD NW) g45p1svt w=(2.35u) l=45n nf=1 m=(1)
ends NOR4X6

// gsclib045_backbias/NOR4X8/schematic

simulator lang=spectre

subckt NOR4X8 A B C D Y NW VSS VDD
mn2 (Y C VSS VSS) g45n1svt w=(2.065u) l=45n nf=1 m=(1)
mn3 (Y D VSS VSS) g45n1svt w=(2.065u) l=45n nf=1 m=(1)
mn0 (Y A VSS VSS) g45n1svt w=(2.065u) l=45n nf=1 m=(1)
mn1 (Y B VSS VSS) g45n1svt w=(2.065u) l=45n nf=1 m=(1)
mp1 (n1 B n0 NW) g45p1svt w=(3.115u) l=45n nf=1 m=(1)
mp3 (Y D n2 NW) g45p1svt w=(3.115u) l=45n nf=1 m=(1)
mp2 (n2 C n1 NW) g45p1svt w=(3.115u) l=45n nf=1 m=(1)
mp0 (n0 A VDD NW) g45p1svt w=(3.115u) l=45n nf=1 m=(1)
ends NOR4X8

// gsclib045_backbias/NOR4XL/schematic

simulator lang=spectre

subckt NOR4XL A B C D Y NW VSS VDD
mn2 (Y C VSS VSS) g45n1svt w=(145n) l=45n nf=1 m=(1)
mn3 (Y D VSS VSS) g45n1svt w=(145n) l=45n nf=1 m=(1)
mn0 (Y A VSS VSS) g45n1svt w=(145n) l=45n nf=1 m=(1)
mn1 (Y B VSS VSS) g45n1svt w=(145n) l=45n nf=1 m=(1)
mp1 (n1 B n0 NW) g45p1svt w=(215n) l=45n nf=1 m=(1)
mp3 (Y D n2 NW) g45p1svt w=(215n) l=45n nf=1 m=(1)
mp2 (n2 C n1 NW) g45p1svt w=(215n) l=45n nf=1 m=(1)
mp0 (n0 A VDD NW) g45p1svt w=(215n) l=45n nf=1 m=(1)
ends NOR4XL

// gsclib045_backbias/OA21X1/schematic

simulator lang=spectre

subckt OA21X1 A0 A1 B0 Y NW VSS VDD
mn1 (net107 A1 VSS VSS) g45n1svt w=(145n) l=45n nf=1 m=(1)
mn0 (net107 A0 VSS VSS) g45n1svt w=(145n) l=45n nf=1 m=(1)
mn3 (Y net95 VSS VSS) g45n1svt w=(260n) l=45n nf=1 m=(1)
mn2 (net95 B0 net107 VSS) g45n1svt w=(145n) l=45n nf=1 m=(1)
mp1 (net95 A1 net98 NW) g45p1svt w=(215n) l=45n nf=1 m=(1)
mp0 (net98 A0 VDD NW) g45p1svt w=(215n) l=45n nf=1 m=(1)
mp3 (Y net95 VDD NW) g45p1svt w=(390n) l=45n nf=1 m=(1)
mp2 (net95 B0 VDD NW) g45p1svt w=(215n) l=45n nf=1 m=(1)
ends OA21X1

// gsclib045_backbias/OA21X2/schematic

simulator lang=spectre

subckt OA21X2 A0 A1 B0 Y VSS VDD NW
mn1 (net107 A1 VSS VSS) g45n1svt w=(145n) l=45n nf=1 m=(1)
mn0 (net107 A0 VSS VSS) g45n1svt w=(145n) l=45n nf=1 m=(1)
mn3 (Y net95 VSS VSS) g45n1svt w=(520n) l=45n nf=1 m=(1)
mn2 (net95 B0 net107 VSS) g45n1svt w=(145n) l=45n nf=1 m=(1)
mp1 (net95 A1 net98 NW) g45p1svt w=(215n) l=45n nf=1 m=(1)
mp0 (net98 A0 VDD NW) g45p1svt w=(215n) l=45n nf=1 m=(1)
mp3 (Y net95 VDD NW) g45p1svt w=(780n) l=45n nf=1 m=(1)
mp2 (net95 B0 VDD NW) g45p1svt w=(215n) l=45n nf=1 m=(1)
ends OA21X2

// gsclib045_backbias/OA21X4/schematic

simulator lang=spectre

subckt OA21X4 A0 A1 B0 Y VSS VDD NW
mn1 (net107 A1 VSS VSS) g45n1svt w=(260n) l=45n nf=1 m=(1)
mn0 (net107 A0 VSS VSS) g45n1svt w=(260n) l=45n nf=1 m=(1)
mn3 (Y net95 VSS VSS) g45n1svt w=(1.04u) l=45n nf=1 m=(1)
mn2 (net95 B0 net107 VSS) g45n1svt w=(260n) l=45n nf=1 m=(1)
mp1 (net95 A1 net98 NW) g45p1svt w=(390n) l=45n nf=1 m=(1)
mp0 (net98 A0 VDD NW) g45p1svt w=(390n) l=45n nf=1 m=(1)
mp3 (Y net95 VDD NW) g45p1svt w=(1.56u) l=45n nf=1 m=(1)
mp2 (net95 B0 VDD NW) g45p1svt w=(390n) l=45n nf=1 m=(1)
ends OA21X4

// gsclib045_backbias/OA21XL/schematic

simulator lang=spectre

subckt OA21XL A0 A1 B0 Y VSS VDD NW
mn1 (net107 A1 VSS VSS) g45n1svt w=(145n) l=45n nf=1 m=(1)
mn0 (net107 A0 VSS VSS) g45n1svt w=(145n) l=45n nf=1 m=(1)
mn3 (Y net95 VSS VSS) g45n1svt w=(145n) l=45n nf=1 m=(1)
mn2 (net95 B0 net107 VSS) g45n1svt w=(145n) l=45n nf=1 m=(1)
mp1 (net95 A1 net98 NW) g45p1svt w=(215n) l=45n nf=1 m=(1)
mp0 (net98 A0 VDD NW) g45p1svt w=(215n) l=45n nf=1 m=(1)
mp3 (Y net95 VDD NW) g45p1svt w=(215n) l=45n nf=1 m=(1)
mp2 (net95 B0 VDD NW) g45p1svt w=(215n) l=45n nf=1 m=(1)
ends OA21XL

// gsclib045_backbias/OA22X1/schematic

simulator lang=spectre

subckt OA22X1 A0 A1 B0 B1 Y VDD VSS NW
mn3 (net128 B1 net124 VSS) g45n1svt w=(145n) l=45n nf=1 m=(1)
mn2 (net128 B0 net124 VSS) g45n1svt w=(145n) l=45n nf=1 m=(1)
mn1 (net124 A1 VSS VSS) g45n1svt w=(145n) l=45n nf=1 m=(1)
mn0 (net124 A0 VSS VSS) g45n1svt w=(145n) l=45n nf=1 m=(1)
mn4 (Y net128 VSS VSS) g45n1svt w=(260n) l=45n nf=1 m=(1)
mp3 (net128 B1 net115 NW) g45p1svt w=(215n) l=45n nf=1 m=(1)
mp2 (net115 B0 VDD NW) g45p1svt w=(215n) l=45n nf=1 m=(1)
mp1 (net128 A1 net119 NW) g45p1svt w=(215n) l=45n nf=1 m=(1)
mp0 (net119 A0 VDD NW) g45p1svt w=(215n) l=45n nf=1 m=(1)
mp4 (Y net128 VDD NW) g45p1svt w=(390n) l=45n nf=1 m=(1)
ends OA22X1

// gsclib045_backbias/OA22X2/schematic

simulator lang=spectre

subckt OA22X2 A0 A1 B0 B1 Y VSS VDD NW
mn3 (net128 B1 net124 VSS) g45n1svt w=(145n) l=45n nf=1 m=(1)
mn2 (net128 B0 net124 VSS) g45n1svt w=(145n) l=45n nf=1 m=(1)
mn1 (net124 A1 VSS VSS) g45n1svt w=(145n) l=45n nf=1 m=(1)
mn0 (net124 A0 VSS VSS) g45n1svt w=(145n) l=45n nf=1 m=(1)
mn4 (Y net128 VSS VSS) g45n1svt w=(520n) l=45n nf=1 m=(1)
mp3 (net128 B1 net115 NW) g45p1svt w=(215n) l=45n nf=1 m=(1)
mp2 (net115 B0 VDD NW) g45p1svt w=(215n) l=45n nf=1 m=(1)
mp1 (net128 A1 net119 NW) g45p1svt w=(215n) l=45n nf=1 m=(1)
mp0 (net119 A0 VDD NW) g45p1svt w=(215n) l=45n nf=1 m=(1)
mp4 (Y net128 VDD NW) g45p1svt w=(780n) l=45n nf=1 m=(1)
ends OA22X2

// gsclib045_backbias/OA22X4/schematic

simulator lang=spectre

subckt OA22X4 A0 A1 B0 B1 Y VSS VDD NW
mn3 (net128 B1 net124 VSS) g45n1svt w=(260n) l=45n nf=1 m=(1)
mn2 (net128 B0 net124 VSS) g45n1svt w=(260n) l=45n nf=1 m=(1)
mn1 (net124 A1 VSS VSS) g45n1svt w=(260n) l=45n nf=1 m=(1)
mn0 (net124 A0 VSS VSS) g45n1svt w=(260n) l=45n nf=1 m=(1)
mn4 (Y net128 VSS VSS) g45n1svt w=(1.04u) l=45n nf=1 m=(1)
mp3 (net128 B1 net115 NW) g45p1svt w=(390n) l=45n nf=1 m=(1)
mp2 (net115 B0 VDD NW) g45p1svt w=(390n) l=45n nf=1 m=(1)
mp1 (net128 A1 net119 NW) g45p1svt w=(390n) l=45n nf=1 m=(1)
mp0 (net119 A0 VDD NW) g45p1svt w=(390n) l=45n nf=1 m=(1)
mp4 (Y net128 VDD NW) g45p1svt w=(1.56u) l=45n nf=1 m=(1)
ends OA22X4

// gsclib045_backbias/OA22XL/schematic

simulator lang=spectre

subckt OA22XL A0 A1 B0 B1 Y VSS VDD NW
mn3 (net128 B1 net124 VSS) g45n1svt w=(145n) l=45n nf=1 m=(1)
mn2 (net128 B0 net124 VSS) g45n1svt w=(145n) l=45n nf=1 m=(1)
mn1 (net124 A1 VSS VSS) g45n1svt w=(145n) l=45n nf=1 m=(1)
mn0 (net124 A0 VSS VSS) g45n1svt w=(145n) l=45n nf=1 m=(1)
mn4 (Y net128 VSS VSS) g45n1svt w=(145n) l=45n nf=1 m=(1)
mp3 (net128 B1 net115 NW) g45p1svt w=(215n) l=45n nf=1 m=(1)
mp2 (net115 B0 VDD NW) g45p1svt w=(215n) l=45n nf=1 m=(1)
mp1 (net128 A1 net119 NW) g45p1svt w=(215n) l=45n nf=1 m=(1)
mp0 (net119 A0 VDD NW) g45p1svt w=(215n) l=45n nf=1 m=(1)
mp4 (Y net128 VDD NW) g45p1svt w=(215n) l=45n nf=1 m=(1)
ends OA22XL

// gsclib045_backbias/OAI211X1/schematic

simulator lang=spectre

subckt OAI211X1 A0 A1 B0 C0 Y NW VSS VDD
mn1 (n0 A1 VSS VSS) g45n1svt w=(260n) l=45n nf=1 m=(1)
mn0 (n0 A0 VSS VSS) g45n1svt w=(260n) l=45n nf=1 m=(1)
mn2 (n1 B0 n0 VSS) g45n1svt w=(260n) l=45n nf=1 m=(1)
mn3 (Y C0 n1 VSS) g45n1svt w=(260n) l=45n nf=1 m=(1)
mp1 (Y A1 n2 NW) g45p1svt w=(390n) l=45n nf=1 m=(1)
mp0 (n2 A0 VDD NW) g45p1svt w=(390n) l=45n nf=1 m=(1)
mp3 (Y C0 VDD NW) g45p1svt w=(390n) l=45n nf=1 m=(1)
mp2 (Y B0 VDD NW) g45p1svt w=(390n) l=45n nf=1 m=(1)
ends OAI211X1

// gsclib045_backbias/OAI211X2/schematic

simulator lang=spectre

subckt OAI211X2 A0 A1 B0 C0 Y NW VSS VDD
mn1 (n0 A1 VSS VSS) g45n1svt w=(520n) l=45n nf=1 m=(1)
mn0 (n0 A0 VSS VSS) g45n1svt w=(520n) l=45n nf=1 m=(1)
mn2 (n1 B0 n0 VSS) g45n1svt w=(520n) l=45n nf=1 m=(1)
mn3 (Y C0 n1 VSS) g45n1svt w=(520n) l=45n nf=1 m=(1)
mp1 (Y A1 n2 NW) g45p1svt w=(780n) l=45n nf=1 m=(1)
mp0 (n2 A0 VDD NW) g45p1svt w=(780n) l=45n nf=1 m=(1)
mp3 (Y C0 VDD NW) g45p1svt w=(780n) l=45n nf=1 m=(1)
mp2 (Y B0 VDD NW) g45p1svt w=(780n) l=45n nf=1 m=(1)
ends OAI211X2

// gsclib045_backbias/OAI211X4/schematic

simulator lang=spectre

subckt OAI211X4 A0 A1 B0 C0 Y NW VSS VDD
mn1 (n0 A1 VSS VSS) g45n1svt w=(1.04u) l=45n nf=1 m=(1)
mn0 (n0 A0 VSS VSS) g45n1svt w=(1.04u) l=45n nf=1 m=(1)
mn2 (n1 B0 n0 VSS) g45n1svt w=(1.04u) l=45n nf=1 m=(1)
mn3 (Y C0 n1 VSS) g45n1svt w=(1.04u) l=45n nf=1 m=(1)
mp1 (Y A1 n2 NW) g45p1svt w=(1.56u) l=45n nf=1 m=(1)
mp0 (n2 A0 VDD NW) g45p1svt w=(1.56u) l=45n nf=1 m=(1)
mp3 (Y C0 VDD NW) g45p1svt w=(1.56u) l=45n nf=1 m=(1)
mp2 (Y B0 VDD NW) g45p1svt w=(1.56u) l=45n nf=1 m=(1)
ends OAI211X4

// gsclib045_backbias/OAI211XL/schematic

simulator lang=spectre

subckt OAI211XL A0 A1 B0 C0 Y NW VSS VDD
mn1 (n0 A1 VSS VSS) g45n1svt w=(145n) l=45n nf=1 m=(1)
mn0 (n0 A0 VSS VSS) g45n1svt w=(145n) l=45n nf=1 m=(1)
mn2 (n1 B0 n0 VSS) g45n1svt w=(145n) l=45n nf=1 m=(1)
mn3 (Y C0 n1 VSS) g45n1svt w=(145n) l=45n nf=1 m=(1)
mp1 (Y A1 n2 NW) g45p1svt w=(215n) l=45n nf=1 m=(1)
mp0 (n2 A0 VDD NW) g45p1svt w=(215n) l=45n nf=1 m=(1)
mp3 (Y C0 VDD NW) g45p1svt w=(215n) l=45n nf=1 m=(1)
mp2 (Y B0 VDD NW) g45p1svt w=(215n) l=45n nf=1 m=(1)
ends OAI211XL

// gsclib045_backbias/OAI21X1/schematic

simulator lang=spectre

subckt OAI21X1 A0 A1 B0 Y VSS VDD NW
mn2 (Y B0 n0 VSS) g45n1svt w=(260n) l=45n nf=1 m=(1)
mn1 (n0 A1 VSS VSS) g45n1svt w=(260n) l=45n nf=1 m=(1)
mn0 (n0 A0 VSS VSS) g45n1svt w=(260n) l=45n nf=1 m=(1)
mp0 (n1 A0 VDD NW) g45p1svt w=(390n) l=45n nf=1 m=(1)
mp2 (Y B0 VDD NW) g45p1svt w=(390n) l=45n nf=1 m=(1)
mp1 (Y A1 n1 NW) g45p1svt w=(390n) l=45n nf=1 m=(1)
ends OAI21X1

// gsclib045_backbias/OAI21X2/schematic

simulator lang=spectre

subckt OAI21X2 A0 A1 B0 Y NW VSS VDD
mn2 (Y B0 n0 VSS) g45n1svt w=(520n) l=45n nf=1 m=(1)
mn1 (n0 A1 VSS VSS) g45n1svt w=(520n) l=45n nf=1 m=(1)
mn0 (n0 A0 VSS VSS) g45n1svt w=(520n) l=45n nf=1 m=(1)
mp0 (n1 A0 VDD NW) g45p1svt w=(780n) l=45n nf=1 m=(1)
mp2 (Y B0 VDD NW) g45p1svt w=(780n) l=45n nf=1 m=(1)
mp1 (Y A1 n1 NW) g45p1svt w=(780n) l=45n nf=1 m=(1)
ends OAI21X2

// gsclib045_backbias/OAI21X4/schematic

simulator lang=spectre

subckt OAI21X4 A0 A1 B0 Y VDD VSS NW
mn2 (Y B0 n0 VSS) g45n1svt w=(1.04u) l=45n nf=1 m=(1)
mn1 (n0 A1 VSS VSS) g45n1svt w=(1.04u) l=45n nf=1 m=(1)
mn0 (n0 A0 VSS VSS) g45n1svt w=(1.04u) l=45n nf=1 m=(1)
mp0 (n1 A0 VDD NW) g45p1svt w=(1.56u) l=45n nf=1 m=(1)
mp2 (Y B0 VDD NW) g45p1svt w=(1.56u) l=45n nf=1 m=(1)
mp1 (Y A1 n1 NW) g45p1svt w=(1.56u) l=45n nf=1 m=(1)
ends OAI21X4

// gsclib045_backbias/OAI21XL/schematic

simulator lang=spectre

subckt OAI21XL A0 A1 B0 Y VDD VSS NW
mn2 (Y B0 n0 VSS) g45n1svt w=(145n) l=45n nf=1 m=(1)
mn1 (n0 A1 VSS VSS) g45n1svt w=(145n) l=45n nf=1 m=(1)
mn0 (n0 A0 VSS VSS) g45n1svt w=(145n) l=45n nf=1 m=(1)
mp0 (n1 A0 VDD NW) g45p1svt w=(215n) l=45n nf=1 m=(1)
mp2 (Y B0 VDD NW) g45p1svt w=(215n) l=45n nf=1 m=(1)
mp1 (Y A1 n1 NW) g45p1svt w=(215n) l=45n nf=1 m=(1)
ends OAI21XL

// gsclib045_backbias/OAI221X1/schematic

simulator lang=spectre

subckt OAI221X1 A0 A1 B0 B1 C0 Y NW VDD VSS
mn4 (Y C0 net132 VSS) g45n1svt w=(260n) l=45n nf=1 m=(1)
mn0 (net128 A0 VSS VSS) g45n1svt w=(260n) l=45n nf=1 m=(1)
mn1 (net128 A1 VSS VSS) g45n1svt w=(260n) l=45n nf=1 m=(1)
mn2 (net132 B0 net128 VSS) g45n1svt w=(260n) l=45n nf=1 m=(1)
mn3 (net132 B1 net128 VSS) g45n1svt w=(260n) l=45n nf=1 m=(1)
mp3 (Y B1 net123 NW) g45p1svt w=(390n) l=45n nf=1 m=(1)
mp0 (net115 A0 VDD NW) g45p1svt w=(390n) l=45n nf=1 m=(1)
mp1 (Y A1 net115 NW) g45p1svt w=(390n) l=45n nf=1 m=(1)
mp2 (net123 B0 VDD NW) g45p1svt w=(390n) l=45n nf=1 m=(1)
mp4 (Y C0 VDD NW) g45p1svt w=(390n) l=45n nf=1 m=(1)
ends OAI221X1

// gsclib045_backbias/OAI221X2/schematic

simulator lang=spectre

subckt OAI221X2 A0 A1 B0 B1 C0 Y NW VSS VDD
mn4 (Y C0 net132 VSS) g45n1svt w=(520n) l=45n nf=1 m=(1)
mn0 (net128 A0 VSS VSS) g45n1svt w=(520n) l=45n nf=1 m=(1)
mn1 (net128 A1 VSS VSS) g45n1svt w=(520n) l=45n nf=1 m=(1)
mn2 (net132 B0 net128 VSS) g45n1svt w=(520n) l=45n nf=1 m=(1)
mn3 (net132 B1 net128 VSS) g45n1svt w=(520n) l=45n nf=1 m=(1)
mp3 (Y B1 net123 NW) g45p1svt w=(780n) l=45n nf=1 m=(1)
mp0 (net115 A0 VDD NW) g45p1svt w=(780n) l=45n nf=1 m=(1)
mp1 (Y A1 net115 NW) g45p1svt w=(780n) l=45n nf=1 m=(1)
mp2 (net123 B0 VDD NW) g45p1svt w=(780n) l=45n nf=1 m=(1)
mp4 (Y C0 VDD NW) g45p1svt w=(780n) l=45n nf=1 m=(1)
ends OAI221X2

// gsclib045_backbias/OAI221X4/schematic

simulator lang=spectre

subckt OAI221X4 A0 A1 B0 B1 C0 Y NW VSS VDD
mn4 (Y C0 net132 VSS) g45n1svt w=(1.04u) l=45n nf=1 m=(1)
mn0 (net128 A0 VSS VSS) g45n1svt w=(1.04u) l=45n nf=1 m=(1)
mn1 (net128 A1 VSS VSS) g45n1svt w=(1.04u) l=45n nf=1 m=(1)
mn2 (net132 B0 net128 VSS) g45n1svt w=(1.04u) l=45n nf=1 m=(1)
mn3 (net132 B1 net128 VSS) g45n1svt w=(1.04u) l=45n nf=1 m=(1)
mp3 (Y B1 net123 NW) g45p1svt w=(1.56u) l=45n nf=1 m=(1)
mp0 (net115 A0 VDD NW) g45p1svt w=(1.56u) l=45n nf=1 m=(1)
mp1 (Y A1 net115 NW) g45p1svt w=(1.56u) l=45n nf=1 m=(1)
mp2 (net123 B0 VDD NW) g45p1svt w=(1.56u) l=45n nf=1 m=(1)
mp4 (Y C0 VDD NW) g45p1svt w=(1.56u) l=45n nf=1 m=(1)
ends OAI221X4

// gsclib045_backbias/OAI221XL/schematic

simulator lang=spectre

subckt OAI221XL A0 A1 B0 B1 C0 Y NW VSS VDD
mn4 (Y C0 net132 VSS) g45n1svt w=(145n) l=45n nf=1 m=(1)
mn0 (net128 A0 VSS VSS) g45n1svt w=(145n) l=45n nf=1 m=(1)
mn1 (net128 A1 VSS VSS) g45n1svt w=(145n) l=45n nf=1 m=(1)
mn2 (net132 B0 net128 VSS) g45n1svt w=(145n) l=45n nf=1 m=(1)
mn3 (net132 B1 net128 VSS) g45n1svt w=(145n) l=45n nf=1 m=(1)
mp3 (Y B1 net123 NW) g45p1svt w=(215n) l=45n nf=1 m=(1)
mp0 (net115 A0 VDD NW) g45p1svt w=(215n) l=45n nf=1 m=(1)
mp1 (Y A1 net115 NW) g45p1svt w=(215n) l=45n nf=1 m=(1)
mp2 (net123 B0 VDD NW) g45p1svt w=(215n) l=45n nf=1 m=(1)
mp4 (Y C0 VDD NW) g45p1svt w=(215n) l=45n nf=1 m=(1)
ends OAI221XL

// gsclib045_backbias/OAI222X1/schematic

simulator lang=spectre

subckt OAI222X1 A0 A1 B0 B1 C0 C1 Y NW VDD VSS
mn5 (Y C1 n0 VSS) g45n1svt w=(260n) l=45n nf=1 m=(1)
mn4 (Y C0 n0 VSS) g45n1svt w=(260n) l=45n nf=1 m=(1)
mn3 (n0 B1 n1 VSS) g45n1svt w=(260n) l=45n nf=1 m=(1)
mn2 (n0 B0 n1 VSS) g45n1svt w=(260n) l=45n nf=1 m=(1)
mn0 (n1 A0 VSS VSS) g45n1svt w=(260n) l=45n nf=1 m=(1)
mn1 (n1 A1 VSS VSS) g45n1svt w=(260n) l=45n nf=1 m=(1)
mp5 (Y C1 n4 NW) g45p1svt w=(390n) l=45n nf=1 m=(1)
mp4 (n4 C0 VDD NW) g45p1svt w=(390n) l=45n nf=1 m=(1)
mp3 (Y B1 n3 NW) g45p1svt w=(390n) l=45n nf=1 m=(1)
mp2 (n3 B0 VDD NW) g45p1svt w=(390n) l=45n nf=1 m=(1)
mp1 (Y A1 n2 NW) g45p1svt w=(390n) l=45n nf=1 m=(1)
mp0 (n2 A0 VDD NW) g45p1svt w=(390n) l=45n nf=1 m=(1)
ends OAI222X1

// gsclib045_backbias/OAI222X2/schematic

simulator lang=spectre

subckt OAI222X2 A0 A1 B0 B1 C0 C1 Y VSS VDD NW
mn5 (Y C1 n0 VSS) g45n1svt w=(520n) l=45n nf=1 m=(1)
mn4 (Y C0 n0 VSS) g45n1svt w=(520n) l=45n nf=1 m=(1)
mn3 (n0 B1 n1 VSS) g45n1svt w=(520n) l=45n nf=1 m=(1)
mn2 (n0 B0 n1 VSS) g45n1svt w=(520n) l=45n nf=1 m=(1)
mn0 (n1 A0 VSS VSS) g45n1svt w=(520n) l=45n nf=1 m=(1)
mn1 (n1 A1 VSS VSS) g45n1svt w=(520n) l=45n nf=1 m=(1)
mp5 (Y C1 n4 NW) g45p1svt w=(780n) l=45n nf=1 m=(1)
mp4 (n4 C0 VDD NW) g45p1svt w=(780n) l=45n nf=1 m=(1)
mp3 (Y B1 n3 NW) g45p1svt w=(780n) l=45n nf=1 m=(1)
mp2 (n3 B0 VDD NW) g45p1svt w=(780n) l=45n nf=1 m=(1)
mp1 (Y A1 n2 NW) g45p1svt w=(780n) l=45n nf=1 m=(1)
mp0 (n2 A0 VDD NW) g45p1svt w=(780n) l=45n nf=1 m=(1)
ends OAI222X2

// gsclib045_backbias/OAI222X4/schematic

simulator lang=spectre

subckt OAI222X4 A0 A1 B0 B1 C0 C1 Y VSS VDD NW
mn5 (Y C1 n0 VSS) g45n1svt w=(1.04u) l=45n nf=1 m=(1)
mn4 (Y C0 n0 VSS) g45n1svt w=(1.04u) l=45n nf=1 m=(1)
mn3 (n0 B1 n1 VSS) g45n1svt w=(1.04u) l=45n nf=1 m=(1)
mn2 (n0 B0 n1 VSS) g45n1svt w=(1.04u) l=45n nf=1 m=(1)
mn0 (n1 A0 VSS VSS) g45n1svt w=(1.04u) l=45n nf=1 m=(1)
mn1 (n1 A1 VSS VSS) g45n1svt w=(1.04u) l=45n nf=1 m=(1)
mp5 (Y C1 n4 NW) g45p1svt w=(1.56u) l=45n nf=1 m=(1)
mp4 (n4 C0 VDD NW) g45p1svt w=(1.56u) l=45n nf=1 m=(1)
mp3 (Y B1 n3 NW) g45p1svt w=(1.56u) l=45n nf=1 m=(1)
mp2 (n3 B0 VDD NW) g45p1svt w=(1.56u) l=45n nf=1 m=(1)
mp1 (Y A1 n2 NW) g45p1svt w=(1.56u) l=45n nf=1 m=(1)
mp0 (n2 A0 VDD NW) g45p1svt w=(1.56u) l=45n nf=1 m=(1)
ends OAI222X4

// gsclib045_backbias/OAI222XL/schematic

simulator lang=spectre

subckt OAI222XL A0 A1 B0 B1 C0 C1 Y VSS VDD NW
mn5 (Y C1 n0 VSS) g45n1svt w=(145n) l=45n nf=1 m=(1)
mn4 (Y C0 n0 VSS) g45n1svt w=(145n) l=45n nf=1 m=(1)
mn3 (n0 B1 n1 VSS) g45n1svt w=(145n) l=45n nf=1 m=(1)
mn2 (n0 B0 n1 VSS) g45n1svt w=(145n) l=45n nf=1 m=(1)
mn0 (n1 A0 VSS VSS) g45n1svt w=(145n) l=45n nf=1 m=(1)
mn1 (n1 A1 VSS VSS) g45n1svt w=(145n) l=45n nf=1 m=(1)
mp5 (Y C1 n4 NW) g45p1svt w=(215n) l=45n nf=1 m=(1)
mp4 (n4 C0 VDD NW) g45p1svt w=(215n) l=45n nf=1 m=(1)
mp3 (Y B1 n3 NW) g45p1svt w=(215n) l=45n nf=1 m=(1)
mp2 (n3 B0 VDD NW) g45p1svt w=(215n) l=45n nf=1 m=(1)
mp1 (Y A1 n2 NW) g45p1svt w=(215n) l=45n nf=1 m=(1)
mp0 (n2 A0 VDD NW) g45p1svt w=(215n) l=45n nf=1 m=(1)
ends OAI222XL

// gsclib045_backbias/OAI22X1/schematic

simulator lang=spectre

subckt OAI22X1 A0 A1 B0 B1 Y VDD VSS NW
mn0 (net102 A0 VSS VSS) g45n1svt w=(260n) l=45n nf=1 m=(1)
mn3 (Y B1 net102 VSS) g45n1svt w=(260n) l=45n nf=1 m=(1)
mn1 (net102 A1 VSS VSS) g45n1svt w=(260n) l=45n nf=1 m=(1)
mn2 (Y B0 net102 VSS) g45n1svt w=(260n) l=45n nf=1 m=(1)
mp3 (Y B1 net85 NW) g45p1svt w=(390n) l=45n nf=1 m=(1)
mp1 (Y A1 net93 NW) g45p1svt w=(390n) l=45n nf=1 m=(1)
mp0 (net93 A0 VDD NW) g45p1svt w=(390n) l=45n nf=1 m=(1)
mp2 (net85 B0 VDD NW) g45p1svt w=(390n) l=45n nf=1 m=(1)
ends OAI22X1

// gsclib045_backbias/OAI22X2/schematic

simulator lang=spectre

subckt OAI22X2 A0 A1 B0 B1 Y NW VDD VSS
mn0 (net102 A0 VSS VSS) g45n1svt w=(520n) l=45n nf=1 m=(1)
mn3 (Y B1 net102 VSS) g45n1svt w=(520n) l=45n nf=1 m=(1)
mn1 (net102 A1 VSS VSS) g45n1svt w=(520n) l=45n nf=1 m=(1)
mn2 (Y B0 net102 VSS) g45n1svt w=(520n) l=45n nf=1 m=(1)
mp3 (Y B1 net85 NW) g45p1svt w=(780n) l=45n nf=1 m=(1)
mp1 (Y A1 net93 NW) g45p1svt w=(780n) l=45n nf=1 m=(1)
mp0 (net93 A0 VDD NW) g45p1svt w=(780n) l=45n nf=1 m=(1)
mp2 (net85 B0 VDD NW) g45p1svt w=(780n) l=45n nf=1 m=(1)
ends OAI22X2

// gsclib045_backbias/OAI22X4/schematic

simulator lang=spectre

subckt OAI22X4 A0 A1 B0 B1 Y NW VDD VSS
mn0 (net102 A0 VSS VSS) g45n1svt w=(1.04u) l=45n nf=1 m=(1)
mn3 (Y B1 net102 VSS) g45n1svt w=(1.04u) l=45n nf=1 m=(1)
mn1 (net102 A1 VSS VSS) g45n1svt w=(1.04u) l=45n nf=1 m=(1)
mn2 (Y B0 net102 VSS) g45n1svt w=(1.04u) l=45n nf=1 m=(1)
mp3 (Y B1 net85 NW) g45p1svt w=(1.56u) l=45n nf=1 m=(1)
mp1 (Y A1 net93 NW) g45p1svt w=(1.56u) l=45n nf=1 m=(1)
mp0 (net93 A0 VDD NW) g45p1svt w=(1.56u) l=45n nf=1 m=(1)
mp2 (net85 B0 VDD NW) g45p1svt w=(1.56u) l=45n nf=1 m=(1)
ends OAI22X4

// gsclib045_backbias/OAI22XL/schematic

simulator lang=spectre

subckt OAI22XL A0 A1 B0 B1 Y NW VDD VSS
mn0 (net102 A0 VSS VSS) g45n1svt w=(145n) l=45n nf=1 m=(1)
mn3 (Y B1 net102 VSS) g45n1svt w=(145n) l=45n nf=1 m=(1)
mn1 (net102 A1 VSS VSS) g45n1svt w=(145n) l=45n nf=1 m=(1)
mn2 (Y B0 net102 VSS) g45n1svt w=(145n) l=45n nf=1 m=(1)
mp3 (Y B1 net85 NW) g45p1svt w=(215n) l=45n nf=1 m=(1)
mp1 (Y A1 net93 NW) g45p1svt w=(215n) l=45n nf=1 m=(1)
mp0 (net93 A0 VDD NW) g45p1svt w=(215n) l=45n nf=1 m=(1)
mp2 (net85 B0 VDD NW) g45p1svt w=(215n) l=45n nf=1 m=(1)
ends OAI22XL

// gsclib045_backbias/OAI2BB1X1/schematic

simulator lang=spectre

subckt OAI2BB1X1 A0N A1N B0 Y NW VDD VSS
mn3 (Y n0 n2 VSS) g45n1svt w=(260n) l=45n nf=1 m=(1)
mn2 (n2 B0 VSS VSS) g45n1svt w=(260n) l=45n nf=1 m=(1)
mn0 (n1 A0N VSS VSS) g45n1svt w=(145n) l=45n nf=1 m=(1)
mn1 (n0 A1N n1 VSS) g45n1svt w=(145n) l=45n nf=1 m=(1)
mp2 (Y B0 VDD NW) g45p1svt w=(390n) l=45n nf=1 m=(1)
mp1 (n0 A1N VDD NW) g45p1svt w=(215n) l=45n nf=1 m=(1)
mp0 (n0 A0N VDD NW) g45p1svt w=(215n) l=45n nf=1 m=(1)
mp3 (Y n0 VDD NW) g45p1svt w=(390n) l=45n nf=1 m=(1)
ends OAI2BB1X1

// gsclib045_backbias/OAI2BB1X2/schematic

simulator lang=spectre

subckt OAI2BB1X2 A0N A1N B0 Y NW VSS VDD
mn3 (Y n0 n2 VSS) g45n1svt w=(520n) l=45n nf=1 m=(1)
mn2 (n2 B0 VSS VSS) g45n1svt w=(520n) l=45n nf=1 m=(1)
mn0 (n1 A0N VSS VSS) g45n1svt w=(145n) l=45n nf=1 m=(1)
mn1 (n0 A1N n1 VSS) g45n1svt w=(145n) l=45n nf=1 m=(1)
mp2 (Y B0 VDD NW) g45p1svt w=(780n) l=45n nf=1 m=(1)
mp1 (n0 A1N VDD NW) g45p1svt w=(215n) l=45n nf=1 m=(1)
mp0 (n0 A0N VDD NW) g45p1svt w=(215n) l=45n nf=1 m=(1)
mp3 (Y n0 VDD NW) g45p1svt w=(780n) l=45n nf=1 m=(1)
ends OAI2BB1X2

// gsclib045_backbias/OAI2BB1X4/schematic

simulator lang=spectre

subckt OAI2BB1X4 A0N A1N B0 Y NW VSS VDD
mn3 (Y n0 n2 VSS) g45n1svt w=(1.04u) l=45n nf=1 m=(1)
mn2 (n2 B0 VSS VSS) g45n1svt w=(1.04u) l=45n nf=1 m=(1)
mn0 (n1 A0N VSS VSS) g45n1svt w=(260n) l=45n nf=1 m=(1)
mn1 (n0 A1N n1 VSS) g45n1svt w=(260n) l=45n nf=1 m=(1)
mp2 (Y B0 VDD NW) g45p1svt w=(1.56u) l=45n nf=1 m=(1)
mp1 (n0 A1N VDD NW) g45p1svt w=(390n) l=45n nf=1 m=(1)
mp0 (n0 A0N VDD NW) g45p1svt w=(390n) l=45n nf=1 m=(1)
mp3 (Y n0 VDD NW) g45p1svt w=(1.56u) l=45n nf=1 m=(1)
ends OAI2BB1X4

// gsclib045_backbias/OAI2BB1XL/schematic

simulator lang=spectre

subckt OAI2BB1XL A0N A1N B0 Y NW VSS VDD
mn3 (Y n0 n2 VSS) g45n1svt w=(145n) l=45n nf=1 m=(1)
mn2 (n2 B0 VSS VSS) g45n1svt w=(145n) l=45n nf=1 m=(1)
mn0 (n1 A0N VSS VSS) g45n1svt w=(145n) l=45n nf=1 m=(1)
mn1 (n0 A1N n1 VSS) g45n1svt w=(145n) l=45n nf=1 m=(1)
mp2 (Y B0 VDD NW) g45p1svt w=(215n) l=45n nf=1 m=(1)
mp1 (n0 A1N VDD NW) g45p1svt w=(215n) l=45n nf=1 m=(1)
mp0 (n0 A0N VDD NW) g45p1svt w=(215n) l=45n nf=1 m=(1)
mp3 (Y n0 VDD NW) g45p1svt w=(215n) l=45n nf=1 m=(1)
ends OAI2BB1XL

// gsclib045_backbias/OAI2BB2X1/schematic

simulator lang=spectre

subckt OAI2BB2X1 A0N A1N B0 B1 Y VDD NW VSS
mn5 (Y B1 n4 VSS) g45n1svt w=(260n) l=45n nf=1 m=(1)
mn4 (Y B0 n4 VSS) g45n1svt w=(260n) l=45n nf=1 m=(1)
mn2 (n4 n0 VSS VSS) g45n1svt w=(260n) l=45n nf=1 m=(1)
mn0 (n0 A0N VSS VSS) g45n1svt w=(145n) l=45n nf=1 m=(1)
mn1 (n1 A1N VSS VSS) g45n1svt w=(145n) l=45n nf=1 m=(1)
mn3 (n4 n1 VSS VSS) g45n1svt w=(260n) l=45n nf=1 m=(1)
mp5 (Y B1 n3 NW) g45p1svt w=(390n) l=45n nf=1 m=(1)
mp4 (n3 B0 VDD NW) g45p1svt w=(390n) l=45n nf=1 m=(1)
mp0 (n0 A0N VDD NW) g45p1svt w=(215n) l=45n nf=1 m=(1)
mp2 (n2 n0 VDD NW) g45p1svt w=(390n) l=45n nf=1 m=(1)
mp1 (n1 A1N VDD NW) g45p1svt w=(215n) l=45n nf=1 m=(1)
mp3 (Y n1 n2 NW) g45p1svt w=(390n) l=45n nf=1 m=(1)
ends OAI2BB2X1

// gsclib045_backbias/OAI2BB2X2/schematic

simulator lang=spectre

subckt OAI2BB2X2 A0N A1N B0 B1 Y VDD NW VSS
mn5 (Y B1 n4 VSS) g45n1svt w=(520n) l=45n nf=1 m=(1)
mn4 (Y B0 n4 VSS) g45n1svt w=(520n) l=45n nf=1 m=(1)
mn2 (n4 n0 VSS VSS) g45n1svt w=(520n) l=45n nf=1 m=(1)
mn0 (n0 A0N VSS VSS) g45n1svt w=(145n) l=45n nf=1 m=(1)
mn1 (n1 A1N VSS VSS) g45n1svt w=(145n) l=45n nf=1 m=(1)
mn3 (n4 n1 VSS VSS) g45n1svt w=(520n) l=45n nf=1 m=(1)
mp5 (Y B1 n3 NW) g45p1svt w=(780n) l=45n nf=1 m=(1)
mp4 (n3 B0 VDD NW) g45p1svt w=(780n) l=45n nf=1 m=(1)
mp0 (n0 A0N VDD NW) g45p1svt w=(215n) l=45n nf=1 m=(1)
mp2 (n2 n0 VDD NW) g45p1svt w=(780n) l=45n nf=1 m=(1)
mp1 (n1 A1N VDD NW) g45p1svt w=(215n) l=45n nf=1 m=(1)
mp3 (Y n1 n2 NW) g45p1svt w=(780n) l=45n nf=1 m=(1)
ends OAI2BB2X2

// gsclib045_backbias/OAI2BB2X4/schematic

simulator lang=spectre

subckt OAI2BB2X4 A0N A1N B0 B1 Y VDD NW VSS
mn5 (Y B1 n4 VSS) g45n1svt w=(1.04u) l=45n nf=1 m=(1)
mn4 (Y B0 n4 VSS) g45n1svt w=(1.04u) l=45n nf=1 m=(1)
mn2 (n4 n0 VSS VSS) g45n1svt w=(1.04u) l=45n nf=1 m=(1)
mn0 (n0 A0N VSS VSS) g45n1svt w=(260n) l=45n nf=1 m=(1)
mn1 (n1 A1N VSS VSS) g45n1svt w=(260n) l=45n nf=1 m=(1)
mn3 (n4 n1 VSS VSS) g45n1svt w=(1.04u) l=45n nf=1 m=(1)
mp5 (Y B1 n3 NW) g45p1svt w=(1.56u) l=45n nf=1 m=(1)
mp4 (n3 B0 VDD NW) g45p1svt w=(1.56u) l=45n nf=1 m=(1)
mp0 (n0 A0N VDD NW) g45p1svt w=(390n) l=45n nf=1 m=(1)
mp2 (n2 n0 VDD NW) g45p1svt w=(1.56u) l=45n nf=1 m=(1)
mp1 (n1 A1N VDD NW) g45p1svt w=(390n) l=45n nf=1 m=(1)
mp3 (Y n1 n2 NW) g45p1svt w=(1.56u) l=45n nf=1 m=(1)
ends OAI2BB2X4

// gsclib045_backbias/OAI2BB2XL/schematic

simulator lang=spectre

subckt OAI2BB2XL A0N A1N B0 B1 Y VDD NW VSS
mn5 (Y B1 n4 VSS) g45n1svt w=(145n) l=45n nf=1 m=(1)
mn4 (Y B0 n4 VSS) g45n1svt w=(145n) l=45n nf=1 m=(1)
mn2 (n4 n0 VSS VSS) g45n1svt w=(145n) l=45n nf=1 m=(1)
mn0 (n0 A0N VSS VSS) g45n1svt w=(145n) l=45n nf=1 m=(1)
mn1 (n1 A1N VSS VSS) g45n1svt w=(145n) l=45n nf=1 m=(1)
mn3 (n4 n1 VSS VSS) g45n1svt w=(145n) l=45n nf=1 m=(1)
mp5 (Y B1 n3 NW) g45p1svt w=(215n) l=45n nf=1 m=(1)
mp4 (n3 B0 VDD NW) g45p1svt w=(215n) l=45n nf=1 m=(1)
mp0 (n0 A0N VDD NW) g45p1svt w=(215n) l=45n nf=1 m=(1)
mp2 (n2 n0 VDD NW) g45p1svt w=(215n) l=45n nf=1 m=(1)
mp1 (n1 A1N VDD NW) g45p1svt w=(215n) l=45n nf=1 m=(1)
mp3 (Y n1 n2 NW) g45p1svt w=(215n) l=45n nf=1 m=(1)
ends OAI2BB2XL

// gsclib045_backbias/OAI31X1/schematic

simulator lang=spectre

subckt OAI31X1 A0 A1 A2 B0 Y NW VSS VDD
mn3 (Y B0 n0 VSS) g45n1svt w=(260n) l=45n nf=1 m=(1)
mn0 (n0 A0 VSS VSS) g45n1svt w=(260n) l=45n nf=1 m=(1)
mn2 (n0 A2 VSS VSS) g45n1svt w=(260n) l=45n nf=1 m=(1)
mn1 (n0 A1 VSS VSS) g45n1svt w=(260n) l=45n nf=1 m=(1)
mp2 (Y A2 n2 NW) g45p1svt w=(390n) l=45n nf=1 m=(1)
mp1 (n2 A1 n1 NW) g45p1svt w=(390n) l=45n nf=1 m=(1)
mp3 (Y B0 VDD NW) g45p1svt w=(390n) l=45n nf=1 m=(1)
mp0 (n1 A0 VDD NW) g45p1svt w=(390n) l=45n nf=1 m=(1)
ends OAI31X1

// gsclib045_backbias/OAI31X2/schematic

simulator lang=spectre

subckt OAI31X2 A0 A1 A2 B0 Y NW VSS VDD
mn3 (Y B0 n0 VSS) g45n1svt w=(520n) l=45n nf=1 m=(1)
mn0 (n0 A0 VSS VSS) g45n1svt w=(520n) l=45n nf=1 m=(1)
mn2 (n0 A2 VSS VSS) g45n1svt w=(520n) l=45n nf=1 m=(1)
mn1 (n0 A1 VSS VSS) g45n1svt w=(520n) l=45n nf=1 m=(1)
mp2 (Y A2 n2 NW) g45p1svt w=(780n) l=45n nf=1 m=(1)
mp1 (n2 A1 n1 NW) g45p1svt w=(780n) l=45n nf=1 m=(1)
mp3 (Y B0 VDD NW) g45p1svt w=(780n) l=45n nf=1 m=(1)
mp0 (n1 A0 VDD NW) g45p1svt w=(780n) l=45n nf=1 m=(1)
ends OAI31X2

// gsclib045_backbias/OAI31X4/schematic

simulator lang=spectre

subckt OAI31X4 A0 A1 A2 B0 Y NW VSS VDD
mn3 (Y B0 n0 VSS) g45n1svt w=(1.04u) l=45n nf=1 m=(1)
mn0 (n0 A0 VSS VSS) g45n1svt w=(1.04u) l=45n nf=1 m=(1)
mn2 (n0 A2 VSS VSS) g45n1svt w=(1.04u) l=45n nf=1 m=(1)
mn1 (n0 A1 VSS VSS) g45n1svt w=(1.04u) l=45n nf=1 m=(1)
mp2 (Y A2 n2 NW) g45p1svt w=(1.56u) l=45n nf=1 m=(1)
mp1 (n2 A1 n1 NW) g45p1svt w=(1.56u) l=45n nf=1 m=(1)
mp3 (Y B0 VDD NW) g45p1svt w=(1.56u) l=45n nf=1 m=(1)
mp0 (n1 A0 VDD NW) g45p1svt w=(1.56u) l=45n nf=1 m=(1)
ends OAI31X4

// gsclib045_backbias/OAI31XL/schematic

simulator lang=spectre

subckt OAI31XL A0 A1 A2 B0 Y NW VSS VDD
mn3 (Y B0 n0 VSS) g45n1svt w=(145n) l=45n nf=1 m=(1)
mn0 (n0 A0 VSS VSS) g45n1svt w=(145n) l=45n nf=1 m=(1)
mn2 (n0 A2 VSS VSS) g45n1svt w=(145n) l=45n nf=1 m=(1)
mn1 (n0 A1 VSS VSS) g45n1svt w=(145n) l=45n nf=1 m=(1)
mp2 (Y A2 n2 NW) g45p1svt w=(215n) l=45n nf=1 m=(1)
mp1 (n2 A1 n1 NW) g45p1svt w=(215n) l=45n nf=1 m=(1)
mp3 (Y B0 VDD NW) g45p1svt w=(215n) l=45n nf=1 m=(1)
mp0 (n1 A0 VDD NW) g45p1svt w=(215n) l=45n nf=1 m=(1)
ends OAI31XL

// gsclib045_backbias/OAI32X1/schematic

simulator lang=spectre

subckt OAI32X1 A0 A1 A2 B0 B1 Y NW VSS VDD
mn3 (Y B0 n0 VSS) g45n1svt w=(260n) l=45n nf=1 m=(1)
mn4 (Y B1 n0 VSS) g45n1svt w=(260n) l=45n nf=1 m=(1)
mn2 (n0 A2 VSS VSS) g45n1svt w=(260n) l=45n nf=1 m=(1)
mn0 (n0 A0 VSS VSS) g45n1svt w=(260n) l=45n nf=1 m=(1)
mn1 (n0 A1 VSS VSS) g45n1svt w=(260n) l=45n nf=1 m=(1)
mp2 (Y A2 n2 NW) g45p1svt w=(390n) l=45n nf=1 m=(1)
mp3 (n4 B0 VDD NW) g45p1svt w=(390n) l=45n nf=1 m=(1)
mp0 (n1 A0 VDD NW) g45p1svt w=(390n) l=45n nf=1 m=(1)
mp4 (Y B1 n4 NW) g45p1svt w=(390n) l=45n nf=1 m=(1)
mp1 (n2 A1 n1 NW) g45p1svt w=(390n) l=45n nf=1 m=(1)
ends OAI32X1

// gsclib045_backbias/OAI32X2/schematic

simulator lang=spectre

subckt OAI32X2 A0 A1 A2 B0 B1 Y NW VDD VSS
mn3 (Y B0 n0 VSS) g45n1svt w=(520n) l=45n nf=1 m=(1)
mn4 (Y B1 n0 VSS) g45n1svt w=(520n) l=45n nf=1 m=(1)
mn2 (n0 A2 VSS VSS) g45n1svt w=(520n) l=45n nf=1 m=(1)
mn0 (n0 A0 VSS VSS) g45n1svt w=(520n) l=45n nf=1 m=(1)
mn1 (n0 A1 VSS VSS) g45n1svt w=(520n) l=45n nf=1 m=(1)
mp2 (Y A2 n2 NW) g45p1svt w=(780n) l=45n nf=1 m=(1)
mp3 (n4 B0 VDD NW) g45p1svt w=(780n) l=45n nf=1 m=(1)
mp0 (n1 A0 VDD NW) g45p1svt w=(780n) l=45n nf=1 m=(1)
mp4 (Y B1 n4 NW) g45p1svt w=(780n) l=45n nf=1 m=(1)
mp1 (n2 A1 n1 NW) g45p1svt w=(780n) l=45n nf=1 m=(1)
ends OAI32X2

// gsclib045_backbias/OAI32X4/schematic

simulator lang=spectre

subckt OAI32X4 A0 A1 A2 B0 B1 Y NW VDD VSS
mn3 (Y B0 n0 VSS) g45n1svt w=(1.04u) l=45n nf=1 m=(1)
mn4 (Y B1 n0 VSS) g45n1svt w=(1.04u) l=45n nf=1 m=(1)
mn2 (n0 A2 VSS VSS) g45n1svt w=(1.04u) l=45n nf=1 m=(1)
mn0 (n0 A0 VSS VSS) g45n1svt w=(1.04u) l=45n nf=1 m=(1)
mn1 (n0 A1 VSS VSS) g45n1svt w=(1.04u) l=45n nf=1 m=(1)
mp2 (Y A2 n2 NW) g45p1svt w=(1.56u) l=45n nf=1 m=(1)
mp3 (n4 B0 VDD NW) g45p1svt w=(1.56u) l=45n nf=1 m=(1)
mp0 (n1 A0 VDD NW) g45p1svt w=(1.56u) l=45n nf=1 m=(1)
mp4 (Y B1 n4 NW) g45p1svt w=(1.56u) l=45n nf=1 m=(1)
mp1 (n2 A1 n1 NW) g45p1svt w=(1.56u) l=45n nf=1 m=(1)
ends OAI32X4

// gsclib045_backbias/OAI32XL/schematic

simulator lang=spectre

subckt OAI32XL A0 A1 A2 B0 B1 Y NW VDD VSS
mn3 (Y B0 n0 VSS) g45n1svt w=(145n) l=45n nf=1 m=(1)
mn4 (Y B1 n0 VSS) g45n1svt w=(145n) l=45n nf=1 m=(1)
mn2 (n0 A2 VSS VSS) g45n1svt w=(145n) l=45n nf=1 m=(1)
mn0 (n0 A0 VSS VSS) g45n1svt w=(145n) l=45n nf=1 m=(1)
mn1 (n0 A1 VSS VSS) g45n1svt w=(145n) l=45n nf=1 m=(1)
mp2 (Y A2 n2 NW) g45p1svt w=(215n) l=45n nf=1 m=(1)
mp3 (n4 B0 VDD NW) g45p1svt w=(215n) l=45n nf=1 m=(1)
mp0 (n1 A0 VDD NW) g45p1svt w=(215n) l=45n nf=1 m=(1)
mp4 (Y B1 n4 NW) g45p1svt w=(215n) l=45n nf=1 m=(1)
mp1 (n2 A1 n1 NW) g45p1svt w=(215n) l=45n nf=1 m=(1)
ends OAI32XL

// gsclib045_backbias/OAI33X1/schematic

simulator lang=spectre

subckt OAI33X1 A0 A1 A2 B0 B1 B2 Y NW VSS VDD
mn0 (no A0 VSS VSS) g45n1svt w=(260n) l=45n nf=1 m=(1)
mn4 (Y B0 no VSS) g45n1svt w=(260n) l=45n nf=1 m=(1)
mn3 (Y B1 no VSS) g45n1svt w=(260n) l=45n nf=1 m=(1)
mn1 (no A1 VSS VSS) g45n1svt w=(260n) l=45n nf=1 m=(1)
mn2 (no A2 VSS VSS) g45n1svt w=(260n) l=45n nf=1 m=(1)
mn5 (Y B2 no VSS) g45n1svt w=(260n) l=45n nf=1 m=(1)
mp1 (n2 A1 n1 NW) g45p1svt w=(390n) l=45n nf=1 m=(1)
mp4 (n4 B0 n3 NW) g45p1svt w=(390n) l=45n nf=1 m=(1)
mp3 (n3 B1 VDD NW) g45p1svt w=(390n) l=45n nf=1 m=(1)
mp5 (Y B2 n4 NW) g45p1svt w=(390n) l=45n nf=1 m=(1)
mp0 (n1 A0 VDD NW) g45p1svt w=(390n) l=45n nf=1 m=(1)
mp2 (Y A2 n2 NW) g45p1svt w=(390n) l=45n nf=1 m=(1)
ends OAI33X1

// gsclib045_backbias/OAI33X2/schematic

simulator lang=spectre

subckt OAI33X2 A0 A1 A2 B0 B1 B2 Y NW VSS VDD
mn0 (n0 A0 VSS VSS) g45n1svt w=(520n) l=45n nf=1 m=(1)
mn4 (Y B0 n0 VSS) g45n1svt w=(520n) l=45n nf=1 m=(1)
mn3 (Y B1 n0 VSS) g45n1svt w=(520n) l=45n nf=1 m=(1)
mn1 (n0 A1 VSS VSS) g45n1svt w=(520n) l=45n nf=1 m=(1)
mn2 (n0 A2 VSS VSS) g45n1svt w=(520n) l=45n nf=1 m=(1)
mn5 (Y B2 n0 VSS) g45n1svt w=(520n) l=45n nf=1 m=(1)
mp1 (n2 A1 n1 NW) g45p1svt w=(790n) l=45n nf=1 m=(1)
mp4 (n4 B0 n3 NW) g45p1svt w=(790n) l=45n nf=1 m=(1)
mp3 (n3 B1 VDD NW) g45p1svt w=(790n) l=45n nf=1 m=(1)
mp5 (Y B2 n4 NW) g45p1svt w=(790n) l=45n nf=1 m=(1)
mp0 (n1 A0 VDD NW) g45p1svt w=(790n) l=45n nf=1 m=(1)
mp2 (Y A2 n2 NW) g45p1svt w=(790n) l=45n nf=1 m=(1)
ends OAI33X2

// gsclib045_backbias/OAI33X4/schematic

simulator lang=spectre

subckt OAI33X4 A0 A1 A2 B0 B1 B2 Y NW VSS VDD
mn0 (no A0 VSS VSS) g45n1svt w=(1.04u) l=45n nf=1 m=(1)
mn4 (Y B0 no VSS) g45n1svt w=(1.04u) l=45n nf=1 m=(1)
mn3 (Y B1 no VSS) g45n1svt w=(1.04u) l=45n nf=1 m=(1)
mn1 (no A1 VSS VSS) g45n1svt w=(1.04u) l=45n nf=1 m=(1)
mn2 (no A2 VSS VSS) g45n1svt w=(1.04u) l=45n nf=1 m=(1)
mn5 (Y B2 no VSS) g45n1svt w=(1.04u) l=45n nf=1 m=(1)
mp1 (n2 A1 n1 NW) g45p1svt w=(1.56u) l=45n nf=1 m=(1)
mp4 (n4 B0 n3 NW) g45p1svt w=(1.56u) l=45n nf=1 m=(1)
mp3 (n3 B1 VDD NW) g45p1svt w=(1.56u) l=45n nf=1 m=(1)
mp5 (Y B2 n4 NW) g45p1svt w=(1.56u) l=45n nf=1 m=(1)
mp0 (n1 A0 VDD NW) g45p1svt w=(1.56u) l=45n nf=1 m=(1)
mp2 (Y A2 n2 NW) g45p1svt w=(1.56u) l=45n nf=1 m=(1)
ends OAI33X4

// gsclib045_backbias/OAI33XL/schematic

simulator lang=spectre

subckt OAI33XL A0 A1 A2 B0 B1 B2 Y NW VSS VDD
mn0 (no A0 VSS VSS) g45n1svt w=(145n) l=45n nf=1 m=(1)
mn4 (Y B0 no VSS) g45n1svt w=(145n) l=45n nf=1 m=(1)
mn3 (Y B1 no VSS) g45n1svt w=(145n) l=45n nf=1 m=(1)
mn1 (no A1 VSS VSS) g45n1svt w=(145n) l=45n nf=1 m=(1)
mn2 (no A2 VSS VSS) g45n1svt w=(145n) l=45n nf=1 m=(1)
mn5 (Y B2 no VSS) g45n1svt w=(145n) l=45n nf=1 m=(1)
mp1 (n2 A1 n1 NW) g45p1svt w=(215n) l=45n nf=1 m=(1)
mp4 (n4 B0 n3 NW) g45p1svt w=(215n) l=45n nf=1 m=(1)
mp3 (n3 B1 VDD NW) g45p1svt w=(215n) l=45n nf=1 m=(1)
mp5 (Y B2 n4 NW) g45p1svt w=(215n) l=45n nf=1 m=(1)
mp0 (n1 A0 VDD NW) g45p1svt w=(215n) l=45n nf=1 m=(1)
mp2 (Y A2 n2 NW) g45p1svt w=(215n) l=45n nf=1 m=(1)
ends OAI33XL

// gsclib045_backbias/OR2X1/schematic

simulator lang=spectre

subckt OR2X1 A B Y NW VSS VDD
mn2 (Y n0 VSS VSS) g45n1svt w=(260n) l=45n nf=1 m=(1)
mn0 (n0 A VSS VSS) g45n1svt w=(145n) l=45n nf=1 m=(1)
mn1 (n0 B VSS VSS) g45n1svt w=(145n) l=45n nf=1 m=(1)
mp1 (n0 B n1 NW) g45p1svt w=(215n) l=45n nf=1 m=(1)
mp2 (Y n0 VDD NW) g45p1svt w=(390n) l=45n nf=1 m=(1)
mp0 (n1 A VDD NW) g45p1svt w=(215n) l=45n nf=1 m=(1)
ends OR2X1

// gsclib045_backbias/OR2X2/schematic

simulator lang=spectre

subckt OR2X2 A B Y VSS VDD NW
mn2 (Y n0 VSS VSS) g45n1svt w=(520n) l=45n nf=1 m=(1)
mn0 (n0 A VSS VSS) g45n1svt w=(145n) l=45n nf=1 m=(1)
mn1 (n0 B VSS VSS) g45n1svt w=(145n) l=45n nf=1 m=(1)
mp1 (n0 B n1 NW) g45p1svt w=(215n) l=45n nf=1 m=(1)
mp2 (Y n0 VDD NW) g45p1svt w=(780n) l=45n nf=1 m=(1)
mp0 (n1 A VDD NW) g45p1svt w=(215n) l=45n nf=1 m=(1)
ends OR2X2

// gsclib045_backbias/OR2X4/schematic

simulator lang=spectre

subckt OR2X4 A B Y VSS VDD NW
mn2 (Y n0 VSS VSS) g45n1svt w=(1.04u) l=45n nf=1 m=(1)
mn0 (n0 A VSS VSS) g45n1svt w=(260n) l=45n nf=1 m=(1)
mn1 (n0 B VSS VSS) g45n1svt w=(260n) l=45n nf=1 m=(1)
mp1 (n0 B n1 NW) g45p1svt w=(390n) l=45n nf=1 m=(1)
mp2 (Y n0 VDD NW) g45p1svt w=(1.56u) l=45n nf=1 m=(1)
mp0 (n1 A VDD NW) g45p1svt w=(390n) l=45n nf=1 m=(1)
ends OR2X4

// gsclib045_backbias/OR2X6/schematic

simulator lang=spectre

subckt OR2X6 A B Y VSS VDD NW
mn2 (Y n0 VSS VSS) g45n1svt w=(1.55u) l=45n nf=1 m=(1)
mn0 (n0 A VSS VSS) g45n1svt w=(520n) l=45n nf=1 m=(1)
mn1 (n0 B VSS VSS) g45n1svt w=(520n) l=45n nf=1 m=(1)
mp1 (n0 B n1 NW) g45p1svt w=(780n) l=45n nf=1 m=(1)
mp2 (Y n0 VDD NW) g45p1svt w=(2.35u) l=45n nf=1 m=(1)
mp0 (n1 A VDD NW) g45p1svt w=(780n) l=45n nf=1 m=(1)
ends OR2X6

// gsclib045_backbias/OR2X8/schematic

simulator lang=spectre

subckt OR2X8 A B Y VDD NW VSS
mn2 (Y n0 VSS VSS) g45n1svt w=(2.1u) l=45n nf=1 m=(1)
mn0 (n0 A VSS VSS) g45n1svt w=(520n) l=45n nf=1 m=(1)
mn1 (n0 B VSS VSS) g45n1svt w=(520n) l=45n nf=1 m=(1)
mp1 (n0 B n1 NW) g45p1svt w=(780n) l=45n nf=1 m=(1)
mp2 (Y n0 VDD NW) g45p1svt w=(3.15u) l=45n nf=1 m=(1)
mp0 (n1 A VDD NW) g45p1svt w=(780n) l=45n nf=1 m=(1)
ends OR2X8

// gsclib045_backbias/OR2XL/schematic

simulator lang=spectre

subckt OR2XL A B Y VSS VDD NW
mn2 (Y n0 VSS VSS) g45n1svt w=(145n) l=45n nf=1 m=(1)
mn0 (n0 A VSS VSS) g45n1svt w=(145n) l=45n nf=1 m=(1)
mn1 (n0 B VSS VSS) g45n1svt w=(145n) l=45n nf=1 m=(1)
mp1 (n0 B n1 NW) g45p1svt w=(215n) l=45n nf=1 m=(1)
mp2 (Y n0 VDD NW) g45p1svt w=(215n) l=45n nf=1 m=(1)
mp0 (n1 A VDD NW) g45p1svt w=(215n) l=45n nf=1 m=(1)
ends OR2XL

// gsclib045_backbias/OR3X1/schematic

simulator lang=spectre

subckt OR3X1 A B C Y VDD VSS NW
mn3 (Y n0 VSS VSS) g45n1svt w=(260n) l=45n nf=1 m=(1)
mn0 (n0 A VSS VSS) g45n1svt w=(145n) l=45n nf=1 m=(1)
mn1 (n0 B VSS VSS) g45n1svt w=(145n) l=45n nf=1 m=(1)
mn2 (n0 C VSS VSS) g45n1svt w=(145n) l=45n nf=1 m=(1)
mp3 (Y n0 VDD NW) g45p1svt w=(390n) l=45n nf=1 m=(1)
mp1 (n2 B n1 NW) g45p1svt w=(215n) l=45n nf=1 m=(1)
mp2 (n0 C n2 NW) g45p1svt w=(215n) l=45n nf=1 m=(1)
mp0 (n1 A VDD NW) g45p1svt w=(215n) l=45n nf=1 m=(1)
ends OR3X1

// gsclib045_backbias/OR3X2/schematic

simulator lang=spectre

subckt OR3X2 A B C Y VDD NW VSS
mn3 (Y n0 VSS VSS) g45n1svt w=(520n) l=45n nf=1 m=(1)
mn0 (n0 A VSS VSS) g45n1svt w=(145n) l=45n nf=1 m=(1)
mn1 (n0 B VSS VSS) g45n1svt w=(145n) l=45n nf=1 m=(1)
mn2 (n0 C VSS VSS) g45n1svt w=(145n) l=45n nf=1 m=(1)
mp3 (Y n0 VDD NW) g45p1svt w=(780n) l=45n nf=1 m=(1)
mp1 (n2 B n1 NW) g45p1svt w=(215n) l=45n nf=1 m=(1)
mp2 (n0 C n2 NW) g45p1svt w=(215n) l=45n nf=1 m=(1)
mp0 (n1 A VDD NW) g45p1svt w=(215n) l=45n nf=1 m=(1)
ends OR3X2

// gsclib045_backbias/OR3X4/schematic

simulator lang=spectre

subckt OR3X4 A B C Y VDD NW VSS
mn3 (Y n0 VSS VSS) g45n1svt w=(1.04u) l=45n nf=1 m=(1)
mn0 (n0 A VSS VSS) g45n1svt w=(260n) l=45n nf=1 m=(1)
mn1 (n0 B VSS VSS) g45n1svt w=(260n) l=45n nf=1 m=(1)
mn2 (n0 C VSS VSS) g45n1svt w=(260n) l=45n nf=1 m=(1)
mp3 (Y n0 VDD NW) g45p1svt w=(1.56u) l=45n nf=1 m=(1)
mp1 (n2 B n1 NW) g45p1svt w=(390n) l=45n nf=1 m=(1)
mp2 (n0 C n2 NW) g45p1svt w=(390n) l=45n nf=1 m=(1)
mp0 (n1 A VDD NW) g45p1svt w=(390n) l=45n nf=1 m=(1)
ends OR3X4

// gsclib045_backbias/OR3X6/schematic

simulator lang=spectre

subckt OR3X6 A B C Y VDD NW VSS
mn3 (Y n0 VSS VSS) g45n1svt w=(1.55u) l=45n nf=1 m=(1)
mn0 (n0 A VSS VSS) g45n1svt w=(520n) l=45n nf=1 m=(1)
mn1 (n0 B VSS VSS) g45n1svt w=(520n) l=45n nf=1 m=(1)
mn2 (n0 C VSS VSS) g45n1svt w=(520n) l=45n nf=1 m=(1)
mp3 (Y n0 VDD NW) g45p1svt w=(2.35u) l=45n nf=1 m=(1)
mp1 (n2 B n1 NW) g45p1svt w=(780n) l=45n nf=1 m=(1)
mp2 (n0 C n2 NW) g45p1svt w=(780n) l=45n nf=1 m=(1)
mp0 (n1 A VDD NW) g45p1svt w=(780n) l=45n nf=1 m=(1)
ends OR3X6

// gsclib045_backbias/OR3X8/schematic

simulator lang=spectre

subckt OR3X8 A B C Y VDD NW VSS
mn3 (Y n0 VSS VSS) g45n1svt w=(2.065u) l=45n nf=1 m=(1)
mn0 (n0 A VSS VSS) g45n1svt w=(520n) l=45n nf=1 m=(1)
mn1 (n0 B VSS VSS) g45n1svt w=(520n) l=45n nf=1 m=(1)
mn2 (n0 C VSS VSS) g45n1svt w=(520n) l=45n nf=1 m=(1)
mp3 (Y n0 VDD NW) g45p1svt w=(3.115u) l=45n nf=1 m=(1)
mp1 (n2 B n1 NW) g45p1svt w=(780n) l=45n nf=1 m=(1)
mp2 (n0 C n2 NW) g45p1svt w=(780n) l=45n nf=1 m=(1)
mp0 (n1 A VDD NW) g45p1svt w=(780n) l=45n nf=1 m=(1)
ends OR3X8

// gsclib045_backbias/OR3XL/schematic

simulator lang=spectre

subckt OR3XL A B C Y VDD NW VSS
mn3 (Y n0 VSS VSS) g45n1svt w=(145n) l=45n nf=1 m=(1)
mn0 (n0 A VSS VSS) g45n1svt w=(145n) l=45n nf=1 m=(1)
mn1 (n0 B VSS VSS) g45n1svt w=(145n) l=45n nf=1 m=(1)
mn2 (n0 C VSS VSS) g45n1svt w=(145n) l=45n nf=1 m=(1)
mp3 (Y n0 VDD NW) g45p1svt w=(215n) l=45n nf=1 m=(1)
mp1 (n2 B n1 NW) g45p1svt w=(215n) l=45n nf=1 m=(1)
mp2 (n0 C n2 NW) g45p1svt w=(215n) l=45n nf=1 m=(1)
mp0 (n1 A VDD NW) g45p1svt w=(215n) l=45n nf=1 m=(1)
ends OR3XL

// gsclib045_backbias/OR4X1/schematic

simulator lang=spectre

subckt OR4X1 A B C D Y VDD VSS NW
mn4 (Y n0 VSS VSS) g45n1svt w=(260n) l=45n nf=1 m=(1)
mn3 (n0 D VSS VSS) g45n1svt w=(145n) l=45n nf=1 m=(1)
mn0 (n0 A VSS VSS) g45n1svt w=(145n) l=45n nf=1 m=(1)
mn2 (n0 C VSS VSS) g45n1svt w=(145n) l=45n nf=1 m=(1)
mn1 (n0 B VSS VSS) g45n1svt w=(145n) l=45n nf=1 m=(1)
mp4 (Y n0 VDD NW) g45p1svt w=(390n) l=45n nf=1 m=(1)
mp0 (n1 A VDD NW) g45p1svt w=(215n) l=45n nf=1 m=(1)
mp3 (n0 D n3 NW) g45p1svt w=(215n) l=45n nf=1 m=(1)
mp1 (n2 B n1 NW) g45p1svt w=(215n) l=45n nf=1 m=(1)
mp2 (n3 C n2 NW) g45p1svt w=(215n) l=45n nf=1 m=(1)
ends OR4X1

// gsclib045_backbias/OR4X2/schematic

simulator lang=spectre

subckt OR4X2 A B C D Y VDD VSS NW
mn4 (Y n0 VSS VSS) g45n1svt w=(520n) l=45n nf=1 m=(1)
mn3 (n0 D VSS VSS) g45n1svt w=(145n) l=45n nf=1 m=(1)
mn0 (n0 A VSS VSS) g45n1svt w=(145n) l=45n nf=1 m=(1)
mn2 (n0 C VSS VSS) g45n1svt w=(145n) l=45n nf=1 m=(1)
mn1 (n0 B VSS VSS) g45n1svt w=(145n) l=45n nf=1 m=(1)
mp4 (Y n0 VDD NW) g45p1svt w=(780n) l=45n nf=1 m=(1)
mp0 (n1 A VDD NW) g45p1svt w=(215n) l=45n nf=1 m=(1)
mp3 (n0 D n3 NW) g45p1svt w=(215n) l=45n nf=1 m=(1)
mp1 (n2 B n1 NW) g45p1svt w=(215n) l=45n nf=1 m=(1)
mp2 (n3 C n2 NW) g45p1svt w=(215n) l=45n nf=1 m=(1)
ends OR4X2

// gsclib045_backbias/OR4X4/schematic

simulator lang=spectre

subckt OR4X4 A B C D Y VDD VSS NW
mn4 (Y n0 VSS VSS) g45n1svt w=(1.04u) l=45n nf=1 m=(1)
mn3 (n0 D VSS VSS) g45n1svt w=(260n) l=45n nf=1 m=(1)
mn0 (n0 A VSS VSS) g45n1svt w=(260n) l=45n nf=1 m=(1)
mn2 (n0 C VSS VSS) g45n1svt w=(260n) l=45n nf=1 m=(1)
mn1 (n0 B VSS VSS) g45n1svt w=(260n) l=45n nf=1 m=(1)
mp4 (Y n0 VDD NW) g45p1svt w=(1.56u) l=45n nf=1 m=(1)
mp0 (n1 A VDD NW) g45p1svt w=(390n) l=45n nf=1 m=(1)
mp3 (n0 D n3 NW) g45p1svt w=(390n) l=45n nf=1 m=(1)
mp1 (n2 B n1 NW) g45p1svt w=(390n) l=45n nf=1 m=(1)
mp2 (n3 C n2 NW) g45p1svt w=(390n) l=45n nf=1 m=(1)
ends OR4X4

// gsclib045_backbias/OR4X6/schematic

simulator lang=spectre

subckt OR4X6 A B C D Y VDD VSS NW
mn4 (Y n0 VSS VSS) g45n1svt w=(1.55u) l=45n nf=1 m=(1)
mn3 (n0 D VSS VSS) g45n1svt w=(520n) l=45n nf=1 m=(1)
mn0 (n0 A VSS VSS) g45n1svt w=(520n) l=45n nf=1 m=(1)
mn2 (n0 C VSS VSS) g45n1svt w=(520n) l=45n nf=1 m=(1)
mn1 (n0 B VSS VSS) g45n1svt w=(520n) l=45n nf=1 m=(1)
mp4 (Y n0 VDD NW) g45p1svt w=(2.35u) l=45n nf=1 m=(1)
mp0 (n1 A VDD NW) g45p1svt w=(780n) l=45n nf=1 m=(1)
mp3 (n0 D n3 NW) g45p1svt w=(780n) l=45n nf=1 m=(1)
mp1 (n2 B n1 NW) g45p1svt w=(780n) l=45n nf=1 m=(1)
mp2 (n3 C n2 NW) g45p1svt w=(780n) l=45n nf=1 m=(1)
ends OR4X6

// gsclib045_backbias/OR4X8/schematic

simulator lang=spectre

subckt OR4X8 A B C D Y VDD VSS NW
mn4 (Y n0 VSS VSS) g45n1svt w=(2.065u) l=45n nf=1 m=(1)
mn3 (n0 D VSS VSS) g45n1svt w=(520n) l=45n nf=1 m=(1)
mn0 (n0 A VSS VSS) g45n1svt w=(520n) l=45n nf=1 m=(1)
mn2 (n0 C VSS VSS) g45n1svt w=(520n) l=45n nf=1 m=(1)
mn1 (n0 B VSS VSS) g45n1svt w=(520n) l=45n nf=1 m=(1)
mp4 (Y n0 VDD NW) g45p1svt w=(3.115u) l=45n nf=1 m=(1)
mp0 (n1 A VDD NW) g45p1svt w=(780n) l=45n nf=1 m=(1)
mp3 (n0 D n3 NW) g45p1svt w=(780n) l=45n nf=1 m=(1)
mp1 (n2 B n1 NW) g45p1svt w=(780n) l=45n nf=1 m=(1)
mp2 (n3 C n2 NW) g45p1svt w=(780n) l=45n nf=1 m=(1)
ends OR4X8

// gsclib045_backbias/OR4XL/schematic

simulator lang=spectre

subckt OR4XL A B C D Y VDD VSS NW
mn4 (Y n0 VSS VSS) g45n1svt w=(145n) l=45n nf=1 m=(1)
mn3 (n0 D VSS VSS) g45n1svt w=(145n) l=45n nf=1 m=(1)
mn0 (n0 A VSS VSS) g45n1svt w=(145n) l=45n nf=1 m=(1)
mn2 (n0 C VSS VSS) g45n1svt w=(145n) l=45n nf=1 m=(1)
mn1 (n0 B VSS VSS) g45n1svt w=(145n) l=45n nf=1 m=(1)
mp4 (Y n0 VDD NW) g45p1svt w=(215n) l=45n nf=1 m=(1)
mp0 (n1 A VDD NW) g45p1svt w=(215n) l=45n nf=1 m=(1)
mp3 (n0 D n3 NW) g45p1svt w=(215n) l=45n nf=1 m=(1)
mp1 (n2 B n1 NW) g45p1svt w=(215n) l=45n nf=1 m=(1)
mp2 (n3 C n2 NW) g45p1svt w=(215n) l=45n nf=1 m=(1)
ends OR4XL

// gsclib045_backbias/TIEHI/schematic

simulator lang=spectre

subckt TIEHI Y VSS VDD NW
mp0 (Y net25 VDD NW) g45p1svt w=(390n) l=45n nf=1 m=(1)
mn0 (net25 net25 VSS VSS) g45n1svt w=(260n) l=45n nf=1 m=(1)
ends TIEHI

// gsclib045_backbias/TIELO/schematic

simulator lang=spectre

subckt TIELO Y VSS VDD NW
mp0 (net25 net25 VDD NW) g45p1svt w=(390n) l=45n nf=1 m=(1)
mn0 (Y net25 VSS VSS) g45n1svt w=(260n) l=45n nf=1 m=(1)
ends TIELO

// gsclib045_backbias/TLATNCAX12/schematic

simulator lang=spectre

subckt TLATNCAX12 CK E ECK VSS VDD NW
mn5 (net254 E VSS VSS) g45n1svt w=(145n) l=45n nf=1 m=(1)
mn6 (n0 CKb net254 VSS) g45n1svt w=(145n) l=45n nf=1 m=(1)
mn22 (ECK ECKb VSS VSS) g45n1svt w=(3.1u) l=45n nf=1 m=(1)
mn21 (ECKb CKbb net238 VSS) g45n1svt w=(780n) l=45n nf=1 m=(1)
mn20 (net238 Eint VSS VSS) g45n1svt w=(780n) l=45n nf=1 m=(1)
mn16 (n0 CKbb net230 VSS) g45n1svt w=(145n) l=45n nf=1 m=(1)
mn15 (net230 Eint VSS VSS) g45n1svt w=(145n) l=45n nf=1 m=(1)
mn0 (CKb CK VSS VSS) g45n1svt w=(145n) l=45n nf=1 m=(1)
mn10 (Eint n0 VSS VSS) g45n1svt w=(260n) l=45n nf=1 m=(1)
mn1 (CKbb CKb VSS VSS) g45n1svt w=(145n) l=45n nf=1 m=(1)
mp6 (n0 CKbb net217 NW) g45p1svt w=(215n) l=45n nf=1 m=(1)
mp5 (net217 E VDD NW) g45p1svt w=(215n) l=45n nf=1 m=(1)
mp22 (ECK ECKb VDD NW) g45p1svt w=(4.7u) l=45n nf=1 m=(1)
mp16 (n0 CKb net205 NW) g45p1svt w=(215n) l=45n nf=1 m=(1)
mp15 (net205 Eint VDD NW) g45p1svt w=(215n) l=45n nf=1 m=(1)
mp0 (CKb CK VDD NW) g45p1svt w=(215n) l=45n nf=1 m=(1)
mp1 (CKbb CKb VDD NW) g45p1svt w=(215n) l=45n nf=1 m=(1)
mp20 (ECKb Eint VDD NW) g45p1svt w=(1.17u) l=45n nf=1 m=(1)
mp21 (ECKb CKbb VDD NW) g45p1svt w=(1.17u) l=45n nf=1 m=(1)
mp10 (Eint n0 VDD NW) g45p1svt w=(390n) l=45n nf=1 m=(1)
ends TLATNCAX12

// gsclib045_backbias/TLATNCAX16/schematic

simulator lang=spectre

subckt TLATNCAX16 CK E ECK VSS VDD NW
mn5 (net254 E VSS VSS) g45n1svt w=(145n) l=45n nf=1 m=(1)
mn6 (n0 CKb net254 VSS) g45n1svt w=(145n) l=45n nf=1 m=(1)
mn22 (ECK ECKb VSS VSS) g45n1svt w=(4.13u) l=45n nf=1 m=(1)
mn21 (ECKb CKbb net238 VSS) g45n1svt w=(1.04u) l=45n nf=1 m=(1)
mn20 (net238 Eint VSS VSS) g45n1svt w=(1.04u) l=45n nf=1 m=(1)
mn16 (n0 CKbb net230 VSS) g45n1svt w=(145n) l=45n nf=1 m=(1)
mn15 (net230 Eint VSS VSS) g45n1svt w=(145n) l=45n nf=1 m=(1)
mn0 (CKb CK VSS VSS) g45n1svt w=(145n) l=45n nf=1 m=(1)
mn10 (Eint n0 VSS VSS) g45n1svt w=(410n) l=45n nf=1 m=(1)
mn1 (CKbb CKb VSS VSS) g45n1svt w=(145n) l=45n nf=1 m=(1)
mp6 (n0 CKbb net217 NW) g45p1svt w=(215n) l=45n nf=1 m=(1)
mp5 (net217 E VDD NW) g45p1svt w=(215n) l=45n nf=1 m=(1)
mp22 (ECK ECKb VDD NW) g45p1svt w=(6.23u) l=45n nf=1 m=(1)
mp16 (n0 CKb net205 NW) g45p1svt w=(215n) l=45n nf=1 m=(1)
mp15 (net205 Eint VDD NW) g45p1svt w=(215n) l=45n nf=1 m=(1)
mp0 (CKb CK VDD NW) g45p1svt w=(215n) l=45n nf=1 m=(1)
mp1 (CKbb CKb VDD NW) g45p1svt w=(215n) l=45n nf=1 m=(1)
mp20 (ECKb Eint VDD NW) g45p1svt w=(1.56u) l=45n nf=1 m=(1)
mp21 (ECKb CKbb VDD NW) g45p1svt w=(1.56u) l=45n nf=1 m=(1)
mp10 (Eint n0 VDD NW) g45p1svt w=(620n) l=45n nf=1 m=(1)
ends TLATNCAX16

// gsclib045_backbias/TLATNCAX2/schematic

simulator lang=spectre

subckt TLATNCAX2 CK E ECK VDD NW VSS
mn5 (net254 E VSS VSS) g45n1svt w=(145n) l=45n nf=1 m=(1)
mn6 (n0 CKb net254 VSS) g45n1svt w=(145n) l=45n nf=1 m=(1)
mn22 (ECK ECKb VSS VSS) g45n1svt w=(520n) l=45n nf=1 m=(1)
mn21 (ECKb CKbb net238 VSS) g45n1svt w=(145n) l=45n nf=1 m=(1)
mn20 (net238 Eint VSS VSS) g45n1svt w=(145n) l=45n nf=1 m=(1)
mn16 (n0 CKbb net230 VSS) g45n1svt w=(145n) l=45n nf=1 m=(1)
mn15 (net230 Eint VSS VSS) g45n1svt w=(145n) l=45n nf=1 m=(1)
mn0 (CKb CK VSS VSS) g45n1svt w=(145n) l=45n nf=1 m=(1)
mn10 (Eint n0 VSS VSS) g45n1svt w=(145n) l=45n nf=1 m=(1)
mn1 (CKbb CKb VSS VSS) g45n1svt w=(145n) l=45n nf=1 m=(1)
mp6 (n0 CKbb net217 NW) g45p1svt w=(215n) l=45n nf=1 m=(1)
mp5 (net217 E VDD NW) g45p1svt w=(215n) l=45n nf=1 m=(1)
mp22 (ECK ECKb VDD NW) g45p1svt w=(780n) l=45n nf=1 m=(1)
mp16 (n0 CKb net205 NW) g45p1svt w=(215n) l=45n nf=1 m=(1)
mp15 (net205 Eint VDD NW) g45p1svt w=(215n) l=45n nf=1 m=(1)
mp0 (CKb CK VDD NW) g45p1svt w=(215n) l=45n nf=1 m=(1)
mp1 (CKbb CKb VDD NW) g45p1svt w=(215n) l=45n nf=1 m=(1)
mp20 (ECKb Eint VDD NW) g45p1svt w=(215n) l=45n nf=1 m=(1)
mp21 (ECKb CKbb VDD NW) g45p1svt w=(215n) l=45n nf=1 m=(1)
mp10 (Eint n0 VDD NW) g45p1svt w=(215n) l=45n nf=1 m=(1)
ends TLATNCAX2

// gsclib045_backbias/TLATNCAX20/schematic

simulator lang=spectre

subckt TLATNCAX20 CK E ECK VSS VDD NW
mn5 (net254 E VSS VSS) g45n1svt w=(145n) l=45n nf=1 m=(1)
mn6 (n0 CKb net254 VSS) g45n1svt w=(145n) l=45n nf=1 m=(1)
mn22 (ECK ECKb VSS VSS) g45n1svt w=(5.185u) l=45n nf=1 m=(1)
mn21 (ECKb CKbb net238 VSS) g45n1svt w=(1.3u) l=45n nf=1 m=(1)
mn20 (net238 Eint VSS VSS) g45n1svt w=(1.3u) l=45n nf=1 m=(1)
mn16 (n0 CKbb net230 VSS) g45n1svt w=(145n) l=45n nf=1 m=(1)
mn15 (net230 Eint VSS VSS) g45n1svt w=(145n) l=45n nf=1 m=(1)
mn0 (CKb CK VSS VSS) g45n1svt w=(145n) l=45n nf=1 m=(1)
mn10 (Eint n0 VSS VSS) g45n1svt w=(520n) l=45n nf=1 m=(1)
mn1 (CKbb CKb VSS VSS) g45n1svt w=(145n) l=45n nf=1 m=(1)
mp6 (n0 CKbb net217 NW) g45p1svt w=(215n) l=45n nf=1 m=(1)
mp5 (net217 E VDD NW) g45p1svt w=(215n) l=45n nf=1 m=(1)
mp22 (ECK ECKb VDD NW) g45p1svt w=(7.815u) l=45n nf=1 m=(1)
mp16 (n0 CKb net205 NW) g45p1svt w=(215n) l=45n nf=1 m=(1)
mp15 (net205 Eint VDD NW) g45p1svt w=(215n) l=45n nf=1 m=(1)
mp0 (CKb CK VDD NW) g45p1svt w=(215n) l=45n nf=1 m=(1)
mp1 (CKbb CKb VDD NW) g45p1svt w=(215n) l=45n nf=1 m=(1)
mp20 (ECKb Eint VDD NW) g45p1svt w=(1.95u) l=45n nf=1 m=(1)
mp21 (ECKb CKbb VDD NW) g45p1svt w=(1.95u) l=45n nf=1 m=(1)
mp10 (Eint n0 VDD NW) g45p1svt w=(780n) l=45n nf=1 m=(1)
ends TLATNCAX20

// gsclib045_backbias/TLATNCAX3/schematic

simulator lang=spectre

subckt TLATNCAX3 CK E ECK VDD VSS NW
mn5 (net254 E VSS VSS) g45n1svt w=(145n) l=45n nf=1 m=(1)
mn6 (n0 CKb net254 VSS) g45n1svt w=(145n) l=45n nf=1 m=(1)
mn22 (ECK ECKb VSS VSS) g45n1svt w=(780n) l=45n nf=1 m=(1)
mn21 (ECKb CKbb net238 VSS) g45n1svt w=(260n) l=45n nf=1 m=(1)
mn20 (net238 Eint VSS VSS) g45n1svt w=(260n) l=45n nf=1 m=(1)
mn16 (n0 CKbb net230 VSS) g45n1svt w=(145n) l=45n nf=1 m=(1)
mn15 (net230 Eint VSS VSS) g45n1svt w=(145n) l=45n nf=1 m=(1)
mn0 (CKb CK VSS VSS) g45n1svt w=(145n) l=45n nf=1 m=(1)
mn10 (Eint n0 VSS VSS) g45n1svt w=(145n) l=45n nf=1 m=(1)
mn1 (CKbb CKb VSS VSS) g45n1svt w=(145n) l=45n nf=1 m=(1)
mp6 (n0 CKbb net217 NW) g45p1svt w=(215n) l=45n nf=1 m=(1)
mp5 (net217 E VDD NW) g45p1svt w=(215n) l=45n nf=1 m=(1)
mp22 (ECK ECKb VDD NW) g45p1svt w=(1.17u) l=45n nf=1 m=(1)
mp16 (n0 CKb net205 NW) g45p1svt w=(215n) l=45n nf=1 m=(1)
mp15 (net205 Eint VDD NW) g45p1svt w=(215n) l=45n nf=1 m=(1)
mp0 (CKb CK VDD NW) g45p1svt w=(215n) l=45n nf=1 m=(1)
mp1 (CKbb CKb VDD NW) g45p1svt w=(215n) l=45n nf=1 m=(1)
mp20 (ECKb Eint VDD NW) g45p1svt w=(390n) l=45n nf=1 m=(1)
mp21 (ECKb CKbb VDD NW) g45p1svt w=(390n) l=45n nf=1 m=(1)
mp10 (Eint n0 VDD NW) g45p1svt w=(215n) l=45n nf=1 m=(1)
ends TLATNCAX3

// gsclib045_backbias/TLATNCAX4/schematic

simulator lang=spectre

subckt TLATNCAX4 CK E ECK VSS VDD NW
mn5 (net254 E VSS VSS) g45n1svt w=(145n) l=45n nf=1 m=(1)
mn6 (n0 CKb net254 VSS) g45n1svt w=(145n) l=45n nf=1 m=(1)
mn22 (ECK ECKb VSS VSS) g45n1svt w=(1.04u) l=45n nf=1 m=(1)
mn21 (ECKb CKbb net238 VSS) g45n1svt w=(260n) l=45n nf=1 m=(1)
mn20 (net238 Eint VSS VSS) g45n1svt w=(260n) l=45n nf=1 m=(1)
mn16 (n0 CKbb net230 VSS) g45n1svt w=(145n) l=45n nf=1 m=(1)
mn15 (net230 Eint VSS VSS) g45n1svt w=(145n) l=45n nf=1 m=(1)
mn0 (CKb CK VSS VSS) g45n1svt w=(145n) l=45n nf=1 m=(1)
mn10 (Eint n0 VSS VSS) g45n1svt w=(145n) l=45n nf=1 m=(1)
mn1 (CKbb CKb VSS VSS) g45n1svt w=(145n) l=45n nf=1 m=(1)
mp6 (n0 CKbb net217 NW) g45p1svt w=(215n) l=45n nf=1 m=(1)
mp5 (net217 E VDD NW) g45p1svt w=(215n) l=45n nf=1 m=(1)
mp22 (ECK ECKb VDD NW) g45p1svt w=(1.56u) l=45n nf=1 m=(1)
mp16 (n0 CKb net205 NW) g45p1svt w=(215n) l=45n nf=1 m=(1)
mp15 (net205 Eint VDD NW) g45p1svt w=(215n) l=45n nf=1 m=(1)
mp0 (CKb CK VDD NW) g45p1svt w=(215n) l=45n nf=1 m=(1)
mp1 (CKbb CKb VDD NW) g45p1svt w=(215n) l=45n nf=1 m=(1)
mp20 (ECKb Eint VDD NW) g45p1svt w=(390n) l=45n nf=1 m=(1)
mp21 (ECKb CKbb VDD NW) g45p1svt w=(390n) l=45n nf=1 m=(1)
mp10 (Eint n0 VDD NW) g45p1svt w=(215n) l=45n nf=1 m=(1)
ends TLATNCAX4

// gsclib045_backbias/TLATNCAX6/schematic

simulator lang=spectre

subckt TLATNCAX6 CK E ECK VSS VDD NW
mn5 (net254 E VSS VSS) g45n1svt w=(145n) l=45n nf=1 m=(1)
mn6 (n0 CKb net254 VSS) g45n1svt w=(145n) l=45n nf=1 m=(1)
mn22 (ECK ECKb VSS VSS) g45n1svt w=(1.55u) l=45n nf=1 m=(1)
mn21 (ECKb CKbb net238 VSS) g45n1svt w=(520n) l=45n nf=1 m=(1)
mn20 (net238 Eint VSS VSS) g45n1svt w=(520n) l=45n nf=1 m=(1)
mn16 (n0 CKbb net230 VSS) g45n1svt w=(145n) l=45n nf=1 m=(1)
mn15 (net230 Eint VSS VSS) g45n1svt w=(145n) l=45n nf=1 m=(1)
mn0 (CKb CK VSS VSS) g45n1svt w=(145n) l=45n nf=1 m=(1)
mn10 (Eint n0 VSS VSS) g45n1svt w=(205n) l=45n nf=1 m=(1)
mn1 (CKbb CKb VSS VSS) g45n1svt w=(145n) l=45n nf=1 m=(1)
mp6 (n0 CKbb net217 NW) g45p1svt w=(215n) l=45n nf=1 m=(1)
mp5 (net217 E VDD NW) g45p1svt w=(215n) l=45n nf=1 m=(1)
mp22 (ECK ECKb VDD NW) g45p1svt w=(2.35u) l=45n nf=1 m=(1)
mp16 (n0 CKb net205 NW) g45p1svt w=(215n) l=45n nf=1 m=(1)
mp15 (net205 Eint VDD NW) g45p1svt w=(215n) l=45n nf=1 m=(1)
mp0 (CKb CK VDD NW) g45p1svt w=(215n) l=45n nf=1 m=(1)
mp1 (CKbb CKb VDD NW) g45p1svt w=(215n) l=45n nf=1 m=(1)
mp20 (ECKb Eint VDD NW) g45p1svt w=(780n) l=45n nf=1 m=(1)
mp21 (ECKb CKbb VDD NW) g45p1svt w=(780n) l=45n nf=1 m=(1)
mp10 (Eint n0 VDD NW) g45p1svt w=(310n) l=45n nf=1 m=(1)
ends TLATNCAX6

// gsclib045_backbias/TLATNCAX8/schematic

simulator lang=spectre

subckt TLATNCAX8 CK E ECK VSS NW VDD
mn5 (net254 E VSS VSS) g45n1svt w=(145n) l=45n nf=1 m=(1)
mn6 (n0 CKb net254 VSS) g45n1svt w=(145n) l=45n nf=1 m=(1)
mn22 (ECK ECKb VSS VSS) g45n1svt w=(2.065u) l=45n nf=1 m=(1)
mn21 (ECKb CKbb net238 VSS) g45n1svt w=(520n) l=45n nf=1 m=(1)
mn20 (net238 Eint VSS VSS) g45n1svt w=(520n) l=45n nf=1 m=(1)
mn16 (n0 CKbb net230 VSS) g45n1svt w=(145n) l=45n nf=1 m=(1)
mn15 (net230 Eint VSS VSS) g45n1svt w=(145n) l=45n nf=1 m=(1)
mn0 (CKb CK VSS VSS) g45n1svt w=(145n) l=45n nf=1 m=(1)
mn10 (Eint n0 VSS VSS) g45n1svt w=(205n) l=45n nf=1 m=(1)
mn1 (CKbb CKb VSS VSS) g45n1svt w=(145n) l=45n nf=1 m=(1)
mp6 (n0 CKbb net217 NW) g45p1svt w=(215n) l=45n nf=1 m=(1)
mp5 (net217 E VDD NW) g45p1svt w=(215n) l=45n nf=1 m=(1)
mp22 (ECK ECKb VDD NW) g45p1svt w=(3.115u) l=45n nf=1 m=(1)
mp16 (n0 CKb net205 NW) g45p1svt w=(215n) l=45n nf=1 m=(1)
mp15 (net205 Eint VDD NW) g45p1svt w=(215n) l=45n nf=1 m=(1)
mp0 (CKb CK VDD NW) g45p1svt w=(215n) l=45n nf=1 m=(1)
mp1 (CKbb CKb VDD NW) g45p1svt w=(215n) l=45n nf=1 m=(1)
mp20 (ECKb Eint VDD NW) g45p1svt w=(780n) l=45n nf=1 m=(1)
mp21 (ECKb CKbb VDD NW) g45p1svt w=(780n) l=45n nf=1 m=(1)
mp10 (Eint n0 VDD NW) g45p1svt w=(310n) l=45n nf=1 m=(1)
ends TLATNCAX8

// gsclib045_backbias/TLATNSRX1/schematic

simulator lang=spectre

subckt TLATNSRX1 D GN Q QN RN SN NW VSS VDD
mn5 (net366 D VSS VSS) g45n1svt w=(145n) l=45n nf=1 m=(1)
mn6 (n5 GNb net366 VSS) g45n1svt w=(145n) l=45n nf=1 m=(1)
mn17 (n5 GNbb net354 VSS) g45n1svt w=(145n) l=45n nf=1 m=(1)
mn16 (net354 qint net350 VSS) g45n1svt w=(145n) l=45n nf=1 m=(1)
mn15 (net350 RN VSS VSS) g45n1svt w=(145n) l=45n nf=1 m=(1)
mn11 (qint n5 net342 VSS) g45n1svt w=(145n) l=45n nf=1 m=(1)
mn10 (net342 SN VSS VSS) g45n1svt w=(145n) l=45n nf=1 m=(1)
mn21 (Q qbint VSS VSS) g45n1svt w=(260n) l=45n nf=1 m=(1)
mn0 (GNbp GN VSS VSS) g45n1svt w=(145n) l=45n nf=1 m=(1)
mn2 (GNbb GNbp net326 VSS) g45n1svt w=(145n) l=45n nf=1 m=(1)
mn1 (net326 RN VSS VSS) g45n1svt w=(145n) l=45n nf=1 m=(1)
mn3 (GNb GNbb VSS VSS) g45n1svt w=(145n) l=45n nf=1 m=(1)
mn20 (qbint qint VSS VSS) g45n1svt w=(260n) l=45n nf=1 m=(1)
mn22 (QN qint VSS VSS) g45n1svt w=(260n) l=45n nf=1 m=(1)
mp6 (n5 GNbb net313 NW) g45p1svt w=(215n) l=45n nf=1 m=(1)
mp5 (net313 D VDD NW) g45p1svt w=(215n) l=45n nf=1 m=(1)
mp10 (qint SN VDD NW) g45p1svt w=(215n) l=45n nf=1 m=(1)
mp22 (QN qint VDD NW) g45p1svt w=(390n) l=45n nf=1 m=(1)
mp21 (Q qbint VDD NW) g45p1svt w=(390n) l=45n nf=1 m=(1)
mp0 (GNbp GN VDD NW) g45p1svt w=(215n) l=45n nf=1 m=(1)
mp3 (GNb GNbb VDD NW) g45p1svt w=(215n) l=45n nf=1 m=(1)
mp17 (n5 GNb net270 NW) g45p1svt w=(215n) l=45n nf=1 m=(1)
mp2 (GNbb GNbp VDD NW) g45p1svt w=(215n) l=45n nf=1 m=(1)
mp16 (net270 qint VDD NW) g45p1svt w=(215n) l=45n nf=1 m=(1)
mp15 (net270 RN VDD NW) g45p1svt w=(215n) l=45n nf=1 m=(1)
mp20 (qbint qint VDD NW) g45p1svt w=(390n) l=45n nf=1 m=(1)
mp1 (GNbb RN VDD NW) g45p1svt w=(215n) l=45n nf=1 m=(1)
mp11 (qint n5 VDD NW) g45p1svt w=(215n) l=45n nf=1 m=(1)
ends TLATNSRX1

// gsclib045_backbias/TLATNSRX2/schematic

simulator lang=spectre

subckt TLATNSRX2 D GN Q QN RN SN VSS VDD NW
mn5 (net366 D VSS VSS) g45n1svt w=(145n) l=45n nf=1 m=(1)
mn6 (n5 GNb net366 VSS) g45n1svt w=(145n) l=45n nf=1 m=(1)
mn17 (n5 GNbb net354 VSS) g45n1svt w=(145n) l=45n nf=1 m=(1)
mn16 (net354 qint net350 VSS) g45n1svt w=(145n) l=45n nf=1 m=(1)
mn15 (net350 RN VSS VSS) g45n1svt w=(145n) l=45n nf=1 m=(1)
mn11 (qint n5 net342 VSS) g45n1svt w=(205n) l=45n nf=1 m=(1)
mn10 (net342 SN VSS VSS) g45n1svt w=(205n) l=45n nf=1 m=(1)
mn21 (Q qbint VSS VSS) g45n1svt w=(520n) l=45n nf=1 m=(1)
mn0 (GNbp GN VSS VSS) g45n1svt w=(145n) l=45n nf=1 m=(1)
mn2 (GNbb GNbp net326 VSS) g45n1svt w=(145n) l=45n nf=1 m=(1)
mn1 (net326 RN VSS VSS) g45n1svt w=(145n) l=45n nf=1 m=(1)
mn3 (GNb GNbb VSS VSS) g45n1svt w=(145n) l=45n nf=1 m=(1)
mn20 (qbint qint VSS VSS) g45n1svt w=(520n) l=45n nf=1 m=(1)
mn22 (QN qint VSS VSS) g45n1svt w=(520n) l=45n nf=1 m=(1)
mp6 (n5 GNbb net313 NW) g45p1svt w=(215n) l=45n nf=1 m=(1)
mp5 (net313 D VDD NW) g45p1svt w=(215n) l=45n nf=1 m=(1)
mp10 (qint SN VDD NW) g45p1svt w=(310n) l=45n nf=1 m=(1)
mp22 (QN qint VDD NW) g45p1svt w=(780n) l=45n nf=1 m=(1)
mp21 (Q qbint VDD NW) g45p1svt w=(780n) l=45n nf=1 m=(1)
mp0 (GNbp GN VDD NW) g45p1svt w=(215n) l=45n nf=1 m=(1)
mp3 (GNb GNbb VDD NW) g45p1svt w=(215n) l=45n nf=1 m=(1)
mp17 (n5 GNb net270 NW) g45p1svt w=(215n) l=45n nf=1 m=(1)
mp2 (GNbb GNbp VDD NW) g45p1svt w=(215n) l=45n nf=1 m=(1)
mp16 (net270 qint VDD NW) g45p1svt w=(215n) l=45n nf=1 m=(1)
mp15 (net270 RN VDD NW) g45p1svt w=(215n) l=45n nf=1 m=(1)
mp20 (qbint qint VDD NW) g45p1svt w=(780n) l=45n nf=1 m=(1)
mp1 (GNbb RN VDD NW) g45p1svt w=(215n) l=45n nf=1 m=(1)
mp11 (qint n5 VDD NW) g45p1svt w=(310n) l=45n nf=1 m=(1)
ends TLATNSRX2

// gsclib045_backbias/TLATNSRX4/schematic

simulator lang=spectre

subckt TLATNSRX4 D GN Q QN RN SN VSS VDD NW
mn5 (net366 D VSS VSS) g45n1svt w=(145n) l=45n nf=1 m=(1)
mn6 (n5 GNb net366 VSS) g45n1svt w=(145n) l=45n nf=1 m=(1)
mn17 (n5 GNbb net354 VSS) g45n1svt w=(145n) l=45n nf=1 m=(1)
mn16 (net354 qint net350 VSS) g45n1svt w=(145n) l=45n nf=1 m=(1)
mn15 (net350 RN VSS VSS) g45n1svt w=(145n) l=45n nf=1 m=(1)
mn11 (qint n5 net342 VSS) g45n1svt w=(410n) l=45n nf=1 m=(1)
mn10 (net342 SN VSS VSS) g45n1svt w=(410n) l=45n nf=1 m=(1)
mn21 (Q qbint VSS VSS) g45n1svt w=(1.04u) l=45n nf=1 m=(1)
mn0 (GNbp GN VSS VSS) g45n1svt w=(145n) l=45n nf=1 m=(1)
mn2 (GNbb GNbp net326 VSS) g45n1svt w=(145n) l=45n nf=1 m=(1)
mn1 (net326 RN VSS VSS) g45n1svt w=(145n) l=45n nf=1 m=(1)
mn3 (GNb GNbb VSS VSS) g45n1svt w=(145n) l=45n nf=1 m=(1)
mn20 (qbint qint VSS VSS) g45n1svt w=(1.04u) l=45n nf=1 m=(1)
mn22 (QN qint VSS VSS) g45n1svt w=(1.04u) l=45n nf=1 m=(1)
mp6 (n5 GNbb net313 NW) g45p1svt w=(215n) l=45n nf=1 m=(1)
mp5 (net313 D VDD NW) g45p1svt w=(215n) l=45n nf=1 m=(1)
mp10 (qint SN VDD NW) g45p1svt w=(620n) l=45n nf=1 m=(1)
mp22 (QN qint VDD NW) g45p1svt w=(1.56u) l=45n nf=1 m=(1)
mp21 (Q qbint VDD NW) g45p1svt w=(1.56u) l=45n nf=1 m=(1)
mp0 (GNbp GN VDD NW) g45p1svt w=(215n) l=45n nf=1 m=(1)
mp3 (GNb GNbb VDD NW) g45p1svt w=(215n) l=45n nf=1 m=(1)
mp17 (n5 GNb net270 NW) g45p1svt w=(215n) l=45n nf=1 m=(1)
mp2 (GNbb GNbp VDD NW) g45p1svt w=(215n) l=45n nf=1 m=(1)
mp16 (net270 qint VDD NW) g45p1svt w=(215n) l=45n nf=1 m=(1)
mp15 (net270 RN VDD NW) g45p1svt w=(215n) l=45n nf=1 m=(1)
mp20 (qbint qint VDD NW) g45p1svt w=(1.56u) l=45n nf=1 m=(1)
mp1 (GNbb RN VDD NW) g45p1svt w=(215n) l=45n nf=1 m=(1)
mp11 (qint n5 VDD NW) g45p1svt w=(620n) l=45n nf=1 m=(1)
ends TLATNSRX4

// gsclib045_backbias/TLATNSRXL/schematic

simulator lang=spectre

subckt TLATNSRXL D GN Q QN RN SN VSS VDD NW
mn5 (net366 D VSS VSS) g45n1svt w=(145n) l=45n nf=1 m=(1)
mn6 (n5 GNb net366 VSS) g45n1svt w=(145n) l=45n nf=1 m=(1)
mn17 (n5 GNbb net354 VSS) g45n1svt w=(145n) l=45n nf=1 m=(1)
mn16 (net354 qint net350 VSS) g45n1svt w=(145n) l=45n nf=1 m=(1)
mn15 (net350 RN VSS VSS) g45n1svt w=(145n) l=45n nf=1 m=(1)
mn11 (qint n5 net342 VSS) g45n1svt w=(145n) l=45n nf=1 m=(1)
mn10 (net342 SN VSS VSS) g45n1svt w=(145n) l=45n nf=1 m=(1)
mn21 (Q qbint VSS VSS) g45n1svt w=(145n) l=45n nf=1 m=(1)
mn0 (GNbp GN VSS VSS) g45n1svt w=(145n) l=45n nf=1 m=(1)
mn2 (GNbb GNbp net326 VSS) g45n1svt w=(145n) l=45n nf=1 m=(1)
mn1 (net326 RN VSS VSS) g45n1svt w=(145n) l=45n nf=1 m=(1)
mn3 (GNb GNbb VSS VSS) g45n1svt w=(145n) l=45n nf=1 m=(1)
mn20 (qbint qint VSS VSS) g45n1svt w=(145n) l=45n nf=1 m=(1)
mn22 (QN qint VSS VSS) g45n1svt w=(145n) l=45n nf=1 m=(1)
mp6 (n5 GNbb net313 NW) g45p1svt w=(215n) l=45n nf=1 m=(1)
mp5 (net313 D VDD NW) g45p1svt w=(215n) l=45n nf=1 m=(1)
mp10 (qint SN VDD NW) g45p1svt w=(215n) l=45n nf=1 m=(1)
mp22 (QN qint VDD NW) g45p1svt w=(215n) l=45n nf=1 m=(1)
mp21 (Q qbint VDD NW) g45p1svt w=(215n) l=45n nf=1 m=(1)
mp0 (GNbp GN VDD NW) g45p1svt w=(215n) l=45n nf=1 m=(1)
mp3 (GNb GNbb VDD NW) g45p1svt w=(215n) l=45n nf=1 m=(1)
mp17 (n5 GNb net270 NW) g45p1svt w=(215n) l=45n nf=1 m=(1)
mp2 (GNbb GNbp VDD NW) g45p1svt w=(215n) l=45n nf=1 m=(1)
mp16 (net270 qint VDD NW) g45p1svt w=(215n) l=45n nf=1 m=(1)
mp15 (net270 RN VDD NW) g45p1svt w=(215n) l=45n nf=1 m=(1)
mp20 (qbint qint VDD NW) g45p1svt w=(215n) l=45n nf=1 m=(1)
mp1 (GNbb RN VDD NW) g45p1svt w=(215n) l=45n nf=1 m=(1)
mp11 (qint n5 VDD NW) g45p1svt w=(215n) l=45n nf=1 m=(1)
ends TLATNSRXL

// gsclib045_backbias/TLATNTSCAX12/schematic

simulator lang=spectre

subckt TLATNTSCAX12 CK E ECK SE VSS VDD NW
mn1 (Eb E VSS VSS) g45n1svt w=(145n) l=45n nf=1 m=(1)
mn0 (Eb SE VSS VSS) g45n1svt w=(145n) l=45n nf=1 m=(1)
mn22 (ECK ECKb VSS VSS) g45n1svt w=(3.1u) l=45n nf=1 m=(1)
mn21 (ECKb CKbb net271 VSS) g45n1svt w=(780n) l=45n nf=1 m=(1)
mn20 (net271 Eint VSS VSS) g45n1svt w=(780n) l=45n nf=1 m=(1)
mn16 (n5 CKbb net263 VSS) g45n1svt w=(145n) l=45n nf=1 m=(1)
mn15 (net263 Eint VSS VSS) g45n1svt w=(145n) l=45n nf=1 m=(1)
mn2 (CKb CK VSS VSS) g45n1svt w=(145n) l=45n nf=1 m=(1)
mn10 (Eint n5 VSS VSS) g45n1svt w=(260n) l=45n nf=1 m=(1)
mn5 (Eb CKb n5 VSS) g45n1svt w=(145n) l=45n nf=1 m=(1)
mn3 (CKbb CKb VSS VSS) g45n1svt w=(145n) l=45n nf=1 m=(1)
mp1 (Eb E net246 NW) g45p1svt w=(215n) l=45n nf=1 m=(1)
mp0 (net246 SE VDD NW) g45p1svt w=(215n) l=45n nf=1 m=(1)
mp22 (ECK ECKb VDD NW) g45p1svt w=(4.7u) l=45n nf=1 m=(1)
mp16 (n5 CKb net234 NW) g45p1svt w=(215n) l=45n nf=1 m=(1)
mp15 (net234 Eint VDD NW) g45p1svt w=(215n) l=45n nf=1 m=(1)
mp2 (CKb CK VDD NW) g45p1svt w=(215n) l=45n nf=1 m=(1)
mp10 (Eint n5 VDD NW) g45p1svt w=(390n) l=45n nf=1 m=(1)
mp3 (CKbb CKb VDD NW) g45p1svt w=(215n) l=45n nf=1 m=(1)
mp5 (n5 CKbb Eb NW) g45p1svt w=(215n) l=45n nf=1 m=(1)
mp21 (ECKb CKbb VDD NW) g45p1svt w=(1.17u) l=45n nf=1 m=(1)
mp20 (ECKb Eint VDD NW) g45p1svt w=(1.17u) l=45n nf=1 m=(1)
ends TLATNTSCAX12

// gsclib045_backbias/TLATNTSCAX16/schematic

simulator lang=spectre

subckt TLATNTSCAX16 CK E ECK SE VSS VDD NW
mn1 (Eb E VSS VSS) g45n1svt w=(145n) l=45n nf=1 m=(1)
mn0 (Eb SE VSS VSS) g45n1svt w=(145n) l=45n nf=1 m=(1)
mn22 (ECK ECKb VSS VSS) g45n1svt w=(4.13u) l=45n nf=1 m=(1)
mn21 (ECKb CKbb net271 VSS) g45n1svt w=(1.04u) l=45n nf=1 m=(1)
mn20 (net271 Eint VSS VSS) g45n1svt w=(1.04u) l=45n nf=1 m=(1)
mn16 (n5 CKbb net263 VSS) g45n1svt w=(145n) l=45n nf=1 m=(1)
mn15 (net263 Eint VSS VSS) g45n1svt w=(145n) l=45n nf=1 m=(1)
mn2 (CKb CK VSS VSS) g45n1svt w=(145n) l=45n nf=1 m=(1)
mn10 (Eint n5 VSS VSS) g45n1svt w=(410n) l=45n nf=1 m=(1)
mn5 (Eb CKb n5 VSS) g45n1svt w=(145n) l=45n nf=1 m=(1)
mn3 (CKbb CKb VSS VSS) g45n1svt w=(145n) l=45n nf=1 m=(1)
mp1 (Eb E net246 NW) g45p1svt w=(215n) l=45n nf=1 m=(1)
mp0 (net246 SE VDD NW) g45p1svt w=(215n) l=45n nf=1 m=(1)
mp22 (ECK ECKb VDD NW) g45p1svt w=(6.23u) l=45n nf=1 m=(1)
mp16 (n5 CKb net234 NW) g45p1svt w=(215n) l=45n nf=1 m=(1)
mp15 (net234 Eint VDD NW) g45p1svt w=(215n) l=45n nf=1 m=(1)
mp2 (CKb CK VDD NW) g45p1svt w=(215n) l=45n nf=1 m=(1)
mp10 (Eint n5 VDD NW) g45p1svt w=(620n) l=45n nf=1 m=(1)
mp3 (CKbb CKb VDD NW) g45p1svt w=(215n) l=45n nf=1 m=(1)
mp5 (n5 CKbb Eb NW) g45p1svt w=(215n) l=45n nf=1 m=(1)
mp21 (ECKb CKbb VDD NW) g45p1svt w=(1.56u) l=45n nf=1 m=(1)
mp20 (ECKb Eint VDD NW) g45p1svt w=(1.56u) l=45n nf=1 m=(1)
ends TLATNTSCAX16

// gsclib045_backbias/TLATNTSCAX2/schematic

simulator lang=spectre

subckt TLATNTSCAX2 CK E ECK SE VSS NW VDD
mn1 (Eb E VSS VSS) g45n1svt w=(145n) l=45n nf=1 m=(1)
mn0 (Eb SE VSS VSS) g45n1svt w=(145n) l=45n nf=1 m=(1)
mn22 (ECK ECKb VSS VSS) g45n1svt w=(520n) l=45n nf=1 m=(1)
mn21 (ECKb CKbb net271 VSS) g45n1svt w=(145n) l=45n nf=1 m=(1)
mn20 (net271 Eint VSS VSS) g45n1svt w=(145n) l=45n nf=1 m=(1)
mn16 (n5 CKbb net263 VSS) g45n1svt w=(145n) l=45n nf=1 m=(1)
mn15 (net263 Eint VSS VSS) g45n1svt w=(145n) l=45n nf=1 m=(1)
mn2 (CKb CK VSS VSS) g45n1svt w=(145n) l=45n nf=1 m=(1)
mn10 (Eint n5 VSS VSS) g45n1svt w=(145n) l=45n nf=1 m=(1)
mn5 (Eb CKb n5 VSS) g45n1svt w=(145n) l=45n nf=1 m=(1)
mn3 (CKbb CKb VSS VSS) g45n1svt w=(145n) l=45n nf=1 m=(1)
mp1 (Eb E net246 NW) g45p1svt w=(215n) l=45n nf=1 m=(1)
mp0 (net246 SE VDD NW) g45p1svt w=(215n) l=45n nf=1 m=(1)
mp22 (ECK ECKb VDD NW) g45p1svt w=(780n) l=45n nf=1 m=(1)
mp16 (n5 CKb net234 NW) g45p1svt w=(215n) l=45n nf=1 m=(1)
mp15 (net234 Eint VDD NW) g45p1svt w=(215n) l=45n nf=1 m=(1)
mp2 (CKb CK VDD NW) g45p1svt w=(215n) l=45n nf=1 m=(1)
mp10 (Eint n5 VDD NW) g45p1svt w=(215n) l=45n nf=1 m=(1)
mp3 (CKbb CKb VDD NW) g45p1svt w=(215n) l=45n nf=1 m=(1)
mp5 (n5 CKbb Eb NW) g45p1svt w=(215n) l=45n nf=1 m=(1)
mp21 (ECKb CKbb VDD NW) g45p1svt w=(215n) l=45n nf=1 m=(1)
mp20 (ECKb Eint VDD NW) g45p1svt w=(215n) l=45n nf=1 m=(1)
ends TLATNTSCAX2

// gsclib045_backbias/TLATNTSCAX20/schematic

simulator lang=spectre

subckt TLATNTSCAX20 CK E ECK SE VSS VDD NW
mn1 (Eb E VSS VSS) g45n1svt w=(145n) l=45n nf=1 m=(1)
mn0 (Eb SE VSS VSS) g45n1svt w=(145n) l=45n nf=1 m=(1)
mn22 (ECK ECKb VSS VSS) g45n1svt w=(5.185u) l=45n nf=1 m=(1)
mn21 (ECKb CKbb net271 VSS) g45n1svt w=(1.3u) l=45n nf=1 m=(1)
mn20 (net271 Eint VSS VSS) g45n1svt w=(1.3u) l=45n nf=1 m=(1)
mn16 (n5 CKbb net263 VSS) g45n1svt w=(145n) l=45n nf=1 m=(1)
mn15 (net263 Eint VSS VSS) g45n1svt w=(145n) l=45n nf=1 m=(1)
mn2 (CKb CK VSS VSS) g45n1svt w=(145n) l=45n nf=1 m=(1)
mn10 (Eint n5 VSS VSS) g45n1svt w=(520n) l=45n nf=1 m=(1)
mn5 (Eb CKb n5 VSS) g45n1svt w=(145n) l=45n nf=1 m=(1)
mn3 (CKbb CKb VSS VSS) g45n1svt w=(145n) l=45n nf=1 m=(1)
mp1 (Eb E net246 NW) g45p1svt w=(215n) l=45n nf=1 m=(1)
mp0 (net246 SE VDD NW) g45p1svt w=(215n) l=45n nf=1 m=(1)
mp22 (ECK ECKb VDD NW) g45p1svt w=(7.815u) l=45n nf=1 m=(1)
mp16 (n5 CKb net234 NW) g45p1svt w=(215n) l=45n nf=1 m=(1)
mp15 (net234 Eint VDD NW) g45p1svt w=(215n) l=45n nf=1 m=(1)
mp2 (CKb CK VDD NW) g45p1svt w=(215n) l=45n nf=1 m=(1)
mp10 (Eint n5 VDD NW) g45p1svt w=(780n) l=45n nf=1 m=(1)
mp3 (CKbb CKb VDD NW) g45p1svt w=(215n) l=45n nf=1 m=(1)
mp5 (n5 CKbb Eb NW) g45p1svt w=(215n) l=45n nf=1 m=(1)
mp21 (ECKb CKbb VDD NW) g45p1svt w=(1.95u) l=45n nf=1 m=(1)
mp20 (ECKb Eint VDD NW) g45p1svt w=(1.95u) l=45n nf=1 m=(1)
ends TLATNTSCAX20

// gsclib045_backbias/TLATNTSCAX3/schematic

simulator lang=spectre

subckt TLATNTSCAX3 CK E ECK SE VSS NW VDD
mn1 (Eb E VSS VSS) g45n1svt w=(145n) l=45n nf=1 m=(1)
mn0 (Eb SE VSS VSS) g45n1svt w=(145n) l=45n nf=1 m=(1)
mn22 (ECK ECKb VSS VSS) g45n1svt w=(780n) l=45n nf=1 m=(1)
mn21 (ECKb CKbb net271 VSS) g45n1svt w=(260n) l=45n nf=1 m=(1)
mn20 (net271 Eint VSS VSS) g45n1svt w=(260n) l=45n nf=1 m=(1)
mn16 (n5 CKbb net263 VSS) g45n1svt w=(145n) l=45n nf=1 m=(1)
mn15 (net263 Eint VSS VSS) g45n1svt w=(145n) l=45n nf=1 m=(1)
mn2 (CKb CK VSS VSS) g45n1svt w=(145n) l=45n nf=1 m=(1)
mn10 (Eint n5 VSS VSS) g45n1svt w=(145n) l=45n nf=1 m=(1)
mn5 (Eb CKb n5 VSS) g45n1svt w=(145n) l=45n nf=1 m=(1)
mn3 (CKbb CKb VSS VSS) g45n1svt w=(145n) l=45n nf=1 m=(1)
mp1 (Eb E net246 NW) g45p1svt w=(215n) l=45n nf=1 m=(1)
mp0 (net246 SE VDD NW) g45p1svt w=(215n) l=45n nf=1 m=(1)
mp22 (ECK ECKb VDD NW) g45p1svt w=(1.17u) l=45n nf=1 m=(1)
mp16 (n5 CKb net234 NW) g45p1svt w=(215n) l=45n nf=1 m=(1)
mp15 (net234 Eint VDD NW) g45p1svt w=(215n) l=45n nf=1 m=(1)
mp2 (CKb CK VDD NW) g45p1svt w=(215n) l=45n nf=1 m=(1)
mp10 (Eint n5 VDD NW) g45p1svt w=(215n) l=45n nf=1 m=(1)
mp3 (CKbb CKb VDD NW) g45p1svt w=(215n) l=45n nf=1 m=(1)
mp5 (n5 CKbb Eb NW) g45p1svt w=(215n) l=45n nf=1 m=(1)
mp21 (ECKb CKbb VDD NW) g45p1svt w=(390n) l=45n nf=1 m=(1)
mp20 (ECKb Eint VDD NW) g45p1svt w=(390n) l=45n nf=1 m=(1)
ends TLATNTSCAX3

// gsclib045_backbias/TLATNTSCAX4/schematic

simulator lang=spectre

subckt TLATNTSCAX4 CK E ECK SE NW VSS VDD
mn1 (Eb E VSS VSS) g45n1svt w=(145n) l=45n nf=1 m=(1)
mn0 (Eb SE VSS VSS) g45n1svt w=(145n) l=45n nf=1 m=(1)
mn22 (ECK ECKb VSS VSS) g45n1svt w=(1.04u) l=45n nf=1 m=(1)
mn21 (ECKb CKbb net271 VSS) g45n1svt w=(260n) l=45n nf=1 m=(1)
mn20 (net271 Eint VSS VSS) g45n1svt w=(260n) l=45n nf=1 m=(1)
mn16 (n5 CKbb net263 VSS) g45n1svt w=(145n) l=45n nf=1 m=(1)
mn15 (net263 Eint VSS VSS) g45n1svt w=(145n) l=45n nf=1 m=(1)
mn2 (CKb CK VSS VSS) g45n1svt w=(145n) l=45n nf=1 m=(1)
mn10 (Eint n5 VSS VSS) g45n1svt w=(145n) l=45n nf=1 m=(1)
mn5 (Eb CKb n5 VSS) g45n1svt w=(145n) l=45n nf=1 m=(1)
mn3 (CKbb CKb VSS VSS) g45n1svt w=(145n) l=45n nf=1 m=(1)
mp1 (Eb E net246 NW) g45p1svt w=(215n) l=45n nf=1 m=(1)
mp0 (net246 SE VDD NW) g45p1svt w=(215n) l=45n nf=1 m=(1)
mp22 (ECK ECKb VDD NW) g45p1svt w=(1.56u) l=45n nf=1 m=(1)
mp16 (n5 CKb net234 NW) g45p1svt w=(215n) l=45n nf=1 m=(1)
mp15 (net234 Eint VDD NW) g45p1svt w=(215n) l=45n nf=1 m=(1)
mp2 (CKb CK VDD NW) g45p1svt w=(215n) l=45n nf=1 m=(1)
mp10 (Eint n5 VDD NW) g45p1svt w=(215n) l=45n nf=1 m=(1)
mp3 (CKbb CKb VDD NW) g45p1svt w=(215n) l=45n nf=1 m=(1)
mp5 (n5 CKbb Eb NW) g45p1svt w=(215n) l=45n nf=1 m=(1)
mp21 (ECKb CKbb VDD NW) g45p1svt w=(390n) l=45n nf=1 m=(1)
mp20 (ECKb Eint VDD NW) g45p1svt w=(390n) l=45n nf=1 m=(1)
ends TLATNTSCAX4

// gsclib045_backbias/TLATNTSCAX6/schematic

simulator lang=spectre

subckt TLATNTSCAX6 CK E ECK SE VSS VDD NW
mn1 (Eb E VSS VSS) g45n1svt w=(145n) l=45n nf=1 m=(1)
mn0 (Eb SE VSS VSS) g45n1svt w=(145n) l=45n nf=1 m=(1)
mn22 (ECK ECKb VSS VSS) g45n1svt w=(1.55u) l=45n nf=1 m=(1)
mn21 (ECKb CKbb net271 VSS) g45n1svt w=(520n) l=45n nf=1 m=(1)
mn20 (net271 Eint VSS VSS) g45n1svt w=(520n) l=45n nf=1 m=(1)
mn16 (n5 CKbb net263 VSS) g45n1svt w=(145n) l=45n nf=1 m=(1)
mn15 (net263 Eint VSS VSS) g45n1svt w=(145n) l=45n nf=1 m=(1)
mn2 (CKb CK VSS VSS) g45n1svt w=(145n) l=45n nf=1 m=(1)
mn10 (Eint n5 VSS VSS) g45n1svt w=(205n) l=45n nf=1 m=(1)
mn5 (Eb CKb n5 VSS) g45n1svt w=(145n) l=45n nf=1 m=(1)
mn3 (CKbb CKb VSS VSS) g45n1svt w=(145n) l=45n nf=1 m=(1)
mp1 (Eb E net246 NW) g45p1svt w=(215n) l=45n nf=1 m=(1)
mp0 (net246 SE VDD NW) g45p1svt w=(215n) l=45n nf=1 m=(1)
mp22 (ECK ECKb VDD NW) g45p1svt w=(2.35u) l=45n nf=1 m=(1)
mp16 (n5 CKb net234 NW) g45p1svt w=(215n) l=45n nf=1 m=(1)
mp15 (net234 Eint VDD NW) g45p1svt w=(215n) l=45n nf=1 m=(1)
mp2 (CKb CK VDD NW) g45p1svt w=(215n) l=45n nf=1 m=(1)
mp10 (Eint n5 VDD NW) g45p1svt w=(310n) l=45n nf=1 m=(1)
mp3 (CKbb CKb VDD NW) g45p1svt w=(215n) l=45n nf=1 m=(1)
mp5 (n5 CKbb Eb NW) g45p1svt w=(215n) l=45n nf=1 m=(1)
mp21 (ECKb CKbb VDD NW) g45p1svt w=(780n) l=45n nf=1 m=(1)
mp20 (ECKb Eint VDD NW) g45p1svt w=(780n) l=45n nf=1 m=(1)
ends TLATNTSCAX6

// gsclib045_backbias/TLATNTSCAX8/schematic

simulator lang=spectre

subckt TLATNTSCAX8 CK E ECK SE VSS VDD NW
mn1 (Eb E VSS VSS) g45n1svt w=(145n) l=45n nf=1 m=(1)
mn0 (Eb SE VSS VSS) g45n1svt w=(145n) l=45n nf=1 m=(1)
mn22 (ECK ECKb VSS VSS) g45n1svt w=(2.065u) l=45n nf=1 m=(1)
mn21 (ECKb CKbb net271 VSS) g45n1svt w=(520n) l=45n nf=1 m=(1)
mn20 (net271 Eint VSS VSS) g45n1svt w=(520n) l=45n nf=1 m=(1)
mn16 (n5 CKbb net263 VSS) g45n1svt w=(145n) l=45n nf=1 m=(1)
mn15 (net263 Eint VSS VSS) g45n1svt w=(145n) l=45n nf=1 m=(1)
mn2 (CKb CK VSS VSS) g45n1svt w=(145n) l=45n nf=1 m=(1)
mn10 (Eint n5 VSS VSS) g45n1svt w=(205n) l=45n nf=1 m=(1)
mn5 (Eb CKb n5 VSS) g45n1svt w=(145n) l=45n nf=1 m=(1)
mn3 (CKbb CKb VSS VSS) g45n1svt w=(145n) l=45n nf=1 m=(1)
mp1 (Eb E net246 NW) g45p1svt w=(215n) l=45n nf=1 m=(1)
mp0 (net246 SE VDD NW) g45p1svt w=(215n) l=45n nf=1 m=(1)
mp22 (ECK ECKb VDD NW) g45p1svt w=(3.115u) l=45n nf=1 m=(1)
mp16 (n5 CKb net234 NW) g45p1svt w=(215n) l=45n nf=1 m=(1)
mp15 (net234 Eint VDD NW) g45p1svt w=(215n) l=45n nf=1 m=(1)
mp2 (CKb CK VDD NW) g45p1svt w=(215n) l=45n nf=1 m=(1)
mp10 (Eint n5 VDD NW) g45p1svt w=(310n) l=45n nf=1 m=(1)
mp3 (CKbb CKb VDD NW) g45p1svt w=(215n) l=45n nf=1 m=(1)
mp5 (n5 CKbb Eb NW) g45p1svt w=(215n) l=45n nf=1 m=(1)
mp21 (ECKb CKbb VDD NW) g45p1svt w=(780n) l=45n nf=1 m=(1)
mp20 (ECKb Eint VDD NW) g45p1svt w=(780n) l=45n nf=1 m=(1)
ends TLATNTSCAX8

// gsclib045_backbias/TLATNX1/schematic

simulator lang=spectre

subckt TLATNX1 D GN Q QN VDD VSS NW
mn5 (net257 D VSS VSS) g45n1svt w=(145n) l=45n nf=1 m=(1)
mn6 (n0 GNb net257 VSS) g45n1svt w=(145n) l=45n nf=1 m=(1)
mn16 (n0 GNbb net245 VSS) g45n1svt w=(145n) l=45n nf=1 m=(1)
mn15 (net245 Qint VSS VSS) g45n1svt w=(145n) l=45n nf=1 m=(1)
mn22 (QN Qint VSS VSS) g45n1svt w=(260n) l=45n nf=1 m=(1)
mn21 (Q Qbint VSS VSS) g45n1svt w=(260n) l=45n nf=1 m=(1)
mn0 (GNb GN VSS VSS) g45n1svt w=(145n) l=45n nf=1 m=(1)
mn1 (GNbb GNb VSS VSS) g45n1svt w=(145n) l=45n nf=1 m=(1)
mn10 (Qint n0 VSS VSS) g45n1svt w=(145n) l=45n nf=1 m=(1)
mn20 (Qbint Qint VSS VSS) g45n1svt w=(260n) l=45n nf=1 m=(1)
mp6 (n0 GNbb net220 NW) g45p1svt w=(215n) l=45n nf=1 m=(1)
mp5 (net220 D VDD NW) g45p1svt w=(215n) l=45n nf=1 m=(1)
mp16 (n0 GNb net212 NW) g45p1svt w=(215n) l=45n nf=1 m=(1)
mp15 (net212 Qint VDD NW) g45p1svt w=(215n) l=45n nf=1 m=(1)
mp22 (QN Qint VDD NW) g45p1svt w=(390n) l=45n nf=1 m=(1)
mp21 (Q Qbint VDD NW) g45p1svt w=(390n) l=45n nf=1 m=(1)
mp0 (GNb GN VDD NW) g45p1svt w=(215n) l=45n nf=1 m=(1)
mp1 (GNbb GNb VDD NW) g45p1svt w=(215n) l=45n nf=1 m=(1)
mp10 (Qint n0 VDD NW) g45p1svt w=(215n) l=45n nf=1 m=(1)
mp20 (Qbint Qint VDD NW) g45p1svt w=(390n) l=45n nf=1 m=(1)
ends TLATNX1

// gsclib045_backbias/TLATNX2/schematic

simulator lang=spectre

subckt TLATNX2 D GN Q QN VSS NW VDD
mn5 (net257 D VSS VSS) g45n1svt w=(145n) l=45n nf=1 m=(1)
mn6 (n0 GNb net257 VSS) g45n1svt w=(145n) l=45n nf=1 m=(1)
mn16 (n0 GNbb net245 VSS) g45n1svt w=(145n) l=45n nf=1 m=(1)
mn15 (net245 Qint VSS VSS) g45n1svt w=(145n) l=45n nf=1 m=(1)
mn22 (QN Qint VSS VSS) g45n1svt w=(520n) l=45n nf=1 m=(1)
mn21 (Q Qbint VSS VSS) g45n1svt w=(520n) l=45n nf=1 m=(1)
mn0 (GNb GN VSS VSS) g45n1svt w=(145n) l=45n nf=1 m=(1)
mn1 (GNbb GNb VSS VSS) g45n1svt w=(145n) l=45n nf=1 m=(1)
mn10 (Qint n0 VSS VSS) g45n1svt w=(205n) l=45n nf=1 m=(1)
mn20 (Qbint Qint VSS VSS) g45n1svt w=(520n) l=45n nf=1 m=(1)
mp6 (n0 GNbb net220 NW) g45p1svt w=(215n) l=45n nf=1 m=(1)
mp5 (net220 D VDD NW) g45p1svt w=(215n) l=45n nf=1 m=(1)
mp16 (n0 GNb net212 NW) g45p1svt w=(215n) l=45n nf=1 m=(1)
mp15 (net212 Qint VDD NW) g45p1svt w=(215n) l=45n nf=1 m=(1)
mp22 (QN Qint VDD NW) g45p1svt w=(780n) l=45n nf=1 m=(1)
mp21 (Q Qbint VDD NW) g45p1svt w=(780n) l=45n nf=1 m=(1)
mp0 (GNb GN VDD NW) g45p1svt w=(215n) l=45n nf=1 m=(1)
mp1 (GNbb GNb VDD NW) g45p1svt w=(215n) l=45n nf=1 m=(1)
mp10 (Qint n0 VDD NW) g45p1svt w=(310n) l=45n nf=1 m=(1)
mp20 (Qbint Qint VDD NW) g45p1svt w=(780n) l=45n nf=1 m=(1)
ends TLATNX2

// gsclib045_backbias/TLATNX4/schematic

simulator lang=spectre

subckt TLATNX4 D GN Q QN VSS NW VDD
mn5 (net257 D VSS VSS) g45n1svt w=(145n) l=45n nf=1 m=(1)
mn6 (n0 GNb net257 VSS) g45n1svt w=(145n) l=45n nf=1 m=(1)
mn16 (n0 GNbb net245 VSS) g45n1svt w=(145n) l=45n nf=1 m=(1)
mn15 (net245 Qint VSS VSS) g45n1svt w=(145n) l=45n nf=1 m=(1)
mn22 (QN Qint VSS VSS) g45n1svt w=(1.04u) l=45n nf=1 m=(1)
mn21 (Q Qbint VSS VSS) g45n1svt w=(1.04u) l=45n nf=1 m=(1)
mn0 (GNb GN VSS VSS) g45n1svt w=(145n) l=45n nf=1 m=(1)
mn1 (GNbb GNb VSS VSS) g45n1svt w=(145n) l=45n nf=1 m=(1)
mn10 (Qint n0 VSS VSS) g45n1svt w=(410n) l=45n nf=1 m=(1)
mn20 (Qbint Qint VSS VSS) g45n1svt w=(1.04u) l=45n nf=1 m=(1)
mp6 (n0 GNbb net220 NW) g45p1svt w=(215n) l=45n nf=1 m=(1)
mp5 (net220 D VDD NW) g45p1svt w=(215n) l=45n nf=1 m=(1)
mp16 (n0 GNb net212 NW) g45p1svt w=(215n) l=45n nf=1 m=(1)
mp15 (net212 Qint VDD NW) g45p1svt w=(215n) l=45n nf=1 m=(1)
mp22 (QN Qint VDD NW) g45p1svt w=(1.56u) l=45n nf=1 m=(1)
mp21 (Q Qbint VDD NW) g45p1svt w=(1.56u) l=45n nf=1 m=(1)
mp0 (GNb GN VDD NW) g45p1svt w=(215n) l=45n nf=1 m=(1)
mp1 (GNbb GNb VDD NW) g45p1svt w=(215n) l=45n nf=1 m=(1)
mp10 (Qint n0 VDD NW) g45p1svt w=(620n) l=45n nf=1 m=(1)
mp20 (Qbint Qint VDD NW) g45p1svt w=(1.56u) l=45n nf=1 m=(1)
ends TLATNX4

// gsclib045_backbias/TLATNXL/schematic

simulator lang=spectre

subckt TLATNXL D GN Q QN VSS NW VDD
mn5 (net257 D VSS VSS) g45n1svt w=(145n) l=45n nf=1 m=(1)
mn6 (n0 GNb net257 VSS) g45n1svt w=(145n) l=45n nf=1 m=(1)
mn16 (n0 GNbb net245 VSS) g45n1svt w=(145n) l=45n nf=1 m=(1)
mn15 (net245 Qint VSS VSS) g45n1svt w=(145n) l=45n nf=1 m=(1)
mn22 (QN Qint VSS VSS) g45n1svt w=(145n) l=45n nf=1 m=(1)
mn21 (Q Qbint VSS VSS) g45n1svt w=(145n) l=45n nf=1 m=(1)
mn0 (GNb GN VSS VSS) g45n1svt w=(145n) l=45n nf=1 m=(1)
mn1 (GNbb GNb VSS VSS) g45n1svt w=(145n) l=45n nf=1 m=(1)
mn10 (Qint n0 VSS VSS) g45n1svt w=(145n) l=45n nf=1 m=(1)
mn20 (Qbint Qint VSS VSS) g45n1svt w=(145n) l=45n nf=1 m=(1)
mp6 (n0 GNbb net220 NW) g45p1svt w=(215n) l=45n nf=1 m=(1)
mp5 (net220 D VDD NW) g45p1svt w=(215n) l=45n nf=1 m=(1)
mp16 (n0 GNb net212 NW) g45p1svt w=(215n) l=45n nf=1 m=(1)
mp15 (net212 Qint VDD NW) g45p1svt w=(215n) l=45n nf=1 m=(1)
mp22 (QN Qint VDD NW) g45p1svt w=(215n) l=45n nf=1 m=(1)
mp21 (Q Qbint VDD NW) g45p1svt w=(215n) l=45n nf=1 m=(1)
mp0 (GNb GN VDD NW) g45p1svt w=(215n) l=45n nf=1 m=(1)
mp1 (GNbb GNb VDD NW) g45p1svt w=(215n) l=45n nf=1 m=(1)
mp10 (Qint n0 VDD NW) g45p1svt w=(215n) l=45n nf=1 m=(1)
mp20 (Qbint Qint VDD NW) g45p1svt w=(215n) l=45n nf=1 m=(1)
ends TLATNXL

// gsclib045_backbias/TLATSRX1/schematic

simulator lang=spectre

subckt TLATSRX1 D G Q QN RN SN VDD VSS NW
mn5 (net191 D VSS VSS) g45n1svt w=(145n) l=45n nf=1 m=(1)
mn6 (n5 Gbb net191 VSS) g45n1svt w=(145n) l=45n nf=1 m=(1)
mn10 (net183 SN VSS VSS) g45n1svt w=(145n) l=45n nf=1 m=(1)
mn11 (Qint n5 net183 VSS) g45n1svt w=(145n) l=45n nf=1 m=(1)
mn17 (n5 Gb net171 VSS) g45n1svt w=(145n) l=45n nf=1 m=(1)
mn16 (net171 Qint net167 VSS) g45n1svt w=(145n) l=45n nf=1 m=(1)
mn15 (net167 RN VSS VSS) g45n1svt w=(145n) l=45n nf=1 m=(1)
mn1 (Gb G net159 VSS) g45n1svt w=(145n) l=45n nf=1 m=(1)
mn0 (net159 RN VSS VSS) g45n1svt w=(145n) l=45n nf=1 m=(1)
mn22 (QN Qint VSS VSS) g45n1svt w=(260n) l=45n nf=1 m=(1)
mn21 (Q Qbint VSS VSS) g45n1svt w=(260n) l=45n nf=1 m=(1)
mn2 (Gbb Gb VSS VSS) g45n1svt w=(145n) l=45n nf=1 m=(1)
mn20 (Qbint Qint VSS VSS) g45n1svt w=(260n) l=45n nf=1 m=(1)
mp6 (n5 Gb net142 NW) g45p1svt w=(215n) l=45n nf=1 m=(1)
mp5 (net142 D VDD NW) g45p1svt w=(215n) l=45n nf=1 m=(1)
mp10 (Qint SN VDD NW) g45p1svt w=(215n) l=45n nf=1 m=(1)
mp1 (Gb G VDD NW) g45p1svt w=(215n) l=45n nf=1 m=(1)
mp22 (QN Qint VDD NW) g45p1svt w=(390n) l=45n nf=1 m=(1)
mp21 (Q Qbint VDD NW) g45p1svt w=(390n) l=45n nf=1 m=(1)
mp2 (Gbb Gb VDD NW) g45p1svt w=(215n) l=45n nf=1 m=(1)
mp17 (n5 Gbb net103 NW) g45p1svt w=(215n) l=45n nf=1 m=(1)
mp16 (net103 Qint VDD NW) g45p1svt w=(215n) l=45n nf=1 m=(1)
mp15 (net103 RN VDD NW) g45p1svt w=(215n) l=45n nf=1 m=(1)
mp0 (Gb RN VDD NW) g45p1svt w=(215n) l=45n nf=1 m=(1)
mp20 (Qbint Qint VDD NW) g45p1svt w=(390n) l=45n nf=1 m=(1)
mp11 (Qint n5 VDD NW) g45p1svt w=(215n) l=45n nf=1 m=(1)
ends TLATSRX1

// gsclib045_backbias/TLATSRX2/schematic

simulator lang=spectre

subckt TLATSRX2 D G Q QN RN SN VSS VDD NW
mn5 (net191 D VSS VSS) g45n1svt w=(145n) l=45n nf=1 m=(1)
mn6 (n5 Gbb net191 VSS) g45n1svt w=(145n) l=45n nf=1 m=(1)
mn10 (net183 SN VSS VSS) g45n1svt w=(205n) l=45n nf=1 m=(1)
mn11 (Qint n5 net183 VSS) g45n1svt w=(205n) l=45n nf=1 m=(1)
mn17 (n5 Gb net171 VSS) g45n1svt w=(145n) l=45n nf=1 m=(1)
mn16 (net171 Qint net167 VSS) g45n1svt w=(145n) l=45n nf=1 m=(1)
mn15 (net167 RN VSS VSS) g45n1svt w=(145n) l=45n nf=1 m=(1)
mn1 (Gb G net159 VSS) g45n1svt w=(145n) l=45n nf=1 m=(1)
mn0 (net159 RN VSS VSS) g45n1svt w=(145n) l=45n nf=1 m=(1)
mn22 (QN Qint VSS VSS) g45n1svt w=(520n) l=45n nf=1 m=(1)
mn21 (Q Qbint VSS VSS) g45n1svt w=(520n) l=45n nf=1 m=(1)
mn2 (Gbb Gb VSS VSS) g45n1svt w=(145n) l=45n nf=1 m=(1)
mn20 (Qbint Qint VSS VSS) g45n1svt w=(520n) l=45n nf=1 m=(1)
mp6 (n5 Gb net142 NW) g45p1svt w=(215n) l=45n nf=1 m=(1)
mp5 (net142 D VDD NW) g45p1svt w=(215n) l=45n nf=1 m=(1)
mp10 (Qint SN VDD NW) g45p1svt w=(310n) l=45n nf=1 m=(1)
mp1 (Gb G VDD NW) g45p1svt w=(215n) l=45n nf=1 m=(1)
mp22 (QN Qint VDD NW) g45p1svt w=(780n) l=45n nf=1 m=(1)
mp21 (Q Qbint VDD NW) g45p1svt w=(780n) l=45n nf=1 m=(1)
mp2 (Gbb Gb VDD NW) g45p1svt w=(215n) l=45n nf=1 m=(1)
mp17 (n5 Gbb net103 NW) g45p1svt w=(215n) l=45n nf=1 m=(1)
mp16 (net103 Qint VDD NW) g45p1svt w=(215n) l=45n nf=1 m=(1)
mp15 (net103 RN VDD NW) g45p1svt w=(215n) l=45n nf=1 m=(1)
mp0 (Gb RN VDD NW) g45p1svt w=(215n) l=45n nf=1 m=(1)
mp20 (Qbint Qint VDD NW) g45p1svt w=(780n) l=45n nf=1 m=(1)
mp11 (Qint n5 VDD NW) g45p1svt w=(310n) l=45n nf=1 m=(1)
ends TLATSRX2

// gsclib045_backbias/TLATSRX4/schematic

simulator lang=spectre

subckt TLATSRX4 D G Q QN RN SN VSS VDD NW
mn5 (net191 D VSS VSS) g45n1svt w=(145n) l=45n nf=1 m=(1)
mn6 (n5 Gbb net191 VSS) g45n1svt w=(145n) l=45n nf=1 m=(1)
mn10 (net183 SN VSS VSS) g45n1svt w=(410n) l=45n nf=1 m=(1)
mn11 (Qint n5 net183 VSS) g45n1svt w=(410n) l=45n nf=1 m=(1)
mn17 (n5 Gb net171 VSS) g45n1svt w=(145n) l=45n nf=1 m=(1)
mn16 (net171 Qint net167 VSS) g45n1svt w=(145n) l=45n nf=1 m=(1)
mn15 (net167 RN VSS VSS) g45n1svt w=(145n) l=45n nf=1 m=(1)
mn1 (Gb G net159 VSS) g45n1svt w=(145n) l=45n nf=1 m=(1)
mn0 (net159 RN VSS VSS) g45n1svt w=(145n) l=45n nf=1 m=(1)
mn22 (QN Qint VSS VSS) g45n1svt w=(1.04u) l=45n nf=1 m=(1)
mn21 (Q Qbint VSS VSS) g45n1svt w=(1.04u) l=45n nf=1 m=(1)
mn2 (Gbb Gb VSS VSS) g45n1svt w=(145n) l=45n nf=1 m=(1)
mn20 (Qbint Qint VSS VSS) g45n1svt w=(1.04u) l=45n nf=1 m=(1)
mp6 (n5 Gb net142 NW) g45p1svt w=(215n) l=45n nf=1 m=(1)
mp5 (net142 D VDD NW) g45p1svt w=(215n) l=45n nf=1 m=(1)
mp10 (Qint SN VDD NW) g45p1svt w=(620n) l=45n nf=1 m=(1)
mp1 (Gb G VDD NW) g45p1svt w=(215n) l=45n nf=1 m=(1)
mp22 (QN Qint VDD NW) g45p1svt w=(1.56u) l=45n nf=1 m=(1)
mp21 (Q Qbint VDD NW) g45p1svt w=(1.56u) l=45n nf=1 m=(1)
mp2 (Gbb Gb VDD NW) g45p1svt w=(215n) l=45n nf=1 m=(1)
mp17 (n5 Gbb net103 NW) g45p1svt w=(215n) l=45n nf=1 m=(1)
mp16 (net103 Qint VDD NW) g45p1svt w=(215n) l=45n nf=1 m=(1)
mp15 (net103 RN VDD NW) g45p1svt w=(215n) l=45n nf=1 m=(1)
mp0 (Gb RN VDD NW) g45p1svt w=(215n) l=45n nf=1 m=(1)
mp20 (Qbint Qint VDD NW) g45p1svt w=(1.56u) l=45n nf=1 m=(1)
mp11 (Qint n5 VDD NW) g45p1svt w=(620n) l=45n nf=1 m=(1)
ends TLATSRX4

// gsclib045_backbias/TLATSRXL/schematic

simulator lang=spectre

subckt TLATSRXL D G Q QN RN SN VSS VDD NW
mn5 (net191 D VSS VSS) g45n1svt w=(145n) l=45n nf=1 m=(1)
mn6 (n5 Gbb net191 VSS) g45n1svt w=(145n) l=45n nf=1 m=(1)
mn10 (net183 SN VSS VSS) g45n1svt w=(145n) l=45n nf=1 m=(1)
mn11 (Qint n5 net183 VSS) g45n1svt w=(145n) l=45n nf=1 m=(1)
mn17 (n5 Gb net171 VSS) g45n1svt w=(145n) l=45n nf=1 m=(1)
mn16 (net171 Qint net167 VSS) g45n1svt w=(145n) l=45n nf=1 m=(1)
mn15 (net167 RN VSS VSS) g45n1svt w=(145n) l=45n nf=1 m=(1)
mn1 (Gb G net159 VSS) g45n1svt w=(145n) l=45n nf=1 m=(1)
mn0 (net159 RN VSS VSS) g45n1svt w=(145n) l=45n nf=1 m=(1)
mn22 (QN Qint VSS VSS) g45n1svt w=(145n) l=45n nf=1 m=(1)
mn21 (Q Qbint VSS VSS) g45n1svt w=(145n) l=45n nf=1 m=(1)
mn2 (Gbb Gb VSS VSS) g45n1svt w=(145n) l=45n nf=1 m=(1)
mn20 (Qbint Qint VSS VSS) g45n1svt w=(145n) l=45n nf=1 m=(1)
mp6 (n5 Gb net142 NW) g45p1svt w=(215n) l=45n nf=1 m=(1)
mp5 (net142 D VDD NW) g45p1svt w=(215n) l=45n nf=1 m=(1)
mp10 (Qint SN VDD NW) g45p1svt w=(215n) l=45n nf=1 m=(1)
mp1 (Gb G VDD NW) g45p1svt w=(215n) l=45n nf=1 m=(1)
mp22 (QN Qint VDD NW) g45p1svt w=(215n) l=45n nf=1 m=(1)
mp21 (Q Qbint VDD NW) g45p1svt w=(215n) l=45n nf=1 m=(1)
mp2 (Gbb Gb VDD NW) g45p1svt w=(215n) l=45n nf=1 m=(1)
mp17 (n5 Gbb net103 NW) g45p1svt w=(215n) l=45n nf=1 m=(1)
mp16 (net103 Qint VDD NW) g45p1svt w=(215n) l=45n nf=1 m=(1)
mp15 (net103 RN VDD NW) g45p1svt w=(215n) l=45n nf=1 m=(1)
mp0 (Gb RN VDD NW) g45p1svt w=(215n) l=45n nf=1 m=(1)
mp20 (Qbint Qint VDD NW) g45p1svt w=(215n) l=45n nf=1 m=(1)
mp11 (Qint n5 VDD NW) g45p1svt w=(215n) l=45n nf=1 m=(1)
ends TLATSRXL

// gsclib045_backbias/TLATX1/schematic

simulator lang=spectre

subckt TLATX1 D G Q QN VSS NW VDD
mn5 (net257 D VSS VSS) g45n1svt w=(145n) l=45n nf=1 m=(1)
mn6 (n0 Gbb net257 VSS) g45n1svt w=(145n) l=45n nf=1 m=(1)
mn16 (n0 Gb net245 VSS) g45n1svt w=(145n) l=45n nf=1 m=(1)
mn15 (net245 Qint VSS VSS) g45n1svt w=(145n) l=45n nf=1 m=(1)
mn22 (QN Qint VSS VSS) g45n1svt w=(260n) l=45n nf=1 m=(1)
mn21 (Q Qbint VSS VSS) g45n1svt w=(260n) l=45n nf=1 m=(1)
mn0 (Gb G VSS VSS) g45n1svt w=(145n) l=45n nf=1 m=(1)
mn10 (Qint n0 VSS VSS) g45n1svt w=(145n) l=45n nf=1 m=(1)
mn20 (Qbint Qint VSS VSS) g45n1svt w=(260n) l=45n nf=1 m=(1)
mn1 (Gbb Gb VSS VSS) g45n1svt w=(145n) l=45n nf=1 m=(1)
mp6 (n0 Gb net220 NW) g45p1svt w=(215n) l=45n nf=1 m=(1)
mp5 (net220 D VDD NW) g45p1svt w=(215n) l=45n nf=1 m=(1)
mp16 (n0 Gbb net212 NW) g45p1svt w=(215n) l=45n nf=1 m=(1)
mp15 (net212 Qint VDD NW) g45p1svt w=(215n) l=45n nf=1 m=(1)
mp22 (QN Qint VDD NW) g45p1svt w=(390n) l=45n nf=1 m=(1)
mp21 (Q Qbint VDD NW) g45p1svt w=(390n) l=45n nf=1 m=(1)
mp0 (Gb G VDD NW) g45p1svt w=(215n) l=45n nf=1 m=(1)
mp1 (Gbb Gb VDD NW) g45p1svt w=(215n) l=45n nf=1 m=(1)
mp10 (Qint n0 VDD NW) g45p1svt w=(215n) l=45n nf=1 m=(1)
mp20 (Qbint Qint VDD NW) g45p1svt w=(390n) l=45n nf=1 m=(1)
ends TLATX1

// gsclib045_backbias/TLATX2/schematic

simulator lang=spectre

subckt TLATX2 D G Q QN VDD NW VSS
mn5 (net257 D VSS VSS) g45n1svt w=(145n) l=45n nf=1 m=(1)
mn6 (n0 Gbb net257 VSS) g45n1svt w=(145n) l=45n nf=1 m=(1)
mn16 (n0 Gb net245 VSS) g45n1svt w=(145n) l=45n nf=1 m=(1)
mn15 (net245 Qint VSS VSS) g45n1svt w=(145n) l=45n nf=1 m=(1)
mn22 (QN Qint VSS VSS) g45n1svt w=(520n) l=45n nf=1 m=(1)
mn21 (Q Qbint VSS VSS) g45n1svt w=(520n) l=45n nf=1 m=(1)
mn0 (Gb G VSS VSS) g45n1svt w=(145n) l=45n nf=1 m=(1)
mn10 (Qint n0 VSS VSS) g45n1svt w=(205n) l=45n nf=1 m=(1)
mn20 (Qbint Qint VSS VSS) g45n1svt w=(520n) l=45n nf=1 m=(1)
mn1 (Gbb Gb VSS VSS) g45n1svt w=(145n) l=45n nf=1 m=(1)
mp6 (n0 Gb net220 NW) g45p1svt w=(215n) l=45n nf=1 m=(1)
mp5 (net220 D VDD NW) g45p1svt w=(215n) l=45n nf=1 m=(1)
mp16 (n0 Gbb net212 NW) g45p1svt w=(215n) l=45n nf=1 m=(1)
mp15 (net212 Qint VDD NW) g45p1svt w=(215n) l=45n nf=1 m=(1)
mp22 (QN Qint VDD NW) g45p1svt w=(780n) l=45n nf=1 m=(1)
mp21 (Q Qbint VDD NW) g45p1svt w=(780n) l=45n nf=1 m=(1)
mp0 (Gb G VDD NW) g45p1svt w=(215n) l=45n nf=1 m=(1)
mp1 (Gbb Gb VDD NW) g45p1svt w=(215n) l=45n nf=1 m=(1)
mp10 (Qint n0 VDD NW) g45p1svt w=(310n) l=45n nf=1 m=(1)
mp20 (Qbint Qint VDD NW) g45p1svt w=(780n) l=45n nf=1 m=(1)
ends TLATX2

// gsclib045_backbias/TLATX4/schematic

simulator lang=spectre

subckt TLATX4 D G Q QN VDD NW VSS
mn5 (net257 D VSS VSS) g45n1svt w=(145n) l=45n nf=1 m=(1)
mn6 (n0 Gbb net257 VSS) g45n1svt w=(145n) l=45n nf=1 m=(1)
mn16 (n0 Gb net245 VSS) g45n1svt w=(145n) l=45n nf=1 m=(1)
mn15 (net245 Qint VSS VSS) g45n1svt w=(145n) l=45n nf=1 m=(1)
mn22 (QN Qint VSS VSS) g45n1svt w=(1.04u) l=45n nf=1 m=(1)
mn21 (Q Qbint VSS VSS) g45n1svt w=(1.04u) l=45n nf=1 m=(1)
mn0 (Gb G VSS VSS) g45n1svt w=(145n) l=45n nf=1 m=(1)
mn10 (Qint n0 VSS VSS) g45n1svt w=(410n) l=45n nf=1 m=(1)
mn20 (Qbint Qint VSS VSS) g45n1svt w=(1.04u) l=45n nf=1 m=(1)
mn1 (Gbb Gb VSS VSS) g45n1svt w=(145n) l=45n nf=1 m=(1)
mp6 (n0 Gb net220 NW) g45p1svt w=(215n) l=45n nf=1 m=(1)
mp5 (net220 D VDD NW) g45p1svt w=(215n) l=45n nf=1 m=(1)
mp16 (n0 Gbb net212 NW) g45p1svt w=(215n) l=45n nf=1 m=(1)
mp15 (net212 Qint VDD NW) g45p1svt w=(215n) l=45n nf=1 m=(1)
mp22 (QN Qint VDD NW) g45p1svt w=(1.56u) l=45n nf=1 m=(1)
mp21 (Q Qbint VDD NW) g45p1svt w=(1.56u) l=45n nf=1 m=(1)
mp0 (Gb G VDD NW) g45p1svt w=(215n) l=45n nf=1 m=(1)
mp1 (Gbb Gb VDD NW) g45p1svt w=(215n) l=45n nf=1 m=(1)
mp10 (Qint n0 VDD NW) g45p1svt w=(620n) l=45n nf=1 m=(1)
mp20 (Qbint Qint VDD NW) g45p1svt w=(1.56u) l=45n nf=1 m=(1)
ends TLATX4

// gsclib045_backbias/TLATXL/schematic

simulator lang=spectre

subckt TLATXL D G Q QN VDD NW VSS
mn5 (net257 D VSS VSS) g45n1svt w=(145n) l=45n nf=1 m=(1)
mn6 (n0 Gbb net257 VSS) g45n1svt w=(145n) l=45n nf=1 m=(1)
mn16 (n0 Gb net245 VSS) g45n1svt w=(145n) l=45n nf=1 m=(1)
mn15 (net245 Qint VSS VSS) g45n1svt w=(145n) l=45n nf=1 m=(1)
mn22 (QN Qint VSS VSS) g45n1svt w=(145n) l=45n nf=1 m=(1)
mn21 (Q Qbint VSS VSS) g45n1svt w=(145n) l=45n nf=1 m=(1)
mn0 (Gb G VSS VSS) g45n1svt w=(145n) l=45n nf=1 m=(1)
mn10 (Qint n0 VSS VSS) g45n1svt w=(145n) l=45n nf=1 m=(1)
mn20 (Qbint Qint VSS VSS) g45n1svt w=(145n) l=45n nf=1 m=(1)
mn1 (Gbb Gb VSS VSS) g45n1svt w=(145n) l=45n nf=1 m=(1)
mp6 (n0 Gb net220 NW) g45p1svt w=(215n) l=45n nf=1 m=(1)
mp5 (net220 D VDD NW) g45p1svt w=(215n) l=45n nf=1 m=(1)
mp16 (n0 Gbb net212 NW) g45p1svt w=(215n) l=45n nf=1 m=(1)
mp15 (net212 Qint VDD NW) g45p1svt w=(215n) l=45n nf=1 m=(1)
mp22 (QN Qint VDD NW) g45p1svt w=(215n) l=45n nf=1 m=(1)
mp21 (Q Qbint VDD NW) g45p1svt w=(215n) l=45n nf=1 m=(1)
mp0 (Gb G VDD NW) g45p1svt w=(215n) l=45n nf=1 m=(1)
mp1 (Gbb Gb VDD NW) g45p1svt w=(215n) l=45n nf=1 m=(1)
mp10 (Qint n0 VDD NW) g45p1svt w=(215n) l=45n nf=1 m=(1)
mp20 (Qbint Qint VDD NW) g45p1svt w=(215n) l=45n nf=1 m=(1)
ends TLATXL

// gsclib045_backbias/XNOR2X1/schematic

simulator lang=spectre

subckt XNOR2X1 A B Y VDD NW VSS
mn1 (n2 B VSS VSS) g45n1svt w=(145n) l=45n nf=1 m=(1)
mn2 (net145 n1 VSS VSS) g45n1svt w=(145n) l=45n nf=1 m=(1)
mn3 (n0 n2 net145 VSS) g45n1svt w=(145n) l=45n nf=1 m=(1)
mn5 (Y n0 VSS VSS) g45n1svt w=(260n) l=45n nf=1 m=(1)
mn0 (n1 A VSS VSS) g45n1svt w=(145n) l=45n nf=1 m=(1)
mn4 (n0 B n1 VSS) g45n1svt w=(145n) l=45n nf=1 m=(1)
mp0 (n1 A VDD NW) g45p1svt w=(215n) l=45n nf=1 m=(1)
mp4 (n1 n2 n0 NW) g45p1svt w=(215n) l=45n nf=1 m=(1)
mp2 (net112 n1 VDD NW) g45p1svt w=(215n) l=45n nf=1 m=(1)
mp1 (n2 B VDD NW) g45p1svt w=(215n) l=45n nf=1 m=(1)
mp3 (n0 B net112 NW) g45p1svt w=(215n) l=45n nf=1 m=(1)
mp5 (Y n0 VDD NW) g45p1svt w=(390n) l=45n nf=1 m=(1)
ends XNOR2X1

// gsclib045_backbias/XNOR2X2/schematic

simulator lang=spectre

subckt XNOR2X2 A B Y NW VDD VSS
mn1 (n2 B VSS VSS) g45n1svt w=(145n) l=45n nf=1 m=(1)
mn2 (net145 n1 VSS VSS) g45n1svt w=(145n) l=45n nf=1 m=(1)
mn3 (n0 n2 net145 VSS) g45n1svt w=(145n) l=45n nf=1 m=(1)
mn5 (Y n0 VSS VSS) g45n1svt w=(520n) l=45n nf=1 m=(1)
mn0 (n1 A VSS VSS) g45n1svt w=(145n) l=45n nf=1 m=(1)
mn4 (n0 B n1 VSS) g45n1svt w=(145n) l=45n nf=1 m=(1)
mp0 (n1 A VDD NW) g45p1svt w=(215n) l=45n nf=1 m=(1)
mp4 (n1 n2 n0 NW) g45p1svt w=(215n) l=45n nf=1 m=(1)
mp2 (net112 n1 VDD NW) g45p1svt w=(215n) l=45n nf=1 m=(1)
mp1 (n2 B VDD NW) g45p1svt w=(215n) l=45n nf=1 m=(1)
mp3 (n0 B net112 NW) g45p1svt w=(215n) l=45n nf=1 m=(1)
mp5 (Y n0 VDD NW) g45p1svt w=(780n) l=45n nf=1 m=(1)
ends XNOR2X2

// gsclib045_backbias/XNOR2X4/schematic

simulator lang=spectre

subckt XNOR2X4 A B Y VDD NW VSS
mn1 (n2 B VSS VSS) g45n1svt w=(145n) l=45n nf=1 m=(1)
mn2 (net145 n1 VSS VSS) g45n1svt w=(260n) l=45n nf=1 m=(1)
mn3 (n0 n2 net145 VSS) g45n1svt w=(260n) l=45n nf=1 m=(1)
mn5 (Y n0 VSS VSS) g45n1svt w=(1.04u) l=45n nf=1 m=(1)
mn0 (n1 A VSS VSS) g45n1svt w=(145n) l=45n nf=1 m=(1)
mn4 (n0 B n1 VSS) g45n1svt w=(260n) l=45n nf=1 m=(1)
mp0 (n1 A VDD NW) g45p1svt w=(215n) l=45n nf=1 m=(1)
mp4 (n1 n2 n0 NW) g45p1svt w=(390n) l=45n nf=1 m=(1)
mp2 (net112 n1 VDD NW) g45p1svt w=(390n) l=45n nf=1 m=(1)
mp1 (n2 B VDD NW) g45p1svt w=(215n) l=45n nf=1 m=(1)
mp3 (n0 B net112 NW) g45p1svt w=(390n) l=45n nf=1 m=(1)
mp5 (Y n0 VDD NW) g45p1svt w=(1.56u) l=45n nf=1 m=(1)
ends XNOR2X4

// gsclib045_backbias/XNOR2XL/schematic

simulator lang=spectre

subckt XNOR2XL A B Y NW VDD VSS
mn1 (n2 B VSS VSS) g45n1svt w=(145n) l=45n nf=1 m=(1)
mn2 (net145 n1 VSS VSS) g45n1svt w=(145n) l=45n nf=1 m=(1)
mn3 (n0 n2 net145 VSS) g45n1svt w=(145n) l=45n nf=1 m=(1)
mn5 (Y n0 VSS VSS) g45n1svt w=(145n) l=45n nf=1 m=(1)
mn0 (n1 A VSS VSS) g45n1svt w=(145n) l=45n nf=1 m=(1)
mn4 (n0 B n1 VSS) g45n1svt w=(145n) l=45n nf=1 m=(1)
mp0 (n1 A VDD NW) g45p1svt w=(215n) l=45n nf=1 m=(1)
mp4 (n1 n2 n0 NW) g45p1svt w=(215n) l=45n nf=1 m=(1)
mp2 (net112 n1 VDD NW) g45p1svt w=(215n) l=45n nf=1 m=(1)
mp1 (n2 B VDD NW) g45p1svt w=(215n) l=45n nf=1 m=(1)
mp3 (n0 B net112 NW) g45p1svt w=(215n) l=45n nf=1 m=(1)
mp5 (Y n0 VDD NW) g45p1svt w=(215n) l=45n nf=1 m=(1)
ends XNOR2XL

// gsclib045_backbias/XNOR3X1/schematic

simulator lang=spectre

subckt XNOR3X1 A B C Y NW VDD VSS
mn8 (Y n11 VSS VSS) g45n1svt w=(205n) l=45n nf=1 m=(1)
mn10 (n12 n61 n8 VSS) g45n1svt w=(205n) l=45n nf=1 m=(1)
mn2 (n9 n61 n62 VSS) g45n1svt w=(205n) l=45n nf=1 m=(1)
mn1 (n9 B n8 VSS) g45n1svt w=(190n) l=45n nf=1 m=(1)
mn9 (n8 n62 VSS VSS) g45n1svt w=(190n) l=45n nf=1 m=(1)
mn11 (n12 B n62 VSS) g45n1svt w=(205n) l=45n nf=1 m=(1)
mn6 (n11 C n9 VSS) g45n1svt w=(190n) l=45n nf=1 m=(1)
mn5 (n11 n60 n12 VSS) g45n1svt w=(190n) l=45n nf=1 m=(1)
mn7 (n60 C VSS VSS) g45n1svt w=(190n) l=45n nf=1 m=(1)
mn4 (n61 B VSS VSS) g45n1svt w=(190n) l=45n nf=1 m=(1)
mn3 (n62 A VSS VSS) g45n1svt w=(205n) l=45n nf=1 m=(1)
mp8 (Y n11 VDD NW) g45p1svt w=(390n) l=45n nf=1 m=(1)
mp3 (n62 A VDD NW) g45p1svt w=(390n) l=45n nf=1 m=(1)
mp6 (n9 n60 n11 NW) g45p1svt w=(310n) l=45n nf=1 m=(1)
mp11 (n62 n61 n12 NW) g45p1svt w=(390n) l=45n nf=1 m=(1)
mp2 (n62 B n9 NW) g45p1svt w=(390n) l=45n nf=1 m=(1)
mp5 (n12 C n11 NW) g45p1svt w=(310n) l=45n nf=1 m=(1)
mp1 (n8 n61 n9 NW) g45p1svt w=(310n) l=45n nf=1 m=(1)
mp10 (n8 B n12 NW) g45p1svt w=(310n) l=45n nf=1 m=(1)
mp4 (n61 B VDD NW) g45p1svt w=(310n) l=45n nf=1 m=(1)
mp9 (n8 n62 VDD NW) g45p1svt w=(310n) l=45n nf=1 m=(1)
mp7 (n60 C VDD NW) g45p1svt w=(310n) l=45n nf=1 m=(1)
ends XNOR3X1

// gsclib045_backbias/XNOR3XL/schematic

simulator lang=spectre

subckt XNOR3XL A B C Y NW VDD VSS
mn8 (Y n11 VSS VSS) g45n1svt w=(205n) l=45n nf=1 m=(1)
mn10 (n12 n61 n8 VSS) g45n1svt w=(205n) l=45n nf=1 m=(1)
mn2 (n9 n61 n62 VSS) g45n1svt w=(190n) l=45n nf=1 m=(1)
mn1 (n9 B n8 VSS) g45n1svt w=(190n) l=45n nf=1 m=(1)
mn9 (n8 n62 VSS VSS) g45n1svt w=(190n) l=45n nf=1 m=(1)
mn11 (n12 B n62 VSS) g45n1svt w=(190n) l=45n nf=1 m=(1)
mn6 (n11 C n9 VSS) g45n1svt w=(190n) l=45n nf=1 m=(1)
mn5 (n11 n60 n12 VSS) g45n1svt w=(190n) l=45n nf=1 m=(1)
mn7 (n60 C VSS VSS) g45n1svt w=(190n) l=45n nf=1 m=(1)
mn4 (n61 B VSS VSS) g45n1svt w=(190n) l=45n nf=1 m=(1)
mn3 (n62 A VSS VSS) g45n1svt w=(205n) l=45n nf=1 m=(1)
mp8 (Y n11 VDD NW) g45p1svt w=(205n) l=45n nf=1 m=(1)
mp3 (n62 A VDD NW) g45p1svt w=(310n) l=45n nf=1 m=(1)
mp6 (n9 n60 n11 NW) g45p1svt w=(310n) l=45n nf=1 m=(1)
mp11 (n62 n61 n12 NW) g45p1svt w=(310n) l=45n nf=1 m=(1)
mp2 (n62 B n9 NW) g45p1svt w=(310n) l=45n nf=1 m=(1)
mp5 (n12 C n11 NW) g45p1svt w=(310n) l=45n nf=1 m=(1)
mp1 (n8 n61 n9 NW) g45p1svt w=(310n) l=45n nf=1 m=(1)
mp10 (n8 B n12 NW) g45p1svt w=(310n) l=45n nf=1 m=(1)
mp4 (n61 B VDD NW) g45p1svt w=(310n) l=45n nf=1 m=(1)
mp9 (n8 n62 VDD NW) g45p1svt w=(310n) l=45n nf=1 m=(1)
mp7 (n60 C VDD NW) g45p1svt w=(310n) l=45n nf=1 m=(1)
ends XNOR3XL

// gsclib045_backbias/XOR2X1/schematic

simulator lang=spectre

subckt XOR2X1 A B Y NW VDD VSS
mn1 (n2 B VSS VSS) g45n1svt w=(145n) l=45n nf=1 m=(1)
mn0 (n1 A VSS VSS) g45n1svt w=(145n) l=45n nf=1 m=(1)
mn5 (Y n0 VSS VSS) g45n1svt w=(260n) l=45n nf=1 m=(1)
mn3 (n0 B net131 VSS) g45n1svt w=(145n) l=45n nf=1 m=(1)
mn4 (n0 n2 n1 VSS) g45n1svt w=(145n) l=45n nf=1 m=(1)
mn2 (net131 n1 VSS VSS) g45n1svt w=(145n) l=45n nf=1 m=(1)
mp3 (n0 n2 net130 NW) g45p1svt w=(215n) l=45n nf=1 m=(1)
mp1 (n2 B VDD NW) g45p1svt w=(215n) l=45n nf=1 m=(1)
mp4 (n1 B n0 NW) g45p1svt w=(215n) l=45n nf=1 m=(1)
mp0 (n1 A VDD NW) g45p1svt w=(215n) l=45n nf=1 m=(1)
mp5 (Y n0 VDD NW) g45p1svt w=(390n) l=45n nf=1 m=(1)
mp2 (net130 n1 VDD NW) g45p1svt w=(215n) l=45n nf=1 m=(1)
ends XOR2X1

// gsclib045_backbias/XOR2X2/schematic

simulator lang=spectre

subckt XOR2X2 A B Y VDD VSS NW
mn1 (n2 B VSS VSS) g45n1svt w=(145n) l=45n nf=1 m=(1)
mn0 (n1 A VSS VSS) g45n1svt w=(145n) l=45n nf=1 m=(1)
mn5 (Y n0 VSS VSS) g45n1svt w=(520n) l=45n nf=1 m=(1)
mn3 (n0 B net131 VSS) g45n1svt w=(145n) l=45n nf=1 m=(1)
mn4 (n0 n2 n1 VSS) g45n1svt w=(145n) l=45n nf=1 m=(1)
mn2 (net131 n1 VSS VSS) g45n1svt w=(145n) l=45n nf=1 m=(1)
mp3 (n0 n2 net130 NW) g45p1svt w=(215n) l=45n nf=1 m=(1)
mp1 (n2 B VDD NW) g45p1svt w=(215n) l=45n nf=1 m=(1)
mp4 (n1 B n0 NW) g45p1svt w=(215n) l=45n nf=1 m=(1)
mp0 (n1 A VDD NW) g45p1svt w=(215n) l=45n nf=1 m=(1)
mp5 (Y n0 VDD NW) g45p1svt w=(780n) l=45n nf=1 m=(1)
mp2 (net130 n1 VDD NW) g45p1svt w=(215n) l=45n nf=1 m=(1)
ends XOR2X2

// gsclib045_backbias/XOR2X4/schematic

simulator lang=spectre

subckt XOR2X4 A B Y VDD VSS NW
mn1 (n2 B VSS VSS) g45n1svt w=(145n) l=45n nf=1 m=(1)
mn0 (n1 A VSS VSS) g45n1svt w=(145n) l=45n nf=1 m=(1)
mn5 (Y n0 VSS VSS) g45n1svt w=(1.04u) l=45n nf=1 m=(1)
mn3 (n0 B net131 VSS) g45n1svt w=(260n) l=45n nf=1 m=(1)
mn4 (n0 n2 n1 VSS) g45n1svt w=(260n) l=45n nf=1 m=(1)
mn2 (net131 n1 VSS VSS) g45n1svt w=(260n) l=45n nf=1 m=(1)
mp3 (n0 n2 net130 NW) g45p1svt w=(390n) l=45n nf=1 m=(1)
mp1 (n2 B VDD NW) g45p1svt w=(215n) l=45n nf=1 m=(1)
mp4 (n1 B n0 NW) g45p1svt w=(390n) l=45n nf=1 m=(1)
mp0 (n1 A VDD NW) g45p1svt w=(215n) l=45n nf=1 m=(1)
mp5 (Y n0 VDD NW) g45p1svt w=(1.56u) l=45n nf=1 m=(1)
mp2 (net130 n1 VDD NW) g45p1svt w=(390n) l=45n nf=1 m=(1)
ends XOR2X4

// gsclib045_backbias/XOR2XL/schematic

simulator lang=spectre

subckt XOR2XL A B Y NW VDD VSS
mn1 (n2 B VSS VSS) g45n1svt w=(145n) l=45n nf=1 m=(1)
mn0 (n1 A VSS VSS) g45n1svt w=(145n) l=45n nf=1 m=(1)
mn5 (Y n0 VSS VSS) g45n1svt w=(145n) l=45n nf=1 m=(1)
mn3 (n0 B net131 VSS) g45n1svt w=(145n) l=45n nf=1 m=(1)
mn4 (n0 n2 n1 VSS) g45n1svt w=(145n) l=45n nf=1 m=(1)
mn2 (net131 n1 VSS VSS) g45n1svt w=(145n) l=45n nf=1 m=(1)
mp3 (n0 n2 net130 NW) g45p1svt w=(215n) l=45n nf=1 m=(1)
mp1 (n2 B VDD NW) g45p1svt w=(215n) l=45n nf=1 m=(1)
mp4 (n1 B n0 NW) g45p1svt w=(215n) l=45n nf=1 m=(1)
mp0 (n1 A VDD NW) g45p1svt w=(215n) l=45n nf=1 m=(1)
mp5 (Y n0 VDD NW) g45p1svt w=(215n) l=45n nf=1 m=(1)
mp2 (net130 n1 VDD NW) g45p1svt w=(215n) l=45n nf=1 m=(1)
ends XOR2XL

// gsclib045_backbias/XOR3X1/schematic

simulator lang=spectre

subckt XOR3X1 A B C Y VSS NW VDD
mn3 (n56 n60 n50 VSS) g45n1svt w=(190n) l=45n nf=1 m=(1)
mn10 (n62 A VSS VSS) g45n1svt w=(205n) l=45n nf=1 m=(1)
mn4 (n44 C n50 VSS) g45n1svt w=(190n) l=45n nf=1 m=(1)
mn8 (n60 C VSS VSS) g45n1svt w=(190n) l=45n nf=1 m=(1)
mn9 (n61 B VSS VSS) g45n1svt w=(190n) l=45n nf=1 m=(1)
mn6 (n56 B n11 VSS) g45n1svt w=(190n) l=45n nf=1 m=(1)
mn1 (n62 B n44 VSS) g45n1svt w=(205n) l=45n nf=1 m=(1)
mn2 (n11 n61 n44 VSS) g45n1svt w=(190n) l=45n nf=1 m=(1)
mn0 (n11 n62 VSS VSS) g45n1svt w=(190n) l=45n nf=1 m=(1)
mn5 (n62 n61 n56 VSS) g45n1svt w=(205n) l=45n nf=1 m=(1)
mn7 (Y n50 VSS VSS) g45n1svt w=(205n) l=45n nf=1 m=(1)
mp10 (n62 A VDD NW) g45p1svt w=(390n) l=45n nf=1 m=(1)
mp1 (n44 n61 n62 NW) g45p1svt w=(390n) l=45n nf=1 m=(1)
mp7 (Y n50 VDD NW) g45p1svt w=(390n) l=45n nf=1 m=(1)
mp2 (n44 B n11 NW) g45p1svt w=(310n) l=45n nf=1 m=(1)
mp9 (n61 B VDD NW) g45p1svt w=(310n) l=45n nf=1 m=(1)
mp3 (n50 C n56 NW) g45p1svt w=(310n) l=45n nf=1 m=(1)
mp8 (n60 C VDD NW) g45p1svt w=(310n) l=45n nf=1 m=(1)
mp4 (n50 n60 n44 NW) g45p1svt w=(310n) l=45n nf=1 m=(1)
mp0 (n11 n62 VDD NW) g45p1svt w=(310n) l=45n nf=1 m=(1)
mp6 (n11 n61 n56 NW) g45p1svt w=(310n) l=45n nf=1 m=(1)
mp5 (n56 B n62 NW) g45p1svt w=(390n) l=45n nf=1 m=(1)
ends XOR3X1

// gsclib045_backbias/XOR3XL/schematic

simulator lang=spectre

subckt XOR3XL A B C Y VSS NW VDD
mn3 (n56 n60 n50 VSS) g45n1svt w=(190n) l=45n nf=1 m=(1)
mn10 (n62 A VSS VSS) g45n1svt w=(190n) l=45n nf=1 m=(1)
mn4 (n44 C n50 VSS) g45n1svt w=(190n) l=45n nf=1 m=(1)
mn8 (n60 C VSS VSS) g45n1svt w=(190n) l=45n nf=1 m=(1)
mn9 (n61 B VSS VSS) g45n1svt w=(190n) l=45n nf=1 m=(1)
mn6 (n56 B n11 VSS) g45n1svt w=(190n) l=45n nf=1 m=(1)
mn1 (n62 B n44 VSS) g45n1svt w=(190n) l=45n nf=1 m=(1)
mn2 (n11 n61 n44 VSS) g45n1svt w=(190n) l=45n nf=1 m=(1)
mn0 (n11 n62 VSS VSS) g45n1svt w=(190n) l=45n nf=1 m=(1)
mn5 (n62 n61 n56 VSS) g45n1svt w=(190n) l=45n nf=1 m=(1)
mn7 (Y n50 VSS VSS) g45n1svt w=(190n) l=45n nf=1 m=(1)
mp10 (n62 A VDD NW) g45p1svt w=(310n) l=45n nf=1 m=(1)
mp1 (n44 n61 n62 NW) g45p1svt w=(310n) l=45n nf=1 m=(1)
mp7 (Y n50 VDD NW) g45p1svt w=(205n) l=45n nf=1 m=(1)
mp2 (n44 B n11 NW) g45p1svt w=(310n) l=45n nf=1 m=(1)
mp9 (n61 B VDD NW) g45p1svt w=(310n) l=45n nf=1 m=(1)
mp3 (n50 C n56 NW) g45p1svt w=(310n) l=45n nf=1 m=(1)
mp8 (n60 C VDD NW) g45p1svt w=(310n) l=45n nf=1 m=(1)
mp4 (n50 n60 n44 NW) g45p1svt w=(310n) l=45n nf=1 m=(1)
mp0 (n11 n62 VDD NW) g45p1svt w=(310n) l=45n nf=1 m=(1)
mp6 (n11 n61 n56 NW) g45p1svt w=(310n) l=45n nf=1 m=(1)
mp5 (n56 B n62 NW) g45p1svt w=(310n) l=45n nf=1 m=(1)
ends XOR3XL
