// gsclib045_backbias/TLATNX4/schematic

simulator lang=spectre

subckt TLATNX4 D GN Q QN VSS NW VDD
mn5 (net257 D VSS VSS) g45n1svt w=(145n) l=45n nf=1 m=(1)
mn6 (n0 GNb net257 VSS) g45n1svt w=(145n) l=45n nf=1 m=(1)
mn16 (n0 GNbb net245 VSS) g45n1svt w=(145n) l=45n nf=1 m=(1)
mn15 (net245 Qint VSS VSS) g45n1svt w=(145n) l=45n nf=1 m=(1)
mn22 (QN Qint VSS VSS) g45n1svt w=(1.04u) l=45n nf=1 m=(1)
mn21 (Q Qbint VSS VSS) g45n1svt w=(1.04u) l=45n nf=1 m=(1)
mn0 (GNb GN VSS VSS) g45n1svt w=(145n) l=45n nf=1 m=(1)
mn1 (GNbb GNb VSS VSS) g45n1svt w=(145n) l=45n nf=1 m=(1)
mn10 (Qint n0 VSS VSS) g45n1svt w=(410n) l=45n nf=1 m=(1)
mn20 (Qbint Qint VSS VSS) g45n1svt w=(1.04u) l=45n nf=1 m=(1)
mp6 (n0 GNbb net220 NW) g45p1svt w=(215n) l=45n nf=1 m=(1)
mp5 (net220 D VDD NW) g45p1svt w=(215n) l=45n nf=1 m=(1)
mp16 (n0 GNb net212 NW) g45p1svt w=(215n) l=45n nf=1 m=(1)
mp15 (net212 Qint VDD NW) g45p1svt w=(215n) l=45n nf=1 m=(1)
mp22 (QN Qint VDD NW) g45p1svt w=(1.56u) l=45n nf=1 m=(1)
mp21 (Q Qbint VDD NW) g45p1svt w=(1.56u) l=45n nf=1 m=(1)
mp0 (GNb GN VDD NW) g45p1svt w=(215n) l=45n nf=1 m=(1)
mp1 (GNbb GNb VDD NW) g45p1svt w=(215n) l=45n nf=1 m=(1)
mp10 (Qint n0 VDD NW) g45p1svt w=(620n) l=45n nf=1 m=(1)
mp20 (Qbint Qint VDD NW) g45p1svt w=(1.56u) l=45n nf=1 m=(1)
ends TLATNX4
