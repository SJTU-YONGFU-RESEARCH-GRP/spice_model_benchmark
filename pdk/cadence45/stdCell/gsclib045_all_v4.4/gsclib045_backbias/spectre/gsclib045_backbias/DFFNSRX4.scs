// gsclib045_backbias/DFFNSRX4/schematic

simulator lang=spectre

subckt DFFNSRX4 CKN D Q QN RN SN NW VSS VDD
mn26 (n20 CKNbb n21 VSS) g45n1svt w=(145n) l=45n nf=1 m=(1)
mn25 (n21 D VSS VSS) g45n1svt w=(145n) l=45n nf=1 m=(1)
mn57 (QN qint VSS VSS) g45n1svt w=(1.04u) l=45n nf=1 m=(1)
mn55 (Q qbint VSS VSS) g45n1svt w=(1.04u) l=45n nf=1 m=(1)
mn36 (n20 CKNb n30 VSS) g45n1svt w=(145n) l=45n nf=1 m=(1)
mn35 (n30 mout VSS VSS) g45n1svt w=(145n) l=45n nf=1 m=(1)
mn22 (RNb RN VSS VSS) g45n1svt w=(145n) l=45n nf=1 m=(1)
mn20 (CKNb CKN VSS VSS) g45n1svt w=(145n) l=45n nf=1 m=(1)
mn45 (qbint n35 VSS VSS) g45n1svt w=(410n) l=45n nf=1 m=(1)
mn56 (qint qbint VSS VSS) g45n1svt w=(260n) l=45n nf=1 m=(1)
mn52 (n40 qbint n42 VSS) g45n1svt w=(145n) l=45n nf=1 m=(1)
mn51 (n40 RNb n42 VSS) g45n1svt w=(145n) l=45n nf=1 m=(1)
mn50 (n42 SN VSS VSS) g45n1svt w=(145n) l=45n nf=1 m=(1)
mn53 (n40 CKNbb n35 VSS) g45n1svt w=(145n) l=45n nf=1 m=(1)
mn21 (CKNbb CKNb VSS VSS) g45n1svt w=(145n) l=45n nf=1 m=(1)
mn32 (mout n20 n25 VSS) g45n1svt w=(145n) l=45n nf=1 m=(1)
mn31 (n25 RNb mout VSS) g45n1svt w=(145n) l=45n nf=1 m=(1)
mn30 (n25 SN VSS VSS) g45n1svt w=(145n) l=45n nf=1 m=(1)
mn40 (n35 CKNb mout VSS) g45n1svt w=(145n) l=45n nf=1 m=(1)
mp25 (n22 D VDD NW) g45p1svt w=(215n) l=45n nf=1 m=(1)
mp26 (n20 CKNb n22 NW) g45p1svt w=(215n) l=45n nf=1 m=(1)
mp51 (n43 RNb VDD NW) g45p1svt w=(215n) l=45n nf=1 m=(1)
mp57 (QN qint VDD NW) g45p1svt w=(1.56u) l=45n nf=1 m=(1)
mp55 (Q qbint VDD NW) g45p1svt w=(1.56u) l=45n nf=1 m=(1)
mp36 (n20 CKNbb n31 NW) g45p1svt w=(215n) l=45n nf=1 m=(1)
mp35 (n31 mout VDD NW) g45p1svt w=(215n) l=45n nf=1 m=(1)
mp32 (mout n20 n26 NW) g45p1svt w=(215n) l=45n nf=1 m=(1)
mp31 (n26 RNb VDD NW) g45p1svt w=(215n) l=45n nf=1 m=(1)
mp22 (RNb RN VDD NW) g45p1svt w=(215n) l=45n nf=1 m=(1)
mp20 (CKNb CKN VDD NW) g45p1svt w=(215n) l=45n nf=1 m=(1)
mp53 (n41 CKNb n35 NW) g45p1svt w=(215n) l=45n nf=1 m=(1)
mp50 (n41 SN VDD NW) g45p1svt w=(215n) l=45n nf=1 m=(1)
mp45 (qbint n35 VDD NW) g45p1svt w=(620n) l=45n nf=1 m=(1)
mp56 (qint qbint VDD NW) g45p1svt w=(390n) l=45n nf=1 m=(1)
mp21 (CKNbb CKNb VDD NW) g45p1svt w=(215n) l=45n nf=1 m=(1)
mp40 (n35 CKNbb mout NW) g45p1svt w=(215n) l=45n nf=1 m=(1)
mp52 (n41 qbint n43 NW) g45p1svt w=(215n) l=45n nf=1 m=(1)
mp30 (mout SN VDD NW) g45p1svt w=(215n) l=45n nf=1 m=(1)
ends DFFNSRX4
