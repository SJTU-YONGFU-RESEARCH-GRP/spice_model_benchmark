// gsclib045_backbias/OAI2BB1X4/schematic

simulator lang=spectre

subckt OAI2BB1X4 A0N A1N B0 Y NW VSS VDD
mn3 (Y n0 n2 VSS) g45n1svt w=(1.04u) l=45n nf=1 m=(1)
mn2 (n2 B0 VSS VSS) g45n1svt w=(1.04u) l=45n nf=1 m=(1)
mn0 (n1 A0N VSS VSS) g45n1svt w=(260n) l=45n nf=1 m=(1)
mn1 (n0 A1N n1 VSS) g45n1svt w=(260n) l=45n nf=1 m=(1)
mp2 (Y B0 VDD NW) g45p1svt w=(1.56u) l=45n nf=1 m=(1)
mp1 (n0 A1N VDD NW) g45p1svt w=(390n) l=45n nf=1 m=(1)
mp0 (n0 A0N VDD NW) g45p1svt w=(390n) l=45n nf=1 m=(1)
mp3 (Y n0 VDD NW) g45p1svt w=(1.56u) l=45n nf=1 m=(1)
ends OAI2BB1X4
