// gsclib045_backbias/OR2X6/schematic

simulator lang=spectre

subckt OR2X6 A B Y VSS VDD NW
mn2 (Y n0 VSS VSS) g45n1svt w=(1.55u) l=45n nf=1 m=(1)
mn0 (n0 A VSS VSS) g45n1svt w=(520n) l=45n nf=1 m=(1)
mn1 (n0 B VSS VSS) g45n1svt w=(520n) l=45n nf=1 m=(1)
mp1 (n0 B n1 NW) g45p1svt w=(780n) l=45n nf=1 m=(1)
mp2 (Y n0 VDD NW) g45p1svt w=(2.35u) l=45n nf=1 m=(1)
mp0 (n1 A VDD NW) g45p1svt w=(780n) l=45n nf=1 m=(1)
ends OR2X6
