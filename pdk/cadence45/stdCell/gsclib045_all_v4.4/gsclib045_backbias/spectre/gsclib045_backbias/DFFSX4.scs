// gsclib045_backbias/DFFSX4/schematic

simulator lang=spectre

subckt DFFSX4 CK D Q QN SN NW VSS VDD
mn51 (n40 qbint n42 VSS) g45n1svt w=(145n) l=45n nf=1 m=(1)
mn52 (n35 CKb n40 VSS) g45n1svt w=(145n) l=45n nf=1 m=(1)
mn50 (n42 SN VSS VSS) g45n1svt w=(145n) l=45n nf=1 m=(1)
mn26 (n20 CKb n21 VSS) g45n1svt w=(145n) l=45n nf=1 m=(1)
mn25 (n21 D VSS VSS) g45n1svt w=(145n) l=45n nf=1 m=(1)
mn57 (QN net331 VSS VSS) g45n1svt w=(1.04u) l=45n nf=1 m=(1)
mn55 (Q qbint VSS VSS) g45n1svt w=(1.04u) l=45n nf=1 m=(1)
mn30 (n25 SN VSS VSS) g45n1svt w=(145n) l=45n nf=1 m=(1)
mn31 (mout n20 n25 VSS) g45n1svt w=(145n) l=45n nf=1 m=(1)
mn35 (n20 CKbb n30 VSS) g45n1svt w=(145n) l=45n nf=1 m=(1)
mn36 (n30 mout VSS VSS) g45n1svt w=(145n) l=45n nf=1 m=(1)
mn56 (net331 qbint VSS VSS) g45n1svt w=(260n) l=45n nf=1 m=(1)
mn20 (CKb CK VSS VSS) g45n1svt w=(145n) l=45n nf=1 m=(1)
mn21 (CKbb CKb VSS VSS) g45n1svt w=(145n) l=45n nf=1 m=(1)
mn45 (qbint n35 VSS VSS) g45n1svt w=(410n) l=45n nf=1 m=(1)
mn40 (n35 CKbb mout VSS) g45n1svt w=(145n) l=45n nf=1 m=(1)
mp26 (n20 CKbb n22 NW) g45p1svt w=(215n) l=45n nf=1 m=(1)
mp25 (n22 D VDD NW) g45p1svt w=(215n) l=45n nf=1 m=(1)
mp57 (QN net331 VDD NW) g45p1svt w=(1.56u) l=45n nf=1 m=(1)
mp55 (Q qbint VDD NW) g45p1svt w=(1.56u) l=45n nf=1 m=(1)
mp36 (n20 CKb n31 NW) g45p1svt w=(215n) l=45n nf=1 m=(1)
mp35 (n31 mout VDD NW) g45p1svt w=(215n) l=45n nf=1 m=(1)
mp20 (CKb CK VDD NW) g45p1svt w=(215n) l=45n nf=1 m=(1)
mp31 (mout n20 VDD NW) g45p1svt w=(215n) l=45n nf=1 m=(1)
mp40 (n35 CKb mout NW) g45p1svt w=(215n) l=45n nf=1 m=(1)
mp56 (net331 qbint VDD NW) g45p1svt w=(390n) l=45n nf=1 m=(1)
mp45 (qbint n35 VDD NW) g45p1svt w=(620n) l=45n nf=1 m=(1)
mp52 (n35 CKbb n41 NW) g45p1svt w=(215n) l=45n nf=1 m=(1)
mp21 (CKbb CKb VDD NW) g45p1svt w=(215n) l=45n nf=1 m=(1)
mp30 (mout SN VDD NW) g45p1svt w=(215n) l=45n nf=1 m=(1)
mp51 (n41 qbint VDD NW) g45p1svt w=(215n) l=45n nf=1 m=(1)
mp50 (n41 SN VDD NW) g45p1svt w=(215n) l=45n nf=1 m=(1)
ends DFFSX4
