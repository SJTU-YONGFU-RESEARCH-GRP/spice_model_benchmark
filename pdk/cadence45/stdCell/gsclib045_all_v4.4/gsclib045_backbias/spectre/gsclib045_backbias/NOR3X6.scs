// gsclib045_backbias/NOR3X6/schematic

simulator lang=spectre

subckt NOR3X6 A B C Y VSS VDD NW
mn0 (Y A VSS VSS) g45n1svt w=(1.55u) l=45n nf=1 m=(1)
mn1 (Y B VSS VSS) g45n1svt w=(1.55u) l=45n nf=1 m=(1)
mn2 (Y C VSS VSS) g45n1svt w=(1.55u) l=45n nf=1 m=(1)
mp1 (n1 B n0 NW) g45p1svt w=(2.34u) l=45n nf=1 m=(1)
mp2 (Y C n1 NW) g45p1svt w=(2.34u) l=45n nf=1 m=(1)
mp0 (n0 A VDD NW) g45p1svt w=(2.34u) l=45n nf=1 m=(1)
ends NOR3X6
