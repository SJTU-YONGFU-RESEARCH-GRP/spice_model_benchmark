// gsclib045_backbias/AOI31X2/schematic

simulator lang=spectre

subckt AOI31X2 A0 A1 A2 B0 Y VSS NW VDD
mn3 (Y B0 VSS VSS) g45n1svt w=(520n) l=45n nf=1 m=(1)
mn1 (net100 A1 net104 VSS) g45n1svt w=(520n) l=45n nf=1 m=(1)
mn2 (Y A2 net100 VSS) g45n1svt w=(520n) l=45n nf=1 m=(1)
mn0 (net104 A0 VSS VSS) g45n1svt w=(520n) l=45n nf=1 m=(1)
mp2 (net81 A2 VDD NW) g45p1svt w=(780n) l=45n nf=1 m=(1)
mp3 (Y B0 net81 NW) g45p1svt w=(780n) l=45n nf=1 m=(1)
mp1 (net81 A1 VDD NW) g45p1svt w=(780n) l=45n nf=1 m=(1)
mp0 (net81 A0 VDD NW) g45p1svt w=(780n) l=45n nf=1 m=(1)
ends AOI31X2
