// gsclib045_backbias/AOI31XL/schematic

simulator lang=spectre

subckt AOI31XL A0 A1 A2 B0 Y VSS NW VDD
mn3 (Y B0 VSS VSS) g45n1svt w=(145n) l=45n nf=1 m=(1)
mn1 (net101 A1 net97 VSS) g45n1svt w=(145n) l=45n nf=1 m=(1)
mn2 (Y A2 net101 VSS) g45n1svt w=(145n) l=45n nf=1 m=(1)
mn0 (net97 A0 VSS VSS) g45n1svt w=(145n) l=45n nf=1 m=(1)
mp2 (net89 A2 VDD NW) g45p1svt w=(215n) l=45n nf=1 m=(1)
mp3 (Y B0 net89 NW) g45p1svt w=(215n) l=45n nf=1 m=(1)
mp1 (net89 A1 VDD NW) g45p1svt w=(215n) l=45n nf=1 m=(1)
mp0 (net89 A0 VDD NW) g45p1svt w=(215n) l=45n nf=1 m=(1)
ends AOI31XL
