// gsclib045_backbias/AND2X8/schematic

simulator lang=spectre

subckt AND2X8 A B Y NW VSS VDD
mn2 (Y n0 VSS VSS) g45n1svt w=(2.065u) l=45n nf=1 m=(1)
mn0 (net69 A VSS VSS) g45n1svt w=(520n) l=45n nf=1 m=(1)
mn1 (n0 B net69 VSS) g45n1svt w=(520n) l=45n nf=1 m=(1)
mp1 (n0 B VDD NW) g45p1svt w=(780n) l=45n nf=1 m=(1)
mp0 (n0 A VDD NW) g45p1svt w=(780n) l=45n nf=1 m=(1)
mp2 (Y n0 VDD NW) g45p1svt w=(3.115u) l=45n nf=1 m=(1)
ends AND2X8
