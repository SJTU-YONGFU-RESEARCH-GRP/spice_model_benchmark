// gsclib045_backbias/AOI21X2/schematic

simulator lang=spectre

subckt AOI21X2 A0 A1 B0 Y VSS NW VDD
mn2 (Y B0 VSS VSS) g45n1svt w=(520n) l=45n nf=1 m=(1)
mn0 (net74 A0 VSS VSS) g45n1svt w=(520n) l=45n nf=1 m=(1)
mn1 (Y A1 net74 VSS) g45n1svt w=(520n) l=45n nf=1 m=(1)
mp2 (Y B0 net70 NW) g45p1svt w=(780n) l=45n nf=1 m=(1)
mp1 (net70 A1 VDD NW) g45p1svt w=(780n) l=45n nf=1 m=(1)
mp0 (net70 A0 VDD NW) g45p1svt w=(780n) l=45n nf=1 m=(1)
ends AOI21X2
