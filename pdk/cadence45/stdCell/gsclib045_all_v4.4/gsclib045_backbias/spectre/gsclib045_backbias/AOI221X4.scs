// gsclib045_backbias/AOI221X4/schematic

simulator lang=spectre

subckt AOI221X4 A0 A1 B0 B1 C0 Y VSS VDD NW
mn2 (net116 B0 VSS VSS) g45n1svt w=(1.04u) l=45n nf=1 m=(1)
mn3 (Y B1 net116 VSS) g45n1svt w=(1.04u) l=45n nf=1 m=(1)
mn4 (Y C0 VSS VSS) g45n1svt w=(1.04u) l=45n nf=1 m=(1)
mn1 (Y A1 net120 VSS) g45n1svt w=(1.04u) l=45n nf=1 m=(1)
mn0 (net120 A0 VSS VSS) g45n1svt w=(1.04u) l=45n nf=1 m=(1)
mp3 (net104 B1 net107 NW) g45p1svt w=(1.56u) l=45n nf=1 m=(1)
mp2 (net104 B0 net107 NW) g45p1svt w=(1.56u) l=45n nf=1 m=(1)
mp0 (net107 A0 VDD NW) g45p1svt w=(1.56u) l=45n nf=1 m=(1)
mp1 (net107 A1 VDD NW) g45p1svt w=(1.56u) l=45n nf=1 m=(1)
mp4 (Y C0 net104 NW) g45p1svt w=(1.56u) l=45n nf=1 m=(1)
ends AOI221X4
