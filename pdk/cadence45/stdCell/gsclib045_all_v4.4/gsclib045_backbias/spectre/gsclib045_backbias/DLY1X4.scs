// gsclib045_backbias/DLY1X4/schematic

simulator lang=spectre

subckt DLY1X4 A Y NW VDD VSS
mn2 (n1 VDD n4 VSS) g45n1svt w=(145n) l=45n nf=1 m=(1)
mn1 (n4 n0 VSS VSS) g45n1svt w=(145n) l=45n nf=1 m=(1)
mn4 (Y n2 VSS VSS) g45n1svt w=(1.04u) l=45n nf=1 m=(1)
mn0 (n0 A VSS VSS) g45n1svt w=(145n) l=45n nf=1 m=(1)
mn3 (n2 n1 VSS VSS) g45n1svt w=(260n) l=45n nf=1 m=(1)
mp2 (n1 VSS n5 NW) g45p1svt w=(215n) l=45n nf=1 m=(1)
mp1 (n5 n0 VDD NW) g45p1svt w=(215n) l=45n nf=1 m=(1)
mp4 (Y n2 VDD NW) g45p1svt w=(1.56u) l=45n nf=1 m=(1)
mp0 (n0 A VDD NW) g45p1svt w=(215n) l=45n nf=1 m=(1)
mp3 (n2 n1 VDD NW) g45p1svt w=(390n) l=45n nf=1 m=(1)
ends DLY1X4
