// gsclib045_backbias/SDFFNSRX4/schematic

simulator lang=spectre

subckt SDFFNSRX4 CKN D Q QN RN SE SI SN NW VSS VDD
mn13 (net538 SI VSS VSS) g45n1svt w=(145n) l=45n nf=1 m=(1)
mn14 (Db SE net538 VSS) g45n1svt w=(145n) l=45n nf=1 m=(1)
mn12 (Db SEb net546 VSS) g45n1svt w=(145n) l=45n nf=1 m=(1)
mn11 (net546 D VSS VSS) g45n1svt w=(145n) l=45n nf=1 m=(1)
mn57 (QN qint VSS VSS) g45n1svt w=(1.04u) l=45n nf=1 m=(1)
mn55 (Q qbint VSS VSS) g45n1svt w=(1.04u) l=45n nf=1 m=(1)
mn36 (n20 CKNb net582 VSS) g45n1svt w=(145n) l=45n nf=1 m=(1)
mn35 (net582 mout VSS VSS) g45n1svt w=(145n) l=45n nf=1 m=(1)
mn22 (RNb RN VSS VSS) g45n1svt w=(145n) l=45n nf=1 m=(1)
mn20 (CKNb CKN VSS VSS) g45n1svt w=(145n) l=45n nf=1 m=(1)
mn10 (SEb SE VSS VSS) g45n1svt w=(145n) l=45n nf=1 m=(1)
mn31 (mout RNb net521 VSS) g45n1svt w=(145n) l=45n nf=1 m=(1)
mn51 (net0363 RNb net498 VSS) g45n1svt w=(145n) l=45n nf=1 m=(1)
mn25 (Db CKNbb n20 VSS) g45n1svt w=(145n) l=45n nf=1 m=(1)
mn30 (net521 SN VSS VSS) g45n1svt w=(145n) l=45n nf=1 m=(1)
mn21 (CKNbb CKNb VSS VSS) g45n1svt w=(145n) l=45n nf=1 m=(1)
mn45 (qbint n35 VSS VSS) g45n1svt w=(410n) l=45n nf=1 m=(1)
mn50 (net498 SN VSS VSS) g45n1svt w=(145n) l=45n nf=1 m=(1)
mn32 (mout n20 net521 VSS) g45n1svt w=(145n) l=45n nf=1 m=(1)
mn56 (qint qbint VSS VSS) g45n1svt w=(260n) l=45n nf=1 m=(1)
mn53 (n35 CKNbb net0363 VSS) g45n1svt w=(145n) l=45n nf=1 m=(1)
mn52 (net0363 qbint net498 VSS) g45n1svt w=(145n) l=45n nf=1 m=(1)
mn40 (mout CKNb n35 VSS) g45n1svt w=(145n) l=45n nf=1 m=(1)
mp14 (Db SEb net453 NW) g45p1svt w=(215n) l=45n nf=1 m=(1)
mp13 (net453 SI VDD NW) g45p1svt w=(215n) l=45n nf=1 m=(1)
mp12 (Db SE net461 NW) g45p1svt w=(215n) l=45n nf=1 m=(1)
mp11 (net461 D VDD NW) g45p1svt w=(215n) l=45n nf=1 m=(1)
mp52 (net566 qbint net414 NW) g45p1svt w=(215n) l=45n nf=1 m=(1)
mp51 (net414 RNb VDD NW) g45p1svt w=(215n) l=45n nf=1 m=(1)
mp57 (QN qint VDD NW) g45p1svt w=(1.56u) l=45n nf=1 m=(1)
mp55 (Q qbint VDD NW) g45p1svt w=(1.56u) l=45n nf=1 m=(1)
mp36 (n20 CKNbb net486 NW) g45p1svt w=(215n) l=45n nf=1 m=(1)
mp35 (net486 mout VDD NW) g45p1svt w=(215n) l=45n nf=1 m=(1)
mp32 (mout n20 net478 NW) g45p1svt w=(215n) l=45n nf=1 m=(1)
mp31 (net478 RNb VDD NW) g45p1svt w=(215n) l=45n nf=1 m=(1)
mp22 (RNb RN VDD NW) g45p1svt w=(215n) l=45n nf=1 m=(1)
mp20 (CKNb CKN VDD NW) g45p1svt w=(215n) l=45n nf=1 m=(1)
mp53 (n35 CKNb net566 NW) g45p1svt w=(215n) l=45n nf=1 m=(1)
mp56 (qint qbint VDD NW) g45p1svt w=(390n) l=45n nf=1 m=(1)
mp21 (CKNbb CKNb VDD NW) g45p1svt w=(215n) l=45n nf=1 m=(1)
mp25 (n20 CKNb Db NW) g45p1svt w=(215n) l=45n nf=1 m=(1)
mp50 (net566 SN VDD NW) g45p1svt w=(215n) l=45n nf=1 m=(1)
mp10 (SEb SE VDD NW) g45p1svt w=(215n) l=45n nf=1 m=(1)
mp45 (qbint n35 VDD NW) g45p1svt w=(620n) l=45n nf=1 m=(1)
mp40 (n35 CKNbb mout NW) g45p1svt w=(215n) l=45n nf=1 m=(1)
mp30 (mout SN VDD NW) g45p1svt w=(215n) l=45n nf=1 m=(1)
ends SDFFNSRX4
