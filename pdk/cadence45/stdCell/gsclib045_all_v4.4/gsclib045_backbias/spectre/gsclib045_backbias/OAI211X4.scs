// gsclib045_backbias/OAI211X4/schematic

simulator lang=spectre

subckt OAI211X4 A0 A1 B0 C0 Y NW VSS VDD
mn1 (n0 A1 VSS VSS) g45n1svt w=(1.04u) l=45n nf=1 m=(1)
mn0 (n0 A0 VSS VSS) g45n1svt w=(1.04u) l=45n nf=1 m=(1)
mn2 (n1 B0 n0 VSS) g45n1svt w=(1.04u) l=45n nf=1 m=(1)
mn3 (Y C0 n1 VSS) g45n1svt w=(1.04u) l=45n nf=1 m=(1)
mp1 (Y A1 n2 NW) g45p1svt w=(1.56u) l=45n nf=1 m=(1)
mp0 (n2 A0 VDD NW) g45p1svt w=(1.56u) l=45n nf=1 m=(1)
mp3 (Y C0 VDD NW) g45p1svt w=(1.56u) l=45n nf=1 m=(1)
mp2 (Y B0 VDD NW) g45p1svt w=(1.56u) l=45n nf=1 m=(1)
ends OAI211X4
