// gsclib045_backbias/AND3XL/schematic

simulator lang=spectre

subckt AND3XL A B C Y VDD VSS NW
mn3 (Y net87 VSS VSS) g45n1svt w=(145n) l=45n nf=1 m=(1)
mn1 (net107 B net103 VSS) g45n1svt w=(145n) l=45n nf=1 m=(1)
mn0 (net103 A VSS VSS) g45n1svt w=(145n) l=45n nf=1 m=(1)
mn2 (net87 C net107 VSS) g45n1svt w=(145n) l=45n nf=1 m=(1)
mp1 (net87 B VDD NW) g45p1svt w=(215n) l=45n nf=1 m=(1)
mp2 (net87 C VDD NW) g45p1svt w=(215n) l=45n nf=1 m=(1)
mp0 (net87 A VDD NW) g45p1svt w=(215n) l=45n nf=1 m=(1)
mp3 (Y net87 VDD NW) g45p1svt w=(215n) l=45n nf=1 m=(1)
ends AND3XL
