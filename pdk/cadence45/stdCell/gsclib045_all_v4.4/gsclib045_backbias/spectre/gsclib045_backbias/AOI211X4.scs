// gsclib045_backbias/AOI211X4/schematic

simulator lang=spectre

subckt AOI211X4 A0 A1 B0 C0 Y VSS NW VDD
mn2 (Y B0 VSS VSS) g45n1svt w=(1.04u) l=45n nf=1 m=(1)
mn3 (Y C0 VSS VSS) g45n1svt w=(1.04u) l=45n nf=1 m=(1)
mn1 (Y A1 net99 VSS) g45n1svt w=(1.04u) l=45n nf=1 m=(1)
mn0 (net99 A0 VSS VSS) g45n1svt w=(1.04u) l=45n nf=1 m=(1)
mp3 (Y C0 net82 NW) g45p1svt w=(1.56u) l=45n nf=1 m=(1)
mp2 (net82 B0 net91 NW) g45p1svt w=(1.56u) l=45n nf=1 m=(1)
mp1 (net91 A1 VDD NW) g45p1svt w=(1.56u) l=45n nf=1 m=(1)
mp0 (net91 A0 VDD NW) g45p1svt w=(1.56u) l=45n nf=1 m=(1)
ends AOI211X4
