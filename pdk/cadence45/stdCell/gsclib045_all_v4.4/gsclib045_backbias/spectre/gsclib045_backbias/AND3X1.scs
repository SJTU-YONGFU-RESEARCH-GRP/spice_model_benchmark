// gsclib045_backbias/AND3X1/schematic

simulator lang=spectre

subckt AND3X1 A B C Y VDD VSS NW
mn3 (Y net086 VSS VSS) g45n1svt w=(260n) l=45n nf=1 m=(1)
mn1 (net0106 B net0102 VSS) g45n1svt w=(145n) l=45n nf=1 m=(1)
mn0 (net0102 A VSS VSS) g45n1svt w=(145n) l=45n nf=1 m=(1)
mn2 (net086 C net0106 VSS) g45n1svt w=(145n) l=45n nf=1 m=(1)
mp1 (net086 B VDD NW) g45p1svt w=(215n) l=45n nf=1 m=(1)
mp2 (net086 C VDD NW) g45p1svt w=(215n) l=45n nf=1 m=(1)
mp0 (net086 A VDD NW) g45p1svt w=(215n) l=45n nf=1 m=(1)
mp3 (Y net086 VDD NW) g45p1svt w=(390n) l=45n nf=1 m=(1)
ends AND3X1
