// gsclib045_backbias/CLKMX2X8/schematic

simulator lang=spectre

subckt CLKMX2X8 A B S0 Y VDD NW VSS
mn3 (net140 B VSS VSS) g45n1svt w=(205n) l=45n nf=1 m=(1)
mn0 (S0b S0 VSS VSS) g45n1svt w=(145n) l=45n nf=1 m=(1)
mn2 (n0 S0b net148 VSS) g45n1svt w=(205n) l=45n nf=1 m=(1)
mn1 (net148 A VSS VSS) g45n1svt w=(205n) l=45n nf=1 m=(1)
mn5 (Y n0 VSS VSS) g45n1svt w=(2.065u) l=45n nf=1 m=(1)
mn4 (n0 S0 net140 VSS) g45n1svt w=(205n) l=45n nf=1 m=(1)
mp4 (n0 S0b net115 NW) g45p1svt w=(310n) l=45n nf=1 m=(1)
mp3 (net115 B VDD NW) g45p1svt w=(310n) l=45n nf=1 m=(1)
mp5 (Y n0 VDD NW) g45p1svt w=(3.115u) l=45n nf=1 m=(1)
mp2 (n0 S0 net123 NW) g45p1svt w=(310n) l=45n nf=1 m=(1)
mp0 (S0b S0 VDD NW) g45p1svt w=(215n) l=45n nf=1 m=(1)
mp1 (net123 A VDD NW) g45p1svt w=(310n) l=45n nf=1 m=(1)
ends CLKMX2X8
