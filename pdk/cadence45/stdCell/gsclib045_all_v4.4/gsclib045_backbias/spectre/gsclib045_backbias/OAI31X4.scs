// gsclib045_backbias/OAI31X4/schematic

simulator lang=spectre

subckt OAI31X4 A0 A1 A2 B0 Y NW VSS VDD
mn3 (Y B0 n0 VSS) g45n1svt w=(1.04u) l=45n nf=1 m=(1)
mn0 (n0 A0 VSS VSS) g45n1svt w=(1.04u) l=45n nf=1 m=(1)
mn2 (n0 A2 VSS VSS) g45n1svt w=(1.04u) l=45n nf=1 m=(1)
mn1 (n0 A1 VSS VSS) g45n1svt w=(1.04u) l=45n nf=1 m=(1)
mp2 (Y A2 n2 NW) g45p1svt w=(1.56u) l=45n nf=1 m=(1)
mp1 (n2 A1 n1 NW) g45p1svt w=(1.56u) l=45n nf=1 m=(1)
mp3 (Y B0 VDD NW) g45p1svt w=(1.56u) l=45n nf=1 m=(1)
mp0 (n1 A0 VDD NW) g45p1svt w=(1.56u) l=45n nf=1 m=(1)
ends OAI31X4
