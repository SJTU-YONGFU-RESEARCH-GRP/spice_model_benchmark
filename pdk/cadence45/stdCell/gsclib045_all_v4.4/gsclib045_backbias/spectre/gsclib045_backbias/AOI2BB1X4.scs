// gsclib045_backbias/AOI2BB1X4/schematic

simulator lang=spectre

subckt AOI2BB1X4 A0N A1N B0 Y NW VDD VSS
mn2 (Y B0 VSS VSS) g45n1svt w=(1.04u) l=45n nf=1 m=(1)
mn1 (net104 A1N VSS VSS) g45n1svt w=(260n) l=45n nf=1 m=(1)
mn3 (Y net104 VSS VSS) g45n1svt w=(1.04u) l=45n nf=1 m=(1)
mn0 (net104 A0N VSS VSS) g45n1svt w=(260n) l=45n nf=1 m=(1)
mp3 (Y net104 net79 NW) g45p1svt w=(1.56u) l=45n nf=1 m=(1)
mp2 (net79 B0 VDD NW) g45p1svt w=(1.56u) l=45n nf=1 m=(1)
mp1 (net104 A1N net87 NW) g45p1svt w=(390n) l=45n nf=1 m=(1)
mp0 (net87 A0N VDD NW) g45p1svt w=(390n) l=45n nf=1 m=(1)
ends AOI2BB1X4
