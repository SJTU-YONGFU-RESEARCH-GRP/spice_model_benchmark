// gsclib045_backbias/SDFFSRX4/schematic

simulator lang=spectre

subckt SDFFSRX4 CK D Q QN RN SE SI SN VSS VDD NW
mn13 (n2 SI VSS VSS) g45n1svt w=(145n) l=45n nf=1 m=(1)
mn14 (Db SE n2 VSS) g45n1svt w=(145n) l=45n nf=1 m=(1)
mn12 (Db SEb n0 VSS) g45n1svt w=(145n) l=45n nf=1 m=(1)
mn11 (n0 D VSS VSS) g45n1svt w=(145n) l=45n nf=1 m=(1)
mn57 (QN net573 VSS VSS) g45n1svt w=(1.04u) l=45n nf=1 m=(1)
mn55 (Q qbint VSS VSS) g45n1svt w=(1.04u) l=45n nf=1 m=(1)
mn35 (n6 mout VSS VSS) g45n1svt w=(145n) l=45n nf=1 m=(1)
mn36 (n20 CKbb n6 VSS) g45n1svt w=(145n) l=45n nf=1 m=(1)
mn22 (RNb RN VSS VSS) g45n1svt w=(145n) l=45n nf=1 m=(1)
mn20 (CKb CK VSS VSS) g45n1svt w=(145n) l=45n nf=1 m=(1)
mn10 (SEb SE VSS VSS) g45n1svt w=(145n) l=45n nf=1 m=(1)
mn56 (net573 qbint VSS VSS) g45n1svt w=(260n) l=45n nf=1 m=(1)
mn25 (Db CKb n20 VSS) g45n1svt w=(145n) l=45n nf=1 m=(1)
mn32 (mout n20 n4 VSS) g45n1svt w=(145n) l=45n nf=1 m=(1)
mn53 (n35 CKb n10 VSS) g45n1svt w=(145n) l=45n nf=1 m=(1)
mn30 (n4 SN VSS VSS) g45n1svt w=(145n) l=45n nf=1 m=(1)
mn50 (n8 SN VSS VSS) g45n1svt w=(145n) l=45n nf=1 m=(1)
mn51 (n10 RNb n8 VSS) g45n1svt w=(145n) l=45n nf=1 m=(1)
mn40 (n35 CKbb mout VSS) g45n1svt w=(145n) l=45n nf=1 m=(1)
mn31 (mout RNb n4 VSS) g45n1svt w=(145n) l=45n nf=1 m=(1)
mn21 (CKbb CKb VSS VSS) g45n1svt w=(145n) l=45n nf=1 m=(1)
mn52 (n10 qbint n8 VSS) g45n1svt w=(145n) l=45n nf=1 m=(1)
mn45 (qbint n35 VSS VSS) g45n1svt w=(410n) l=45n nf=1 m=(1)
mp14 (Db SEb n3 NW) g45p1svt w=(215n) l=45n nf=1 m=(1)
mp13 (n3 SI VDD NW) g45p1svt w=(215n) l=45n nf=1 m=(1)
mp12 (Db SE n1 NW) g45p1svt w=(215n) l=45n nf=1 m=(1)
mp11 (n1 D VDD NW) g45p1svt w=(215n) l=45n nf=1 m=(1)
mp52 (n11 qbint n9 NW) g45p1svt w=(215n) l=45n nf=1 m=(1)
mp51 (n9 RNb VDD NW) g45p1svt w=(215n) l=45n nf=1 m=(1)
mp57 (QN net573 VDD NW) g45p1svt w=(1.56u) l=45n nf=1 m=(1)
mp55 (Q qbint VDD NW) g45p1svt w=(1.56u) l=45n nf=1 m=(1)
mp36 (n20 CKb n7 NW) g45p1svt w=(215n) l=45n nf=1 m=(1)
mp35 (n7 mout VDD NW) g45p1svt w=(215n) l=45n nf=1 m=(1)
mp32 (mout n20 n5 NW) g45p1svt w=(215n) l=45n nf=1 m=(1)
mp31 (n5 RNb VDD NW) g45p1svt w=(215n) l=45n nf=1 m=(1)
mp22 (RNb RN VDD NW) g45p1svt w=(215n) l=45n nf=1 m=(1)
mp20 (CKb CK VDD NW) g45p1svt w=(215n) l=45n nf=1 m=(1)
mp21 (CKbb CKb VDD NW) g45p1svt w=(215n) l=45n nf=1 m=(1)
mp45 (qbint n35 VDD NW) g45p1svt w=(620n) l=45n nf=1 m=(1)
mp30 (mout SN VDD NW) g45p1svt w=(215n) l=45n nf=1 m=(1)
mp25 (n20 CKbb Db NW) g45p1svt w=(215n) l=45n nf=1 m=(1)
mp56 (net573 qbint VDD NW) g45p1svt w=(390n) l=45n nf=1 m=(1)
mp40 (n35 CKb mout NW) g45p1svt w=(215n) l=45n nf=1 m=(1)
mp53 (n35 CKbb n11 NW) g45p1svt w=(215n) l=45n nf=1 m=(1)
mp50 (n11 SN VDD NW) g45p1svt w=(215n) l=45n nf=1 m=(1)
mp10 (SEb SE VDD NW) g45p1svt w=(215n) l=45n nf=1 m=(1)
ends SDFFSRX4
