// Generated for: spectre (May  1 11:27:40 2013 )
// Library name: gsclib045_backbias
// Cell name: AOI22X2
// View name: extracted

simulator lang=spectre

subckt AOI22X2 A0 A1 B0 B1 NW VDD VSS Y
mp0_1__rcx (net89 \2\:A0 \1\:VDD NW) g45p1svt w=(3.9e-07) l=4.5e-08 nf=1 \
        as=7.995e-14 ad=9.262e-14 ps=1.19e-06 pd=1.255e-06 nrd=1.16667 \
        nrs=1.16667 sa=1.4e-07 sb=1.84e-06 sd=160n sca=31.4293 \
        scb=0.0302361 scc=0.00287283 m=(2)
mp1 (\10\:net89 \3\:A1 \1\:VDD NW) g45p1svt w=(3.9e-07) l=4.5e-08 nf=1 \
        as=7.995e-14 ad=6.24e-14 ps=1.19e-06 pd=1.1e-06 nrd=1.16667 \
        nrs=1.16667 sa=3.45e-07 sb=1.635e-06 sd=160n sca=25.8099 \
        scb=0.0207374 scc=0.00244421 m=(2)
mp3 (\1\:Y \1\:B1 \3\:net89 NW) g45p1svt w=(3.9e-07) l=4.5e-08 nf=1 \
        as=6.24e-14 ad=6.24e-14 ps=1.1e-06 pd=1.1e-06 nrd=1.16667 \
        nrs=1.16667 sa=1.43e-06 sb=5.5e-07 sd=160n sca=24.4001 \
        scb=0.0188912 scc=0.00243299 m=(2)
mp2_1__rcx (\1\:Y \1\:B0 net89 NW) g45p1svt w=(3.9e-07) l=4.5e-08 nf=1 \
        as=9.262e-14 ad=6.24e-14 ps=1.255e-06 pd=1.1e-06 nrd=1.16667 \
        nrs=1.16667 sa=1.225e-06 sb=7.55e-07 sd=160n sca=23.571 \
        scb=0.0183444 scc=0.00243237 m=(2)
C1 (NW VSS) capacitor c=2.65346e-16
C2 (Y VSS) capacitor c=3.79012e-17
C3 (B1 VSS) capacitor c=5.73436e-17
C4 (A0 VSS) capacitor c=2.38427e-17
C5 (VDD VSS) capacitor c=3.78864e-17
C6 (B0 VSS) capacitor c=3.77173e-17
C7 (11 VSS) capacitor c=1.596e-18
C8 (12 VSS) capacitor c=3.31755e-18
C9 (net89 VSS) capacitor c=2.40756e-16
C10 (\1\:B1 VSS) capacitor c=9.70409e-17
C11 (\1\:B0 VSS) capacitor c=3.13574e-16
C12 (\6\:B0 VSS) capacitor c=3.72191e-17
C13 (\6\:B1 VSS) capacitor c=3.4551e-17
C14 (\4\:B1 VSS) capacitor c=4.76982e-17
C15 (\3\:B0 VSS) capacitor c=4.10391e-17
C16 (\6\:A0 VSS) capacitor c=5.79125e-17
C17 (\1\:A1 VSS) capacitor c=5.63712e-17
C18 (\4\:A1 VSS) capacitor c=5.13876e-17
C19 (\1\:A0 VSS) capacitor c=5.02193e-17
C20 (\3\:A1 VSS) capacitor c=9.86241e-17
C21 (\2\:A0 VSS) capacitor c=3.18573e-16
C22 (\1\:Y VSS) capacitor c=1.97644e-16
C23 (\3\:net89 VSS) capacitor c=1.1181e-16
C24 (\1\:VDD VSS) capacitor c=3.11991e-16
C25 (\10\:net89 VSS) capacitor c=3.47449e-17
C26 (\9\:Y VSS) capacitor c=5.0633e-17
C27 (\7\:Y VSS) capacitor c=5.36694e-17
C28 (\2\:A1 VSS) capacitor c=3.68702e-17
C29 (\3\:B1 VSS) capacitor c=1.87409e-17
C30 (\7\:A1 VSS) capacitor c=2.88107e-17
C31 (\9\:A1 VSS) capacitor c=3.70623e-17
C32 (\8\:B1 VSS) capacitor c=2.79725e-17
C33 (\5\:Y VSS) capacitor c=4.39301e-17
C34 (\6\:Y VSS) capacitor c=7.17132e-17
Rk13 (\5\:Y Y) resistor r=0.06149 c=0
Rk10 (\1\:Y \5\:Y) resistor r=0.2738 c=0
Rk11 (\5\:Y \6\:Y) resistor r=0.2504 c=0
Rk12 (\6\:Y \8\:Y) resistor r=0.3232 c=0
Rk14 (\6\:Y \10\:Y) resistor r=0.3095 c=0
Rk6 (\7\:B1 \8\:B1) resistor r=0.001097 c=0
Rk7 (\9\:B1 B1) resistor r=0.001206 c=0
Rk8 (\8\:B1 \9\:B1) resistor r=0.03292 c=0
Rk5 (\2\:A0 A0) resistor r=0.1194 c=0
Rk22 (\2\:VSS \4\:VSS) resistor r=0.6683 c=0
Rk24 (\5\:VSS VSS) resistor r=0.18 c=0
Rk23 (\4\:VSS \5\:VSS) resistor r=0.3211 c=0
Rk25 (\4\:VSS \7\:VSS) resistor r=0.2111 c=0
Rk26 (\5\:VSS \9\:VSS) resistor r=0.2293 c=0
Rk28 (\1\:VDD VDD) resistor r=0.1374 c=0
Rk20 (B0 \1\:B0) resistor r=0.1831 c=0
Rk1 (\7\:A1 \8\:A1) resistor r=0.001293 c=0
Rk2 (A1 \9\:A1) resistor r=0.001164 c=0
Rk3 (\7\:A1 \9\:A1) resistor r=0.0225 c=0
Rk19 (net89 \11\:net89) resistor r=0.06242 c=0
Rl13 (\3\:B1 \1\:B1) resistor r=13.5863 c=0
Rl16 (\3\:B1 \6\:B1) resistor r=32.2187 c=0
Rl14 (\3\:B1 \4\:B1) resistor r=75.2063 c=0
Rl9 (\2\:A0 \6\:A0) resistor r=29.5379 c=0
Rl1 (\2\:A0 \1\:A0) resistor r=30.9849 c=0
Rl18 (\1\:B0 \6\:B0) resistor r=24.7951 c=0
Rl11 (\1\:B0 \3\:B0) resistor r=29.5379 c=0
Rl3 (\2\:A1 \1\:A1) resistor r=95.9194 c=0
Rl5 (\2\:A1 \4\:A1) resistor r=51.7685 c=0
Rl4 (\2\:A1 \3\:A1) resistor r=10.4 c=0
Rz1 (\8\:Y \7\:Y) resistor r=75 c=0
Rz2 (\10\:Y \9\:Y) resistor r=75 c=0
Rz3 (\1\:VSS \2\:VSS) resistor r=75 c=0
Rz4 (\6\:VSS \7\:VSS) resistor r=75 c=0
Rz5 (\8\:VSS \9\:VSS) resistor r=75 c=0
Ry4 (net89 \3\:net89) resistor r=62 c=0
Ry7 (\11\:net89 \10\:net89) resistor r=31 c=0
Rx4 (\7\:B1 \1\:B1) resistor r=45 c=0
Rx1 (\8\:A1 \3\:A1) resistor r=45 c=0
mn0_1__rcx (10 \1\:A0 \8\:VSS VSS) g45n1svt w=(2.6e-07) l=4.5e-08 nf=1 \
        as=3.64e-14 ad=1.56e-14 ps=8e-07 pd=6.4e-07 nrd=1.16667 \
        nrs=1.16667 sa=1.4e-07 sb=1.45e-06 sd=160n sca=10.79 scb=0.0100512 \
        scc=0.000418069 m=(1)
mn1_1__rcx (\7\:Y \4\:A1 10 VSS) g45n1svt w=(2.6e-07) l=4.5e-08 nf=1 \
        as=1.56e-14 ad=4.16e-14 ps=6.4e-07 pd=8.4e-07 nrd=1.16667 \
        nrs=1.16667 sa=2.45e-07 sb=1.345e-06 sd=160n sca=10.79 \
        scb=0.0100512 scc=0.000418069 m=(1)
mn1 (\7\:Y \1\:A1 11 VSS) g45n1svt w=(2.6e-07) l=4.5e-08 nf=1 as=1.56e-14 \
        ad=4.16e-14 ps=6.4e-07 pd=8.4e-07 nrd=1.16667 nrs=1.16667 \
        sa=4.5e-07 sb=1.14e-06 sd=160n sca=10.79 scb=0.0100512 \
        scc=0.000418069 m=(1)
mn0 (11 \6\:A0 \6\:VSS VSS) g45n1svt w=(2.6e-07) l=4.5e-08 nf=1 \
        as=9.79e-14 ad=1.56e-14 ps=1.37e-06 pd=6.4e-07 nrd=1.16667 \
        nrs=1.16667 sa=5.55e-07 sb=1.035e-06 sd=160n sca=10.79 \
        scb=0.0100512 scc=0.000418069 m=(1)
mn2_1__rcx (12 \3\:B0 \6\:VSS VSS) g45n1svt w=(2.6e-07) l=4.5e-08 nf=1 \
        as=9.79e-14 ad=3.12e-14 ps=1.37e-06 pd=7.6e-07 nrd=1.16667 \
        nrs=1.16667 sa=9.35e-07 sb=6.55e-07 sd=160n sca=10.79 \
        scb=0.0100512 scc=0.000418069 m=(1)
mn3_1__rcx (\9\:Y \4\:B1 12 VSS) g45n1svt w=(2.6e-07) l=4.5e-08 nf=1 \
        as=3.12e-14 ad=4.16e-14 ps=7.6e-07 pd=8.4e-07 nrd=1.16667 \
        nrs=1.16667 sa=1.1e-06 sb=4.9e-07 sd=160n sca=10.79 scb=0.0100512 \
        scc=0.000418069 m=(1)
mn3 (\9\:Y \6\:B1 13 VSS) g45n1svt w=(2.6e-07) l=4.5e-08 nf=1 as=2.6e-14 \
        ad=4.16e-14 ps=7.2e-07 pd=8.4e-07 nrd=1.16667 nrs=1.16667 \
        sa=1.305e-06 sb=2.85e-07 sd=160n sca=10.79 scb=0.0100512 \
        scc=0.000418069 m=(1)
mn2 (13 \6\:B0 \1\:VSS VSS) g45n1svt w=(2.6e-07) l=4.5e-08 nf=1 \
        as=3.64e-14 ad=2.6e-14 ps=8e-07 pd=7.2e-07 nrd=1.16667 nrs=1.16667 \
        sa=1.45e-06 sb=1.4e-07 sd=160n sca=10.79 scb=0.0100512 \
        scc=0.000418069 m=(1)
ends AOI22X2
// End of subcircuit definition.
