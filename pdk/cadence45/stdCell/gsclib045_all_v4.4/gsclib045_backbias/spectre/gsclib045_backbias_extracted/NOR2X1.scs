// Generated for: spectre (May  1 11:30:44 2013 )
// Library name: gsclib045_backbias
// Cell name: NOR2X1
// View name: extracted

simulator lang=spectre

subckt NOR2X1 A B NW VDD VSS Y
mp0 (net41 \1\:A \1\:VDD NW) g45p1svt w=(3.9e-07) l=4.5e-08 nf=1 \
        as=5.46e-14 ad=2.34e-14 ps=1.06e-06 pd=9e-07 nrd=1.16667 \
        nrs=1.16667 sa=1.4e-07 sb=3e-07 sd=160n sca=47.9961 scb=0.0439169 \
        scc=0.00481722 m=(1)
mp1 (\1\:Y \3\:B net41 NW) g45p1svt w=(3.9e-07) l=4.5e-08 nf=1 \
        as=2.34e-14 ad=7.605e-14 ps=9e-07 pd=1.17e-06 nrd=1.16667 \
        nrs=1.16667 sa=2.45e-07 sb=1.95e-07 sd=160n sca=44.1 scb=0.0398973 \
        scc=0.00391616 m=(1)
C1 (A VSS) capacitor c=6.64409e-17
C2 (VDD VSS) capacitor c=9.03998e-17
C3 (NW VSS) capacitor c=1.12203e-16
C4 (Y VSS) capacitor c=3.8922e-17
C5 (B VSS) capacitor c=5.76317e-17
C6 (net41 VSS) capacitor c=1.01113e-18
C7 (\3\:B VSS) capacitor c=6.41479e-17
C8 (\1\:A VSS) capacitor c=6.44101e-17
C9 (\1\:B VSS) capacitor c=3.39562e-17
C10 (\4\:A VSS) capacitor c=3.25501e-17
C11 (\2\:B VSS) capacitor c=3.50524e-17
C12 (\3\:A VSS) capacitor c=1.24498e-17
C13 (\1\:Y VSS) capacitor c=7.46817e-17
C14 (\1\:VDD VSS) capacitor c=6.57453e-17
C15 (\3\:Y VSS) capacitor c=5.1272e-17
C16 (\2\:A VSS) capacitor c=2.63394e-17
C17 (\4\:B VSS) capacitor c=6.30393e-17
Rk1 (\5\:A A) resistor r=0.01003 c=0
Rk8 (\2\:VDD VDD) resistor r=0.3729 c=0
Rk3 (\2\:Y Y) resistor r=0.2872 c=0
Rk4 (Y \4\:Y) resistor r=0.2283 c=0
Rk6 (\4\:VSS VSS) resistor r=0.1004 c=0
Rk5 (\2\:VSS \4\:VSS) resistor r=0.1357 c=0
Rk7 (VSS \6\:VSS) resistor r=0.3123 c=0
Rk2 (\4\:B B) resistor r=0.1667 c=0
Rl1 (\1\:A \2\:A) resistor r=37.3411 c=0
Rl3 (\2\:A \4\:A) resistor r=64.2642 c=0
Rl2 (\2\:A \3\:A) resistor r=3.7301 c=0
Rl5 (\2\:B \3\:B) resistor r=28.079 c=0
Rl4 (\1\:B \2\:B) resistor r=72.7926 c=0
Rz1 (\3\:Y \4\:Y) resistor r=37.5 c=0
Rz2 (\1\:VSS \2\:VSS) resistor r=75 c=0
Rz3 (\5\:VSS \6\:VSS) resistor r=37.5 c=0
Ry3 (\1\:VDD \2\:VDD) resistor r=20.6667 c=0
Ry1 (\1\:Y \2\:Y) resistor r=20.6667 c=0
Rx1 (\3\:A \5\:A) resistor r=45 c=0
Rx2 (\2\:B \4\:B) resistor r=45 c=0
mn0 (\3\:Y \4\:A \5\:VSS VSS) g45n1svt w=(2.6e-07) l=4.5e-08 nf=1 \
        as=3.64e-14 ad=4.16e-14 ps=8e-07 pd=8.4e-07 nrd=1.16667 \
        nrs=1.16667 sa=1.4e-07 sb=3.15e-07 sd=160n sca=12.8392 \
        scb=0.0126987 scc=0.00074151 m=(1)
mn1 (\3\:Y \1\:B \1\:VSS VSS) g45n1svt w=(2.6e-07) l=4.5e-08 nf=1 \
        as=5.2e-14 ad=4.16e-14 ps=1.4e-06 pd=8.4e-07 nrd=1.16667 \
        nrs=1.16667 sa=3.45e-07 sb=1.1e-07 sd=160n sca=12.8392 \
        scb=0.0126987 scc=0.00074151 m=(1)
ends NOR2X1
// End of subcircuit definition.
