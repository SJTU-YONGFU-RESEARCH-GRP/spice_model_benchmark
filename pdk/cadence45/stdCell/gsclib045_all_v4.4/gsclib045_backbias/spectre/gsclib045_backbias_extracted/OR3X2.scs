// Generated for: spectre (May  1 11:31:57 2013 )
// Library name: gsclib045_backbias
// Cell name: OR3X2
// View name: extracted

simulator lang=spectre

subckt OR3X2 A B C NW VDD VSS Y
mp2 (\15\:n0 \1\:C n2 NW) g45p1svt w=(2.15e-07) l=4.5e-08 nf=1 \
        as=3.44e-14 ad=3.01e-14 ps=7.5e-07 pd=7.1e-07 nrd=1.16667 \
        nrs=1.16667 sa=1.4e-07 sb=1.05e-06 sd=160n sca=25.9711 \
        scb=0.030099 scc=0.00176698 m=(1)
mp1 (n2 \1\:B n1 NW) g45p1svt w=(2.15e-07) l=4.5e-08 nf=1 as=3.655e-14 \
        ad=3.44e-14 ps=7.7e-07 pd=7.5e-07 nrd=1.16667 nrs=1.16667 \
        sa=3.45e-07 sb=8.45e-07 sd=160n sca=15.9373 scb=0.0154264 \
        scc=0.000402358 m=(1)
mp0 (n1 \3\:A \1\:VDD NW) g45p1svt w=(2.15e-07) l=4.5e-08 nf=1 \
        as=6.535e-14 ad=3.655e-14 ps=1.16e-06 pd=7.7e-07 nrd=1.16667 \
        nrs=1.16667 sa=5.6e-07 sb=6.3e-07 sd=160n sca=13.9701 \
        scb=0.0119484 scc=0.000361488 m=(1)
C1 (C VSS) capacitor c=2.88828e-17
C2 (NW VSS) capacitor c=2.21809e-16
C3 (A VSS) capacitor c=7.64402e-17
C4 (VDD VSS) capacitor c=6.13703e-17
C5 (B VSS) capacitor c=3.07466e-17
C6 (n0 VSS) capacitor c=1.75401e-16
C7 (n2 VSS) capacitor c=5.11997e-18
C8 (n1 VSS) capacitor c=7.66594e-18
C9 (\3\:A VSS) capacitor c=5.57996e-17
C10 (\1\:B VSS) capacitor c=4.19357e-17
C11 (\1\:C VSS) capacitor c=4.83244e-17
C12 (\1\:A VSS) capacitor c=4.06474e-17
C13 (\4\:B VSS) capacitor c=5.35893e-17
C14 (\4\:C VSS) capacitor c=3.86158e-17
C15 (\2\:A VSS) capacitor c=6.51792e-17
C16 (\3\:B VSS) capacitor c=2.83231e-17
C17 (\3\:C VSS) capacitor c=1.68262e-17
C18 (\1\:VDD VSS) capacitor c=2.11079e-16
C19 (\2\:Y VSS) capacitor c=7.81703e-17
C20 (\15\:n0 VSS) capacitor c=7.86276e-17
C21 (\4\:Y VSS) capacitor c=6.08426e-17
C22 (\13\:n0 VSS) capacitor c=2.72943e-17
C23 (\11\:n0 VSS) capacitor c=5.40998e-17
C24 (\2\:C VSS) capacitor c=4.46071e-17
C25 (\2\:B VSS) capacitor c=4.12343e-17
C26 (\5\:C VSS) capacitor c=4.15819e-17
C27 (\5\:B VSS) capacitor c=5.88357e-17
C28 (\8\:n0 VSS) capacitor c=6.31827e-17
C29 (\9\:n0 VSS) capacitor c=2.73322e-17
C30 (\10\:n0 VSS) capacitor c=1.13847e-16
C31 (\1\:Y VSS) capacitor c=5.33783e-17
Rk9 (Y \1\:Y) resistor r=0.02462 c=0
Rk10 (\1\:Y \3\:Y) resistor r=0.3696 c=0
Rk11 (\1\:Y \5\:Y) resistor r=0.2381 c=0
Rk1 (C \5\:C) resistor r=0.1167 c=0
Rk3 (\4\:A A) resistor r=0.004839 c=0
Rk18 (\1\:VDD VDD) resistor r=0.3278 c=0
Rk14 (\5\:VSS VSS) resistor r=0.1023 c=0
Rk13 (\1\:VSS \5\:VSS) resistor r=0.1978 c=0
Rk16 (\5\:VSS \9\:VSS) resistor r=0.1755 c=0
Rk2 (B \5\:B) resistor r=0.1047 c=0
Rk4 (\8\:n0 \9\:n0) resistor r=0.3198 c=0
Rk5 (\9\:n0 \10\:n0) resistor r=0.04884 c=0
Rk6 (\10\:n0 \12\:n0) resistor r=0.3857 c=0
Rk7 (\9\:n0 \14\:n0) resistor r=0.09798 c=0
Rk8 (\10\:n0 \16\:n0) resistor r=0.7681 c=0
Rl1 (\1\:C \2\:C) resistor r=154.649 c=0
Rl3 (\2\:C \4\:C) resistor r=108.495 c=0
Rl2 (\2\:C \3\:C) resistor r=5.6709 c=0
Rl8 (\2\:A \3\:A) resistor r=145.69 c=0
Rl7 (\1\:A \2\:A) resistor r=101.718 c=0
Rl4 (\1\:B \2\:B) resistor r=85.4181 c=0
Rl6 (\2\:B \4\:B) resistor r=177.726 c=0
Rl5 (\2\:B \3\:B) resistor r=3.1183 c=0
Rz3 (\5\:Y \4\:Y) resistor r=37.5 c=0
Rz6 (\9\:VSS \8\:VSS) resistor r=75 c=0
Rz1 (\12\:n0 \11\:n0) resistor r=75 c=0
Rz2 (\14\:n0 \13\:n0) resistor r=75 c=0
Ry2 (\3\:Y \2\:Y) resistor r=20.6667 c=0
Ry1 (\16\:n0 \15\:n0) resistor r=62 c=0
Rx1 (\3\:C \5\:C) resistor r=45 c=0
Rx3 (\2\:A \4\:A) resistor r=45 c=0
Rx2 (\3\:B \5\:B) resistor r=45 c=0
Rx4 (\8\:n0 n0) resistor r=45 c=0
mn2 (\11\:n0 \4\:C \8\:VSS VSS) g45n1svt w=(1.45e-07) l=4.5e-08 nf=1 \
        as=2.32e-14 ad=2.03e-14 ps=6.1e-07 pd=5.7e-07 nrd=1.16667 \
        nrs=1.16667 sa=1.4e-07 sb=1.095e-06 sd=160n sca=6.59604 \
        scb=0.00318587 scc=2.16275e-05 m=(1)
mn1 (\13\:n0 \4\:B \8\:VSS VSS) g45n1svt w=(1.45e-07) l=4.5e-08 nf=1 \
        as=2.32e-14 ad=2.972e-14 ps=6.1e-07 pd=7e-07 nrd=1.16667 \
        nrs=1.16667 sa=3.45e-07 sb=8.9e-07 sd=160n sca=6.59604 \
        scb=0.00318587 scc=2.16275e-05 m=(1)
mn0 (\13\:n0 \1\:A \1\:VSS VSS) g45n1svt w=(1.45e-07) l=4.5e-08 nf=1 \
        as=4.775e-14 ad=2.972e-14 ps=1.02e-06 pd=7e-07 nrd=1.16667 \
        nrs=1.16667 sa=5.95e-07 sb=6.4e-07 sd=160n sca=6.59604 \
        scb=0.00318587 scc=2.16275e-05 m=(1)
mn3 (\4\:Y n0 \1\:VSS VSS) g45n1svt w=(2.6e-07) l=4.5e-08 nf=1 \
        as=4.207e-14 ad=4.16e-14 ps=9.1e-07 pd=8.4e-07 nrd=1.16667 \
        nrs=1.16667 sa=5.40577e-07 sb=3.45e-07 sd=160n sca=7.84363 \
        scb=0.00546499 scc=9.84911e-05 m=(2)
mp3 (\2\:Y n0 \1\:VDD NW) g45p1svt w=(3.9e-07) l=4.5e-08 nf=1 \
        as=6.973e-14 ad=6.24e-14 ps=1.16e-06 pd=1.1e-06 nrd=1.16667 \
        nrs=1.16667 sa=5.0109e-07 sb=3.95e-07 sd=160n sca=29.1463 \
        scb=0.0209237 scc=0.00296778 m=(2)
ends OR3X2
// End of subcircuit definition.
