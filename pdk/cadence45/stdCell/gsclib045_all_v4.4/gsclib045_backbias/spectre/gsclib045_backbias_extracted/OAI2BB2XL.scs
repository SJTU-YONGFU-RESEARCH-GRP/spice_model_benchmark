// Generated for: spectre (May  1 11:31:40 2013 )
// Library name: gsclib045_backbias
// Cell name: OAI2BB2XL
// View name: extracted

simulator lang=spectre

subckt OAI2BB2XL A0N A1N B0 B1 NW VDD VSS Y
mp1 (\7\:n1 \1\:A1N \7\:VDD NW) g45p1svt w=(2.15e-07) l=4.5e-08 nf=1 \
        as=3.44e-14 ad=3.01e-14 ps=7.5e-07 pd=7.1e-07 nrd=1.16667 \
        nrs=1.16667 sa=1.4e-07 sb=4.45e-07 sd=160n sca=21.2082 \
        scb=0.024206 scc=0.000913232 m=(1)
mp0 (\8\:n0 \1\:A0N \7\:VDD NW) g45p1svt w=(2.15e-07) l=4.5e-08 nf=1 \
        as=3.44e-14 ad=5.16e-14 ps=7.5e-07 pd=9.1e-07 nrd=1.16667 \
        nrs=1.16667 sa=3.45e-07 sb=2.4e-07 sd=160n sca=15.1467 \
        scb=0.0140576 scc=0.000405776 m=(1)
mp2 (n2 n0 \1\:VDD NW) g45p1svt w=(2.15e-07) l=4.5e-08 nf=1 as=3.01e-14 \
        ad=1.29e-14 ps=7.1e-07 pd=5.5e-07 nrd=1.16667 nrs=1.16667 \
        sa=1.4e-07 sb=5.55e-07 sd=160n sca=10.6631 scb=0.00766851 \
        scc=8.4038e-05 m=(1)
mp3 (\3\:Y n1 n2 NW) g45p1svt w=(2.15e-07) l=4.5e-08 nf=1 as=1.29e-14 \
        ad=3.44e-14 ps=5.5e-07 pd=7.5e-07 nrd=1.16667 nrs=1.16667 \
        sa=2.45e-07 sb=4.5e-07 sd=160n sca=11.0775 scb=0.00792476 \
        scc=8.42509e-05 m=(1)
mp5 (\3\:Y \1\:B1 n3 NW) g45p1svt w=(2.15e-07) l=4.5e-08 nf=1 as=1.29e-14 \
        ad=3.44e-14 ps=5.5e-07 pd=7.5e-07 nrd=1.16667 nrs=1.16667 \
        sa=4.5e-07 sb=2.45e-07 sd=160n sca=12.6898 scb=0.00990074 \
        scc=9.48225e-05 m=(1)
mp4 (n3 \3\:B0 \5\:VDD NW) g45p1svt w=(2.15e-07) l=4.5e-08 nf=1 \
        as=3.01e-14 ad=1.29e-14 ps=7.1e-07 pd=5.5e-07 nrd=1.16667 \
        nrs=1.16667 sa=5.55e-07 sb=1.4e-07 sd=160n sca=14.5245 \
        scb=0.0130308 scc=0.000155148 m=(1)
C1 (NW VSS) capacitor c=3.47936e-16
C2 (A0N VSS) capacitor c=1.03316e-16
C3 (B0 VSS) capacitor c=5.37853e-17
C4 (VDD VSS) capacitor c=3.72755e-17
C5 (A1N VSS) capacitor c=7.24798e-17
C6 (n1 VSS) capacitor c=1.14538e-16
C7 (n0 VSS) capacitor c=9.26058e-17
C8 (n4 VSS) capacitor c=5.86839e-17
C9 (n3 VSS) capacitor c=6.6552e-18
C10 (\3\:B0 VSS) capacitor c=6.7608e-17
C11 (\1\:B1 VSS) capacitor c=7.5604e-17
C12 (\1\:A0N VSS) capacitor c=4.73899e-17
C13 (\1\:A1N VSS) capacitor c=3.24887e-17
C14 (\1\:B0 VSS) capacitor c=4.25401e-17
C15 (\3\:B1 VSS) capacitor c=4.6971e-17
C16 (\2\:n1 VSS) capacitor c=5.09694e-17
C17 (\3\:n0 VSS) capacitor c=3.29351e-17
C18 (\3\:A0N VSS) capacitor c=3.54066e-17
C19 (\3\:A1N VSS) capacitor c=4.53189e-17
C20 (\4\:B0 VSS) capacitor c=1.22587e-17
C21 (\2\:B1 VSS) capacitor c=5.91522e-17
C22 (\3\:n1 VSS) capacitor c=2.6058e-17
C23 (\2\:n0 VSS) capacitor c=4.13811e-17
C24 (\2\:A0N VSS) capacitor c=3.61426e-17
C25 (\2\:A1N VSS) capacitor c=3.97249e-17
C26 (\5\:VDD VSS) capacitor c=9.05894e-17
C27 (\3\:Y VSS) capacitor c=1.33433e-16
C28 (\1\:VDD VSS) capacitor c=1.83243e-17
C29 (\8\:n0 VSS) capacitor c=3.27551e-17
C30 (\7\:VDD VSS) capacitor c=3.0917e-17
C31 (\7\:n1 VSS) capacitor c=6.53433e-17
C32 (\1\:Y VSS) capacitor c=1.09206e-16
C33 (\3\:n4 VSS) capacitor c=1.91291e-16
C34 (\5\:n4 VSS) capacitor c=1.43512e-16
C35 (\6\:n0 VSS) capacitor c=5.984e-17
C36 (\5\:n1 VSS) capacitor c=2.21956e-16
C37 (\2\:B0 VSS) capacitor c=4.51078e-17
C38 (\4\:A1N VSS) capacitor c=5.24448e-17
C39 (\4\:A0N VSS) capacitor c=2.53737e-17
C40 (\4\:n0 VSS) capacitor c=4.04086e-17
C41 (\5\:n0 VSS) capacitor c=6.65317e-17
C42 (\4\:n1 VSS) capacitor c=2.31455e-16
C43 (\4\:B1 VSS) capacitor c=1.25519e-16
C44 (\5\:B0 VSS) capacitor c=4.08622e-17
C45 (\3\:VDD VSS) capacitor c=8.5422e-17
C46 (\4\:VDD VSS) capacitor c=5.84044e-17
Rk11 (\2\:Y Y) resistor r=0.715 c=0
Rk12 (Y \4\:Y) resistor r=0.003012 c=0
Rk10 (\4\:B1 B1) resistor r=0.003 c=0
Rk21 (\2\:VSS \4\:VSS) resistor r=0.3339 c=0
Rk23 (\5\:VSS VSS) resistor r=0.1124 c=0
Rk22 (\4\:VSS \5\:VSS) resistor r=0.3885 c=0
Rk24 (\5\:VSS \7\:VSS) resistor r=0.07381 c=0
Rk4 (\4\:A0N A0N) resistor r=0.009001 c=0
Rk15 (B0 \5\:B0) resistor r=0.1827 c=0
Rk16 (\2\:VDD \3\:VDD) resistor r=0.2273 c=0
Rk18 (\4\:VDD VDD) resistor r=0.1324 c=0
Rk17 (\3\:VDD \4\:VDD) resistor r=0.471 c=0
Rk19 (\3\:VDD \6\:VDD) resistor r=0.5283 c=0
Rk20 (\4\:VDD \8\:VDD) resistor r=0.2974 c=0
Rk1 (A1N \4\:A1N) resistor r=0.165 c=0
Rk8 (\4\:n1 \6\:n1) resistor r=1.6729 c=0
Rk9 (\6\:n1 \8\:n1) resistor r=0.5418 c=0
Rk5 (\4\:n0 \5\:n0) resistor r=0.267 c=0
Rk6 (\5\:n0 \7\:n0) resistor r=0.3793 c=0
Rk7 (\5\:n0 \9\:n0) resistor r=0.1828 c=0
Rk13 (\2\:n4 \4\:n4) resistor r=0.5383 c=0
Rk14 (\4\:n4 \6\:n4) resistor r=1.0234 c=0
Rl9 (\1\:B1 \2\:B1) resistor r=116.076 c=0
Rl10 (\2\:B1 \3\:B1) resistor r=131.461 c=0
Rl3 (\1\:A0N \2\:A0N) resistor r=149.175 c=0
Rl4 (\2\:A0N \3\:A0N) resistor r=35.7134 c=0
Rl12 (\2\:B0 \3\:B0) resistor r=124.51 c=0
Rl11 (\1\:B0 \2\:B0) resistor r=166.77 c=0
Rl13 (\2\:B0 \4\:B0) resistor r=4.5402 c=0
Rl1 (\1\:A1N \2\:A1N) resistor r=41.0764 c=0
Rl2 (\2\:A1N \3\:A1N) resistor r=150.692 c=0
Rl7 (n1 \2\:n1) resistor r=273.077 c=0
Rl8 (\2\:n1 \3\:n1) resistor r=37.2302 c=0
Rl5 (n0 \2\:n0) resistor r=203.4 c=0
Rl6 (\2\:n0 \3\:n0) resistor r=149.233 c=0
Rz3 (\1\:Y \2\:Y) resistor r=75 c=0
Rz7 (\1\:VSS \2\:VSS) resistor r=75 c=0
Rz8 (\6\:VSS \7\:VSS) resistor r=75 c=0
Rz2 (\5\:n1 \6\:n1) resistor r=75 c=0
Rz1 (\6\:n0 \7\:n0) resistor r=75 c=0
Rz4 (n4 \2\:n4) resistor r=75 c=0
Rz5 (\3\:n4 \4\:n4) resistor r=75 c=0
Rz6 (\5\:n4 \6\:n4) resistor r=75 c=0
Ry3 (\3\:Y \4\:Y) resistor r=62 c=0
Ry4 (\1\:VDD \2\:VDD) resistor r=62 c=0
Ry5 (\5\:VDD \6\:VDD) resistor r=62 c=0
Ry6 (\7\:VDD \8\:VDD) resistor r=62 c=0
Ry2 (\7\:n1 \8\:n1) resistor r=62 c=0
Ry1 (\8\:n0 \9\:n0) resistor r=62 c=0
Rx5 (\2\:B1 \4\:B1) resistor r=45 c=0
Rx2 (\2\:A0N \4\:A0N) resistor r=45 c=0
Rx6 (\4\:B0 \5\:B0) resistor r=45 c=0
Rx1 (\2\:A1N \4\:A1N) resistor r=45 c=0
Rx4 (\3\:n1 \4\:n1) resistor r=45 c=0
Rx3 (\2\:n0 \4\:n0) resistor r=45 c=0
mn1 (\5\:n1 \3\:A1N \6\:VSS VSS) g45n1svt w=(1.45e-07) l=4.5e-08 nf=1 \
        as=4.538e-14 ad=2.465e-14 ps=1.32e-06 pd=6.3e-07 nrd=1.16667 \
        nrs=1.16667 sa=1.7e-07 sb=4.2e-07 sd=160n sca=10.0732 \
        scb=0.00911402 scc=0.000253284 m=(1)
mn0 (\6\:n0 \3\:A0N \6\:VSS VSS) g45n1svt w=(1.45e-07) l=4.5e-08 nf=1 \
        as=4.538e-14 ad=3.19e-14 ps=1.32e-06 pd=7.3e-07 nrd=1.16667 \
        nrs=1.16667 sa=3.7e-07 sb=2.2e-07 sd=160n sca=10.0732 \
        scb=0.00911402 scc=0.000253284 m=(1)
mn2 (\5\:n4 \3\:n0 \1\:VSS VSS) g45n1svt w=(1.45e-07) l=4.5e-08 nf=1 \
        as=5.22e-14 ad=3.698e-14 ps=1.01e-06 pd=8e-07 nrd=1.16667 \
        nrs=1.16667 sa=2.55e-07 sb=1.005e-06 sd=160n sca=8.70265 \
        scb=0.00681258 scc=0.000126945 m=(1)
mn3 (\3\:n4 \2\:n1 \1\:VSS VSS) g45n1svt w=(1.45e-07) l=4.5e-08 nf=1 \
        as=5.22e-14 ad=2.32e-14 ps=1.01e-06 pd=6.1e-07 nrd=1.16667 \
        nrs=1.16667 sa=6.6e-07 sb=6e-07 sd=160n sca=8.70265 scb=0.00681258 \
        scc=0.000126945 m=(1)
mn5 (\1\:Y \3\:B1 \3\:n4 VSS) g45n1svt w=(1.45e-07) l=4.5e-08 nf=1 \
        as=2.32e-14 ad=3.045e-14 ps=6.1e-07 pd=7.1e-07 nrd=1.16667 \
        nrs=1.16667 sa=8.65e-07 sb=3.95e-07 sd=160n sca=8.70265 \
        scb=0.00681258 scc=0.000126945 m=(1)
mn4 (\1\:Y \1\:B0 n4 VSS) g45n1svt w=(1.45e-07) l=4.5e-08 nf=1 \
        as=2.03e-14 ad=3.045e-14 ps=5.7e-07 pd=7.1e-07 nrd=1.16667 \
        nrs=1.16667 sa=1.12e-06 sb=1.4e-07 sd=160n sca=8.70265 \
        scb=0.00681258 scc=0.000126945 m=(1)
ends OAI2BB2XL
// End of subcircuit definition.
