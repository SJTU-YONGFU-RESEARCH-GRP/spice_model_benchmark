// Generated for: spectre (May  1 11:31:11 2013 )
// Library name: gsclib045_backbias
// Cell name: OA21X4
// View name: extracted

simulator lang=spectre

subckt OA21X4 A0 A1 B0 NW VDD VSS Y
mp0 (net98 \1\:A0 \10\:VDD NW) g45p1svt w=(3.9e-07) l=4.5e-08 nf=1 \
        as=5.46e-14 ad=2.34e-14 ps=1.06e-06 pd=9e-07 nrd=1.16667 \
        nrs=1.16667 sa=1.4e-07 sb=1.47e-06 sd=160n sca=21.318 \
        scb=0.0198005 scc=0.0015222 m=(1)
mp1 (\18\:net95 \1\:A1 net98 NW) g45p1svt w=(3.9e-07) l=4.5e-08 nf=1 \
        as=2.34e-14 ad=6.24e-14 ps=9e-07 pd=1.1e-06 nrd=1.16667 \
        nrs=1.16667 sa=2.45e-07 sb=1.365e-06 sd=160n sca=19.8317 \
        scb=0.0173912 scc=0.00148974 m=(1)
mp2 (\18\:net95 \1\:B0 \1\:VDD NW) g45p1svt w=(3.9e-07) l=4.5e-08 nf=1 \
        as=1.404e-13 ad=6.24e-14 ps=1.5e-06 pd=1.1e-06 nrd=1.16667 \
        nrs=1.16667 sa=4.5e-07 sb=1.16e-06 sd=160n sca=18.4632 \
        scb=0.0159033 scc=0.00148415 m=(1)
mp3 (\1\:Y net95 \1\:VDD NW) g45p1svt w=(3.9e-07) l=4.5e-08 nf=1 \
        as=7.995e-14 ad=6.24e-14 ps=1.19e-06 pd=1.1e-06 nrd=1.16667 \
        nrs=1.16667 sa=8.55e-07 sb=7.55e-07 sd=160n sca=17.7856 \
        scb=0.015626 scc=0.00148402 m=(4)
C1 (B0 VSS) capacitor c=7.49505e-17
C2 (VDD VSS) capacitor c=3.36587e-17
C3 (NW VSS) capacitor c=2.96282e-16
C4 (A1 VSS) capacitor c=3.28181e-17
C5 (A0 VSS) capacitor c=3.61158e-17
C6 (Y VSS) capacitor c=5.42048e-17
C7 (net107 VSS) capacitor c=6.28202e-17
C8 (net95 VSS) capacitor c=3.06689e-16
C9 (\1\:B0 VSS) capacitor c=4.55998e-17
C10 (\1\:A1 VSS) capacitor c=9.12662e-17
C11 (\1\:A0 VSS) capacitor c=7.84394e-17
C12 (\3\:B0 VSS) capacitor c=3.85282e-17
C13 (\3\:A1 VSS) capacitor c=4.4238e-17
C14 (\4\:A0 VSS) capacitor c=3.81571e-17
C15 (\2\:B0 VSS) capacitor c=3.67198e-17
C16 (\2\:A1 VSS) capacitor c=5.81938e-17
C17 (\3\:A0 VSS) capacitor c=1.7297e-17
C18 (\1\:VDD VSS) capacitor c=3.40259e-16
C19 (\1\:Y VSS) capacitor c=2.05813e-16
C20 (\18\:net95 VSS) capacitor c=8.99662e-17
C21 (\10\:VDD VSS) capacitor c=2.54155e-17
C22 (\4\:Y VSS) capacitor c=1.02728e-16
C23 (\20\:net95 VSS) capacitor c=5.81587e-17
C24 (\3\:net107 VSS) capacitor c=4.66882e-17
C25 (\2\:A0 VSS) capacitor c=5.04731e-17
C26 (\5\:A0 VSS) capacitor c=1.6271e-17
C27 (\4\:A1 VSS) capacitor c=7.05169e-17
C28 (\4\:B0 VSS) capacitor c=3.16787e-17
C29 (\17\:net95 VSS) capacitor c=9.83827e-17
C30 (\5\:VDD VSS) capacitor c=3.39915e-17
Rk4 (\4\:B0 B0) resistor r=0.164 c=0
Rk24 (\5\:VDD VDD) resistor r=0.1047 c=0
Rk23 (\1\:VDD \5\:VDD) resistor r=0.2576 c=0
Rk27 (\5\:VDD \11\:VDD) resistor r=0.2588 c=0
Rk2 (A1 \4\:A1) resistor r=0.06334 c=0
Rk18 (\8\:VSS VSS) resistor r=0.1573 c=0
Rk17 (\1\:VSS \8\:VSS) resistor r=0.3433 c=0
Rk20 (\8\:VSS \12\:VSS) resistor r=0.1726 c=0
Rk1 (A0 \5\:A0) resistor r=0.0987 c=0
Rk10 (\1\:Y Y) resistor r=0.1568 c=0
Rk11 (Y \4\:Y) resistor r=0.1759 c=0
Rk3 (\2\:net107 \4\:net107) resistor r=0.2381 c=0
Rk6 (net95 \17\:net95) resistor r=0.1939 c=0
Rk7 (\17\:net95 \19\:net95) resistor r=0.6004 c=0
Rk8 (\17\:net95 \21\:net95) resistor r=0.3853 c=0
Rl6 (\1\:B0 \2\:B0) resistor r=98.7687 c=0
Rl7 (\2\:B0 \3\:B0) resistor r=56.461 c=0
Rl4 (\1\:A1 \2\:A1) resistor r=102.615 c=0
Rl5 (\2\:A1 \3\:A1) resistor r=52.6149 c=0
Rl1 (\1\:A0 \2\:A0) resistor r=101.317 c=0
Rl3 (\2\:A0 \4\:A0) resistor r=60.1705 c=0
Rl2 (\2\:A0 \3\:A0) resistor r=22.7732 c=0
Rz9 (\12\:VSS \11\:VSS) resistor r=75 c=0
Rz1 (net107 \2\:net107) resistor r=75 c=0
Rz2 (\3\:net107 \4\:net107) resistor r=75 c=0
Rz3 (\21\:net95 \20\:net95) resistor r=75 c=0
Ry8 (\11\:VDD \10\:VDD) resistor r=62 c=0
Ry1 (\19\:net95 \18\:net95) resistor r=31 c=0
Rx3 (\2\:B0 \4\:B0) resistor r=45 c=0
Rx2 (\2\:A1 \4\:A1) resistor r=45 c=0
Rx1 (\3\:A0 \5\:A0) resistor r=45 c=0
mn0 (\3\:net107 \4\:A0 \11\:VSS VSS) g45n1svt w=(2.6e-07) l=4.5e-08 nf=1 \
        as=4.16e-14 ad=3.64e-14 ps=8.4e-07 pd=8e-07 nrd=1.16667 \
        nrs=1.16667 sa=1.4e-07 sb=5.28462e-07 sd=160n sca=7.84363 \
        scb=0.00546499 scc=9.84911e-05 m=(1)
mn1 (net107 \3\:A1 \11\:VSS VSS) g45n1svt w=(2.6e-07) l=4.5e-08 nf=1 \
        as=4.16e-14 ad=4.16e-14 ps=8.4e-07 pd=8.4e-07 nrd=1.16667 \
        nrs=1.16667 sa=3.45e-07 sb=3.23462e-07 sd=160n sca=7.84363 \
        scb=0.00546499 scc=9.84911e-05 m=(1)
mn2 (\20\:net95 \3\:B0 net107 VSS) g45n1svt w=(2.6e-07) l=4.5e-08 nf=1 \
        as=4.16e-14 ad=3.08e-14 ps=8.4e-07 pd=8e-07 nrd=1.16667 \
        nrs=1.16667 sa=5.5e-07 sb=1.18462e-07 sd=160n sca=7.84363 \
        scb=0.00546499 scc=9.84911e-05 m=(1)
mn3 (\4\:Y net95 \1\:VSS VSS) g45n1svt w=(2.6e-07) l=4.5e-08 nf=1 \
        as=4.25e-14 ad=4.16e-14 ps=9.95e-07 pd=8.4e-07 nrd=1.16667 \
        nrs=1.16667 sa=1e-07 sb=7.55e-07 sd=160n sca=17.5885 scb=0.0172826 \
        scc=0.00162584 m=(4)
ends OA21X4
// End of subcircuit definition.
