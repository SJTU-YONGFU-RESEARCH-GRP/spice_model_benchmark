// Generated for: spectre (May  1 11:31:50 2013 )
// Library name: gsclib045_backbias
// Cell name: OAI33XL
// View name: extracted

simulator lang=spectre

subckt OAI33XL A0 A1 A2 B0 B1 B2 NW VDD VSS Y
mp0 (n1 \1\:A0 \4\:VDD NW) g45p1svt w=(2.15e-07) l=4.5e-08 nf=1 \
        as=3.01e-14 ad=1.29e-14 ps=7.1e-07 pd=5.5e-07 nrd=1.16667 \
        nrs=1.16667 sa=1.4e-07 sb=1.205e-06 sd=160n sca=14.5245 \
        scb=0.0130308 scc=0.000155148 m=(1)
mp1 (n2 \1\:A1 n1 NW) g45p1svt w=(2.15e-07) l=4.5e-08 nf=1 as=1.29e-14 \
        ad=4.085e-14 ps=5.5e-07 pd=8.1e-07 nrd=1.16667 nrs=1.16667 \
        sa=2.45e-07 sb=1.1e-06 sd=160n sca=12.6898 scb=0.00990074 \
        scc=9.48225e-05 m=(1)
mp2 (\4\:Y \1\:A2 n2 NW) g45p1svt w=(2.15e-07) l=4.5e-08 nf=1 \
        as=4.085e-14 ad=7.203e-14 ps=8.1e-07 pd=1.1e-06 nrd=1.16667 \
        nrs=1.16667 sa=4.8e-07 sb=8.65e-07 sd=160n sca=10.9418 \
        scb=0.00782693 scc=8.41447e-05 m=(1)
mp5 (\4\:Y \1\:B2 n4 NW) g45p1svt w=(2.15e-07) l=4.5e-08 nf=1 \
        as=3.763e-14 ad=7.203e-14 ps=7.8e-07 pd=1.1e-06 nrd=1.16667 \
        nrs=1.16667 sa=8.6e-07 sb=4.85e-07 sd=160n sca=11.0076 \
        scb=0.00787274 scc=8.41904e-05 m=(1)
mp3 (n3 \1\:B1 n4 NW) g45p1svt w=(2.15e-07) l=4.5e-08 nf=1 as=3.762e-14 \
        ad=1.72e-14 ps=7.8e-07 pd=5.9e-07 nrd=1.16667 nrs=1.16667 \
        sa=1.08e-06 sb=2.65e-07 sd=160n sca=12.6898 scb=0.00990074 \
        scc=9.48225e-05 m=(1)
mp4 (\1\:VDD \3\:B0 n3 NW) g45p1svt w=(2.15e-07) l=4.5e-08 nf=1 \
        as=1.72e-14 ad=3.01e-14 ps=5.9e-07 pd=7.1e-07 nrd=1.16667 \
        nrs=1.16667 sa=1.205e-06 sb=1.4e-07 sd=160n sca=15.0399 \
        scb=0.0139456 scc=0.00018525 m=(1)
C1 (NW VSS) capacitor c=3.18309e-16
C2 (A1 VSS) capacitor c=7.66163e-17
C3 (A0 VSS) capacitor c=2.57534e-17
C4 (Y VSS) capacitor c=1.02532e-16
C5 (B2 VSS) capacitor c=4.27248e-17
C6 (VDD VSS) capacitor c=3.02607e-17
C7 (no VSS) capacitor c=6.43621e-17
C8 (n2 VSS) capacitor c=6.10291e-18
C9 (n4 VSS) capacitor c=2.97781e-19
C10 (\3\:B0 VSS) capacitor c=7.461e-17
C11 (\1\:B1 VSS) capacitor c=6.95324e-17
C12 (\1\:B2 VSS) capacitor c=3.47479e-17
C13 (\1\:A2 VSS) capacitor c=3.94708e-17
C14 (\1\:A1 VSS) capacitor c=7.73384e-17
C15 (\1\:A0 VSS) capacitor c=9.00932e-17
C16 (\1\:B0 VSS) capacitor c=3.66777e-17
C17 (\3\:B1 VSS) capacitor c=5.47641e-17
C18 (\3\:B2 VSS) capacitor c=5.84461e-17
C19 (\3\:A2 VSS) capacitor c=4.58401e-17
C20 (\3\:A1 VSS) capacitor c=5.09082e-17
C21 (\3\:A0 VSS) capacitor c=4.00249e-17
C22 (\2\:B0 VSS) capacitor c=7.19184e-17
C23 (\2\:B1 VSS) capacitor c=8.17109e-17
C24 (\2\:B2 VSS) capacitor c=5.66699e-17
C25 (\2\:A2 VSS) capacitor c=6.12637e-17
C26 (\2\:A1 VSS) capacitor c=8.95814e-17
C27 (\2\:A0 VSS) capacitor c=7.41564e-17
C28 (\1\:VDD VSS) capacitor c=1.28624e-16
C29 (\4\:Y VSS) capacitor c=8.31196e-17
C30 (\4\:VDD VSS) capacitor c=1.86611e-17
C31 (\6\:Y VSS) capacitor c=3.02292e-17
C32 (\5\:no VSS) capacitor c=1.12001e-16
C33 (\1\:Y VSS) capacitor c=7.20292e-17
C34 (\3\:no VSS) capacitor c=1.0318e-16
C35 (\4\:A0 VSS) capacitor c=4.32932e-17
C36 (\4\:A1 VSS) capacitor c=2.54496e-17
C37 (\4\:A2 VSS) capacitor c=1.16934e-16
C38 (\4\:B2 VSS) capacitor c=6.0212e-17
C39 (\4\:B1 VSS) capacitor c=1.11211e-16
C40 (\4\:B0 VSS) capacitor c=1.22268e-16
C41 (\3\:Y VSS) capacitor c=7.05625e-17
C42 (\3\:VDD VSS) capacitor c=8.80514e-17
Rk4 (\4\:A1 A1) resistor r=0.02997 c=0
Rk7 (\4\:B1 B1) resistor r=0.002997 c=0
Rk1 (\4\:A0 A0) resistor r=0.08702 c=0
Rk12 (\3\:Y Y) resistor r=0.439 c=0
Rk11 (\2\:Y \3\:Y) resistor r=0.3711 c=0
Rk13 (Y \5\:Y) resistor r=0.6486 c=0
Rk14 (\3\:Y \7\:Y) resistor r=0.05799 c=0
Rk6 (\4\:B2 B2) resistor r=0.2018 c=0
Rk10 (\4\:B0 B0) resistor r=0.008207 c=0
Rk20 (\4\:VSS VSS) resistor r=0.03715 c=0
Rk19 (\3\:VSS \4\:VSS) resistor r=0.2051 c=0
Rk21 (\3\:VSS \6\:VSS) resistor r=0.1843 c=0
Rk22 (\4\:VSS \8\:VSS) resistor r=0.1793 c=0
Rk16 (\3\:VDD VDD) resistor r=0.08728 c=0
Rk15 (\2\:VDD \3\:VDD) resistor r=0.8204 c=0
Rk17 (\3\:VDD \5\:VDD) resistor r=0.1834 c=0
Rk5 (\4\:A2 A2) resistor r=0.002997 c=0
Rk8 (\2\:no \4\:no) resistor r=0.5366 c=0
Rk9 (\4\:no \6\:no) resistor r=0.5703 c=0
Rl3 (\1\:A1 \2\:A1) resistor r=158.384 c=0
Rl4 (\2\:A1 \3\:A1) resistor r=150.692 c=0
Rl9 (\1\:B1 \2\:B1) resistor r=141.076 c=0
Rl10 (\2\:B1 \3\:B1) resistor r=168 c=0
Rl1 (\1\:A0 \2\:A0) resistor r=219.208 c=0
Rl2 (\2\:A0 \3\:A0) resistor r=109.41 c=0
Rl7 (\1\:B2 \2\:B2) resistor r=69.9225 c=0
Rl8 (\2\:B2 \3\:B2) resistor r=239.153 c=0
Rl12 (\2\:B0 \3\:B0) resistor r=215.18 c=0
Rl11 (\1\:B0 \2\:B0) resistor r=96.2379 c=0
Rl5 (\1\:A2 \2\:A2) resistor r=141.076 c=0
Rl6 (\2\:A2 \3\:A2) resistor r=168 c=0
Rz4 (\1\:Y \2\:Y) resistor r=75 c=0
Rz5 (\6\:Y \7\:Y) resistor r=75 c=0
Rz6 (\5\:VSS \6\:VSS) resistor r=75 c=0
Rz7 (\7\:VSS \8\:VSS) resistor r=75 c=0
Rz1 (no \2\:no) resistor r=75 c=0
Rz2 (\3\:no \4\:no) resistor r=75 c=0
Rz3 (\5\:no \6\:no) resistor r=75 c=0
Ry1 (\4\:Y \5\:Y) resistor r=62 c=0
Ry2 (\1\:VDD \2\:VDD) resistor r=62 c=0
Ry3 (\4\:VDD \5\:VDD) resistor r=62 c=0
Rx2 (\2\:A1 \4\:A1) resistor r=45 c=0
Rx5 (\2\:B1 \4\:B1) resistor r=45 c=0
Rx1 (\2\:A0 \4\:A0) resistor r=45 c=0
Rx4 (\2\:B2 \4\:B2) resistor r=45 c=0
Rx6 (\2\:B0 \4\:B0) resistor r=45 c=0
Rx3 (\2\:A2 \4\:A2) resistor r=45 c=0
mn0 (no \3\:A0 \7\:VSS VSS) g45n1svt w=(1.45e-07) l=4.5e-08 nf=1 \
        as=2.03e-14 ad=2.32e-14 ps=5.7e-07 pd=6.1e-07 nrd=1.16667 \
        nrs=1.16667 sa=1.4e-07 sb=1.385e-06 sd=160n sca=6.67224 \
        scb=0.00331168 scc=2.36561e-05 m=(1)
mn1 (no \3\:A1 \5\:VSS VSS) g45n1svt w=(1.45e-07) l=4.5e-08 nf=1 \
        as=2.755e-14 ad=2.32e-14 ps=6.7e-07 pd=6.1e-07 nrd=1.16667 \
        nrs=1.16667 sa=3.45e-07 sb=1.18e-06 sd=160n sca=6.67224 \
        scb=0.00331168 scc=2.36561e-05 m=(1)
mn2 (\3\:no \3\:A2 \5\:VSS VSS) g45n1svt w=(1.45e-07) l=4.5e-08 nf=1 \
        as=2.755e-14 ad=4.857e-14 ps=6.7e-07 pd=9.6e-07 nrd=1.16667 \
        nrs=1.16667 sa=5.8e-07 sb=9.45e-07 sd=160n sca=6.67224 \
        scb=0.00331168 scc=2.36561e-05 m=(1)
mn5 (\1\:Y \3\:B2 \3\:no VSS) g45n1svt w=(1.45e-07) l=4.5e-08 nf=1 \
        as=4.857e-14 ad=2.537e-14 ps=9.6e-07 pd=6.4e-07 nrd=1.16667 \
        nrs=1.16667 sa=9.6e-07 sb=5.65e-07 sd=160n sca=6.67224 \
        scb=0.00331168 scc=2.36561e-05 m=(1)
mn3 (\1\:Y \3\:B1 \5\:no VSS) g45n1svt w=(1.45e-07) l=4.5e-08 nf=1 \
        as=2.32e-14 ad=2.537e-14 ps=6.1e-07 pd=6.4e-07 nrd=1.16667 \
        nrs=1.16667 sa=1.18e-06 sb=3.45e-07 sd=160n sca=6.67224 \
        scb=0.00331168 scc=2.36561e-05 m=(1)
mn4 (\6\:Y \1\:B0 \5\:no VSS) g45n1svt w=(1.45e-07) l=4.5e-08 nf=1 \
        as=2.32e-14 ad=2.03e-14 ps=6.1e-07 pd=5.7e-07 nrd=1.16667 \
        nrs=1.16667 sa=1.385e-06 sb=1.4e-07 sd=160n sca=6.67224 \
        scb=0.00331168 scc=2.36561e-05 m=(1)
ends OAI33XL
// End of subcircuit definition.
