// Generated for: spectre (May  1 11:30:48 2013 )
// Library name: gsclib045_backbias
// Cell name: NOR2XL
// View name: extracted

simulator lang=spectre

subckt NOR2XL A B NW VDD VSS Y
mp0 (net41 \1\:A \1\:VDD NW) g45p1svt w=(2.15e-07) l=4.5e-08 nf=1 \
        as=3.01e-14 ad=1.29e-14 ps=7.1e-07 pd=5.5e-07 nrd=1.16667 \
        nrs=1.16667 sa=1.4e-07 sb=2.45e-07 sd=160n sca=29.8819 \
        scb=0.0359119 scc=0.00165852 m=(1)
mp1 (\1\:Y \3\:B net41 NW) g45p1svt w=(2.15e-07) l=4.5e-08 nf=1 \
        as=1.29e-14 ad=3.01e-14 ps=5.5e-07 pd=7.1e-07 nrd=1.16667 \
        nrs=1.16667 sa=2.45e-07 sb=1.4e-07 sd=160n sca=30.7015 \
        scb=0.0368156 scc=0.00184473 m=(1)
C1 (A VSS) capacitor c=6.27631e-17
C2 (NW VSS) capacitor c=1.38201e-16
C3 (VDD VSS) capacitor c=9.23591e-17
C4 (B VSS) capacitor c=1.37603e-17
C5 (\3\:B VSS) capacitor c=5.582e-17
C6 (\1\:A VSS) capacitor c=7.21071e-17
C7 (\1\:B VSS) capacitor c=2.54707e-17
C8 (\4\:A VSS) capacitor c=2.37275e-17
C9 (\2\:B VSS) capacitor c=3.49375e-17
C10 (\3\:A VSS) capacitor c=1.17125e-17
C11 (\1\:Y VSS) capacitor c=5.96858e-17
C12 (\1\:VDD VSS) capacitor c=3.3245e-17
C13 (\3\:Y VSS) capacitor c=7.95481e-17
C14 (\2\:A VSS) capacitor c=2.44568e-17
C15 (\4\:B VSS) capacitor c=6.78888e-17
Rk1 (\5\:A A) resistor r=0.01612 c=0
Rk3 (Y \2\:Y) resistor r=0.003074 c=0
Rk4 (\2\:Y \4\:Y) resistor r=0.4895 c=0
Rk5 (\2\:VSS \4\:VSS) resistor r=0.2445 c=0
Rk7 (\5\:VSS VSS) resistor r=0.01703 c=0
Rk6 (\4\:VSS \5\:VSS) resistor r=0.08218 c=0
Rk8 (\5\:VSS \7\:VSS) resistor r=0.1617 c=0
Rk9 (\2\:VDD VDD) resistor r=0.3582 c=0
Rk2 (\4\:B B) resistor r=0.07915 c=0
Rl1 (\1\:A \2\:A) resistor r=106.972 c=0
Rl3 (\2\:A \4\:A) resistor r=34.3295 c=0
Rl2 (\2\:A \3\:A) resistor r=1.2666 c=0
Rl5 (\2\:B \3\:B) resistor r=72.8068 c=0
Rl4 (\1\:B \2\:B) resistor r=41.6242 c=0
Rz1 (\3\:Y \4\:Y) resistor r=75 c=0
Rz2 (\1\:VSS \2\:VSS) resistor r=75 c=0
Rz3 (\6\:VSS \7\:VSS) resistor r=75 c=0
Ry1 (\1\:Y \2\:Y) resistor r=62 c=0
Ry3 (\1\:VDD \2\:VDD) resistor r=62 c=0
Rx1 (\3\:A \5\:A) resistor r=45 c=0
Rx2 (\2\:B \4\:B) resistor r=45 c=0
mn0 (\3\:Y \4\:A \6\:VSS VSS) g45n1svt w=(1.45e-07) l=4.5e-08 nf=1 \
        as=5.36e-14 ad=2.32e-14 ps=1.48e-06 pd=6.1e-07 nrd=1.16667 \
        nrs=1.16667 sa=1e-07 sb=3.05e-07 sd=160n sca=21.4614 scb=0.0218523 \
        scc=0.00230065 m=(1)
mn1 (\3\:Y \1\:B \1\:VSS VSS) g45n1svt w=(1.45e-07) l=4.5e-08 nf=1 \
        as=5.36e-14 ad=2.32e-14 ps=1.48e-06 pd=6.1e-07 nrd=1.16667 \
        nrs=1.16667 sa=3.05e-07 sb=1e-07 sd=160n sca=21.4614 scb=0.0218523 \
        scc=0.00230065 m=(1)
ends NOR2XL
// End of subcircuit definition.
