// Generated for: spectre (May  1 11:30:59 2013 )
// Library name: gsclib045_backbias
// Cell name: NOR4BBXL
// View name: extracted

simulator lang=spectre

subckt NOR4BBXL AN BN C D NW VDD VSS Y
mp1 (\9\:n1 \1\:BN \4\:VDD NW) g45p1svt w=(2.15e-07) l=4.5e-08 nf=1 \
        as=3.01e-14 ad=3.01e-14 ps=7.1e-07 pd=7.1e-07 nrd=1.16667 \
        nrs=1.16667 sa=1.4e-07 sb=1.4e-07 sd=160n sca=49.4198 \
        scb=0.0326741 scc=0.00592591 m=(1)
mp5 (\4\:Y \1\:D n4 NW) g45p1svt w=(2.15e-07) l=4.5e-08 nf=1 as=1.29e-14 \
        ad=3.01e-14 ps=5.5e-07 pd=7.1e-07 nrd=1.16667 nrs=1.16667 \
        sa=1.4e-07 sb=8.6e-07 sd=160n sca=10.2576 scb=0.00735405 \
        scc=7.25622e-05 m=(1)
mp4 (n4 \1\:C n3 NW) g45p1svt w=(2.15e-07) l=4.5e-08 nf=1 as=2.472e-14 \
        ad=1.29e-14 ps=6.6e-07 pd=5.5e-07 nrd=1.16667 nrs=1.16667 \
        sa=2.45e-07 sb=7.55e-07 sd=160n sca=10.1345 scb=0.00732736 \
        scc=7.25592e-05 m=(1)
mp3 (n3 n1 n2 NW) g45p1svt w=(2.15e-07) l=4.5e-08 nf=1 as=4.408e-14 \
        ad=2.473e-14 ps=8.4e-07 pd=6.6e-07 nrd=1.16667 nrs=1.16667 \
        sa=4.05e-07 sb=5.95e-07 sd=160n sca=10.4338 scb=0.00740954 \
        scc=7.25741e-05 m=(1)
mp2 (n2 \4\:n0 \1\:VDD NW) g45p1svt w=(2.15e-07) l=4.5e-08 nf=1 \
        as=3.44e-14 ad=4.408e-14 ps=7.5e-07 pd=8.4e-07 nrd=1.16667 \
        nrs=1.16667 sa=6.55e-07 sb=3.45e-07 sd=160n sca=11.603 \
        scb=0.00833729 scc=7.42936e-05 m=(1)
mp0 (\5\:n0 \1\:AN \1\:VDD NW) g45p1svt w=(2.15e-07) l=4.5e-08 nf=1 \
        as=3.44e-14 ad=3.01e-14 ps=7.5e-07 pd=7.1e-07 nrd=1.16667 \
        nrs=1.16667 sa=8.6e-07 sb=1.4e-07 sd=160n sca=14.4159 \
        scb=0.0128226 scc=0.000143703 m=(1)
C1 (AN VSS) capacitor c=4.70827e-17
C2 (NW VSS) capacitor c=3.3911e-16
C3 (Y VSS) capacitor c=9.38392e-17
C4 (C VSS) capacitor c=3.71993e-17
C5 (D VSS) capacitor c=6.73577e-17
C6 (VDD VSS) capacitor c=3.20845e-17
C7 (n1 VSS) capacitor c=7.80214e-17
C8 (n0 VSS) capacitor c=2.25807e-17
C9 (n4 VSS) capacitor c=1.5042e-18
C10 (n3 VSS) capacitor c=2.64379e-18
C11 (n2 VSS) capacitor c=5.28568e-18
C12 (\1\:AN VSS) capacitor c=3.25888e-17
C13 (\4\:n0 VSS) capacitor c=7.48545e-17
C14 (\1\:C VSS) capacitor c=6.53781e-17
C15 (\1\:D VSS) capacitor c=7.21675e-17
C16 (\1\:BN VSS) capacitor c=2.81338e-17
C17 (\3\:AN VSS) capacitor c=7.50831e-17
C18 (\3\:n0 VSS) capacitor c=3.05112e-17
C19 (\4\:n1 VSS) capacitor c=3.9988e-17
C20 (\3\:C VSS) capacitor c=7.92613e-17
C21 (\3\:D VSS) capacitor c=5.85066e-17
C22 (\3\:BN VSS) capacitor c=2.41369e-17
C23 (\2\:AN VSS) capacitor c=5.56846e-17
C24 (\3\:n1 VSS) capacitor c=2.78987e-17
C25 (\2\:C VSS) capacitor c=8.73646e-17
C26 (\2\:D VSS) capacitor c=5.59654e-17
C27 (\2\:BN VSS) capacitor c=2.33826e-17
C28 (\5\:n0 VSS) capacitor c=7.47057e-17
C29 (\1\:VDD VSS) capacitor c=1.55122e-16
C30 (\4\:Y VSS) capacitor c=7.79213e-17
C31 (\9\:n1 VSS) capacitor c=6.69379e-17
C32 (\4\:VDD VSS) capacitor c=5.34957e-17
C33 (\9\:n0 VSS) capacitor c=2.46753e-17
C34 (\1\:Y VSS) capacitor c=3.20497e-17
C35 (\6\:Y VSS) capacitor c=6.6607e-17
C36 (\7\:n1 VSS) capacitor c=1.44878e-17
C37 (\2\:n1 VSS) capacitor c=5.32926e-17
C38 (\2\:n0 VSS) capacitor c=5.26101e-17
C39 (\4\:BN VSS) capacitor c=3.23423e-17
C40 (\6\:BN VSS) capacitor c=5.6589e-17
C41 (\4\:D VSS) capacitor c=4.1533e-17
C42 (\4\:C VSS) capacitor c=6.47517e-17
C43 (\5\:n1 VSS) capacitor c=8.03686e-17
C44 (\6\:n1 VSS) capacitor c=6.80573e-17
C45 (\3\:Y VSS) capacitor c=6.48446e-17
C46 (\4\:AN VSS) capacitor c=5.34595e-17
C47 (\7\:n0 VSS) capacitor c=7.22209e-17
C48 (\8\:n0 VSS) capacitor c=3.92852e-17
C49 (\3\:VDD VSS) capacitor c=1.06132e-16
Rk1 (\4\:BN BN) resistor r=0.009523 c=0
Rk3 (\4\:BN \6\:BN) resistor r=0.08106 c=0
Rk2 (\5\:BN \6\:BN) resistor r=0.009523 c=0
Rk13 (\4\:AN AN) resistor r=0.1852 c=0
Rk10 (\3\:Y Y) resistor r=0.2585 c=0
Rk9 (\2\:Y \3\:Y) resistor r=0.1247 c=0
Rk11 (Y \5\:Y) resistor r=0.6791 c=0
Rk12 (\3\:Y \7\:Y) resistor r=0.4067 c=0
Rk20 (\2\:VSS \3\:VSS) resistor r=0.4082 c=0
Rk21 (\3\:VSS \5\:VSS) resistor r=0.03239 c=0
Rk22 (\5\:VSS \6\:VSS) resistor r=0.1878 c=0
Rk24 (\7\:VSS VSS) resistor r=0.08478 c=0
Rk23 (\6\:VSS \7\:VSS) resistor r=0.1776 c=0
Rk25 (\3\:VSS \9\:VSS) resistor r=0.1787 c=0
Rk26 (\6\:VSS \11\:VSS) resistor r=0.07358 c=0
Rk27 (\7\:VSS \13\:VSS) resistor r=0.07358 c=0
Rk5 (\4\:C C) resistor r=0.05486 c=0
Rk4 (\4\:D D) resistor r=0.02433 c=0
Rk18 (\3\:VDD VDD) resistor r=0.1023 c=0
Rk17 (\2\:VDD \3\:VDD) resistor r=0.8115 c=0
Rk19 (\3\:VDD \5\:VDD) resistor r=0.4207 c=0
Rk6 (\5\:n1 \6\:n1) resistor r=0.397 c=0
Rk7 (\6\:n1 \8\:n1) resistor r=0.1263 c=0
Rk8 (\6\:n1 \10\:n1) resistor r=0.316 c=0
Rk14 (\6\:n0 \7\:n0) resistor r=0.6684 c=0
Rk15 (\7\:n0 \8\:n0) resistor r=0.2776 c=0
Rk16 (\7\:n0 \10\:n0) resistor r=0.2342 c=0
Rl1 (\1\:BN \2\:BN) resistor r=48.0769 c=0
Rl2 (\2\:BN \3\:BN) resistor r=39.8352 c=0
Rl13 (\1\:AN \2\:AN) resistor r=33.3841 c=0
Rl14 (\2\:AN \3\:AN) resistor r=268 c=0
Rl5 (\1\:C \2\:C) resistor r=45.9489 c=0
Rl6 (\2\:C \3\:C) resistor r=253.823 c=0
Rl3 (\1\:D \2\:D) resistor r=80.7464 c=0
Rl4 (\2\:D \3\:D) resistor r=257.487 c=0
Rl7 (n1 \2\:n1) resistor r=220.033 c=0
Rl9 (\2\:n1 \4\:n1) resistor r=96.9565 c=0
Rl8 (\2\:n1 \3\:n1) resistor r=2.4801 c=0
Rl12 (\2\:n0 \4\:n0) resistor r=272.791 c=0
Rl11 (\2\:n0 \3\:n0) resistor r=45.868 c=0
Rl10 (n0 \2\:n0) resistor r=2.0213 c=0
Rz2 (\1\:Y \2\:Y) resistor r=75 c=0
Rz3 (\6\:Y \7\:Y) resistor r=75 c=0
Rz5 (\1\:VSS \2\:VSS) resistor r=75 c=0
Rz6 (\8\:VSS \9\:VSS) resistor r=75 c=0
Rz7 (\10\:VSS \11\:VSS) resistor r=75 c=0
Rz8 (\12\:VSS \13\:VSS) resistor r=75 c=0
Rz1 (\7\:n1 \8\:n1) resistor r=75 c=0
Rz4 (\9\:n0 \10\:n0) resistor r=75 c=0
Ry2 (\4\:Y \5\:Y) resistor r=62 c=0
Ry4 (\1\:VDD \2\:VDD) resistor r=62 c=0
Ry5 (\4\:VDD \5\:VDD) resistor r=62 c=0
Ry1 (\9\:n1 \10\:n1) resistor r=62 c=0
Ry3 (\5\:n0 \6\:n0) resistor r=62 c=0
Rx1 (\2\:BN \5\:BN) resistor r=45 c=0
Rx5 (\2\:AN \4\:AN) resistor r=45 c=0
Rx3 (\2\:C \4\:C) resistor r=45 c=0
Rx2 (\2\:D \4\:D) resistor r=45 c=0
Rx4 (\3\:n1 \5\:n1) resistor r=45 c=0
Rx6 (n0 \8\:n0) resistor r=45 c=0
mn1 (\7\:n1 \3\:BN \12\:VSS VSS) g45n1svt w=(1.45e-07) l=4.5e-08 nf=1 \
        as=4.215e-14 ad=2.03e-14 ps=1.4e-06 pd=5.7e-07 nrd=1.16667 \
        nrs=1.16667 sa=1e-07 sb=1.4e-07 sd=160n sca=16.2011 scb=0.0172667 \
        scc=0.0012292 m=(1)
mn5 (\6\:Y \3\:D \10\:VSS VSS) g45n1svt w=(1.45e-07) l=4.5e-08 nf=1 \
        as=3.04e-14 ad=2.32e-14 ps=9.3e-07 pd=6.1e-07 nrd=1.16667 \
        nrs=1.16667 sa=1e-07 sb=1.005e-06 sd=160n sca=6.59604 \
        scb=0.00318587 scc=2.16275e-05 m=(1)
mn4 (\6\:Y \3\:C \8\:VSS VSS) g45n1svt w=(1.45e-07) l=4.5e-08 nf=1 \
        as=2.32e-14 ad=2.32e-14 ps=6.1e-07 pd=6.1e-07 nrd=1.16667 \
        nrs=1.16667 sa=3.05e-07 sb=8e-07 sd=160n sca=6.59604 \
        scb=0.00318587 scc=2.16275e-05 m=(1)
mn3 (\1\:Y \4\:n1 \8\:VSS VSS) g45n1svt w=(1.45e-07) l=4.5e-08 nf=1 \
        as=2.32e-14 ad=2.973e-14 ps=6.1e-07 pd=7e-07 nrd=1.16667 \
        nrs=1.16667 sa=5.1e-07 sb=5.95e-07 sd=160n sca=6.59604 \
        scb=0.00318587 scc=2.16275e-05 m=(1)
mn2 (\1\:Y \3\:n0 \1\:VSS VSS) g45n1svt w=(1.45e-07) l=4.5e-08 nf=1 \
        as=2.32e-14 ad=2.973e-14 ps=6.1e-07 pd=7e-07 nrd=1.16667 \
        nrs=1.16667 sa=7.6e-07 sb=3.45e-07 sd=160n sca=6.59604 \
        scb=0.00318587 scc=2.16275e-05 m=(1)
mn0 (\9\:n0 \3\:AN \1\:VSS VSS) g45n1svt w=(1.45e-07) l=4.5e-08 nf=1 \
        as=2.32e-14 ad=2.03e-14 ps=6.1e-07 pd=5.7e-07 nrd=1.16667 \
        nrs=1.16667 sa=9.65e-07 sb=1.4e-07 sd=160n sca=6.59604 \
        scb=0.00318587 scc=2.16275e-05 m=(1)
ends NOR4BBXL
// End of subcircuit definition.
