// Generated for: spectre (May  1 11:33:38 2013 )
// Library name: gsclib045_backbias
// Cell name: TLATSRX4
// View name: extracted

simulator lang=spectre

subckt TLATSRX4 D G NW Q QN RN SN VDD VSS
mp1 (\11\:Gb \4\:G \34\:VDD NW) g45p1svt w=(2.15e-07) l=4.5e-08 nf=1 \
        as=3.01e-14 ad=4.408e-14 ps=7.1e-07 pd=8.4e-07 nrd=1.16667 \
        nrs=1.16667 sa=1.4e-07 sb=2e-06 sd=160n sca=26.1093 scb=0.0251079 \
        scc=0.0024536 m=(1)
mp0 (\11\:Gb \1\:RN \4\:VDD NW) g45p1svt w=(2.15e-07) l=4.5e-08 nf=1 \
        as=1.0522e-13 ad=4.408e-14 ps=2.08e-06 pd=8.4e-07 nrd=1.16667 \
        nrs=1.16667 sa=3.9e-07 sb=2e-06 sd=160n sca=23.7329 scb=0.0218323 \
        scc=0.00242471 m=(1)
mp15 (\3\:net103 \6\:RN \4\:VDD NW) g45p1svt w=(2.15e-07) l=4.5e-08 nf=1 \
        as=7.327e-14 ad=3.44e-14 ps=1.82e-06 pd=7.5e-07 nrd=1.16667 \
        nrs=1.16667 sa=2e-06 sb=3.05e-07 sd=160n sca=15.2551 scb=0.0150251 \
        scc=0.000885438 m=(1)
mp16 (\3\:net103 \32\:Qint \14\:VDD NW) g45p1svt w=(2.15e-07) l=4.5e-08 \
        nf=1 as=4.915e-14 ad=3.44e-14 ps=1.54e-06 pd=7.5e-07 nrd=1.16667 \
        nrs=1.16667 sa=2e-06 sb=1e-07 sd=160n sca=15.2551 scb=0.0150251 \
        scc=0.000885438 m=(1)
mp17 (\8\:n5 Gbb net103 NW) g45p1svt w=(2.15e-07) l=4.5e-08 nf=1 \
        as=5.11e-14 ad=4.837e-14 ps=1e-06 pd=8.8e-07 nrd=1.16667 \
        nrs=1.16667 sa=2.37674e-07 sb=1.04e-06 sd=160n sca=12.3081 \
        scb=0.0110829 scc=0.000360616 m=(1)
mp6 (\8\:n5 \3\:Gb net142 NW) g45p1svt w=(2.15e-07) l=4.5e-08 nf=1 \
        as=1.72e-14 ad=4.837e-14 ps=5.9e-07 pd=8.8e-07 nrd=1.16667 \
        nrs=1.16667 sa=5.07674e-07 sb=7.7e-07 sd=160n sca=12.4312 \
        scb=0.0111096 scc=0.000360619 m=(1)
mp5 (net142 \1\:D \1\:VDD NW) g45p1svt w=(2.15e-07) l=4.5e-08 nf=1 \
        as=9.245e-14 ad=1.72e-14 ps=1.29e-06 pd=5.9e-07 nrd=1.16667 \
        nrs=1.16667 sa=6.32674e-07 sb=6.45e-07 sd=160n sca=12.7779 \
        scb=0.0112399 scc=0.000360661 m=(1)
mp2 (\4\:Gbb \5\:Gb \1\:VDD NW) g45p1svt w=(2.15e-07) l=4.5e-08 nf=1 \
        as=9.245e-14 ad=3.655e-14 ps=1.29e-06 pd=7.7e-07 nrd=1.16667 \
        nrs=1.16667 sa=1.10767e-06 sb=1.7e-07 sd=160n sca=18.9906 \
        scb=0.0207424 scc=0.000624384 m=(1)
C1 (D VSS) capacitor c=4.9169e-17
C2 (G VSS) capacitor c=5.64377e-17
C3 (QN VSS) capacitor c=2.99719e-16
C4 (NW VSS) capacitor c=9.43268e-16
C5 (RN VSS) capacitor c=6.57853e-16
C6 (Q VSS) capacitor c=2.98435e-16
C7 (VDD VSS) capacitor c=3.30463e-17
C8 (SN VSS) capacitor c=3.89521e-16
C9 (Gb VSS) capacitor c=3.96839e-17
C10 (Qbint VSS) capacitor c=2.9052e-16
C11 (Qint VSS) capacitor c=2.64401e-16
C12 (18 VSS) capacitor c=1.99305e-18
C13 (n5 VSS) capacitor c=2.51787e-17
C14 (19 VSS) capacitor c=1.00421e-18
C15 (net171 VSS) capacitor c=5.28892e-19
C16 (net191 VSS) capacitor c=1.10871e-17
C17 (Gbb VSS) capacitor c=5.22823e-17
C18 (net103 VSS) capacitor c=7.04944e-17
C19 (\5\:Gb VSS) capacitor c=1.91199e-17
C20 (\1\:D VSS) capacitor c=4.75402e-17
C21 (\3\:Gb VSS) capacitor c=5.59907e-17
C22 (\32\:Qint VSS) capacitor c=3.27203e-17
C23 (\6\:RN VSS) capacitor c=7.60366e-17
C24 (\1\:RN VSS) capacitor c=4.2367e-17
C25 (\4\:G VSS) capacitor c=3.34793e-17
C26 (\7\:Gb VSS) capacitor c=3.73296e-17
C27 (\3\:D VSS) capacitor c=3.62127e-17
C28 (\2\:Gbb VSS) capacitor c=4.06657e-17
C29 (\30\:Qint VSS) capacitor c=5.1073e-17
C30 (\5\:RN VSS) capacitor c=4.84478e-17
C31 (\6\:SN VSS) capacitor c=5.10645e-17
C32 (\5\:n5 VSS) capacitor c=3.77705e-17
C33 (\1\:SN VSS) capacitor c=5.67699e-17
C34 (\3\:RN VSS) capacitor c=3.94689e-17
C35 (\1\:G VSS) capacitor c=6.18365e-17
C36 (\6\:Gb VSS) capacitor c=3.02411e-17
C37 (\2\:D VSS) capacitor c=4.64732e-17
C38 (\4\:Gb VSS) capacitor c=5.25499e-17
C39 (\3\:Gbb VSS) capacitor c=2.26233e-17
C40 (\2\:Gb VSS) capacitor c=4.08425e-17
C41 (\31\:Qint VSS) capacitor c=4.39172e-17
C42 (\4\:RN VSS) capacitor c=3.14658e-17
C43 (\2\:RN VSS) capacitor c=3.58419e-17
C44 (\3\:G VSS) capacitor c=1.30566e-17
C45 (\4\:Gbb VSS) capacitor c=5.28911e-17
C46 (\1\:VDD VSS) capacitor c=1.56909e-16
C47 (\8\:n5 VSS) capacitor c=7.49006e-17
C48 (\14\:VDD VSS) capacitor c=1.97873e-17
C49 (\3\:net103 VSS) capacitor c=6.85603e-17
C50 (\34\:Qint VSS) capacitor c=1.85529e-16
C51 (\18\:VDD VSS) capacitor c=1.80563e-17
C52 (\11\:Gb VSS) capacitor c=4.76666e-16
C53 (\34\:VDD VSS) capacitor c=4.3259e-17
C54 (\6\:Gbb VSS) capacitor c=1.07698e-16
C55 (\12\:n5 VSS) capacitor c=2.39574e-17
C56 (\40\:Qint VSS) capacitor c=9.28993e-17
C57 (\14\:Qbint VSS) capacitor c=2.97667e-16
C58 (\13\:Gb VSS) capacitor c=7.01738e-17
C59 (\2\:G VSS) capacitor c=1.92354e-17
C60 (\8\:Qint VSS) capacitor c=2.78335e-16
C61 (\3\:n5 VSS) capacitor c=1.57569e-16
C62 (\5\:G VSS) capacitor c=1.95794e-17
C63 (\18\:Qbint VSS) capacitor c=5.27947e-17
C64 (\7\:RN VSS) capacitor c=6.48537e-16
C65 (\8\:RN VSS) capacitor c=2.67301e-17
C66 (\33\:Qint VSS) capacitor c=6.67113e-17
C67 (\38\:Qint VSS) capacitor c=9.48739e-17
C68 (\39\:Qint VSS) capacitor c=2.24089e-17
C69 (\10\:n5 VSS) capacitor c=1.24035e-16
C70 (\11\:n5 VSS) capacitor c=1.02052e-16
C71 (\4\:D VSS) capacitor c=6.77938e-17
C72 (\8\:Gb VSS) capacitor c=7.05228e-17
C73 (\9\:Gb VSS) capacitor c=1.10718e-16
C74 (\10\:Gb VSS) capacitor c=5.7659e-16
C75 (\15\:Gb VSS) capacitor c=5.69575e-17
C76 (\16\:Gb VSS) capacitor c=7.02672e-17
C77 (\8\:Gbb VSS) capacitor c=9.26604e-17
C78 (\3\:VDD VSS) capacitor c=9.23815e-17
C79 (\4\:VDD VSS) capacitor c=7.60726e-16
C80 (\13\:VDD VSS) capacitor c=4.65469e-17
Rk29 (D \4\:D) resistor r=0.1125 c=0
Rk1 (\5\:G G) resistor r=0.05653 c=0
Rk18 (\7\:RN RN) resistor r=5.6724 c=0
Rk19 (RN \8\:RN) resistor r=0.03296 c=0
Rk61 (\2\:VSS \3\:VSS) resistor r=0.2379 c=0
Rk62 (\3\:VSS \4\:VSS) resistor r=0.4635 c=0
Rk63 (\4\:VSS \5\:VSS) resistor r=0.2078 c=0
Rk73 (\6\:VSS VSS) resistor r=0.3555 c=0
Rk64 (\5\:VSS \6\:VSS) resistor r=0.4082 c=0
Rk74 (\3\:VSS \16\:VSS) resistor r=0.222 c=0
Rk75 (\5\:VSS \18\:VSS) resistor r=0.1222 c=0
Rk38 (\2\:VDD \3\:VDD) resistor r=0.773 c=0
Rk39 (\3\:VDD \4\:VDD) resistor r=0.2117 c=0
Rk49 (\13\:VDD VDD) resistor r=0.1123 c=0
Rk48 (\4\:VDD \13\:VDD) resistor r=0.2854 c=0
Rk50 (\3\:VDD \15\:VDD) resistor r=0.04328 c=0
Rk52 (\4\:VDD \19\:VDD) resistor r=0.07358 c=0
Rk60 (\13\:VDD \35\:VDD) resistor r=0.38 c=0
Rk30 (\8\:Gb \9\:Gb) resistor r=0.4521 c=0
Rk31 (\9\:Gb \10\:Gb) resistor r=0.4621 c=0
Rk32 (\10\:Gb \12\:Gb) resistor r=4.327 c=0
Rk33 (\12\:Gb \14\:Gb) resistor r=0.4282 c=0
Rk34 (\9\:Gb \15\:Gb) resistor r=0.2637 c=0
Rk35 (\10\:Gb \16\:Gb) resistor r=0.4096 c=0
Rk8 (\14\:Qbint \18\:Qbint) resistor r=0.3455 c=0
Rk20 (\33\:Qint \34\:Qint) resistor r=0.415 c=0
Rk22 (\34\:Qint \38\:Qint) resistor r=0.3009 c=0
Rk23 (\38\:Qint \39\:Qint) resistor r=0.1109 c=0
Rk24 (\38\:Qint \41\:Qint) resistor r=0.5798 c=0
Rk26 (\9\:n5 \10\:n5) resistor r=0.4864 c=0
Rk27 (\10\:n5 \11\:n5) resistor r=0.7341 c=0
Rk28 (\10\:n5 \13\:n5) resistor r=0.09314 c=0
Rk36 (\5\:Gbb \7\:Gbb) resistor r=0.4726 c=0
Rk37 (\7\:Gbb \8\:Gbb) resistor r=0.7035 c=0
Rk25 (\2\:net103 \4\:net103) resistor r=0.2607 c=0
Rl64 (\1\:D \2\:D) resistor r=77.6148 c=0
Rl65 (\2\:D \3\:D) resistor r=89.1533 c=0
Rl3 (\2\:G \4\:G) resistor r=76.385 c=0
Rl1 (\1\:G \2\:G) resistor r=86.048 c=0
Rl2 (\2\:G \3\:G) resistor r=8.3231 c=0
Rl57 (\5\:RN \6\:RN) resistor r=170.72 c=0
Rl56 (\4\:RN \5\:RN) resistor r=35.7417 c=0
Rl4 (\1\:RN \2\:RN) resistor r=81.461 c=0
Rl5 (\2\:RN \3\:RN) resistor r=39.1533 c=0
Rl55 (SN \6\:SN) resistor r=85.7713 c=0
Rl46 (SN \1\:SN) resistor r=88.4615 c=0
Rl66 (\5\:Gb \6\:Gb) resistor r=30.7692 c=0
Rl67 (\6\:Gb \7\:Gb) resistor r=137.637 c=0
Rl63 (\3\:Gb \4\:Gb) resistor r=131.925 c=0
Rl60 (Gb \2\:Gb) resistor r=98.7687 c=0
Rl59 (\31\:Qint \32\:Qint) resistor r=24.7951 c=0
Rl58 (\31\:Qint \30\:Qint) resistor r=128.823 c=0
Rl24 (\8\:Qint Qint) resistor r=143.497 c=0
Rl48 (\2\:n5 n5) resistor r=28.1859 c=0
Rl51 (\3\:n5 \5\:n5) resistor r=28.0797 c=0
Rl49 (\3\:n5 \2\:n5) resistor r=7.5029 c=0
Rl61 (Gbb \2\:Gbb) resistor r=192.308 c=0
Rl62 (\2\:Gbb \3\:Gbb) resistor r=24.2328 c=0
Rz11 (\16\:VSS \15\:VSS) resistor r=75 c=0
Rz12 (\18\:VSS \17\:VSS) resistor r=75 c=0
Rz9 (\13\:Gb \14\:Gb) resistor r=75 c=0
Rz7 (\41\:Qint \40\:Qint) resistor r=75 c=0
Rz8 (\13\:n5 \12\:n5) resistor r=75 c=0
Rz10 (\6\:Gbb \7\:Gbb) resistor r=75 c=0
Ry26 (\2\:VSS \1\:VSS) resistor r=31 c=0
Ry27 (\4\:VSS \1\:VSS) resistor r=5.1667 c=0
Ry29 (\6\:VSS \1\:VSS) resistor r=2.5833 c=0
Ry14 (\2\:VDD \1\:VDD) resistor r=62 c=0
Ry15 (\15\:VDD \14\:VDD) resistor r=62 c=0
Ry17 (\19\:VDD \18\:VDD) resistor r=62 c=0
Ry25 (\35\:VDD \34\:VDD) resistor r=62 c=0
Ry12 (\11\:Gb \12\:Gb) resistor r=62 c=0
Ry11 (\9\:n5 \8\:n5) resistor r=62 c=0
Ry13 (\4\:Gbb \5\:Gbb) resistor r=62 c=0
Ry9 (net103 \2\:net103) resistor r=62 c=0
Ry10 (\3\:net103 \4\:net103) resistor r=62 c=0
Rx10 (\2\:D \4\:D) resistor r=45 c=0
Rx1 (\3\:G \5\:G) resistor r=45 c=0
Rx5 (\4\:RN \7\:RN) resistor r=45 c=0
Rx6 (\2\:RN \8\:RN) resistor r=45 c=0
Rx11 (\6\:Gb \8\:Gb) resistor r=45 c=0
Rx12 (\4\:Gb \15\:Gb) resistor r=45 c=0
Rx13 (\2\:Gb \16\:Gb) resistor r=45 c=0
Rx2 (\18\:Qbint Qbint) resistor r=45 c=0
Rx7 (\33\:Qint \31\:Qint) resistor r=45 c=0
Rx8 (\39\:Qint Qint) resistor r=45 c=0
Rx9 (\11\:n5 \2\:n5) resistor r=45 c=0
Rx14 (\3\:Gbb \8\:Gbb) resistor r=45 c=0
mn1 (\13\:Gb \1\:G net159 VSS) g45n1svt w=(1.45e-07) l=4.5e-08 nf=1 \
        as=8.7e-15 ad=2.03e-14 ps=4.1e-07 pd=5.7e-07 nrd=1.16667 \
        nrs=1.16667 sa=1.4e-07 sb=2e-06 sd=160n sca=13.9854 scb=0.014728 \
        scc=0.000819645 m=(1)
mn0 (net159 \3\:RN \6\:VSS VSS) g45n1svt w=(1.45e-07) l=4.5e-08 nf=1 \
        as=7.355e-14 ad=8.7e-15 ps=1.13e-06 pd=4.1e-07 nrd=1.16667 \
        nrs=1.16667 sa=2.45e-07 sb=2e-06 sd=160n sca=13.9854 scb=0.014728 \
        scc=0.000819645 m=(1)
mn15 (net167 \5\:RN \17\:VSS VSS) g45n1svt w=(1.45e-07) l=4.5e-08 nf=1 \
        as=6.85e-14 ad=2.683e-14 ps=1.29e-06 pd=6.6e-07 nrd=1.16667 \
        nrs=1.16667 sa=2e-06 sb=1.695e-06 sd=160n sca=13.9854 scb=0.014728 \
        scc=0.000819645 m=(1)
mn16 (net171 \30\:Qint net167 VSS) g45n1svt w=(1.45e-07) l=4.5e-08 nf=1 \
        as=2.683e-14 ad=3.698e-14 ps=6.6e-07 pd=8e-07 nrd=1.16667 \
        nrs=1.16667 sa=2e-06 sb=1.465e-06 sd=160n sca=13.9854 scb=0.014728 \
        scc=0.000819645 m=(1)
mn17 (\12\:n5 Gb net171 VSS) g45n1svt w=(1.45e-07) l=4.5e-08 nf=1 \
        as=3.698e-14 ad=2.393e-14 ps=8e-07 pd=6.2e-07 nrd=1.16667 \
        nrs=1.16667 sa=2e-06 sb=1.165e-06 sd=160n sca=13.9854 scb=0.014728 \
        scc=0.000819645 m=(1)
mn6 (\12\:n5 \2\:Gbb net191 VSS) g45n1svt w=(1.45e-07) l=4.5e-08 nf=1 \
        as=5.075e-14 ad=2.393e-14 ps=9.9e-07 pd=6.2e-07 nrd=1.16667 \
        nrs=1.16667 sa=2e-06 sb=9.55e-07 sd=160n sca=13.9854 scb=0.014728 \
        scc=0.000819645 m=(1)
mn5 (net191 \3\:D \15\:VSS VSS) g45n1svt w=(1.45e-07) l=4.5e-08 nf=1 \
        as=6.998e-14 ad=5.075e-14 ps=1.3e-06 pd=9.9e-07 nrd=1.16667 \
        nrs=1.16667 sa=2e-06 sb=5.6e-07 sd=160n sca=13.9854 scb=0.014728 \
        scc=0.000819645 m=(1)
mn2 (\6\:Gbb \7\:Gb \15\:VSS VSS) g45n1svt w=(1.45e-07) l=4.5e-08 nf=1 \
        as=6.998e-14 ad=2.03e-14 ps=1.3e-06 pd=5.7e-07 nrd=1.16667 \
        nrs=1.16667 sa=2e-06 sb=1.4e-07 sd=160n sca=13.9854 scb=0.014728 \
        scc=0.000819645 m=(1)
mn20 (\14\:Qbint \8\:Qint \6\:VSS VSS) g45n1svt w=(2.6e-07) l=4.5e-08 \
        nf=1 as=9.815e-14 ad=4.16e-14 ps=1.275e-06 pd=8.4e-07 nrd=1.16667 \
        nrs=1.16667 sa=1.72462e-06 sb=2e-06 sd=160n sca=11.3041 \
        scb=0.010759 scc=0.000493236 m=(4)
mn21_1__rcx (Q Qbint \6\:VSS VSS) g45n1svt w=(2.6e-07) l=4.5e-08 nf=1 \
        as=8.729e-14 ad=5.2e-14 ps=1.2025e-06 pd=9.2e-07 nrd=1.16667 \
        nrs=1.16667 sa=4.44615e-07 sb=2e-06 sd=160n sca=11.3041 \
        scb=0.010759 scc=0.000493236 m=(4)
mn22 (QN Qint \6\:VSS VSS) g45n1svt w=(2.6e-07) l=4.5e-08 nf=1 \
        as=1.0554e-13 ad=4.16e-14 ps=1.3425e-06 pd=8.4e-07 nrd=1.16667 \
        nrs=1.16667 sa=2e-06 sb=1.82865e-06 sd=160n sca=11.3041 \
        scb=0.010759 scc=0.000493236 m=(4)
mn10_1__rcx (18 \1\:SN \6\:VSS VSS) g45n1svt w=(2.05e-07) l=4.5e-08 nf=1 \
        as=8.675e-14 ad=1.435e-14 ps=1.23e-06 pd=5.5e-07 nrd=1.16667 \
        nrs=1.16667 sa=2e-06 sb=1.62537e-06 sd=160n sca=12.4149 \
        scb=0.012446 scc=0.000614222 m=(1)
mn11_1__rcx (\40\:Qint \5\:n5 18 VSS) g45n1svt w=(2.05e-07) l=4.5e-08 \
        nf=1 as=1.435e-14 ad=4.305e-14 ps=5.5e-07 pd=8.3e-07 nrd=1.16667 \
        nrs=1.16667 sa=2e-06 sb=1.59171e-06 sd=160n sca=12.4149 \
        scb=0.012446 scc=0.000614222 m=(1)
mn11 (\40\:Qint n5 19 VSS) g45n1svt w=(2.05e-07) l=4.5e-08 nf=1 \
        as=2.768e-14 ad=4.305e-14 ps=6.8e-07 pd=8.3e-07 nrd=1.16667 \
        nrs=1.16667 sa=2e-06 sb=1.51707e-06 sd=160n sca=12.4149 \
        scb=0.012446 scc=0.000614222 m=(1)
mn10 (19 \6\:SN \17\:VSS VSS) g45n1svt w=(2.05e-07) l=4.5e-08 nf=1 \
        as=6.85e-14 ad=2.768e-14 ps=1.29e-06 pd=6.8e-07 nrd=1.16667 \
        nrs=1.16667 sa=2e-06 sb=1.4361e-06 sd=160n sca=12.4149 \
        scb=0.012446 scc=0.000614222 m=(1)
mp20_1__rcx (\14\:Qbint \8\:Qint \4\:VDD NW) g45p1svt w=(3.9e-07) \
        l=4.5e-08 nf=1 as=1.4445e-13 ad=6.825e-14 ps=1.59e-06 pd=1.13e-06 \
        nrd=1.16667 nrs=1.16667 sa=1.72179e-06 sb=2e-06 sd=160n \
        sca=17.2385 scb=0.0152696 scc=0.00137893 m=(4)
mp21_1__rcx (Q Qbint \4\:VDD NW) g45p1svt w=(3.9e-07) l=4.5e-08 nf=1 \
        as=1.3416e-13 ad=7.8e-14 ps=1.71e-06 pd=1.18e-06 nrd=1.16667 \
        nrs=1.16667 sa=4.52821e-07 sb=2e-06 sd=160n sca=17.2385 \
        scb=0.0152696 scc=0.00137893 m=(4)
mp22_1__rcx (QN Qint \4\:VDD NW) g45p1svt w=(3.9e-07) l=4.5e-08 nf=1 \
        as=1.122e-13 ad=9.848e-14 ps=1.44e-06 pd=1.285e-06 nrd=1.16667 \
        nrs=1.16667 sa=2e-06 sb=1.7925e-06 sd=160n sca=17.2385 \
        scb=0.0152696 scc=0.00137893 m=(4)
mp11 (\34\:Qint \3\:n5 \18\:VDD NW) g45p1svt w=(3.1e-07) l=4.5e-08 nf=1 \
        as=8.35e-14 ad=4.96e-14 ps=1.84e-06 pd=9.4e-07 nrd=1.16667 \
        nrs=1.16667 sa=2e-06 sb=8.29758e-07 sd=160n sca=19.1541 \
        scb=0.0174883 scc=0.00172295 m=(2)
mp10_1__rcx (\34\:Qint SN \4\:VDD NW) g45p1svt w=(3.1e-07) l=4.5e-08 \
        nf=1 as=9.604e-14 ad=4.96e-14 ps=1.67e-06 pd=9.4e-07 nrd=1.16667 \
        nrs=1.16667 sa=2e-06 sb=1.03476e-06 sd=160n sca=19.1541 \
        scb=0.0174883 scc=0.00172295 m=(2)
ends TLATSRX4
// End of subcircuit definition.
