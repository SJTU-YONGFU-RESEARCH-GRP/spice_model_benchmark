// Generated for: spectre (May  1 11:30:59 2013 )
// Library name: gsclib045_backbias
// Cell name: NOR4BBX4
// View name: extracted

simulator lang=spectre

subckt NOR4BBX4 AN BN C D NW VDD VSS Y
mp1 (\18\:n1 \1\:BN \7\:VDD NW) g45p1svt w=(3.9e-07) l=4.5e-08 nf=1 \
        as=6.24e-14 ad=5.46e-14 ps=1.1e-06 pd=1.06e-06 nrd=1.16667 \
        nrs=1.16667 sa=1.4e-07 sb=3.75e-07 sd=160n sca=16.9422 \
        scb=0.0172816 scc=0.000388705 m=(1)
mp0 (\17\:n0 \1\:AN \7\:VDD NW) g45p1svt w=(3.9e-07) l=4.5e-08 nf=1 \
        as=6.24e-14 ad=6.63e-14 ps=1.1e-06 pd=1.12e-06 nrd=1.16667 \
        nrs=1.16667 sa=3.45e-07 sb=1.7e-07 sd=160n sca=13.2347 \
        scb=0.0110279 scc=0.000235823 m=(1)
mp2_1__rcx (n2 n0 \1\:VDD NW) g45p1svt w=(3.9e-07) l=4.5e-08 nf=1 \
        as=6.24e-14 ad=6.045e-14 ps=1.1e-06 pd=1.09e-06 nrd=1.16667 \
        nrs=1.16667 sa=1.4e-07 sb=1.575e-06 sd=160n sca=11.7201 \
        scb=0.00999512 scc=0.000291798 m=(4)
mp4_1__rcx (n4 \1\:C n3 NW) g45p1svt w=(3.9e-07) l=4.5e-08 nf=1 \
        as=6.24e-14 ad=6.045e-14 ps=1.1e-06 pd=1.09e-06 nrd=1.16667 \
        nrs=1.16667 sa=1.4e-07 sb=1.575e-06 sd=160n sca=11.7201 \
        scb=0.00999512 scc=0.000291798 m=(4)
mp5 (Y \1\:D n4 NW) g45p1svt w=(3.9e-07) l=4.5e-08 nf=1 as=6.045e-14 \
        ad=6.24e-14 ps=1.09e-06 pd=1.1e-06 nrd=1.16667 nrs=1.16667 \
        sa=9.6e-07 sb=7.55e-07 sd=160n sca=12.0193 scb=0.0100773 \
        scc=0.000291813 m=(4)
mp3_1__rcx (\5\:n3 n1 n2 NW) g45p1svt w=(3.9e-07) l=4.5e-08 nf=1 \
        as=6.045e-14 ad=6.24e-14 ps=1.09e-06 pd=1.1e-06 nrd=1.16667 \
        nrs=1.16667 sa=9.6e-07 sb=7.55e-07 sd=160n sca=11.7201 \
        scb=0.00999512 scc=0.000291798 m=(4)
C1 (BN VSS) capacitor c=1.00058e-16
C2 (D VSS) capacitor c=3.49783e-17
C3 (NW VSS) capacitor c=6.00529e-16
C4 (VDD VSS) capacitor c=4.79051e-17
C5 (C VSS) capacitor c=4.87056e-17
C6 (AN VSS) capacitor c=7.94216e-17
C7 (Y VSS) capacitor c=1.84957e-16
C8 (n1 VSS) capacitor c=3.07305e-16
C9 (n0 VSS) capacitor c=3.04487e-16
C10 (n2 VSS) capacitor c=3.93424e-16
C11 (n3 VSS) capacitor c=1.58867e-16
C12 (n4 VSS) capacitor c=3.68174e-16
C13 (\1\:D VSS) capacitor c=3.2137e-16
C14 (\1\:C VSS) capacitor c=3.13129e-16
C15 (\1\:AN VSS) capacitor c=4.44805e-17
C16 (\1\:BN VSS) capacitor c=4.66609e-17
C17 (\3\:AN VSS) capacitor c=3.44906e-17
C18 (\3\:BN VSS) capacitor c=3.08708e-17
C19 (\2\:AN VSS) capacitor c=3.23091e-17
C20 (\2\:BN VSS) capacitor c=3.89292e-17
C21 (\5\:n3 VSS) capacitor c=1.35173e-16
C22 (\1\:VDD VSS) capacitor c=5.77371e-16
C23 (\17\:n0 VSS) capacitor c=5.97706e-17
C24 (\7\:VDD VSS) capacitor c=3.48412e-17
C25 (\18\:n1 VSS) capacitor c=8.46237e-17
C26 (\7\:Y VSS) capacitor c=1.14224e-16
C27 (\11\:Y VSS) capacitor c=1.14865e-16
C28 (\15\:Y VSS) capacitor c=1.4361e-16
C29 (\19\:n0 VSS) capacitor c=5.76574e-17
C30 (\16\:n1 VSS) capacitor c=2.49252e-16
C31 (\4\:BN VSS) capacitor c=3.42037e-17
C32 (\4\:AN VSS) capacitor c=5.13404e-17
C33 (\15\:n0 VSS) capacitor c=5.59675e-17
C34 (\16\:n0 VSS) capacitor c=6.65793e-17
C35 (\15\:n1 VSS) capacitor c=1.6417e-16
C36 (\16\:D VSS) capacitor c=6.73414e-17
C37 (\4\:Y VSS) capacitor c=1.06587e-16
C38 (\4\:VDD VSS) capacitor c=5.56174e-17
Rk1 (\4\:BN BN) resistor r=0.02098 c=0
Rk19 (\16\:D D) resistor r=0.04495 c=0
Rk60 (\4\:VDD VDD) resistor r=0.1675 c=0
Rk59 (\1\:VDD \4\:VDD) resistor r=0.3881 c=0
Rk62 (\4\:VDD \8\:VDD) resistor r=0.1804 c=0
Rk13 (\15\:C C) resistor r=0.002997 c=0
Rk2 (AN \4\:AN) resistor r=0.1348 c=0
Rk49 (\15\:VSS VSS) resistor r=0.1299 c=0
Rk48 (\1\:VSS \15\:VSS) resistor r=0.3606 c=0
Rk57 (\15\:VSS \31\:VSS) resistor r=0.2791 c=0
Rk25 (\7\:Y \11\:Y) resistor r=0.2972 c=0
Rk27 (\11\:Y \15\:Y) resistor r=0.2969 c=0
Rk21 (Y \4\:Y) resistor r=0.341 c=0
Rk23 (\4\:Y \7\:Y) resistor r=0.2983 c=0
Rk6 (\15\:n1 \17\:n1) resistor r=1.5866 c=0
Rk7 (\17\:n1 \19\:n1) resistor r=0.6493 c=0
Rk3 (\15\:n0 \16\:n0) resistor r=0.3138 c=0
Rk4 (\16\:n0 \18\:n0) resistor r=0.2641 c=0
Rk5 (\16\:n0 \20\:n0) resistor r=0.2621 c=0
Rk15 (n3 \5\:n3) resistor r=0.4344 c=0
Rl1 (\1\:BN \2\:BN) resistor r=92.3077 c=0
Rl2 (\2\:BN \3\:BN) resistor r=57.1429 c=0
Rl3 (\1\:AN \2\:AN) resistor r=91.0764 c=0
Rl4 (\2\:AN \3\:AN) resistor r=56.461 c=0
Rz20 (\31\:VSS \30\:VSS) resistor r=75 c=0
Rz2 (\17\:n1 \16\:n1) resistor r=75 c=0
Rz1 (\20\:n0 \19\:n0) resistor r=75 c=0
Ry23 (\8\:VDD \7\:VDD) resistor r=62 c=0
Ry2 (\19\:n1 \18\:n1) resistor r=62 c=0
Ry1 (\18\:n0 \17\:n0) resistor r=20.6667 c=0
Rx1 (\2\:BN \4\:BN) resistor r=45 c=0
Rx6 (\16\:D \1\:D) resistor r=45 c=0
Rx5 (\15\:C \1\:C) resistor r=45 c=0
Rx2 (\2\:AN \4\:AN) resistor r=45 c=0
Rx4 (\15\:n1 n1) resistor r=45 c=0
Rx3 (\15\:n0 n0) resistor r=45 c=0
mn1 (\16\:n1 \3\:BN \30\:VSS VSS) g45n1svt w=(2.6e-07) l=4.5e-08 nf=1 \
        as=6.11e-14 ad=3.64e-14 ps=9.9e-07 pd=8e-07 nrd=1.16667 \
        nrs=1.16667 sa=1.4e-07 sb=4.6e-07 sd=160n sca=15.3338 \
        scb=0.0153436 scc=0.00119435 m=(1)
mn0 (\19\:n0 \3\:AN \30\:VSS VSS) g45n1svt w=(2.6e-07) l=4.5e-08 nf=1 \
        as=6.11e-14 ad=4.68e-14 ps=9.9e-07 pd=8.8e-07 nrd=1.16667 \
        nrs=1.16667 sa=4.2e-07 sb=1.8e-07 sd=160n sca=15.3338 \
        scb=0.0153436 scc=0.00119435 m=(1)
mn4_1__rcx (\7\:Y \1\:C \1\:VSS VSS) g45n1svt w=(2.6e-07) l=4.5e-08 nf=1 \
        as=4.355e-14 ad=4.16e-14 ps=8.55e-07 pd=8.4e-07 nrd=1.16667 \
        nrs=1.16667 sa=1.81e-06 sb=1.605e-06 sd=160n sca=7.84363 \
        scb=0.00546499 scc=9.84911e-05 m=(4)
mn3_1__rcx (\11\:Y n1 \1\:VSS VSS) g45n1svt w=(2.6e-07) l=4.5e-08 nf=1 \
        as=4.355e-14 ad=4.16e-14 ps=8.55e-07 pd=8.4e-07 nrd=1.16667 \
        nrs=1.16667 sa=9.6e-07 sb=2e-06 sd=160n sca=7.84363 scb=0.00546499 \
        scc=9.84911e-05 m=(4)
mn2_1__rcx (\15\:Y n0 \1\:VSS VSS) g45n1svt w=(2.6e-07) l=4.5e-08 nf=1 \
        as=4.03e-14 ad=4.16e-14 ps=8.3e-07 pd=8.4e-07 nrd=1.16667 \
        nrs=1.16667 sa=1.4e-07 sb=2e-06 sd=160n sca=7.84363 scb=0.00546499 \
        scc=9.84911e-05 m=(4)
mn5_1__rcx (\4\:Y \1\:D \1\:VSS VSS) g45n1svt w=(2.6e-07) l=4.5e-08 nf=1 \
        as=4.03e-14 ad=4.55e-14 ps=8.3e-07 pd=8.7e-07 nrd=1.16667 \
        nrs=1.16667 sa=2e-06 sb=7.85e-07 sd=160n sca=7.84363 \
        scb=0.00546499 scc=9.84911e-05 m=(4)
ends NOR4BBX4
// End of subcircuit definition.
