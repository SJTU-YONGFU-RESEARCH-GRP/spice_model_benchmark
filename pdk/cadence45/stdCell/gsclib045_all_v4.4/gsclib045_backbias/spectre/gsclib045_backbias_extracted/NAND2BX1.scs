// Generated for: spectre (May  1 11:30:11 2013 )
// Library name: gsclib045_backbias
// Cell name: NAND2BX1
// View name: extracted

simulator lang=spectre

subckt NAND2BX1 AN B NW VDD VSS Y
mp2 (\1\:Y \4\:B \3\:VDD NW) g45p1svt w=(3.9e-07) l=4.5e-08 nf=1 \
        as=6.315e-14 ad=6.24e-14 ps=1.75e-06 pd=1.1e-06 nrd=1.16667 \
        nrs=1.16667 sa=1e-07 sb=4.30321e-07 sd=160n sca=40.0601 \
        scb=0.0398737 scc=0.00422188 m=(1)
mp1 (\1\:Y n0 \1\:VDD NW) g45p1svt w=(3.9e-07) l=4.5e-08 nf=1 \
        as=5.19e-14 ad=6.24e-14 ps=1.1e-06 pd=1.1e-06 nrd=1.16667 \
        nrs=1.16667 sa=3.05e-07 sb=2.25321e-07 sd=160n sca=30.8677 \
        scb=0.0275043 scc=0.00252863 m=(1)
C1 (Y VSS) capacitor c=6.98105e-17
C2 (NW VSS) capacitor c=1.57787e-16
C3 (VDD VSS) capacitor c=9.85366e-17
C4 (AN VSS) capacitor c=3.52583e-17
C5 (n1 VSS) capacitor c=1.56892e-18
C6 (n0 VSS) capacitor c=5.74477e-17
C7 (\1\:AN VSS) capacitor c=4.33123e-17
C8 (\4\:B VSS) capacitor c=4.00496e-17
C9 (\3\:AN VSS) capacitor c=3.59295e-17
C10 (\3\:n0 VSS) capacitor c=6.42643e-17
C11 (\1\:B VSS) capacitor c=5.59285e-17
C12 (\2\:AN VSS) capacitor c=3.92783e-17
C13 (\2\:n0 VSS) capacitor c=4.46418e-17
C14 (\3\:B VSS) capacitor c=1.09983e-17
C15 (\4\:n0 VSS) capacitor c=6.84821e-17
C16 (\1\:VDD VSS) capacitor c=6.21156e-17
C17 (\1\:Y VSS) capacitor c=4.08979e-17
C18 (\3\:VDD VSS) capacitor c=8.59876e-18
C19 (\7\:n0 VSS) capacitor c=4.82194e-17
C20 (\4\:Y VSS) capacitor c=7.47529e-17
C21 (\2\:B VSS) capacitor c=2.68345e-17
C22 (\5\:B VSS) capacitor c=3.32724e-17
C23 (\6\:B VSS) capacitor c=1.91864e-17
C24 (\6\:n0 VSS) capacitor c=1.22933e-16
C25 (\4\:AN VSS) capacitor c=4.95055e-17
Rk4 (\2\:Y Y) resistor r=0.1555 c=0
Rk5 (Y \5\:Y) resistor r=0.5005 c=0
Rk1 (B \5\:B) resistor r=0.002798 c=0
Rk3 (\5\:B \6\:B) resistor r=0.06107 c=0
Rk2 (\6\:B \7\:B) resistor r=0.002946 c=0
Rk13 (\4\:VSS VSS) resistor r=0.1502 c=0
Rk12 (\2\:VSS \4\:VSS) resistor r=0.3415 c=0
Rk10 (\2\:VDD VDD) resistor r=0.4953 c=0
Rk11 (VDD \4\:VDD) resistor r=0.06044 c=0
Rk9 (\4\:AN AN) resistor r=0.03221 c=0
Rk7 (\5\:n0 \6\:n0) resistor r=0.5506 c=0
Rk8 (\6\:n0 \8\:n0) resistor r=0.2967 c=0
Rl3 (\2\:B \4\:B) resistor r=39.8465 c=0
Rl1 (\1\:B \2\:B) resistor r=57.2019 c=0
Rl2 (\2\:B \3\:B) resistor r=6.4152 c=0
Rl6 (\1\:AN \2\:AN) resistor r=78.079 c=0
Rl7 (\2\:AN \3\:AN) resistor r=70.3867 c=0
Rl4 (n0 \2\:n0) resistor r=49.5142 c=0
Rl5 (\2\:n0 \3\:n0) resistor r=42.2135 c=0
Rz1 (\4\:Y \5\:Y) resistor r=75 c=0
Rz3 (\1\:VSS \2\:VSS) resistor r=37.5 c=0
Rz2 (\7\:n0 \8\:n0) resistor r=75 c=0
Ry1 (\1\:Y \2\:Y) resistor r=31 c=0
Ry3 (\1\:VDD \2\:VDD) resistor r=62 c=0
Ry4 (\3\:VDD \4\:VDD) resistor r=62 c=0
Ry2 (\4\:n0 \5\:n0) resistor r=62 c=0
Rx1 (\3\:B \7\:B) resistor r=45 c=0
Rx3 (\2\:AN \4\:AN) resistor r=45 c=0
Rx2 (\2\:n0 \6\:n0) resistor r=45 c=0
mn2 (\4\:Y \1\:B n1 VSS) g45n1svt w=(2.6e-07) l=4.5e-08 nf=1 as=1.56e-14 \
        ad=3.08e-14 ps=6.4e-07 pd=8e-07 nrd=1.16667 nrs=1.16667 \
        sa=1.18462e-07 sb=3.76058e-07 sd=160n sca=15.3338 scb=0.0153436 \
        scc=0.00119435 m=(1)
mn1 (n1 \3\:n0 \1\:VSS VSS) g45n1svt w=(2.6e-07) l=4.5e-08 nf=1 \
        as=4.365e-14 ad=1.56e-14 ps=9e-07 pd=6.4e-07 nrd=1.16667 \
        nrs=1.16667 sa=2.23462e-07 sb=2.71058e-07 sd=160n sca=15.3338 \
        scb=0.0153436 scc=0.00119435 m=(1)
mn0 (\7\:n0 \3\:AN \1\:VSS VSS) g45n1svt w=(1.45e-07) l=4.5e-08 nf=1 \
        as=4.365e-14 ad=2.03e-14 ps=9e-07 pd=5.7e-07 nrd=1.16667 \
        nrs=1.16667 sa=4.41379e-07 sb=1.4e-07 sd=160n sca=19.8813 \
        scb=0.0206549 scc=0.00197265 m=(1)
mp0 (\4\:n0 \1\:AN \1\:VDD NW) g45p1svt w=(2.15e-07) l=4.5e-08 nf=1 \
        as=5.19e-14 ad=2.63e-14 ps=1.1e-06 pd=7.1e-07 nrd=1.16667 \
        nrs=1.16667 sa=5.1e-07 sb=1.22326e-07 sd=160n sca=26.8107 \
        scb=0.0301615 scc=0.00168945 m=(1)
ends NAND2BX1
// End of subcircuit definition.
