// Generated for: spectre (May  1 11:33:35 2013 )
// Library name: gsclib045_backbias
// Cell name: TLATNXL
// View name: extracted

simulator lang=spectre

subckt TLATNXL D GN NW Q QN VDD VSS
mp1 (\7\:GNbb GNb \10\:VDD NW) g45p1svt w=(2.15e-07) l=4.5e-08 nf=1 \
        as=5.73e-14 ad=3.01e-14 ps=1.47e-06 pd=7.1e-07 nrd=1.16667 \
        nrs=1.16667 sa=1.4e-07 sb=1.34233e-06 sd=160n sca=21.1459 \
        scb=0.0238169 scc=0.000917416 m=(1)
mp5 (net220 \1\:D \10\:VDD NW) g45p1svt w=(2.15e-07) l=4.5e-08 nf=1 \
        as=5.73e-14 ad=6.235e-14 ps=1.47e-06 pd=1.01e-06 nrd=1.16667 \
        nrs=1.16667 sa=3.45e-07 sb=1.13733e-06 sd=160n sca=14.0472 \
        scb=0.012275 scc=0.000208339 m=(1)
mp6 (\8\:n0 GNbb net220 NW) g45p1svt w=(2.15e-07) l=4.5e-08 nf=1 \
        as=6.235e-14 ad=5.697e-14 ps=1.01e-06 pd=9.6e-07 nrd=1.16667 \
        nrs=1.16667 sa=6.8e-07 sb=8.02326e-07 sd=160n sca=11.5667 \
        scb=0.00927227 scc=0.000188008 m=(1)
mp16 (\8\:n0 \6\:GNb net212 NW) g45p1svt w=(2.15e-07) l=4.5e-08 nf=1 \
        as=1.29e-14 ad=5.697e-14 ps=5.5e-07 pd=9.6e-07 nrd=1.16667 \
        nrs=1.16667 sa=9.9e-07 sb=4.92326e-07 sd=160n sca=11.1138 \
        scb=0.00912362 scc=0.000187967 m=(1)
mp15 (net212 \4\:Qint \8\:VDD NW) g45p1svt w=(2.15e-07) l=4.5e-08 nf=1 \
        as=8.21e-14 ad=1.29e-14 ps=1.45e-06 pd=5.5e-07 nrd=1.16667 \
        nrs=1.16667 sa=1.095e-06 sb=3.87326e-07 sd=160n sca=11.1138 \
        scb=0.00912362 scc=0.000187967 m=(1)
mp10 (\18\:Qint n0 \8\:VDD NW) g45p1svt w=(2.15e-07) l=4.5e-08 nf=1 \
        as=8.21e-14 ad=2.63e-14 ps=1.45e-06 pd=7.1e-07 nrd=1.16667 \
        nrs=1.16667 sa=1.36e-06 sb=1.22326e-07 sd=160n sca=11.1138 \
        scb=0.00912362 scc=0.000187967 m=(1)
mp0 (\14\:GNb \4\:GN \6\:VDD NW) g45p1svt w=(2.15e-07) l=4.5e-08 nf=1 \
        as=3.44e-14 ad=2.69e-14 ps=7.5e-07 pd=7.2e-07 nrd=1.16667 \
        nrs=1.16667 sa=1.25116e-07 sb=3.45e-07 sd=160n sca=10.3756 \
        scb=0.00778655 scc=9.84544e-05 m=(1)
mp22 (\3\:QN \11\:Qint \6\:VDD NW) g45p1svt w=(2.15e-07) l=4.5e-08 nf=1 \
        as=3.44e-14 ad=3.01e-14 ps=7.5e-07 pd=7.1e-07 nrd=1.16667 \
        nrs=1.16667 sa=3.30116e-07 sb=1.4e-07 sd=160n sca=10.3756 \
        scb=0.00778655 scc=9.84544e-05 m=(1)
mp20 (\9\:Qbint \5\:Qint \1\:VDD NW) g45p1svt w=(2.15e-07) l=4.5e-08 \
        nf=1 as=3.44e-14 ad=3.01e-14 ps=7.5e-07 pd=7.1e-07 nrd=1.16667 \
        nrs=1.16667 sa=1.4e-07 sb=3.7e-07 sd=160n sca=48.8019 \
        scb=0.0316124 scc=0.00590646 m=(1)
mp21 (\3\:Q Qbint \1\:VDD NW) g45p1svt w=(2.15e-07) l=4.5e-08 nf=1 \
        as=3.44e-14 ad=3.548e-14 ps=7.5e-07 pd=7.6e-07 nrd=1.16667 \
        nrs=1.16667 sa=3.45e-07 sb=1.65e-07 sd=160n sca=56.1973 \
        scb=0.0435219 scc=0.00667686 m=(1)
C1 (GN VSS) capacitor c=1.10324e-16
C2 (D VSS) capacitor c=3.86855e-17
C3 (VDD VSS) capacitor c=3.92921e-17
C4 (NW VSS) capacitor c=4.55488e-16
C5 (Q VSS) capacitor c=3.1024e-17
C6 (GNb VSS) capacitor c=5.88691e-17
C7 (GNbb VSS) capacitor c=2.76524e-17
C8 (n0 VSS) capacitor c=6.16314e-17
C9 (net245 VSS) capacitor c=7.16463e-18
C10 (Qint VSS) capacitor c=2.93766e-17
C11 (Qbint VSS) capacitor c=3.79508e-17
C12 (net220 VSS) capacitor c=6.33193e-18
C13 (net212 VSS) capacitor c=7.7467e-19
C14 (\5\:Qint VSS) capacitor c=2.82596e-17
C15 (\11\:Qint VSS) capacitor c=6.00869e-17
C16 (\4\:GN VSS) capacitor c=3.6433e-17
C17 (\4\:Qint VSS) capacitor c=6.90984e-17
C18 (\6\:GNb VSS) capacitor c=5.03006e-17
C19 (\1\:D VSS) capacitor c=3.68335e-17
C20 (\4\:Qbint VSS) capacitor c=2.83678e-17
C21 (\10\:Qint VSS) capacitor c=3.65732e-17
C22 (\8\:Qint VSS) capacitor c=1.16642e-17
C23 (\3\:GN VSS) capacitor c=4.3196e-17
C24 (\3\:n0 VSS) capacitor c=2.47223e-17
C25 (\3\:Qint VSS) capacitor c=5.39182e-17
C26 (\4\:GNbb VSS) capacitor c=5.63315e-17
C27 (\4\:GNb VSS) capacitor c=6.36922e-17
C28 (\3\:D VSS) capacitor c=8.98017e-17
C29 (\3\:GNb VSS) capacitor c=3.0207e-17
C30 (\3\:Qbint VSS) capacitor c=2.05142e-17
C31 (\9\:Qint VSS) capacitor c=2.06563e-17
C32 (\1\:GN VSS) capacitor c=2.91668e-17
C33 (\2\:n0 VSS) capacitor c=6.4556e-17
C34 (\7\:GNb VSS) capacitor c=4.08245e-17
C35 (\3\:GNbb VSS) capacitor c=2.68933e-17
C36 (\5\:GNb VSS) capacitor c=4.58382e-17
C37 (\2\:D VSS) capacitor c=5.13529e-17
C38 (\2\:GNb VSS) capacitor c=4.31074e-17
C39 (\3\:Q VSS) capacitor c=2.45396e-17
C40 (\1\:VDD VSS) capacitor c=1.15144e-16
C41 (\9\:Qbint VSS) capacitor c=3.48738e-17
C42 (\3\:QN VSS) capacitor c=9.13185e-17
C43 (\6\:VDD VSS) capacitor c=3.82989e-17
C44 (\14\:GNb VSS) capacitor c=2.74302e-17
C45 (\18\:Qint VSS) capacitor c=5.87406e-17
C46 (\8\:VDD VSS) capacitor c=1.83511e-17
C47 (\8\:n0 VSS) capacitor c=7.98461e-17
C48 (\10\:VDD VSS) capacitor c=9.90171e-18
C49 (\7\:GNbb VSS) capacitor c=8.46999e-17
C50 (\1\:Q VSS) capacitor c=2.28657e-17
C51 (\7\:Qbint VSS) capacitor c=2.76169e-17
C52 (\1\:QN VSS) capacitor c=9.08368e-17
C53 (\8\:GNb VSS) capacitor c=1.17978e-16
C54 (\16\:Qint VSS) capacitor c=3.08221e-17
C55 (\6\:n0 VSS) capacitor c=6.39053e-17
C56 (\5\:GNbb VSS) capacitor c=6.37788e-17
C57 (\2\:GNbb VSS) capacitor c=3.3939e-17
C58 (\2\:Qint VSS) capacitor c=4.30873e-17
C59 (\2\:GN VSS) capacitor c=3.79702e-17
C60 (\6\:Qint VSS) capacitor c=3.96129e-17
C61 (\7\:Qint VSS) capacitor c=4.52588e-17
C62 (\2\:Qbint VSS) capacitor c=1.91063e-17
C63 (\4\:D VSS) capacitor c=7.24585e-17
C64 (\9\:GNbb VSS) capacitor c=7.45707e-17
C65 (\4\:n0 VSS) capacitor c=3.48835e-17
C66 (\5\:n0 VSS) capacitor c=9.66794e-17
C67 (\10\:GNb VSS) capacitor c=1.63302e-16
C68 (\11\:GNb VSS) capacitor c=1.30434e-16
C69 (\12\:GNb VSS) capacitor c=7.46549e-17
C70 (\13\:GNb VSS) capacitor c=5.1503e-17
C71 (\16\:GNb VSS) capacitor c=2.99677e-17
C72 (\12\:Qint VSS) capacitor c=1.28818e-16
C73 (\13\:Qint VSS) capacitor c=1.66694e-16
C74 (\14\:Qint VSS) capacitor c=5.9586e-17
C75 (\15\:Qint VSS) capacitor c=3.409e-17
C76 (\5\:Qbint VSS) capacitor c=3.64712e-17
C77 (\6\:Qbint VSS) capacitor c=2.89469e-17
C78 (\3\:VDD VSS) capacitor c=1.07315e-16
C79 (\4\:VDD VSS) capacitor c=9.70298e-17
C80 (\5\:VDD VSS) capacitor c=5.6347e-17
Rk13 (\5\:GN GN) resistor r=0.003 c=0
Rk1 (\4\:D D) resistor r=0.04318 c=0
Rk33 (\2\:VSS \4\:VSS) resistor r=0.3106 c=0
Rk34 (\4\:VSS \5\:VSS) resistor r=0.416 c=0
Rk35 (\5\:VSS \6\:VSS) resistor r=0.3863 c=0
Rk37 (\7\:VSS VSS) resistor r=0.1224 c=0
Rk36 (\6\:VSS \7\:VSS) resistor r=0.4289 c=0
Rk38 (\5\:VSS \9\:VSS) resistor r=0.3069 c=0
Rk39 (\6\:VSS \11\:VSS) resistor r=0.3311 c=0
Rk40 (\7\:VSS \13\:VSS) resistor r=0.2719 c=0
Rk26 (\2\:VDD \3\:VDD) resistor r=0.7891 c=0
Rk27 (\3\:VDD \4\:VDD) resistor r=0.3958 c=0
Rk29 (\5\:VDD VDD) resistor r=0.1375 c=0
Rk28 (\4\:VDD \5\:VDD) resistor r=0.4785 c=0
Rk30 (\3\:VDD \7\:VDD) resistor r=0.1784 c=0
Rk31 (\4\:VDD \9\:VDD) resistor r=0.07381 c=0
Rk32 (\5\:VDD \11\:VDD) resistor r=0.07381 c=0
Rk24 (Q \2\:Q) resistor r=0.12 c=0
Rk25 (Q \4\:Q) resistor r=0.177 c=0
Rk19 (\2\:QN QN) resistor r=0.006001 c=0
Rk20 (QN \4\:QN) resistor r=0.5101 c=0
Rk7 (\9\:GNb \10\:GNb) resistor r=0.7178 c=0
Rk8 (\10\:GNb \11\:GNb) resistor r=0.9246 c=0
Rk9 (\11\:GNb \12\:GNb) resistor r=0.4434 c=0
Rk10 (\12\:GNb \13\:GNb) resistor r=0.2123 c=0
Rk11 (\10\:GNb \15\:GNb) resistor r=0.1281 c=0
Rk12 (\11\:GNb \16\:GNb) resistor r=0.08656 c=0
Rk2 (\6\:GNbb \8\:GNbb) resistor r=0.5709 c=0
Rk3 (\8\:GNbb \9\:GNbb) resistor r=0.487 c=0
Rk4 (\4\:n0 \5\:n0) resistor r=0.1314 c=0
Rk5 (\5\:n0 \7\:n0) resistor r=0.478 c=0
Rk6 (\5\:n0 \9\:n0) resistor r=0.4275 c=0
Rk14 (\12\:Qint \13\:Qint) resistor r=1.0034 c=0
Rk15 (\13\:Qint \14\:Qint) resistor r=0.3093 c=0
Rk16 (\14\:Qint \15\:Qint) resistor r=0.1014 c=0
Rk17 (\13\:Qint \17\:Qint) resistor r=0.02381 c=0
Rk18 (\14\:Qint \19\:Qint) resistor r=0.2778 c=0
Rk21 (\5\:Qbint \6\:Qbint) resistor r=0.1193 c=0
Rk22 (\6\:Qbint \8\:Qbint) resistor r=0.1087 c=0
Rk23 (\6\:Qbint \10\:Qbint) resistor r=0.1957 c=0
Rl17 (\2\:GN \4\:GN) resistor r=69.7859 c=0
Rl16 (\2\:GN \3\:GN) resistor r=203.093 c=0
Rl15 (\1\:GN \2\:GN) resistor r=5.7469 c=0
Rl3 (\1\:D \2\:D) resistor r=29.5379 c=0
Rl4 (\2\:D \3\:D) resistor r=177.615 c=0
Rl9 (\6\:GNb \7\:GNb) resistor r=61.5157 c=0
Rl5 (\4\:GNb \5\:GNb) resistor r=29.5379 c=0
Rl1 (GNb \2\:GNb) resistor r=168 c=0
Rl2 (\2\:GNb \3\:GNb) resistor r=39.1533 c=0
Rl6 (GNbb \2\:GNbb) resistor r=35.772 c=0
Rl8 (\2\:GNbb \4\:GNbb) resistor r=193.464 c=0
Rl7 (\2\:GNbb \3\:GNbb) resistor r=32.3537 c=0
Rl13 (n0 \2\:n0) resistor r=194.208 c=0
Rl14 (\2\:n0 \3\:n0) resistor r=34.4104 c=0
Rl21 (\8\:Qint \9\:Qint) resistor r=29.5379 c=0
Rl12 (\2\:Qint \4\:Qint) resistor r=92.0218 c=0
Rl11 (\2\:Qint \3\:Qint) resistor r=153.126 c=0
Rl10 (Qint \2\:Qint) resistor r=9.9043 c=0
Rl18 (\5\:Qint \6\:Qint) resistor r=51.1566 c=0
Rl22 (\6\:Qint \10\:Qint) resistor r=89.6181 c=0
Rl23 (\7\:Qint \11\:Qint) resistor r=187.982 c=0
Rl20 (\7\:Qint \8\:Qint) resistor r=96.5658 c=0
Rl19 (\6\:Qint \7\:Qint) resistor r=195.503 c=0
Rl24 (Qbint \2\:Qbint) resistor r=99.7141 c=0
Rl26 (\2\:Qbint \4\:Qbint) resistor r=36.2526 c=0
Rl25 (\2\:Qbint \3\:Qbint) resistor r=2.0166 c=0
Rz8 (\1\:VSS \2\:VSS) resistor r=75 c=0
Rz9 (\8\:VSS \9\:VSS) resistor r=75 c=0
Rz10 (\10\:VSS \11\:VSS) resistor r=75 c=0
Rz11 (\12\:VSS \13\:VSS) resistor r=75 c=0
Rz7 (\1\:Q \2\:Q) resistor r=75 c=0
Rz5 (\1\:QN \2\:QN) resistor r=75 c=0
Rz3 (\8\:GNb \9\:GNb) resistor r=75 c=0
Rz1 (\5\:GNbb \6\:GNbb) resistor r=75 c=0
Rz2 (\6\:n0 \7\:n0) resistor r=75 c=0
Rz4 (\16\:Qint \17\:Qint) resistor r=75 c=0
Rz6 (\7\:Qbint \8\:Qbint) resistor r=75 c=0
Ry12 (\3\:VSS \4\:VSS) resistor r=15.5 c=0
Ry13 (\3\:VSS \6\:VSS) resistor r=5.1667 c=0
Ry8 (\1\:VDD \2\:VDD) resistor r=62 c=0
Ry9 (\6\:VDD \7\:VDD) resistor r=62 c=0
Ry10 (\8\:VDD \9\:VDD) resistor r=62 c=0
Ry11 (\10\:VDD \11\:VDD) resistor r=62 c=0
Ry7 (\3\:Q \4\:Q) resistor r=62 c=0
Ry5 (\3\:QN \4\:QN) resistor r=62 c=0
Ry3 (\14\:GNb \15\:GNb) resistor r=62 c=0
Ry1 (\7\:GNbb \8\:GNbb) resistor r=62 c=0
Ry2 (\8\:n0 \9\:n0) resistor r=62 c=0
Ry4 (\18\:Qint \19\:Qint) resistor r=62 c=0
Ry6 (\9\:Qbint \10\:Qbint) resistor r=62 c=0
Rx7 (\1\:GN \5\:GN) resistor r=45 c=0
Rx1 (\2\:D \4\:D) resistor r=45 c=0
Rx4 (\5\:GNb \12\:GNb) resistor r=45 c=0
Rx5 (\2\:GNb \13\:GNb) resistor r=45 c=0
Rx6 (\7\:GNb \16\:GNb) resistor r=45 c=0
Rx2 (\3\:GNbb \9\:GNbb) resistor r=45 c=0
Rx3 (\2\:n0 \4\:n0) resistor r=45 c=0
Rx8 (\9\:Qint \12\:Qint) resistor r=45 c=0
Rx9 (Qint \15\:Qint) resistor r=45 c=0
Rx10 (\3\:Qbint \5\:Qbint) resistor r=45 c=0
mn1 (\5\:GNbb \3\:GNb \12\:VSS VSS) g45n1svt w=(1.45e-07) l=4.5e-08 nf=1 \
        as=2.32e-14 ad=2.465e-14 ps=6.1e-07 pd=6.3e-07 nrd=1.16667 \
        nrs=1.16667 sa=1.7e-07 sb=1.2e-06 sd=160n sca=10.2779 \
        scb=0.00944477 scc=0.000275883 m=(1)
mn5 (net257 \3\:D \12\:VSS VSS) g45n1svt w=(1.45e-07) l=4.5e-08 nf=1 \
        as=2.32e-14 ad=8.7e-15 ps=6.1e-07 pd=4.1e-07 nrd=1.16667 \
        nrs=1.16667 sa=3.75e-07 sb=9.95e-07 sd=160n sca=10.2779 \
        scb=0.00944477 scc=0.000275883 m=(1)
mn6 (\6\:n0 \4\:GNb net257 VSS) g45n1svt w=(1.45e-07) l=4.5e-08 nf=1 \
        as=8.7e-15 ad=2.682e-14 ps=4.1e-07 pd=6.6e-07 nrd=1.16667 \
        nrs=1.16667 sa=4.8e-07 sb=8.9e-07 sd=160n sca=10.2779 \
        scb=0.00944477 scc=0.000275883 m=(1)
mn16 (\6\:n0 \4\:GNbb net245 VSS) g45n1svt w=(1.45e-07) l=4.5e-08 nf=1 \
        as=3.915e-14 ad=2.682e-14 ps=8.3e-07 pd=6.6e-07 nrd=1.16667 \
        nrs=1.16667 sa=7.1e-07 sb=6.6e-07 sd=160n sca=10.2779 \
        scb=0.00944477 scc=0.000275883 m=(1)
mn15 (net245 \3\:Qint \10\:VSS VSS) g45n1svt w=(1.45e-07) l=4.5e-08 nf=1 \
        as=2.32e-14 ad=3.915e-14 ps=6.1e-07 pd=8.3e-07 nrd=1.16667 \
        nrs=1.16667 sa=1.025e-06 sb=3.45e-07 sd=160n sca=10.2779 \
        scb=0.00944477 scc=0.000275883 m=(1)
mn10 (\16\:Qint \3\:n0 \10\:VSS VSS) g45n1svt w=(1.45e-07) l=4.5e-08 \
        nf=1 as=2.32e-14 ad=2.03e-14 ps=6.1e-07 pd=5.7e-07 nrd=1.16667 \
        nrs=1.16667 sa=1.23e-06 sb=1.4e-07 sd=160n sca=10.2779 \
        scb=0.00944477 scc=0.000275883 m=(1)
mn0 (\8\:GNb \3\:GN \8\:VSS VSS) g45n1svt w=(1.45e-07) l=4.5e-08 nf=1 \
        as=3.988e-14 ad=3.698e-14 ps=8.4e-07 pd=8e-07 nrd=1.16667 \
        nrs=1.16667 sa=2.55e-07 sb=4.6e-07 sd=160n sca=10.4914 \
        scb=0.00978575 scc=0.000300434 m=(1)
mn22 (\1\:QN \8\:Qint \8\:VSS VSS) g45n1svt w=(1.45e-07) l=4.5e-08 nf=1 \
        as=3.988e-14 ad=2.03e-14 ps=8.4e-07 pd=5.7e-07 nrd=1.16667 \
        nrs=1.16667 sa=5.75e-07 sb=1.4e-07 sd=160n sca=10.4914 \
        scb=0.00978575 scc=0.000300434 m=(1)
mn20 (\7\:Qbint \10\:Qint \1\:VSS VSS) g45n1svt w=(1.45e-07) l=4.5e-08 \
        nf=1 as=2.32e-14 ad=2.03e-14 ps=6.1e-07 pd=5.7e-07 nrd=1.16667 \
        nrs=1.16667 sa=1.4e-07 sb=3.7e-07 sd=160n sca=10.4914 \
        scb=0.00978575 scc=0.000300434 m=(1)
mn21 (\1\:Q \4\:Qbint \1\:VSS VSS) g45n1svt w=(1.45e-07) l=4.5e-08 nf=1 \
        as=2.32e-14 ad=2.393e-14 ps=6.1e-07 pd=6.2e-07 nrd=1.16667 \
        nrs=1.16667 sa=3.45e-07 sb=1.65e-07 sd=160n sca=10.4914 \
        scb=0.00978575 scc=0.000300434 m=(1)
ends TLATNXL
// End of subcircuit definition.
