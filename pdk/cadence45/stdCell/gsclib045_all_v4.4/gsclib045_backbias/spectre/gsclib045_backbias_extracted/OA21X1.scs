// Generated for: spectre (May  1 11:31:09 2013 )
// Library name: gsclib045_backbias
// Cell name: OA21X1
// View name: extracted

simulator lang=spectre

subckt OA21X1 A0 A1 B0 NW VDD VSS Y
mp0 (net98 \1\:A0 \3\:VDD NW) g45p1svt w=(2.15e-07) l=4.5e-08 nf=1 \
        as=3.01e-14 ad=3.225e-14 ps=7.1e-07 pd=7.3e-07 nrd=1.16667 \
        nrs=1.16667 sa=1.4e-07 sb=7.85e-07 sd=160n sca=26.8266 \
        scb=0.0313637 scc=0.00190754 m=(1)
mp1 (\8\:net95 \1\:A1 net98 NW) g45p1svt w=(2.15e-07) l=4.5e-08 nf=1 \
        as=3.225e-14 ad=3.655e-14 ps=7.3e-07 pd=7.7e-07 nrd=1.16667 \
        nrs=1.16667 sa=3.35e-07 sb=5.9e-07 sd=160n sca=17.3843 \
        scb=0.0171664 scc=0.000551089 m=(1)
mp2 (\8\:net95 \1\:B0 \1\:VDD NW) g45p1svt w=(2.15e-07) l=4.5e-08 nf=1 \
        as=6.535e-14 ad=3.655e-14 ps=1.16e-06 pd=7.7e-07 nrd=1.16667 \
        nrs=1.16667 sa=5.5e-07 sb=3.75e-07 sd=160n sca=15.8515 \
        scb=0.0140891 scc=0.000503754 m=(1)
C1 (B0 VSS) capacitor c=4.14344e-17
C2 (NW VSS) capacitor c=2.08249e-16
C3 (A1 VSS) capacitor c=4.76027e-17
C4 (VDD VSS) capacitor c=7.40812e-17
C5 (Y VSS) capacitor c=1.2388e-17
C6 (net107 VSS) capacitor c=6.21057e-17
C7 (net95 VSS) capacitor c=3.96918e-17
C8 (net98 VSS) capacitor c=9.00465e-18
C9 (\4\:net95 VSS) capacitor c=4.78575e-17
C10 (\1\:B0 VSS) capacitor c=6.17557e-17
C11 (\1\:A1 VSS) capacitor c=3.99424e-17
C12 (\1\:A0 VSS) capacitor c=5.19338e-17
C13 (\3\:B0 VSS) capacitor c=2.82163e-17
C14 (\3\:A1 VSS) capacitor c=5.37297e-17
C15 (\4\:A0 VSS) capacitor c=3.12319e-17
C16 (\3\:net95 VSS) capacitor c=2.50643e-17
C17 (\2\:B0 VSS) capacitor c=5.14565e-17
C18 (\2\:A1 VSS) capacitor c=5.65716e-17
C19 (\3\:A0 VSS) capacitor c=1.47093e-17
C20 (\1\:Y VSS) capacitor c=7.16783e-17
C21 (\1\:VDD VSS) capacitor c=1.47049e-16
C22 (\8\:net95 VSS) capacitor c=6.17428e-17
C23 (\3\:VDD VSS) capacitor c=2.56199e-17
C24 (\3\:Y VSS) capacitor c=4.79845e-17
C25 (\5\:net95 VSS) capacitor c=5.66069e-17
C26 (\3\:net107 VSS) capacitor c=4.23115e-17
C27 (\2\:A0 VSS) capacitor c=3.2166e-17
C28 (\2\:net95 VSS) capacitor c=1.91589e-17
C29 (\5\:A0 VSS) capacitor c=3.93199e-17
C30 (\7\:A0 VSS) capacitor c=3.76014e-17
C31 (\4\:A1 VSS) capacitor c=3.20939e-17
C32 (\6\:B0 VSS) capacitor c=4.58861e-17
C33 (\7\:net95 VSS) capacitor c=7.35291e-17
Rk6 (\4\:B0 B0) resistor r=0.006735 c=0
Rk8 (\4\:B0 \6\:B0) resistor r=0.02172 c=0
Rk7 (\5\:B0 \6\:B0) resistor r=0.006735 c=0
Rk4 (\4\:A1 A1) resistor r=0.1016 c=0
Rk17 (\2\:VDD VDD) resistor r=0.6189 c=0
Rk18 (VDD \4\:VDD) resistor r=0.3148 c=0
Rk1 (\5\:A0 \6\:A0) resistor r=0.002221 c=0
Rk2 (A0 \7\:A0) resistor r=0.002132 c=0
Rk3 (\5\:A0 \7\:A0) resistor r=0.1329 c=0
Rk12 (\4\:Y Y) resistor r=0.03658 c=0
Rk11 (\2\:Y \4\:Y) resistor r=0.5453 c=0
Rk13 (\2\:VSS \4\:VSS) resistor r=0.2569 c=0
Rk15 (\5\:VSS VSS) resistor r=0.1173 c=0
Rk14 (\4\:VSS \5\:VSS) resistor r=0.1326 c=0
Rk16 (\5\:VSS \7\:VSS) resistor r=0.07346 c=0
Rk5 (\2\:net107 \4\:net107) resistor r=0.2251 c=0
Rk9 (\6\:net95 \7\:net95) resistor r=0.2976 c=0
Rk10 (\7\:net95 \9\:net95) resistor r=0.3018 c=0
Rl6 (\1\:B0 \2\:B0) resistor r=153.021 c=0
Rl7 (\2\:B0 \3\:B0) resistor r=26.098 c=0
Rl4 (\1\:A1 \2\:A1) resistor r=62.6365 c=0
Rl5 (\2\:A1 \3\:A1) resistor r=116.483 c=0
Rl1 (\1\:A0 \2\:A0) resistor r=167.022 c=0
Rl3 (\2\:A0 \4\:A0) resistor r=36.2526 c=0
Rl2 (\2\:A0 \3\:A0) resistor r=4.3144 c=0
Rl10 (\2\:net95 \4\:net95) resistor r=57.4064 c=0
Rl8 (net95 \2\:net95) resistor r=122.357 c=0
Rl9 (\2\:net95 \3\:net95) resistor r=4.3144 c=0
Rz4 (\3\:Y \4\:Y) resistor r=37.5 c=0
Rz5 (\1\:VSS \2\:VSS) resistor r=75 c=0
Rz6 (\6\:VSS \7\:VSS) resistor r=75 c=0
Rz1 (net107 \2\:net107) resistor r=75 c=0
Rz2 (\3\:net107 \4\:net107) resistor r=75 c=0
Rz3 (\5\:net95 \6\:net95) resistor r=75 c=0
Ry4 (\1\:VDD \2\:VDD) resistor r=20.6667 c=0
Ry5 (\3\:VDD \4\:VDD) resistor r=62 c=0
Ry2 (\1\:Y \2\:Y) resistor r=20.6667 c=0
Ry1 (\8\:net95 \9\:net95) resistor r=62 c=0
Rx3 (\2\:B0 \5\:B0) resistor r=45 c=0
Rx2 (\2\:A1 \4\:A1) resistor r=45 c=0
Rx1 (\3\:A0 \6\:A0) resistor r=45 c=0
Rx4 (\3\:net95 \7\:net95) resistor r=45 c=0
mn0 (\3\:net107 \4\:A0 \6\:VSS VSS) g45n1svt w=(1.45e-07) l=4.5e-08 nf=1 \
        as=4.465e-14 ad=2.03e-14 ps=1.31e-06 pd=5.7e-07 nrd=1.16667 \
        nrs=1.16667 sa=1.4e-07 sb=5.5e-07 sd=160n sca=10.0732 \
        scb=0.00911402 scc=0.000253284 m=(1)
mn1 (net107 \3\:A1 \6\:VSS VSS) g45n1svt w=(1.45e-07) l=4.5e-08 nf=1 \
        as=4.465e-14 ad=2.465e-14 ps=1.31e-06 pd=6.3e-07 nrd=1.16667 \
        nrs=1.16667 sa=3.35e-07 sb=3.55e-07 sd=160n sca=10.0732 \
        scb=0.00911402 scc=0.000253284 m=(1)
mn2 (\5\:net95 \3\:B0 net107 VSS) g45n1svt w=(1.45e-07) l=4.5e-08 nf=1 \
        as=2.465e-14 ad=2.03e-14 ps=6.3e-07 pd=5.7e-07 nrd=1.16667 \
        nrs=1.16667 sa=5.5e-07 sb=1.4e-07 sd=160n sca=10.0732 \
        scb=0.00911402 scc=0.000253284 m=(1)
mn3 (\3\:Y net95 \1\:VSS VSS) g45n1svt w=(2.6e-07) l=4.5e-08 nf=1 \
        as=5.67e-14 ad=3.64e-14 ps=1.5e-06 pd=8e-07 nrd=1.16667 \
        nrs=1.16667 sa=1e-07 sb=1.4e-07 sd=160n sca=17.5885 scb=0.0172826 \
        scc=0.00162584 m=(1)
mp3 (\1\:Y \4\:net95 \1\:VDD NW) g45p1svt w=(3.9e-07) l=4.5e-08 nf=1 \
        as=6.535e-14 ad=5.46e-14 ps=1.16e-06 pd=1.06e-06 nrd=1.16667 \
        nrs=1.16667 sa=4.95577e-07 sb=1.4e-07 sd=160n sca=17.0231 \
        scb=0.0168642 scc=0.000422034 m=(1)
ends OA21X1
// End of subcircuit definition.
