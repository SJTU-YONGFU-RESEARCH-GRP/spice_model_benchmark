// Generated for: spectre (May  1 11:30:34 2013 )
// Library name: gsclib045_backbias
// Cell name: NAND4BXL
// View name: extracted

simulator lang=spectre

subckt NAND4BXL AN B C D NW VDD VSS Y
mp4 (\4\:Y \3\:D \7\:VDD NW) g45p1svt w=(2.15e-07) l=4.5e-08 nf=1 \
        as=3.01e-14 ad=3.44e-14 ps=7.1e-07 pd=7.5e-07 nrd=1.16667 \
        nrs=1.16667 sa=1.4e-07 sb=1.035e-06 sd=160n sca=18.0123 \
        scb=0.019139 scc=0.000475418 m=(1)
mp3 (\4\:Y \1\:C \5\:VDD NW) g45p1svt w=(2.15e-07) l=4.5e-08 nf=1 \
        as=5.515e-14 ad=3.44e-14 ps=1.45e-06 pd=7.5e-07 nrd=1.16667 \
        nrs=1.16667 sa=3.45e-07 sb=8.3e-07 sd=160n sca=13.4568 \
        scb=0.0111557 scc=0.000195491 m=(1)
mp2 (\1\:Y \1\:B \5\:VDD NW) g45p1svt w=(2.15e-07) l=4.5e-08 nf=1 \
        as=5.515e-14 ad=3.44e-14 ps=1.45e-06 pd=7.5e-07 nrd=1.16667 \
        nrs=1.16667 sa=5.4e-07 sb=6.35e-07 sd=160n sca=12.6657 \
        scb=0.00981458 scc=0.000188357 m=(1)
mp1 (\1\:Y net118 \1\:VDD NW) g45p1svt w=(2.15e-07) l=4.5e-08 nf=1 \
        as=8.21e-14 ad=3.44e-14 ps=1.45e-06 pd=7.5e-07 nrd=1.16667 \
        nrs=1.16667 sa=7.45e-07 sb=4.3e-07 sd=160n sca=13.5027 \
        scb=0.0112382 scc=0.000196207 m=(1)
mp0 (\4\:net118 \1\:AN \1\:VDD NW) g45p1svt w=(2.15e-07) l=4.5e-08 nf=1 \
        as=8.21e-14 ad=3.548e-14 ps=1.45e-06 pd=7.6e-07 nrd=1.16667 \
        nrs=1.16667 sa=1.01e-06 sb=1.65e-07 sd=160n sca=21.9147 \
        scb=0.024825 scc=0.00104914 m=(1)
C1 (NW VSS) capacitor c=2.46043e-16
C2 (B VSS) capacitor c=3.09207e-17
C3 (VDD VSS) capacitor c=2.71235e-17
C4 (C VSS) capacitor c=1.23095e-16
C5 (D VSS) capacitor c=7.57814e-17
C6 (AN VSS) capacitor c=9.18193e-17
C7 (Y VSS) capacitor c=7.01679e-17
C8 (net130 VSS) capacitor c=9.49579e-19
C9 (net126 VSS) capacitor c=5.24897e-19
C10 (net122 VSS) capacitor c=4.42068e-19
C11 (net118 VSS) capacitor c=6.8077e-17
C12 (\1\:AN VSS) capacitor c=3.96037e-17
C13 (\1\:B VSS) capacitor c=7.65503e-17
C14 (\1\:C VSS) capacitor c=6.35828e-17
C15 (\3\:D VSS) capacitor c=5.25861e-17
C16 (\3\:AN VSS) capacitor c=5.09076e-17
C17 (\3\:net118 VSS) capacitor c=2.94712e-17
C18 (\3\:B VSS) capacitor c=3.15778e-17
C19 (\3\:C VSS) capacitor c=5.01541e-17
C20 (\1\:D VSS) capacitor c=3.40705e-17
C21 (\2\:AN VSS) capacitor c=4.99928e-17
C22 (\2\:net118 VSS) capacitor c=6.43813e-17
C23 (\2\:B VSS) capacitor c=6.71778e-17
C24 (\2\:C VSS) capacitor c=6.44475e-17
C25 (\2\:D VSS) capacitor c=5.49287e-17
C26 (\4\:net118 VSS) capacitor c=5.43156e-17
C27 (\1\:VDD VSS) capacitor c=7.76239e-17
C28 (\1\:Y VSS) capacitor c=2.98359e-17
C29 (\5\:VDD VSS) capacitor c=9.23787e-18
C30 (\4\:Y VSS) capacitor c=8.27347e-18
C31 (\7\:VDD VSS) capacitor c=3.25559e-17
C32 (\8\:net118 VSS) capacitor c=3.23143e-17
C33 (\6\:Y VSS) capacitor c=4.36987e-17
C34 (\4\:D VSS) capacitor c=4.27124e-17
C35 (\4\:B VSS) capacitor c=7.49227e-17
C36 (\3\:Y VSS) capacitor c=1.02043e-16
C37 (\6\:net118 VSS) capacitor c=5.00385e-17
C38 (\7\:net118 VSS) capacitor c=4.10944e-17
C39 (\3\:VDD VSS) capacitor c=3.81816e-17
C40 (\4\:VDD VSS) capacitor c=2.48739e-17
Rk18 (\4\:VSS VSS) resistor r=0.3004 c=0
Rk17 (\2\:VSS \4\:VSS) resistor r=0.329 c=0
Rk3 (B \4\:B) resistor r=0.1018 c=0
Rk12 (\2\:VDD \3\:VDD) resistor r=0.3096 c=0
Rk14 (\4\:VDD VDD) resistor r=0.04716 c=0
Rk13 (\3\:VDD \4\:VDD) resistor r=0.185 c=0
Rk15 (\3\:VDD \6\:VDD) resistor r=0.07334 c=0
Rk16 (\4\:VDD \8\:VDD) resistor r=0.2658 c=0
Rk2 (C \4\:C) resistor r=0.003963 c=0
Rk1 (D \4\:D) resistor r=0.08679 c=0
Rk8 (AN \4\:AN) resistor r=0.01485 c=0
Rk5 (\3\:Y Y) resistor r=0.661 c=0
Rk4 (\2\:Y \3\:Y) resistor r=0.351 c=0
Rk6 (\3\:Y \5\:Y) resistor r=0.03284 c=0
Rk7 (Y \7\:Y) resistor r=0.1702 c=0
Rk9 (\5\:net118 \6\:net118) resistor r=0.4822 c=0
Rk10 (\6\:net118 \7\:net118) resistor r=0.2454 c=0
Rk11 (\6\:net118 \9\:net118) resistor r=0.1824 c=0
Rl5 (\1\:B \2\:B) resistor r=226.098 c=0
Rl6 (\2\:B \3\:B) resistor r=26.098 c=0
Rl3 (\1\:C \2\:C) resistor r=166.076 c=0
Rl4 (\2\:C \3\:C) resistor r=92.9995 c=0
Rl2 (\2\:D \3\:D) resistor r=220.212 c=0
Rl1 (\1\:D \2\:D) resistor r=40.3846 c=0
Rl9 (\1\:AN \2\:AN) resistor r=100 c=0
Rl10 (\2\:AN \3\:AN) resistor r=160.989 c=0
Rl7 (net118 \2\:net118) resistor r=216.483 c=0
Rl8 (\2\:net118 \3\:net118) resistor r=35.7134 c=0
Rz3 (\1\:VSS \2\:VSS) resistor r=75 c=0
Rz1 (\6\:Y \7\:Y) resistor r=75 c=0
Rz2 (\8\:net118 \9\:net118) resistor r=75 c=0
Ry4 (\1\:VDD \2\:VDD) resistor r=62 c=0
Ry5 (\5\:VDD \6\:VDD) resistor r=62 c=0
Ry6 (\7\:VDD \8\:VDD) resistor r=62 c=0
Ry1 (\1\:Y \2\:Y) resistor r=62 c=0
Ry2 (\4\:Y \5\:Y) resistor r=62 c=0
Ry3 (\4\:net118 \5\:net118) resistor r=62 c=0
Rx3 (\2\:B \4\:B) resistor r=45 c=0
Rx2 (\2\:C \4\:C) resistor r=45 c=0
Rx1 (\2\:D \4\:D) resistor r=45 c=0
Rx4 (\2\:AN \4\:AN) resistor r=45 c=0
Rx5 (\2\:net118 \7\:net118) resistor r=45 c=0
mn4 (\6\:Y \1\:D net130 VSS) g45n1svt w=(1.45e-07) l=4.5e-08 nf=1 \
        as=1.595e-14 ad=2.03e-14 ps=5.1e-07 pd=5.7e-07 nrd=1.16667 \
        nrs=1.16667 sa=1.4e-07 sb=8.85e-07 sd=160n sca=6.75077 \
        scb=0.00344229 scc=2.58723e-05 m=(1)
mn3 (net130 \3\:C net126 VSS) g45n1svt w=(1.45e-07) l=4.5e-08 nf=1 \
        as=1.667e-14 ad=1.595e-14 ps=5.2e-07 pd=5.1e-07 nrd=1.16667 \
        nrs=1.16667 sa=2.95e-07 sb=7.3e-07 sd=160n sca=6.75077 \
        scb=0.00344229 scc=2.58723e-05 m=(1)
mn2 (net126 \3\:B net122 VSS) g45n1svt w=(1.45e-07) l=4.5e-08 nf=1 \
        as=2.61e-14 ad=1.668e-14 ps=6.5e-07 pd=5.2e-07 nrd=1.16667 \
        nrs=1.16667 sa=4.55e-07 sb=5.7e-07 sd=160n sca=6.75077 \
        scb=0.00344229 scc=2.58723e-05 m=(1)
mn1 (net122 \3\:net118 \1\:VSS VSS) g45n1svt w=(1.45e-07) l=4.5e-08 nf=1 \
        as=2.32e-14 ad=2.61e-14 ps=6.1e-07 pd=6.5e-07 nrd=1.16667 \
        nrs=1.16667 sa=6.8e-07 sb=3.45e-07 sd=160n sca=6.75077 \
        scb=0.00344229 scc=2.58723e-05 m=(1)
mn0 (\8\:net118 \3\:AN \1\:VSS VSS) g45n1svt w=(1.45e-07) l=4.5e-08 nf=1 \
        as=2.32e-14 ad=2.03e-14 ps=6.1e-07 pd=5.7e-07 nrd=1.16667 \
        nrs=1.16667 sa=8.85e-07 sb=1.4e-07 sd=160n sca=6.75077 \
        scb=0.00344229 scc=2.58723e-05 m=(1)
ends NAND4BXL
// End of subcircuit definition.
