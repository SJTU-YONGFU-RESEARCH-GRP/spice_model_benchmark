// Generated for: spectre (May  1 11:30:34 2013 )
// Library name: gsclib045_backbias
// Cell name: NAND4BX4
// View name: extracted

simulator lang=spectre

subckt NAND4BX4 AN B C D NW VDD VSS Y
mp0 (\20\:net118 \1\:AN \11\:VDD NW) g45p1svt w=(3.9e-07) l=4.5e-08 nf=1 \
        as=5.46e-14 ad=5.46e-14 ps=1.06e-06 pd=1.06e-06 nrd=1.16667 \
        nrs=1.16667 sa=1.4e-07 sb=1.4e-07 sd=160n sca=43.6185 \
        scb=0.0386349 scc=0.00465805 m=(1)
mp4_1__rcx (\23\:Y \1\:D \1\:VDD NW) g45p1svt w=(3.9e-07) l=4.5e-08 nf=1 \
        as=7.459e-14 ad=6.24e-14 ps=1.1625e-06 pd=1.1e-06 nrd=1.16667 \
        nrs=1.16667 sa=2e-06 sb=7.55e-07 sd=160n sca=17.2385 scb=0.0152696 \
        scc=0.00137893 m=(4)
mp3 (\17\:Y C \1\:VDD NW) g45p1svt w=(3.9e-07) l=4.5e-08 nf=1 \
        as=7.654e-14 ad=6.24e-14 ps=1.1725e-06 pd=1.1e-06 nrd=1.16667 \
        nrs=1.16667 sa=1.795e-06 sb=1.72e-06 sd=160n sca=17.2385 \
        scb=0.0152696 scc=0.00137893 m=(4)
mp2 (Y \1\:B \1\:VDD NW) g45p1svt w=(3.9e-07) l=4.5e-08 nf=1 \
        as=6.386e-14 ad=6.24e-14 ps=1.1075e-06 pd=1.1e-06 nrd=1.16667 \
        nrs=1.16667 sa=9.75e-07 sb=2e-06 sd=160n sca=17.2385 scb=0.0152696 \
        scc=0.00137893 m=(4)
mp1 (\6\:Y net118 \1\:VDD NW) g45p1svt w=(3.9e-07) l=4.5e-08 nf=1 \
        as=6.191e-14 ad=6.24e-14 ps=1.0975e-06 pd=1.1e-06 nrd=1.16667 \
        nrs=1.16667 sa=1.4e-07 sb=2e-06 sd=160n sca=18.4951 scb=0.0160444 \
        scc=0.00137992 m=(4)
C1 (NW VSS) capacitor c=5.09898e-16
C2 (Y VSS) capacitor c=1.40387e-16
C3 (C VSS) capacitor c=5.42779e-16
C4 (VDD VSS) capacitor c=4.91735e-17
C5 (B VSS) capacitor c=9.66178e-17
C6 (AN VSS) capacitor c=2.02132e-17
C7 (D VSS) capacitor c=5.82619e-17
C8 (net118 VSS) capacitor c=3.3698e-16
C9 (net122 VSS) capacitor c=3.87046e-16
C10 (net126 VSS) capacitor c=2.35839e-16
C11 (net130 VSS) capacitor c=4.16595e-16
C12 (\1\:D VSS) capacitor c=3.10557e-16
C13 (\1\:B VSS) capacitor c=3.02249e-16
C14 (\1\:AN VSS) capacitor c=3.17949e-17
C15 (\4\:AN VSS) capacitor c=2.95472e-17
C16 (\3\:AN VSS) capacitor c=1.05263e-17
C17 (\1\:VDD VSS) capacitor c=8.46572e-16
C18 (\20\:net118 VSS) capacitor c=8.3097e-17
C19 (\11\:VDD VSS) capacitor c=3.90356e-17
C20 (\1\:Y VSS) capacitor c=3.66617e-16
C21 (\5\:net126 VSS) capacitor c=2.06261e-16
C22 (\18\:net118 VSS) capacitor c=2.13766e-17
C23 (\2\:AN VSS) capacitor c=1.06902e-17
C24 (\5\:AN VSS) capacitor c=8.10096e-17
C25 (\17\:net118 VSS) capacitor c=5.38429e-17
C26 (\5\:Y VSS) capacitor c=2.59301e-16
C27 (\6\:Y VSS) capacitor c=1.56368e-16
C28 (\17\:Y VSS) capacitor c=1.82939e-16
C29 (\23\:Y VSS) capacitor c=1.98771e-16
Rk26 (\5\:Y Y) resistor r=0.02031 c=0
Rk23 (\1\:Y \5\:Y) resistor r=1.9032 c=0
Rk24 (\5\:Y \6\:Y) resistor r=0.2682 c=0
Rk32 (Y \17\:Y) resistor r=0.3091 c=0
Rk36 (\17\:Y \23\:Y) resistor r=0.4323 c=0
Rk64 (\2\:VSS \3\:VSS) resistor r=1.1038 c=0
Rk67 (\4\:VSS VSS) resistor r=0.3085 c=0
Rk65 (\3\:VSS \4\:VSS) resistor r=0.03743 c=0
Rk68 (VSS \7\:VSS) resistor r=0.2823 c=0
Rk54 (\1\:VDD VDD) resistor r=0.2056 c=0
Rk55 (VDD \12\:VDD) resistor r=0.3173 c=0
Rk6 (B \1\:B) resistor r=0.01834 c=0
Rk1 (\5\:AN AN) resistor r=0.01142 c=0
Rk20 (\1\:D D) resistor r=0.006306 c=0
Rk3 (net118 \17\:net118) resistor r=0.3292 c=0
Rk4 (\17\:net118 \19\:net118) resistor r=0.1043 c=0
Rk5 (\17\:net118 \21\:net118) resistor r=0.3004 c=0
Rk14 (net126 \5\:net126) resistor r=0.4888 c=0
Rl1 (\1\:AN \2\:AN) resistor r=57.4064 c=0
Rl3 (\2\:AN \4\:AN) resistor r=34.3295 c=0
Rl2 (\2\:AN \3\:AN) resistor r=1.2666 c=0
Rz18 (\7\:VSS \6\:VSS) resistor r=75 c=0
Rz1 (\19\:net118 \18\:net118) resistor r=75 c=0
Ry20 (\2\:VSS \1\:VSS) resistor r=6.2 c=0
Ry21 (\3\:VSS \1\:VSS) resistor r=5.1667 c=0
Ry11 (\12\:VDD \11\:VDD) resistor r=62 c=0
Ry1 (\21\:net118 \20\:net118) resistor r=20.6667 c=0
Rx1 (\3\:AN \5\:AN) resistor r=45 c=0
mn0 (\18\:net118 \4\:AN \6\:VSS VSS) g45n1svt w=(2.6e-07) l=4.5e-08 nf=1 \
        as=3.64e-14 ad=3.64e-14 ps=8e-07 pd=8e-07 nrd=1.16667 nrs=1.16667 \
        sa=1.4e-07 sb=1.4e-07 sd=160n sca=15.3338 scb=0.0153436 \
        scc=0.00119435 m=(1)
mn2_1__rcx (\5\:net126 \1\:B net122 VSS) g45n1svt w=(2.6e-07) l=4.5e-08 \
        nf=1 as=4.03e-14 ad=4.16e-14 ps=8.3e-07 pd=8.4e-07 nrd=1.16667 \
        nrs=1.16667 sa=9.6e-07 sb=7.55e-07 sd=160n sca=10.3222 \
        scb=0.00938145 scc=0.000353946 m=(4)
mn1 (net122 net118 \4\:VSS VSS) g45n1svt w=(2.6e-07) l=4.5e-08 nf=1 \
        as=4.16e-14 ad=4.03e-14 ps=8.4e-07 pd=8.3e-07 nrd=1.16667 \
        nrs=1.16667 sa=1.4e-07 sb=1.575e-06 sd=160n sca=10.3222 \
        scb=0.00938145 scc=0.000353946 m=(4)
mn3 (net130 C net126 VSS) g45n1svt w=(2.6e-07) l=4.5e-08 nf=1 as=4.16e-14 \
        ad=6.24e-14 ps=8.4e-07 pd=1e-06 nrd=1.16667 nrs=1.16667 sa=1.4e-07 \
        sb=1.77e-06 sd=160n sca=9.50447 scb=0.0081528 scc=0.00025289 m=(4)
mn4_1__rcx (\1\:Y \1\:D net130 VSS) g45n1svt w=(2.6e-07) l=4.5e-08 nf=1 \
        as=4.355e-14 ad=4.16e-14 ps=8.55e-07 pd=8.4e-07 nrd=1.16667 \
        nrs=1.16667 sa=1.13e-06 sb=7.8e-07 sd=160n sca=9.50447 \
        scb=0.0081528 scc=0.00025289 m=(4)
ends NAND4BX4
// End of subcircuit definition.
