// Generated for: spectre (May  1 11:28:32 2013 )
// Library name: gsclib045_backbias
// Cell name: CLKXOR2X1
// View name: extracted

simulator lang=spectre

subckt CLKXOR2X1 A B NW VDD VSS Y
mp5 (\1\:Y \4\:n0 \4\:VDD NW) g45p1svt w=(3.9e-07) l=4.5e-08 nf=1 \
        as=9.79e-14 ad=5.46e-14 ps=1.9e-06 pd=1.06e-06 nrd=1.16667 \
        nrs=1.16667 sa=1.4e-07 sb=7.03654e-07 sd=160n sca=44.1638 \
        scb=0.0392167 scc=0.00476734 m=(1)
C1 (A VSS) capacitor c=8.00352e-17
C2 (NW VSS) capacitor c=2.47159e-16
C3 (VDD VSS) capacitor c=3.50684e-17
C4 (Y VSS) capacitor c=4.65105e-17
C5 (B VSS) capacitor c=5.62197e-17
C6 (n0 VSS) capacitor c=2.29814e-17
C7 (n1 VSS) capacitor c=5.80448e-17
C8 (n2 VSS) capacitor c=5.50553e-17
C9 (net130 VSS) capacitor c=2.04336e-18
C10 (\7\:B VSS) capacitor c=3.79895e-17
C11 (\3\:n1 VSS) capacitor c=8.31239e-17
C12 (\2\:n2 VSS) capacitor c=8.60769e-17
C13 (\1\:B VSS) capacitor c=3.51366e-17
C14 (\1\:A VSS) capacitor c=4.37537e-17
C15 (\4\:n0 VSS) capacitor c=3.65769e-17
C16 (\5\:B VSS) capacitor c=4.27677e-17
C17 (\3\:B VSS) capacitor c=7.68548e-17
C18 (\3\:A VSS) capacitor c=4.29484e-17
C19 (\3\:n0 VSS) capacitor c=4.11985e-17
C20 (\6\:B VSS) capacitor c=5.54707e-17
C21 (\2\:n1 VSS) capacitor c=8.08194e-17
C22 (\4\:B VSS) capacitor c=7.41743e-17
C23 (\3\:n2 VSS) capacitor c=3.34936e-17
C24 (\2\:B VSS) capacitor c=4.08312e-17
C25 (\2\:A VSS) capacitor c=5.64589e-17
C26 (\4\:n2 VSS) capacitor c=1.29986e-17
C27 (\1\:VDD VSS) capacitor c=1.40806e-16
C28 (\8\:n0 VSS) capacitor c=1.22978e-16
C29 (\8\:n1 VSS) capacitor c=6.65199e-17
C30 (\4\:VDD VSS) capacitor c=2.75197e-17
C31 (\1\:Y VSS) capacitor c=7.93514e-17
C32 (\8\:n2 VSS) capacitor c=5.37854e-17
C33 (\5\:n0 VSS) capacitor c=1.2593e-16
C34 (\6\:n1 VSS) capacitor c=6.54697e-17
C35 (\3\:Y VSS) capacitor c=2.57457e-17
C36 (\2\:n0 VSS) capacitor c=1.92799e-17
C37 (\4\:A VSS) capacitor c=4.53432e-17
C38 (\7\:n0 VSS) capacitor c=2.38338e-16
C39 (\4\:n1 VSS) capacitor c=5.83893e-17
C40 (\5\:n1 VSS) capacitor c=1.27502e-16
C41 (\8\:B VSS) capacitor c=3.74039e-17
C42 (\9\:B VSS) capacitor c=4.42946e-17
C43 (\10\:B VSS) capacitor c=6.72349e-17
C44 (\6\:n2 VSS) capacitor c=1.1546e-16
C45 (\7\:n2 VSS) capacitor c=7.92795e-17
C46 (\3\:VDD VSS) capacitor c=7.75223e-17
Rk3 (A \4\:A) resistor r=0.111 c=0
Rk15 (\2\:VSS \4\:VSS) resistor r=0.4317 c=0
Rk17 (\5\:VSS VSS) resistor r=0.1025 c=0
Rk16 (\4\:VSS \5\:VSS) resistor r=0.2483 c=0
Rk18 (\5\:VSS \7\:VSS) resistor r=0.2349 c=0
Rk20 (\3\:VDD VDD) resistor r=0.1166 c=0
Rk19 (\2\:VDD \3\:VDD) resistor r=0.7296 c=0
Rk21 (\3\:VDD \5\:VDD) resistor r=0.06846 c=0
Rk1 (\2\:Y Y) resistor r=0.4562 c=0
Rk2 (Y \4\:Y) resistor r=0.04518 c=0
Rk9 (\8\:B B) resistor r=0.1323 c=0
Rk10 (B \9\:B) resistor r=0.08217 c=0
Rk11 (\9\:B \10\:B) resistor r=0.2616 c=0
Rk4 (\6\:n0 \7\:n0) resistor r=0.9732 c=0
Rk5 (\7\:n0 \9\:n0) resistor r=0.8284 c=0
Rk6 (\4\:n1 \5\:n1) resistor r=0.3091 c=0
Rk7 (\5\:n1 \7\:n1) resistor r=0.2829 c=0
Rk8 (\5\:n1 \9\:n1) resistor r=0.4309 c=0
Rk12 (\5\:n2 \6\:n2) resistor r=0.03827 c=0
Rk13 (\6\:n2 \7\:n2) resistor r=0.5822 c=0
Rk14 (\6\:n2 \9\:n2) resistor r=0.5296 c=0
Rl4 (\1\:A \2\:A) resistor r=96.8456 c=0
Rl5 (\2\:A \3\:A) resistor r=110.307 c=0
Rl13 (\6\:B \7\:B) resistor r=76.2049 c=0
Rl12 (\5\:B \6\:B) resistor r=126.718 c=0
Rl9 (\3\:B \4\:B) resistor r=130.002 c=0
Rl6 (\1\:B \2\:B) resistor r=24.2328 c=0
Rl3 (\2\:n0 \4\:n0) resistor r=43.1104 c=0
Rl2 (\2\:n0 \3\:n0) resistor r=87.3411 c=0
Rl1 (n0 \2\:n0) resistor r=1.2334 c=0
Rl11 (\2\:n1 \3\:n1) resistor r=140.679 c=0
Rl10 (n1 \2\:n1) resistor r=72.7035 c=0
Rl7 (n2 \2\:n2) resistor r=241.883 c=0
Rl8 (\2\:n2 \3\:n2) resistor r=24.2328 c=0
Rz5 (\1\:VSS \2\:VSS) resistor r=75 c=0
Rz6 (\6\:VSS \7\:VSS) resistor r=75 c=0
Rz1 (\3\:Y \4\:Y) resistor r=37.5 c=0
Rz2 (\5\:n0 \6\:n0) resistor r=75 c=0
Rz3 (\6\:n1 \7\:n1) resistor r=75 c=0
Rz4 (\8\:n2 \9\:n2) resistor r=75 c=0
Ry6 (\1\:VDD \2\:VDD) resistor r=62 c=0
Ry7 (\4\:VDD \5\:VDD) resistor r=62 c=0
Ry1 (\1\:Y \2\:Y) resistor r=20.6667 c=0
Ry2 (\8\:n0 \9\:n0) resistor r=62 c=0
Ry3 (\8\:n1 \9\:n1) resistor r=62 c=0
Ry4 (\4\:n2 \5\:n2) resistor r=62 c=0
Rx1 (\2\:A \4\:A) resistor r=45 c=0
Rx4 (\6\:B \8\:B) resistor r=45 c=0
Rx5 (\4\:B \9\:B) resistor r=45 c=0
Rx6 (\2\:B \10\:B) resistor r=45 c=0
Rx2 (n0 \7\:n0) resistor r=45 c=0
Rx3 (\2\:n1 \4\:n1) resistor r=45 c=0
Rx7 (\3\:n2 \7\:n2) resistor r=45 c=0
mn5 (\3\:Y \3\:n0 \6\:VSS VSS) g45n1svt w=(2.6e-07) l=4.5e-08 nf=1 \
        as=4.25e-14 ad=3.64e-14 ps=9.2e-07 pd=8e-07 nrd=1.16667 \
        nrs=1.16667 sa=1.4e-07 sb=7.29519e-07 sd=160n sca=9.14564 \
        scb=0.00759168 scc=0.000213449 m=(1)
mn0 (\6\:n1 \3\:A \6\:VSS VSS) g45n1svt w=(1.45e-07) l=4.5e-08 nf=1 \
        as=4.25e-14 ad=3.915e-14 ps=9.2e-07 pd=8.3e-07 nrd=1.16667 \
        nrs=1.16667 sa=3.85e-07 sb=9.7e-07 sd=160n sca=8.55924 \
        scb=0.0065649 scc=0.000116351 m=(1)
mn4 (\5\:n0 n2 \6\:n1 VSS) g45n1svt w=(1.45e-07) l=4.5e-08 nf=1 \
        as=3.915e-14 ad=2.32e-14 ps=8.3e-07 pd=6.1e-07 nrd=1.16667 \
        nrs=1.16667 sa=7e-07 sb=6.55e-07 sd=160n sca=8.55924 scb=0.0065649 \
        scc=0.000116351 m=(1)
mn3 (\5\:n0 \3\:B net139 VSS) g45n1svt w=(1.45e-07) l=4.5e-08 nf=1 \
        as=8.7e-15 ad=2.32e-14 ps=4.1e-07 pd=6.1e-07 nrd=1.16667 \
        nrs=1.16667 sa=9.05e-07 sb=4.5e-07 sd=160n sca=8.55924 \
        scb=0.0065649 scc=0.000116351 m=(1)
mn2 (net139 n1 \1\:VSS VSS) g45n1svt w=(1.45e-07) l=4.5e-08 nf=1 \
        as=2.32e-14 ad=8.7e-15 ps=6.1e-07 pd=4.1e-07 nrd=1.16667 \
        nrs=1.16667 sa=1.01e-06 sb=3.45e-07 sd=160n sca=8.55924 \
        scb=0.0065649 scc=0.000116351 m=(1)
mn1 (\8\:n2 \5\:B \1\:VSS VSS) g45n1svt w=(1.45e-07) l=4.5e-08 nf=1 \
        as=2.32e-14 ad=2.03e-14 ps=6.1e-07 pd=5.7e-07 nrd=1.16667 \
        nrs=1.16667 sa=1.215e-06 sb=1.4e-07 sd=160n sca=8.55924 \
        scb=0.0065649 scc=0.000116351 m=(1)
mp0 (\8\:n1 \1\:A \4\:VDD NW) g45p1svt w=(2.15e-07) l=4.5e-08 nf=1 \
        as=9.79e-14 ad=3.44e-14 ps=1.9e-06 pd=7.5e-07 nrd=1.16667 \
        nrs=1.16667 sa=3.85e-07 sb=9.5e-07 sd=160n sca=15.6438 \
        scb=0.0148425 scc=0.000445561 m=(1)
mp4 (\8\:n0 \1\:B \8\:n1 NW) g45p1svt w=(2.15e-07) l=4.5e-08 nf=1 \
        as=3.44e-14 ad=3.762e-14 ps=7.5e-07 pd=7.8e-07 nrd=1.16667 \
        nrs=1.16667 sa=5.9e-07 sb=7.45e-07 sd=160n sca=13.754 \
        scb=0.0122361 scc=0.000425664 m=(1)
mp3 (\8\:n0 \2\:n2 net130 NW) g45p1svt w=(2.15e-07) l=4.5e-08 nf=1 \
        as=2.903e-14 ad=3.762e-14 ps=7e-07 pd=7.8e-07 nrd=1.16667 \
        nrs=1.16667 sa=8.1e-07 sb=5.25e-07 sd=160n sca=13.561 \
        scb=0.0120014 scc=0.000425312 m=(1)
mp2 (net130 \3\:n1 \1\:VDD NW) g45p1svt w=(2.15e-07) l=4.5e-08 nf=1 \
        as=3.44e-14 ad=2.903e-14 ps=7.5e-07 pd=7e-07 nrd=1.16667 \
        nrs=1.16667 sa=9.9e-07 sb=3.45e-07 sd=160n sca=14.4668 \
        scb=0.0130588 scc=0.000428492 m=(1)
mp1 (\4\:n2 \7\:B \1\:VDD NW) g45p1svt w=(2.15e-07) l=4.5e-08 nf=1 \
        as=3.44e-14 ad=3.01e-14 ps=7.5e-07 pd=7.1e-07 nrd=1.16667 \
        nrs=1.16667 sa=1.195e-06 sb=1.4e-07 sd=160n sca=17.9454 \
        scb=0.0188744 scc=0.000556907 m=(1)
ends CLKXOR2X1
// End of subcircuit definition.
