// Generated for: spectre (May  1 11:32:45 2013 )
// Library name: gsclib045_backbias
// Cell name: SDFFX2
// View name: extracted

simulator lang=spectre

subckt SDFFX2 CK D NW Q QN SE SI VDD VSS
mp10 (\10\:SEb \1\:SE \19\:VDD NW) g45p1svt w=(2.15e-07) l=4.5e-08 nf=1 \
        as=3.44e-14 ad=3.01e-14 ps=7.5e-07 pd=7.1e-07 nrd=1.16667 \
        nrs=1.16667 sa=1.4e-07 sb=1.39e-06 sd=160n sca=16.6694 \
        scb=0.0168672 scc=0.000344817 m=(1)
mp11 (net384 \1\:D \19\:VDD NW) g45p1svt w=(2.15e-07) l=4.5e-08 nf=1 \
        as=3.44e-14 ad=2.903e-14 ps=7.5e-07 pd=7e-07 nrd=1.16667 \
        nrs=1.16667 sa=3.45e-07 sb=1.185e-06 sd=160n sca=12.9619 \
        scb=0.0106134 scc=0.000191935 m=(1)
mp12 (\5\:Db \6\:SE net384 NW) g45p1svt w=(2.15e-07) l=4.5e-08 nf=1 \
        as=2.903e-14 ad=6.558e-14 ps=7e-07 pd=1.04e-06 nrd=1.16667 \
        nrs=1.16667 sa=5.25e-07 sb=1.005e-06 sd=160n sca=11.8125 \
        scb=0.00941499 scc=0.000188107 m=(1)
mp14 (\5\:Db \3\:SEb net392 NW) g45p1svt w=(2.15e-07) l=4.5e-08 nf=1 \
        as=1.29e-14 ad=6.558e-14 ps=5.5e-07 pd=1.04e-06 nrd=1.16667 \
        nrs=1.16667 sa=8.75e-07 sb=6.55e-07 sd=160n sca=11.1138 \
        scb=0.00912362 scc=0.000187967 m=(1)
mp13 (net392 \1\:SI \17\:VDD NW) g45p1svt w=(2.15e-07) l=4.5e-08 nf=1 \
        as=1.1327e-13 ad=1.29e-14 ps=1.74e-06 pd=5.5e-07 nrd=1.16667 \
        nrs=1.16667 sa=9.8e-07 sb=5.5e-07 sd=160n sca=11.1138 \
        scb=0.00912362 scc=0.000187967 m=(1)
mp21 (\18\:CKbb \7\:CKb \17\:VDD NW) g45p1svt w=(2.15e-07) l=4.5e-08 \
        nf=1 as=1.1327e-13 ad=3.01e-14 ps=1.74e-06 pd=7.1e-07 nrd=1.16667 \
        nrs=1.16667 sa=1.39e-06 sb=1.4e-07 sd=160n sca=11.1138 \
        scb=0.00912362 scc=0.000187967 m=(1)
mp25 (\9\:n20 CKbb \3\:Db NW) g45p1svt w=(2.15e-07) l=4.5e-08 nf=1 \
        as=3.01e-14 ad=3.44e-14 ps=7.1e-07 pd=7.5e-07 nrd=1.16667 \
        nrs=1.16667 sa=1.4e-07 sb=1.67e-06 sd=160n sca=14.5646 \
        scb=0.0142004 scc=0.000753562 m=(1)
mp36 (\9\:n20 \2\:CKb net356 NW) g45p1svt w=(2.15e-07) l=4.5e-08 nf=1 \
        as=1.29e-14 ad=3.44e-14 ps=5.5e-07 pd=7.5e-07 nrd=1.16667 \
        nrs=1.16667 sa=3.45e-07 sb=1.465e-06 sd=160n sca=14.5646 \
        scb=0.0142004 scc=0.000753562 m=(1)
mp35 (net356 mout \15\:VDD NW) g45p1svt w=(2.15e-07) l=4.5e-08 nf=1 \
        as=9.23e-14 ad=1.29e-14 ps=1.62e-06 pd=5.5e-07 nrd=1.16667 \
        nrs=1.16667 sa=4.5e-07 sb=1.36e-06 sd=160n sca=14.5646 \
        scb=0.0142004 scc=0.000753562 m=(1)
mp30 (\8\:mout n20 \15\:VDD NW) g45p1svt w=(2.15e-07) l=4.5e-08 nf=1 \
        as=9.23e-14 ad=5.805e-14 ps=1.62e-06 pd=9.7e-07 nrd=1.16667 \
        nrs=1.16667 sa=7.15e-07 sb=1.095e-06 sd=160n sca=14.5646 \
        scb=0.0142004 scc=0.000753562 m=(1)
mp40 (\7\:n30 \9\:CKb \8\:mout NW) g45p1svt w=(2.15e-07) l=4.5e-08 nf=1 \
        as=5.805e-14 ad=3.44e-14 ps=9.7e-07 pd=7.5e-07 nrd=1.16667 \
        nrs=1.16667 sa=1.03e-06 sb=7.8e-07 sd=160n sca=14.5646 \
        scb=0.0142004 scc=0.000753562 m=(1)
mp51 (\7\:n30 \7\:CKbb net376 NW) g45p1svt w=(2.15e-07) l=4.5e-08 nf=1 \
        as=2.687e-14 ad=3.44e-14 ps=6.8e-07 pd=7.5e-07 nrd=1.16667 \
        nrs=1.16667 sa=1.235e-06 sb=5.75e-07 sd=160n sca=14.5646 \
        scb=0.0142004 scc=0.000753562 m=(1)
mp50 (net376 \4\:qbint \13\:VDD NW) g45p1svt w=(2.15e-07) l=4.5e-08 nf=1 \
        as=9.705e-14 ad=2.687e-14 ps=1.62e-06 pd=6.8e-07 nrd=1.16667 \
        nrs=1.16667 sa=1.405e-06 sb=4.05e-07 sd=160n sca=14.5646 \
        scb=0.0142004 scc=0.000753562 m=(1)
mp20 (\13\:CKb \1\:CK \1\:VDD NW) g45p1svt w=(2.15e-07) l=4.5e-08 nf=1 \
        as=6.857e-14 ad=3.01e-14 ps=1.19e-06 pd=7.1e-07 nrd=1.16667 \
        nrs=1.16667 sa=1.4e-07 sb=1.265e-06 sd=160n sca=22.8495 \
        scb=0.0214046 scc=0.00242442 m=(1)
mp56 (\8\:net367 \14\:qbint \1\:VDD NW) g45p1svt w=(2.15e-07) l=4.5e-08 \
        nf=1 as=5.727e-14 ad=3.01e-14 ps=1.15e-06 pd=7.1e-07 nrd=1.16667 \
        nrs=1.16667 sa=1.265e-06 sb=1.4e-07 sd=160n sca=28.2418 \
        scb=0.0288633 scc=0.00256816 m=(1)
C1 (D VSS) capacitor c=5.06327e-17
C2 (CK VSS) capacitor c=6.51772e-17
C3 (NW VSS) capacitor c=7.49325e-16
C4 (SI VSS) capacitor c=3.82876e-17
C5 (QN VSS) capacitor c=2.50867e-17
C6 (VDD VSS) capacitor c=4.08748e-17
C7 (Q VSS) capacitor c=4.36319e-17
C8 (SE VSS) capacitor c=7.1095e-17
C9 (SEb VSS) capacitor c=6.4864e-17
C10 (net449 VSS) capacitor c=8.64555e-20
C11 (Db VSS) capacitor c=8.73008e-17
C12 (net461 VSS) capacitor c=1.52853e-18
C13 (CKbb VSS) capacitor c=3.81295e-17
C14 (CKb VSS) capacitor c=3.22442e-17
C15 (n20 VSS) capacitor c=5.03582e-17
C16 (mout VSS) capacitor c=6.08294e-17
C17 (n30 VSS) capacitor c=5.92325e-17
C18 (net436 VSS) capacitor c=1.34497e-18
C19 (qbint VSS) capacitor c=3.3061e-17
C20 (net367 VSS) capacitor c=1.72565e-16
C21 (net384 VSS) capacitor c=1.63206e-18
C22 (net392 VSS) capacitor c=1.24686e-18
C23 (net376 VSS) capacitor c=1.91844e-18
C24 (\14\:qbint VSS) capacitor c=5.95113e-17
C25 (\5\:qbint VSS) capacitor c=4.69637e-16
C26 (\1\:CK VSS) capacitor c=3.147e-17
C27 (\4\:qbint VSS) capacitor c=4.87606e-17
C28 (\7\:CKbb VSS) capacitor c=6.09076e-17
C29 (\9\:CKb VSS) capacitor c=6.58164e-17
C30 (\2\:CKb VSS) capacitor c=6.09503e-17
C31 (\7\:CKb VSS) capacitor c=4.54392e-17
C32 (\1\:SI VSS) capacitor c=6.55088e-17
C33 (\3\:SEb VSS) capacitor c=6.14788e-17
C34 (\6\:SE VSS) capacitor c=4.25288e-17
C35 (\1\:D VSS) capacitor c=3.51228e-17
C36 (\1\:SE VSS) capacitor c=3.95462e-17
C37 (\13\:qbint VSS) capacitor c=3.36692e-17
C38 (\3\:CK VSS) capacitor c=2.84447e-17
C39 (\4\:n30 VSS) capacitor c=3.31759e-17
C40 (\3\:qbint VSS) capacitor c=7.15843e-17
C41 (\8\:CKb VSS) capacitor c=7.87326e-17
C42 (\5\:CKbb VSS) capacitor c=3.55762e-17
C43 (\4\:n20 VSS) capacitor c=3.38161e-17
C44 (\3\:mout VSS) capacitor c=7.44818e-17
C45 (\3\:CKbb VSS) capacitor c=6.92319e-17
C46 (\6\:CKb VSS) capacitor c=3.26943e-17
C47 (\5\:CKb VSS) capacitor c=3.30225e-17
C48 (\3\:SI VSS) capacitor c=3.75096e-17
C49 (\4\:SE VSS) capacitor c=4.70367e-17
C50 (\3\:D VSS) capacitor c=7.60944e-17
C51 (\3\:SE VSS) capacitor c=3.57069e-17
C52 (\12\:qbint VSS) capacitor c=2.85867e-17
C53 (\6\:net367 VSS) capacitor c=2.38774e-17
C54 (\2\:CK VSS) capacitor c=3.38552e-17
C55 (\3\:n30 VSS) capacitor c=2.66129e-17
C56 (\8\:CKbb VSS) capacitor c=4.29369e-17
C57 (\10\:CKb VSS) capacitor c=2.45876e-17
C58 (\6\:CKbb VSS) capacitor c=3.37066e-17
C59 (\3\:n20 VSS) capacitor c=2.97148e-17
C60 (\2\:mout VSS) capacitor c=5.47316e-17
C61 (\4\:CKbb VSS) capacitor c=2.45232e-17
C62 (\2\:CKbb VSS) capacitor c=5.54039e-17
C63 (\2\:SI VSS) capacitor c=4.52639e-17
C64 (\4\:SEb VSS) capacitor c=3.61409e-17
C65 (\5\:SE VSS) capacitor c=6.23608e-17
C66 (\2\:SEb VSS) capacitor c=2.81077e-17
C67 (\2\:D VSS) capacitor c=6.19497e-17
C68 (\2\:SE VSS) capacitor c=3.72947e-17
C69 (\8\:net367 VSS) capacitor c=1.44769e-17
C70 (\1\:VDD VSS) capacitor c=4.13161e-16
C71 (\1\:QN VSS) capacitor c=9.5145e-17
C72 (\1\:Q VSS) capacitor c=9.1e-17
C73 (\13\:CKb VSS) capacitor c=1.31023e-16
C74 (\24\:qbint VSS) capacitor c=3.24979e-17
C75 (\13\:VDD VSS) capacitor c=2.38453e-17
C76 (\7\:n30 VSS) capacitor c=6.83591e-17
C77 (\8\:mout VSS) capacitor c=2.408e-17
C78 (\15\:VDD VSS) capacitor c=1.78645e-17
C79 (\9\:n20 VSS) capacitor c=4.11499e-17
C80 (\3\:Db VSS) capacitor c=1.68566e-16
C81 (\18\:CKbb VSS) capacitor c=1.03253e-16
C82 (\17\:VDD VSS) capacitor c=3.18708e-17
C83 (\5\:Db VSS) capacitor c=1.69624e-16
C84 (\19\:VDD VSS) capacitor c=4.05439e-17
C85 (\10\:SEb VSS) capacitor c=5.39404e-17
C86 (\12\:net367 VSS) capacitor c=2.60359e-17
C87 (\3\:QN VSS) capacitor c=2.72486e-17
C88 (\3\:Q VSS) capacitor c=3.24067e-17
C89 (\11\:CKb VSS) capacitor c=6.52974e-17
C90 (\18\:qbint VSS) capacitor c=8.51141e-17
C91 (\9\:n30 VSS) capacitor c=4.76289e-17
C92 (\6\:mout VSS) capacitor c=6.43574e-17
C93 (\7\:n20 VSS) capacitor c=3.84254e-17
C94 (\13\:CKbb VSS) capacitor c=1.01122e-16
C95 (\7\:Db VSS) capacitor c=8.80833e-17
C96 (\8\:SEb VSS) capacitor c=1.64562e-17
C97 (\3\:CKb VSS) capacitor c=8.69317e-17
C98 (\4\:CKb VSS) capacitor c=3.76935e-17
C99 (\2\:n20 VSS) capacitor c=2.58555e-17
C100 (\2\:qbint VSS) capacitor c=3.33521e-17
C101 (\2\:n30 VSS) capacitor c=2.67193e-17
C102 (\4\:D VSS) capacitor c=7.11369e-17
C103 (\7\:SE VSS) capacitor c=6.50433e-17
C104 (\5\:SEb VSS) capacitor c=1.25767e-16
C105 (\6\:SEb VSS) capacitor c=1.40764e-16
C106 (\7\:SEb VSS) capacitor c=1.20507e-16
C107 (\4\:SI VSS) capacitor c=6.93199e-17
C108 (\5\:n20 VSS) capacitor c=3.82786e-17
C109 (\6\:n20 VSS) capacitor c=5.09407e-17
C110 (\4\:mout VSS) capacitor c=3.44152e-17
C111 (\5\:mout VSS) capacitor c=5.28895e-17
C112 (\9\:CKbb VSS) capacitor c=2.32513e-17
C113 (\10\:CKbb VSS) capacitor c=1.1161e-16
C114 (\11\:CKbb VSS) capacitor c=8.13381e-17
C115 (\12\:CKbb VSS) capacitor c=6.76192e-17
C116 (\15\:CKbb VSS) capacitor c=4.99068e-17
C117 (\16\:CKbb VSS) capacitor c=2.55335e-17
C118 (\17\:CKbb VSS) capacitor c=7.27484e-17
C119 (\5\:n30 VSS) capacitor c=3.49756e-17
C120 (\6\:n30 VSS) capacitor c=6.07298e-17
C121 (\15\:CKb VSS) capacitor c=1.42419e-16
C122 (\16\:CKb VSS) capacitor c=6.43091e-17
C123 (\4\:CK VSS) capacitor c=5.72587e-17
C124 (\15\:qbint VSS) capacitor c=6.3117e-17
C125 (\22\:qbint VSS) capacitor c=3.23885e-17
C126 (\23\:qbint VSS) capacitor c=4.00392e-17
C127 (\10\:net367 VSS) capacitor c=2.01144e-17
C128 (\11\:net367 VSS) capacitor c=2.34912e-17
C129 (\5\:VDD VSS) capacitor c=9.50643e-17
C130 (\6\:VDD VSS) capacitor c=1.10953e-16
C131 (\7\:VDD VSS) capacitor c=1.02553e-16
C132 (\8\:VDD VSS) capacitor c=5.83091e-17
Rk1 (D \4\:D) resistor r=0.2261 c=0
Rk32 (CK \4\:CK) resistor r=0.07801 c=0
Rk8 (SI \4\:SI) resistor r=0.05294 c=0
Rk35 (\2\:QN QN) resistor r=0.3617 c=0
Rk36 (QN \4\:QN) resistor r=0.03697 c=0
Rk66 (\1\:VDD \5\:VDD) resistor r=0.466 c=0
Rk67 (\5\:VDD \6\:VDD) resistor r=0.4625 c=0
Rk68 (\6\:VDD \7\:VDD) resistor r=0.5779 c=0
Rk70 (\8\:VDD VDD) resistor r=0.1675 c=0
Rk69 (\7\:VDD \8\:VDD) resistor r=0.4209 c=0
Rk73 (\5\:VDD \14\:VDD) resistor r=0.1025 c=0
Rk74 (\6\:VDD \16\:VDD) resistor r=0.0433 c=0
Rk75 (\7\:VDD \18\:VDD) resistor r=0.1025 c=0
Rk76 (\8\:VDD \20\:VDD) resistor r=0.2673 c=0
Rk33 (\2\:Q Q) resistor r=0.3452 c=0
Rk34 (Q \4\:Q) resistor r=0.04101 c=0
Rk51 (\1\:VSS \7\:VSS) resistor r=0.3123 c=0
Rk52 (\7\:VSS \8\:VSS) resistor r=0.1377 c=0
Rk53 (\8\:VSS \9\:VSS) resistor r=0.45 c=0
Rk54 (\9\:VSS \10\:VSS) resistor r=0.5754 c=0
Rk55 (\10\:VSS \11\:VSS) resistor r=0.03742 c=0
Rk57 (\12\:VSS VSS) resistor r=0.1525 c=0
Rk56 (\11\:VSS \12\:VSS) resistor r=0.3985 c=0
Rk60 (\8\:VSS \18\:VSS) resistor r=0.3505 c=0
Rk61 (\9\:VSS \20\:VSS) resistor r=0.0433 c=0
Rk62 (\10\:VSS \22\:VSS) resistor r=0.3416 c=0
Rk63 (\12\:VSS \24\:VSS) resistor r=0.3499 c=0
Rk3 (\8\:SE SE) resistor r=0.002303 c=0
Rk2 (\7\:SE \8\:SE) resistor r=0.2281 c=0
Rk4 (\5\:SEb \6\:SEb) resistor r=0.8118 c=0
Rk5 (\6\:SEb \7\:SEb) resistor r=0.6592 c=0
Rk6 (\7\:SEb \9\:SEb) resistor r=0.07492 c=0
Rk7 (\7\:SEb \11\:SEb) resistor r=0.519 c=0
Rk9 (\2\:Db \4\:Db) resistor r=0.5195 c=0
Rk10 (\4\:Db \6\:Db) resistor r=0.9882 c=0
Rk11 (\6\:Db \8\:Db) resistor r=0.4497 c=0
Rk18 (\9\:CKbb \10\:CKbb) resistor r=0.01531 c=0
Rk19 (\10\:CKbb \11\:CKbb) resistor r=0.7662 c=0
Rk20 (\11\:CKbb \12\:CKbb) resistor r=0.2063 c=0
Rk21 (\12\:CKbb \14\:CKbb) resistor r=0.3626 c=0
Rk22 (\10\:CKbb \15\:CKbb) resistor r=0.2605 c=0
Rk23 (\11\:CKbb \16\:CKbb) resistor r=0.0805 c=0
Rk24 (\12\:CKbb \17\:CKbb) resistor r=0.3382 c=0
Rk25 (\14\:CKbb \19\:CKbb) resistor r=0.6092 c=0
Rk29 (\12\:CKb \14\:CKb) resistor r=0.4211 c=0
Rk30 (\14\:CKb \15\:CKb) resistor r=0.9213 c=0
Rk31 (\15\:CKb \16\:CKb) resistor r=0.5198 c=0
Rk12 (\5\:n20 \6\:n20) resistor r=0.2193 c=0
Rk13 (\6\:n20 \8\:n20) resistor r=0.09574 c=0
Rk14 (\6\:n20 \10\:n20) resistor r=0.2608 c=0
Rk15 (\4\:mout \5\:mout) resistor r=0.2074 c=0
Rk16 (\5\:mout \7\:mout) resistor r=0.2755 c=0
Rk17 (\5\:mout \9\:mout) resistor r=0.1424 c=0
Rk26 (\5\:n30 \6\:n30) resistor r=0.1422 c=0
Rk27 (\6\:n30 \8\:n30) resistor r=0.4313 c=0
Rk28 (\6\:n30 \10\:n30) resistor r=0.2305 c=0
Rk37 (\15\:qbint \5\:qbint) resistor r=0.4764 c=0
Rk39 (\5\:qbint \19\:qbint) resistor r=0.6089 c=0
Rk42 (\19\:qbint \22\:qbint) resistor r=0.2861 c=0
Rk43 (\22\:qbint \23\:qbint) resistor r=0.1273 c=0
Rk44 (\22\:qbint \25\:qbint) resistor r=0.1429 c=0
Rk45 (\9\:net367 \10\:net367) resistor r=0.09349 c=0
Rk46 (\10\:net367 \11\:net367) resistor r=0.1152 c=0
Rk47 (\10\:net367 \13\:net367) resistor r=0.156 c=0
Rl3 (\1\:D \2\:D) resistor r=24.2328 c=0
Rl4 (\2\:D \3\:D) resistor r=145.387 c=0
Rl34 (\1\:CK \2\:CK) resistor r=53.8462 c=0
Rl35 (\2\:CK \3\:CK) resistor r=39.5604 c=0
Rl9 (\1\:SI \2\:SI) resistor r=72.3097 c=0
Rl10 (\2\:SI \3\:SI) resistor r=97.3098 c=0
Rl7 (\5\:SE \6\:SE) resistor r=85.7713 c=0
Rl6 (\4\:SE \5\:SE) resistor r=153.4 c=0
Rl1 (\1\:SE \2\:SE) resistor r=83.3841 c=0
Rl2 (\2\:SE \3\:SE) resistor r=89.1533 c=0
Rl8 (\3\:SEb \4\:SEb) resistor r=45.3867 c=0
Rl5 (SEb \2\:SEb) resistor r=83.8482 c=0
Rl25 (\7\:CKbb \8\:CKbb) resistor r=31.461 c=0
Rl24 (\5\:CKbb \6\:CKbb) resistor r=31.461 c=0
Rl12 (\3\:CKbb \4\:CKbb) resistor r=93.4636 c=0
Rl11 (CKbb \2\:CKbb) resistor r=54.5677 c=0
Rl26 (\8\:CKb \9\:CKb) resistor r=222.208 c=0
Rl27 (\9\:CKb \10\:CKb) resistor r=24.2328 c=0
Rl13 (CKb \2\:CKb) resistor r=24.2328 c=0
Rl14 (\2\:CKb \3\:CKb) resistor r=170.697 c=0
Rl17 (\3\:CKb \6\:CKb) resistor r=30.4507 c=0
Rl18 (\4\:CKb \7\:CKb) resistor r=143.912 c=0
Rl16 (\4\:CKb \5\:CKb) resistor r=105.747 c=0
Rl15 (\3\:CKb \4\:CKb) resistor r=150.39 c=0
Rl21 (n20 \2\:n20) resistor r=113.25 c=0
Rl23 (\2\:n20 \4\:n20) resistor r=34.4036 c=0
Rl22 (\2\:n20 \3\:n20) resistor r=14.7297 c=0
Rl19 (mout \2\:mout) resistor r=24.2328 c=0
Rl20 (\2\:mout \3\:mout) resistor r=101.526 c=0
Rl31 (n30 \2\:n30) resistor r=113.493 c=0
Rl33 (\2\:n30 \4\:n30) resistor r=24.7024 c=0
Rl32 (\2\:n30 \3\:n30) resistor r=4.4012 c=0
Rl48 (\13\:qbint \14\:qbint) resistor r=117.308 c=0
Rl47 (\12\:qbint \13\:qbint) resistor r=69.208 c=0
Rl30 (\2\:qbint \4\:qbint) resistor r=40.0987 c=0
Rl29 (\2\:qbint \3\:qbint) resistor r=107.406 c=0
Rl28 (\2\:qbint qbint) resistor r=11.5001 c=0
Rl45 (net367 \6\:net367) resistor r=9.5287 c=0
Rz10 (\4\:QN \3\:QN) resistor r=75 c=0
Rz9 (\4\:Q \3\:Q) resistor r=75 c=0
Rz16 (\18\:VSS \17\:VSS) resistor r=75 c=0
Rz17 (\20\:VSS \19\:VSS) resistor r=75 c=0
Rz18 (\22\:VSS \21\:VSS) resistor r=75 c=0
Rz19 (\24\:VSS \23\:VSS) resistor r=75 c=0
Rz1 (\8\:SEb \9\:SEb) resistor r=75 c=0
Rz2 (Db \2\:Db) resistor r=75 c=0
Rz3 (\7\:Db \8\:Db) resistor r=75 c=0
Rz6 (\13\:CKbb \14\:CKbb) resistor r=75 c=0
Rz8 (\11\:CKb \12\:CKb) resistor r=75 c=0
Rz4 (\7\:n20 \8\:n20) resistor r=75 c=0
Rz5 (\6\:mout \7\:mout) resistor r=75 c=0
Rz7 (\9\:n30 \10\:n30) resistor r=75 c=0
Rz11 (\19\:qbint \18\:qbint) resistor r=75 c=0
Rz12 (\13\:net367 \12\:net367) resistor r=75 c=0
Ry10 (\2\:QN \1\:QN) resistor r=20.6667 c=0
Ry19 (\14\:VDD \13\:VDD) resistor r=62 c=0
Ry20 (\16\:VDD \15\:VDD) resistor r=62 c=0
Ry21 (\18\:VDD \17\:VDD) resistor r=62 c=0
Ry22 (\20\:VDD \19\:VDD) resistor r=62 c=0
Ry9 (\2\:Q \1\:Q) resistor r=20.6667 c=0
Ry13 (\1\:VSS \3\:VSS) resistor r=15.5 c=0
Ry14 (\7\:VSS \3\:VSS) resistor r=5.1667 c=0
Ry15 (\11\:VSS \3\:VSS) resistor r=5.1667 c=0
Ry1 (\10\:SEb \11\:SEb) resistor r=62 c=0
Ry2 (\3\:Db \4\:Db) resistor r=62 c=0
Ry3 (\5\:Db \6\:Db) resistor r=62 c=0
Ry6 (\18\:CKbb \19\:CKbb) resistor r=62 c=0
Ry8 (\13\:CKb \14\:CKb) resistor r=62 c=0
Ry4 (\9\:n20 \10\:n20) resistor r=62 c=0
Ry5 (\8\:mout \9\:mout) resistor r=62 c=0
Ry7 (\7\:n30 \8\:n30) resistor r=62 c=0
Ry11 (\25\:qbint \24\:qbint) resistor r=62 c=0
Ry12 (\9\:net367 \8\:net367) resistor r=62 c=0
Rx1 (\2\:D \4\:D) resistor r=45 c=0
Rx16 (\2\:CK \4\:CK) resistor r=45 c=0
Rx6 (\2\:SI \4\:SI) resistor r=45 c=0
Rx2 (\5\:SE \7\:SE) resistor r=45 c=0
Rx3 (\2\:SE \8\:SE) resistor r=45 c=0
Rx4 (\4\:SEb \5\:SEb) resistor r=45 c=0
Rx5 (\2\:SEb \6\:SEb) resistor r=45 c=0
Rx9 (\6\:CKbb \9\:CKbb) resistor r=45 c=0
Rx10 (\8\:CKbb \15\:CKbb) resistor r=45 c=0
Rx11 (\4\:CKbb \16\:CKbb) resistor r=45 c=0
Rx12 (\2\:CKbb \17\:CKbb) resistor r=45 c=0
Rx14 (\10\:CKb \15\:CKb) resistor r=45 c=0
Rx15 (CKb \16\:CKb) resistor r=45 c=0
Rx7 (\3\:n20 \5\:n20) resistor r=45 c=0
Rx8 (\2\:mout \4\:mout) resistor r=45 c=0
Rx13 (\3\:n30 \5\:n30) resistor r=45 c=0
Rx17 (\15\:qbint \12\:qbint) resistor r=45 c=0
Rx20 (\23\:qbint qbint) resistor r=45 c=0
Rx21 (\11\:net367 \6\:net367) resistor r=45 c=0
mn10 (\8\:SEb \3\:SE \23\:VSS VSS) g45n1svt w=(1.45e-07) l=4.5e-08 nf=1 \
        as=2.32e-14 ad=2.03e-14 ps=6.1e-07 pd=5.7e-07 nrd=1.16667 \
        nrs=1.16667 sa=1.4e-07 sb=1.21e-06 sd=160n sca=16.2011 \
        scb=0.0172667 scc=0.0012292 m=(1)
mn11 (net449 \3\:D \23\:VSS VSS) g45n1svt w=(1.45e-07) l=4.5e-08 nf=1 \
        as=2.32e-14 ad=8.7e-15 ps=6.1e-07 pd=4.1e-07 nrd=1.16667 \
        nrs=1.16667 sa=3.45e-07 sb=1.005e-06 sd=160n sca=16.2011 \
        scb=0.0172667 scc=0.0012292 m=(1)
mn12 (\7\:Db SEb net449 VSS) g45n1svt w=(1.45e-07) l=4.5e-08 nf=1 \
        as=8.7e-15 ad=3.335e-14 ps=4.1e-07 pd=7.5e-07 nrd=1.16667 \
        nrs=1.16667 sa=4.5e-07 sb=9e-07 sd=160n sca=16.2011 scb=0.0172667 \
        scc=0.0012292 m=(1)
mn14 (\7\:Db \4\:SE net461 VSS) g45n1svt w=(1.45e-07) l=4.5e-08 nf=1 \
        as=3.045e-14 ad=3.335e-14 ps=7.1e-07 pd=7.5e-07 nrd=1.16667 \
        nrs=1.16667 sa=7.25e-07 sb=6.25e-07 sd=160n sca=16.2011 \
        scb=0.0172667 scc=0.0012292 m=(1)
mn13 (net461 \3\:SI \21\:VSS VSS) g45n1svt w=(1.45e-07) l=4.5e-08 nf=1 \
        as=2.682e-14 ad=3.045e-14 ps=6.6e-07 pd=7.1e-07 nrd=1.16667 \
        nrs=1.16667 sa=9.8e-07 sb=3.7e-07 sd=160n sca=16.2011 \
        scb=0.0172667 scc=0.0012292 m=(1)
mn21 (\13\:CKbb \5\:CKb \21\:VSS VSS) g45n1svt w=(1.45e-07) l=4.5e-08 \
        nf=1 as=2.682e-14 ad=2.03e-14 ps=6.6e-07 pd=5.7e-07 nrd=1.16667 \
        nrs=1.16667 sa=1.21e-06 sb=1.4e-07 sd=160n sca=16.2011 \
        scb=0.0172667 scc=0.0012292 m=(1)
mn25 (\7\:n20 \6\:CKb Db VSS) g45n1svt w=(1.45e-07) l=4.5e-08 nf=1 \
        as=4.567e-14 ad=2.32e-14 ps=9.2e-07 pd=6.1e-07 nrd=1.16667 \
        nrs=1.16667 sa=3.15e-07 sb=1.615e-06 sd=160n sca=19.1673 \
        scb=0.0200674 scc=0.00182521 m=(1)
mn36 (\7\:n20 \3\:CKbb net429 VSS) g45n1svt w=(1.45e-07) l=4.5e-08 nf=1 \
        as=8.7e-15 ad=2.32e-14 ps=4.1e-07 pd=6.1e-07 nrd=1.16667 \
        nrs=1.16667 sa=5.2e-07 sb=1.41e-06 sd=160n sca=19.1673 \
        scb=0.0200674 scc=0.00182521 m=(1)
mn35 (net429 \3\:mout \19\:VSS VSS) g45n1svt w=(1.45e-07) l=4.5e-08 nf=1 \
        as=8.11e-14 ad=8.7e-15 ps=1.55e-06 pd=4.1e-07 nrd=1.16667 \
        nrs=1.16667 sa=6.25e-07 sb=1.305e-06 sd=160n sca=19.1673 \
        scb=0.0200674 scc=0.00182521 m=(1)
mn30 (\6\:mout \4\:n20 \19\:VSS VSS) g45n1svt w=(1.45e-07) l=4.5e-08 \
        nf=1 as=8.11e-14 ad=2.32e-14 ps=1.55e-06 pd=6.1e-07 nrd=1.16667 \
        nrs=1.16667 sa=8.9e-07 sb=1.04e-06 sd=160n sca=19.1673 \
        scb=0.0200674 scc=0.00182521 m=(1)
mn40 (\9\:n30 \5\:CKbb \6\:mout VSS) g45n1svt w=(1.45e-07) l=4.5e-08 nf=1 \
        as=2.32e-14 ad=4.857e-14 ps=6.1e-07 pd=9.6e-07 nrd=1.16667 \
        nrs=1.16667 sa=1.095e-06 sb=8.35e-07 sd=160n sca=19.1673 \
        scb=0.0200674 scc=0.00182521 m=(1)
mn51 (\9\:n30 \8\:CKb net436 VSS) g45n1svt w=(1.45e-07) l=4.5e-08 nf=1 \
        as=9.42e-15 ad=4.857e-14 ps=4.2e-07 pd=9.6e-07 nrd=1.16667 \
        nrs=1.16667 sa=1.475e-06 sb=4.55e-07 sd=160n sca=19.1673 \
        scb=0.0200674 scc=0.00182521 m=(1)
mn50 (net436 \3\:qbint \17\:VSS VSS) g45n1svt w=(1.45e-07) l=4.5e-08 \
        nf=1 as=2.92e-14 ad=9.42e-15 ps=7.3e-07 pd=4.2e-07 nrd=1.16667 \
        nrs=1.16667 sa=1.585e-06 sb=3.45e-07 sd=160n sca=19.1673 \
        scb=0.0200674 scc=0.00182521 m=(1)
mn20 (\11\:CKb \3\:CK \1\:VSS VSS) g45n1svt w=(1.45e-07) l=4.5e-08 nf=1 \
        as=9.13e-14 ad=3.19e-14 ps=1.62e-06 pd=7.3e-07 nrd=1.16667 \
        nrs=1.16667 sa=2.2e-07 sb=1.32e-06 sd=160n sca=23.279 \
        scb=0.0230742 scc=0.00267719 m=(1)
mn56 (\12\:net367 \13\:qbint \1\:VSS VSS) g45n1svt w=(1.45e-07) \
        l=4.5e-08 nf=1 as=6.272e-14 ad=2.03e-14 ps=1.67e-06 pd=5.7e-07 \
        nrd=1.16667 nrs=1.16667 sa=1.4e-06 sb=1.4e-07 sd=160n sca=23.279 \
        scb=0.0230742 scc=0.00267719 m=(1)
mn45 (\18\:qbint \4\:n30 \17\:VSS VSS) g45n1svt w=(2.05e-07) l=4.5e-08 \
        nf=1 as=2.92e-14 ad=2.87e-14 ps=7.3e-07 pd=6.9e-07 nrd=1.16667 \
        nrs=1.16667 sa=1.29537e-06 sb=1.4e-07 sd=160n sca=16.6038 \
        scb=0.0171168 scc=0.00137311 m=(1)
mn55 (\3\:Q \5\:qbint \1\:VSS VSS) g45n1svt w=(2.6e-07) l=4.5e-08 nf=1 \
        as=9.345e-14 ad=4.16e-14 ps=1.61e-06 pd=8.4e-07 nrd=1.16667 \
        nrs=1.16667 sa=3.5125e-07 sb=9.25577e-07 sd=160n sca=17.5885 \
        scb=0.0172826 scc=0.00162584 m=(2)
mn57_1__rcx (\3\:QN net367 \1\:VSS VSS) g45n1svt w=(2.6e-07) l=4.5e-08 \
        nf=1 as=7.916e-14 ad=4.16e-14 ps=1.635e-06 pd=8.4e-07 nrd=1.16667 \
        nrs=1.16667 sa=8.2125e-07 sb=4.55577e-07 sd=160n sca=17.5885 \
        scb=0.0172826 scc=0.00162584 m=(2)
mp45 (\24\:qbint n30 \13\:VDD NW) g45p1svt w=(3.1e-07) l=4.5e-08 nf=1 \
        as=9.705e-14 ad=4.34e-14 ps=1.62e-06 pd=9e-07 nrd=1.16667 \
        nrs=1.16667 sa=1.21032e-06 sb=1.4e-07 sd=160n sca=13.1273 \
        scb=0.0119313 scc=0.000538101 m=(1)
mp55 (\1\:Q \5\:qbint \1\:VDD NW) g45p1svt w=(3.9e-07) l=4.5e-08 nf=1 \
        as=6.549e-14 ad=7.41e-14 ps=1.145e-06 pd=1.16e-06 nrd=1.16667 \
        nrs=1.16667 sa=2.77821e-07 sb=8.93846e-07 sd=160n sca=17.2385 \
        scb=0.0152696 scc=0.00137893 m=(2)
mp57_1__rcx (\1\:QN net367 \1\:VDD NW) g45p1svt w=(3.9e-07) l=4.5e-08 \
        nf=1 as=5.984e-14 ad=6.24e-14 ps=1.125e-06 pd=1.1e-06 nrd=1.16667 \
        nrs=1.16667 sa=7.17821e-07 sb=4.53846e-07 sd=160n sca=17.7255 \
        scb=0.0154354 scc=0.00137898 m=(2)
ends SDFFX2
// End of subcircuit definition.
