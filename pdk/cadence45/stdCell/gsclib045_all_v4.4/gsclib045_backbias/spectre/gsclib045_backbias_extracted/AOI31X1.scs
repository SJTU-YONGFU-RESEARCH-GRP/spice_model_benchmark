// Generated for: spectre (May  1 11:27:50 2013 )
// Library name: gsclib045_backbias
// Cell name: AOI31X1
// View name: extracted

simulator lang=spectre

subckt AOI31X1 A0 A1 A2 B0 NW VDD VSS Y
mp0 (net81 \3\:A0 \4\:VDD NW) g45p1svt w=(3.9e-07) l=4.5e-08 nf=1 \
        as=5.46e-14 ad=6.24e-14 ps=1.06e-06 pd=1.1e-06 nrd=1.16667 \
        nrs=1.16667 sa=1.4e-07 sb=7.7e-07 sd=160n sca=18.8466 \
        scb=0.0203197 scc=0.000573038 m=(1)
mp1 (net81 \1\:A1 \1\:VDD NW) g45p1svt w=(3.9e-07) l=4.5e-08 nf=1 \
        as=6.24e-14 ad=6.24e-14 ps=1.1e-06 pd=1.1e-06 nrd=1.16667 \
        nrs=1.16667 sa=3.45e-07 sb=5.65e-07 sd=160n sca=14.4531 \
        scb=0.0120361 scc=0.000241045 m=(1)
mp2 (\3\:net81 \1\:A2 \1\:VDD NW) g45p1svt w=(3.9e-07) l=4.5e-08 nf=1 \
        as=6.24e-14 ad=6.825e-14 ps=1.1e-06 pd=1.13e-06 nrd=1.16667 \
        nrs=1.16667 sa=5.5e-07 sb=3.6e-07 sd=160n sca=14.3825 \
        scb=0.0118943 scc=0.000239579 m=(1)
mp3 (\4\:Y \1\:B0 \3\:net81 NW) g45p1svt w=(3.9e-07) l=4.5e-08 nf=1 \
        as=6.825e-14 ad=5.46e-14 ps=1.13e-06 pd=1.06e-06 nrd=1.16667 \
        nrs=1.16667 sa=7.7e-07 sb=1.4e-07 sd=160n sca=19.0814 \
        scb=0.0207066 scc=0.000603442 m=(1)
C1 (Y VSS) capacitor c=1.85752e-17
C2 (A2 VSS) capacitor c=7.84495e-17
C3 (A1 VSS) capacitor c=7.77391e-17
C4 (NW VSS) capacitor c=2.05745e-16
C5 (B0 VSS) capacitor c=6.56184e-17
C6 (A0 VSS) capacitor c=5.05588e-17
C7 (VDD VSS) capacitor c=2.47327e-17
C8 (net81 VSS) capacitor c=9.97002e-17
C9 (\1\:B0 VSS) capacitor c=4.57066e-17
C10 (\1\:A2 VSS) capacitor c=5.74695e-17
C11 (\1\:A1 VSS) capacitor c=7.24131e-17
C12 (\3\:A0 VSS) capacitor c=4.62567e-17
C13 (\3\:B0 VSS) capacitor c=3.91103e-17
C14 (\3\:A2 VSS) capacitor c=6.05989e-17
C15 (\3\:A1 VSS) capacitor c=6.47379e-17
C16 (\1\:A0 VSS) capacitor c=7.37786e-17
C17 (\2\:B0 VSS) capacitor c=4.40211e-17
C18 (\2\:A2 VSS) capacitor c=6.30883e-17
C19 (\2\:A1 VSS) capacitor c=7.81129e-17
C20 (\2\:A0 VSS) capacitor c=5.77367e-17
C21 (\4\:Y VSS) capacitor c=2.23629e-17
C22 (\3\:net81 VSS) capacitor c=1.02232e-16
C23 (\1\:VDD VSS) capacitor c=1.69903e-16
C24 (\4\:VDD VSS) capacitor c=4.31092e-17
C25 (\1\:Y VSS) capacitor c=1.21208e-16
C26 (\4\:A0 VSS) capacitor c=2.20668e-17
C27 (\4\:A1 VSS) capacitor c=4.72232e-17
C28 (\4\:A2 VSS) capacitor c=3.7989e-17
C29 (\4\:B0 VSS) capacitor c=5.32533e-17
C30 (\3\:Y VSS) capacitor c=9.12615e-17
C31 (\3\:VDD VSS) capacitor c=4.04651e-17
Rk10 (\3\:Y Y) resistor r=0.01805 c=0
Rk8 (\2\:Y \3\:Y) resistor r=0.9703 c=0
Rk9 (\3\:Y \5\:Y) resistor r=0.2458 c=0
Rk4 (\6\:A2 A2) resistor r=0.001036 c=0
Rk5 (\4\:A2 \6\:A2) resistor r=0.05079 c=0
Rk2 (\4\:A1 A1) resistor r=0.1517 c=0
Rk11 (\2\:VSS \4\:VSS) resistor r=0.4073 c=0
Rk13 (\5\:VSS VSS) resistor r=0.09234 c=0
Rk12 (\4\:VSS \5\:VSS) resistor r=0.1578 c=0
Rk14 (\5\:VSS \7\:VSS) resistor r=0.2143 c=0
Rk7 (\4\:B0 B0) resistor r=0.1654 c=0
Rk1 (A0 \4\:A0) resistor r=0.1111 c=0
Rk16 (\3\:VDD VDD) resistor r=0.04219 c=0
Rk15 (\2\:VDD \3\:VDD) resistor r=0.4427 c=0
Rk17 (\3\:VDD \5\:VDD) resistor r=0.2789 c=0
Rk6 (\2\:net81 \4\:net81) resistor r=0.5322 c=0
Rl5 (\1\:A2 \2\:A2) resistor r=110.771 c=0
Rl6 (\2\:A2 \3\:A2) resistor r=91.5405 c=0
Rl3 (\1\:A1 \2\:A1) resistor r=175.692 c=0
Rl4 (\2\:A1 \3\:A1) resistor r=29.5379 c=0
Rl7 (\1\:B0 \2\:B0) resistor r=113.462 c=0
Rl8 (\2\:B0 \3\:B0) resistor r=93.4066 c=0
Rl2 (\2\:A0 \3\:A0) resistor r=78.079 c=0
Rl1 (\1\:A0 \2\:A0) resistor r=138.261 c=0
Rz1 (\1\:Y \2\:Y) resistor r=37.5 c=0
Rz2 (\1\:VSS \2\:VSS) resistor r=37.5 c=0
Rz3 (\6\:VSS \7\:VSS) resistor r=37.5 c=0
Ry3 (\4\:Y \5\:Y) resistor r=31 c=0
Ry5 (\1\:VDD \2\:VDD) resistor r=31 c=0
Ry6 (\4\:VDD \5\:VDD) resistor r=20.6667 c=0
Ry1 (net81 \2\:net81) resistor r=31 c=0
Ry2 (\3\:net81 \4\:net81) resistor r=31 c=0
Rx3 (\2\:A2 \4\:A2) resistor r=45 c=0
Rx2 (\2\:A1 \4\:A1) resistor r=45 c=0
Rx4 (\2\:B0 \4\:B0) resistor r=45 c=0
Rx1 (\2\:A0 \4\:A0) resistor r=45 c=0
mn0 (net93 \1\:A0 \6\:VSS VSS) g45n1svt w=(2.6e-07) l=4.5e-08 nf=1 \
        as=3.64e-14 ad=1.56e-14 ps=8e-07 pd=6.4e-07 nrd=1.16667 \
        nrs=1.16667 sa=1.4e-07 sb=6.15e-07 sd=160n sca=7.84363 \
        scb=0.00546499 scc=9.84911e-05 m=(1)
mn1 (net97 \3\:A1 net93 VSS) g45n1svt w=(2.6e-07) l=4.5e-08 nf=1 \
        as=1.56e-14 ad=2.99e-14 ps=6.4e-07 pd=7.5e-07 nrd=1.16667 \
        nrs=1.16667 sa=2.45e-07 sb=5.1e-07 sd=160n sca=7.84363 \
        scb=0.00546499 scc=9.84911e-05 m=(1)
mn2 (\1\:Y \3\:A2 net97 VSS) g45n1svt w=(2.6e-07) l=4.5e-08 nf=1 \
        as=2.99e-14 ad=4.29e-14 ps=7.5e-07 pd=8.5e-07 nrd=1.16667 \
        nrs=1.16667 sa=4.05e-07 sb=3.5e-07 sd=160n sca=7.84363 \
        scb=0.00546499 scc=9.84911e-05 m=(1)
mn3 (\1\:Y \3\:B0 \1\:VSS VSS) g45n1svt w=(2.6e-07) l=4.5e-08 nf=1 \
        as=3.64e-14 ad=4.29e-14 ps=8e-07 pd=8.5e-07 nrd=1.16667 \
        nrs=1.16667 sa=6.15e-07 sb=1.4e-07 sd=160n sca=7.84363 \
        scb=0.00546499 scc=9.84911e-05 m=(1)
ends AOI31X1
// End of subcircuit definition.
