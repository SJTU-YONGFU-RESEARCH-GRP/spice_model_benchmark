// Generated for: spectre (May  1 11:30:29 2013 )
// Library name: gsclib045_backbias
// Cell name: NAND4BBX2
// View name: extracted

simulator lang=spectre

subckt NAND4BBX2 AN BN C D NW VDD VSS Y
mp1 (\10\:n1 \1\:BN \16\:VDD NW) g45p1svt w=(2.15e-07) l=4.5e-08 nf=1 \
        as=3.44e-14 ad=3.655e-14 ps=7.5e-07 pd=7.7e-07 nrd=1.16667 \
        nrs=1.16667 sa=1.7e-07 sb=3.45e-07 sd=160n sca=14.4249 \
        scb=0.0128702 scc=0.000158043 m=(1)
mp0 (\10\:n0 \3\:AN \16\:VDD NW) g45p1svt w=(2.15e-07) l=4.5e-08 nf=1 \
        as=3.44e-14 ad=3.01e-14 ps=7.5e-07 pd=7.1e-07 nrd=1.16667 \
        nrs=1.16667 sa=3.75e-07 sb=1.4e-07 sd=160n sca=11.7702 \
        scb=0.00871161 scc=9.98964e-05 m=(1)
C1 (BN VSS) capacitor c=4.17711e-17
C2 (D VSS) capacitor c=4.01485e-17
C3 (NW VSS) capacitor c=4.22974e-16
C4 (Y VSS) capacitor c=2.89299e-17
C5 (VDD VSS) capacitor c=4.46017e-17
C6 (C VSS) capacitor c=3.59717e-17
C7 (AN VSS) capacitor c=8.03082e-17
C8 (n1 VSS) capacitor c=1.81902e-16
C9 (n0 VSS) capacitor c=1.65652e-16
C10 (n4 VSS) capacitor c=2.3112e-16
C11 (n3 VSS) capacitor c=9.21477e-17
C12 (n2 VSS) capacitor c=1.66971e-16
C13 (\3\:AN VSS) capacitor c=3.76942e-17
C14 (\1\:BN VSS) capacitor c=3.87939e-17
C15 (\1\:D VSS) capacitor c=1.67448e-16
C16 (\1\:C VSS) capacitor c=1.9358e-16
C17 (\1\:AN VSS) capacitor c=4.53613e-17
C18 (\3\:BN VSS) capacitor c=3.7186e-17
C19 (\2\:AN VSS) capacitor c=4.01825e-17
C20 (\2\:BN VSS) capacitor c=3.88925e-17
C21 (\1\:VDD VSS) capacitor c=5.03483e-16
C22 (\9\:Y VSS) capacitor c=3.68824e-17
C23 (\11\:Y VSS) capacitor c=3.58333e-17
C24 (\13\:Y VSS) capacitor c=3.46816e-17
C25 (\7\:Y VSS) capacitor c=4.10936e-17
C26 (\10\:n0 VSS) capacitor c=6.93533e-17
C27 (\16\:VDD VSS) capacitor c=3.52342e-17
C28 (\10\:n1 VSS) capacitor c=5.66679e-17
C29 (\1\:Y VSS) capacitor c=6.16294e-17
C30 (\3\:n3 VSS) capacitor c=7.75226e-17
C31 (\12\:n0 VSS) capacitor c=6.88148e-17
C32 (\12\:n1 VSS) capacitor c=1.61021e-17
C33 (\4\:BN VSS) capacitor c=7.5416e-17
C34 (\4\:AN VSS) capacitor c=4.21776e-17
C35 (\8\:n0 VSS) capacitor c=6.09786e-17
C36 (\9\:n0 VSS) capacitor c=7.92701e-17
C37 (\8\:n1 VSS) capacitor c=2.16198e-16
C38 (\9\:n1 VSS) capacitor c=2.49346e-16
C39 (\7\:C VSS) capacitor c=7.48321e-17
C40 (\7\:D VSS) capacitor c=7.61304e-17
C41 (\3\:Y VSS) capacitor c=8.37597e-17
C42 (\4\:Y VSS) capacitor c=6.72013e-17
C43 (\5\:Y VSS) capacitor c=2.56082e-17
C44 (\6\:Y VSS) capacitor c=2.73863e-17
C45 (\7\:VDD VSS) capacitor c=6.68927e-17
Rk1 (BN \4\:BN) resistor r=0.07076 c=0
Rk13 (\7\:D D) resistor r=0.02379 c=0
Rk14 (\2\:Y \3\:Y) resistor r=0.5148 c=0
Rk15 (\3\:Y \4\:Y) resistor r=0.3409 c=0
Rk16 (\4\:Y \5\:Y) resistor r=0.309 c=0
Rk22 (\6\:Y Y) resistor r=0.02589 c=0
Rk17 (\5\:Y \6\:Y) resistor r=0.1921 c=0
Rk18 (\6\:Y \8\:Y) resistor r=0.07409 c=0
Rk19 (\3\:Y \10\:Y) resistor r=0.06391 c=0
Rk20 (\4\:Y \12\:Y) resistor r=0.05797 c=0
Rk21 (\5\:Y \14\:Y) resistor r=0.05797 c=0
Rk30 (\7\:VDD VDD) resistor r=0.1952 c=0
Rk29 (\1\:VDD \7\:VDD) resistor r=0.4435 c=0
Rk35 (\7\:VDD \17\:VDD) resistor r=0.2421 c=0
Rk12 (C \7\:C) resistor r=0.02484 c=0
Rk2 (AN \4\:AN) resistor r=0.1348 c=0
Rk36 (\2\:VSS \3\:VSS) resistor r=0.6619 c=0
Rk37 (\3\:VSS \4\:VSS) resistor r=0.1402 c=0
Rk39 (\5\:VSS VSS) resistor r=0.2077 c=0
Rk38 (\4\:VSS \5\:VSS) resistor r=0.3434 c=0
Rk40 (\3\:VSS \7\:VSS) resistor r=0.2367 c=0
Rk41 (\5\:VSS \9\:VSS) resistor r=0.327 c=0
Rk6 (\8\:n1 \9\:n1) resistor r=1.6447 c=0
Rk7 (\9\:n1 \11\:n1) resistor r=0.5767 c=0
Rk8 (\9\:n1 \13\:n1) resistor r=0.09278 c=0
Rk3 (\8\:n0 \9\:n0) resistor r=0.3117 c=0
Rk4 (\9\:n0 \11\:n0) resistor r=0.446 c=0
Rk5 (\9\:n0 \13\:n0) resistor r=0.2934 c=0
Rk11 (\2\:n3 \4\:n3) resistor r=0.4745 c=0
Rl1 (\1\:BN \2\:BN) resistor r=100.692 c=0
Rl2 (\2\:BN \3\:BN) resistor r=98.7687 c=0
Rl4 (\2\:AN \3\:AN) resistor r=101.099 c=0
Rl3 (\1\:AN \2\:AN) resistor r=100 c=0
Rz8 (\2\:Y \1\:Y) resistor r=75 c=0
Rz12 (\7\:VSS \6\:VSS) resistor r=75 c=0
Rz13 (\9\:VSS \8\:VSS) resistor r=75 c=0
Rz2 (\13\:n1 \12\:n1) resistor r=75 c=0
Rz1 (\13\:n0 \12\:n0) resistor r=75 c=0
Rz6 (\2\:n3 n3) resistor r=75 c=0
Rz7 (\4\:n3 \3\:n3) resistor r=75 c=0
Ry3 (\8\:Y \7\:Y) resistor r=20.6667 c=0
Ry4 (\10\:Y \9\:Y) resistor r=31 c=0
Ry5 (\12\:Y \11\:Y) resistor r=31 c=0
Ry6 (\14\:Y \13\:Y) resistor r=31 c=0
Ry12 (\17\:VDD \16\:VDD) resistor r=62 c=0
Ry13 (\2\:VSS \1\:VSS) resistor r=15.5 c=0
Ry14 (\4\:VSS \1\:VSS) resistor r=5.1667 c=0
Ry2 (\11\:n1 \10\:n1) resistor r=62 c=0
Ry1 (\11\:n0 \10\:n0) resistor r=62 c=0
Rx1 (\2\:BN \4\:BN) resistor r=45 c=0
Rx6 (\7\:D \1\:D) resistor r=45 c=0
Rx5 (\7\:C \1\:C) resistor r=45 c=0
Rx2 (\2\:AN \4\:AN) resistor r=45 c=0
Rx4 (\8\:n1 n1) resistor r=45 c=0
Rx3 (\8\:n0 n0) resistor r=45 c=0
mn1 (\12\:n1 \3\:BN \8\:VSS VSS) g45n1svt w=(1.45e-07) l=4.5e-08 nf=1 \
        as=3.175e-14 ad=2.03e-14 ps=7.3e-07 pd=5.7e-07 nrd=1.16667 \
        nrs=1.16667 sa=1.4e-07 sb=4.85e-07 sd=160n sca=13.9854 \
        scb=0.014728 scc=0.000819645 m=(1)
mn0 (\12\:n0 \1\:AN \8\:VSS VSS) g45n1svt w=(1.45e-07) l=4.5e-08 nf=1 \
        as=3.175e-14 ad=3.263e-14 ps=7.3e-07 pd=7.4e-07 nrd=1.16667 \
        nrs=1.16667 sa=4e-07 sb=2.25e-07 sd=160n sca=13.9854 scb=0.014728 \
        scc=0.000819645 m=(1)
mn2_1__rcx (n4 n0 \6\:VSS VSS) g45n1svt w=(2.6e-07) l=4.5e-08 nf=1 \
        as=4.16e-14 ad=4.095e-14 ps=8.4e-07 pd=8.35e-07 nrd=1.16667 \
        nrs=1.16667 sa=1.4e-07 sb=7.7e-07 sd=160n sca=11.3041 scb=0.010759 \
        scc=0.000493236 m=(2)
mn5 (\1\:Y \1\:D n2 VSS) g45n1svt w=(2.6e-07) l=4.5e-08 nf=1 as=3.9e-14 \
        ad=4.16e-14 ps=8.2e-07 pd=8.4e-07 nrd=1.16667 nrs=1.16667 \
        sa=5.5e-07 sb=3.45e-07 sd=160n sca=10.104 scb=0.00906063 \
        scc=0.000325539 m=(2)
mn3_1__rcx (\3\:n3 n1 n4 VSS) g45n1svt w=(2.6e-07) l=4.5e-08 nf=1 \
        as=4.095e-14 ad=4.16e-14 ps=8.35e-07 pd=8.4e-07 nrd=1.16667 \
        nrs=1.16667 sa=5.65e-07 sb=3.45e-07 sd=160n sca=11.3041 \
        scb=0.010759 scc=0.000493236 m=(2)
mn4 (n2 \1\:C n3 VSS) g45n1svt w=(2.6e-07) l=4.5e-08 nf=1 as=4.16e-14 \
        ad=3.9e-14 ps=8.4e-07 pd=8.2e-07 nrd=1.16667 nrs=1.16667 \
        sa=1.4e-07 sb=7.55e-07 sd=160n sca=10.104 scb=0.00906063 \
        scc=0.000325539 m=(2)
mp4_1__rcx (\11\:Y \1\:C \1\:VDD NW) g45p1svt w=(3.9e-07) l=4.5e-08 nf=1 \
        as=6.24e-14 ad=6.24e-14 ps=1.1e-06 pd=1.1e-06 nrd=1.16667 \
        nrs=1.16667 sa=9.6e-07 sb=7.95e-07 sd=160n sca=15.5579 \
        scb=0.0139499 scc=0.00102271 m=(2)
mp2 (\7\:Y n0 \1\:VDD NW) g45p1svt w=(3.9e-07) l=4.5e-08 nf=1 \
        as=5.85e-14 ad=6.24e-14 ps=1.08e-06 pd=1.1e-06 nrd=1.16667 \
        nrs=1.16667 sa=1.4e-07 sb=1.615e-06 sd=160n sca=15.4348 \
        scb=0.0139233 scc=0.00102271 m=(2)
mp5_1__rcx (\9\:Y \1\:D \1\:VDD NW) g45p1svt w=(3.9e-07) l=4.5e-08 nf=1 \
        as=5.85e-14 ad=7.8e-14 ps=1.08e-06 pd=1.18e-06 nrd=1.16667 \
        nrs=1.16667 sa=1.37e-06 sb=3.85e-07 sd=160n sca=17.7593 scb=0.0161 \
        scc=0.00103173 m=(2)
mp3 (\13\:Y n1 \1\:VDD NW) g45p1svt w=(3.9e-07) l=4.5e-08 nf=1 \
        as=6.24e-14 ad=6.24e-14 ps=1.1e-06 pd=1.1e-06 nrd=1.16667 \
        nrs=1.16667 sa=5.5e-07 sb=1.205e-06 sd=160n sca=15.4348 \
        scb=0.0139233 scc=0.00102271 m=(2)
ends NAND4BBX2
// End of subcircuit definition.
