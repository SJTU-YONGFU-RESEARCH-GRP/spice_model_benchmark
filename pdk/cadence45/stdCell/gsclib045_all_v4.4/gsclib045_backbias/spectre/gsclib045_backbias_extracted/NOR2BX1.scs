// Generated for: spectre (May  1 11:30:40 2013 )
// Library name: gsclib045_backbias
// Cell name: NOR2BX1
// View name: extracted

simulator lang=spectre

subckt NOR2BX1 AN B NW VDD VSS Y
mp2 (\3\:Y \1\:B net59 NW) g45p1svt w=(3.9e-07) l=4.5e-08 nf=1 \
        as=2.34e-14 ad=5.46e-14 ps=9e-07 pd=1.06e-06 nrd=1.16667 \
        nrs=1.16667 sa=1.4e-07 sb=3.74551e-07 sd=160n sca=22.6423 \
        scb=0.024839 scc=0.000882584 m=(1)
mp1 (net59 \3\:net76 \1\:VDD NW) g45p1svt w=(3.9e-07) l=4.5e-08 nf=1 \
        as=6.535e-14 ad=2.34e-14 ps=1.16e-06 pd=9e-07 nrd=1.16667 \
        nrs=1.16667 sa=2.45e-07 sb=2.69551e-07 sd=160n sca=19.5802 \
        scb=0.0197242 scc=0.000428585 m=(1)
C1 (Y VSS) capacitor c=6.21874e-17
C2 (VDD VSS) capacitor c=5.99687e-17
C3 (B VSS) capacitor c=3.75768e-17
C4 (NW VSS) capacitor c=1.73255e-16
C5 (net76 VSS) capacitor c=5.55501e-17
C6 (\1\:AN VSS) capacitor c=3.74762e-17
C7 (\3\:net76 VSS) capacitor c=7.73694e-17
C8 (\1\:B VSS) capacitor c=7.64491e-17
C9 (\3\:AN VSS) capacitor c=4.1217e-17
C10 (\3\:B VSS) capacitor c=3.00489e-17
C11 (\2\:AN VSS) capacitor c=3.78605e-17
C12 (\2\:net76 VSS) capacitor c=5.06691e-17
C13 (\2\:B VSS) capacitor c=4.5952e-17
C14 (\4\:net76 VSS) capacitor c=4.20944e-17
C15 (\1\:VDD VSS) capacitor c=9.75756e-17
C16 (\3\:Y VSS) capacitor c=5.03459e-17
C17 (\8\:net76 VSS) capacitor c=6.24397e-17
C18 (\1\:Y VSS) capacitor c=9.17909e-17
C19 (\4\:B VSS) capacitor c=8.18532e-17
C20 (\6\:net76 VSS) capacitor c=9.44316e-17
C21 (\7\:net76 VSS) capacitor c=2.01805e-17
C22 (\4\:AN VSS) capacitor c=5.35535e-17
C23 (\6\:AN VSS) capacitor c=4.35411e-17
Rk7 (\4\:AN \5\:AN) resistor r=0.005473 c=0
Rk8 (AN \6\:AN) resistor r=0.005473 c=0
Rk9 (\4\:AN \6\:AN) resistor r=0.02665 c=0
Rk1 (\2\:Y Y) resistor r=0.6199 c=0
Rk2 (Y \4\:Y) resistor r=0.1582 c=0
Rk13 (\2\:VDD VDD) resistor r=0.4176 c=0
Rk3 (B \4\:B) resistor r=0.07664 c=0
Rk11 (\4\:VSS VSS) resistor r=0.1509 c=0
Rk10 (\2\:VSS \4\:VSS) resistor r=0.4021 c=0
Rk12 (VSS \6\:VSS) resistor r=0.07697 c=0
Rk4 (\5\:net76 \6\:net76) resistor r=0.2842 c=0
Rk5 (\6\:net76 \7\:net76) resistor r=0.04832 c=0
Rk6 (\6\:net76 \9\:net76) resistor r=0.4595 c=0
Rl5 (\1\:AN \2\:AN) resistor r=53.0211 c=0
Rl6 (\2\:AN \3\:AN) resistor r=87.6365 c=0
Rl1 (\1\:B \2\:B) resistor r=92.3077 c=0
Rl2 (\2\:B \3\:B) resistor r=56.8681 c=0
Rl4 (\2\:net76 \3\:net76) resistor r=29.5379 c=0
Rl3 (net76 \2\:net76) resistor r=115.365 c=0
Rz1 (\1\:Y \2\:Y) resistor r=75 c=0
Rz3 (\1\:VSS \2\:VSS) resistor r=75 c=0
Rz4 (\5\:VSS \6\:VSS) resistor r=75 c=0
Rz2 (\8\:net76 \9\:net76) resistor r=75 c=0
Ry1 (\3\:Y \4\:Y) resistor r=20.6667 c=0
Ry4 (\1\:VDD \2\:VDD) resistor r=31 c=0
Ry2 (\4\:net76 \5\:net76) resistor r=62 c=0
Rx3 (\2\:AN \5\:AN) resistor r=45 c=0
Rx1 (\2\:B \4\:B) resistor r=45 c=0
Rx2 (\2\:net76 \7\:net76) resistor r=45 c=0
mn2 (\1\:Y \3\:B \5\:VSS VSS) g45n1svt w=(2.6e-07) l=4.5e-08 nf=1 \
        as=4.85e-14 ad=4.16e-14 ps=1.41e-06 pd=8.4e-07 nrd=1.16667 \
        nrs=1.16667 sa=1e-07 sb=4.41635e-07 sd=160n sca=13.198 \
        scb=0.0131159 scc=0.000803647 m=(1)
mn1 (\1\:Y net76 \1\:VSS VSS) g45n1svt w=(2.6e-07) l=4.5e-08 nf=1 \
        as=3.47e-14 ad=4.16e-14 ps=8.4e-07 pd=8.4e-07 nrd=1.16667 \
        nrs=1.16667 sa=3.05e-07 sb=2.36635e-07 sd=160n sca=13.198 \
        scb=0.0131159 scc=0.000803647 m=(1)
mn0 (\8\:net76 \3\:AN \1\:VSS VSS) g45n1svt w=(1.45e-07) l=4.5e-08 nf=1 \
        as=3.47e-14 ad=2.03e-14 ps=8.4e-07 pd=5.7e-07 nrd=1.16667 \
        nrs=1.16667 sa=5.1e-07 sb=1.4e-07 sd=160n sca=16.7245 \
        scb=0.0178071 scc=0.00133148 m=(1)
mp0 (\4\:net76 \1\:AN \1\:VDD NW) g45p1svt w=(2.15e-07) l=4.5e-08 nf=1 \
        as=6.535e-14 ad=3.01e-14 ps=1.16e-06 pd=7.1e-07 nrd=1.16667 \
        nrs=1.16667 sa=4.8e-07 sb=1.4e-07 sd=160n sca=28.1856 \
        scb=0.0322489 scc=0.00190885 m=(1)
ends NOR2BX1
// End of subcircuit definition.
