// Generated for: spectre (May  1 11:28:06 2013 )
// Library name: gsclib045_backbias
// Cell name: BUFX4
// View name: extracted

simulator lang=spectre

subckt BUFX4 A NW VDD VSS Y
mp0 (\14\:n0 \1\:A VDD NW) g45p1svt w=(3.9e-07) l=4.5e-08 nf=1 \
        as=6.24e-14 ad=5.46e-14 ps=1.1e-06 pd=1.06e-06 nrd=1.16667 \
        nrs=1.16667 sa=9.75e-07 sb=1.4e-07 sd=160n sca=20.4961 \
        scb=0.0204164 scc=0.00119548 m=(1)
mp1 (\1\:Y n0 VDD NW) g45p1svt w=(3.9e-07) l=4.5e-08 nf=1 as=6.337e-14 \
        ad=6.24e-14 ps=1.105e-06 pd=1.1e-06 nrd=1.16667 nrs=1.16667 \
        sa=1.4e-07 sb=9.75e-07 sd=160n sca=29.498 scb=0.0332632 \
        scc=0.00250913 m=(4)
C1 (NW VSS) capacitor c=2.06483e-16
C2 (Y VSS) capacitor c=2.49766e-17
C3 (A VSS) capacitor c=3.07099e-17
C4 (VDD VSS) capacitor c=3.77519e-16
C5 (n0 VSS) capacitor c=2.43364e-16
C6 (\1\:A VSS) capacitor c=4.25632e-17
C7 (\3\:A VSS) capacitor c=4.83298e-17
C8 (\2\:A VSS) capacitor c=4.04491e-17
C9 (\8\:n0 VSS) capacitor c=3.82133e-17
C10 (\14\:n0 VSS) capacitor c=8.79585e-17
C11 (\1\:Y VSS) capacitor c=3.66198e-16
C12 (\17\:n0 VSS) capacitor c=5.70209e-17
C13 (\4\:A VSS) capacitor c=6.13338e-17
C14 (\16\:n0 VSS) capacitor c=9.5183e-17
Rk3 (\1\:Y Y) resistor r=0.1185 c=0
Rk7 (\4\:A A) resistor r=0.01672 c=0
Rk8 (\15\:n0 \16\:n0) resistor r=0.5815 c=0
Rk9 (\16\:n0 \18\:n0) resistor r=0.3907 c=0
Rl13 (\1\:A \2\:A) resistor r=55.0021 c=0
Rl14 (\2\:A \3\:A) resistor r=105.002 c=0
Rl7 (n0 \8\:n0) resistor r=3.8088 c=0
Rz3 (\18\:n0 \17\:n0) resistor r=37.5 c=0
Ry3 (\15\:n0 \14\:n0) resistor r=20.6667 c=0
Rx1 (\2\:A \4\:A) resistor r=45 c=0
Rx2 (\16\:n0 \8\:n0) resistor r=45 c=0
mn0 (VSS \3\:A \17\:n0 VSS) g45n1svt w=(2.6e-07) l=4.5e-08 nf=1 \
        as=3.64e-14 ad=4.16e-14 ps=8e-07 pd=8.4e-07 nrd=1.16667 \
        nrs=1.16667 sa=9.75e-07 sb=1.4e-07 sd=160n sca=7.84363 \
        scb=0.00546499 scc=9.84911e-05 m=(1)
mn1 (VSS n0 \1\:Y VSS) g45n1svt w=(2.6e-07) l=4.5e-08 nf=1 as=4.16e-14 \
        ad=4.225e-14 ps=8.4e-07 pd=8.45e-07 nrd=1.16667 nrs=1.16667 \
        sa=1.4e-07 sb=9.75e-07 sd=160n sca=7.84363 scb=0.00546499 \
        scc=9.84911e-05 m=(4)
ends BUFX4
// End of subcircuit definition.
