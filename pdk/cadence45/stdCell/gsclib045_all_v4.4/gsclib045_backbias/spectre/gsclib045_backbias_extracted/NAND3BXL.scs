// Generated for: spectre (May  1 11:30:22 2013 )
// Library name: gsclib045_backbias
// Cell name: NAND3BXL
// View name: extracted

simulator lang=spectre

subckt NAND3BXL AN B C NW VDD VSS Y
mp3 (\3\:Y \3\:C \4\:VDD NW) g45p1svt w=(2.15e-07) l=4.5e-08 nf=1 \
        as=5.9e-14 ad=2.63e-14 ps=1.53e-06 pd=7.1e-07 nrd=1.16667 \
        nrs=1.16667 sa=1.22326e-07 sb=7.17326e-07 sd=160n sca=26.1913 \
        scb=0.0299385 scc=0.0017385 m=(1)
mp2 (\1\:Y \1\:B \4\:VDD NW) g45p1svt w=(2.15e-07) l=4.5e-08 nf=1 \
        as=5.9e-14 ad=3.44e-14 ps=1.53e-06 pd=7.5e-07 nrd=1.16667 \
        nrs=1.16667 sa=3.17326e-07 sb=5.22326e-07 sd=160n sca=17.2808 \
        scb=0.0163439 scc=0.000383193 m=(1)
mp1 (\1\:Y n0 \1\:VDD NW) g45p1svt w=(2.15e-07) l=4.5e-08 nf=1 \
        as=5.83e-14 ad=3.44e-14 ps=1.52e-06 pd=7.5e-07 nrd=1.16667 \
        nrs=1.16667 sa=5.22326e-07 sb=3.17326e-07 sd=160n sca=17.2808 \
        scb=0.0163439 scc=0.000383193 m=(1)
mp0 (\4\:n0 \1\:AN \1\:VDD NW) g45p1svt w=(2.15e-07) l=4.5e-08 nf=1 \
        as=5.83e-14 ad=2.63e-14 ps=1.52e-06 pd=7.1e-07 nrd=1.16667 \
        nrs=1.16667 sa=7.17326e-07 sb=1.22326e-07 sd=160n sca=26.1913 \
        scb=0.0299385 scc=0.0017385 m=(1)
C1 (B VSS) capacitor c=3.84051e-17
C2 (VDD VSS) capacitor c=3.51144e-17
C3 (C VSS) capacitor c=2.24632e-17
C4 (NW VSS) capacitor c=1.81229e-16
C5 (Y VSS) capacitor c=1.46343e-17
C6 (n0 VSS) capacitor c=6.39307e-17
C7 (\1\:AN VSS) capacitor c=4.08798e-17
C8 (\1\:B VSS) capacitor c=5.18918e-17
C9 (\3\:C VSS) capacitor c=5.20075e-17
C10 (\3\:AN VSS) capacitor c=3.8988e-17
C11 (\3\:n0 VSS) capacitor c=3.00054e-17
C12 (\3\:B VSS) capacitor c=4.71228e-17
C13 (\1\:C VSS) capacitor c=2.79712e-17
C14 (\2\:AN VSS) capacitor c=4.63377e-17
C15 (\2\:n0 VSS) capacitor c=5.81203e-17
C16 (\2\:B VSS) capacitor c=5.26549e-17
C17 (\2\:C VSS) capacitor c=4.39862e-17
C18 (\4\:n0 VSS) capacitor c=5.02769e-17
C19 (\1\:VDD VSS) capacitor c=6.63848e-17
C20 (\1\:Y VSS) capacitor c=4.07056e-17
C21 (\4\:VDD VSS) capacitor c=1.24222e-17
C22 (\3\:Y VSS) capacitor c=4.21205e-17
C23 (\8\:n0 VSS) capacitor c=1.87338e-17
C24 (\5\:Y VSS) capacitor c=6.7085e-17
C25 (\4\:C VSS) capacitor c=4.85573e-17
C26 (\4\:B VSS) capacitor c=2.76454e-17
C27 (\4\:AN VSS) capacitor c=6.74071e-17
C28 (\6\:AN VSS) capacitor c=4.63384e-17
C29 (\6\:n0 VSS) capacitor c=4.89806e-17
C30 (\7\:n0 VSS) capacitor c=4.7036e-17
C31 (\3\:VDD VSS) capacitor c=2.11061e-17
Rk2 (B \4\:B) resistor r=0.02441 c=0
Rk16 (\4\:VSS VSS) resistor r=0.2003 c=0
Rk15 (\2\:VSS \4\:VSS) resistor r=0.4089 c=0
Rk13 (\3\:VDD VDD) resistor r=0.1176 c=0
Rk12 (\2\:VDD \3\:VDD) resistor r=0.2189 c=0
Rk14 (\3\:VDD \5\:VDD) resistor r=0.05128 c=0
Rk1 (C \4\:C) resistor r=0.02587 c=0
Rk6 (\4\:AN \5\:AN) resistor r=0.006173 c=0
Rk7 (AN \6\:AN) resistor r=0.00607 c=0
Rk8 (\4\:AN \6\:AN) resistor r=0.06409 c=0
Rk5 (\4\:Y Y) resistor r=0.05294 c=0
Rk3 (\2\:Y \4\:Y) resistor r=0.2876 c=0
Rk4 (\4\:Y \6\:Y) resistor r=0.4768 c=0
Rk9 (\5\:n0 \6\:n0) resistor r=0.3387 c=0
Rk10 (\6\:n0 \7\:n0) resistor r=0.1884 c=0
Rk11 (\6\:n0 \9\:n0) resistor r=0.1249 c=0
Rl3 (\1\:B \2\:B) resistor r=75.6918 c=0
Rl4 (\2\:B \3\:B) resistor r=94.9225 c=0
Rl2 (\2\:C \3\:C) resistor r=129.319 c=0
Rl1 (\1\:C \2\:C) resistor r=38.3096 c=0
Rl7 (\1\:AN \2\:AN) resistor r=68.4057 c=0
Rl8 (\2\:AN \3\:AN) resistor r=95.3288 c=0
Rl5 (n0 \2\:n0) resistor r=137.637 c=0
Rl6 (\2\:n0 \3\:n0) resistor r=26.098 c=0
Rz3 (\1\:VSS \2\:VSS) resistor r=75 c=0
Rz1 (\5\:Y \6\:Y) resistor r=75 c=0
Rz2 (\8\:n0 \9\:n0) resistor r=75 c=0
Ry4 (\1\:VDD \2\:VDD) resistor r=62 c=0
Ry5 (\4\:VDD \5\:VDD) resistor r=62 c=0
Ry1 (\1\:Y \2\:Y) resistor r=62 c=0
Ry2 (\3\:Y \4\:Y) resistor r=62 c=0
Ry3 (\4\:n0 \5\:n0) resistor r=62 c=0
Rx2 (\2\:B \4\:B) resistor r=45 c=0
Rx1 (\2\:C \4\:C) resistor r=45 c=0
Rx3 (\2\:AN \5\:AN) resistor r=45 c=0
Rx4 (\2\:n0 \7\:n0) resistor r=45 c=0
mn3 (\5\:Y \1\:C n1 VSS) g45n1svt w=(1.45e-07) l=4.5e-08 nf=1 \
        as=1.957e-14 ad=2.03e-14 ps=5.6e-07 pd=5.7e-07 nrd=1.16667 \
        nrs=1.16667 sa=1.4e-07 sb=7.15e-07 sd=160n sca=13.6097 \
        scb=0.014254 scc=0.000755054 m=(1)
mn2 (n1 \3\:B n2 VSS) g45n1svt w=(1.45e-07) l=4.5e-08 nf=1 as=2.102e-14 \
        ad=1.957e-14 ps=5.8e-07 pd=5.6e-07 nrd=1.16667 nrs=1.16667 \
        sa=3.2e-07 sb=5.35e-07 sd=160n sca=13.6097 scb=0.014254 \
        scc=0.000755054 m=(1)
mn1 (n2 \3\:n0 \1\:VSS VSS) g45n1svt w=(1.45e-07) l=4.5e-08 nf=1 \
        as=2.32e-14 ad=2.102e-14 ps=6.1e-07 pd=5.8e-07 nrd=1.16667 \
        nrs=1.16667 sa=5.1e-07 sb=3.45e-07 sd=160n sca=13.6097 \
        scb=0.014254 scc=0.000755054 m=(1)
mn0 (\8\:n0 \3\:AN \1\:VSS VSS) g45n1svt w=(1.45e-07) l=4.5e-08 nf=1 \
        as=2.32e-14 ad=2.03e-14 ps=6.1e-07 pd=5.7e-07 nrd=1.16667 \
        nrs=1.16667 sa=7.15e-07 sb=1.4e-07 sd=160n sca=13.6097 \
        scb=0.014254 scc=0.000755054 m=(1)
ends NAND3BXL
// End of subcircuit definition.
