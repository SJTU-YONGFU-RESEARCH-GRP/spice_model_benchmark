// Generated for: spectre (May  1 11:27:12 2013 )
// Library name: gsclib045_backbias
// Cell name: AND4X6
// View name: extracted

simulator lang=spectre

subckt AND4X6 A B C D NW VDD VSS Y
mp3 (\16\:net116 \3\:D \15\:VDD NW) g45p1svt w=(3.9e-07) l=4.5e-08 nf=1 \
        as=1.128e-13 ad=6.24e-14 ps=1.67e-06 pd=1.1e-06 nrd=1.16667 \
        nrs=1.16667 sa=8.15e-07 sb=1.92013e-06 sd=160n sca=13.5671 \
        scb=0.012183 scc=0.000647513 m=(2)
mp0 (\16\:net116 A \1\:VDD NW) g45p1svt w=(3.9e-07) l=4.5e-08 nf=1 \
        as=1.1165e-13 ad=6.24e-14 ps=1.61e-06 pd=1.1e-06 nrd=1.16667 \
        nrs=1.16667 sa=1.4e-07 sb=1.98071e-06 sd=160n sca=18.0971 \
        scb=0.0181198 scc=0.000732406 m=(2)
mp1_1__rcx (\16\:net116 B \1\:VDD NW) g45p1svt w=(3.9e-07) l=4.5e-08 \
        nf=1 as=1.128e-13 ad=6.24e-14 ps=1.67e-06 pd=1.1e-06 nrd=1.16667 \
        nrs=1.16667 sa=3.45e-07 sb=1.96231e-06 sd=160n sca=15.113 \
        scb=0.013285 scc=0.000649598 m=(2)
mp2 (\16\:net116 \1\:C \1\:VDD NW) g45p1svt w=(3.9e-07) l=4.5e-08 nf=1 \
        as=1.128e-13 ad=6.24e-14 ps=1.67e-06 pd=1.1e-06 nrd=1.16667 \
        nrs=1.16667 sa=6.1e-07 sb=1.93853e-06 sd=160n sca=13.8524 \
        scb=0.01226 scc=0.000647526 m=(2)
C1 (NW VSS) capacitor c=4.09782e-16
C2 (Y VSS) capacitor c=1.3871e-17
C3 (B VSS) capacitor c=5.35954e-16
C4 (VDD VSS) capacitor c=2.92431e-17
C5 (D VSS) capacitor c=4.43043e-17
C6 (A VSS) capacitor c=6.55865e-16
C7 (12 VSS) capacitor c=8.18896e-18
C8 (net116 VSS) capacitor c=2.84616e-16
C9 (13 VSS) capacitor c=2.27984e-18
C10 (14 VSS) capacitor c=8.35121e-18
C11 (15 VSS) capacitor c=2.26439e-18
C12 (\6\:A VSS) capacitor c=8.10804e-17
C13 (\6\:B VSS) capacitor c=7.53585e-17
C14 (\7\:C VSS) capacitor c=5.33809e-17
C15 (\1\:D VSS) capacitor c=6.33252e-17
C16 (\5\:D VSS) capacitor c=1.76577e-17
C17 (\3\:C VSS) capacitor c=3.95852e-17
C18 (\3\:B VSS) capacitor c=6.5123e-17
C19 (\1\:A VSS) capacitor c=5.99855e-17
C20 (\2\:D VSS) capacitor c=2.80293e-17
C21 (\1\:C VSS) capacitor c=4.13998e-16
C22 (\1\:Y VSS) capacitor c=2.4527e-16
C23 (\1\:VDD VSS) capacitor c=6.16535e-16
C24 (\16\:net116 VSS) capacitor c=3.69583e-16
C25 (\15\:VDD VSS) capacitor c=2.811e-17
C26 (\24\:net116 VSS) capacitor c=8.59358e-17
C27 (\3\:D VSS) capacitor c=1.1944e-16
C28 (\7\:D VSS) capacitor c=3.27801e-17
C29 (\14\:net116 VSS) capacitor c=7.61827e-17
C30 (\15\:net116 VSS) capacitor c=1.2307e-16
C31 (\4\:Y VSS) capacitor c=2.14436e-16
Rk15 (\1\:Y Y) resistor r=0.04656 c=0
Rk16 (Y \4\:Y) resistor r=0.1832 c=0
Rk39 (\1\:VSS \7\:VSS) resistor r=0.3782 c=0
Rk41 (\8\:VSS VSS) resistor r=0.1248 c=0
Rk40 (\7\:VSS \8\:VSS) resistor r=0.4258 c=0
Rk44 (\8\:VSS \14\:VSS) resistor r=0.2027 c=0
Rk29 (\1\:VDD VDD) resistor r=0.08224 c=0
Rk33 (\1\:VDD \16\:VDD) resistor r=0.102 c=0
Rk3 (\1\:C C) resistor r=0.009678 c=0
Rk1 (\7\:D D) resistor r=0.2106 c=0
Rk9 (\15\:net116 \16\:net116) resistor r=0.5321 c=0
Rk8 (\14\:net116 \15\:net116) resistor r=0.3077 c=0
Rk13 (\15\:net116 \25\:net116) resistor r=0.7326 c=0
Rl16 (B \6\:B) resistor r=126.098 c=0
Rl4 (B \3\:B) resistor r=110.713 c=0
Rl14 (\1\:C \7\:C) resistor r=45.3297 c=0
Rl6 (\1\:C \3\:C) resistor r=110.418 c=0
Rl8 (\2\:D \1\:D) resistor r=105.323 c=0
Rl11 (\2\:D \5\:D) resistor r=24.2328 c=0
Rl9 (\3\:D \2\:D) resistor r=87.3759 c=0
Rl18 (A \6\:A) resistor r=115.18 c=0
Rl1 (A \1\:A) resistor r=116.483 c=0
Rz8 (\14\:VSS \13\:VSS) resistor r=75 c=0
Rz1 (\25\:net116 \24\:net116) resistor r=75 c=0
Ry15 (\1\:VSS \3\:VSS) resistor r=12.4 c=0
Ry16 (\7\:VSS \3\:VSS) resistor r=5.1667 c=0
Ry12 (\16\:VDD \15\:VDD) resistor r=62 c=0
Rx1 (\7\:D \2\:D) resistor r=45 c=0
Rx8 (\14\:net116 net116) resistor r=22.5 c=0
mn0_1__rcx (10 \1\:A \13\:VSS VSS) g45n1svt w=(2.6e-07) l=4.5e-08 nf=1 \
        as=3.64e-14 ad=1.95e-14 ps=8e-07 pd=6.7e-07 nrd=1.16667 \
        nrs=1.16667 sa=1.4e-07 sb=2e-06 sd=160n sca=9.14564 scb=0.00759168 \
        scc=0.000213449 m=(1)
mn1_1__rcx (11 \3\:B 10 VSS) g45n1svt w=(2.6e-07) l=4.5e-08 nf=1 \
        as=1.95e-14 ad=5.72e-14 ps=6.7e-07 pd=9.6e-07 nrd=1.16667 \
        nrs=1.16667 sa=2.6e-07 sb=2e-06 sd=160n sca=9.14564 scb=0.00759168 \
        scc=0.000213449 m=(1)
mn2_1__rcx (11 \3\:C 12 VSS) g45n1svt w=(2.6e-07) l=4.5e-08 nf=1 \
        as=6.76e-14 ad=5.72e-14 ps=1.04e-06 pd=9.6e-07 nrd=1.16667 \
        nrs=1.16667 sa=5.25e-07 sb=2e-06 sd=160n sca=9.14564 \
        scb=0.00759168 scc=0.000213449 m=(1)
mn3_1__rcx (\24\:net116 \5\:D 12 VSS) g45n1svt w=(2.6e-07) l=4.5e-08 nf=1 \
        as=6.76e-14 ad=4.16e-14 ps=1.04e-06 pd=8.4e-07 nrd=1.16667 \
        nrs=1.16667 sa=8.3e-07 sb=1.99e-06 sd=160n sca=9.14564 \
        scb=0.00759168 scc=0.000213449 m=(1)
mn3 (\24\:net116 \1\:D 13 VSS) g45n1svt w=(2.6e-07) l=4.5e-08 nf=1 \
        as=1.69e-14 ad=4.16e-14 ps=6.5e-07 pd=8.4e-07 nrd=1.16667 \
        nrs=1.16667 sa=1.035e-06 sb=1.785e-06 sd=160n sca=9.14564 \
        scb=0.00759168 scc=0.000213449 m=(1)
mn2 (13 \7\:C 14 VSS) g45n1svt w=(2.6e-07) l=4.5e-08 nf=1 as=7.15e-14 \
        ad=1.69e-14 ps=1.07e-06 pd=6.5e-07 nrd=1.16667 nrs=1.16667 \
        sa=1.145e-06 sb=1.675e-06 sd=160n sca=9.14564 scb=0.00759168 \
        scc=0.000213449 m=(1)
mn1 (15 \6\:B 14 VSS) g45n1svt w=(2.6e-07) l=4.5e-08 nf=1 as=7.15e-14 \
        ad=1.56e-14 ps=1.07e-06 pd=6.4e-07 nrd=1.16667 nrs=1.16667 \
        sa=1.465e-06 sb=1.355e-06 sd=160n sca=9.14564 scb=0.00759168 \
        scc=0.000213449 m=(1)
mn0 (15 \6\:A \1\:VSS VSS) g45n1svt w=(2.6e-07) l=4.5e-08 nf=1 \
        as=6.87e-14 ad=1.56e-14 ps=1.11e-06 pd=6.4e-07 nrd=1.16667 \
        nrs=1.16667 sa=1.57e-06 sb=1.25e-06 sd=160n sca=9.14564 \
        scb=0.00759168 scc=0.000213449 m=(1)
mn4_1__rcx (\4\:Y net116 \1\:VSS VSS) g45n1svt w=(3.1e-07) l=4.5e-08 \
        nf=1 as=5.342e-14 ad=4.836e-14 ps=9.74e-07 pd=9.32e-07 nrd=1.16667 \
        nrs=1.16667 sa=1.57613e-06 sb=9.6e-07 sd=160n sca=10.4852 \
        scb=0.00950193 scc=0.000416321 m=(5)
mp4_1__rcx (\1\:Y net116 \1\:VDD NW) g45p1svt w=(4.7e-07) l=4.5e-08 nf=1 \
        as=9.39e-14 ad=7.332e-14 ps=1.44e-06 pd=1.252e-06 nrd=1.16667 \
        nrs=1.16667 sa=1.53511e-06 sb=9.6e-07 sd=160n sca=26.9787 \
        scb=0.0178954 scc=0.0027966 m=(5)
ends AND4X6
// End of subcircuit definition.
