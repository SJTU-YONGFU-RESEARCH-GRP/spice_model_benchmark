// Generated for: spectre (May  1 11:28:59 2013 )
// Library name: gsclib045_backbias
// Cell name: DFFSRHQX4
// View name: extracted

simulator lang=spectre

subckt DFFSRHQX4 CK D NW Q RN SN VDD VSS
mp55_1__rcx (Q qbint \8\:VDD NW) g45p1svt w=(3.9e-07) l=4.5e-08 nf=1 \
        as=5.925e-14 ad=6.727e-14 ps=1.09e-06 pd=1.125e-06 nrd=1.16667 \
        nrs=1.16667 sa=1.4e-07 sb=1.26436e-06 sd=160n sca=23.6869 \
        scb=0.022528 scc=0.00180834 m=(4)
C1 (RN VSS) capacitor c=4.76846e-17
C2 (VDD VSS) capacitor c=2.90289e-17
C3 (NW VSS) capacitor c=9.60723e-16
C4 (D VSS) capacitor c=5.97066e-17
C5 (Q VSS) capacitor c=2.61523e-16
C6 (qbint VSS) capacitor c=2.60196e-16
C7 (n35 VSS) capacitor c=1.83936e-17
C8 (RNb VSS) capacitor c=2.52329e-17
C9 (n40 VSS) capacitor c=7.76128e-17
C10 (n42 VSS) capacitor c=1.32548e-16
C11 (CKb VSS) capacitor c=3.92168e-17
C12 (mout VSS) capacitor c=1.00022e-16
C13 (CKbb VSS) capacitor c=2.7593e-17
C14 (n25 VSS) capacitor c=5.49539e-17
C15 (n20 VSS) capacitor c=4.03733e-17
C16 (n30 VSS) capacitor c=2.00257e-18
C17 (n43 VSS) capacitor c=8.35437e-19
C18 (n41 VSS) capacitor c=9.07667e-17
C19 (n26 VSS) capacitor c=5.75359e-18
C20 (n31 VSS) capacitor c=6.28923e-18
C21 (n22 VSS) capacitor c=2.92289e-18
C22 (\1\:CK VSS) capacitor c=2.64012e-17
C23 (\9\:CKb VSS) capacitor c=5.64681e-17
C24 (\1\:D VSS) capacitor c=6.7214e-17
C25 (\5\:CKbb VSS) capacitor c=3.80915e-17
C26 (\5\:CKb VSS) capacitor c=3.59993e-17
C27 (\4\:mout VSS) capacitor c=4.92966e-17
C28 (\6\:SN VSS) capacitor c=7.45625e-17
C29 (\3\:n20 VSS) capacitor c=6.37411e-17
C30 (\6\:RNb VSS) capacitor c=1.19837e-16
C31 (\3\:CKb VSS) capacitor c=4.36181e-17
C32 (\3\:CKbb VSS) capacitor c=5.10122e-17
C33 (\1\:SN VSS) capacitor c=4.93783e-17
C34 (\15\:qbint VSS) capacitor c=9.77578e-17
C35 (\2\:RNb VSS) capacitor c=5.73805e-17
C36 (\3\:RN VSS) capacitor c=4.14765e-17
C37 (\3\:CK VSS) capacitor c=2.19379e-17
C38 (\11\:CKb VSS) capacitor c=2.52134e-17
C39 (\3\:D VSS) capacitor c=5.64441e-17
C40 (\7\:CKb VSS) capacitor c=5.29246e-17
C41 (\9\:CKbb VSS) capacitor c=6.5801e-17
C42 (\5\:SN VSS) capacitor c=9.01512e-17
C43 (\4\:n20 VSS) capacitor c=3.37067e-17
C44 (\8\:RNb VSS) capacitor c=4.32389e-17
C45 (\3\:SN VSS) capacitor c=4.70152e-17
C46 (\18\:qbint VSS) capacitor c=3.10153e-17
C47 (\5\:RNb VSS) capacitor c=4.81474e-17
C48 (\1\:RN VSS) capacitor c=3.55298e-17
C49 (\2\:CK VSS) capacitor c=2.20061e-17
C50 (\10\:CKb VSS) capacitor c=4.69058e-17
C51 (\4\:D VSS) capacitor c=2.61566e-17
C52 (\6\:CKbb VSS) capacitor c=5.11154e-17
C53 (\8\:CKb VSS) capacitor c=3.17945e-17
C54 (\6\:CKb VSS) capacitor c=4.82763e-17
C55 (\8\:CKbb VSS) capacitor c=3.7634e-17
C56 (\3\:mout VSS) capacitor c=2.1777e-17
C57 (\7\:SN VSS) capacitor c=2.55215e-17
C58 (\4\:CKbb VSS) capacitor c=3.58823e-17
C59 (\4\:CKb VSS) capacitor c=4.02672e-17
C60 (\2\:CKb VSS) capacitor c=2.38615e-17
C61 (\7\:RNb VSS) capacitor c=7.6346e-17
C62 (\4\:SN VSS) capacitor c=2.01777e-17
C63 (\17\:qbint VSS) capacitor c=3.24945e-17
C64 (\4\:RNb VSS) capacitor c=3.19002e-17
C65 (\2\:RN VSS) capacitor c=3.93545e-17
C66 (\8\:qbint VSS) capacitor c=2.09935e-17
C67 (\1\:VDD VSS) capacitor c=8.99182e-17
C68 (\20\:CKb VSS) capacitor c=6.90735e-17
C69 (\16\:CKbb VSS) capacitor c=1.92062e-17
C70 (\12\:VDD VSS) capacitor c=3.20971e-17
C71 (\5\:n20 VSS) capacitor c=9.70541e-17
C72 (\14\:VDD VSS) capacitor c=5.93403e-17
C73 (\6\:mout VSS) capacitor c=1.87036e-16
C74 (\16\:VDD VSS) capacitor c=5.3358e-17
C75 (\9\:mout VSS) capacitor c=3.52769e-17
C76 (\9\:n35 VSS) capacitor c=7.63892e-17
C77 (\18\:VDD VSS) capacitor c=3.19866e-17
C78 (\3\:n41 VSS) capacitor c=7.99108e-17
C79 (\20\:VDD VSS) capacitor c=4.73344e-17
C80 (\12\:RNb VSS) capacitor c=6.00164e-17
C81 (\25\:qbint VSS) capacitor c=6.31943e-17
C82 (\18\:CKb VSS) capacitor c=1.10354e-16
C83 (\12\:CKbb VSS) capacitor c=9.93e-17
C84 (\7\:n20 VSS) capacitor c=9.48231e-17
C85 (\14\:mout VSS) capacitor c=1.39369e-16
C86 (\3\:n25 VSS) capacitor c=6.87093e-17
C87 (\12\:mout VSS) capacitor c=1.18962e-16
C88 (\13\:n35 VSS) capacitor c=6.39083e-17
C89 (\3\:n42 VSS) capacitor c=1.29125e-16
C90 (\3\:n40 VSS) capacitor c=9.41385e-17
C91 (\9\:RNb VSS) capacitor c=5.71471e-17
C92 (\23\:qbint VSS) capacitor c=2.17745e-17
C93 (\2\:n35 VSS) capacitor c=2.01991e-16
C94 (\3\:RNb VSS) capacitor c=5.79987e-17
C95 (\16\:qbint VSS) capacitor c=2.99164e-17
C96 (\2\:SN VSS) capacitor c=3.26016e-17
C97 (\2\:CKbb VSS) capacitor c=6.33545e-17
C98 (\2\:n20 VSS) capacitor c=2.90099e-17
C99 (\2\:mout VSS) capacitor c=5.68744e-17
C100 (\7\:CKbb VSS) capacitor c=4.83101e-17
C101 (\2\:D VSS) capacitor c=4.48345e-17
C102 (\4\:RN VSS) capacitor c=4.60385e-17
C103 (\11\:RNb VSS) capacitor c=6.38908e-17
C104 (\19\:qbint VSS) capacitor c=1.62185e-16
C105 (\20\:qbint VSS) capacitor c=1.3811e-16
C106 (\21\:qbint VSS) capacitor c=3.24395e-17
C107 (\22\:qbint VSS) capacitor c=2.81797e-17
C108 (\14\:RNb VSS) capacitor c=9.76506e-17
C109 (\15\:RNb VSS) capacitor c=7.92981e-17
C110 (\11\:n35 VSS) capacitor c=2.70203e-16
C111 (\12\:n35 VSS) capacitor c=2.71347e-16
C112 (\8\:SN VSS) capacitor c=2.32343e-16
C113 (\9\:SN VSS) capacitor c=2.58565e-16
C114 (\5\:mout VSS) capacitor c=5.99315e-17
C115 (\8\:mout VSS) capacitor c=1.50113e-16
C116 (\10\:CKbb VSS) capacitor c=2.03779e-16
C117 (\11\:CKbb VSS) capacitor c=1.8654e-16
C118 (\9\:n20 VSS) capacitor c=7.09107e-17
C119 (\5\:D VSS) capacitor c=5.2635e-17
C120 (\14\:CKbb VSS) capacitor c=9.87274e-17
C121 (\15\:CKbb VSS) capacitor c=6.16961e-17
C122 (\12\:CKb VSS) capacitor c=1.09186e-16
C123 (\13\:CKb VSS) capacitor c=3.70362e-16
C124 (\14\:CKb VSS) capacitor c=3.09234e-16
C125 (\15\:CKb VSS) capacitor c=1.29688e-16
C126 (\16\:CKb VSS) capacitor c=4.43375e-17
C127 (\17\:CKb VSS) capacitor c=1.22839e-16
C128 (\4\:CK VSS) capacitor c=9.0789e-17
C129 (\3\:VDD VSS) capacitor c=1.19207e-16
C130 (\4\:VDD VSS) capacitor c=1.09302e-16
C131 (\5\:VDD VSS) capacitor c=1.30994e-16
C132 (\6\:VDD VSS) capacitor c=1.30179e-16
C133 (\7\:VDD VSS) capacitor c=7.49095e-17
C134 (\8\:VDD VSS) capacitor c=4.29136e-16
Rk23 (\8\:SN SN) resistor r=1.8473 c=0
Rk24 (SN \9\:SN) resistor r=0.06253 c=0
Rk65 (\2\:VSS \3\:VSS) resistor r=0.07755 c=0
Rk66 (\3\:VSS \4\:VSS) resistor r=0.4209 c=0
Rk67 (\4\:VSS \5\:VSS) resistor r=0.1528 c=0
Rk68 (\5\:VSS \6\:VSS) resistor r=0.2556 c=0
Rk69 (\6\:VSS \7\:VSS) resistor r=0.9478 c=0
Rk70 (\7\:VSS \8\:VSS) resistor r=0.2521 c=0
Rk76 (\9\:VSS VSS) resistor r=0.0798 c=0
Rk71 (\8\:VSS \9\:VSS) resistor r=0.7761 c=0
Rk77 (\3\:VSS \15\:VSS) resistor r=0.2911 c=0
Rk78 (\4\:VSS \17\:VSS) resistor r=0.3201 c=0
Rk79 (\6\:VSS \19\:VSS) resistor r=0.2443 c=0
Rk80 (\8\:VSS \21\:VSS) resistor r=0.04331 c=0
Rk7 (RN \4\:RN) resistor r=0.05865 c=0
Rk46 (\2\:VDD \3\:VDD) resistor r=0.8295 c=0
Rk47 (\3\:VDD \4\:VDD) resistor r=0.5112 c=0
Rk48 (\4\:VDD \5\:VDD) resistor r=0.4736 c=0
Rk49 (\5\:VDD \6\:VDD) resistor r=0.7335 c=0
Rk50 (\6\:VDD \7\:VDD) resistor r=0.3372 c=0
Rk55 (\8\:VDD VDD) resistor r=0.0798 c=0
Rk51 (\7\:VDD \8\:VDD) resistor r=0.3808 c=0
Rk56 (\3\:VDD \13\:VDD) resistor r=0.2477 c=0
Rk57 (\4\:VDD \15\:VDD) resistor r=0.2656 c=0
Rk58 (\5\:VDD \17\:VDD) resistor r=0.1728 c=0
Rk59 (\6\:VDD \19\:VDD) resistor r=0.04331 c=0
Rk60 (\7\:VDD \21\:VDD) resistor r=0.1561 c=0
Rk45 (CK \4\:CK) resistor r=0.0153 c=0
Rk34 (D \5\:D) resistor r=0.08008 c=0
Rk10 (\19\:qbint \20\:qbint) resistor r=1.2162 c=0
Rk11 (\20\:qbint \21\:qbint) resistor r=0.1152 c=0
Rk12 (\21\:qbint \22\:qbint) resistor r=0.1482 c=0
Rk13 (\20\:qbint \24\:qbint) resistor r=0.06093 c=0
Rk14 (\21\:qbint \26\:qbint) resistor r=0.3308 c=0
Rk19 (\10\:n35 \11\:n35) resistor r=0.1886 c=0
Rk20 (\11\:n35 \12\:n35) resistor r=1.9986 c=0
Rk21 (\11\:n35 \14\:n35) resistor r=0.2625 c=0
Rk8 (\10\:RNb \11\:RNb) resistor r=0.1815 c=0
Rk9 (\11\:RNb \13\:RNb) resistor r=0.1938 c=0
Rk16 (\14\:RNb \15\:RNb) resistor r=0.6195 c=0
Rk17 (\2\:n40 \4\:n40) resistor r=0.623 c=0
Rk15 (\2\:n42 \4\:n42) resistor r=0.8462 c=0
Rk38 (\12\:CKb \13\:CKb) resistor r=0.8894 c=0
Rk39 (\13\:CKb \14\:CKb) resistor r=1.8388 c=0
Rk40 (\14\:CKb \15\:CKb) resistor r=0.8798 c=0
Rk41 (\14\:CKb \16\:CKb) resistor r=0.1205 c=0
Rk42 (\15\:CKb \17\:CKb) resistor r=0.3403 c=0
Rk43 (\17\:CKb \19\:CKb) resistor r=0.5888 c=0
Rk44 (\19\:CKb \21\:CKb) resistor r=0.3865 c=0
Rk25 (\5\:mout \7\:mout) resistor r=0.2798 c=0
Rk26 (\7\:mout \8\:mout) resistor r=0.9427 c=0
Rk27 (\8\:mout \10\:mout) resistor r=0.1127 c=0
Rk28 (\8\:mout \11\:mout) resistor r=0.234 c=0
Rk29 (\11\:mout \13\:mout) resistor r=0.05313 c=0
Rk30 (\11\:mout \15\:mout) resistor r=0.7334 c=0
Rk31 (\10\:CKbb \11\:CKbb) resistor r=1.2728 c=0
Rk35 (\13\:CKbb \14\:CKbb) resistor r=0.5601 c=0
Rk36 (\14\:CKbb \15\:CKbb) resistor r=0.42 c=0
Rk37 (\14\:CKbb \17\:CKbb) resistor r=0.07802 c=0
Rk22 (\2\:n25 \4\:n25) resistor r=0.3098 c=0
Rk32 (\6\:n20 \8\:n20) resistor r=0.5043 c=0
Rk33 (\8\:n20 \9\:n20) resistor r=0.4955 c=0
Rk18 (\2\:n41 \4\:n41) resistor r=0.2898 c=0
Rl43 (\5\:SN \6\:SN) resistor r=199.566 c=0
Rl44 (\6\:SN \7\:SN) resistor r=24.2328 c=0
Rl30 (\1\:SN \2\:SN) resistor r=51.1566 c=0
Rl31 (\2\:SN \3\:SN) resistor r=156.926 c=0
Rl32 (\2\:SN \4\:SN) resistor r=63.8348 c=0
Rl22 (\2\:RN \3\:RN) resistor r=62.6374 c=0
Rl21 (\1\:RN \2\:RN) resistor r=88.4615 c=0
Rl59 (\1\:CK \2\:CK) resistor r=71.1538 c=0
Rl60 (\2\:CK \3\:CK) resistor r=39.5604 c=0
Rl54 (\1\:D \2\:D) resistor r=64.8465 c=0
Rl55 (\2\:D \3\:D) resistor r=111.048 c=0
Rl56 (\2\:D \4\:D) resistor r=4.5402 c=0
Rl7 (qbint \8\:qbint) resistor r=5.1512 c=0
Rl27 (\16\:qbint \15\:qbint) resistor r=120.868 c=0
Rl29 (\16\:qbint \18\:qbint) resistor r=34.3295 c=0
Rl28 (\16\:qbint \17\:qbint) resistor r=8.3038 c=0
Rl14 (\2\:n35 n35) resistor r=1.2713 c=0
Rl39 (\6\:RNb \8\:RNb) resistor r=119.231 c=0
Rl38 (\6\:RNb \7\:RNb) resistor r=718.744 c=0
Rl23 (RNb \2\:RNb) resistor r=29.5379 c=0
Rl24 (\2\:RNb \3\:RNb) resistor r=117.286 c=0
Rl26 (\3\:RNb \5\:RNb) resistor r=82.3738 c=0
Rl25 (\3\:RNb \4\:RNb) resistor r=138.387 c=0
Rl57 (\9\:CKb \10\:CKb) resistor r=164.56 c=0
Rl58 (\10\:CKb \11\:CKb) resistor r=26.098 c=0
Rl49 (\7\:CKb \8\:CKb) resistor r=28.079 c=0
Rl48 (\5\:CKb \6\:CKb) resistor r=24.2328 c=0
Rl34 (\3\:CKb \4\:CKb) resistor r=29.5379 c=0
Rl33 (CKb \2\:CKb) resistor r=29.5379 c=0
Rl47 (\2\:mout \4\:mout) resistor r=34.3295 c=0
Rl45 (mout \2\:mout) resistor r=178.126 c=0
Rl46 (\2\:mout \3\:mout) resistor r=4.3144 c=0
Rl50 (\5\:CKbb \6\:CKbb) resistor r=24.7951 c=0
Rl36 (\2\:CKbb \3\:CKbb) resistor r=159.159 c=0
Rl35 (CKbb \2\:CKbb) resistor r=34.2969 c=0
Rl37 (\2\:CKbb \4\:CKbb) resistor r=165.959 c=0
Rl53 (\7\:CKbb \9\:CKbb) resistor r=85.2786 c=0
Rl51 (\6\:CKbb \7\:CKbb) resistor r=173.363 c=0
Rl52 (\7\:CKbb \8\:CKbb) resistor r=5.8511 c=0
Rl41 (\2\:n20 \3\:n20) resistor r=91.7544 c=0
Rl42 (\2\:n20 \4\:n20) resistor r=25.6317 c=0
Rl40 (n20 \2\:n20) resistor r=73.9835 c=0
Rz17 (\15\:VSS \14\:VSS) resistor r=75 c=0
Rz18 (\17\:VSS \16\:VSS) resistor r=75 c=0
Rz19 (\19\:VSS \18\:VSS) resistor r=75 c=0
Rz20 (\21\:VSS \20\:VSS) resistor r=75 c=0
Rz4 (\24\:qbint \23\:qbint) resistor r=75 c=0
Rz9 (\14\:n35 \13\:n35) resistor r=75 c=0
Rz3 (\9\:RNb \10\:RNb) resistor r=75 c=0
Rz7 (n40 \2\:n40) resistor r=75 c=0
Rz8 (\3\:n40 \4\:n40) resistor r=75 c=0
Rz5 (n42 \2\:n42) resistor r=75 c=0
Rz6 (\3\:n42 \4\:n42) resistor r=75 c=0
Rz16 (\18\:CKb \19\:CKb) resistor r=75 c=0
Rz12 (\12\:mout \13\:mout) resistor r=75 c=0
Rz13 (\14\:mout \15\:mout) resistor r=75 c=0
Rz15 (\12\:CKbb \13\:CKbb) resistor r=75 c=0
Rz10 (n25 \2\:n25) resistor r=75 c=0
Rz11 (\3\:n25 \4\:n25) resistor r=75 c=0
Rz14 (\7\:n20 \8\:n20) resistor r=75 c=0
Ry23 (\2\:VSS \1\:VSS) resistor r=62 c=0
Ry24 (\5\:VSS \1\:VSS) resistor r=5.1667 c=0
Ry25 (\7\:VSS \1\:VSS) resistor r=5.1667 c=0
Ry26 (\9\:VSS \1\:VSS) resistor r=5.1667 c=0
Ry13 (\2\:VDD \1\:VDD) resistor r=62 c=0
Ry14 (\13\:VDD \12\:VDD) resistor r=62 c=0
Ry15 (\15\:VDD \14\:VDD) resistor r=62 c=0
Ry16 (\17\:VDD \16\:VDD) resistor r=62 c=0
Ry17 (\19\:VDD \18\:VDD) resistor r=62 c=0
Ry18 (\21\:VDD \20\:VDD) resistor r=62 c=0
Ry4 (\26\:qbint \25\:qbint) resistor r=62 c=0
Ry7 (\10\:n35 \9\:n35) resistor r=31 c=0
Ry3 (\12\:RNb \13\:RNb) resistor r=62 c=0
Ry12 (\20\:CKb \21\:CKb) resistor r=62 c=0
Ry8 (\6\:mout \7\:mout) resistor r=62 c=0
Ry9 (\9\:mout \10\:mout) resistor r=62 c=0
Ry11 (\16\:CKbb \17\:CKbb) resistor r=62 c=0
Ry10 (\5\:n20 \6\:n20) resistor r=62 c=0
Ry5 (n41 \2\:n41) resistor r=62 c=0
Ry6 (\3\:n41 \4\:n41) resistor r=62 c=0
Rx8 (\7\:SN \8\:SN) resistor r=45 c=0
Rx9 (\4\:SN \9\:SN) resistor r=45 c=0
Rx1 (\2\:RN \4\:RN) resistor r=45 c=0
Rx21 (\2\:CK \4\:CK) resistor r=45 c=0
Rx14 (\4\:D \5\:D) resistor r=45 c=0
Rx3 (\19\:qbint \17\:qbint) resistor r=45 c=0
Rx4 (\22\:qbint \8\:qbint) resistor r=45 c=0
Rx7 (\12\:n35 n35) resistor r=45 c=0
Rx2 (\4\:RNb \11\:RNb) resistor r=45 c=0
Rx5 (\7\:RNb \14\:RNb) resistor r=45 c=0
Rx6 (RNb \15\:RNb) resistor r=45 c=0
Rx16 (\2\:CKb \12\:CKb) resistor r=45 c=0
Rx17 (\4\:CKb \13\:CKb) resistor r=45 c=0
Rx18 (\8\:CKb \15\:CKb) resistor r=45 c=0
Rx19 (\6\:CKb \16\:CKb) resistor r=45 c=0
Rx20 (\10\:CKb \17\:CKb) resistor r=45 c=0
Rx10 (\3\:mout \5\:mout) resistor r=45 c=0
Rx11 (\8\:CKbb \10\:CKbb) resistor r=45 c=0
Rx12 (\4\:CKbb \11\:CKbb) resistor r=45 c=0
Rx15 (\6\:CKbb \15\:CKbb) resistor r=45 c=0
Rx13 (n20 \9\:n20) resistor r=45 c=0
mn55_1__rcx (Q qbint \9\:VSS VSS) g45n1svt w=(2.6e-07) l=4.5e-08 nf=1 \
        as=4.076e-14 ad=4.16e-14 ps=8.425e-07 pd=8.4e-07 nrd=1.16667 \
        nrs=1.16667 sa=1.4e-07 sb=1.1626e-06 sd=160n sca=9.14564 \
        scb=0.00759168 scc=0.000213449 m=(4)
mn51 (\3\:n40 \5\:RNb n42 VSS) g45n1svt w=(2.05e-07) l=4.5e-08 nf=1 \
        as=5.638e-14 ad=4.1e-14 ps=9.6e-07 pd=8.1e-07 nrd=1.16667 \
        nrs=1.16667 sa=2.75e-07 sb=5.95488e-07 sd=160n sca=13.0797 \
        scb=0.0132969 scc=0.000723565 m=(1)
mn52 (\3\:n40 \18\:qbint \3\:n42 VSS) g45n1svt w=(2.05e-07) l=4.5e-08 \
        nf=1 as=3.588e-14 ad=4.1e-14 ps=7.6e-07 pd=8.1e-07 nrd=1.16667 \
        nrs=1.16667 sa=5.2e-07 sb=3.50488e-07 sd=160n sca=13.0797 \
        scb=0.0132969 scc=0.000723565 m=(1)
mn50 (\3\:n42 \3\:SN \20\:VSS VSS) g45n1svt w=(2.05e-07) l=4.5e-08 nf=1 \
        as=5.305e-14 ad=3.588e-14 ps=1.66e-06 pd=7.6e-07 nrd=1.16667 \
        nrs=1.16667 sa=7.4e-07 sb=1.30488e-07 sd=160n sca=13.0797 \
        scb=0.0132969 scc=0.000723565 m=(1)
mn53 (\13\:n35 CKb n40 VSS) g45n1svt w=(2.05e-07) l=4.5e-08 nf=1 \
        as=3.55e-14 ad=5.125e-14 ps=8.6e-07 pd=9.1e-07 nrd=1.16667 \
        nrs=1.16667 sa=1.73171e-07 sb=5.8e-07 sd=160n sca=13.8179 \
        scb=0.0141903 scc=0.000851218 m=(1)
mn40 (\13\:n35 CKbb \12\:mout VSS) g45n1svt w=(2.05e-07) l=4.5e-08 nf=1 \
        as=5.843e-14 ad=5.125e-14 ps=9.8e-07 pd=9.1e-07 nrd=1.16667 \
        nrs=1.16667 sa=4.68171e-07 sb=2.85e-07 sd=160n sca=13.8179 \
        scb=0.0141903 scc=0.000851218 m=(1)
mn31 (\14\:mout \8\:RNb \3\:n25 VSS) g45n1svt w=(2.05e-07) l=4.5e-08 nf=1 \
        as=2.87e-14 ad=3.588e-14 ps=6.9e-07 pd=7.6e-07 nrd=1.16667 \
        nrs=1.16667 sa=1.4e-07 sb=1.42902e-06 sd=160n sca=12.7388 \
        scb=0.0128661 scc=0.000666764 m=(1)
mn32 (\14\:mout \4\:n20 n25 VSS) g45n1svt w=(2.05e-07) l=4.5e-08 nf=1 \
        as=6.115e-14 ad=3.588e-14 ps=1.17e-06 pd=7.6e-07 nrd=1.16667 \
        nrs=1.16667 sa=3.6e-07 sb=1.20902e-06 sd=160n sca=12.7388 \
        scb=0.0128661 scc=0.000666764 m=(1)
mn30 (n25 \5\:SN \18\:VSS VSS) g45n1svt w=(2.05e-07) l=4.5e-08 nf=1 \
        as=3.28e-14 ad=6.115e-14 ps=7.3e-07 pd=1.17e-06 nrd=1.16667 \
        nrs=1.16667 sa=5.80122e-07 sb=1.03805e-06 sd=160n sca=10.1075 \
        scb=0.00913344 scc=0.000289639 m=(1)
mn35 (n30 mout \18\:VSS VSS) g45n1svt w=(2.05e-07) l=4.5e-08 nf=1 \
        as=3.28e-14 ad=1.23e-14 ps=7.3e-07 pd=5.3e-07 nrd=1.16667 \
        nrs=1.16667 sa=7.85122e-07 sb=8.33049e-07 sd=160n sca=10.1075 \
        scb=0.00913344 scc=0.000289639 m=(1)
mn36 (\7\:n20 \9\:CKbb n30 VSS) g45n1svt w=(2.05e-07) l=4.5e-08 nf=1 \
        as=1.23e-14 ad=5.97e-14 ps=5.3e-07 pd=1.1e-06 nrd=1.16667 \
        nrs=1.16667 sa=8.90122e-07 sb=7.28049e-07 sd=160n sca=10.1075 \
        scb=0.00913344 scc=0.000289639 m=(1)
mn26 (\7\:n20 \7\:CKb n21 VSS) g45n1svt w=(2.05e-07) l=4.5e-08 nf=1 \
        as=2.153e-14 ad=5.97e-14 ps=6.2e-07 pd=1.1e-06 nrd=1.16667 \
        nrs=1.16667 sa=1.13159e-06 sb=5.25854e-07 sd=160n sca=11.814 \
        scb=0.0116374 scc=0.000520744 m=(1)
mn25 (n21 \3\:D \16\:VSS VSS) g45n1svt w=(2.05e-07) l=4.5e-08 nf=1 \
        as=3.79e-14 ad=2.153e-14 ps=8.5e-07 pd=6.2e-07 nrd=1.16667 \
        nrs=1.16667 sa=1.28159e-06 sb=3.75854e-07 sd=160n sca=11.814 \
        scb=0.0116374 scc=0.000520744 m=(1)
mn45 (\23\:qbint \2\:n35 \9\:VSS VSS) g45n1svt w=(2.05e-07) l=4.5e-08 \
        nf=1 as=4.444e-14 ad=3.28e-14 ps=1.03e-06 pd=7.3e-07 nrd=1.16667 \
        nrs=1.16667 sa=9.85e-07 sb=4.37683e-07 sd=160n sca=8.14041 \
        scb=0.00590656 scc=0.000103269 m=(2)
mn22 (\9\:RNb \1\:RN \9\:VSS VSS) g45n1svt w=(1.45e-07) l=4.5e-08 nf=1 \
        as=4.545e-14 ad=2.755e-14 ps=1.17e-06 pd=6.7e-07 nrd=1.16667 \
        nrs=1.16667 sa=5.89655e-07 sb=1.9e-07 sd=160n sca=13.253 \
        scb=0.0137915 scc=0.000695334 m=(1)
mn21 (\12\:CKbb \11\:CKb \16\:VSS VSS) g45n1svt w=(1.45e-07) l=4.5e-08 \
        nf=1 as=3.79e-14 ad=3.263e-14 ps=8.5e-07 pd=7.4e-07 nrd=1.16667 \
        nrs=1.16667 sa=1.50121e-06 sb=2.25e-07 sd=160n sca=13.253 \
        scb=0.0137915 scc=0.000695334 m=(1)
mn20 (\18\:CKb \3\:CK \14\:VSS VSS) g45n1svt w=(1.45e-07) l=4.5e-08 nf=1 \
        as=2.03e-14 ad=2.973e-14 ps=5.7e-07 pd=7e-07 nrd=1.16667 \
        nrs=1.16667 sa=2.05e-07 sb=1.4e-07 sd=160n sca=11.7118 \
        scb=0.0116498 scc=0.000458536 m=(1)
mp51 (n43 \2\:RNb \20\:VDD NW) g45p1svt w=(3.1e-07) l=4.5e-08 nf=1 \
        as=1.0875e-13 ad=1.86e-14 ps=1.53e-06 pd=7.4e-07 nrd=1.16667 \
        nrs=1.16667 sa=2.85e-07 sb=3.78065e-07 sd=160n sca=14.1869 \
        scb=0.0131869 scc=0.000739194 m=(1)
mp52 (n43 \15\:qbint \3\:n41 NW) g45p1svt w=(3.1e-07) l=4.5e-08 nf=1 \
        as=5.737e-14 ad=1.86e-14 ps=1.22e-06 pd=7.4e-07 nrd=1.16667 \
        nrs=1.16667 sa=3.9e-07 sb=2.73065e-07 sd=160n sca=14.1869 \
        scb=0.0131869 scc=0.000739194 m=(1)
mp50 (\3\:n41 \1\:SN \18\:VDD NW) g45p1svt w=(3.1e-07) l=4.5e-08 nf=1 \
        as=7.37e-14 ad=5.737e-14 ps=1.31e-06 pd=1.22e-06 nrd=1.16667 \
        nrs=1.16667 sa=4.04355e-07 sb=1.7e-07 sd=160n sca=10.6524 \
        scb=0.00831156 scc=0.000128379 m=(1)
mp53 (\9\:n35 \3\:CKbb n41 NW) g45p1svt w=(3.1e-07) l=4.5e-08 nf=1 \
        as=8.835e-14 ad=5.89e-14 ps=1.19e-06 pd=1e-06 nrd=1.16667 \
        nrs=1.16667 sa=2.85e-07 sb=4.6e-07 sd=160n sca=19.1541 \
        scb=0.0174883 scc=0.00172295 m=(1)
mp40 (\9\:n35 \3\:CKb \9\:mout NW) g45p1svt w=(3.1e-07) l=4.5e-08 nf=1 \
        as=6.975e-14 ad=5.89e-14 ps=1.07e-06 pd=1e-06 nrd=1.16667 \
        nrs=1.16667 sa=5.2e-07 sb=2.25e-07 sd=160n sca=19.1541 \
        scb=0.0174883 scc=0.00172295 m=(1)
mp31 (n26 \6\:RNb \16\:VDD NW) g45p1svt w=(3.1e-07) l=4.5e-08 nf=1 \
        as=1.6975e-13 ad=4.34e-14 ps=2.04e-06 pd=9e-07 nrd=1.16667 \
        nrs=1.16667 sa=4.45e-07 sb=1.06331e-06 sd=160n sca=35.6995 \
        scb=0.0234062 scc=0.00420468 m=(1)
mp32 (\6\:mout \3\:n20 n26 NW) g45p1svt w=(3.1e-07) l=4.5e-08 nf=1 \
        as=4.34e-14 ad=4.96e-14 ps=9e-07 pd=9.4e-07 nrd=1.16667 \
        nrs=1.16667 sa=6.3e-07 sb=8.78306e-07 sd=160n sca=35.6995 \
        scb=0.0234062 scc=0.00420468 m=(1)
mp30 (\6\:mout \6\:SN \14\:VDD NW) g45p1svt w=(3.1e-07) l=4.5e-08 nf=1 \
        as=7.695e-14 ad=4.96e-14 ps=1.47e-06 pd=9.4e-07 nrd=1.16667 \
        nrs=1.16667 sa=8.35e-07 sb=6.73306e-07 sd=160n sca=35.6995 \
        scb=0.0234062 scc=0.00420468 m=(1)
mp35 (n31 \4\:mout \14\:VDD NW) g45p1svt w=(3.1e-07) l=4.5e-08 nf=1 \
        as=7.695e-14 ad=4.185e-14 ps=1.47e-06 pd=8.9e-07 nrd=1.16667 \
        nrs=1.16667 sa=6.22419e-07 sb=1.05492e-06 sd=160n sca=12.3129 \
        scb=0.0108562 scc=0.00039161 m=(1)
mp36 (\5\:n20 \5\:CKb n31 NW) g45p1svt w=(3.1e-07) l=4.5e-08 nf=1 \
        as=4.185e-14 ad=1.24e-13 ps=8.9e-07 pd=1.42e-06 nrd=1.16667 \
        nrs=1.16667 sa=8.02419e-07 sb=8.74919e-07 sd=160n sca=12.3129 \
        scb=0.0108562 scc=0.00039161 m=(1)
mp26 (\5\:n20 \5\:CKbb n22 NW) g45p1svt w=(3.1e-07) l=4.5e-08 nf=1 \
        as=3.565e-14 ad=1.24e-13 ps=8.5e-07 pd=1.42e-06 nrd=1.16667 \
        nrs=1.16667 sa=1.24742e-06 sb=4.29919e-07 sd=160n sca=12.3129 \
        scb=0.0108562 scc=0.00039161 m=(1)
mp25 (n22 \1\:D \12\:VDD NW) g45p1svt w=(3.1e-07) l=4.5e-08 nf=1 \
        as=4.39e-14 ad=3.565e-14 ps=9.4e-07 pd=8.5e-07 nrd=1.16667 \
        nrs=1.16667 sa=1.40742e-06 sb=2.69919e-07 sd=160n sca=12.3129 \
        scb=0.0108562 scc=0.00039161 m=(1)
mp45_1__rcx (\25\:qbint \2\:n35 \8\:VDD NW) g45p1svt w=(3.1e-07) \
        l=4.5e-08 nf=1 as=5.827e-14 ad=4.96e-14 ps=1.09e-06 pd=9.4e-07 \
        nrd=1.16667 nrs=1.16667 sa=9.85e-07 sb=5.54677e-07 sd=160n \
        sca=13.6224 scb=0.0125368 scc=0.000630866 m=(2)
mp22 (\12\:RNb \3\:RN \8\:VDD NW) g45p1svt w=(2.15e-07) l=4.5e-08 nf=1 \
        as=5.895e-14 ad=3.977e-14 ps=1.08e-06 pd=8e-07 nrd=1.16667 \
        nrs=1.16667 sa=1.465e-06 sb=1.85e-07 sd=160n sca=15.2551 \
        scb=0.0150251 scc=0.000885438 m=(1)
mp21 (\16\:CKbb \9\:CKb \12\:VDD NW) g45p1svt w=(2.15e-07) l=4.5e-08 \
        nf=1 as=4.39e-14 ad=3.01e-14 ps=9.4e-07 pd=7.1e-07 nrd=1.16667 \
        nrs=1.16667 sa=1.34698e-06 sb=1.4e-07 sd=160n sca=10.6521 \
        scb=0.00815229 scc=0.000119636 m=(1)
mp20 (\20\:CKb \1\:CK \1\:VDD NW) g45p1svt w=(2.15e-07) l=4.5e-08 nf=1 \
        as=3.01e-14 ad=5.4e-14 ps=7.1e-07 pd=1.13e-06 nrd=1.16667 \
        nrs=1.16667 sa=2.51163e-07 sb=1.4e-07 sd=160n sca=52.4731 \
        scb=0.0379902 scc=0.00614793 m=(1)
ends DFFSRHQX4
// End of subcircuit definition.
