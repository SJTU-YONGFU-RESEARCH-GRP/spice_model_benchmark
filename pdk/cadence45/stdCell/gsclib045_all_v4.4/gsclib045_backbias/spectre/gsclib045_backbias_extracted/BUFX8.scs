// Generated for: spectre (May  1 11:28:08 2013 )
// Library name: gsclib045_backbias
// Cell name: BUFX8
// View name: extracted

simulator lang=spectre

subckt BUFX8 A NW VDD VSS Y
mp1_1__rcx (\1\:Y n0 \1\:VDD NW) g45p1svt w=(4.45e-07) l=4.5e-08 nf=1 \
        as=7.073e-14 ad=6.993e-14 ps=1.21e-06 pd=1.20429e-06 nrd=1.16667 \
        nrs=1.16667 sa=1.4e-07 sb=1.72438e-06 sd=160n sca=25.5327 \
        scb=0.0229112 scc=0.00209852 m=(7)
C1 (NW VSS) capacitor c=2.67775e-16
C2 (VDD VSS) capacitor c=4.08748e-17
C3 (Y VSS) capacitor c=1.72777e-17
C4 (n0 VSS) capacitor c=6.71252e-16
C5 (\1\:A VSS) capacitor c=1.55357e-16
C6 (\6\:A VSS) capacitor c=1.74337e-17
C7 (\1\:VDD VSS) capacitor c=5.85178e-16
C8 (\22\:n0 VSS) capacitor c=7.77746e-17
C9 (\1\:Y VSS) capacitor c=4.08746e-16
C10 (\28\:n0 VSS) capacitor c=2.17215e-17
C11 (\6\:Y VSS) capacitor c=4.30288e-16
C12 (\24\:n0 VSS) capacitor c=4.16116e-17
C13 (\8\:A VSS) capacitor c=7.61977e-17
Rk35 (\1\:VSS VSS) resistor r=0.1802 c=0
Rk25 (\1\:VDD VDD) resistor r=0.1802 c=0
Rk20 (A \8\:A) resistor r=0.01092 c=0
Rk4 (\1\:Y Y) resistor r=0.1156 c=0
Rk5 (Y \6\:Y) resistor r=0.09208 c=0
Rk16 (\24\:n0 n0) resistor r=0.1704 c=0
Rk15 (\23\:n0 \24\:n0) resistor r=0.2673 c=0
Rk19 (\24\:n0 \29\:n0) resistor r=0.164 c=0
Rl23 (\1\:A \6\:A) resistor r=10.1271 c=0
Rz5 (\29\:n0 \28\:n0) resistor r=75 c=0
Ry5 (\23\:n0 \22\:n0) resistor r=20.6667 c=0
Rx4 (\8\:A \6\:A) resistor r=45 c=0
mn1_1__rcx (\1\:VSS n0 \6\:Y VSS) g45n1svt w=(2.95e-07) l=4.5e-08 nf=1 \
        as=4.636e-14 ad=4.69e-14 ps=9.0429e-07 pd=9.1e-07 nrd=1.16667 \
        nrs=1.16667 sa=1.4e-07 sb=1.72661e-06 sd=160n sca=14.382 \
        scb=0.0140935 scc=0.0010585 m=(7)
mn0 (\1\:VSS \1\:A \28\:n0 VSS) g45n1svt w=(2.6e-07) l=4.5e-08 nf=1 \
        as=4.16e-14 ad=4.075e-14 ps=8.4e-07 pd=8.55e-07 nrd=1.16667 \
        nrs=1.16667 sa=1.575e-06 sb=3.45e-07 sd=160n sca=15.3338 \
        scb=0.0153436 scc=0.00119435 m=(2)
mp0 (\22\:n0 \1\:A \1\:VDD NW) g45p1svt w=(3.9e-07) l=4.5e-08 nf=1 \
        as=6.125e-14 ad=6.24e-14 ps=1.135e-06 pd=1.1e-06 nrd=1.16667 \
        nrs=1.16667 sa=1.575e-06 sb=3.45e-07 sd=160n sca=25.9035 \
        scb=0.0222272 scc=0.0023141 m=(2)
ends BUFX8
// End of subcircuit definition.
