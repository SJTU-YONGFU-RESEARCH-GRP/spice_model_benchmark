// Generated for: spectre (May  1 11:27:55 2013 )
// Library name: gsclib045_backbias
// Cell name: AOI32X4
// View name: extracted

simulator lang=spectre

subckt AOI32X4 A0 A1 A2 B0 B1 NW VDD VSS Y
mp0_1__rcx (net106 A0 \1\:VDD NW) g45p1svt w=(3.9e-07) l=4.5e-08 nf=1 \
        as=6.386e-14 ad=6.435e-14 ps=1.1075e-06 pd=1.11e-06 nrd=1.16667 \
        nrs=1.16667 sa=1.4e-07 sb=2e-06 sd=160n sca=24.9718 scb=0.0274046 \
        scc=0.00171026 m=(4)
mp1_1__rcx (net106 \2\:A1 \1\:VDD NW) g45p1svt w=(3.9e-07) l=4.5e-08 \
        nf=1 as=6.386e-14 ad=6.435e-14 ps=1.1075e-06 pd=1.11e-06 \
        nrd=1.16667 nrs=1.16667 sa=3.45e-07 sb=2e-06 sd=160n sca=18.9104 \
        scb=0.0172562 scc=0.00120281 m=(4)
mp2_1__rcx (net106 A2 \1\:VDD NW) g45p1svt w=(3.9e-07) l=4.5e-08 nf=1 \
        as=6.24e-14 ad=6.435e-14 ps=1.1e-06 pd=1.11e-06 nrd=1.16667 \
        nrs=1.16667 sa=5.5e-07 sb=2e-06 sd=160n sca=17.1755 scb=0.0150279 \
        scc=0.00118894 m=(4)
mp3_1__rcx (\10\:Y B0 net106 NW) g45p1svt w=(3.9e-07) l=4.5e-08 nf=1 \
        as=6.435e-14 ad=6.24e-14 ps=1.11e-06 pd=1.1e-06 nrd=1.16667 \
        nrs=1.16667 sa=2e-06 sb=1.575e-06 sd=160n sca=16.2669 \
        scb=0.0145797 scc=0.00118861 m=(4)
mp4_1__rcx (\10\:Y B1 net106 NW) g45p1svt w=(3.9e-07) l=4.5e-08 nf=1 \
        as=6.24e-14 ad=6.24e-14 ps=1.1e-06 pd=1.1e-06 nrd=1.16667 \
        nrs=1.16667 sa=2e-06 sb=1.37e-06 sd=160n sca=16.2669 scb=0.0145797 \
        scc=0.00118861 m=(4)
C1 (A2 VSS) capacitor c=4.90394e-16
C2 (B1 VSS) capacitor c=3.92484e-16
C3 (NW VSS) capacitor c=5.16957e-16
C4 (A0 VSS) capacitor c=8.71638e-16
C5 (Y VSS) capacitor c=7.59207e-17
C6 (B0 VSS) capacitor c=5.60995e-16
C7 (A1 VSS) capacitor c=2.55925e-17
C8 (VDD VSS) capacitor c=3.83329e-17
C9 (11 VSS) capacitor c=1.36221e-18
C10 (12 VSS) capacitor c=4.06732e-18
C11 (13 VSS) capacitor c=2.24904e-18
C12 (14 VSS) capacitor c=4.22545e-18
C13 (15 VSS) capacitor c=3.93582e-18
C14 (16 VSS) capacitor c=8.5743e-18
C15 (17 VSS) capacitor c=7.51963e-18
C16 (18 VSS) capacitor c=4.16847e-18
C17 (19 VSS) capacitor c=3.58574e-18
C18 (20 VSS) capacitor c=1.90394e-18
C19 (21 VSS) capacitor c=2.01768e-18
C20 (net106 VSS) capacitor c=8.01314e-16
C21 (\12\:B0 VSS) capacitor c=7.29675e-17
C22 (\12\:B1 VSS) capacitor c=4.7925e-17
C23 (\10\:B1 VSS) capacitor c=4.94859e-17
C24 (\8\:B0 VSS) capacitor c=5.1585e-17
C25 (\9\:B0 VSS) capacitor c=7.13526e-17
C26 (\4\:B1 VSS) capacitor c=5.56322e-17
C27 (\6\:B1 VSS) capacitor c=4.56328e-17
C28 (\1\:B0 VSS) capacitor c=4.30159e-17
C29 (\12\:A0 VSS) capacitor c=4.59808e-17
C30 (\13\:A1 VSS) capacitor c=4.59144e-17
C31 (\12\:A2 VSS) capacitor c=4.29392e-17
C32 (\10\:A2 VSS) capacitor c=2.35545e-17
C33 (\9\:A1 VSS) capacitor c=4.72943e-17
C34 (\9\:A0 VSS) capacitor c=3.42244e-17
C35 (\7\:A0 VSS) capacitor c=5.39412e-17
C36 (\6\:A1 VSS) capacitor c=6.91757e-17
C37 (\1\:A2 VSS) capacitor c=5.23548e-17
C38 (\5\:A2 VSS) capacitor c=2.56701e-17
C39 (\1\:A1 VSS) capacitor c=6.12597e-17
C40 (\1\:A0 VSS) capacitor c=5.01673e-17
C41 (\2\:A1 VSS) capacitor c=8.43746e-16
C42 (\10\:Y VSS) capacitor c=2.73203e-16
C43 (\1\:VDD VSS) capacitor c=7.47763e-16
C44 (\1\:Y VSS) capacitor c=6.15147e-17
C45 (\3\:Y VSS) capacitor c=6.98175e-17
C46 (\6\:Y VSS) capacitor c=1.56419e-16
C47 (\8\:Y VSS) capacitor c=1.28996e-16
C48 (\2\:A2 VSS) capacitor c=3.922e-17
C49 (\9\:A2 VSS) capacitor c=2.27657e-17
C50 (\3\:B1 VSS) capacitor c=3.514e-17
C51 (\9\:B1 VSS) capacitor c=4.38527e-17
C52 (\5\:Y VSS) capacitor c=1.09702e-16
Rk19 (Y \10\:Y) resistor r=0.1127 c=0
Rk14 (\2\:Y \4\:Y) resistor r=0.4599 c=0
Rk18 (\5\:Y Y) resistor r=0.4494 c=0
Rk15 (\4\:Y \5\:Y) resistor r=0.3002 c=0
Rk16 (\5\:Y \7\:Y) resistor r=0.4803 c=0
Rk17 (\7\:Y \9\:Y) resistor r=0.8447 c=0
Rk40 (\2\:VSS \4\:VSS) resistor r=0.5028 c=0
Rk41 (\4\:VSS \5\:VSS) resistor r=0.4312 c=0
Rk42 (\5\:VSS \6\:VSS) resistor r=0.6218 c=0
Rk43 (\6\:VSS \7\:VSS) resistor r=0.09661 c=0
Rk45 (\8\:VSS VSS) resistor r=0.1149 c=0
Rk44 (\7\:VSS \8\:VSS) resistor r=0.4359 c=0
Rk46 (\4\:VSS \10\:VSS) resistor r=0.07144 c=0
Rk47 (\5\:VSS \12\:VSS) resistor r=0.04328 c=0
Rk48 (\6\:VSS \14\:VSS) resistor r=0.04328 c=0
Rk49 (\8\:VSS \16\:VSS) resistor r=0.1987 c=0
Rk7 (\2\:A1 A1) resistor r=0.08428 c=0
Rk55 (\1\:VDD VDD) resistor r=0.1324 c=0
Rl6 (\2\:A2 A2) resistor r=62.3759 c=0
Rl5 (\2\:A2 \1\:A2) resistor r=73.0548 c=0
Rl8 (\2\:A2 \5\:A2) resistor r=59.5933 c=0
Rl20 (\9\:A2 A2) resistor r=77.3125 c=0
Rl23 (\9\:A2 \12\:A2) resistor r=100.426 c=0
Rl21 (\9\:A2 \10\:A2) resistor r=35.772 c=0
Rl32 (\3\:B1 B1) resistor r=7.101 c=0
Rl33 (\3\:B1 \4\:B1) resistor r=86.6019 c=0
Rl35 (\3\:B1 \6\:B1) resistor r=136.023 c=0
Rl42 (\9\:B1 B1) resistor r=25.8618 c=0
Rl45 (\9\:B1 \12\:B1) resistor r=60.0739 c=0
Rl43 (\9\:B1 \10\:B1) resistor r=67.7662 c=0
Rl28 (A0 \12\:A0) resistor r=40.1797 c=0
Rl16 (A0 \9\:A0) resistor r=24.2328 c=0
Rl14 (A0 \7\:A0) resistor r=98.3529 c=0
Rl1 (A0 \1\:A0) resistor r=30.2349 c=0
Rl47 (B0 \12\:B0) resistor r=98.0541 c=0
Rl39 (B0 \8\:B0) resistor r=40.6783 c=0
Rl40 (B0 \9\:B0) resistor r=109.334 c=0
Rl29 (B0 \1\:B0) resistor r=31.9251 c=0
Rl26 (\2\:A1 \13\:A1) resistor r=52.7257 c=0
Rl18 (\2\:A1 \9\:A1) resistor r=56.8681 c=0
Rl11 (\2\:A1 \6\:A1) resistor r=44.9225 c=0
Rl3 (\2\:A1 \1\:A1) resistor r=44.9225 c=0
Rz1 (\2\:Y \1\:Y) resistor r=75 c=0
Rz2 (\4\:Y \3\:Y) resistor r=75 c=0
Rz3 (\7\:Y \6\:Y) resistor r=75 c=0
Rz4 (\9\:Y \8\:Y) resistor r=75 c=0
Rz5 (\1\:VSS \2\:VSS) resistor r=75 c=0
Rz6 (\9\:VSS \10\:VSS) resistor r=75 c=0
Rz7 (\11\:VSS \12\:VSS) resistor r=75 c=0
Rz8 (\13\:VSS \14\:VSS) resistor r=75 c=0
Rz9 (\15\:VSS \16\:VSS) resistor r=75 c=0
Ry17 (\3\:VSS \4\:VSS) resistor r=5.6364 c=0
Ry18 (\3\:VSS \7\:VSS) resistor r=5.1667 c=0
mn0_1__rcx (11 \1\:A0 \15\:VSS VSS) g45n1svt w=(2.6e-07) l=4.5e-08 nf=1 \
        as=3.64e-14 ad=1.56e-14 ps=8e-07 pd=6.4e-07 nrd=1.16667 \
        nrs=1.16667 sa=1.4e-07 sb=2e-06 sd=160n sca=9.14564 scb=0.00759168 \
        scc=0.000213449 m=(1)
mn1_1__rcx (11 \1\:A1 12 VSS) g45n1svt w=(2.6e-07) l=4.5e-08 nf=1 \
        as=4.68e-14 ad=1.56e-14 ps=8.8e-07 pd=6.4e-07 nrd=1.16667 \
        nrs=1.16667 sa=2.45e-07 sb=2e-06 sd=160n sca=9.14564 \
        scb=0.00759168 scc=0.000213449 m=(1)
mn2_1__rcx (\8\:Y \5\:A2 12 VSS) g45n1svt w=(2.6e-07) l=4.5e-08 nf=1 \
        as=4.68e-14 ad=4.16e-14 ps=8.8e-07 pd=8.4e-07 nrd=1.16667 \
        nrs=1.16667 sa=4.7e-07 sb=2e-06 sd=160n sca=9.14564 scb=0.00759168 \
        scc=0.000213449 m=(1)
mn2_2__rcx (\8\:Y \1\:A2 13 VSS) g45n1svt w=(2.6e-07) l=4.5e-08 nf=1 \
        as=1.56e-14 ad=4.16e-14 ps=6.4e-07 pd=8.4e-07 nrd=1.16667 \
        nrs=1.16667 sa=6.75e-07 sb=2e-06 sd=160n sca=9.14564 \
        scb=0.00759168 scc=0.000213449 m=(1)
mn1_2__rcx (13 \6\:A1 14 VSS) g45n1svt w=(2.6e-07) l=4.5e-08 nf=1 \
        as=2.99e-14 ad=1.56e-14 ps=7.5e-07 pd=6.4e-07 nrd=1.16667 \
        nrs=1.16667 sa=7.8e-07 sb=2e-06 sd=160n sca=9.14564 scb=0.00759168 \
        scc=0.000213449 m=(1)
mn0_2__rcx (14 \7\:A0 \13\:VSS VSS) g45n1svt w=(2.6e-07) l=4.5e-08 nf=1 \
        as=8.06e-14 ad=2.99e-14 ps=1.35e-06 pd=7.5e-07 nrd=1.16667 \
        nrs=1.16667 sa=9.4e-07 sb=2e-06 sd=160n sca=9.14564 scb=0.00759168 \
        scc=0.000213449 m=(1)
mn0_3__rcx (15 \9\:A0 \13\:VSS VSS) g45n1svt w=(2.6e-07) l=4.5e-08 nf=1 \
        as=8.06e-14 ad=2.73e-14 ps=1.35e-06 pd=7.3e-07 nrd=1.16667 \
        nrs=1.16667 sa=1.205e-06 sb=2e-06 sd=160n sca=9.14564 \
        scb=0.00759168 scc=0.000213449 m=(1)
mn1_3__rcx (15 \9\:A1 16 VSS) g45n1svt w=(2.6e-07) l=4.5e-08 nf=1 \
        as=5.2e-14 ad=2.73e-14 ps=9.2e-07 pd=7.3e-07 nrd=1.16667 \
        nrs=1.16667 sa=1.355e-06 sb=2e-06 sd=160n sca=9.14564 \
        scb=0.00759168 scc=0.000213449 m=(1)
mn2_3__rcx (\6\:Y \10\:A2 16 VSS) g45n1svt w=(2.6e-07) l=4.5e-08 nf=1 \
        as=5.2e-14 ad=4.16e-14 ps=9.2e-07 pd=8.4e-07 nrd=1.16667 \
        nrs=1.16667 sa=1.6e-06 sb=2e-06 sd=160n sca=9.14564 scb=0.00759168 \
        scc=0.000213449 m=(1)
mn2 (\6\:Y \12\:A2 17 VSS) g45n1svt w=(2.6e-07) l=4.5e-08 nf=1 \
        as=4.55e-14 ad=4.16e-14 ps=8.7e-07 pd=8.4e-07 nrd=1.16667 \
        nrs=1.16667 sa=1.805e-06 sb=2e-06 sd=160n sca=9.14564 \
        scb=0.00759168 scc=0.000213449 m=(1)
mn1 (17 \13\:A1 18 VSS) g45n1svt w=(2.6e-07) l=4.5e-08 nf=1 as=2.99e-14 \
        ad=4.55e-14 ps=7.5e-07 pd=8.7e-07 nrd=1.16667 nrs=1.16667 sa=2e-06 \
        sb=1.785e-06 sd=160n sca=9.14564 scb=0.00759168 scc=0.000213449 \
        m=(1)
mn0 (18 \12\:A0 \11\:VSS VSS) g45n1svt w=(2.6e-07) l=4.5e-08 nf=1 \
        as=9.36e-14 ad=2.99e-14 ps=1.45e-06 pd=7.5e-07 nrd=1.16667 \
        nrs=1.16667 sa=2e-06 sb=1.625e-06 sd=160n sca=9.14564 \
        scb=0.00759168 scc=0.000213449 m=(1)
mn3_1__rcx (19 \1\:B0 \11\:VSS VSS) g45n1svt w=(2.6e-07) l=4.5e-08 nf=1 \
        as=9.36e-14 ad=3.51e-14 ps=1.45e-06 pd=7.9e-07 nrd=1.16667 \
        nrs=1.16667 sa=2e-06 sb=1.31e-06 sd=160n sca=9.14564 \
        scb=0.00759168 scc=0.000213449 m=(1)
mn4_1__rcx (\3\:Y \6\:B1 19 VSS) g45n1svt w=(2.6e-07) l=4.5e-08 nf=1 \
        as=3.51e-14 ad=4.16e-14 ps=7.9e-07 pd=8.4e-07 nrd=1.16667 \
        nrs=1.16667 sa=2e-06 sb=1.13e-06 sd=160n sca=9.14564 \
        scb=0.00759168 scc=0.000213449 m=(1)
mn4_2__rcx (\3\:Y \4\:B1 20 VSS) g45n1svt w=(2.6e-07) l=4.5e-08 nf=1 \
        as=1.56e-14 ad=4.16e-14 ps=6.4e-07 pd=8.4e-07 nrd=1.16667 \
        nrs=1.16667 sa=2e-06 sb=9.25e-07 sd=160n sca=9.14564 \
        scb=0.00759168 scc=0.000213449 m=(1)
mn3_2__rcx (20 \9\:B0 \9\:VSS VSS) g45n1svt w=(2.6e-07) l=4.5e-08 nf=1 \
        as=8.06e-14 ad=1.56e-14 ps=1.35e-06 pd=6.4e-07 nrd=1.16667 \
        nrs=1.16667 sa=2e-06 sb=8.2e-07 sd=160n sca=9.14564 scb=0.00759168 \
        scc=0.000213449 m=(1)
mn3_3__rcx (21 \8\:B0 \9\:VSS VSS) g45n1svt w=(2.6e-07) l=4.5e-08 nf=1 \
        as=8.06e-14 ad=1.56e-14 ps=1.35e-06 pd=6.4e-07 nrd=1.16667 \
        nrs=1.16667 sa=2e-06 sb=5.55e-07 sd=160n sca=9.14564 \
        scb=0.00759168 scc=0.000213449 m=(1)
mn4_3__rcx (\1\:Y \10\:B1 21 VSS) g45n1svt w=(2.6e-07) l=4.5e-08 nf=1 \
        as=1.56e-14 ad=4.16e-14 ps=6.4e-07 pd=8.4e-07 nrd=1.16667 \
        nrs=1.16667 sa=2e-06 sb=4.5e-07 sd=160n sca=9.14564 scb=0.00759168 \
        scc=0.000213449 m=(1)
mn4 (\1\:Y \12\:B1 22 VSS) g45n1svt w=(2.6e-07) l=4.5e-08 nf=1 \
        as=1.56e-14 ad=4.16e-14 ps=6.4e-07 pd=8.4e-07 nrd=1.16667 \
        nrs=1.16667 sa=2e-06 sb=2.45e-07 sd=160n sca=9.14564 \
        scb=0.00759168 scc=0.000213449 m=(1)
mn3 (22 \12\:B0 \1\:VSS VSS) g45n1svt w=(2.6e-07) l=4.5e-08 nf=1 \
        as=3.64e-14 ad=1.56e-14 ps=8e-07 pd=6.4e-07 nrd=1.16667 \
        nrs=1.16667 sa=2e-06 sb=1.4e-07 sd=160n sca=9.14564 scb=0.00759168 \
        scc=0.000213449 m=(1)
ends AOI32X4
// End of subcircuit definition.
