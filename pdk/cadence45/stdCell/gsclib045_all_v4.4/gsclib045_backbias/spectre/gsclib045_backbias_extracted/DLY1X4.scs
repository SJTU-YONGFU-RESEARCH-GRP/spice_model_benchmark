// Generated for: spectre (May  1 11:29:16 2013 )
// Library name: gsclib045_backbias
// Cell name: DLY1X4
// View name: extracted

simulator lang=spectre

subckt DLY1X4 A NW VDD VSS Y
mp0 (\8\:n0 \1\:A \14\:VDD NW) g45p1svt w=(2.15e-07) l=4.5e-08 nf=1 \
        as=3.44e-14 ad=3.01e-14 ps=7.5e-07 pd=7.1e-07 nrd=1.16667 \
        nrs=1.16667 sa=1.4e-07 sb=4.75e-07 sd=160n sca=17.5351 \
        scb=0.0182864 scc=0.000415857 m=(1)
mp1 (n5 n0 \14\:VDD NW) g45p1svt w=(2.15e-07) l=4.5e-08 nf=1 as=3.44e-14 \
        ad=1.613e-14 ps=7.5e-07 pd=5.8e-07 nrd=1.16667 nrs=1.16667 \
        sa=3.45e-07 sb=2.7e-07 sd=160n sca=12.8452 scb=0.0102734 \
        scc=0.000135926 m=(1)
mp2 (\8\:n1 \2\:VSS n5 NW) g45p1svt w=(2.15e-07) l=4.5e-08 nf=1 \
        as=1.613e-14 ad=3.225e-14 ps=5.8e-07 pd=7.3e-07 nrd=1.16667 \
        nrs=1.16667 sa=4.65e-07 sb=1.5e-07 sd=160n sca=11.8288 \
        scb=0.00897951 scc=0.000129234 m=(1)
C1 (Y VSS) capacitor c=1.83969e-17
C2 (NW VSS) capacitor c=3.16171e-16
C3 (VDD VSS) capacitor c=4.30972e-17
C4 (n0 VSS) capacitor c=8.2893e-17
C5 (n1 VSS) capacitor c=4.19574e-17
C6 (n2 VSS) capacitor c=2.13084e-16
C7 (n5 VSS) capacitor c=9.53257e-19
C8 (\1\:A VSS) capacitor c=4.02234e-17
C9 (\3\:n1 VSS) capacitor c=3.25602e-17
C10 (\1\:VDD VSS) capacitor c=6.26701e-17
C11 (\3\:n0 VSS) capacitor c=4.76703e-17
C12 (\3\:A VSS) capacitor c=4.27172e-17
C13 (\6\:n2 VSS) capacitor c=2.34909e-17
C14 (\2\:n1 VSS) capacitor c=3.67508e-17
C15 (\2\:VDD VSS) capacitor c=4.1901e-17
C16 (\2\:n0 VSS) capacitor c=8.16794e-17
C17 (\2\:A VSS) capacitor c=5.73924e-17
C18 (\3\:VDD VSS) capacitor c=3.21331e-16
C19 (\1\:Y VSS) capacitor c=1.59439e-16
C20 (\14\:n2 VSS) capacitor c=9.49358e-17
C21 (\8\:n1 VSS) capacitor c=8.33174e-17
C22 (\14\:VDD VSS) capacitor c=2.68434e-17
C23 (\8\:n0 VSS) capacitor c=6.85268e-17
C24 (\4\:Y VSS) capacitor c=7.41649e-17
C25 (\17\:n2 VSS) capacitor c=5.09456e-17
C26 (\6\:n1 VSS) capacitor c=6.72835e-17
C27 (\6\:n0 VSS) capacitor c=2.65707e-17
C28 (\4\:A VSS) capacitor c=1.15531e-16
C29 (\4\:n0 VSS) capacitor c=4.8958e-17
C30 (\5\:n0 VSS) capacitor c=5.16442e-17
C31 (\4\:n1 VSS) capacitor c=4.55304e-17
C32 (\5\:n1 VSS) capacitor c=8.49019e-17
C33 (\16\:n2 VSS) capacitor c=9.13895e-17
C34 (\7\:VDD VSS) capacitor c=5.63157e-17
C35 (\8\:VDD VSS) capacitor c=2.21799e-17
C36 (\13\:VDD VSS) capacitor c=9.62493e-17
Rk11 (\1\:Y Y) resistor r=0.04849 c=0
Rk12 (Y \4\:Y) resistor r=0.1952 c=0
Rk26 (\3\:VSS \8\:VSS) resistor r=0.08007 c=0
Rk27 (\8\:VSS \9\:VSS) resistor r=0.2632 c=0
Rk29 (\10\:VSS VSS) resistor r=0.1225 c=0
Rk28 (\9\:VSS \10\:VSS) resistor r=0.115 c=0
Rk32 (\9\:VSS \15\:VSS) resistor r=0.8216 c=0
Rk33 (\10\:VSS \17\:VSS) resistor r=0.3084 c=0
Rk17 (\3\:VDD \7\:VDD) resistor r=0.3432 c=0
Rk19 (\8\:VDD VDD) resistor r=0.15 c=0
Rk18 (\7\:VDD \8\:VDD) resistor r=0.0874 c=0
Rk22 (\7\:VDD \13\:VDD) resistor r=0.6293 c=0
Rk23 (\8\:VDD \15\:VDD) resistor r=0.2826 c=0
Rk1 (A \4\:A) resistor r=0.004953 c=0
Rk2 (\4\:n0 \5\:n0) resistor r=0.1912 c=0
Rk3 (\5\:n0 \7\:n0) resistor r=0.1365 c=0
Rk4 (\5\:n0 \9\:n0) resistor r=0.5147 c=0
Rk5 (\4\:n1 \5\:n1) resistor r=0.1467 c=0
Rk6 (\5\:n1 \7\:n1) resistor r=0.3376 c=0
Rk7 (\5\:n1 \9\:n1) resistor r=0.4299 c=0
Rk8 (\15\:n2 \16\:n2) resistor r=0.4506 c=0
Rk9 (\16\:n2 \18\:n2) resistor r=0.2492 c=0
Rl6 (\1\:VSS \2\:VSS) resistor r=57.6695 c=0
Rl5 (\2\:VDD \1\:VDD) resistor r=97.2519 c=0
Rl1 (\1\:A \2\:A) resistor r=109.615 c=0
Rl2 (\2\:A \3\:A) resistor r=101.099 c=0
Rl3 (n0 \2\:n0) resistor r=196.982 c=0
Rl4 (\2\:n0 \3\:n0) resistor r=47.2144 c=0
Rl7 (n1 \2\:n1) resistor r=26.098 c=0
Rl8 (\2\:n1 \3\:n1) resistor r=41.4826 c=0
Rl13 (n2 \6\:n2) resistor r=4.8851 c=0
Rz9 (\17\:VSS \16\:VSS) resistor r=75 c=0
Rz1 (\6\:n0 \7\:n0) resistor r=75 c=0
Rz2 (\6\:n1 \7\:n1) resistor r=75 c=0
Rz3 (\18\:n2 \17\:n2) resistor r=75 c=0
Ry9 (\15\:VDD \14\:VDD) resistor r=62 c=0
Ry1 (\8\:n0 \9\:n0) resistor r=62 c=0
Ry2 (\8\:n1 \9\:n1) resistor r=62 c=0
Ry3 (\15\:n2 \14\:n2) resistor r=20.6667 c=0
Rx6 (\15\:VSS \1\:VSS) resistor r=45 c=0
Rx5 (\13\:VDD \2\:VDD) resistor r=45 c=0
Rx1 (\2\:A \4\:A) resistor r=45 c=0
Rx2 (\2\:n0 \4\:n0) resistor r=45 c=0
Rx3 (\2\:n1 \4\:n1) resistor r=45 c=0
Rx4 (\16\:n2 \6\:n2) resistor r=45 c=0
mn0 (\6\:n0 \3\:A \16\:VSS VSS) g45n1svt w=(1.45e-07) l=4.5e-08 nf=1 \
        as=2.32e-14 ad=2.03e-14 ps=6.1e-07 pd=5.7e-07 nrd=1.16667 \
        nrs=1.16667 sa=1.4e-07 sb=5.3e-07 sd=160n sca=11.1906 \
        scb=0.0108717 scc=0.000387468 m=(1)
mn1 (n4 \3\:n0 \16\:VSS VSS) g45n1svt w=(1.45e-07) l=4.5e-08 nf=1 \
        as=2.32e-14 ad=8.7e-15 ps=6.1e-07 pd=4.1e-07 nrd=1.16667 \
        nrs=1.16667 sa=3.45e-07 sb=3.25e-07 sd=160n sca=11.1906 \
        scb=0.0108717 scc=0.000387468 m=(1)
mn2 (\6\:n1 \1\:VDD n4 VSS) g45n1svt w=(1.45e-07) l=4.5e-08 nf=1 \
        as=8.7e-15 ad=3.19e-14 ps=4.1e-07 pd=7.3e-07 nrd=1.16667 \
        nrs=1.16667 sa=4.5e-07 sb=2.2e-07 sd=160n sca=11.1906 \
        scb=0.0108717 scc=0.000387468 m=(1)
mn3 (\17\:n2 \3\:n1 \3\:VSS VSS) g45n1svt w=(2.6e-07) l=4.5e-08 nf=1 \
        as=4.16e-14 ad=3.64e-14 ps=8.4e-07 pd=8e-07 nrd=1.16667 \
        nrs=1.16667 sa=1.4e-07 sb=9.6e-07 sd=160n sca=15.3338 \
        scb=0.0153436 scc=0.00119435 m=(1)
mn4_1__rcx (\4\:Y n2 \3\:VSS VSS) g45n1svt w=(2.6e-07) l=4.5e-08 nf=1 \
        as=4.03e-14 ad=4.16e-14 ps=8.3e-07 pd=8.4e-07 nrd=1.16667 \
        nrs=1.16667 sa=3.45e-07 sb=7.55e-07 sd=160n sca=15.3338 \
        scb=0.0153436 scc=0.00119435 m=(4)
mp3 (\14\:n2 n1 \3\:VDD NW) g45p1svt w=(3.9e-07) l=4.5e-08 nf=1 \
        as=6.24e-14 ad=5.46e-14 ps=1.1e-06 pd=1.06e-06 nrd=1.16667 \
        nrs=1.16667 sa=1.4e-07 sb=9.6e-07 sd=160n sca=30.5009 \
        scb=0.0202006 scc=0.00336097 m=(1)
mp4_1__rcx (\1\:Y n2 \3\:VDD NW) g45p1svt w=(3.9e-07) l=4.5e-08 nf=1 \
        as=6.045e-14 ad=6.24e-14 ps=1.09e-06 pd=1.1e-06 nrd=1.16667 \
        nrs=1.16667 sa=3.45e-07 sb=7.55e-07 sd=160n sca=30.7862 \
        scb=0.0202776 scc=0.00336099 m=(4)
ends DLY1X4
// End of subcircuit definition.
