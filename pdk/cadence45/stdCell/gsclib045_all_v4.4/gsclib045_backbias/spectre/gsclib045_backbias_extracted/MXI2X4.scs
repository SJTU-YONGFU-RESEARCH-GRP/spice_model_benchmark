// Generated for: spectre (May  1 11:30:00 2013 )
// Library name: gsclib045_backbias
// Cell name: MXI2X4
// View name: extracted

simulator lang=spectre

subckt MXI2X4 A B NW S0 VDD VSS Y
mp0 (\6\:S0b \3\:S0 \11\:VDD NW) g45p1svt w=(2.15e-07) l=4.5e-08 nf=1 \
        as=4.623e-14 ad=3.655e-14 ps=8.6e-07 pd=7.7e-07 nrd=1.16667 \
        nrs=1.16667 sa=1.7e-07 sb=2e-06 sd=160n sca=18.506 scb=0.019899 \
        scc=0.000532288 m=(1)
mp1 (n4 \1\:A \11\:VDD NW) g45p1svt w=(2.15e-07) l=4.5e-08 nf=1 \
        as=4.623e-14 ad=4.837e-14 ps=8.6e-07 pd=8.8e-07 nrd=1.16667 \
        nrs=1.16667 sa=4.3e-07 sb=2e-06 sd=160n sca=12.703 scb=0.0101766 \
        scc=0.000164323 m=(1)
mp2 (\6\:n0 \4\:S0 n4 NW) g45p1svt w=(2.15e-07) l=4.5e-08 nf=1 \
        as=4.837e-14 ad=3.655e-14 ps=8.8e-07 pd=7.7e-07 nrd=1.16667 \
        nrs=1.16667 sa=7e-07 sb=1.85e-06 sd=160n sca=11.2588 \
        scb=0.00885445 scc=0.000160725 m=(1)
mp4 (\6\:n0 S0b n6 NW) g45p1svt w=(2.15e-07) l=4.5e-08 nf=1 as=7.955e-14 \
        ad=3.655e-14 ps=1.17e-06 pd=7.7e-07 nrd=1.16667 nrs=1.16667 \
        sa=9.15e-07 sb=1.635e-06 sd=160n sca=10.9013 scb=0.00874909 \
        scc=0.000160703 m=(1)
mp3 (n6 \1\:B \1\:VDD NW) g45p1svt w=(2.15e-07) l=4.5e-08 nf=1 \
        as=5.835e-14 ad=7.955e-14 ps=1.16e-06 pd=1.17e-06 nrd=1.16667 \
        nrs=1.16667 sa=1.33e-06 sb=1.22e-06 sd=160n sca=10.9013 \
        scb=0.00874909 scc=0.000160703 m=(1)
C1 (NW VSS) capacitor c=4.14458e-16
C2 (Y VSS) capacitor c=2.13768e-16
C3 (VDD VSS) capacitor c=3.75314e-17
C4 (A VSS) capacitor c=6.19858e-17
C5 (S0b VSS) capacitor c=4.14344e-17
C6 (n0 VSS) capacitor c=3.55143e-17
C7 (n5 VSS) capacitor c=3.47383e-18
C8 (n1 VSS) capacitor c=3.12944e-16
C9 (n6 VSS) capacitor c=1.14139e-17
C10 (\3\:n0 VSS) capacitor c=5.74692e-17
C11 (\1\:B VSS) capacitor c=4.07188e-17
C12 (\4\:S0 VSS) capacitor c=4.37418e-17
C13 (\1\:A VSS) capacitor c=5.09972e-17
C14 (\3\:S0 VSS) capacitor c=2.52428e-17
C15 (\3\:B VSS) capacitor c=6.08874e-17
C16 (\6\:S0 VSS) capacitor c=5.49286e-17
C17 (\3\:S0b VSS) capacitor c=4.11969e-17
C18 (\3\:A VSS) capacitor c=3.87401e-17
C19 (\1\:S0 VSS) capacitor c=5.72726e-17
C20 (\2\:n0 VSS) capacitor c=5.07969e-17
C21 (\2\:B VSS) capacitor c=5.90213e-17
C22 (\7\:S0 VSS) capacitor c=4.1061e-17
C23 (\2\:S0b VSS) capacitor c=5.09442e-17
C24 (\5\:S0 VSS) capacitor c=2.79369e-17
C25 (\2\:A VSS) capacitor c=5.21695e-17
C26 (\2\:S0 VSS) capacitor c=5.21991e-17
C27 (\20\:n1 VSS) capacitor c=4.49428e-17
C28 (\1\:VDD VSS) capacitor c=4.26949e-16
C29 (\6\:n0 VSS) capacitor c=9.64334e-17
C30 (\11\:VDD VSS) capacitor c=3.90261e-17
C31 (\6\:S0b VSS) capacitor c=5.97159e-17
C32 (\16\:n1 VSS) capacitor c=4.77859e-17
C33 (\1\:Y VSS) capacitor c=1.29046e-16
C34 (\8\:n0 VSS) capacitor c=3.19024e-17
C35 (\8\:S0b VSS) capacitor c=2.07262e-17
C36 (\4\:A VSS) capacitor c=5.49372e-17
C37 (\4\:S0b VSS) capacitor c=9.30638e-17
C38 (\5\:S0b VSS) capacitor c=1.19605e-16
C39 (\8\:S0 VSS) capacitor c=8.70748e-17
C40 (\9\:S0 VSS) capacitor c=1.07632e-16
C41 (\10\:S0 VSS) capacitor c=6.99689e-17
C42 (\4\:B VSS) capacitor c=1.1232e-16
C43 (\4\:n0 VSS) capacitor c=1.85805e-16
C44 (\5\:n0 VSS) capacitor c=2.73998e-16
C45 (\18\:n1 VSS) capacitor c=4.59679e-17
C46 (\19\:n1 VSS) capacitor c=2.98552e-17
C47 (\5\:VDD VSS) capacitor c=7.8172e-17
Rk8 (B \4\:B) resistor r=0.002509 c=0
Rk6 (\9\:S0 S0) resistor r=0.4955 c=0
Rk5 (\8\:S0 \9\:S0) resistor r=0.4997 c=0
Rk7 (S0 \10\:S0) resistor r=0.01199 c=0
Rk10 (\1\:Y Y) resistor r=0.2301 c=0
Rk33 (\5\:VDD VDD) resistor r=0.1425 c=0
Rk32 (\1\:VDD \5\:VDD) resistor r=0.5963 c=0
Rk37 (\5\:VDD \12\:VDD) resistor r=0.2606 c=0
Rk1 (\4\:A A) resistor r=0.03938 c=0
Rk24 (\1\:VSS \7\:VSS) resistor r=0.1402 c=0
Rk26 (\8\:VSS VSS) resistor r=0.17 c=0
Rk25 (\7\:VSS \8\:VSS) resistor r=0.3809 c=0
Rk29 (\8\:VSS \14\:VSS) resistor r=0.1962 c=0
Rk2 (\4\:S0b \5\:S0b) resistor r=0.7698 c=0
Rk3 (\5\:S0b \7\:S0b) resistor r=0.5832 c=0
Rk4 (\5\:S0b \9\:S0b) resistor r=0.097 c=0
Rk15 (\4\:n0 \5\:n0) resistor r=1.2614 c=0
Rk16 (\5\:n0 \7\:n0) resistor r=0.807 c=0
Rk17 (\5\:n0 \9\:n0) resistor r=0.263 c=0
Rk18 (\17\:n1 \18\:n1) resistor r=0.4226 c=0
Rk19 (\18\:n1 \19\:n1) resistor r=0.1829 c=0
Rk20 (\18\:n1 \21\:n1) resistor r=0.2118 c=0
Rl9 (\1\:B \2\:B) resistor r=91.5405 c=0
Rl10 (\2\:B \3\:B) resistor r=189.939 c=0
Rl8 (\6\:S0 \7\:S0) resistor r=81.9251 c=0
Rl5 (\4\:S0 \5\:S0) resistor r=44.9225 c=0
Rl2 (\2\:S0 \3\:S0) resistor r=29.9451 c=0
Rl1 (\1\:S0 \2\:S0) resistor r=226.923 c=0
Rl3 (\1\:A \2\:A) resistor r=154.538 c=0
Rl4 (\2\:A \3\:A) resistor r=100.692 c=0
Rl6 (S0b \2\:S0b) resistor r=107.692 c=0
Rl7 (\2\:S0b \3\:S0b) resistor r=149.176 c=0
Rl26 (\2\:n0 \3\:n0) resistor r=106.925 c=0
Rl25 (n0 \2\:n0) resistor r=96.6933 c=0
Rz9 (\14\:VSS \13\:VSS) resistor r=75 c=0
Rz1 (\8\:S0b \9\:S0b) resistor r=75 c=0
Rz4 (\8\:n0 \9\:n0) resistor r=75 c=0
Rz5 (\17\:n1 \16\:n1) resistor r=75 c=0
Ry12 (\12\:VDD \11\:VDD) resistor r=62 c=0
Ry6 (\1\:VSS \3\:VSS) resistor r=20.6667 c=0
Ry7 (\7\:VSS \3\:VSS) resistor r=5.1667 c=0
Ry1 (\6\:S0b \7\:S0b) resistor r=62 c=0
Ry4 (\6\:n0 \7\:n0) resistor r=62 c=0
Ry5 (\21\:n1 \20\:n1) resistor r=20.6667 c=0
Rx6 (\2\:B \4\:B) resistor r=45 c=0
Rx3 (\7\:S0 \8\:S0) resistor r=45 c=0
Rx4 (\5\:S0 \9\:S0) resistor r=45 c=0
Rx5 (\2\:S0 \10\:S0) resistor r=45 c=0
Rx1 (\2\:A \4\:A) resistor r=45 c=0
Rx2 (\2\:S0b \4\:S0b) resistor r=45 c=0
Rx7 (\2\:n0 \4\:n0) resistor r=45 c=0
Rx8 (\19\:n1 n1) resistor r=45 c=0
mn0 (\8\:S0b \1\:S0 \13\:VSS VSS) g45n1svt w=(1.45e-07) l=4.5e-08 nf=1 \
        as=2.32e-14 ad=2.03e-14 ps=6.1e-07 pd=5.7e-07 nrd=1.16667 \
        nrs=1.16667 sa=1.4e-07 sb=2e-06 sd=160n sca=7.09016 scb=0.00401586 \
        scc=3.69756e-05 m=(1)
mn1 (n3 \3\:A \13\:VSS VSS) g45n1svt w=(1.45e-07) l=4.5e-08 nf=1 \
        as=2.32e-14 ad=5.582e-14 ps=6.1e-07 pd=1.06e-06 nrd=1.16667 \
        nrs=1.16667 sa=3.45e-07 sb=2e-06 sd=160n sca=7.09016 \
        scb=0.00401586 scc=3.69756e-05 m=(1)
mn2 (\8\:n0 \3\:S0b n3 VSS) g45n1svt w=(1.45e-07) l=4.5e-08 nf=1 \
        as=5.582e-14 ad=2.61e-14 ps=1.06e-06 pd=6.5e-07 nrd=1.16667 \
        nrs=1.16667 sa=7.75e-07 sb=1.95e-06 sd=160n sca=7.09016 \
        scb=0.00401586 scc=3.69756e-05 m=(1)
mn4 (\8\:n0 \6\:S0 n5 VSS) g45n1svt w=(1.45e-07) l=4.5e-08 nf=1 \
        as=1.522e-14 ad=2.61e-14 ps=5e-07 pd=6.5e-07 nrd=1.16667 \
        nrs=1.16667 sa=1e-06 sb=1.725e-06 sd=160n sca=7.09016 \
        scb=0.00401586 scc=3.69756e-05 m=(1)
mn3 (n5 \3\:B \1\:VSS VSS) g45n1svt w=(1.45e-07) l=4.5e-08 nf=1 \
        as=6.007e-14 ad=1.522e-14 ps=1.19e-06 pd=5e-07 nrd=1.16667 \
        nrs=1.16667 sa=1.15e-06 sb=1.575e-06 sd=160n sca=7.09016 \
        scb=0.00401586 scc=3.69756e-05 m=(1)
mn5 (\16\:n1 n0 \1\:VSS VSS) g45n1svt w=(2.6e-07) l=4.5e-08 nf=1 \
        as=8.32e-14 ad=3.64e-14 ps=1.16e-06 pd=8e-07 nrd=1.16667 \
        nrs=1.16667 sa=1.62625e-06 sb=1.4e-07 sd=160n sca=8.65991 \
        scb=0.00681295 scc=0.000165238 m=(1)
mn6_1__rcx (\1\:Y n1 \1\:VSS VSS) g45n1svt w=(2.6e-07) l=4.5e-08 nf=1 \
        as=7.522e-14 ad=4.355e-14 ps=1.2475e-06 pd=8.55e-07 nrd=1.16667 \
        nrs=1.16667 sa=8.975e-07 sb=1.195e-06 sd=160n sca=8.65991 \
        scb=0.00681295 scc=0.000165238 m=(4)
mp5 (\20\:n1 \3\:n0 \1\:VDD NW) g45p1svt w=(3.9e-07) l=4.5e-08 nf=1 \
        as=6.24e-14 ad=5.46e-14 ps=1.1e-06 pd=1.06e-06 nrd=1.16667 \
        nrs=1.16667 sa=1.5266e-06 sb=1.4e-07 sd=160n sca=20.2961 \
        scb=0.018091 scc=0.00149586 m=(1)
mp6_1__rcx (Y n1 \1\:VDD NW) g45p1svt w=(3.9e-07) l=4.5e-08 nf=1 \
        as=6.139e-14 ad=6.727e-14 ps=1.115e-06 pd=1.125e-06 nrd=1.16667 \
        nrs=1.16667 sa=9.07628e-07 sb=9.85e-07 sd=160n sca=17.7856 \
        scb=0.015626 scc=0.00148402 m=(4)
ends MXI2X4
// End of subcircuit definition.
