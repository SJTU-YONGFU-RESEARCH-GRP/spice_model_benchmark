// Generated for: spectre (May  1 11:28:26 2013 )
// Library name: gsclib045_backbias
// Cell name: CLKINVX8
// View name: extracted

simulator lang=spectre

subckt CLKINVX8 A NW VDD VSS Y
mp0 (\1\:Y \1\:A \1\:VDD NW) g45p1svt w=(4.45e-07) l=4.5e-08 nf=1 \
        as=6.993e-14 ad=6.993e-14 ps=1.20429e-06 pd=1.20429e-06 \
        nrd=1.16667 nrs=1.16667 sa=1.4e-07 sb=1.37e-06 sd=160n sca=37.2769 \
        scb=0.0322553 scc=0.00356814 m=(7)
C1 (A VSS) capacitor c=2.08287e-17
C2 (Y VSS) capacitor c=1.4391e-17
C3 (NW VSS) capacitor c=2.22761e-16
C4 (VDD VSS) capacitor c=2.17625e-17
C5 (\1\:A VSS) capacitor c=3.97195e-16
C6 (\1\:Y VSS) capacitor c=2.79245e-16
C7 (\1\:VDD VSS) capacitor c=3.68347e-16
C8 (\4\:Y VSS) capacitor c=1.62689e-16
Rk28 (\1\:VSS VSS) resistor r=0.02458 c=0
Rk3 (\1\:A A) resistor r=0.02659 c=0
Rk5 (\1\:Y Y) resistor r=0.1992 c=0
Rk6 (Y \4\:Y) resistor r=0.01233 c=0
Rk20 (\1\:VDD VDD) resistor r=0.02458 c=0
mn0 (\4\:Y \1\:A \1\:VSS VSS) g45n1svt w=(2.95e-07) l=4.5e-08 nf=1 \
        as=4.636e-14 ad=4.636e-14 ps=9.0429e-07 pd=9.0429e-07 nrd=1.16667 \
        nrs=1.16667 sa=1.4e-07 sb=1.37e-06 sd=160n sca=16.4223 \
        scb=0.0158966 scc=0.0014413 m=(7)
ends CLKINVX8
// End of subcircuit definition.
