// Generated for: spectre (May  1 11:32:48 2013 )
// Library name: gsclib045_backbias
// Cell name: SEDFFHQX1
// View name: extracted

simulator lang=spectre

subckt SEDFFHQX1 CK D E NW Q SE SI VDD VSS
mp0 (\7\:Eb \1\:E \19\:VDD NW) g45p1svt w=(2.15e-07) l=4.5e-08 nf=1 \
        as=1.0405e-13 ad=3.01e-14 ps=1.52e-06 pd=7.1e-07 nrd=1.16667 \
        nrs=1.16667 sa=1.4e-07 sb=1.545e-06 sd=160n sca=26.4132 \
        scb=0.0275127 scc=0.00222015 m=(1)
mp10 (\7\:SEb \4\:SE \17\:VDD NW) g45p1svt w=(2.15e-07) l=4.5e-08 nf=1 \
        as=9.545e-14 ad=3.01e-14 ps=1.44e-06 pd=7.1e-07 nrd=1.16667 \
        nrs=1.16667 sa=1.545e-06 sb=1.4e-07 sd=160n sca=21.1782 \
        scb=0.0203295 scc=0.00208843 m=(1)
mp21 (\11\:Ckbb \6\:CKb \1\:VDD NW) g45p1svt w=(2.15e-07) l=4.5e-08 nf=1 \
        as=5.698e-14 ad=3.87e-14 ps=9.6e-07 pd=7.9e-07 nrd=1.16667 \
        nrs=1.16667 sa=1.8e-07 sb=4.65e-07 sd=160n sca=12.1061 \
        scb=0.0090276 scc=8.48627e-05 m=(1)
mp20 (\11\:CKb \1\:CK \1\:VDD NW) g45p1svt w=(2.15e-07) l=4.5e-08 nf=1 \
        as=5.698e-14 ad=3.333e-14 ps=9.6e-07 pd=7.4e-07 nrd=1.16667 \
        nrs=1.16667 sa=4.9e-07 sb=1.55e-07 sd=160n sca=21.8638 \
        scb=0.0242315 scc=0.00109598 m=(1)
C1 (SI VSS) capacitor c=8.31606e-17
C2 (NW VSS) capacitor c=8.67049e-16
C3 (Q VSS) capacitor c=4.10106e-17
C4 (VDD VSS) capacitor c=5.09386e-17
C5 (SE VSS) capacitor c=6.99051e-17
C6 (E VSS) capacitor c=9.29534e-17
C7 (CK VSS) capacitor c=5.63999e-17
C8 (Eb VSS) capacitor c=4.06654e-17
C9 (net526 VSS) capacitor c=3.75784e-18
C10 (Db VSS) capacitor c=1.03378e-16
C11 (net494 VSS) capacitor c=4.2042e-18
C12 (qint VSS) capacitor c=5.99268e-17
C13 (SEb VSS) capacitor c=3.03574e-17
C14 (Dbp VSS) capacitor c=9.78087e-17
C15 (net518 VSS) capacitor c=1.38086e-18
C16 (qbint VSS) capacitor c=2.75014e-17
C17 (n30 VSS) capacitor c=3.85024e-17
C18 (net509 VSS) capacitor c=1.7501e-18
C19 (CKb VSS) capacitor c=7.73984e-17
C20 (mout VSS) capacitor c=5.77335e-17
C21 (Ckbb VSS) capacitor c=4.92171e-17
C22 (n20 VSS) capacitor c=3.9148e-17
C23 (net501 VSS) capacitor c=3.07124e-18
C24 (net449 VSS) capacitor c=6.40668e-18
C25 (net405 VSS) capacitor c=4.25424e-18
C26 (net441 VSS) capacitor c=2.81703e-19
C27 (net426 VSS) capacitor c=3.30932e-18
C28 (net417 VSS) capacitor c=1.17958e-18
C29 (\1\:CK VSS) capacitor c=4.29474e-17
C30 (\6\:CKb VSS) capacitor c=3.66562e-17
C31 (\5\:Ckbb VSS) capacitor c=3.61216e-17
C32 (\4\:CKb VSS) capacitor c=7.88551e-17
C33 (\3\:mout VSS) capacitor c=8.66261e-17
C34 (\3\:n20 VSS) capacitor c=4.18743e-17
C35 (\2\:CKb VSS) capacitor c=4.7475e-17
C36 (\2\:Ckbb VSS) capacitor c=4.37113e-17
C37 (\12\:qbint VSS) capacitor c=5.11156e-17
C38 (\7\:qbint VSS) capacitor c=2.72994e-17
C39 (\8\:qbint VSS) capacitor c=2.0841e-17
C40 (\1\:SI VSS) capacitor c=8.87972e-17
C41 (\3\:SEb VSS) capacitor c=6.32213e-17
C42 (\5\:SE VSS) capacitor c=2.42847e-17
C43 (\4\:SE VSS) capacitor c=2.57212e-17
C44 (\3\:qint VSS) capacitor c=4.44894e-17
C45 (\4\:E VSS) capacitor c=6.98074e-17
C46 (\1\:D VSS) capacitor c=5.24685e-17
C47 (\1\:E VSS) capacitor c=3.78165e-17
C48 (\3\:CK VSS) capacitor c=3.90645e-17
C49 (\10\:CKb VSS) capacitor c=2.7444e-17
C50 (\8\:CKb VSS) capacitor c=4.51818e-17
C51 (\7\:Ckbb VSS) capacitor c=5.17117e-17
C52 (\3\:Ckbb VSS) capacitor c=4.26036e-17
C53 (\9\:qbint VSS) capacitor c=5.34913e-17
C54 (\3\:n30 VSS) capacitor c=4.65101e-17
C55 (\6\:qbint VSS) capacitor c=2.58224e-17
C56 (\5\:qbint VSS) capacitor c=2.34841e-17
C57 (\3\:SI VSS) capacitor c=6.04152e-17
C58 (\1\:SE VSS) capacitor c=1.02496e-16
C59 (\6\:SE VSS) capacitor c=3.19254e-17
C60 (\3\:Eb VSS) capacitor c=4.68411e-17
C61 (\6\:E VSS) capacitor c=3.47872e-17
C62 (\3\:D VSS) capacitor c=5.25249e-17
C63 (\3\:E VSS) capacitor c=2.17879e-17
C64 (\2\:CK VSS) capacitor c=5.87269e-17
C65 (\9\:CKb VSS) capacitor c=2.42959e-17
C66 (\5\:CKb VSS) capacitor c=2.75189e-17
C67 (\2\:mout VSS) capacitor c=4.33655e-17
C68 (\2\:n20 VSS) capacitor c=4.5898e-17
C69 (\4\:Ckbb VSS) capacitor c=3.87197e-17
C70 (\3\:CKb VSS) capacitor c=2.27618e-17
C71 (\11\:qbint VSS) capacitor c=2.63814e-17
C72 (\2\:n30 VSS) capacitor c=4.02887e-17
C73 (\4\:SI VSS) capacitor c=1.47717e-17
C74 (\4\:SEb VSS) capacitor c=4.68113e-17
C75 (\2\:SEb VSS) capacitor c=3.74795e-17
C76 (\3\:SE VSS) capacitor c=3.71862e-17
C77 (\2\:qint VSS) capacitor c=4.04583e-17
C78 (\4\:Eb VSS) capacitor c=3.39561e-17
C79 (\5\:E VSS) capacitor c=5.56957e-17
C80 (\2\:Eb VSS) capacitor c=4.05416e-17
C81 (\2\:D VSS) capacitor c=4.66566e-17
C82 (\2\:E VSS) capacitor c=2.65278e-17
C83 (\11\:CKb VSS) capacitor c=4.2364e-17
C84 (\1\:VDD VSS) capacitor c=1.70041e-16
C85 (\11\:Ckbb VSS) capacitor c=1.36493e-16
C86 (\8\:n20 VSS) capacitor c=3.66083e-17
C87 (\9\:VDD VSS) capacitor c=3.17054e-17
C88 (\8\:mout VSS) capacitor c=6.83803e-17
C89 (\8\:n30 VSS) capacitor c=4.76203e-17
C90 (\11\:VDD VSS) capacitor c=4.72932e-17
C91 (\17\:qbint VSS) capacitor c=5.36373e-17
C92 (\4\:Q VSS) capacitor c=7.61776e-17
C93 (\13\:VDD VSS) capacitor c=7.77899e-17
C94 (\4\:qint VSS) capacitor c=2.59066e-16
C95 (\15\:VDD VSS) capacitor c=4.62146e-17
C96 (\7\:Dbp VSS) capacitor c=1.00916e-16
C97 (\7\:SEb VSS) capacitor c=1.14629e-16
C98 (\17\:VDD VSS) capacitor c=6.07686e-17
C99 (\7\:Db VSS) capacitor c=9.03307e-17
C100 (\19\:VDD VSS) capacitor c=3.95999e-17
C101 (\7\:Eb VSS) capacitor c=7.09017e-17
C102 (\15\:CKb VSS) capacitor c=4.86481e-17
C103 (\15\:Ckbb VSS) capacitor c=1.30706e-16
C104 (\3\:Dbp VSS) capacitor c=3.30189e-16
C105 (\4\:n20 VSS) capacitor c=7.58524e-17
C106 (\6\:mout VSS) capacitor c=3.3191e-17
C107 (\4\:n30 VSS) capacitor c=8.43067e-17
C108 (\15\:qbint VSS) capacitor c=3.64626e-17
C109 (\1\:Q VSS) capacitor c=2.89229e-17
C110 (\7\:qint VSS) capacitor c=5.25155e-17
C111 (\5\:Dbp VSS) capacitor c=3.2511e-16
C112 (\3\:Db VSS) capacitor c=1.7729e-16
C113 (\10\:SEb VSS) capacitor c=9.59199e-17
C114 (\5\:Db VSS) capacitor c=1.49675e-16
C115 (\5\:Eb VSS) capacitor c=6.72616e-17
C116 (\2\:SE VSS) capacitor c=5.6123e-17
C117 (\2\:SI VSS) capacitor c=3.68558e-17
C118 (\2\:qbint VSS) capacitor c=8.49189e-18
C119 (\3\:qbint VSS) capacitor c=1.07698e-17
C120 (\4\:qbint VSS) capacitor c=1.13492e-17
C121 (\10\:qbint VSS) capacitor c=2.18448e-17
C122 (\6\:Ckbb VSS) capacitor c=2.98081e-17
C123 (\4\:D VSS) capacitor c=1.15127e-16
C124 (\7\:E VSS) capacitor c=8.09014e-17
C125 (\7\:CKb VSS) capacitor c=3.797e-17
C126 (\9\:Eb VSS) capacitor c=1.16297e-16
C127 (\10\:Eb VSS) capacitor c=4.95571e-17
C128 (\11\:Eb VSS) capacitor c=1.2457e-16
C129 (\7\:SE VSS) capacitor c=4.05054e-17
C130 (\5\:SEb VSS) capacitor c=7.83703e-17
C131 (\6\:SEb VSS) capacitor c=1.42801e-16
C132 (\9\:SEb VSS) capacitor c=8.06967e-17
C133 (\5\:SI VSS) capacitor c=3.27029e-17
C134 (\6\:qint VSS) capacitor c=2.38958e-16
C135 (\3\:Q VSS) capacitor c=3.88089e-17
C136 (\13\:qbint VSS) capacitor c=5.36332e-17
C137 (\14\:qbint VSS) capacitor c=6.32532e-17
C138 (\6\:n30 VSS) capacitor c=8.50694e-17
C139 (\7\:n30 VSS) capacitor c=5.54079e-17
C140 (\4\:mout VSS) capacitor c=5.34166e-17
C141 (\5\:mout VSS) capacitor c=5.06891e-17
C142 (\6\:n20 VSS) capacitor c=5.96068e-17
C143 (\7\:n20 VSS) capacitor c=5.42465e-17
C144 (\9\:Ckbb VSS) capacitor c=5.66462e-17
C145 (\10\:Ckbb VSS) capacitor c=1.51822e-16
C146 (\13\:Ckbb VSS) capacitor c=1.49784e-16
C147 (\14\:Ckbb VSS) capacitor c=4.42798e-17
C148 (\4\:CK VSS) capacitor c=3.51429e-17
C149 (\13\:CKb VSS) capacitor c=1.66734e-16
C150 (\14\:CKb VSS) capacitor c=8.94369e-17
C151 (\17\:CKb VSS) capacitor c=1.76996e-16
C152 (\18\:CKb VSS) capacitor c=7.5622e-17
C153 (\3\:VDD VSS) capacitor c=1.56535e-16
C154 (\4\:VDD VSS) capacitor c=9.42628e-17
C155 (\5\:VDD VSS) capacitor c=5.51622e-17
C156 (\6\:VDD VSS) capacitor c=1.02559e-16
C157 (\7\:VDD VSS) capacitor c=1.26675e-16
C158 (\8\:VDD VSS) capacitor c=6.76697e-17
Rk1 (D \4\:D) resistor r=0.003212 c=0
Rk16 (\5\:SI SI) resistor r=0.1334 c=0
Rk62 (\2\:VSS \4\:VSS) resistor r=0.4192 c=0
Rk63 (\4\:VSS \5\:VSS) resistor r=0.2758 c=0
Rk64 (\5\:VSS \6\:VSS) resistor r=0.5114 c=0
Rk65 (\6\:VSS \7\:VSS) resistor r=0.2657 c=0
Rk66 (\7\:VSS \8\:VSS) resistor r=0.1293 c=0
Rk67 (\8\:VSS \9\:VSS) resistor r=0.3072 c=0
Rk68 (\9\:VSS \10\:VSS) resistor r=0.6167 c=0
Rk69 (\10\:VSS \11\:VSS) resistor r=0.1478 c=0
Rk71 (\12\:VSS VSS) resistor r=0.278 c=0
Rk70 (\11\:VSS \12\:VSS) resistor r=0.2732 c=0
Rk72 (\5\:VSS \14\:VSS) resistor r=0.1632 c=0
Rk73 (\6\:VSS \16\:VSS) resistor r=0.1632 c=0
Rk74 (\8\:VSS \18\:VSS) resistor r=0.04333 c=0
Rk75 (\9\:VSS \20\:VSS) resistor r=0.2216 c=0
Rk76 (\10\:VSS \22\:VSS) resistor r=0.2016 c=0
Rk77 (\12\:VSS \24\:VSS) resistor r=0.2048 c=0
Rk20 (\3\:Q Q) resistor r=0.1692 c=0
Rk19 (\2\:Q \3\:Q) resistor r=0.1225 c=0
Rk21 (\3\:Q \5\:Q) resistor r=0.2854 c=0
Rk49 (\2\:VDD \3\:VDD) resistor r=0.7523 c=0
Rk50 (\3\:VDD \4\:VDD) resistor r=0.5004 c=0
Rk51 (\4\:VDD \5\:VDD) resistor r=0.3634 c=0
Rk52 (\5\:VDD \6\:VDD) resistor r=0.2078 c=0
Rk53 (\6\:VDD \7\:VDD) resistor r=0.7121 c=0
Rk55 (\8\:VDD VDD) resistor r=0.278 c=0
Rk54 (\7\:VDD \8\:VDD) resistor r=0.411 c=0
Rk56 (\3\:VDD \10\:VDD) resistor r=0.04333 c=0
Rk57 (\4\:VDD \12\:VDD) resistor r=0.3154 c=0
Rk58 (\5\:VDD \14\:VDD) resistor r=0.4456 c=0
Rk59 (\6\:VDD \16\:VDD) resistor r=0.2566 c=0
Rk60 (\7\:VDD \18\:VDD) resistor r=0.2827 c=0
Rk61 (\8\:VDD \20\:VDD) resistor r=0.2518 c=0
Rk8 (\7\:SE SE) resistor r=0.13 c=0
Rk3 (\8\:E E) resistor r=0.004287 c=0
Rk2 (\7\:E \8\:E) resistor r=0.5742 c=0
Rk43 (CK \4\:CK) resistor r=0.1112 c=0
Rk4 (\6\:Eb \8\:Eb) resistor r=0.548 c=0
Rk5 (\8\:Eb \9\:Eb) resistor r=0.4272 c=0
Rk6 (\9\:Eb \10\:Eb) resistor r=0.1752 c=0
Rk7 (\9\:Eb \11\:Eb) resistor r=0.7856 c=0
Rk9 (\2\:Db \4\:Db) resistor r=0.585 c=0
Rk10 (\4\:Db \6\:Db) resistor r=0.8979 c=0
Rk11 (\6\:Db \8\:Db) resistor r=0.4397 c=0
Rk17 (\5\:qint \6\:qint) resistor r=1.9244 c=0
Rk18 (\5\:qint \8\:qint) resistor r=0.2673 c=0
Rk12 (\5\:SEb \6\:SEb) resistor r=0.5176 c=0
Rk13 (\6\:SEb \8\:SEb) resistor r=0.4142 c=0
Rk14 (\6\:SEb \9\:SEb) resistor r=0.3774 c=0
Rk15 (\8\:SEb \11\:SEb) resistor r=0.5281 c=0
Rk34 (\2\:Dbp \4\:Dbp) resistor r=0.4211 c=0
Rk35 (\4\:Dbp \6\:Dbp) resistor r=2.5236 c=0
Rk36 (\6\:Dbp \8\:Dbp) resistor r=0.3891 c=0
Rk22 (\13\:qbint \14\:qbint) resistor r=0.2652 c=0
Rk23 (\14\:qbint \16\:qbint) resistor r=0.1484 c=0
Rk24 (\14\:qbint \18\:qbint) resistor r=0.3029 c=0
Rk25 (\5\:n30 \6\:n30) resistor r=0.5183 c=0
Rk26 (\6\:n30 \7\:n30) resistor r=0.2668 c=0
Rk27 (\6\:n30 \9\:n30) resistor r=0.2781 c=0
Rk44 (\12\:CKb \13\:CKb) resistor r=0.2948 c=0
Rk45 (\13\:CKb \14\:CKb) resistor r=0.6009 c=0
Rk46 (\14\:CKb \16\:CKb) resistor r=0.2778 c=0
Rk47 (\13\:CKb \17\:CKb) resistor r=0.8113 c=0
Rk48 (\17\:CKb \18\:CKb) resistor r=0.6058 c=0
Rk28 (\4\:mout \5\:mout) resistor r=0.2704 c=0
Rk29 (\5\:mout \7\:mout) resistor r=0.06976 c=0
Rk30 (\5\:mout \9\:mout) resistor r=0.2704 c=0
Rk37 (\9\:Ckbb \10\:Ckbb) resistor r=0.2388 c=0
Rk38 (\10\:Ckbb \12\:Ckbb) resistor r=0.3582 c=0
Rk39 (\10\:Ckbb \13\:Ckbb) resistor r=0.9467 c=0
Rk40 (\13\:Ckbb \14\:Ckbb) resistor r=0.1615 c=0
Rk41 (\12\:Ckbb \16\:Ckbb) resistor r=0.7527 c=0
Rk42 (\13\:Ckbb \17\:Ckbb) resistor r=0.0463 c=0
Rk31 (\5\:n20 \6\:n20) resistor r=0.439 c=0
Rk32 (\6\:n20 \7\:n20) resistor r=0.2704 c=0
Rk33 (\6\:n20 \9\:n20) resistor r=0.07077 c=0
Rl3 (\1\:D \2\:D) resistor r=33.8482 c=0
Rl4 (\2\:D \3\:D) resistor r=106.925 c=0
Rl18 (\1\:SI \2\:SI) resistor r=86.2409 c=0
Rl19 (\2\:SI \3\:SI) resistor r=63.9053 c=0
Rl20 (\2\:SI \4\:SI) resistor r=4.5264 c=0
Rl14 (\3\:SE \4\:SE) resistor r=35.3482 c=0
Rl16 (\3\:SE \6\:SE) resistor r=99.7951 c=0
Rl15 (\2\:SE \5\:SE) resistor r=32.3738 c=0
Rl12 (\1\:SE \2\:SE) resistor r=216.851 c=0
Rl13 (\2\:SE \3\:SE) resistor r=146.543 c=0
Rl6 (\4\:E \5\:E) resistor r=177.966 c=0
Rl7 (\5\:E \6\:E) resistor r=24.2328 c=0
Rl1 (\1\:E \2\:E) resistor r=111.538 c=0
Rl2 (\2\:E \3\:E) resistor r=33.7912 c=0
Rl49 (\1\:CK \2\:CK) resistor r=214.129 c=0
Rl50 (\2\:CK \3\:CK) resistor r=101.374 c=0
Rl8 (\3\:Eb \4\:Eb) resistor r=33.8482 c=0
Rl5 (Eb \2\:Eb) resistor r=24.2328 c=0
Rl10 (\2\:qint \3\:qint) resistor r=35.989 c=0
Rl9 (qint \2\:qint) resistor r=108.883 c=0
Rl17 (\3\:SEb \4\:SEb) resistor r=29.5379 c=0
Rl11 (SEb \2\:SEb) resistor r=54.5379 c=0
Rl25 (\2\:qbint \6\:qbint) resistor r=30.4507 c=0
Rl21 (qbint \2\:qbint) resistor r=83.8288 c=0
Rl26 (\3\:qbint \7\:qbint) resistor r=47.7584 c=0
Rl22 (\2\:qbint \3\:qbint) resistor r=19.6209 c=0
Rl27 (\4\:qbint \8\:qbint) resistor r=53.0797 c=0
Rl24 (\4\:qbint \5\:qbint) resistor r=35.772 c=0
Rl23 (\3\:qbint \4\:qbint) resistor r=70.0689 c=0
Rl32 (\10\:qbint \12\:qbint) resistor r=71.8171 c=0
Rl30 (\9\:qbint \10\:qbint) resistor r=88.7699 c=0
Rl31 (\10\:qbint \11\:qbint) resistor r=5.8511 c=0
Rl28 (n30 \2\:n30) resistor r=29.5379 c=0
Rl29 (\2\:n30 \3\:n30) resistor r=79.5379 c=0
Rl34 (CKb \2\:CKb) resistor r=136.104 c=0
Rl48 (\9\:CKb \10\:CKb) resistor r=39.1533 c=0
Rl41 (\4\:CKb \5\:CKb) resistor r=53.079 c=0
Rl35 (\2\:CKb \3\:CKb) resistor r=24.2328 c=0
Rl45 (\6\:CKb \7\:CKb) resistor r=185.772 c=0
Rl46 (\7\:CKb \8\:CKb) resistor r=177.349 c=0
Rl47 (\7\:CKb \9\:CKb) resistor r=80.6945 c=0
Rl40 (\2\:mout \3\:mout) resistor r=70.6854 c=0
Rl39 (mout \2\:mout) resistor r=57.929 c=0
Rl36 (\3\:Ckbb \4\:Ckbb) resistor r=55.0021 c=0
Rl33 (Ckbb \2\:Ckbb) resistor r=34.6607 c=0
Rl42 (\5\:Ckbb \6\:Ckbb) resistor r=38.8561 c=0
Rl43 (\6\:Ckbb \7\:Ckbb) resistor r=96.0468 c=0
Rl44 (\6\:Ckbb \8\:Ckbb) resistor r=2.9709 c=0
Rl38 (\2\:n20 \3\:n20) resistor r=45.708 c=0
Rl37 (n20 \2\:n20) resistor r=72.3097 c=0
Rz15 (\1\:VSS \2\:VSS) resistor r=75 c=0
Rz16 (\13\:VSS \14\:VSS) resistor r=75 c=0
Rz17 (\15\:VSS \16\:VSS) resistor r=75 c=0
Rz18 (\17\:VSS \18\:VSS) resistor r=75 c=0
Rz19 (\19\:VSS \20\:VSS) resistor r=75 c=0
Rz20 (\21\:VSS \22\:VSS) resistor r=75 c=0
Rz21 (\23\:VSS \24\:VSS) resistor r=75 c=0
Rz6 (\1\:Q \2\:Q) resistor r=75 c=0
Rz1 (\5\:Eb \6\:Eb) resistor r=75 c=0
Rz2 (\3\:Db \4\:Db) resistor r=75 c=0
Rz3 (\5\:Db \6\:Db) resistor r=75 c=0
Rz5 (\7\:qint \8\:qint) resistor r=75 c=0
Rz4 (\10\:SEb \11\:SEb) resistor r=75 c=0
Rz11 (\3\:Dbp \4\:Dbp) resistor r=75 c=0
Rz12 (\5\:Dbp \6\:Dbp) resistor r=75 c=0
Rz7 (\15\:qbint \16\:qbint) resistor r=75 c=0
Rz8 (\4\:n30 \5\:n30) resistor r=75 c=0
Rz14 (\15\:CKb \16\:CKb) resistor r=75 c=0
Rz9 (\6\:mout \7\:mout) resistor r=75 c=0
Rz13 (\15\:Ckbb \16\:Ckbb) resistor r=75 c=0
Rz10 (\4\:n20 \5\:n20) resistor r=75 c=0
Ry22 (\3\:VSS \4\:VSS) resistor r=6.8889 c=0
Ry23 (\3\:VSS \7\:VSS) resistor r=5.1667 c=0
Ry24 (\3\:VSS \11\:VSS) resistor r=5.1667 c=0
Ry6 (\4\:Q \5\:Q) resistor r=20.6667 c=0
Ry15 (\1\:VDD \2\:VDD) resistor r=62 c=0
Ry16 (\9\:VDD \10\:VDD) resistor r=62 c=0
Ry17 (\11\:VDD \12\:VDD) resistor r=62 c=0
Ry18 (\13\:VDD \14\:VDD) resistor r=31 c=0
Ry19 (\15\:VDD \16\:VDD) resistor r=62 c=0
Ry20 (\17\:VDD \18\:VDD) resistor r=62 c=0
Ry21 (\19\:VDD \20\:VDD) resistor r=62 c=0
Ry1 (\7\:Eb \8\:Eb) resistor r=62 c=0
Ry2 (Db \2\:Db) resistor r=62 c=0
Ry3 (\7\:Db \8\:Db) resistor r=62 c=0
Ry5 (\4\:qint \5\:qint) resistor r=62 c=0
Ry4 (\7\:SEb \8\:SEb) resistor r=62 c=0
Ry11 (Dbp \2\:Dbp) resistor r=62 c=0
Ry12 (\7\:Dbp \8\:Dbp) resistor r=62 c=0
Ry7 (\17\:qbint \18\:qbint) resistor r=31 c=0
Ry8 (\8\:n30 \9\:n30) resistor r=62 c=0
Ry14 (\11\:CKb \12\:CKb) resistor r=62 c=0
Ry9 (\8\:mout \9\:mout) resistor r=62 c=0
Ry13 (\11\:Ckbb \12\:Ckbb) resistor r=62 c=0
Ry10 (\8\:n20 \9\:n20) resistor r=62 c=0
Rx1 (\2\:D \4\:D) resistor r=45 c=0
Rx9 (\4\:SI \5\:SI) resistor r=45 c=0
Rx6 (\3\:SE \7\:SE) resistor r=45 c=0
Rx2 (\5\:E \7\:E) resistor r=45 c=0
Rx3 (\2\:E \8\:E) resistor r=45 c=0
Rx19 (\2\:CK \4\:CK) resistor r=45 c=0
Rx4 (\2\:Eb \10\:Eb) resistor r=45 c=0
Rx5 (\4\:Eb \11\:Eb) resistor r=45 c=0
Rx10 (\2\:qint \6\:qint) resistor r=45 c=0
Rx7 (\4\:SEb \5\:SEb) resistor r=45 c=0
Rx8 (\2\:SEb \9\:SEb) resistor r=45 c=0
Rx11 (\11\:qbint \13\:qbint) resistor r=45 c=0
Rx12 (qbint \14\:qbint) resistor r=45 c=0
Rx13 (\2\:n30 \7\:n30) resistor r=45 c=0
Rx20 (\9\:CKb \14\:CKb) resistor r=45 c=0
Rx21 (\5\:CKb \17\:CKb) resistor r=45 c=0
Rx22 (\3\:CKb \18\:CKb) resistor r=45 c=0
Rx14 (\2\:mout \4\:mout) resistor r=45 c=0
Rx16 (\8\:Ckbb \9\:Ckbb) resistor r=45 c=0
Rx17 (Ckbb \14\:Ckbb) resistor r=45 c=0
Rx18 (\4\:Ckbb \17\:Ckbb) resistor r=45 c=0
Rx15 (\2\:n20 \7\:n20) resistor r=45 c=0
mn0 (\5\:Eb \3\:E \23\:VSS VSS) g45n1svt w=(1.45e-07) l=4.5e-08 nf=1 \
        as=7.773e-14 ad=2.03e-14 ps=1.37e-06 pd=5.7e-07 nrd=1.16667 \
        nrs=1.16667 sa=1.4e-07 sb=1.655e-06 sd=160n sca=10.9472 \
        scb=0.0104991 scc=0.000356047 m=(1)
mn10 (\10\:SEb \6\:SE \21\:VSS VSS) g45n1svt w=(1.45e-07) l=4.5e-08 nf=1 \
        as=6.468e-14 ad=2.03e-14 ps=1.19e-06 pd=5.7e-07 nrd=1.16667 \
        nrs=1.16667 sa=1.655e-06 sb=1.4e-07 sd=160n sca=10.9472 \
        scb=0.0104991 scc=0.000356047 m=(1)
mn21 (\15\:Ckbb \10\:CKb \1\:VSS VSS) g45n1svt w=(1.45e-07) l=4.5e-08 \
        nf=1 as=2.32e-14 ad=2.03e-14 ps=6.1e-07 pd=5.7e-07 nrd=1.16667 \
        nrs=1.16667 sa=1.4e-07 sb=3.45e-07 sd=160n sca=6.59604 \
        scb=0.00318587 scc=2.16275e-05 m=(1)
mn20 (\15\:CKb \3\:CK \1\:VSS VSS) g45n1svt w=(1.45e-07) l=4.5e-08 nf=1 \
        as=2.32e-14 ad=2.03e-14 ps=6.1e-07 pd=5.7e-07 nrd=1.16667 \
        nrs=1.16667 sa=3.45e-07 sb=1.4e-07 sd=160n sca=6.59604 \
        scb=0.00318587 scc=2.16275e-05 m=(1)
mn3 (net526 \3\:D \23\:VSS VSS) g45n1svt w=(2.6e-07) l=4.5e-08 nf=1 \
        as=7.773e-14 ad=4.29e-14 ps=1.37e-06 pd=8.5e-07 nrd=1.16667 \
        nrs=1.16667 sa=4.02115e-07 sb=1.01692e-06 sd=160n sca=9.14564 \
        scb=0.00759168 scc=0.000213449 m=(1)
mn4 (\5\:Db \6\:E net526 VSS) g45n1svt w=(2.6e-07) l=4.5e-08 nf=1 \
        as=4.29e-14 ad=5.98e-14 ps=8.5e-07 pd=9.8e-07 nrd=1.16667 \
        nrs=1.16667 sa=6.12115e-07 sb=8.06923e-07 sd=160n sca=9.14564 \
        scb=0.00759168 scc=0.000213449 m=(1)
mn2 (\5\:Db \3\:Eb net494 VSS) g45n1svt w=(2.6e-07) l=4.5e-08 nf=1 \
        as=3.51e-14 ad=5.98e-14 ps=7.9e-07 pd=9.8e-07 nrd=1.16667 \
        nrs=1.16667 sa=8.87115e-07 sb=5.31923e-07 sd=160n sca=9.14564 \
        scb=0.00759168 scc=0.000213449 m=(1)
mn1 (net494 qint \21\:VSS VSS) g45n1svt w=(2.6e-07) l=4.5e-08 nf=1 \
        as=6.468e-14 ad=3.51e-14 ps=1.19e-06 pd=7.9e-07 nrd=1.16667 \
        nrs=1.16667 sa=1.06712e-06 sb=3.51923e-07 sd=160n sca=9.14564 \
        scb=0.00759168 scc=0.000213449 m=(1)
mn11 (\3\:Db SEb \5\:Dbp VSS) g45n1svt w=(2.6e-07) l=4.5e-08 nf=1 \
        as=4.94e-14 ad=3.64e-14 ps=9e-07 pd=8e-07 nrd=1.16667 nrs=1.16667 \
        sa=1.4e-07 sb=4.8e-07 sd=160n sca=10.104 scb=0.00906063 \
        scc=0.000325539 m=(1)
mn13 (\5\:Dbp \1\:SE net518 VSS) g45n1svt w=(2.6e-07) l=4.5e-08 nf=1 \
        as=1.56e-14 ad=4.94e-14 ps=6.4e-07 pd=9e-07 nrd=1.16667 \
        nrs=1.16667 sa=3.75e-07 sb=2.45e-07 sd=160n sca=10.104 \
        scb=0.00906063 scc=0.000325539 m=(1)
mn12 (net518 \3\:SI \19\:VSS VSS) g45n1svt w=(2.6e-07) l=4.5e-08 nf=1 \
        as=3.64e-14 ad=1.56e-14 ps=8e-07 pd=6.4e-07 nrd=1.16667 \
        nrs=1.16667 sa=4.8e-07 sb=1.4e-07 sd=160n sca=10.104 \
        scb=0.00906063 scc=0.000325539 m=(1)
mn55 (\1\:Q \6\:qbint \17\:VSS VSS) g45n1svt w=(2.6e-07) l=4.5e-08 nf=1 \
        as=9.285e-14 ad=3.64e-14 ps=1.6e-06 pd=8e-07 nrd=1.16667 \
        nrs=1.16667 sa=3.55288e-07 sb=1.4e-07 sd=160n sca=17.5885 \
        scb=0.0172826 scc=0.00162584 m=(1)
mn56 (\7\:qint \5\:qbint \17\:VSS VSS) g45n1svt w=(2.05e-07) l=4.5e-08 \
        nf=1 as=9.285e-14 ad=2.87e-14 ps=1.6e-06 pd=6.9e-07 nrd=1.16667 \
        nrs=1.16667 sa=1.4e-07 sb=4.05e-07 sd=160n sca=19.867 \
        scb=0.0198061 scc=0.00201945 m=(1)
mn45 (\15\:qbint \3\:n30 \15\:VSS VSS) g45n1svt w=(2.05e-07) l=4.5e-08 \
        nf=1 as=9.278e-14 ad=3.895e-14 ps=1.51e-06 pd=7.9e-07 nrd=1.16667 \
        nrs=1.16667 sa=1.9e-07 sb=1.87e-06 sd=160n sca=19.867 \
        scb=0.0198061 scc=0.00201945 m=(1)
mn50 (net509 \9\:qbint \15\:VSS VSS) g45n1svt w=(2.05e-07) l=4.5e-08 \
        nf=1 as=9.278e-14 ad=2.87e-14 ps=1.51e-06 pd=6.9e-07 nrd=1.16667 \
        nrs=1.16667 sa=5.5e-07 sb=1.51e-06 sd=160n sca=19.867 \
        scb=0.0198061 scc=0.00201945 m=(1)
mn51 (\4\:n30 CKb net509 VSS) g45n1svt w=(2.05e-07) l=4.5e-08 nf=1 \
        as=2.87e-14 ad=3.28e-14 ps=6.9e-07 pd=7.3e-07 nrd=1.16667 \
        nrs=1.16667 sa=7.35e-07 sb=1.325e-06 sd=160n sca=19.867 \
        scb=0.0198061 scc=0.00201945 m=(1)
mn40 (\4\:n30 \3\:Ckbb \6\:mout VSS) g45n1svt w=(2.05e-07) l=4.5e-08 nf=1 \
        as=4.613e-14 ad=3.28e-14 ps=8.6e-07 pd=7.3e-07 nrd=1.16667 \
        nrs=1.16667 sa=9.4e-07 sb=1.12e-06 sd=160n sca=19.867 \
        scb=0.0198061 scc=0.00201945 m=(1)
mn30 (\6\:mout n20 \13\:VSS VSS) g45n1svt w=(2.05e-07) l=4.5e-08 nf=1 \
        as=9.278e-14 ad=4.613e-14 ps=1.51e-06 pd=8.6e-07 nrd=1.16667 \
        nrs=1.16667 sa=1.21e-06 sb=8.5e-07 sd=160n sca=19.867 \
        scb=0.0198061 scc=0.00201945 m=(1)
mn35 (net501 mout \13\:VSS VSS) g45n1svt w=(2.05e-07) l=4.5e-08 nf=1 \
        as=9.278e-14 ad=2.05e-14 ps=1.51e-06 pd=6.1e-07 nrd=1.16667 \
        nrs=1.16667 sa=1.57e-06 sb=4.9e-07 sd=160n sca=19.867 \
        scb=0.0198061 scc=0.00201945 m=(1)
mn36 (\4\:n20 \7\:Ckbb net501 VSS) g45n1svt w=(2.05e-07) l=4.5e-08 nf=1 \
        as=2.05e-14 ad=3.28e-14 ps=6.1e-07 pd=7.3e-07 nrd=1.16667 \
        nrs=1.16667 sa=1.715e-06 sb=3.45e-07 sd=160n sca=19.867 \
        scb=0.0198061 scc=0.00201945 m=(1)
mn25 (\4\:n20 \8\:CKb \3\:Dbp VSS) g45n1svt w=(2.05e-07) l=4.5e-08 nf=1 \
        as=2.87e-14 ad=3.28e-14 ps=6.9e-07 pd=7.3e-07 nrd=1.16667 \
        nrs=1.16667 sa=1.92e-06 sb=1.4e-07 sd=160n sca=19.867 \
        scb=0.0198061 scc=0.00201945 m=(1)
mp3 (net449 \1\:D \19\:VDD NW) g45p1svt w=(3.9e-07) l=4.5e-08 nf=1 \
        as=1.0405e-13 ad=5.265e-14 ps=1.52e-06 pd=1.05e-06 nrd=1.16667 \
        nrs=1.16667 sa=3.68782e-07 sb=9.61731e-07 sd=160n sca=16.8075 \
        scb=0.014774 scc=0.00118868 m=(1)
mp4 (\7\:Db Eb net449 NW) g45p1svt w=(3.9e-07) l=4.5e-08 nf=1 \
        as=5.265e-14 ad=8.19e-14 ps=1.05e-06 pd=1.2e-06 nrd=1.16667 \
        nrs=1.16667 sa=5.48782e-07 sb=7.81731e-07 sd=160n sca=16.3155 \
        scb=0.0145891 scc=0.00118861 m=(1)
mp2 (\7\:Db \4\:E net405 NW) g45p1svt w=(3.9e-07) l=4.5e-08 nf=1 \
        as=5.265e-14 ad=8.19e-14 ps=1.05e-06 pd=1.2e-06 nrd=1.16667 \
        nrs=1.16667 sa=8.03782e-07 sb=5.26731e-07 sd=160n sca=16.2669 \
        scb=0.0145797 scc=0.00118861 m=(1)
mp1 (net405 \3\:qint \17\:VDD NW) g45p1svt w=(3.9e-07) l=4.5e-08 nf=1 \
        as=9.545e-14 ad=5.265e-14 ps=1.44e-06 pd=1.05e-06 nrd=1.16667 \
        nrs=1.16667 sa=9.83782e-07 sb=3.46731e-07 sd=160n sca=16.2669 \
        scb=0.0145797 scc=0.00118861 m=(1)
mp11 (Db \5\:SE \7\:Dbp NW) g45p1svt w=(3.9e-07) l=4.5e-08 nf=1 \
        as=1.404e-13 ad=5.46e-14 ps=1.5e-06 pd=1.06e-06 nrd=1.16667 \
        nrs=1.16667 sa=1.4e-07 sb=6.48462e-07 sd=160n sca=15.8351 \
        scb=0.0142471 scc=0.00110276 m=(1)
mp13 (\7\:Dbp \3\:SEb net441 NW) g45p1svt w=(3.9e-07) l=4.5e-08 nf=1 \
        as=2.34e-14 ad=1.404e-13 ps=9e-07 pd=1.5e-06 nrd=1.16667 \
        nrs=1.16667 sa=5.45e-07 sb=2.43462e-07 sd=160n sca=15.8351 \
        scb=0.0142471 scc=0.00110276 m=(1)
mp12 (net441 \1\:SI \15\:VDD NW) g45p1svt w=(3.9e-07) l=4.5e-08 nf=1 \
        as=5.4e-14 ad=2.34e-14 ps=1.23e-06 pd=9e-07 nrd=1.16667 \
        nrs=1.16667 sa=6.5e-07 sb=1.38462e-07 sd=160n sca=15.8351 \
        scb=0.0142471 scc=0.00110276 m=(1)
mp55 (\4\:Q \7\:qbint \13\:VDD NW) g45p1svt w=(3.9e-07) l=4.5e-08 nf=1 \
        as=5.76e-14 ad=5.46e-14 ps=1.1e-06 pd=1.06e-06 nrd=1.16667 \
        nrs=1.16667 sa=2.75256e-07 sb=1.4e-07 sd=160n sca=30.5009 \
        scb=0.0202006 scc=0.00336097 m=(1)
mp56 (\4\:qint \8\:qbint \13\:VDD NW) g45p1svt w=(3.1e-07) l=4.5e-08 \
        nf=1 as=5.76e-14 ad=3.58e-14 ps=1.1e-06 pd=9e-07 nrd=1.16667 \
        nrs=1.16667 sa=1.15484e-07 sb=3.45e-07 sd=160n sca=35.6995 \
        scb=0.0234062 scc=0.00420468 m=(1)
mp45 (\17\:qbint n30 \11\:VDD NW) g45p1svt w=(3.1e-07) l=4.5e-08 nf=1 \
        as=4.96e-14 ad=6.975e-14 ps=9.4e-07 pd=1.07e-06 nrd=1.16667 \
        nrs=1.16667 sa=2.25e-07 sb=1.83e-06 sd=160n sca=14.8314 \
        scb=0.0138806 scc=0.000865287 m=(1)
mp50 (net426 \12\:qbint \11\:VDD NW) g45p1svt w=(3.1e-07) l=4.5e-08 nf=1 \
        as=4.96e-14 ad=4.34e-14 ps=9.4e-07 pd=9e-07 nrd=1.16667 \
        nrs=1.16667 sa=4.3e-07 sb=1.625e-06 sd=160n sca=14.8314 \
        scb=0.0138806 scc=0.000865287 m=(1)
mp51 (\8\:n30 \2\:Ckbb net426 NW) g45p1svt w=(3.1e-07) l=4.5e-08 nf=1 \
        as=4.34e-14 ad=4.96e-14 ps=9e-07 pd=9.4e-07 nrd=1.16667 \
        nrs=1.16667 sa=6.15e-07 sb=1.44e-06 sd=160n sca=14.8314 \
        scb=0.0138806 scc=0.000865287 m=(1)
mp40 (\8\:n30 \2\:CKb \8\:mout NW) g45p1svt w=(3.1e-07) l=4.5e-08 nf=1 \
        as=1.023e-13 ad=4.96e-14 ps=1.28e-06 pd=9.4e-07 nrd=1.16667 \
        nrs=1.16667 sa=8.2e-07 sb=1.235e-06 sd=160n sca=14.8314 \
        scb=0.0138806 scc=0.000865287 m=(1)
mp30 (\8\:mout \3\:n20 \9\:VDD NW) g45p1svt w=(3.1e-07) l=4.5e-08 nf=1 \
        as=1.054e-13 ad=1.023e-13 ps=1.68e-06 pd=1.28e-06 nrd=1.16667 \
        nrs=1.16667 sa=1.195e-06 sb=8.6e-07 sd=160n sca=14.8314 \
        scb=0.0138806 scc=0.000865287 m=(1)
mp35 (net417 \3\:mout \9\:VDD NW) g45p1svt w=(3.1e-07) l=4.5e-08 nf=1 \
        as=1.054e-13 ad=1.86e-14 ps=1.68e-06 pd=7.4e-07 nrd=1.16667 \
        nrs=1.16667 sa=1.46e-06 sb=5.95e-07 sd=160n sca=14.8314 \
        scb=0.0138806 scc=0.000865287 m=(1)
mp36 (\8\:n20 \4\:CKb net417 NW) g45p1svt w=(3.1e-07) l=4.5e-08 nf=1 \
        as=1.86e-14 ad=4.96e-14 ps=7.4e-07 pd=9.4e-07 nrd=1.16667 \
        nrs=1.16667 sa=1.565e-06 sb=4.9e-07 sd=160n sca=14.8314 \
        scb=0.0138806 scc=0.000865287 m=(1)
mp25 (\8\:n20 \5\:Ckbb Dbp NW) g45p1svt w=(3.1e-07) l=4.5e-08 nf=1 \
        as=8.835e-14 ad=4.96e-14 ps=1.19e-06 pd=9.4e-07 nrd=1.16667 \
        nrs=1.16667 sa=1.77e-06 sb=2.85e-07 sd=160n sca=14.8314 \
        scb=0.0138806 scc=0.000865287 m=(1)
ends SEDFFHQX1
// End of subcircuit definition.
