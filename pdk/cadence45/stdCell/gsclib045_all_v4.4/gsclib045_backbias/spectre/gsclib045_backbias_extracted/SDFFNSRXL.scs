// Generated for: spectre (May  1 11:32:13 2013 )
// Library name: gsclib045_backbias
// Cell name: SDFFNSRXL
// View name: extracted

simulator lang=spectre

subckt SDFFNSRXL CKN D NW Q QN RN SE SI SN VDD VSS
mp57 (\1\:QN \4\:qint \25\:VDD NW) g45p1svt w=(2.15e-07) l=4.5e-08 nf=1 \
        as=3.44e-14 ad=3.548e-14 ps=7.5e-07 pd=7.6e-07 nrd=1.16667 \
        nrs=1.16667 sa=1.65e-07 sb=3.45e-07 sd=160n sca=49.1385 \
        scb=0.0321853 scc=0.00591609 m=(1)
mp56 (\5\:qint \7\:qbint \25\:VDD NW) g45p1svt w=(2.15e-07) l=4.5e-08 \
        nf=1 as=3.44e-14 ad=3.01e-14 ps=7.5e-07 pd=7.1e-07 nrd=1.16667 \
        nrs=1.16667 sa=3.7e-07 sb=1.4e-07 sd=160n sca=46.9517 scb=0.029008 \
        scc=0.00588492 m=(1)
mp55 (\1\:Q qbint \23\:VDD NW) g45p1svt w=(2.15e-07) l=4.5e-08 nf=1 \
        as=3.762e-14 ad=3.01e-14 ps=7.8e-07 pd=7.1e-07 nrd=1.16667 \
        nrs=1.16667 sa=1.4e-07 sb=3.6e-07 sd=160n sca=11.1138 \
        scb=0.00912362 scc=0.000187967 m=(1)
mp22 (\9\:RNb \1\:RN \23\:VDD NW) g45p1svt w=(2.15e-07) l=4.5e-08 nf=1 \
        as=3.762e-14 ad=3.01e-14 ps=7.8e-07 pd=7.1e-07 nrd=1.16667 \
        nrs=1.16667 sa=3.6e-07 sb=1.4e-07 sd=160n sca=11.1138 \
        scb=0.00912362 scc=0.000187967 m=(1)
mp45 (\16\:qbint n35 \21\:VDD NW) g45p1svt w=(2.15e-07) l=4.5e-08 nf=1 \
        as=9.89e-14 ad=3.01e-14 ps=1.73e-06 pd=7.1e-07 nrd=1.16667 \
        nrs=1.16667 sa=1.4e-07 sb=8.9e-07 sd=160n sca=19.7413 scb=0.019281 \
        scc=0.00179464 m=(1)
mp50 (\3\:net566 \1\:SN \21\:VDD NW) g45p1svt w=(2.15e-07) l=4.5e-08 \
        nf=1 as=9.89e-14 ad=4.515e-14 ps=1.73e-06 pd=8.5e-07 nrd=1.16667 \
        nrs=1.16667 sa=4.05e-07 sb=6.25e-07 sd=160n sca=19.7413 \
        scb=0.019281 scc=0.00179464 m=(1)
mp52 (\3\:net566 \8\:qbint net414 NW) g45p1svt w=(2.15e-07) l=4.5e-08 \
        nf=1 as=2.902e-14 ad=4.515e-14 ps=7e-07 pd=8.5e-07 nrd=1.16667 \
        nrs=1.16667 sa=6.6e-07 sb=3.7e-07 sd=160n sca=19.7413 scb=0.019281 \
        scc=0.00179464 m=(1)
mp51 (net414 \2\:RNb \19\:VDD NW) g45p1svt w=(2.15e-07) l=4.5e-08 nf=1 \
        as=9.245e-14 ad=2.902e-14 ps=1.67e-06 pd=7e-07 nrd=1.16667 \
        nrs=1.16667 sa=8.4e-07 sb=1.9e-07 sd=160n sca=19.7413 scb=0.019281 \
        scc=0.00179464 m=(1)
mp53 (\8\:n35 \2\:CKNb net566 NW) g45p1svt w=(2.15e-07) l=4.5e-08 nf=1 \
        as=5.053e-14 ad=5.375e-14 ps=9e-07 pd=9.3e-07 nrd=1.16667 \
        nrs=1.16667 sa=2.35e-07 sb=4.35e-07 sd=160n sca=45.7906 \
        scb=0.0283307 scc=0.00588417 m=(1)
mp40 (\8\:n35 CKNbb \8\:mout NW) g45p1svt w=(2.15e-07) l=4.5e-08 nf=1 \
        as=3.01e-14 ad=5.375e-14 ps=7.1e-07 pd=9.3e-07 nrd=1.16667 \
        nrs=1.16667 sa=5.3e-07 sb=1.4e-07 sd=160n sca=45.7906 \
        scb=0.0283307 scc=0.00588417 m=(1)
mp31 (net478 \4\:RNb \17\:VDD NW) g45p1svt w=(2.15e-07) l=4.5e-08 nf=1 \
        as=9.805e-14 ad=4.408e-14 ps=2.11e-06 pd=8.4e-07 nrd=1.16667 \
        nrs=1.16667 sa=3.1e-07 sb=1.01767e-06 sd=160n sca=24.8095 \
        scb=0.0224988 scc=0.00280688 m=(1)
mp32 (\10\:mout n20 net478 NW) g45p1svt w=(2.15e-07) l=4.5e-08 nf=1 \
        as=4.408e-14 ad=3.763e-14 ps=8.4e-07 pd=7.8e-07 nrd=1.16667 \
        nrs=1.16667 sa=5.6e-07 sb=7.67674e-07 sd=160n sca=24.8095 \
        scb=0.0224988 scc=0.00280688 m=(1)
mp30 (\10\:mout \5\:SN \15\:VDD NW) g45p1svt w=(2.15e-07) l=4.5e-08 nf=1 \
        as=6.49e-14 ad=3.763e-14 ps=1.81e-06 pd=7.8e-07 nrd=1.16667 \
        nrs=1.16667 sa=7.8e-07 sb=5.47674e-07 sd=160n sca=24.8095 \
        scb=0.0224988 scc=0.00280688 m=(1)
mp35 (net486 mout \15\:VDD NW) g45p1svt w=(2.15e-07) l=4.5e-08 nf=1 \
        as=6.49e-14 ad=2.15e-14 ps=1.81e-06 pd=6.3e-07 nrd=1.16667 \
        nrs=1.16667 sa=6.14535e-07 sb=6.65e-07 sd=160n sca=14.2498 \
        scb=0.0138057 scc=0.00069487 m=(1)
mp36 (\4\:n20 \8\:CKNbb net486 NW) g45p1svt w=(2.15e-07) l=4.5e-08 nf=1 \
        as=2.15e-14 ad=6.45e-14 ps=6.3e-07 pd=1.03e-06 nrd=1.16667 \
        nrs=1.16667 sa=7.59535e-07 sb=5.2e-07 sd=160n sca=14.2498 \
        scb=0.0138057 scc=0.00069487 m=(1)
mp25 (\4\:n20 \11\:CKNb \8\:Db NW) g45p1svt w=(2.15e-07) l=4.5e-08 nf=1 \
        as=3.763e-14 ad=6.45e-14 ps=7.8e-07 pd=1.03e-06 nrd=1.16667 \
        nrs=1.16667 sa=1.10453e-06 sb=1.75e-07 sd=160n sca=14.2498 \
        scb=0.0138057 scc=0.00069487 m=(1)
mp21 (\11\:CKNbb \3\:CKNb \13\:VDD NW) g45p1svt w=(2.15e-07) l=4.5e-08 \
        nf=1 as=5.515e-14 ad=3.01e-14 ps=1.78e-06 pd=7.1e-07 nrd=1.16667 \
        nrs=1.16667 sa=1.4e-07 sb=1e-07 sd=160n sca=39.8855 scb=0.0273598 \
        scc=0.00519679 m=(1)
mp20 (\14\:CKNb \1\:CKN \11\:VDD NW) g45p1svt w=(2.15e-07) l=4.5e-08 \
        nf=1 as=3.44e-14 ad=3.01e-14 ps=7.5e-07 pd=7.1e-07 nrd=1.16667 \
        nrs=1.16667 sa=1.4e-07 sb=1.395e-06 sd=160n sca=12.1244 \
        scb=0.0107968 scc=0.000332109 m=(1)
mp11 (net461 \1\:D \11\:VDD NW) g45p1svt w=(2.15e-07) l=4.5e-08 nf=1 \
        as=3.44e-14 ad=2.688e-14 ps=7.5e-07 pd=6.8e-07 nrd=1.16667 \
        nrs=1.16667 sa=3.45e-07 sb=1.19e-06 sd=160n sca=12.1244 \
        scb=0.0107968 scc=0.000332109 m=(1)
mp12 (\6\:Db \2\:SE net461 NW) g45p1svt w=(2.15e-07) l=4.5e-08 nf=1 \
        as=2.688e-14 ad=6.45e-14 ps=6.8e-07 pd=1.03e-06 nrd=1.16667 \
        nrs=1.16667 sa=5.15e-07 sb=1.02e-06 sd=160n sca=12.1244 \
        scb=0.0107968 scc=0.000332109 m=(1)
mp14 (\6\:Db SEb net453 NW) g45p1svt w=(2.15e-07) l=4.5e-08 nf=1 \
        as=3.118e-14 ad=6.45e-14 ps=7.2e-07 pd=1.03e-06 nrd=1.16667 \
        nrs=1.16667 sa=8.6e-07 sb=6.75e-07 sd=160n sca=12.7214 \
        scb=0.0110237 scc=0.000332196 m=(1)
mp13 (net453 \1\:SI \1\:VDD NW) g45p1svt w=(2.15e-07) l=4.5e-08 nf=1 \
        as=6.65e-14 ad=3.118e-14 ps=1.19e-06 pd=7.2e-07 nrd=1.16667 \
        nrs=1.16667 sa=1.05e-06 sb=4.85e-07 sd=160n sca=13.8366 \
        scb=0.012107 scc=0.000335122 m=(1)
mp10 (\6\:SEb \5\:SE \1\:VDD NW) g45p1svt w=(2.15e-07) l=4.5e-08 nf=1 \
        as=6.65e-14 ad=4.73e-14 ps=1.19e-06 pd=8.7e-07 nrd=1.16667 \
        nrs=1.16667 sa=1.315e-06 sb=2.2e-07 sd=160n sca=19.4835 \
        scb=0.0215572 scc=0.000673289 m=(1)
C1 (NW VSS) capacitor c=1.05792e-15
C2 (CKN VSS) capacitor c=5.73297e-17
C3 (QN VSS) capacitor c=2.29654e-17
C4 (SN VSS) capacitor c=2.69945e-16
C5 (SI VSS) capacitor c=7.71195e-17
C6 (VDD VSS) capacitor c=4.17903e-17
C7 (RN VSS) capacitor c=9.91187e-17
C8 (D VSS) capacitor c=6.59313e-17
C9 (Q VSS) capacitor c=2.71737e-17
C10 (qint VSS) capacitor c=2.2096e-17
C11 (qbint VSS) capacitor c=4.21215e-17
C12 (RNb VSS) capacitor c=6.34628e-17
C13 (n35 VSS) capacitor c=4.33108e-17
C14 (net498 VSS) capacitor c=7.65386e-17
C15 (net0363 VSS) capacitor c=1.09657e-16
C16 (CKNbb VSS) capacitor c=2.68744e-17
C17 (mout VSS) capacitor c=5.68864e-17
C18 (CKNb VSS) capacitor c=3.83053e-17
C19 (net521 VSS) capacitor c=7.28116e-17
C20 (n20 VSS) capacitor c=5.42891e-17
C21 (Db VSS) capacitor c=4.25194e-17
C22 (net546 VSS) capacitor c=5.39102e-18
C23 (SEb VSS) capacitor c=2.81075e-17
C24 (net566 VSS) capacitor c=1.03595e-16
C25 (net414 VSS) capacitor c=4.45039e-18
C26 (net478 VSS) capacitor c=3.50425e-18
C27 (net486 VSS) capacitor c=1.12332e-18
C28 (net453 VSS) capacitor c=4.7683e-18
C29 (\5\:SE VSS) capacitor c=5.03188e-17
C30 (\1\:SI VSS) capacitor c=4.73241e-17
C31 (\2\:SE VSS) capacitor c=5.16821e-17
C32 (\1\:D VSS) capacitor c=4.68944e-17
C33 (\1\:CKN VSS) capacitor c=5.31603e-17
C34 (\3\:CKNb VSS) capacitor c=1.72835e-17
C35 (\11\:CKNb VSS) capacitor c=3.55879e-17
C36 (\8\:CKNbb VSS) capacitor c=5.44493e-17
C37 (\5\:SN VSS) capacitor c=5.74178e-17
C38 (\4\:RNb VSS) capacitor c=5.70539e-17
C39 (\2\:CKNb VSS) capacitor c=4.61055e-17
C40 (\2\:RNb VSS) capacitor c=4.61039e-17
C41 (\8\:qbint VSS) capacitor c=6.08167e-17
C42 (\1\:SN VSS) capacitor c=3.38024e-17
C43 (\1\:RN VSS) capacitor c=3.84519e-17
C44 (\7\:qbint VSS) capacitor c=2.82168e-17
C45 (\4\:qint VSS) capacitor c=3.11966e-17
C46 (\7\:SE VSS) capacitor c=2.70425e-17
C47 (\3\:SI VSS) capacitor c=7.5854e-17
C48 (\3\:SE VSS) capacitor c=6.71769e-17
C49 (\3\:SEb VSS) capacitor c=5.34492e-17
C50 (\3\:D VSS) capacitor c=2.6998e-17
C51 (\3\:CKN VSS) capacitor c=3.18467e-17
C52 (\10\:CKNb VSS) capacitor c=2.84141e-17
C53 (\5\:CKNbb VSS) capacitor c=4.61753e-17
C54 (\6\:CKNb VSS) capacitor c=1.54765e-16
C55 (\3\:mout VSS) capacitor c=6.98781e-17
C56 (\7\:SN VSS) capacitor c=6.66809e-17
C57 (\3\:n20 VSS) capacitor c=3.76429e-17
C58 (\6\:RNb VSS) capacitor c=5.30499e-17
C59 (\8\:CKNb VSS) capacitor c=2.78959e-17
C60 (\3\:CKNbb VSS) capacitor c=5.02167e-17
C61 (\9\:qbint VSS) capacitor c=5.79521e-17
C62 (\4\:SN VSS) capacitor c=4.95274e-17
C63 (\3\:n35 VSS) capacitor c=3.62926e-17
C64 (\3\:RN VSS) capacitor c=4.28742e-17
C65 (\6\:qbint VSS) capacitor c=2.38535e-17
C66 (\4\:qbint VSS) capacitor c=2.07847e-17
C67 (\3\:qint VSS) capacitor c=2.7181e-17
C68 (\6\:SE VSS) capacitor c=4.12509e-17
C69 (\2\:SI VSS) capacitor c=4.47846e-17
C70 (\2\:SEb VSS) capacitor c=8.0347e-17
C71 (\4\:SE VSS) capacitor c=5.02239e-17
C72 (\1\:SE VSS) capacitor c=4.19967e-17
C73 (\2\:D VSS) capacitor c=3.8229e-17
C74 (\2\:CKN VSS) capacitor c=3.74895e-17
C75 (\9\:CKNb VSS) capacitor c=1.27537e-17
C76 (\7\:CKNbb VSS) capacitor c=4.37289e-17
C77 (\6\:CKNbb VSS) capacitor c=3.26084e-17
C78 (\2\:mout VSS) capacitor c=5.62742e-17
C79 (\6\:SN VSS) capacitor c=3.60551e-17
C80 (\2\:n20 VSS) capacitor c=3.54406e-17
C81 (\4\:CKNbb VSS) capacitor c=4.53886e-17
C82 (\5\:RNb VSS) capacitor c=2.83961e-17
C83 (\7\:CKNb VSS) capacitor c=7.08571e-17
C84 (\3\:RNb VSS) capacitor c=2.25936e-17
C85 (\10\:qbint VSS) capacitor c=2.86315e-17
C86 (\3\:SN VSS) capacitor c=2.68438e-17
C87 (\2\:n35 VSS) capacitor c=3.67618e-17
C88 (\2\:RN VSS) capacitor c=4.08156e-17
C89 (\5\:qbint VSS) capacitor c=1.75413e-17
C90 (\6\:SEb VSS) capacitor c=1.07342e-16
C91 (\1\:VDD VSS) capacitor c=1.25361e-16
C92 (\6\:Db VSS) capacitor c=7.05087e-17
C93 (\11\:VDD VSS) capacitor c=4.54054e-17
C94 (\14\:CKNb VSS) capacitor c=9.0372e-17
C95 (\13\:VDD VSS) capacitor c=1.0023e-17
C96 (\11\:CKNbb VSS) capacitor c=1.10114e-16
C97 (\8\:Db VSS) capacitor c=1.12843e-16
C98 (\4\:n20 VSS) capacitor c=6.4746e-17
C99 (\15\:VDD VSS) capacitor c=1.3432e-17
C100 (\10\:mout VSS) capacitor c=3.59038e-17
C101 (\17\:VDD VSS) capacitor c=2.21657e-17
C102 (\8\:mout VSS) capacitor c=6.62443e-17
C103 (\8\:n35 VSS) capacitor c=4.56562e-17
C104 (\19\:VDD VSS) capacitor c=3.25819e-17
C105 (\3\:net566 VSS) capacitor c=1.03852e-16
C106 (\21\:VDD VSS) capacitor c=2.81419e-17
C107 (\16\:qbint VSS) capacitor c=6.86266e-17
C108 (\9\:RNb VSS) capacitor c=1.50433e-16
C109 (\23\:VDD VSS) capacitor c=4.08331e-17
C110 (\5\:qint VSS) capacitor c=2.54137e-17
C111 (\25\:VDD VSS) capacitor c=4.64e-17
C112 (\1\:QN VSS) capacitor c=1.97577e-17
C113 (\4\:SEb VSS) capacitor c=7.86725e-17
C114 (\18\:CKNb VSS) capacitor c=5.02557e-17
C115 (\9\:CKNbb VSS) capacitor c=7.47055e-17
C116 (\4\:Db VSS) capacitor c=1.96888e-16
C117 (\7\:n20 VSS) capacitor c=3.4718e-17
C118 (\12\:mout VSS) capacitor c=2.82065e-17
C119 (\3\:net521 VSS) capacitor c=8.27919e-17
C120 (\14\:mout VSS) capacitor c=4.14339e-17
C121 (\4\:n35 VSS) capacitor c=9.10524e-17
C122 (\3\:net0363 VSS) capacitor c=1.15886e-16
C123 (\3\:net498 VSS) capacitor c=6.73179e-17
C124 (\14\:qbint VSS) capacitor c=4.49483e-17
C125 (\11\:RNb VSS) capacitor c=1.09604e-16
C126 (\4\:Q VSS) capacitor c=8.29098e-17
C127 (\9\:qint VSS) capacitor c=2.9431e-17
C128 (\3\:QN VSS) capacitor c=4.27257e-17
C129 (\2\:qint VSS) capacitor c=1.33267e-17
C130 (\2\:qbint VSS) capacitor c=3.55733e-17
C131 (\3\:qbint VSS) capacitor c=4.52122e-17
C132 (\2\:SN VSS) capacitor c=2.43536e-17
C133 (\2\:CKNbb VSS) capacitor c=4.40465e-17
C134 (\7\:qint VSS) capacitor c=2.25757e-17
C135 (\8\:qint VSS) capacitor c=3.57583e-17
C136 (\3\:Q VSS) capacitor c=6.39461e-17
C137 (\4\:CKNb VSS) capacitor c=1.93208e-17
C138 (\5\:CKNb VSS) capacitor c=6.92097e-17
C139 (\11\:qbint VSS) capacitor c=5.09211e-17
C140 (\12\:qbint VSS) capacitor c=1.19332e-16
C141 (\13\:qbint VSS) capacitor c=1.17733e-16
C142 (\6\:n35 VSS) capacitor c=1.93698e-16
C143 (\7\:n35 VSS) capacitor c=1.30154e-16
C144 (\12\:CKNb VSS) capacitor c=9.64988e-17
C145 (\13\:CKNb VSS) capacitor c=1.13116e-16
C146 (\7\:RNb VSS) capacitor c=1.55429e-16
C147 (\8\:RNb VSS) capacitor c=2.33021e-16
C148 (\8\:SN VSS) capacitor c=2.68185e-16
C149 (\9\:SN VSS) capacitor c=3.13286e-17
C150 (\4\:mout VSS) capacitor c=5.1091e-17
C151 (\5\:mout VSS) capacitor c=5.49996e-17
C152 (\6\:mout VSS) capacitor c=6.01698e-17
C153 (\7\:mout VSS) capacitor c=6.83169e-17
C154 (\6\:n20 VSS) capacitor c=8.83829e-17
C155 (\9\:n20 VSS) capacitor c=8.01586e-17
C156 (\13\:CKNbb VSS) capacitor c=1.4867e-16
C157 (\14\:CKNbb VSS) capacitor c=6.32091e-17
C158 (\15\:CKNbb VSS) capacitor c=5.45105e-17
C159 (\16\:CKNbb VSS) capacitor c=1.69515e-16
C160 (\4\:CKN VSS) capacitor c=4.17202e-17
C161 (\16\:CKNb VSS) capacitor c=9.72188e-17
C162 (\17\:CKNb VSS) capacitor c=2.45643e-17
C163 (\4\:D VSS) capacitor c=3.81649e-17
C164 (\3\:Db VSS) capacitor c=2.19111e-16
C165 (\8\:SE VSS) capacitor c=5.58007e-17
C166 (\9\:SE VSS) capacitor c=7.76789e-17
C167 (\10\:SE VSS) capacitor c=7.84055e-17
C168 (\4\:SI VSS) capacitor c=4.33155e-17
C169 (\8\:SEb VSS) capacitor c=7.6843e-17
C170 (\3\:VDD VSS) capacitor c=8.96625e-17
C171 (\4\:VDD VSS) capacitor c=8.15893e-17
C172 (\5\:VDD VSS) capacitor c=1.03172e-16
C173 (\6\:VDD VSS) capacitor c=9.95219e-17
C174 (\7\:VDD VSS) capacitor c=9.84402e-17
C175 (\8\:VDD VSS) capacitor c=8.95005e-17
C176 (\9\:VDD VSS) capacitor c=9.61091e-17
C177 (\10\:VDD VSS) capacitor c=6.48754e-17
Rk42 (\4\:CKN CKN) resistor r=0.1665 c=0
Rk2 (\4\:QN QN) resistor r=0.09288 c=0
Rk1 (\2\:QN \4\:QN) resistor r=0.2248 c=0
Rk51 (\8\:SE \9\:SE) resistor r=0.2657 c=0
Rk53 (\10\:SE SE) resistor r=0.01279 c=0
Rk52 (\9\:SE \10\:SE) resistor r=0.2765 c=0
Rk25 (\8\:SN SN) resistor r=2.0735 c=0
Rk26 (SN \9\:SN) resistor r=0.1035 c=0
Rk54 (SI \4\:SI) resistor r=0.1871 c=0
Rk57 (\2\:VDD \3\:VDD) resistor r=0.6564 c=0
Rk58 (\3\:VDD \4\:VDD) resistor r=0.283 c=0
Rk59 (\4\:VDD \5\:VDD) resistor r=0.5855 c=0
Rk60 (\5\:VDD \6\:VDD) resistor r=0.4416 c=0
Rk61 (\6\:VDD \7\:VDD) resistor r=0.5093 c=0
Rk62 (\7\:VDD \8\:VDD) resistor r=0.3588 c=0
Rk63 (\8\:VDD \9\:VDD) resistor r=0.4651 c=0
Rk65 (\10\:VDD VDD) resistor r=0.2127 c=0
Rk64 (\9\:VDD \10\:VDD) resistor r=0.4134 c=0
Rk66 (\3\:VDD \12\:VDD) resistor r=0.2911 c=0
Rk67 (\4\:VDD \14\:VDD) resistor r=0.07393 c=0
Rk68 (\5\:VDD \16\:VDD) resistor r=0.04331 c=0
Rk69 (\6\:VDD \18\:VDD) resistor r=0.04331 c=0
Rk70 (\7\:VDD \20\:VDD) resistor r=0.04331 c=0
Rk71 (\8\:VDD \22\:VDD) resistor r=0.04331 c=0
Rk72 (\9\:VDD \24\:VDD) resistor r=0.2815 c=0
Rk73 (\10\:VDD \26\:VDD) resistor r=0.4181 c=0
Rk9 (\4\:RN RN) resistor r=0.004839 c=0
Rk46 (\4\:D D) resistor r=0.08852 c=0
Rk7 (\3\:Q Q) resistor r=0.07888 c=0
Rk6 (\2\:Q \3\:Q) resistor r=0.03859 c=0
Rk8 (\3\:Q \5\:Q) resistor r=0.502 c=0
Rk74 (\2\:VSS \3\:VSS) resistor r=0.03742 c=0
Rk75 (\3\:VSS \4\:VSS) resistor r=0.4435 c=0
Rk76 (\4\:VSS \5\:VSS) resistor r=0.2745 c=0
Rk77 (\5\:VSS \6\:VSS) resistor r=0.044 c=0
Rk78 (\6\:VSS \7\:VSS) resistor r=0.534 c=0
Rk79 (\7\:VSS \8\:VSS) resistor r=0.6694 c=0
Rk80 (\8\:VSS \9\:VSS) resistor r=0.691 c=0
Rk81 (\9\:VSS \10\:VSS) resistor r=0.435 c=0
Rk82 (\10\:VSS \11\:VSS) resistor r=0.07504 c=0
Rk84 (\12\:VSS VSS) resistor r=0.2127 c=0
Rk83 (\11\:VSS \12\:VSS) resistor r=0.3384 c=0
Rk85 (\3\:VSS \14\:VSS) resistor r=0.3134 c=0
Rk86 (\4\:VSS \16\:VSS) resistor r=0.3234 c=0
Rk87 (\5\:VSS \18\:VSS) resistor r=0.04331 c=0
Rk88 (\7\:VSS \20\:VSS) resistor r=0.3223 c=0
Rk89 (\9\:VSS \22\:VSS) resistor r=0.04331 c=0
Rk90 (\10\:VSS \24\:VSS) resistor r=0.2878 c=0
Rk91 (\12\:VSS \26\:VSS) resistor r=0.3692 c=0
Rk3 (\6\:qint \7\:qint) resistor r=0.1148 c=0
Rk4 (\7\:qint \8\:qint) resistor r=0.1194 c=0
Rk5 (\7\:qint \10\:qint) resistor r=0.1088 c=0
Rk10 (\11\:qbint \12\:qbint) resistor r=0.3772 c=0
Rk11 (\12\:qbint \13\:qbint) resistor r=0.8163 c=0
Rk12 (\12\:qbint \15\:qbint) resistor r=0.1081 c=0
Rk13 (\15\:qbint \17\:qbint) resistor r=0.4093 c=0
Rk21 (\7\:RNb \8\:RNb) resistor r=1.0765 c=0
Rk22 (\8\:RNb \10\:RNb) resistor r=0.9729 c=0
Rk23 (\10\:RNb \12\:RNb) resistor r=0.6681 c=0
Rk17 (\5\:n35 \6\:n35) resistor r=0.4954 c=0
Rk18 (\6\:n35 \7\:n35) resistor r=1.0387 c=0
Rk19 (\6\:n35 \9\:n35) resistor r=0.1739 c=0
Rk14 (\2\:net498 \4\:net498) resistor r=0.4348 c=0
Rk16 (\2\:net0363 \4\:net0363) resistor r=0.7318 c=0
Rk37 (\10\:CKNbb \12\:CKNbb) resistor r=0.3745 c=0
Rk38 (\12\:CKNbb \13\:CKNbb) resistor r=0.531 c=0
Rk39 (\13\:CKNbb \14\:CKNbb) resistor r=0.2842 c=0
Rk40 (\14\:CKNbb \15\:CKNbb) resistor r=0.1332 c=0
Rk41 (\13\:CKNbb \16\:CKNbb) resistor r=1.1535 c=0
Rk27 (\4\:mout \5\:mout) resistor r=0.2406 c=0
Rk28 (\5\:mout \6\:mout) resistor r=0.3342 c=0
Rk29 (\6\:mout \7\:mout) resistor r=0.2689 c=0
Rk30 (\7\:mout \9\:mout) resistor r=0.395 c=0
Rk31 (\5\:mout \11\:mout) resistor r=0.09337 c=0
Rk32 (\6\:mout \13\:mout) resistor r=0.1022 c=0
Rk33 (\7\:mout \15\:mout) resistor r=0.1469 c=0
Rk20 (\12\:CKNb \13\:CKNb) resistor r=0.5141 c=0
Rk43 (\15\:CKNb \16\:CKNb) resistor r=0.6458 c=0
Rk44 (\16\:CKNb \17\:CKNb) resistor r=0.04241 c=0
Rk45 (\16\:CKNb \19\:CKNb) resistor r=0.288 c=0
Rk24 (\2\:net521 \4\:net521) resistor r=0.5131 c=0
Rk34 (\5\:n20 \6\:n20) resistor r=0.3746 c=0
Rk35 (\6\:n20 \8\:n20) resistor r=0.1396 c=0
Rk36 (\6\:n20 \9\:n20) resistor r=0.398 c=0
Rk47 (\2\:Db \3\:Db) resistor r=0.3037 c=0
Rk48 (\3\:Db \5\:Db) resistor r=1.3668 c=0
Rk49 (\3\:Db \7\:Db) resistor r=0.4492 c=0
Rk50 (\5\:Db \9\:Db) resistor r=0.5648 c=0
Rk55 (\5\:SEb \7\:SEb) resistor r=0.633 c=0
Rk56 (\7\:SEb \8\:SEb) resistor r=0.5733 c=0
Rk15 (\2\:net566 \4\:net566) resistor r=0.3873 c=0
Rl43 (\1\:CKN \2\:CKN) resistor r=114.183 c=0
Rl44 (\2\:CKN \3\:CKN) resistor r=91.5405 c=0
Rl53 (\5\:SE \6\:SE) resistor r=144.231 c=0
Rl54 (\6\:SE \7\:SE) resistor r=28.2967 c=0
Rl50 (\3\:SE \4\:SE) resistor r=41.5405 c=0
Rl47 (\1\:SE \2\:SE) resistor r=63.2246 c=0
Rl30 (\5\:SN \7\:SN) resistor r=146.154 c=0
Rl29 (\5\:SN \6\:SN) resistor r=59.5926 c=0
Rl14 (\1\:SN \2\:SN) resistor r=36.5533 c=0
Rl16 (\2\:SN \4\:SN) resistor r=89.5925 c=0
Rl15 (\2\:SN \3\:SN) resistor r=5.4946 c=0
Rl51 (\1\:SI \2\:SI) resistor r=66.0764 c=0
Rl52 (\2\:SI \3\:SI) resistor r=109.94 c=0
Rl10 (\1\:RN \2\:RN) resistor r=119.922 c=0
Rl11 (\2\:RN \3\:RN) resistor r=89.1533 c=0
Rl45 (\1\:D \2\:D) resistor r=80.0021 c=0
Rl46 (\2\:D \3\:D) resistor r=87.6944 c=0
Rl3 (\2\:qint \4\:qint) resistor r=47.791 c=0
Rl2 (\2\:qint \3\:qint) resistor r=36.2526 c=0
Rl1 (qint \2\:qint) resistor r=2.0213 c=0
Rl17 (\8\:qbint \9\:qbint) resistor r=153.412 c=0
Rl18 (\9\:qbint \10\:qbint) resistor r=111.052 c=0
Rl8 (\5\:qbint \6\:qbint) resistor r=29.5379 c=0
Rl4 (qbint \2\:qbint) resistor r=147.31 c=0
Rl7 (\2\:qbint \5\:qbint) resistor r=28.7715 c=0
Rl9 (\3\:qbint \7\:qbint) resistor r=60.772 c=0
Rl6 (\3\:qbint \4\:qbint) resistor r=28.0797 c=0
Rl5 (\2\:qbint \3\:qbint) resistor r=224.363 c=0
Rl26 (\4\:RNb \6\:RNb) resistor r=146.154 c=0
Rl19 (RNb \2\:RNb) resistor r=163.027 c=0
Rl25 (\4\:RNb \5\:RNb) resistor r=109.128 c=0
Rl20 (\2\:RNb \3\:RNb) resistor r=78.079 c=0
Rl12 (n35 \2\:n35) resistor r=88.4615 c=0
Rl13 (\2\:n35 \3\:n35) resistor r=29.9451 c=0
Rl34 (\7\:CKNbb \8\:CKNbb) resistor r=63.2246 c=0
Rl33 (\5\:CKNbb \6\:CKNbb) resistor r=26.1559 c=0
Rl22 (CKNbb \2\:CKNbb) resistor r=28.0797 c=0
Rl23 (\2\:CKNbb \3\:CKNbb) resistor r=137.261 c=0
Rl24 (\2\:CKNbb \4\:CKNbb) resistor r=179.219 c=0
Rl31 (mout \2\:mout) resistor r=60.7134 c=0
Rl32 (\2\:mout \3\:mout) resistor r=87.6365 c=0
Rl41 (\9\:CKNb \10\:CKNb) resistor r=39.1533 c=0
Rl38 (\6\:CKNb \7\:CKNb) resistor r=505.975 c=0
Rl39 (\7\:CKNb \8\:CKNb) resistor r=32.0175 c=0
Rl21 (CKNb \2\:CKNb) resistor r=55.1375 c=0
Rl35 (\3\:CKNb \4\:CKNb) resistor r=38.0255 c=0
Rl40 (\4\:CKNb \9\:CKNb) resistor r=11.3405 c=0
Rl42 (\5\:CKNb \11\:CKNb) resistor r=82.3738 c=0
Rl37 (\5\:CKNb \6\:CKNb) resistor r=228.824 c=0
Rl36 (\4\:CKNb \5\:CKNb) resistor r=159.512 c=0
Rl27 (n20 \2\:n20) resistor r=91.0764 c=0
Rl28 (\2\:n20 \3\:n20) resistor r=29.5379 c=0
Rl48 (SEb \2\:SEb) resistor r=29.5379 c=0
Rl49 (\2\:SEb \3\:SEb) resistor r=179.104 c=0
Rz1 (\3\:QN \4\:QN) resistor r=75 c=0
Rz3 (\4\:Q \5\:Q) resistor r=75 c=0
Rz21 (\13\:VSS \14\:VSS) resistor r=75 c=0
Rz22 (\15\:VSS \16\:VSS) resistor r=75 c=0
Rz23 (\17\:VSS \18\:VSS) resistor r=75 c=0
Rz24 (\19\:VSS \20\:VSS) resistor r=75 c=0
Rz25 (\21\:VSS \22\:VSS) resistor r=75 c=0
Rz26 (\23\:VSS \24\:VSS) resistor r=75 c=0
Rz27 (\25\:VSS \26\:VSS) resistor r=75 c=0
Rz2 (\9\:qint \10\:qint) resistor r=75 c=0
Rz4 (\14\:qbint \15\:qbint) resistor r=75 c=0
Rz10 (\11\:RNb \12\:RNb) resistor r=75 c=0
Rz9 (\4\:n35 \5\:n35) resistor r=75 c=0
Rz5 (net498 \2\:net498) resistor r=75 c=0
Rz6 (\3\:net498 \4\:net498) resistor r=75 c=0
Rz7 (net0363 \2\:net0363) resistor r=75 c=0
Rz8 (\3\:net0363 \4\:net0363) resistor r=75 c=0
Rz16 (\9\:CKNbb \10\:CKNbb) resistor r=75 c=0
Rz13 (\12\:mout \13\:mout) resistor r=75 c=0
Rz14 (\14\:mout \15\:mout) resistor r=75 c=0
Rz17 (\18\:CKNb \19\:CKNb) resistor r=75 c=0
Rz11 (net521 \2\:net521) resistor r=75 c=0
Rz12 (\3\:net521 \4\:net521) resistor r=75 c=0
Rz15 (\7\:n20 \8\:n20) resistor r=75 c=0
Rz18 (Db \2\:Db) resistor r=75 c=0
Rz19 (\4\:Db \5\:Db) resistor r=75 c=0
Rz20 (\4\:SEb \5\:SEb) resistor r=75 c=0
Ry1 (\1\:QN \2\:QN) resistor r=62 c=0
Ry17 (\1\:VDD \2\:VDD) resistor r=62 c=0
Ry18 (\11\:VDD \12\:VDD) resistor r=62 c=0
Ry19 (\13\:VDD \14\:VDD) resistor r=62 c=0
Ry20 (\15\:VDD \16\:VDD) resistor r=62 c=0
Ry21 (\17\:VDD \18\:VDD) resistor r=62 c=0
Ry22 (\19\:VDD \20\:VDD) resistor r=62 c=0
Ry23 (\21\:VDD \22\:VDD) resistor r=62 c=0
Ry24 (\23\:VDD \24\:VDD) resistor r=62 c=0
Ry25 (\25\:VDD \26\:VDD) resistor r=62 c=0
Ry3 (\1\:Q \2\:Q) resistor r=62 c=0
Ry26 (\1\:VSS \2\:VSS) resistor r=15.5 c=0
Ry27 (\1\:VSS \6\:VSS) resistor r=5.1667 c=0
Ry28 (\1\:VSS \8\:VSS) resistor r=5.1667 c=0
Ry29 (\1\:VSS \11\:VSS) resistor r=5.1667 c=0
Ry2 (\5\:qint \6\:qint) resistor r=62 c=0
Ry4 (\16\:qbint \17\:qbint) resistor r=62 c=0
Ry8 (\9\:RNb \10\:RNb) resistor r=62 c=0
Ry7 (\8\:n35 \9\:n35) resistor r=62 c=0
Ry12 (\11\:CKNbb \12\:CKNbb) resistor r=62 c=0
Ry9 (\8\:mout \9\:mout) resistor r=62 c=0
Ry10 (\10\:mout \11\:mout) resistor r=62 c=0
Ry13 (\14\:CKNb \15\:CKNb) resistor r=62 c=0
Ry11 (\4\:n20 \5\:n20) resistor r=62 c=0
Ry14 (\6\:Db \7\:Db) resistor r=62 c=0
Ry15 (\8\:Db \9\:Db) resistor r=62 c=0
Ry16 (\6\:SEb \7\:SEb) resistor r=62 c=0
Ry5 (net566 \2\:net566) resistor r=62 c=0
Ry6 (\3\:net566 \4\:net566) resistor r=62 c=0
Rx17 (\2\:CKN \4\:CKN) resistor r=45 c=0
Rx20 (\1\:SE \8\:SE) resistor r=45 c=0
Rx21 (\4\:SE \9\:SE) resistor r=45 c=0
Rx22 (\6\:SE \10\:SE) resistor r=45 c=0
Rx10 (\6\:SN \8\:SN) resistor r=45 c=0
Rx11 (\3\:SN \9\:SN) resistor r=45 c=0
Rx23 (\2\:SI \4\:SI) resistor r=45 c=0
Rx2 (\2\:RN \4\:RN) resistor r=45 c=0
Rx19 (\2\:D \4\:D) resistor r=45 c=0
Rx1 (qint \8\:qint) resistor r=45 c=0
Rx3 (\10\:qbint \11\:qbint) resistor r=45 c=0
Rx4 (\5\:qbint \13\:qbint) resistor r=45 c=0
Rx8 (\5\:RNb \7\:RNb) resistor r=45 c=0
Rx9 (\3\:RNb \8\:RNb) resistor r=45 c=0
Rx5 (\2\:n35 \7\:n35) resistor r=45 c=0
Rx14 (\7\:CKNbb \14\:CKNbb) resistor r=45 c=0
Rx15 (\6\:CKNbb \15\:CKNbb) resistor r=45 c=0
Rx16 (\4\:CKNbb \16\:CKNbb) resistor r=45 c=0
Rx12 (\2\:mout \4\:mout) resistor r=45 c=0
Rx6 (\7\:CKNb \12\:CKNb) resistor r=45 c=0
Rx7 (CKNb \13\:CKNb) resistor r=45 c=0
Rx18 (\9\:CKNb \17\:CKNb) resistor r=45 c=0
Rx13 (\2\:n20 \9\:n20) resistor r=45 c=0
Rx24 (\2\:SEb \8\:SEb) resistor r=45 c=0
mn57 (\3\:QN \3\:qint \25\:VSS VSS) g45n1svt w=(1.45e-07) l=4.5e-08 nf=1 \
        as=2.32e-14 ad=2.392e-14 ps=6.1e-07 pd=6.2e-07 nrd=1.16667 \
        nrs=1.16667 sa=1.65e-07 sb=3.45e-07 sd=160n sca=23.279 \
        scb=0.0230742 scc=0.00267719 m=(1)
mn56 (\9\:qint \4\:qbint \25\:VSS VSS) g45n1svt w=(1.45e-07) l=4.5e-08 \
        nf=1 as=2.32e-14 ad=2.03e-14 ps=6.1e-07 pd=5.7e-07 nrd=1.16667 \
        nrs=1.16667 sa=3.7e-07 sb=1.4e-07 sd=160n sca=23.279 scb=0.0230742 \
        scc=0.00267719 m=(1)
mn55 (\4\:Q \6\:qbint \23\:VSS VSS) g45n1svt w=(1.45e-07) l=4.5e-08 nf=1 \
        as=2.537e-14 ad=2.03e-14 ps=6.4e-07 pd=5.7e-07 nrd=1.16667 \
        nrs=1.16667 sa=1.4e-07 sb=4.6e-07 sd=160n sca=10.0732 \
        scb=0.00911402 scc=0.000253284 m=(1)
mn22 (\11\:RNb \3\:RN \23\:VSS VSS) g45n1svt w=(1.45e-07) l=4.5e-08 nf=1 \
        as=2.538e-14 ad=3.48e-14 ps=6.4e-07 pd=7.7e-07 nrd=1.16667 \
        nrs=1.16667 sa=3.6e-07 sb=2.4e-07 sd=160n sca=10.0732 \
        scb=0.00911402 scc=0.000253284 m=(1)
mn45 (\14\:qbint \3\:n35 \21\:VSS VSS) g45n1svt w=(1.45e-07) l=4.5e-08 \
        nf=1 as=7.87e-14 ad=2.392e-14 ps=1.51e-06 pd=6.2e-07 nrd=1.16667 \
        nrs=1.16667 sa=1.65e-07 sb=1e-06 sd=160n sca=16.7245 scb=0.0178071 \
        scc=0.00133148 m=(1)
mn50 (\3\:net498 \4\:SN \21\:VSS VSS) g45n1svt w=(1.45e-07) l=4.5e-08 \
        nf=1 as=7.87e-14 ad=5.002e-14 ps=1.51e-06 pd=9.8e-07 nrd=1.16667 \
        nrs=1.16667 sa=4.3e-07 sb=7.35e-07 sd=160n sca=16.7245 \
        scb=0.0178071 scc=0.00133148 m=(1)
mn52 (\3\:net0363 \9\:qbint \3\:net498 VSS) g45n1svt w=(1.45e-07) \
        l=4.5e-08 nf=1 as=5.002e-14 ad=2.32e-14 ps=9.8e-07 pd=6.1e-07 \
        nrd=1.16667 nrs=1.16667 sa=8.2e-07 sb=3.45e-07 sd=160n sca=16.7245 \
        scb=0.0178071 scc=0.00133148 m=(1)
mn51 (\3\:net0363 RNb net498 VSS) g45n1svt w=(1.45e-07) l=4.5e-08 nf=1 \
        as=2.03e-14 ad=2.32e-14 ps=5.7e-07 pd=6.1e-07 nrd=1.16667 \
        nrs=1.16667 sa=1.025e-06 sb=1.4e-07 sd=160n sca=16.7245 \
        scb=0.0178071 scc=0.00133148 m=(1)
mn53 (\4\:n35 \3\:CKNbb net0363 VSS) g45n1svt w=(1.45e-07) l=4.5e-08 nf=1 \
        as=2.03e-14 ad=4.277e-14 ps=5.7e-07 pd=8.8e-07 nrd=1.16667 \
        nrs=1.16667 sa=1.4e-07 sb=4.8e-07 sd=160n sca=10.7143 \
        scb=0.0101371 scc=0.000327098 m=(1)
mn40 (\14\:mout \8\:CKNb \4\:n35 VSS) g45n1svt w=(1.45e-07) l=4.5e-08 \
        nf=1 as=4.277e-14 ad=2.03e-14 ps=8.8e-07 pd=5.7e-07 nrd=1.16667 \
        nrs=1.16667 sa=4.8e-07 sb=1.4e-07 sd=160n sca=10.7143 \
        scb=0.0101371 scc=0.000327098 m=(1)
mn31 (\12\:mout \6\:RNb \3\:net521 VSS) g45n1svt w=(1.45e-07) l=4.5e-08 \
        nf=1 as=2.03e-14 ad=2.972e-14 ps=5.7e-07 pd=7e-07 nrd=1.16667 \
        nrs=1.16667 sa=1.4e-07 sb=1.125e-06 sd=160n sca=13.253 \
        scb=0.0137915 scc=0.000695334 m=(1)
mn32 (\12\:mout \3\:n20 net521 VSS) g45n1svt w=(1.45e-07) l=4.5e-08 nf=1 \
        as=2.537e-14 ad=2.972e-14 ps=6.4e-07 pd=7e-07 nrd=1.16667 \
        nrs=1.16667 sa=3.9e-07 sb=8.75e-07 sd=160n sca=13.253 \
        scb=0.0137915 scc=0.000695334 m=(1)
mn30 (net521 \7\:SN \19\:VSS VSS) g45n1svt w=(1.45e-07) l=4.5e-08 nf=1 \
        as=2.32e-14 ad=2.537e-14 ps=6.1e-07 pd=6.4e-07 nrd=1.16667 \
        nrs=1.16667 sa=6.1e-07 sb=6.55e-07 sd=160n sca=13.253 \
        scb=0.0137915 scc=0.000695334 m=(1)
mn35 (net582 \3\:mout \19\:VSS VSS) g45n1svt w=(1.45e-07) l=4.5e-08 nf=1 \
        as=2.32e-14 ad=8.7e-15 ps=6.1e-07 pd=4.1e-07 nrd=1.16667 \
        nrs=1.16667 sa=8.15e-07 sb=4.5e-07 sd=160n sca=13.253 \
        scb=0.0137915 scc=0.000695334 m=(1)
mn36 (\7\:n20 \6\:CKNb net582 VSS) g45n1svt w=(1.45e-07) l=4.5e-08 nf=1 \
        as=8.7e-15 ad=2.32e-14 ps=4.1e-07 pd=6.1e-07 nrd=1.16667 \
        nrs=1.16667 sa=9.2e-07 sb=3.45e-07 sd=160n sca=13.253 \
        scb=0.0137915 scc=0.000695334 m=(1)
mn25 (\4\:Db \5\:CKNbb \7\:n20 VSS) g45n1svt w=(1.45e-07) l=4.5e-08 nf=1 \
        as=2.32e-14 ad=2.03e-14 ps=6.1e-07 pd=5.7e-07 nrd=1.16667 \
        nrs=1.16667 sa=1.125e-06 sb=1.4e-07 sd=160n sca=13.253 \
        scb=0.0137915 scc=0.000695334 m=(1)
mn21 (\9\:CKNbb \10\:CKNb \17\:VSS VSS) g45n1svt w=(1.45e-07) l=4.5e-08 \
        nf=1 as=6.725e-14 ad=3.335e-14 ps=1.34e-06 pd=7.5e-07 nrd=1.16667 \
        nrs=1.16667 sa=2.3e-07 sb=1.7e-07 sd=160n sca=13.6097 scb=0.014254 \
        scc=0.000755054 m=(1)
mn20 (\18\:CKNb \3\:CKN \15\:VSS VSS) g45n1svt w=(1.45e-07) l=4.5e-08 \
        nf=1 as=4.422e-14 ad=2.03e-14 ps=9e-07 pd=5.7e-07 nrd=1.16667 \
        nrs=1.16667 sa=1.4e-07 sb=1.385e-06 sd=160n sca=13.6097 \
        scb=0.014254 scc=0.000755054 m=(1)
mn11 (net546 \3\:D \15\:VSS VSS) g45n1svt w=(1.45e-07) l=4.5e-08 nf=1 \
        as=4.422e-14 ad=4.713e-14 ps=9e-07 pd=9.4e-07 nrd=1.16667 \
        nrs=1.16667 sa=4.9e-07 sb=1.035e-06 sd=160n sca=13.6097 \
        scb=0.014254 scc=0.000755054 m=(1)
mn12 (Db \3\:SEb net546 VSS) g45n1svt w=(1.45e-07) l=4.5e-08 nf=1 \
        as=4.713e-14 ad=2.32e-14 ps=9.4e-07 pd=6.1e-07 nrd=1.16667 \
        nrs=1.16667 sa=8.6e-07 sb=6.65e-07 sd=160n sca=13.6097 \
        scb=0.014254 scc=0.000755054 m=(1)
mn14 (Db \3\:SE net538 VSS) g45n1svt w=(1.45e-07) l=4.5e-08 nf=1 \
        as=8.7e-15 ad=2.32e-14 ps=4.1e-07 pd=6.1e-07 nrd=1.16667 \
        nrs=1.16667 sa=1.065e-06 sb=4.6e-07 sd=160n sca=13.6097 \
        scb=0.014254 scc=0.000755054 m=(1)
mn13 (net538 \3\:SI \13\:VSS VSS) g45n1svt w=(1.45e-07) l=4.5e-08 nf=1 \
        as=2.465e-14 ad=8.7e-15 ps=6.3e-07 pd=4.1e-07 nrd=1.16667 \
        nrs=1.16667 sa=1.17e-06 sb=3.55e-07 sd=160n sca=13.6097 \
        scb=0.014254 scc=0.000755054 m=(1)
mn10 (\4\:SEb \7\:SE \13\:VSS VSS) g45n1svt w=(1.45e-07) l=4.5e-08 nf=1 \
        as=2.465e-14 ad=2.03e-14 ps=6.3e-07 pd=5.7e-07 nrd=1.16667 \
        nrs=1.16667 sa=1.385e-06 sb=1.4e-07 sd=160n sca=13.6097 \
        scb=0.014254 scc=0.000755054 m=(1)
ends SDFFNSRXL
// End of subcircuit definition.
