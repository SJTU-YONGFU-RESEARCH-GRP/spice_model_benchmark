// Generated for: spectre (May  1 11:28:27 2013 )
// Library name: gsclib045_backbias
// Cell name: CLKMX2X12
// View name: extracted

simulator lang=spectre

subckt CLKMX2X12 A B NW S0 VDD VSS Y
mp0 (\9\:S0b \1\:S0 \19\:VDD NW) g45p1svt w=(3.9e-07) l=4.5e-08 nf=1 \
        as=5.76e-14 ad=5.46e-14 ps=1.1e-06 pd=1.06e-06 nrd=1.16667 \
        nrs=1.16667 sa=1.4e-07 sb=1.61026e-06 sd=160n sca=16.3241 \
        scb=0.0161972 scc=0.000342398 m=(1)
C1 (S0 VSS) capacitor c=6.40684e-17
C2 (Y VSS) capacitor c=9.54744e-16
C3 (VDD VSS) capacitor c=4.77512e-17
C4 (NW VSS) capacitor c=4.84289e-16
C5 (B VSS) capacitor c=3.89468e-17
C6 (S0b VSS) capacitor c=5.08717e-17
C7 (n0 VSS) capacitor c=5.93648e-16
C8 (net140 VSS) capacitor c=8.56299e-18
C9 (net123 VSS) capacitor c=3.58658e-18
C10 (net115 VSS) capacitor c=4.99478e-18
C11 (\1\:B VSS) capacitor c=3.81655e-17
C12 (\3\:S0b VSS) capacitor c=3.53797e-17
C13 (\6\:S0 VSS) capacitor c=4.38578e-17
C14 (\1\:A VSS) capacitor c=7.04353e-17
C15 (\1\:S0 VSS) capacitor c=4.91618e-17
C16 (\3\:B VSS) capacitor c=5.56467e-17
C17 (\4\:S0 VSS) capacitor c=6.24672e-17
C18 (\2\:S0b VSS) capacitor c=6.76963e-17
C19 (\3\:A VSS) capacitor c=9.47721e-17
C20 (\3\:S0 VSS) capacitor c=5.62627e-17
C21 (\2\:B VSS) capacitor c=4.04353e-17
C22 (\4\:S0b VSS) capacitor c=3.52485e-17
C23 (\5\:S0 VSS) capacitor c=7.37821e-17
C24 (\2\:A VSS) capacitor c=5.48734e-17
C25 (\2\:S0 VSS) capacitor c=4.3818e-17
C26 (\1\:VDD VSS) capacitor c=7.40285e-16
C27 (\44\:n0 VSS) capacitor c=9.86617e-17
C28 (\19\:VDD VSS) capacitor c=3.89014e-17
C29 (\9\:S0b VSS) capacitor c=9.79343e-17
C30 (\42\:n0 VSS) capacitor c=5.73585e-17
C31 (\7\:S0b VSS) capacitor c=8.8816e-17
C32 (\4\:A VSS) capacitor c=4.18614e-17
C33 (\5\:A VSS) capacitor c=5.20564e-17
C34 (\7\:S0 VSS) capacitor c=3.3773e-17
C35 (\8\:S0 VSS) capacitor c=8.38783e-17
C36 (\5\:S0b VSS) capacitor c=7.96225e-17
C37 (\6\:S0b VSS) capacitor c=9.02231e-17
C38 (\4\:B VSS) capacitor c=6.11711e-17
C39 (\40\:n0 VSS) capacitor c=5.63637e-17
C40 (\41\:n0 VSS) capacitor c=1.17885e-16
C41 (\8\:VDD VSS) capacitor c=7.52845e-17
Rk4 (S0 \7\:S0) resistor r=0.03903 c=0
Rk5 (S0 \8\:S0) resistor r=0.4084 c=0
Rk1 (A \4\:A) resistor r=0.002332 c=0
Rk3 (\4\:A \5\:A) resistor r=0.03791 c=0
Rk2 (\5\:A \6\:A) resistor r=0.002413 c=0
Rk49 (\1\:VSS \9\:VSS) resistor r=0.06501 c=0
Rk51 (\10\:VSS VSS) resistor r=0.1776 c=0
Rk50 (\9\:VSS \10\:VSS) resistor r=0.3735 c=0
Rk57 (\10\:VSS \22\:VSS) resistor r=0.2209 c=0
Rk37 (\8\:VDD VDD) resistor r=0.1776 c=0
Rk36 (\1\:VDD \8\:VDD) resistor r=0.5037 c=0
Rk43 (\8\:VDD \20\:VDD) resistor r=0.1786 c=0
Rk9 (\4\:B B) resistor r=0.01175 c=0
Rk6 (\5\:S0b \6\:S0b) resistor r=0.4236 c=0
Rk7 (\6\:S0b \8\:S0b) resistor r=0.3474 c=0
Rk8 (\8\:S0b \10\:S0b) resistor r=0.735 c=0
Rk10 (\40\:n0 \41\:n0) resistor r=0.3134 c=0
Rk11 (\41\:n0 \43\:n0) resistor r=0.4108 c=0
Rk12 (\41\:n0 \45\:n0) resistor r=0.5789 c=0
Rl7 (\5\:S0 \6\:S0) resistor r=28.2967 c=0
Rl6 (\4\:S0 \5\:S0) resistor r=218.796 c=0
Rl1 (\1\:S0 \2\:S0) resistor r=26.098 c=0
Rl2 (\2\:S0 \3\:S0) resistor r=145.329 c=0
Rl3 (\1\:A \2\:A) resistor r=81.461 c=0
Rl4 (\2\:A \3\:A) resistor r=148.769 c=0
Rl9 (\1\:B \2\:B) resistor r=33.3841 c=0
Rl10 (\2\:B \3\:B) resistor r=196.846 c=0
Rl8 (\3\:S0b \4\:S0b) resistor r=30.0021 c=0
Rl5 (S0b \2\:S0b) resistor r=42.6366 c=0
Rz14 (\22\:VSS \21\:VSS) resistor r=75 c=0
Rz1 (\7\:S0b \8\:S0b) resistor r=75 c=0
Rz2 (\43\:n0 \42\:n0) resistor r=75 c=0
Ry15 (\1\:VSS \3\:VSS) resistor r=8.8571 c=0
Ry16 (\9\:VSS \3\:VSS) resistor r=5.1667 c=0
Ry14 (\20\:VDD \19\:VDD) resistor r=62 c=0
Ry1 (\9\:S0b \10\:S0b) resistor r=62 c=0
Ry2 (\45\:n0 \44\:n0) resistor r=62 c=0
Rx2 (\2\:S0 \7\:S0) resistor r=45 c=0
Rx3 (\5\:S0 \8\:S0) resistor r=45 c=0
Rx1 (\2\:A \6\:A) resistor r=45 c=0
Rx6 (\2\:B \4\:B) resistor r=45 c=0
Rx4 (\4\:S0b \5\:S0b) resistor r=45 c=0
Rx5 (S0b \6\:S0b) resistor r=45 c=0
Rx7 (\40\:n0 n0) resistor r=45 c=0
mn0 (\7\:S0b \3\:S0 \21\:VSS VSS) g45n1svt w=(2.6e-07) l=4.5e-08 nf=1 \
        as=3.83e-14 ad=3.64e-14 ps=8.4e-07 pd=8e-07 nrd=1.16667 \
        nrs=1.16667 sa=1.4e-07 sb=1.59808e-06 sd=160n sca=10.104 \
        scb=0.00906063 scc=0.000325539 m=(1)
mn1 (net148 \3\:A \21\:VSS VSS) g45n1svt w=(2.05e-07) l=4.5e-08 nf=1 \
        as=3.83e-14 ad=1.23e-14 ps=8.4e-07 pd=5.3e-07 nrd=1.16667 \
        nrs=1.16667 sa=3.45e-07 sb=2e-06 sd=160n sca=8.84876 scb=0.0071018 \
        scc=0.000159248 m=(1)
mn2 (\42\:n0 \2\:S0b net148 VSS) g45n1svt w=(2.05e-07) l=4.5e-08 nf=1 \
        as=1.23e-14 ad=3.28e-14 ps=5.3e-07 pd=7.3e-07 nrd=1.16667 \
        nrs=1.16667 sa=4.5e-07 sb=2e-06 sd=160n sca=8.84876 scb=0.0071018 \
        scc=0.000159248 m=(1)
mn4 (\42\:n0 \4\:S0 net140 VSS) g45n1svt w=(2.05e-07) l=4.5e-08 nf=1 \
        as=6.458e-14 ad=3.28e-14 ps=1.04e-06 pd=7.3e-07 nrd=1.16667 \
        nrs=1.16667 sa=6.55e-07 sb=2e-06 sd=160n sca=8.84876 scb=0.0071018 \
        scc=0.000159248 m=(1)
mn3 (net140 \3\:B \1\:VSS VSS) g45n1svt w=(2.05e-07) l=4.5e-08 nf=1 \
        as=5.048e-14 ad=6.458e-14 ps=1.01e-06 pd=1.04e-06 nrd=1.16667 \
        nrs=1.16667 sa=1.015e-06 sb=2e-06 sd=160n sca=8.84876 \
        scb=0.0071018 scc=0.000159248 m=(1)
mn5_1__rcx (Y n0 \1\:VSS VSS) g45n1svt w=(3.1e-07) l=4.5e-08 nf=1 \
        as=5.217e-14 ad=4.96e-14 ps=9.63e-07 pd=9.4e-07 nrd=1.16667 \
        nrs=1.16667 sa=8.6379e-07 sb=2e-06 sd=160n sca=11.8347 \
        scb=0.0112322 scc=0.000626052 m=(10)
mp1 (net123 \1\:A \19\:VDD NW) g45p1svt w=(3.1e-07) l=4.5e-08 nf=1 \
        as=5.76e-14 ad=3.255e-14 ps=1.1e-06 pd=8.3e-07 nrd=1.16667 \
        nrs=1.16667 sa=3.45e-07 sb=2e-06 sd=160n sca=12.241 scb=0.00942952 \
        scc=0.00011999 m=(1)
mp2 (\44\:n0 \6\:S0 net123 NW) g45p1svt w=(3.1e-07) l=4.5e-08 nf=1 \
        as=3.255e-14 ad=6.82e-14 ps=8.3e-07 pd=1.06e-06 nrd=1.16667 \
        nrs=1.16667 sa=4.95e-07 sb=2e-06 sd=160n sca=11.314 scb=0.00849585 \
        scc=0.00011741 m=(1)
mp4 (\44\:n0 \3\:S0b net115 NW) g45p1svt w=(3.1e-07) l=4.5e-08 nf=1 \
        as=6.51e-14 ad=6.82e-14 ps=1.04e-06 pd=1.06e-06 nrd=1.16667 \
        nrs=1.16667 sa=7.6e-07 sb=2e-06 sd=160n sca=10.5719 scb=0.0081746 \
        scc=0.000117241 m=(1)
mp3 (net115 \1\:B \1\:VDD NW) g45p1svt w=(3.1e-07) l=4.5e-08 nf=1 \
        as=1.059e-13 ad=6.51e-14 ps=1.52e-06 pd=1.04e-06 nrd=1.16667 \
        nrs=1.16667 sa=1.015e-06 sb=2e-06 sd=160n sca=10.5719 \
        scb=0.0081746 scc=0.000117241 m=(1)
mp5_1__rcx (Y n0 \1\:VDD NW) g45p1svt w=(4.7e-07) l=4.5e-08 nf=1 \
        as=7.733e-14 ad=7.52e-14 ps=1.282e-06 pd=1.26e-06 nrd=1.16667 \
        nrs=1.16667 sa=9.24468e-07 sb=1.985e-06 sd=160n sca=13.3727 \
        scb=0.0119208 scc=0.000609828 m=(10)
ends CLKMX2X12
// End of subcircuit definition.
