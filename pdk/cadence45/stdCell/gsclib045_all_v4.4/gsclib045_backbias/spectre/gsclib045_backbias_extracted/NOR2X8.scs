// Generated for: spectre (May  1 11:30:47 2013 )
// Library name: gsclib045_backbias
// Cell name: NOR2X8
// View name: extracted

simulator lang=spectre

subckt NOR2X8 A B NW VDD VSS Y
mp0_1__rcx (1 \1\:A \10\:VDD NW) g45p1svt w=(4.45e-07) l=4.5e-08 nf=1 \
        as=6.23e-14 ad=2.67e-14 ps=1.17e-06 pd=1.01e-06 nrd=1.16667 \
        nrs=1.16667 sa=1.4e-07 sb=2e-06 sd=160n sca=18.537 scb=0.0176846 \
        scc=0.000953219 m=(1)
mp1_1__rcx (\23\:Y \5\:B 1 NW) g45p1svt w=(4.45e-07) l=4.5e-08 nf=1 \
        as=2.67e-14 ad=7.12e-14 ps=1.01e-06 pd=1.21e-06 nrd=1.16667 \
        nrs=1.16667 sa=2.45e-07 sb=2e-06 sd=160n sca=16.9609 scb=0.0150862 \
        scc=0.00091445 m=(1)
mp1_2__rcx (\23\:Y \1\:B 3 NW) g45p1svt w=(4.45e-07) l=4.5e-08 nf=1 \
        as=2.67e-14 ad=7.12e-14 ps=1.01e-06 pd=1.21e-06 nrd=1.16667 \
        nrs=1.16667 sa=4.5e-07 sb=1.8e-06 sd=160n sca=15.5281 scb=0.013472 \
        scc=0.000907738 m=(1)
mp0_2__rcx (3 \10\:A \8\:VDD NW) g45p1svt w=(4.45e-07) l=4.5e-08 nf=1 \
        as=7.12e-14 ad=2.67e-14 ps=1.21e-06 pd=1.01e-06 nrd=1.16667 \
        nrs=1.16667 sa=5.55e-07 sb=1.695e-06 sd=160n sca=15.1505 \
        scb=0.0132652 scc=0.000907605 m=(1)
mp0_3__rcx (2 \4\:A \8\:VDD NW) g45p1svt w=(4.45e-07) l=4.5e-08 nf=1 \
        as=7.12e-14 ad=2.67e-14 ps=1.21e-06 pd=1.01e-06 nrd=1.16667 \
        nrs=1.16667 sa=7.6e-07 sb=1.49e-06 sd=160n sca=14.8079 \
        scb=0.013166 scc=0.000907585 m=(1)
mp1_3__rcx (\26\:Y \11\:B 2 NW) g45p1svt w=(4.45e-07) l=4.5e-08 nf=1 \
        as=2.67e-14 ad=7.12e-14 ps=1.01e-06 pd=1.21e-06 nrd=1.16667 \
        nrs=1.16667 sa=8.65e-07 sb=1.385e-06 sd=160n sca=14.8079 \
        scb=0.013166 scc=0.000907585 m=(1)
mp1_4__rcx (\26\:Y \12\:B 5 NW) g45p1svt w=(4.45e-07) l=4.5e-08 nf=1 \
        as=2.67e-14 ad=7.12e-14 ps=1.01e-06 pd=1.21e-06 nrd=1.16667 \
        nrs=1.16667 sa=1.07e-06 sb=1.18e-06 sd=160n sca=14.8079 \
        scb=0.013166 scc=0.000907585 m=(1)
mp0_4__rcx (5 \14\:A \6\:VDD NW) g45p1svt w=(4.45e-07) l=4.5e-08 nf=1 \
        as=7.342e-14 ad=2.67e-14 ps=1.22e-06 pd=1.01e-06 nrd=1.16667 \
        nrs=1.16667 sa=1.175e-06 sb=1.075e-06 sd=160n sca=14.8079 \
        scb=0.013166 scc=0.000907585 m=(1)
mp0_5__rcx (4 \16\:A \6\:VDD NW) g45p1svt w=(4.45e-07) l=4.5e-08 nf=1 \
        as=7.342e-14 ad=2.67e-14 ps=1.22e-06 pd=1.01e-06 nrd=1.16667 \
        nrs=1.16667 sa=1.385e-06 sb=8.65e-07 sd=160n sca=14.8079 \
        scb=0.013166 scc=0.000907585 m=(1)
mp1_5__rcx (\29\:Y \17\:B 4 NW) g45p1svt w=(4.45e-07) l=4.5e-08 nf=1 \
        as=2.67e-14 ad=7.12e-14 ps=1.01e-06 pd=1.21e-06 nrd=1.16667 \
        nrs=1.16667 sa=1.49e-06 sb=7.6e-07 sd=160n sca=14.8079 \
        scb=0.013166 scc=0.000907585 m=(1)
mp1_6__rcx (\29\:Y \19\:B 7 NW) g45p1svt w=(4.45e-07) l=4.5e-08 nf=1 \
        as=2.67e-14 ad=7.12e-14 ps=1.01e-06 pd=1.21e-06 nrd=1.16667 \
        nrs=1.16667 sa=1.695e-06 sb=5.55e-07 sd=160n sca=14.8079 \
        scb=0.013166 scc=0.000907585 m=(1)
mp0_6__rcx (7 \22\:A \1\:VDD NW) g45p1svt w=(4.45e-07) l=4.5e-08 nf=1 \
        as=7.12e-14 ad=2.67e-14 ps=1.21e-06 pd=1.01e-06 nrd=1.16667 \
        nrs=1.16667 sa=1.8e-06 sb=4.5e-07 sd=160n sca=14.8079 scb=0.013166 \
        scc=0.000907585 m=(1)
mp0 (6 \23\:A \1\:VDD NW) g45p1svt w=(4.45e-07) l=4.5e-08 nf=1 \
        as=7.12e-14 ad=2.67e-14 ps=1.21e-06 pd=1.01e-06 nrd=1.16667 \
        nrs=1.16667 sa=2e-06 sb=2.45e-07 sd=160n sca=14.8666 scb=0.0131776 \
        scc=0.000907586 m=(1)
mp1 (\32\:Y \22\:B 6 NW) g45p1svt w=(4.45e-07) l=4.5e-08 nf=1 as=2.67e-14 \
        ad=6.23e-14 ps=1.01e-06 pd=1.17e-06 nrd=1.16667 nrs=1.16667 \
        sa=2e-06 sb=1.4e-07 sd=160n sca=15.1213 scb=0.0132536 \
        scc=0.000907601 m=(1)
C1 (A VSS) capacitor c=1.19346e-15
C2 (Y VSS) capacitor c=3.85999e-17
C3 (NW VSS) capacitor c=4.06341e-16
C4 (VDD VSS) capacitor c=3.2255e-17
C5 (B VSS) capacitor c=1.06606e-15
C6 (1 VSS) capacitor c=3.0278e-18
C7 (3 VSS) capacitor c=2.01655e-18
C8 (2 VSS) capacitor c=1.8715e-18
C9 (5 VSS) capacitor c=2.01655e-18
C10 (4 VSS) capacitor c=2.01655e-18
C11 (7 VSS) capacitor c=2.01764e-18
C12 (6 VSS) capacitor c=2.01655e-18
C13 (\22\:B VSS) capacitor c=9.72723e-17
C14 (\23\:A VSS) capacitor c=7.21855e-17
C15 (\22\:A VSS) capacitor c=8.30846e-17
C16 (\19\:B VSS) capacitor c=6.35596e-17
C17 (\17\:B VSS) capacitor c=6.46389e-17
C18 (\16\:A VSS) capacitor c=7.22305e-17
C19 (\14\:A VSS) capacitor c=7.56934e-17
C20 (\12\:B VSS) capacitor c=8.10176e-17
C21 (\11\:B VSS) capacitor c=6.40398e-17
C22 (\4\:A VSS) capacitor c=7.13019e-17
C23 (\10\:A VSS) capacitor c=7.17956e-17
C24 (\1\:B VSS) capacitor c=6.45287e-17
C25 (\5\:B VSS) capacitor c=8.2028e-17
C26 (\1\:A VSS) capacitor c=8.33517e-17
C27 (\32\:Y VSS) capacitor c=2.46804e-17
C28 (\1\:VDD VSS) capacitor c=1.89907e-16
C29 (\29\:Y VSS) capacitor c=3.86308e-17
C30 (\6\:VDD VSS) capacitor c=5.07923e-17
C31 (\26\:Y VSS) capacitor c=3.84442e-17
C32 (\8\:VDD VSS) capacitor c=5.07499e-17
C33 (\23\:Y VSS) capacitor c=3.84946e-17
C34 (\10\:VDD VSS) capacitor c=5.11228e-17
C35 (\1\:Y VSS) capacitor c=9.76543e-16
C36 (\21\:A VSS) capacitor c=5.47632e-17
C37 (\34\:Y VSS) capacitor c=4.81011e-17
C38 (\22\:Y VSS) capacitor c=1.49389e-16
C39 (\25\:Y VSS) capacitor c=8.55299e-17
C40 (\28\:Y VSS) capacitor c=8.55517e-17
C41 (\31\:Y VSS) capacitor c=7.28162e-17
C42 (\3\:VDD VSS) capacitor c=8.14589e-17
C43 (\4\:VDD VSS) capacitor c=6.65215e-17
C44 (\5\:VDD VSS) capacitor c=4.18229e-17
Rk31 (Y \34\:Y) resistor r=0.3651 c=0
Rk32 (\34\:Y \1\:Y) resistor r=0.07606 c=0
Rk22 (\1\:Y \22\:Y) resistor r=0.8362 c=0
Rk23 (\22\:Y \24\:Y) resistor r=0.09088 c=0
Rk24 (\22\:Y \25\:Y) resistor r=0.4605 c=0
Rk25 (\25\:Y \27\:Y) resistor r=0.09088 c=0
Rk26 (\25\:Y \28\:Y) resistor r=0.4641 c=0
Rk27 (\28\:Y \30\:Y) resistor r=0.08751 c=0
Rk30 (\31\:Y Y) resistor r=0.3427 c=0
Rk28 (\28\:Y \31\:Y) resistor r=0.4605 c=0
Rk29 (\31\:Y \33\:Y) resistor r=0.08751 c=0
Rk49 (\2\:VDD \3\:VDD) resistor r=0.563 c=0
Rk50 (\3\:VDD \4\:VDD) resistor r=0.3134 c=0
Rk52 (\5\:VDD VDD) resistor r=0.09997 c=0
Rk51 (\4\:VDD \5\:VDD) resistor r=0.3109 c=0
Rk53 (\3\:VDD \7\:VDD) resistor r=0.2499 c=0
Rk54 (\4\:VDD \9\:VDD) resistor r=0.2499 c=0
Rk55 (\5\:VDD \11\:VDD) resistor r=0.2903 c=0
Rl23 (A \16\:A) resistor r=86.3033 c=0
Rl21 (A \14\:A) resistor r=101.842 c=0
Rl8 (A \4\:A) resistor r=81.5719 c=0
Rl13 (A \10\:A) resistor r=81.5719 c=0
Rl1 (A \1\:A) resistor r=99.5886 c=0
Rl33 (\21\:A A) resistor r=41.0733 c=0
Rl35 (\21\:A \23\:A) resistor r=65.6027 c=0
Rl34 (\21\:A \22\:A) resistor r=132.813 c=0
Rl37 (B \22\:B) resistor r=113.107 c=0
Rl29 (B \19\:B) resistor r=37.4703 c=0
Rl27 (B \17\:B) resistor r=40.3857 c=0
Rl18 (B \12\:B) resistor r=44.8736 c=0
Rl17 (B \11\:B) resistor r=38.5399 c=0
Rl3 (B \1\:B) resistor r=37.6767 c=0
Rl6 (B \5\:B) resistor r=44.8736 c=0
Ry1 (\24\:Y \23\:Y) resistor r=20.6667 c=0
Ry2 (\27\:Y \26\:Y) resistor r=20.6667 c=0
Ry3 (\30\:Y \29\:Y) resistor r=20.6667 c=0
Ry4 (\33\:Y \32\:Y) resistor r=20.6667 c=0
Ry7 (\1\:VDD \2\:VDD) resistor r=31 c=0
Ry8 (\6\:VDD \7\:VDD) resistor r=31 c=0
Ry9 (\8\:VDD \9\:VDD) resistor r=31 c=0
Ry10 (\10\:VDD \11\:VDD) resistor r=20.6667 c=0
mn0_1__rcx (\1\:Y A VSS VSS) g45n1svt w=(2.95e-07) l=4.5e-08 nf=1 \
        as=4.678e-14 ad=4.72e-14 ps=9.0714e-07 pd=9.1e-07 nrd=1.16667 \
        nrs=1.16667 sa=1.4e-07 sb=2e-06 sd=160n sca=11.2331 scb=0.0105428 \
        scc=0.000514855 m=(7)
mn1_1__rcx (\1\:Y B VSS VSS) g45n1svt w=(2.95e-07) l=4.5e-08 nf=1 \
        as=4.72e-14 ad=4.72e-14 ps=9.1e-07 pd=9.1e-07 nrd=1.16667 \
        nrs=1.16667 sa=3.45e-07 sb=2e-06 sd=160n sca=11.2331 scb=0.0105428 \
        scc=0.000514855 m=(7)
ends NOR2X8
// End of subcircuit definition.
