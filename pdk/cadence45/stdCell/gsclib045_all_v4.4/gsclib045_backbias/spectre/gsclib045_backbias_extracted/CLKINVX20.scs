// Generated for: spectre (May  1 11:28:23 2013 )
// Library name: gsclib045_backbias
// Cell name: CLKINVX20
// View name: extracted

simulator lang=spectre

subckt CLKINVX20 A NW VDD VSS Y
mp0 (\1\:Y \1\:A VDD NW) g45p1svt w=(4.6e-07) l=4.5e-08 nf=1 \
        as=7.301e-14 ad=7.36e-14 ps=1.2375e-06 pd=1.24e-06 nrd=1.16667 \
        nrs=1.16667 sa=1.4e-07 sb=2e-06 sd=160n sca=41.0128 scb=0.0371513 \
        scc=0.00426262 m=(16)
C1 (A VSS) capacitor c=1.65572e-17
C2 (VDD VSS) capacitor c=8.37056e-16
C3 (NW VSS) capacitor c=4.12208e-16
C4 (Y VSS) capacitor c=1.05716e-17
C5 (\1\:A VSS) capacitor c=1.27638e-15
C6 (\1\:Y VSS) capacitor c=8.30025e-16
C7 (\12\:Y VSS) capacitor c=7.94554e-16
Rk9 (\1\:A A) resistor r=0.01718 c=0
Rk18 (\1\:Y Y) resistor r=0.03951 c=0
Rk19 (\1\:Y \12\:Y) resistor r=0.1937 c=0
mn0 (\12\:Y \1\:A VSS VSS) g45n1svt w=(3.05e-07) l=4.5e-08 nf=1 \
        as=4.844e-14 ad=4.844e-14 ps=9.2765e-07 pd=9.2765e-07 nrd=1.16667 \
        nrs=1.16667 sa=1.4e-07 sb=2e-06 sd=160n sca=16.121 scb=0.0155296 \
        scc=0.00139557 m=(17)
mp0_16__rcx (\1\:Y \1\:A VDD NW) g45p1svt w=(4.55e-07) l=4.5e-08 nf=1 \
        as=7.33e-14 ad=1.0238e-13 ps=1.24e-06 pd=1.36e-06 nrd=1.16667 \
        nrs=1.16667 sa=2e-06 sb=2.25e-07 sd=160n sca=32.0859 scb=0.0265913 \
        scc=0.00291711 m=(1)
ends CLKINVX20
// End of subcircuit definition.
