// Generated for: spectre (May  1 11:28:22 2013 )
// Library name: gsclib045_backbias
// Cell name: CLKINVX2
// View name: extracted

simulator lang=spectre

subckt CLKINVX2 A NW VDD VSS Y
mp0 (\3\:Y \1\:A \1\:VDD NW) g45p1svt w=(3.9e-07) l=4.5e-08 nf=1 \
        as=5.46e-14 ad=6.24e-14 ps=1.06e-06 pd=1.1e-06 nrd=1.16667 \
        nrs=1.16667 sa=1.4e-07 sb=3.45e-07 sd=160n sca=38.0826 \
        scb=0.0294587 scc=0.00345874 m=(2)
C1 (Y VSS) capacitor c=2.66915e-17
C2 (A VSS) capacitor c=2.50484e-17
C3 (VDD VSS) capacitor c=3.07613e-17
C4 (NW VSS) capacitor c=1.26942e-16
C5 (\1\:A VSS) capacitor c=1.06683e-16
C6 (\4\:A VSS) capacitor c=1.1695e-17
C7 (\1\:VDD VSS) capacitor c=2.02923e-16
C8 (\3\:Y VSS) capacitor c=9.61784e-17
C9 (\1\:Y VSS) capacitor c=1.63529e-17
C10 (\8\:A VSS) capacitor c=6.57892e-17
Rk2 (Y \2\:Y) resistor r=0.05085 c=0
Rk3 (Y \4\:Y) resistor r=0.2572 c=0
Rk1 (A \8\:A) resistor r=0.1424 c=0
Rk5 (\1\:VDD VDD) resistor r=0.09222 c=0
Rk9 (\1\:VSS VSS) resistor r=0.09222 c=0
Rl3 (\1\:A \4\:A) resistor r=4.8851 c=0
Rz1 (\2\:Y \1\:Y) resistor r=75 c=0
Ry1 (\4\:Y \3\:Y) resistor r=20.6667 c=0
Rx1 (\8\:A \4\:A) resistor r=45 c=0
mn0 (\1\:Y \1\:A \1\:VSS VSS) g45n1svt w=(2.6e-07) l=4.5e-08 nf=1 \
        as=3.64e-14 ad=4.16e-14 ps=8e-07 pd=8.4e-07 nrd=1.16667 \
        nrs=1.16667 sa=1.4e-07 sb=3.45e-07 sd=160n sca=15.3338 \
        scb=0.0153436 scc=0.00119435 m=(2)
ends CLKINVX2
// End of subcircuit definition.
