// Generated for: spectre (May  1 11:26:55 2013 )
// Library name: gsclib045_backbias
// Cell name: ADDHX1
// View name: extracted

simulator lang=spectre

subckt ADDHX1 A B CO NW S VDD VSS
mp8 (\3\:CO \4\:COb \10\:VDD NW) g45p1svt w=(3.9e-07) l=4.5e-08 nf=1 \
        as=7.585e-14 ad=5.46e-14 ps=1.83e-06 pd=1.06e-06 nrd=1.16667 \
        nrs=1.16667 sa=1.4e-07 sb=3.20513e-07 sd=160n sca=35.0084 \
        scb=0.0365133 scc=0.00352722 m=(1)
mp5 (\1\:S Sb \1\:VDD NW) g45p1svt w=(3.9e-07) l=4.5e-08 nf=1 \
        as=5.19e-14 ad=5.46e-14 ps=1.1e-06 pd=1.06e-06 nrd=1.16667 \
        nrs=1.16667 sa=6.69103e-07 sb=1.4e-07 sd=160n sca=42.1543 \
        scb=0.0369591 scc=0.00437643 m=(1)
C1 (NW VSS) capacitor c=3.29993e-16
C2 (CO VSS) capacitor c=5.30398e-17
C3 (A VSS) capacitor c=5.13276e-17
C4 (VDD VSS) capacitor c=3.51649e-17
C5 (S VSS) capacitor c=3.98185e-17
C6 (B VSS) capacitor c=9.02611e-17
C7 (COb VSS) capacitor c=2.49001e-17
C8 (n4 VSS) capacitor c=1.28943e-18
C9 (n1 VSS) capacitor c=2.9067e-17
C10 (n0 VSS) capacitor c=9.36118e-17
C11 (Sb VSS) capacitor c=5.14355e-17
C12 (\3\:n1 VSS) capacitor c=5.9932e-17
C13 (\2\:B VSS) capacitor c=1.05988e-16
C14 (\4\:A VSS) capacitor c=5.09175e-17
C15 (\3\:B VSS) capacitor c=5.44924e-17
C16 (\8\:B VSS) capacitor c=2.97321e-17
C17 (\3\:A VSS) capacitor c=6.36827e-17
C18 (\4\:COb VSS) capacitor c=4.69258e-17
C19 (\3\:Sb VSS) capacitor c=4.02665e-17
C20 (\2\:n0 VSS) capacitor c=7.91487e-17
C21 (\1\:B VSS) capacitor c=1.03229e-16
C22 (\6\:A VSS) capacitor c=2.69589e-17
C23 (\7\:B VSS) capacitor c=2.80522e-17
C24 (\6\:B VSS) capacitor c=4.3536e-17
C25 (\1\:A VSS) capacitor c=3.99344e-17
C26 (\3\:COb VSS) capacitor c=5.09606e-17
C27 (\2\:Sb VSS) capacitor c=2.64741e-17
C28 (\3\:n0 VSS) capacitor c=3.72292e-17
C29 (\4\:n1 VSS) capacitor c=3.60883e-17
C30 (\2\:n1 VSS) capacitor c=4.37483e-17
C31 (\5\:A VSS) capacitor c=4.15101e-17
C32 (\5\:B VSS) capacitor c=5.34422e-17
C33 (\2\:A VSS) capacitor c=8.1875e-17
C34 (\1\:S VSS) capacitor c=3.16791e-17
C35 (\1\:VDD VSS) capacitor c=1.29393e-16
C36 (\8\:Sb VSS) capacitor c=6.48562e-17
C37 (\7\:n0 VSS) capacitor c=1.1182e-16
C38 (\6\:VDD VSS) capacitor c=7.38698e-17
C39 (\11\:n1 VSS) capacitor c=2.09575e-17
C40 (\8\:VDD VSS) capacitor c=1.19711e-17
C41 (\9\:COb VSS) capacitor c=2.19204e-17
C42 (\10\:VDD VSS) capacitor c=6.2452e-18
C43 (\3\:CO VSS) capacitor c=3.32149e-17
C44 (\3\:S VSS) capacitor c=3.58838e-17
C45 (\6\:Sb VSS) capacitor c=2.8983e-17
C46 (\5\:n0 VSS) capacitor c=1.46545e-16
C47 (\8\:n1 VSS) capacitor c=6.91697e-17
C48 (\5\:COb VSS) capacitor c=1.20806e-16
C49 (\1\:CO VSS) capacitor c=6.51832e-17
C50 (\2\:COb VSS) capacitor c=2.39798e-17
C51 (\4\:B VSS) capacitor c=3.00612e-17
C52 (\7\:COb VSS) capacitor c=1.1623e-16
C53 (\8\:COb VSS) capacitor c=7.54687e-17
C54 (\7\:A VSS) capacitor c=1.59066e-16
C55 (\8\:A VSS) capacitor c=1.4294e-16
C56 (\5\:n1 VSS) capacitor c=3.14433e-17
C57 (\6\:n1 VSS) capacitor c=1.44134e-16
C58 (\7\:n1 VSS) capacitor c=1.34096e-16
C59 (\10\:n1 VSS) capacitor c=1.30838e-16
C60 (\4\:n0 VSS) capacitor c=6.66217e-17
C61 (\4\:Sb VSS) capacitor c=4.54239e-17
C62 (\5\:Sb VSS) capacitor c=6.57713e-17
C63 (\3\:VDD VSS) capacitor c=9.70681e-17
C64 (\4\:VDD VSS) capacitor c=3.37275e-17
C65 (\5\:VDD VSS) capacitor c=2.61757e-17
Rk28 (\2\:VSS \4\:VSS) resistor r=0.7803 c=0
Rk29 (\4\:VSS \5\:VSS) resistor r=0.04 c=0
Rk31 (\6\:VSS VSS) resistor r=0.1016 c=0
Rk30 (\5\:VSS \6\:VSS) resistor r=0.3579 c=0
Rk32 (\5\:VSS \8\:VSS) resistor r=0.129 c=0
Rk33 (\6\:VSS \10\:VSS) resistor r=0.2133 c=0
Rk1 (\2\:CO CO) resistor r=0.4599 c=0
Rk2 (CO \4\:CO) resistor r=0.0513 c=0
Rk8 (\8\:A A) resistor r=0.06006 c=0
Rk7 (\7\:A \8\:A) resistor r=1.1293 c=0
Rk21 (\2\:VDD \3\:VDD) resistor r=0.7567 c=0
Rk22 (\3\:VDD \4\:VDD) resistor r=0.1679 c=0
Rk24 (\5\:VDD VDD) resistor r=0.08246 c=0
Rk23 (\4\:VDD \5\:VDD) resistor r=0.2358 c=0
Rk25 (\3\:VDD \7\:VDD) resistor r=0.3843 c=0
Rk26 (\4\:VDD \9\:VDD) resistor r=0.129 c=0
Rk27 (\5\:VDD \11\:VDD) resistor r=0.0884 c=0
Rk19 (\2\:S S) resistor r=0.1429 c=0
Rk20 (S \4\:S) resistor r=0.2039 c=0
Rk3 (B \9\:B) resistor r=0.04302 c=0
Rk4 (\6\:COb \7\:COb) resistor r=0.6944 c=0
Rk5 (\7\:COb \8\:COb) resistor r=0.3126 c=0
Rk6 (\7\:COb \10\:COb) resistor r=0.14 c=0
Rk9 (\5\:n1 \6\:n1) resistor r=0.1405 c=0
Rk10 (\6\:n1 \7\:n1) resistor r=0.7645 c=0
Rk11 (\7\:n1 \9\:n1) resistor r=0.3294 c=0
Rk12 (\6\:n1 \10\:n1) resistor r=0.5446 c=0
Rk13 (\7\:n1 \12\:n1) resistor r=0.1051 c=0
Rk14 (\4\:n0 \6\:n0) resistor r=0.4938 c=0
Rk15 (\6\:n0 \8\:n0) resistor r=0.4481 c=0
Rk16 (\4\:Sb \5\:Sb) resistor r=0.2357 c=0
Rk17 (\5\:Sb \7\:Sb) resistor r=0.1233 c=0
Rk18 (\5\:Sb \9\:Sb) resistor r=0.3607 c=0
Rl6 (\4\:A \5\:A) resistor r=99.1749 c=0
Rl7 (\5\:A \6\:A) resistor r=29.9442 c=0
Rl5 (\2\:A \3\:A) resistor r=160.771 c=0
Rl4 (\1\:A \2\:A) resistor r=31.9251 c=0
Rl11 (\2\:B \3\:B) resistor r=328.412 c=0
Rl10 (\1\:B \2\:B) resistor r=204.9 c=0
Rl16 (\5\:B \8\:B) resistor r=93.4057 c=0
Rl14 (\5\:B \6\:B) resistor r=95.3288 c=0
Rl12 (\3\:B \4\:B) resistor r=80.0028 c=0
Rl15 (\4\:B \7\:B) resistor r=78.0797 c=0
Rl13 (\4\:B \5\:B) resistor r=123.856 c=0
Rl3 (\2\:COb \4\:COb) resistor r=37.3411 c=0
Rl2 (\2\:COb \3\:COb) resistor r=106.572 c=0
Rl1 (COb \2\:COb) resistor r=1.2334 c=0
Rl9 (\3\:n1 \4\:n1) resistor r=31.9251 c=0
Rl8 (n1 \2\:n1) resistor r=37.2302 c=0
Rl17 (n0 \2\:n0) resistor r=161.538 c=0
Rl18 (\2\:n0 \3\:n0) resistor r=74.2328 c=0
Rl19 (Sb \2\:Sb) resistor r=39.6174 c=0
Rl20 (\2\:Sb \3\:Sb) resistor r=26.1559 c=0
Rz7 (\1\:VSS \2\:VSS) resistor r=75 c=0
Rz8 (\7\:VSS \8\:VSS) resistor r=75 c=0
Rz9 (\9\:VSS \10\:VSS) resistor r=75 c=0
Rz1 (\1\:CO \2\:CO) resistor r=37.5 c=0
Rz6 (\3\:S \4\:S) resistor r=37.5 c=0
Rz2 (\5\:COb \6\:COb) resistor r=75 c=0
Rz3 (\8\:n1 \9\:n1) resistor r=75 c=0
Rz4 (\5\:n0 \6\:n0) resistor r=75 c=0
Rz5 (\6\:Sb \7\:Sb) resistor r=75 c=0
Ry1 (\3\:CO \4\:CO) resistor r=20.6667 c=0
Ry7 (\1\:VDD \2\:VDD) resistor r=62 c=0
Ry8 (\6\:VDD \7\:VDD) resistor r=62 c=0
Ry9 (\8\:VDD \9\:VDD) resistor r=31 c=0
Ry10 (\10\:VDD \11\:VDD) resistor r=62 c=0
Ry6 (\1\:S \2\:S) resistor r=20.6667 c=0
Ry2 (\9\:COb \10\:COb) resistor r=62 c=0
Ry3 (\11\:n1 \12\:n1) resistor r=62 c=0
Ry4 (\7\:n0 \8\:n0) resistor r=62 c=0
Ry5 (\8\:Sb \9\:Sb) resistor r=62 c=0
Rx3 (\5\:A \7\:A) resistor r=45 c=0
Rx4 (\2\:A \8\:A) resistor r=45 c=0
Rx1 (\5\:B \9\:B) resistor r=45 c=0
Rx2 (COb \8\:COb) resistor r=45 c=0
Rx5 (\4\:n1 \5\:n1) resistor r=45 c=0
Rx6 (\2\:n1 \10\:n1) resistor r=45 c=0
Rx7 (\3\:n0 \4\:n0) resistor r=45 c=0
Rx8 (\2\:Sb \4\:Sb) resistor r=45 c=0
mn8 (\1\:CO \3\:COb \9\:VSS VSS) g45n1svt w=(2.6e-07) l=4.5e-08 nf=1 \
        as=3.47e-14 ad=3.64e-14 ps=8.4e-07 pd=8e-07 nrd=1.16667 \
        nrs=1.16667 sa=1.4e-07 sb=3.11923e-07 sd=160n sca=9.14564 \
        scb=0.00759168 scc=0.000213449 m=(1)
mn5 (\3\:S \3\:Sb \1\:VSS VSS) g45n1svt w=(2.6e-07) l=4.5e-08 nf=1 \
        as=3.47e-14 ad=3.64e-14 ps=8.4e-07 pd=8e-07 nrd=1.16667 \
        nrs=1.16667 sa=6.85577e-07 sb=1.4e-07 sd=160n sca=16.9678 \
        scb=0.0167861 scc=0.00150639 m=(1)
mn6 (n4 \1\:A \9\:VSS VSS) g45n1svt w=(1.45e-07) l=4.5e-08 nf=1 \
        as=3.47e-14 ad=1.305e-14 ps=8.4e-07 pd=4.7e-07 nrd=1.16667 \
        nrs=1.16667 sa=3.45e-07 sb=2.75e-07 sd=160n sca=10.9472 \
        scb=0.0104991 scc=0.000356047 m=(1)
mn7 (\5\:COb \6\:B n4 VSS) g45n1svt w=(1.45e-07) l=4.5e-08 nf=1 \
        as=1.305e-14 ad=2.03e-14 ps=4.7e-07 pd=5.7e-07 nrd=1.16667 \
        nrs=1.16667 sa=4.8e-07 sb=1.4e-07 sd=160n sca=10.9472 \
        scb=0.0104991 scc=0.000356047 m=(1)
mn1 (\8\:n1 \7\:B \7\:VSS VSS) g45n1svt w=(1.45e-07) l=4.5e-08 nf=1 \
        as=7.32e-14 ad=2.03e-14 ps=1.67e-06 pd=5.7e-07 nrd=1.16667 \
        nrs=1.16667 sa=1.4e-07 sb=1.15e-06 sd=160n sca=22.3376 \
        scb=0.0224607 scc=0.00248252 m=(1)
mn0 (\5\:n0 \6\:A \7\:VSS VSS) g45n1svt w=(1.45e-07) l=4.5e-08 nf=1 \
        as=7.32e-14 ad=3.335e-14 ps=1.67e-06 pd=7.5e-07 nrd=1.16667 \
        nrs=1.16667 sa=3.55e-07 sb=9.35e-07 sd=160n sca=22.3376 \
        scb=0.0224607 scc=0.00248252 m=(1)
mn4 (\6\:Sb n1 \5\:n0 VSS) g45n1svt w=(1.45e-07) l=4.5e-08 nf=1 \
        as=3.335e-14 ad=2.393e-14 ps=7.5e-07 pd=6.2e-07 nrd=1.16667 \
        nrs=1.16667 sa=6.3e-07 sb=6.6e-07 sd=160n sca=22.3376 \
        scb=0.0224607 scc=0.00248252 m=(1)
mn3 (\6\:Sb \1\:B n2 VSS) g45n1svt w=(1.45e-07) l=4.5e-08 nf=1 as=8.7e-15 \
        ad=2.393e-14 ps=4.1e-07 pd=6.2e-07 nrd=1.16667 nrs=1.16667 \
        sa=8.4e-07 sb=4.5e-07 sd=160n sca=22.3376 scb=0.0224607 \
        scc=0.00248252 m=(1)
mn2 (n2 \2\:n0 \1\:VSS VSS) g45n1svt w=(1.45e-07) l=4.5e-08 nf=1 \
        as=3.47e-14 ad=8.7e-15 ps=8.4e-07 pd=4.1e-07 nrd=1.16667 \
        nrs=1.16667 sa=9.45e-07 sb=3.45e-07 sd=160n sca=22.3376 \
        scb=0.0224607 scc=0.00248252 m=(1)
mp6 (\9\:COb \3\:A \10\:VDD NW) g45p1svt w=(2.15e-07) l=4.5e-08 nf=1 \
        as=7.585e-14 ad=3.44e-14 ps=1.83e-06 pd=7.5e-07 nrd=1.16667 \
        nrs=1.16667 sa=3.35e-07 sb=3.05e-07 sd=160n sca=15.3248 \
        scb=0.0144711 scc=0.000289176 m=(1)
mp7 (\9\:COb \8\:B \8\:VDD NW) g45p1svt w=(2.15e-07) l=4.5e-08 nf=1 \
        as=5.495e-14 ad=3.44e-14 ps=1.38e-06 pd=7.5e-07 nrd=1.16667 \
        nrs=1.16667 sa=5.4e-07 sb=1e-07 sd=160n sca=12.8165 scb=0.0106177 \
        scc=0.00024049 m=(1)
mp1 (\11\:n1 \3\:B \6\:VDD NW) g45p1svt w=(2.15e-07) l=4.5e-08 nf=1 \
        as=3.655e-14 ad=2.63e-14 ps=7.7e-07 pd=7.1e-07 nrd=1.16667 \
        nrs=1.16667 sa=1.22326e-07 sb=1.15e-06 sd=160n sca=12.7104 \
        scb=0.0116911 scc=0.00042519 m=(1)
mp0 (\7\:n0 \4\:A \6\:VDD NW) g45p1svt w=(2.15e-07) l=4.5e-08 nf=1 \
        as=3.655e-14 ad=5.052e-14 ps=7.7e-07 pd=9e-07 nrd=1.16667 \
        nrs=1.16667 sa=3.37326e-07 sb=9.35e-07 sd=160n sca=12.7104 \
        scb=0.0116911 scc=0.00042519 m=(1)
mp4 (\8\:Sb \2\:B \7\:n0 NW) g45p1svt w=(2.15e-07) l=4.5e-08 nf=1 \
        as=5.053e-14 ad=3.44e-14 ps=9e-07 pd=7.5e-07 nrd=1.16667 \
        nrs=1.16667 sa=6.17326e-07 sb=6.55e-07 sd=160n sca=13.327 \
        scb=0.0119299 scc=0.000425286 m=(1)
mp3 (\8\:Sb \3\:n1 n3 NW) g45p1svt w=(2.15e-07) l=4.5e-08 nf=1 \
        as=1.29e-14 ad=3.44e-14 ps=5.5e-07 pd=7.5e-07 nrd=1.16667 \
        nrs=1.16667 sa=8.22326e-07 sb=4.5e-07 sd=160n sca=14.6061 \
        scb=0.0132457 scc=0.000429538 m=(1)
mp2 (n3 n0 \1\:VDD NW) g45p1svt w=(2.15e-07) l=4.5e-08 nf=1 as=5.19e-14 \
        ad=1.29e-14 ps=1.1e-06 pd=5.5e-07 nrd=1.16667 nrs=1.16667 \
        sa=9.27326e-07 sb=3.45e-07 sd=160n sca=15.9702 scb=0.0153945 \
        scc=0.000454375 m=(1)
ends ADDHX1
// End of subcircuit definition.
