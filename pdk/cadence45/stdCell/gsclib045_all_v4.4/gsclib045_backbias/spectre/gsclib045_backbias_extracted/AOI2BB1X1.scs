// Generated for: spectre (May  1 11:27:43 2013 )
// Library name: gsclib045_backbias
// Cell name: AOI2BB1X1
// View name: extracted

simulator lang=spectre

subckt AOI2BB1X1 A0N A1N B0 NW VDD VSS Y
mp3 (\1\:Y n0 n2 NW) g45p1svt w=(3.9e-07) l=4.5e-08 nf=1 as=2.34e-14 \
        ad=5.46e-14 ps=9e-07 pd=1.06e-06 nrd=1.16667 nrs=1.16667 \
        sa=1.4e-07 sb=4.40705e-07 sd=160n sca=15.9621 scb=0.0150202 \
        scc=0.000309344 m=(1)
mp2 (n2 \3\:B0 \1\:VDD NW) g45p1svt w=(3.9e-07) l=4.5e-08 nf=1 \
        as=6.858e-14 ad=2.34e-14 ps=1.19e-06 pd=9e-07 nrd=1.16667 \
        nrs=1.16667 sa=2.45e-07 sb=3.35705e-07 sd=160n sca=14.5611 \
        scb=0.0122104 scc=0.000254242 m=(1)
C1 (B0 VSS) capacitor c=5.19696e-17
C2 (Y VSS) capacitor c=9.45555e-17
C3 (NW VSS) capacitor c=1.9323e-16
C4 (VDD VSS) capacitor c=6.42486e-17
C5 (A1N VSS) capacitor c=2.50032e-17
C6 (A0N VSS) capacitor c=6.26058e-17
C7 (n0 VSS) capacitor c=9.47555e-17
C8 (n2 VSS) capacitor c=1.73298e-18
C9 (\3\:A1N VSS) capacitor c=7.76076e-17
C10 (\1\:A0N VSS) capacitor c=6.96555e-17
C11 (\3\:B0 VSS) capacitor c=8.93633e-17
C12 (\1\:A1N VSS) capacitor c=3.15495e-17
C13 (\3\:A0N VSS) capacitor c=4.78308e-17
C14 (\1\:B0 VSS) capacitor c=6.02227e-17
C15 (\3\:n0 VSS) capacitor c=3.00092e-17
C16 (\4\:A1N VSS) capacitor c=1.2298e-17
C17 (\2\:A0N VSS) capacitor c=6.3588e-17
C18 (\2\:B0 VSS) capacitor c=6.53245e-17
C19 (\2\:n0 VSS) capacitor c=5.64846e-17
C20 (\4\:n0 VSS) capacitor c=5.53762e-17
C21 (\1\:VDD VSS) capacitor c=1.36568e-16
C22 (\1\:Y VSS) capacitor c=8.04677e-17
C23 (\8\:n0 VSS) capacitor c=3.11138e-17
C24 (\3\:Y VSS) capacitor c=4.46312e-17
C25 (\2\:A1N VSS) capacitor c=4.27096e-17
C26 (\4\:B0 VSS) capacitor c=6.57804e-17
C27 (\4\:A0N VSS) capacitor c=4.60989e-17
C28 (\6\:n0 VSS) capacitor c=1.06595e-16
C29 (\7\:n0 VSS) capacitor c=8.59568e-17
C30 (\5\:A1N VSS) capacitor c=4.34232e-17
Rk3 (B0 \4\:B0) resistor r=0.09846 c=0
Rk1 (\2\:Y Y) resistor r=0.6666 c=0
Rk2 (Y \4\:Y) resistor r=0.08156 c=0
Rk13 (\2\:VSS \4\:VSS) resistor r=0.5016 c=0
Rk15 (\5\:VSS VSS) resistor r=0.03965 c=0
Rk14 (\4\:VSS \5\:VSS) resistor r=0.2103 c=0
Rk16 (\4\:VSS \7\:VSS) resistor r=0.3073 c=0
Rk17 (\5\:VSS \9\:VSS) resistor r=0.1785 c=0
Rk18 (\2\:VDD VDD) resistor r=0.4682 c=0
Rk10 (\5\:A1N \6\:A1N) resistor r=0.01391 c=0
Rk11 (A1N \7\:A1N) resistor r=0.01391 c=0
Rk12 (\5\:A1N \7\:A1N) resistor r=0.02119 c=0
Rk6 (\4\:A0N A0N) resistor r=0.02396 c=0
Rk7 (\5\:n0 \6\:n0) resistor r=0.4796 c=0
Rk8 (\6\:n0 \7\:n0) resistor r=0.3662 c=0
Rk9 (\6\:n0 \9\:n0) resistor r=0.1404 c=0
Rl4 (\2\:B0 \3\:B0) resistor r=87.6365 c=0
Rl3 (\1\:B0 \2\:B0) resistor r=103.021 c=0
Rl8 (\2\:A1N \3\:A1N) resistor r=167.616 c=0
Rl7 (\1\:A1N \2\:A1N) resistor r=71.8171 c=0
Rl9 (\2\:A1N \4\:A1N) resistor r=5.1011 c=0
Rl5 (\1\:A0N \2\:A0N) resistor r=91.0764 c=0
Rl6 (\2\:A0N \3\:A0N) resistor r=106.461 c=0
Rl1 (n0 \2\:n0) resistor r=165.385 c=0
Rl2 (\2\:n0 \3\:n0) resistor r=33.7912 c=0
Rz1 (\3\:Y \4\:Y) resistor r=75 c=0
Rz3 (\1\:VSS \2\:VSS) resistor r=75 c=0
Rz4 (\6\:VSS \7\:VSS) resistor r=75 c=0
Rz5 (\8\:VSS \9\:VSS) resistor r=75 c=0
Rz2 (\8\:n0 \9\:n0) resistor r=75 c=0
Ry1 (\1\:Y \2\:Y) resistor r=20.6667 c=0
Ry4 (\1\:VDD \2\:VDD) resistor r=31 c=0
Ry2 (\4\:n0 \5\:n0) resistor r=62 c=0
Rx1 (\2\:B0 \4\:B0) resistor r=45 c=0
Rx4 (\4\:A1N \6\:A1N) resistor r=45 c=0
Rx2 (\2\:A0N \4\:A0N) resistor r=45 c=0
Rx3 (\2\:n0 \7\:n0) resistor r=45 c=0
mn3 (\3\:Y \3\:n0 \8\:VSS VSS) g45n1svt w=(2.6e-07) l=4.5e-08 nf=1 \
        as=4.03e-14 ad=4.16e-14 ps=8.3e-07 pd=8.4e-07 nrd=1.16667 \
        nrs=1.16667 sa=1.55e-07 sb=5.72692e-07 sd=160n sca=8.22858 \
        scb=0.00610564 scc=0.00012768 m=(1)
mn2 (\3\:Y \1\:B0 \6\:VSS VSS) g45n1svt w=(2.6e-07) l=4.5e-08 nf=1 \
        as=3.47e-14 ad=4.16e-14 ps=8.4e-07 pd=8.4e-07 nrd=1.16667 \
        nrs=1.16667 sa=3.6e-07 sb=3.67692e-07 sd=160n sca=8.22858 \
        scb=0.00610564 scc=0.00012768 m=(1)
mn0 (\8\:n0 \3\:A0N \6\:VSS VSS) g45n1svt w=(1.45e-07) l=4.5e-08 nf=1 \
        as=3.47e-14 ad=2.755e-14 ps=8.4e-07 pd=6.7e-07 nrd=1.16667 \
        nrs=1.16667 sa=5.65e-07 sb=3.75e-07 sd=160n sca=9.68855 \
        scb=0.00848242 scc=0.000213356 m=(1)
mn1 (\8\:n0 \1\:A1N \1\:VSS VSS) g45n1svt w=(1.45e-07) l=4.5e-08 nf=1 \
        as=2.03e-14 ad=2.755e-14 ps=5.7e-07 pd=6.7e-07 nrd=1.16667 \
        nrs=1.16667 sa=8e-07 sb=1.4e-07 sd=160n sca=9.68855 scb=0.00848242 \
        scc=0.000213356 m=(1)
mp0 (n1 \1\:A0N \1\:VDD NW) g45p1svt w=(2.15e-07) l=4.5e-08 nf=1 \
        as=6.858e-14 ad=1.29e-14 ps=1.19e-06 pd=5.5e-07 nrd=1.16667 \
        nrs=1.16667 sa=4.95e-07 sb=2.45e-07 sd=160n sca=15.6375 \
        scb=0.0141102 scc=0.000376252 m=(1)
mp1 (\4\:n0 \3\:A1N n1 NW) g45p1svt w=(2.15e-07) l=4.5e-08 nf=1 \
        as=1.29e-14 ad=3.01e-14 ps=5.5e-07 pd=7.1e-07 nrd=1.16667 \
        nrs=1.16667 sa=6e-07 sb=1.4e-07 sd=160n sca=17.3765 scb=0.017565 \
        scc=0.000461873 m=(1)
ends AOI2BB1X1
// End of subcircuit definition.
