// Generated for: spectre (May  1 11:33:37 2013 )
// Library name: gsclib045_backbias
// Cell name: TLATSRX2
// View name: extracted

simulator lang=spectre

subckt TLATSRX2 D G NW Q QN RN SN VDD VSS
mp2 (\6\:Gbb Gb \22\:VDD NW) g45p1svt w=(2.15e-07) l=4.5e-08 nf=1 \
        as=6.65e-14 ad=3.01e-14 ps=1.19e-06 pd=7.1e-07 nrd=1.16667 \
        nrs=1.16667 sa=1.4e-07 sb=9.9e-07 sd=160n sca=22.2113 \
        scb=0.0236966 scc=0.00141807 m=(1)
mp5 (net142 \1\:D \22\:VDD NW) g45p1svt w=(2.15e-07) l=4.5e-08 nf=1 \
        as=6.65e-14 ad=7.203e-14 ps=1.19e-06 pd=1.1e-06 nrd=1.16667 \
        nrs=1.16667 sa=4.05e-07 sb=7.25e-07 sd=160n sca=18.6067 \
        scb=0.017995 scc=0.00131765 m=(1)
mp6 (\5\:n5 \4\:Gb net142 NW) g45p1svt w=(2.15e-07) l=4.5e-08 nf=1 \
        as=7.203e-14 ad=3.44e-14 ps=1.1e-06 pd=7.5e-07 nrd=1.16667 \
        nrs=1.16667 sa=7.85e-07 sb=3.45e-07 sd=160n sca=17.4145 \
        scb=0.0172865 scc=0.00131682 m=(1)
mp17 (\5\:n5 Gbb \3\:net103 NW) g45p1svt w=(2.15e-07) l=4.5e-08 nf=1 \
        as=3.01e-14 ad=3.44e-14 ps=7.1e-07 pd=7.5e-07 nrd=1.16667 \
        nrs=1.16667 sa=9.9e-07 sb=1.4e-07 sd=160n sca=17.4145 \
        scb=0.0172865 scc=0.00131682 m=(1)
mp16 (net103 Qint \20\:VDD NW) g45p1svt w=(2.15e-07) l=4.5e-08 nf=1 \
        as=4.89e-14 ad=3.44e-14 ps=1.53e-06 pd=7.5e-07 nrd=1.16667 \
        nrs=1.16667 sa=1e-07 sb=2e-06 sd=160n sca=14.8993 scb=0.0146069 \
        scc=0.000816972 m=(1)
mp15 (net103 \5\:RN \18\:VDD NW) g45p1svt w=(2.15e-07) l=4.5e-08 nf=1 \
        as=5.965e-14 ad=3.44e-14 ps=1.63e-06 pd=7.5e-07 nrd=1.16667 \
        nrs=1.16667 sa=3.05e-07 sb=2e-06 sd=160n sca=14.8993 scb=0.0146069 \
        scc=0.000816972 m=(1)
mp0 (\10\:Gb \1\:RN \18\:VDD NW) g45p1svt w=(2.15e-07) l=4.5e-08 nf=1 \
        as=5.965e-14 ad=5.913e-14 ps=1.63e-06 pd=9.8e-07 nrd=1.16667 \
        nrs=1.16667 sa=5e-07 sb=2e-06 sd=160n sca=14.8993 scb=0.0146069 \
        scc=0.000816972 m=(1)
mp1 (\10\:Gb \1\:G \16\:VDD NW) g45p1svt w=(2.15e-07) l=4.5e-08 nf=1 \
        as=1.2245e-13 ad=5.913e-14 ps=2.17e-06 pd=9.8e-07 nrd=1.16667 \
        nrs=1.16667 sa=8.2e-07 sb=2e-06 sd=160n sca=14.8993 scb=0.0146069 \
        scc=0.000816972 m=(1)
C1 (D VSS) capacitor c=5.76857e-17
C2 (SN VSS) capacitor c=7.1228e-17
C3 (NW VSS) capacitor c=6.24921e-16
C4 (Q VSS) capacitor c=5.79928e-17
C5 (VDD VSS) capacitor c=4.16096e-17
C6 (RN VSS) capacitor c=2.4197e-17
C7 (QN VSS) capacitor c=4.17977e-17
C8 (Gb VSS) capacitor c=4.79479e-17
C9 (Gbb VSS) capacitor c=7.83962e-17
C10 (n5 VSS) capacitor c=7.09682e-17
C11 (net171 VSS) capacitor c=4.64568e-19
C12 (net167 VSS) capacitor c=1.12865e-18
C13 (Qint VSS) capacitor c=6.96054e-17
C14 (net159 VSS) capacitor c=1.73155e-18
C15 (Qbint VSS) capacitor c=1.44249e-16
C16 (net142 VSS) capacitor c=8.18643e-18
C17 (net103 VSS) capacitor c=6.10323e-17
C18 (\4\:Qint VSS) capacitor c=1.38598e-16
C19 (\1\:SN VSS) capacitor c=3.91672e-17
C20 (\3\:n5 VSS) capacitor c=2.64188e-17
C21 (\1\:G VSS) capacitor c=2.57718e-17
C22 (\1\:RN VSS) capacitor c=2.9705e-17
C23 (\5\:RN VSS) capacitor c=2.60194e-17
C24 (\4\:Gb VSS) capacitor c=3.22062e-17
C25 (\1\:D VSS) capacitor c=4.1062e-17
C26 (\3\:SN VSS) capacitor c=6.73079e-17
C27 (\3\:G VSS) capacitor c=3.79622e-17
C28 (\6\:RN VSS) capacitor c=3.01316e-17
C29 (\4\:RN VSS) capacitor c=4.46259e-17
C30 (\2\:Qint VSS) capacitor c=6.41278e-17
C31 (\6\:Gb VSS) capacitor c=3.74498e-17
C32 (\3\:Gbb VSS) capacitor c=2.8804e-17
C33 (\3\:D VSS) capacitor c=3.33713e-17
C34 (\3\:Gb VSS) capacitor c=2.25526e-17
C35 (\2\:SN VSS) capacitor c=5.14294e-17
C36 (\2\:n5 VSS) capacitor c=4.23495e-17
C37 (\2\:G VSS) capacitor c=3.33356e-17
C38 (\2\:RN VSS) capacitor c=3.31048e-17
C39 (\3\:Qint VSS) capacitor c=3.29455e-17
C40 (\7\:Gb VSS) capacitor c=3.25482e-17
C41 (\5\:Gb VSS) capacitor c=4.78009e-17
C42 (\2\:Gbb VSS) capacitor c=7.01816e-17
C43 (\2\:D VSS) capacitor c=4.46103e-17
C44 (\2\:Gb VSS) capacitor c=3.80814e-17
C45 (\1\:VDD VSS) capacitor c=4.68036e-16
C46 (\1\:Q VSS) capacitor c=6.635e-17
C47 (\11\:Qbint VSS) capacitor c=8.59004e-17
C48 (\1\:QN VSS) capacitor c=7.76938e-17
C49 (\17\:Qint VSS) capacitor c=9.95087e-17
C50 (\16\:VDD VSS) capacitor c=2.81022e-17
C51 (\10\:Gb VSS) capacitor c=1.98682e-16
C52 (\18\:VDD VSS) capacitor c=1.87007e-17
C53 (\20\:VDD VSS) capacitor c=2.2662e-17
C54 (\3\:net103 VSS) capacitor c=4.87589e-17
C55 (\5\:n5 VSS) capacitor c=2.46225e-16
C56 (\22\:VDD VSS) capacitor c=3.96641e-17
C57 (\6\:Gbb VSS) capacitor c=1.03048e-16
C58 (\3\:Q VSS) capacitor c=2.41995e-17
C59 (\9\:Qbint VSS) capacitor c=2.3429e-17
C60 (\4\:QN VSS) capacitor c=3.02786e-17
C61 (\20\:Qint VSS) capacitor c=1.5798e-16
C62 (\8\:Gb VSS) capacitor c=1.30095e-16
C63 (\7\:n5 VSS) capacitor c=1.01511e-16
C64 (\4\:Gbb VSS) capacitor c=6.30604e-17
C65 (\3\:RN VSS) capacitor c=3.8319e-17
C66 (\7\:Qint VSS) capacitor c=1.36769e-16
C67 (\4\:D VSS) capacitor c=6.35881e-17
C68 (\8\:Gbb VSS) capacitor c=1.06332e-16
C69 (\7\:RN VSS) capacitor c=8.09863e-17
C70 (\4\:G VSS) capacitor c=1.15245e-16
C71 (\12\:Gb VSS) capacitor c=1.63102e-16
C72 (\13\:Gb VSS) capacitor c=1.42381e-16
C73 (\14\:Gb VSS) capacitor c=8.97503e-17
C74 (\15\:Gb VSS) capacitor c=4.92092e-17
C75 (\4\:n5 VSS) capacitor c=2.15123e-16
C76 (\4\:SN VSS) capacitor c=4.61958e-17
C77 (\19\:Qint VSS) capacitor c=6.32249e-17
C78 (\22\:Qint VSS) capacitor c=1.76036e-16
C79 (\23\:Qint VSS) capacitor c=6.2424e-17
C80 (\3\:QN VSS) capacitor c=4.67064e-17
C81 (\7\:Qbint VSS) capacitor c=2.73479e-17
C82 (\8\:Qbint VSS) capacitor c=2.78082e-17
C83 (\6\:VDD VSS) capacitor c=6.43156e-17
C84 (\7\:VDD VSS) capacitor c=5.60671e-17
C85 (\8\:VDD VSS) capacitor c=7.61015e-17
C86 (\9\:VDD VSS) capacitor c=7.07015e-17
Rk1 (\4\:D D) resistor r=0.03569 c=0
Rk14 (SN \4\:SN) resistor r=0.09089 c=0
Rk25 (\2\:Q Q) resistor r=0.2486 c=0
Rk26 (Q \4\:Q) resistor r=0.1848 c=0
Rk6 (\4\:G G) resistor r=0.002999 c=0
Rk30 (\1\:VDD \6\:VDD) resistor r=0.2704 c=0
Rk31 (\6\:VDD \7\:VDD) resistor r=0.3581 c=0
Rk32 (\7\:VDD \8\:VDD) resistor r=0.1992 c=0
Rk34 (\9\:VDD VDD) resistor r=0.1951 c=0
Rk33 (\8\:VDD \9\:VDD) resistor r=0.5226 c=0
Rk38 (\6\:VDD \17\:VDD) resistor r=0.07369 c=0
Rk39 (\7\:VDD \19\:VDD) resistor r=0.07369 c=0
Rk40 (\8\:VDD \21\:VDD) resistor r=0.04329 c=0
Rk41 (\9\:VDD \23\:VDD) resistor r=0.2403 c=0
Rk5 (RN \7\:RN) resistor r=0.0693 c=0
Rk46 (\1\:VSS \8\:VSS) resistor r=0.664 c=0
Rk47 (\8\:VSS \9\:VSS) resistor r=0.3332 c=0
Rk49 (\10\:VSS VSS) resistor r=0.1374 c=0
Rk48 (\9\:VSS \10\:VSS) resistor r=0.4135 c=0
Rk53 (\8\:VSS \18\:VSS) resistor r=0.1255 c=0
Rk54 (\10\:VSS \20\:VSS) resistor r=0.2227 c=0
Rk21 (\3\:QN QN) resistor r=0.1142 c=0
Rk19 (\2\:QN \3\:QN) resistor r=0.3636 c=0
Rk20 (\3\:QN \5\:QN) resistor r=0.1296 c=0
Rk7 (\9\:Gb \11\:Gb) resistor r=0.8825 c=0
Rk8 (\11\:Gb \12\:Gb) resistor r=0.8648 c=0
Rk9 (\12\:Gb \13\:Gb) resistor r=0.8064 c=0
Rk10 (\13\:Gb \14\:Gb) resistor r=0.4937 c=0
Rk11 (\13\:Gb \15\:Gb) resistor r=0.2247 c=0
Rk2 (\5\:Gbb \7\:Gbb) resistor r=0.5506 c=0
Rk3 (\7\:Gbb \8\:Gbb) resistor r=0.7063 c=0
Rk12 (\4\:n5 \6\:n5) resistor r=1.7248 c=0
Rk13 (\6\:n5 \8\:n5) resistor r=0.5673 c=0
Rk15 (\18\:Qint \19\:Qint) resistor r=0.424 c=0
Rk16 (\19\:Qint \21\:Qint) resistor r=0.1339 c=0
Rk17 (\21\:Qint \22\:Qint) resistor r=1.3928 c=0
Rk18 (\19\:Qint \23\:Qint) resistor r=0.2844 c=0
Rk22 (\7\:Qbint \8\:Qbint) resistor r=0.1625 c=0
Rk23 (\8\:Qbint \10\:Qbint) resistor r=0.1341 c=0
Rk24 (\8\:Qbint \12\:Qbint) resistor r=0.2951 c=0
Rk4 (\2\:net103 \4\:net103) resistor r=0.2339 c=0
Rl3 (\1\:D \2\:D) resistor r=96.8456 c=0
Rl4 (\2\:D \3\:D) resistor r=89.1533 c=0
Rl20 (\1\:SN \2\:SN) resistor r=55.0021 c=0
Rl21 (\2\:SN \3\:SN) resistor r=76.1559 c=0
Rl16 (\1\:G \2\:G) resistor r=59.6154 c=0
Rl17 (\2\:G \3\:G) resistor r=139.56 c=0
Rl11 (\1\:RN \2\:RN) resistor r=71.4298 c=0
Rl14 (\2\:RN \5\:RN) resistor r=24.2328 c=0
Rl15 (\3\:RN \6\:RN) resistor r=90.3625 c=0
Rl13 (\3\:RN \4\:RN) resistor r=65.3625 c=0
Rl12 (\2\:RN \3\:RN) resistor r=125.837 c=0
Rl8 (\6\:Gb \7\:Gb) resistor r=67.9995 c=0
Rl5 (\4\:Gb \5\:Gb) resistor r=63.7124 c=0
Rl1 (Gb \2\:Gb) resistor r=157.692 c=0
Rl2 (\2\:Gb \3\:Gb) resistor r=29.9451 c=0
Rl6 (Gbb \2\:Gbb) resistor r=236.093 c=0
Rl7 (\2\:Gbb \3\:Gbb) resistor r=80.0021 c=0
Rl19 (\2\:n5 \3\:n5) resistor r=24.2328 c=0
Rl18 (n5 \2\:n5) resistor r=176.477 c=0
Rl9 (\2\:Qint Qint) resistor r=223.077 c=0
Rl10 (\3\:Qint \2\:Qint) resistor r=24.2328 c=0
Rl24 (\7\:Qint \4\:Qint) resistor r=72.348 c=0
Rz7 (\4\:Q \3\:Q) resistor r=75 c=0
Rz12 (\18\:VSS \17\:VSS) resistor r=75 c=0
Rz13 (\20\:VSS \19\:VSS) resistor r=75 c=0
Rz5 (\5\:QN \4\:QN) resistor r=75 c=0
Rz2 (\8\:Gb \9\:Gb) resistor r=75 c=0
Rz1 (\4\:Gbb \5\:Gbb) resistor r=75 c=0
Rz3 (\7\:n5 \8\:n5) resistor r=75 c=0
Rz4 (\21\:Qint \20\:Qint) resistor r=75 c=0
Rz6 (\10\:Qbint \9\:Qbint) resistor r=75 c=0
Ry9 (\2\:Q \1\:Q) resistor r=20.6667 c=0
Ry14 (\17\:VDD \16\:VDD) resistor r=62 c=0
Ry15 (\19\:VDD \18\:VDD) resistor r=62 c=0
Ry16 (\21\:VDD \20\:VDD) resistor r=62 c=0
Ry17 (\23\:VDD \22\:VDD) resistor r=62 c=0
Ry18 (\1\:VSS \5\:VSS) resistor r=5.1667 c=0
Ry19 (\9\:VSS \5\:VSS) resistor r=5.1667 c=0
Ry7 (\2\:QN \1\:QN) resistor r=20.6667 c=0
Ry4 (\10\:Gb \11\:Gb) resistor r=62 c=0
Ry1 (\6\:Gbb \7\:Gbb) resistor r=62 c=0
Ry5 (\5\:n5 \6\:n5) resistor r=62 c=0
Ry6 (\18\:Qint \17\:Qint) resistor r=31 c=0
Ry8 (\12\:Qbint \11\:Qbint) resistor r=20.6667 c=0
Ry2 (net103 \2\:net103) resistor r=62 c=0
Ry3 (\3\:net103 \4\:net103) resistor r=62 c=0
Rx1 (\2\:D \4\:D) resistor r=45 c=0
Rx9 (\2\:SN \4\:SN) resistor r=45 c=0
Rx4 (\2\:G \4\:G) resistor r=45 c=0
Rx3 (\2\:RN \7\:RN) resistor r=45 c=0
Rx5 (\7\:Gb \12\:Gb) resistor r=45 c=0
Rx6 (\2\:Gb \14\:Gb) resistor r=45 c=0
Rx7 (\5\:Gb \15\:Gb) resistor r=45 c=0
Rx2 (\2\:Gbb \8\:Gbb) resistor r=45 c=0
Rx8 (\2\:n5 \4\:n5) resistor r=45 c=0
Rx10 (\22\:Qint \3\:Qint) resistor r=45 c=0
Rx11 (\23\:Qint \7\:Qint) resistor r=45 c=0
Rx12 (\7\:Qbint Qbint) resistor r=45 c=0
mn2 (\4\:Gbb \3\:Gb \19\:VSS VSS) g45n1svt w=(1.45e-07) l=4.5e-08 nf=1 \
        as=3.988e-14 ad=2.465e-14 ps=8.4e-07 pd=6.3e-07 nrd=1.16667 \
        nrs=1.16667 sa=1.7e-07 sb=2e-06 sd=160n sca=8.15925 scb=0.00587019 \
        scc=8.94977e-05 m=(1)
mn5 (net191 \3\:D \19\:VSS VSS) g45n1svt w=(1.45e-07) l=4.5e-08 nf=1 \
        as=3.987e-14 ad=3.335e-14 ps=8.4e-07 pd=7.5e-07 nrd=1.16667 \
        nrs=1.16667 sa=4.9e-07 sb=1.78e-06 sd=160n sca=8.15925 \
        scb=0.00587019 scc=8.94977e-05 m=(1)
mn6 (\7\:n5 \3\:Gbb net191 VSS) g45n1svt w=(1.45e-07) l=4.5e-08 nf=1 \
        as=3.335e-14 ad=5.8e-14 ps=7.5e-07 pd=1.09e-06 nrd=1.16667 \
        nrs=1.16667 sa=7.65e-07 sb=1.505e-06 sd=160n sca=8.15925 \
        scb=0.00587019 scc=8.94977e-05 m=(1)
mn17 (\7\:n5 \6\:Gb net171 VSS) g45n1svt w=(1.45e-07) l=4.5e-08 nf=1 \
        as=3.045e-14 ad=5.8e-14 ps=7.1e-07 pd=1.09e-06 nrd=1.16667 \
        nrs=1.16667 sa=1.21e-06 sb=1.06e-06 sd=160n sca=8.15925 \
        scb=0.00587019 scc=8.94977e-05 m=(1)
mn16 (net171 \2\:Qint net167 VSS) g45n1svt w=(1.45e-07) l=4.5e-08 nf=1 \
        as=8.7e-15 ad=3.045e-14 ps=4.1e-07 pd=7.1e-07 nrd=1.16667 \
        nrs=1.16667 sa=1.465e-06 sb=8.05e-07 sd=160n sca=8.15925 \
        scb=0.00587019 scc=8.94977e-05 m=(1)
mn15 (net167 \4\:RN \17\:VSS VSS) g45n1svt w=(1.45e-07) l=4.5e-08 nf=1 \
        as=4.99e-14 ad=8.7e-15 ps=1.03e-06 pd=4.1e-07 nrd=1.16667 \
        nrs=1.16667 sa=1.57e-06 sb=7e-07 sd=160n sca=8.15925 \
        scb=0.00587019 scc=8.94977e-05 m=(1)
mn0 (net159 \6\:RN \17\:VSS VSS) g45n1svt w=(1.45e-07) l=4.5e-08 nf=1 \
        as=4.99e-14 ad=3.625e-14 ps=1.03e-06 pd=7.9e-07 nrd=1.16667 \
        nrs=1.16667 sa=1.835e-06 sb=4.35e-07 sd=160n sca=8.15925 \
        scb=0.00587019 scc=8.94977e-05 m=(1)
mn1 (\8\:Gb \3\:G net159 VSS) g45n1svt w=(1.45e-07) l=4.5e-08 nf=1 \
        as=3.625e-14 ad=2.03e-14 ps=7.9e-07 pd=5.7e-07 nrd=1.16667 \
        nrs=1.16667 sa=2e-06 sb=1.4e-07 sd=160n sca=8.15925 scb=0.00587019 \
        scc=8.94977e-05 m=(1)
mn11 (\20\:Qint n5 net183 VSS) g45n1svt w=(2.05e-07) l=4.5e-08 nf=1 \
        as=1.23e-14 ad=2.87e-14 ps=5.3e-07 pd=6.9e-07 nrd=1.16667 \
        nrs=1.16667 sa=1.4e-07 sb=1.565e-06 sd=160n sca=15.0894 \
        scb=0.0156086 scc=0.00108313 m=(1)
mn10 (net183 \3\:SN \1\:VSS VSS) g45n1svt w=(2.05e-07) l=4.5e-08 nf=1 \
        as=5.06e-14 ad=1.23e-14 ps=9.6e-07 pd=5.3e-07 nrd=1.16667 \
        nrs=1.16667 sa=2.45e-07 sb=1.46e-06 sd=160n sca=15.0894 \
        scb=0.0156086 scc=0.00108313 m=(1)
mn20_1__rcx (\9\:Qbint \4\:Qint \1\:VSS VSS) g45n1svt w=(2.6e-07) \
        l=4.5e-08 nf=1 as=4.16e-14 ad=4.16e-14 ps=8.4e-07 pd=8.4e-07 \
        nrd=1.16667 nrs=1.16667 sa=8.63269e-07 sb=7.55e-07 sd=160n \
        sca=13.5771 scb=0.0135427 scc=0.000870653 m=(2)
mn21_1__rcx (\3\:Q Qbint \1\:VSS VSS) g45n1svt w=(2.6e-07) l=4.5e-08 \
        nf=1 as=3.9e-14 ad=4.16e-14 ps=8.2e-07 pd=8.4e-07 nrd=1.16667 \
        nrs=1.16667 sa=1.27327e-06 sb=3.45e-07 sd=160n sca=13.5771 \
        scb=0.0135427 scc=0.000870653 m=(2)
mn22 (\4\:QN \7\:Qint \1\:VSS VSS) g45n1svt w=(2.6e-07) l=4.5e-08 nf=1 \
        as=4.61e-14 ad=4.94e-14 ps=9e-07 pd=9e-07 nrd=1.16667 nrs=1.16667 \
        sa=4.23269e-07 sb=1.195e-06 sd=160n sca=13.5771 scb=0.0135427 \
        scc=0.000870653 m=(2)
mp11 (\17\:Qint \3\:n5 \16\:VDD NW) g45p1svt w=(3.1e-07) l=4.5e-08 nf=1 \
        as=1.2245e-13 ad=8.06e-14 ps=2.17e-06 pd=1.14e-06 nrd=1.16667 \
        nrs=1.16667 sa=9.21855e-07 sb=1.765e-06 sd=160n sca=13.3668 \
        scb=0.0122284 scc=0.000582667 m=(1)
mp10 (\17\:Qint \1\:SN \1\:VDD NW) g45p1svt w=(3.1e-07) l=4.5e-08 nf=1 \
        as=8.55e-14 ad=8.06e-14 ps=1.28e-06 pd=1.14e-06 nrd=1.16667 \
        nrs=1.16667 sa=1.22685e-06 sb=1.46e-06 sd=160n sca=13.3668 \
        scb=0.0122284 scc=0.000582667 m=(1)
mp20 (\11\:Qbint \4\:Qint \1\:VDD NW) g45p1svt w=(3.9e-07) l=4.5e-08 \
        nf=1 as=6.24e-14 ad=6.24e-14 ps=1.1e-06 pd=1.1e-06 nrd=1.16667 \
        nrs=1.16667 sa=1.47756e-06 sb=7.55e-07 sd=160n sca=18.3796 \
        scb=0.0159892 scc=0.00159615 m=(2)
mp22 (\1\:QN \7\:Qint \1\:VDD NW) g45p1svt w=(3.9e-07) l=4.5e-08 nf=1 \
        as=7.395e-14 ad=6.24e-14 ps=1.19e-06 pd=1.1e-06 nrd=1.16667 \
        nrs=1.16667 sa=1.23019e-06 sb=1.165e-06 sd=160n sca=18.3796 \
        scb=0.0159892 scc=0.00159615 m=(2)
mp21_1__rcx (\1\:Q Qbint \1\:VDD NW) g45p1svt w=(3.9e-07) l=4.5e-08 nf=1 \
        as=5.85e-14 ad=6.24e-14 ps=1.08e-06 pd=1.1e-06 nrd=1.16667 \
        nrs=1.16667 sa=1.66154e-06 sb=3.45e-07 sd=160n sca=19.7386 \
        scb=0.0168744 scc=0.00159746 m=(2)
ends TLATSRX2
// End of subcircuit definition.
