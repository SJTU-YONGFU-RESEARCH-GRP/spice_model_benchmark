// Generated for: spectre (May  1 11:28:01 2013 )
// Library name: gsclib045_backbias
// Cell name: BUFX12
// View name: extracted

simulator lang=spectre

subckt BUFX12 A NW VDD VSS Y
mp1_1__rcx (\1\:Y n0 VDD NW) g45p1svt w=(4.7e-07) l=4.5e-08 nf=1 \
        as=7.378e-14 ad=7.52e-14 ps=1.256e-06 pd=1.26e-06 nrd=1.16667 \
        nrs=1.16667 sa=1.4e-07 sb=1.99064e-06 sd=160n sca=28.0481 \
        scb=0.031636 scc=0.00223037 m=(10)
C1 (NW VSS) capacitor c=3.56701e-16
C2 (VDD VSS) capacitor c=8.09827e-16
C3 (A VSS) capacitor c=4.04101e-17
C4 (Y VSS) capacitor c=1.56108e-17
C5 (n0 VSS) capacitor c=9.05359e-16
C6 (\1\:A VSS) capacitor c=2.43962e-16
C7 (\31\:n0 VSS) capacitor c=1.67709e-16
C8 (\1\:Y VSS) capacitor c=5.38119e-16
C9 (\15\:Y VSS) capacitor c=6.38119e-16
C10 (\10\:A VSS) capacitor c=4.06222e-17
C11 (\34\:n0 VSS) capacitor c=4.23734e-17
C12 (\42\:n0 VSS) capacitor c=1.64777e-16
Rk43 (\2\:VSS VSS) resistor r=0.06759 c=0
Rk19 (A \10\:A) resistor r=0.09983 c=0
Rk5 (\1\:Y Y) resistor r=0.1468 c=0
Rk10 (Y \15\:Y) resistor r=0.1717 c=0
Rk22 (\34\:n0 n0) resistor r=0.3289 c=0
Rk21 (\31\:n0 \34\:n0) resistor r=0.2235 c=0
Rk28 (\34\:n0 \42\:n0) resistor r=0.08258 c=0
Ry16 (VSS \1\:VSS) resistor r=5.1667 c=0
Ry15 (\2\:VSS \1\:VSS) resistor r=20.6667 c=0
Rx1 (\10\:A \1\:A) resistor r=45 c=0
mn1_1__rcx (VSS n0 \15\:Y VSS) g45n1svt w=(3.1e-07) l=4.5e-08 nf=1 \
        as=4.96e-14 ad=4.868e-14 ps=9.4e-07 pd=9.36e-07 nrd=1.16667 \
        nrs=1.16667 sa=1.4e-07 sb=1.99113e-06 sd=160n sca=9.61806 \
        scb=0.00827687 scc=0.000298696 m=(10)
mn0_1__rcx (VSS \1\:A \42\:n0 VSS) g45n1svt w=(2.6e-07) l=4.5e-08 nf=1 \
        as=3.987e-14 ad=4.327e-14 ps=8.2667e-07 pd=8.7333e-07 nrd=1.16667 \
        nrs=1.16667 sa=2e-06 sb=5.5e-07 sd=160n sca=10.3222 scb=0.00938145 \
        scc=0.000353946 m=(3)
mp0_1__rcx (\31\:n0 \1\:A VDD NW) g45p1svt w=(3.9e-07) l=4.5e-08 nf=1 \
        as=6.507e-14 ad=5.98e-14 ps=1.15333e-06 pd=1.08667e-06 nrd=1.16667 \
        nrs=1.16667 sa=2e-06 sb=5.5e-07 sd=160n sca=12.5423 scb=0.0105189 \
        scc=0.000333341 m=(3)
ends BUFX12
// End of subcircuit definition.
