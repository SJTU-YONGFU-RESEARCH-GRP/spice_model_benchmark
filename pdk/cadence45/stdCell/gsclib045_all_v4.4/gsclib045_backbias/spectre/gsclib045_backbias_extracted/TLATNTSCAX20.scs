// Generated for: spectre (May  1 11:33:28 2013 )
// Library name: gsclib045_backbias
// Cell name: TLATNTSCAX20
// View name: extracted

simulator lang=spectre

subckt TLATNTSCAX20 CK E ECK NW SE VDD VSS
mp1 (\8\:Eb \1\:E net246 NW) g45p1svt w=(2.15e-07) l=4.5e-08 nf=1 \
        as=1.29e-14 ad=3.01e-14 ps=5.5e-07 pd=7.1e-07 nrd=1.16667 \
        nrs=1.16667 sa=1.4e-07 sb=4.8e-07 sd=160n sca=48.9651 \
        scb=0.0318882 scc=0.00591085 m=(1)
mp0 (net246 \1\:SE \49\:VDD NW) g45p1svt w=(2.15e-07) l=4.5e-08 nf=1 \
        as=4.085e-14 ad=1.29e-14 ps=8.1e-07 pd=5.5e-07 nrd=1.16667 \
        nrs=1.16667 sa=2.45e-07 sb=3.75e-07 sd=160n sca=47.6387 \
        scb=0.0298205 scc=0.00588813 m=(1)
mp2 (\11\:CKb \3\:CK \49\:VDD NW) g45p1svt w=(2.15e-07) l=4.5e-08 nf=1 \
        as=4.085e-14 ad=3.01e-14 ps=8.1e-07 pd=7.1e-07 nrd=1.16667 \
        nrs=1.16667 sa=4.8e-07 sb=1.4e-07 sd=160n sca=46.2776 \
        scb=0.0284965 scc=0.00588421 m=(1)
mp5 (\13\:n5 \3\:CKbb Eb NW) g45p1svt w=(2.15e-07) l=4.5e-08 nf=1 \
        as=6.128e-14 ad=3.44e-14 ps=1e-06 pd=7.5e-07 nrd=1.16667 \
        nrs=1.16667 sa=2.85e-07 sb=6.30233e-07 sd=160n sca=19.7413 \
        scb=0.019281 scc=0.00179464 m=(1)
mp16 (\13\:n5 \3\:CKb net234 NW) g45p1svt w=(2.15e-07) l=4.5e-08 nf=1 \
        as=1.505e-14 ad=3.44e-14 ps=5.7e-07 pd=7.5e-07 nrd=1.16667 \
        nrs=1.16667 sa=4.9e-07 sb=4.25233e-07 sd=160n sca=19.7413 \
        scb=0.019281 scc=0.00179464 m=(1)
mp15 (net234 Eint \47\:VDD NW) g45p1svt w=(2.15e-07) l=4.5e-08 nf=1 \
        as=8.595e-14 ad=1.505e-14 ps=1.61e-06 pd=5.7e-07 nrd=1.16667 \
        nrs=1.16667 sa=6.05e-07 sb=3.10233e-07 sd=160n sca=19.7413 \
        scb=0.019281 scc=0.00179464 m=(1)
mp3 (\23\:CKbb \5\:CKb \47\:VDD NW) g45p1svt w=(2.15e-07) l=4.5e-08 nf=1 \
        as=8.595e-14 ad=2.71e-14 ps=1.61e-06 pd=7.1e-07 nrd=1.16667 \
        nrs=1.16667 sa=5.77674e-07 sb=1.26047e-07 sd=160n sca=45.7906 \
        scb=0.0283307 scc=0.00588417 m=(1)
C1 (NW VSS) capacitor c=1.01257e-15
C2 (CK VSS) capacitor c=6.25885e-17
C3 (SE VSS) capacitor c=5.79578e-17
C4 (E VSS) capacitor c=4.98465e-17
C5 (VDD VSS) capacitor c=4.95353e-17
C6 (ECK VSS) capacitor c=1.62351e-15
C7 (Eb VSS) capacitor c=9.97873e-17
C8 (CKb VSS) capacitor c=3.57516e-17
C9 (n5 VSS) capacitor c=3.56879e-16
C10 (net263 VSS) capacitor c=1.50435e-18
C11 (CKbb VSS) capacitor c=5.9076e-17
C12 (Eint VSS) capacitor c=5.86006e-17
C13 (ECKb VSS) capacitor c=7.91243e-16
C14 (18 VSS) capacitor c=1.72384e-18
C15 (19 VSS) capacitor c=1.72384e-18
C16 (20 VSS) capacitor c=1.72384e-18
C17 (21 VSS) capacitor c=2.10413e-18
C18 (net246 VSS) capacitor c=2.36136e-18
C19 (net234 VSS) capacitor c=1.23525e-18
C20 (\5\:CKb VSS) capacitor c=4.1108e-17
C21 (\3\:CKb VSS) capacitor c=6.52652e-17
C22 (\3\:CKbb VSS) capacitor c=4.42127e-17
C23 (\3\:CK VSS) capacitor c=2.51866e-17
C24 (\1\:SE VSS) capacitor c=5.40373e-17
C25 (\1\:E VSS) capacitor c=6.11667e-17
C26 (\19\:CKbb VSS) capacitor c=8.15055e-17
C27 (\18\:Eint VSS) capacitor c=4.93281e-17
C28 (\16\:Eint VSS) capacitor c=6.54334e-17
C29 (\15\:CKbb VSS) capacitor c=5.97292e-17
C30 (\14\:CKbb VSS) capacitor c=6.1427e-17
C31 (\11\:Eint VSS) capacitor c=4.89386e-17
C32 (\10\:Eint VSS) capacitor c=4.82017e-17
C33 (\5\:CKbb VSS) capacitor c=6.27606e-17
C34 (\9\:CKbb VSS) capacitor c=3.91468e-17
C35 (\4\:Eint VSS) capacitor c=4.35826e-17
C36 (\6\:CKb VSS) capacitor c=5.11055e-17
C37 (\3\:Eint VSS) capacitor c=6.79367e-17
C38 (\1\:CK VSS) capacitor c=2.90938e-17
C39 (\3\:SE VSS) capacitor c=3.0378e-17
C40 (\4\:E VSS) capacitor c=2.47304e-17
C41 (\19\:ECKb VSS) capacitor c=1.69109e-17
C42 (\5\:Eint VSS) capacitor c=7.30874e-16
C43 (\7\:CKb VSS) capacitor c=1.9226e-17
C44 (\2\:Eint VSS) capacitor c=7.10848e-17
C45 (\4\:CKbb VSS) capacitor c=3.39835e-17
C46 (\4\:CKb VSS) capacitor c=3.31032e-17
C47 (\2\:CKb VSS) capacitor c=2.74564e-17
C48 (\2\:CK VSS) capacitor c=2.66919e-17
C49 (\2\:SE VSS) capacitor c=3.58506e-17
C50 (\3\:E VSS) capacitor c=1.44707e-17
C51 (\1\:VDD VSS) capacitor c=1.82694e-15
C52 (\53\:ECKb VSS) capacitor c=5.87701e-16
C53 (\27\:Eint VSS) capacitor c=4.19547e-17
C54 (\23\:CKbb VSS) capacitor c=1.88083e-16
C55 (\47\:VDD VSS) capacitor c=3.4379e-17
C56 (\13\:n5 VSS) capacitor c=1.00332e-16
C57 (\11\:CKb VSS) capacitor c=1.26642e-16
C58 (\49\:VDD VSS) capacitor c=5.8745e-17
C59 (\8\:Eb VSS) capacitor c=7.12659e-17
C60 (\62\:ECKb VSS) capacitor c=8.77729e-17
C61 (\70\:ECKb VSS) capacitor c=1.16696e-16
C62 (\72\:ECKb VSS) capacitor c=7.47248e-17
C63 (\23\:Eint VSS) capacitor c=2.91131e-17
C64 (\26\:CKbb VSS) capacitor c=9.38121e-17
C65 (\11\:n5 VSS) capacitor c=1.95782e-16
C66 (\6\:Eb VSS) capacitor c=2.30057e-17
C67 (\15\:CKb VSS) capacitor c=1.21505e-16
C68 (\4\:Eb VSS) capacitor c=1.46266e-16
C69 (\2\:E VSS) capacitor c=2.47457e-17
C70 (\2\:CKbb VSS) capacitor c=3.99096e-17
C71 (\6\:CKbb VSS) capacitor c=8.64087e-16
C72 (\5\:E VSS) capacitor c=4.45731e-17
C73 (\4\:SE VSS) capacitor c=5.96068e-17
C74 (\4\:CK VSS) capacitor c=6.28934e-17
C75 (\3\:Eb VSS) capacitor c=1.40878e-16
C76 (\8\:CKb VSS) capacitor c=4.03982e-17
C77 (\9\:CKb VSS) capacitor c=6.19401e-17
C78 (\10\:CKb VSS) capacitor c=1.06708e-16
C79 (\13\:CKb VSS) capacitor c=2.89204e-17
C80 (\14\:CKb VSS) capacitor c=9.2195e-17
C81 (\22\:Eint VSS) capacitor c=5.31698e-17
C82 (\25\:Eint VSS) capacitor c=9.33335e-17
C83 (\26\:Eint VSS) capacitor c=9.25399e-17
C84 (\25\:CKbb VSS) capacitor c=1.41925e-16
C85 (\61\:ECKb VSS) capacitor c=6.86157e-17
C86 (\17\:VDD VSS) capacitor c=9.45658e-17
C87 (\18\:VDD VSS) capacitor c=1.04237e-16
Rk111 (\1\:VSS \13\:VSS) resistor r=0.3359 c=0
Rk112 (\13\:VSS \14\:VSS) resistor r=0.3108 c=0
Rk113 (\14\:VSS \15\:VSS) resistor r=0.09767 c=0
Rk114 (\15\:VSS \16\:VSS) resistor r=0.2307 c=0
Rk116 (\16\:VSS \18\:VSS) resistor r=0.3811 c=0
Rk117 (\18\:VSS \19\:VSS) resistor r=0.3863 c=0
Rk118 (\19\:VSS \20\:VSS) resistor r=0.2649 c=0
Rk120 (\21\:VSS VSS) resistor r=0.03469 c=0
Rk119 (\20\:VSS \21\:VSS) resistor r=0.2496 c=0
Rk129 (\13\:VSS \39\:VSS) resistor r=0.1839 c=0
Rk130 (\14\:VSS \41\:VSS) resistor r=0.1839 c=0
Rk133 (\18\:VSS \47\:VSS) resistor r=0.1637 c=0
Rk134 (\20\:VSS \49\:VSS) resistor r=0.04335 c=0
Rk135 (\21\:VSS \51\:VSS) resistor r=0.3574 c=0
Rk3 (\4\:CK CK) resistor r=0.0284 c=0
Rk2 (\4\:SE SE) resistor r=0.07449 c=0
Rk1 (\5\:E E) resistor r=0.1753 c=0
Rk83 (\1\:VDD \17\:VDD) resistor r=0.1928 c=0
Rk85 (\18\:VDD VDD) resistor r=0.2856 c=0
Rk84 (\17\:VDD \18\:VDD) resistor r=0.6872 c=0
Rk100 (\17\:VDD \48\:VDD) resistor r=0.1858 c=0
Rk101 (\18\:VDD \50\:VDD) resistor r=0.4362 c=0
Rk4 (\2\:Eb \3\:Eb) resistor r=0.4377 c=0
Rk5 (\3\:Eb \5\:Eb) resistor r=0.8153 c=0
Rk6 (\3\:Eb \7\:Eb) resistor r=0.05787 c=0
Rk7 (\5\:Eb \9\:Eb) resistor r=0.3455 c=0
Rk8 (\8\:CKb \9\:CKb) resistor r=0.404 c=0
Rk9 (\9\:CKb \10\:CKb) resistor r=0.2456 c=0
Rk10 (\10\:CKb \12\:CKb) resistor r=0.5473 c=0
Rk11 (\9\:CKb \13\:CKb) resistor r=0.04543 c=0
Rk12 (\10\:CKb \14\:CKb) resistor r=0.4838 c=0
Rk13 (\12\:CKb \16\:CKb) resistor r=0.7966 c=0
Rk15 (n5 \12\:n5) resistor r=1.0206 c=0
Rk16 (\12\:n5 \14\:n5) resistor r=0.536 c=0
Rk26 (\6\:CKbb \24\:CKbb) resistor r=1.1642 c=0
Rk27 (\24\:CKbb \25\:CKbb) resistor r=0.5452 c=0
Rk28 (\25\:CKbb \27\:CKbb) resistor r=0.5838 c=0
Rk19 (\5\:Eint \22\:Eint) resistor r=0.2208 c=0
Rk20 (\22\:Eint \24\:Eint) resistor r=0.144 c=0
Rk21 (\22\:Eint \25\:Eint) resistor r=0.3088 c=0
Rk22 (\25\:Eint \26\:Eint) resistor r=0.5477 c=0
Rk23 (\25\:Eint \28\:Eint) resistor r=0.08721 c=0
Rk34 (\53\:ECKb \61\:ECKb) resistor r=0.3335 c=0
Rk35 (\61\:ECKb \63\:ECKb) resistor r=0.4448 c=0
Rk39 (\63\:ECKb \71\:ECKb) resistor r=0.4512 c=0
Rk40 (\71\:ECKb \73\:ECKb) resistor r=0.4717 c=0
Rl7 (\2\:CK \3\:CK) resistor r=29.9451 c=0
Rl6 (\1\:CK \2\:CK) resistor r=51.9231 c=0
Rl4 (\1\:SE \2\:SE) resistor r=50.6918 c=0
Rl5 (\2\:SE \3\:SE) resistor r=29.5379 c=0
Rl1 (\1\:E \2\:E) resistor r=115.362 c=0
Rl3 (\2\:E \4\:E) resistor r=34.2969 c=0
Rl2 (\2\:E \3\:E) resistor r=24.9253 c=0
Rl15 (\5\:CKb \6\:CKb) resistor r=121.154 c=0
Rl16 (\5\:CKb \7\:CKb) resistor r=24.2328 c=0
Rl9 (\3\:CKb \4\:CKb) resistor r=71.8456 c=0
Rl8 (CKb \2\:CKb) resistor r=43.855 c=0
Rl11 (\2\:CKbb \3\:CKbb) resistor r=137.971 c=0
Rl10 (\2\:CKbb CKbb) resistor r=78.3081 c=0
Rl12 (\2\:CKbb \4\:CKbb) resistor r=4.5402 c=0
Rl46 (\6\:CKbb \19\:CKbb) resistor r=171.506 c=0
Rl38 (\6\:CKbb \15\:CKbb) resistor r=107.374 c=0
Rl37 (\6\:CKbb \14\:CKbb) resistor r=135.031 c=0
Rl25 (\6\:CKbb \5\:CKbb) resistor r=141.817 c=0
Rl28 (\6\:CKbb \9\:CKbb) resistor r=111.923 c=0
Rl44 (\5\:Eint \18\:Eint) resistor r=35.7713 c=0
Rl42 (\5\:Eint \16\:Eint) resistor r=77.4625 c=0
Rl33 (\5\:Eint \11\:Eint) resistor r=37.6951 c=0
Rl32 (\5\:Eint \10\:Eint) resistor r=35.7713 c=0
Rl23 (\5\:Eint \4\:Eint) resistor r=37.2302 c=0
Rl13 (\2\:Eint Eint) resistor r=61.7959 c=0
Rl14 (\2\:Eint \3\:Eint) resistor r=115.642 c=0
Rl64 (ECKb \19\:ECKb) resistor r=9.5287 c=0
Rz28 (\39\:VSS \38\:VSS) resistor r=75 c=0
Rz29 (\41\:VSS \40\:VSS) resistor r=75 c=0
Rz32 (\47\:VSS \46\:VSS) resistor r=75 c=0
Rz33 (\49\:VSS \48\:VSS) resistor r=75 c=0
Rz34 (\51\:VSS \50\:VSS) resistor r=75 c=0
Rz1 (\4\:Eb \5\:Eb) resistor r=75 c=0
Rz2 (\6\:Eb \7\:Eb) resistor r=75 c=0
Rz3 (\15\:CKb \16\:CKb) resistor r=75 c=0
Rz4 (\12\:n5 \11\:n5) resistor r=75 c=0
Rz6 (\27\:CKbb \26\:CKbb) resistor r=75 c=0
Rz5 (\24\:Eint \23\:Eint) resistor r=75 c=0
Rz7 (\63\:ECKb \62\:ECKb) resistor r=75 c=0
Rz8 (\71\:ECKb \70\:ECKb) resistor r=75 c=0
Rz9 (\73\:ECKb \72\:ECKb) resistor r=75 c=0
Ry40 (\15\:VSS \1\:VSS) resistor r=5.1667 c=0
Ry41 (\19\:VSS \1\:VSS) resistor r=5.1667 c=0
Ry36 (\48\:VDD \47\:VDD) resistor r=62 c=0
Ry37 (\50\:VDD \49\:VDD) resistor r=62 c=0
Ry1 (Eb \2\:Eb) resistor r=62 c=0
Ry2 (\8\:Eb \9\:Eb) resistor r=62 c=0
Ry3 (\11\:CKb \12\:CKb) resistor r=62 c=0
Ry4 (\14\:n5 \13\:n5) resistor r=62 c=0
Ry6 (\24\:CKbb \23\:CKbb) resistor r=62 c=0
Ry5 (\28\:Eint \27\:Eint) resistor r=62 c=0
Rx3 (\2\:CK \4\:CK) resistor r=45 c=0
Rx2 (\2\:SE \4\:SE) resistor r=45 c=0
Rx1 (\3\:E \5\:E) resistor r=45 c=0
Rx4 (\7\:CKb \8\:CKb) resistor r=45 c=0
Rx5 (\4\:CKb \13\:CKb) resistor r=45 c=0
Rx6 (\2\:CKb \14\:CKb) resistor r=45 c=0
Rx16 (\25\:CKbb \4\:CKbb) resistor r=45 c=0
Rx12 (\26\:Eint \2\:Eint) resistor r=45 c=0
Rx17 (\61\:ECKb \19\:ECKb) resistor r=45 c=0
mn1 (\4\:Eb \4\:E \50\:VSS VSS) g45n1svt w=(1.45e-07) l=4.5e-08 nf=1 \
        as=2.03e-14 ad=3.19e-14 ps=5.7e-07 pd=7.3e-07 nrd=1.16667 \
        nrs=1.16667 sa=1.4e-07 sb=6.95e-07 sd=160n sca=17.8702 \
        scb=0.0189183 scc=0.00156031 m=(1)
mn0 (\4\:Eb \3\:SE \48\:VSS VSS) g45n1svt w=(1.45e-07) l=4.5e-08 nf=1 \
        as=8.353e-14 ad=3.19e-14 ps=1.58e-06 pd=7.3e-07 nrd=1.16667 \
        nrs=1.16667 sa=4.05e-07 sb=4.3e-07 sd=160n sca=17.8702 \
        scb=0.0189183 scc=0.00156031 m=(1)
mn2 (\15\:CKb \1\:CK \48\:VSS VSS) g45n1svt w=(1.45e-07) l=4.5e-08 nf=1 \
        as=8.353e-14 ad=2.03e-14 ps=1.58e-06 pd=5.7e-07 nrd=1.16667 \
        nrs=1.16667 sa=6.95e-07 sb=1.4e-07 sd=160n sca=17.8702 \
        scb=0.0189183 scc=0.00156031 m=(1)
mn5 (\6\:Eb CKb \11\:n5 VSS) g45n1svt w=(1.45e-07) l=4.5e-08 nf=1 \
        as=2.393e-14 ad=2.03e-14 ps=6.2e-07 pd=5.7e-07 nrd=1.16667 \
        nrs=1.16667 sa=1.4e-07 sb=6.29138e-07 sd=160n sca=9.33388 \
        scb=0.00788941 scc=0.00017958 m=(1)
mn16 (\11\:n5 CKbb net263 VSS) g45n1svt w=(1.45e-07) l=4.5e-08 nf=1 \
        as=8.7e-15 ad=2.393e-14 ps=4.1e-07 pd=6.2e-07 nrd=1.16667 \
        nrs=1.16667 sa=3.5e-07 sb=4.19138e-07 sd=160n sca=9.33388 \
        scb=0.00788941 scc=0.00017958 m=(1)
mn15 (net263 \3\:Eint \46\:VSS VSS) g45n1svt w=(1.45e-07) l=4.5e-08 nf=1 \
        as=5.53e-14 ad=8.7e-15 ps=1.29e-06 pd=4.1e-07 nrd=1.16667 \
        nrs=1.16667 sa=4.55e-07 sb=3.14138e-07 sd=160n sca=9.33388 \
        scb=0.00788941 scc=0.00017958 m=(1)
mn3 (\26\:CKbb \6\:CKb \46\:VSS VSS) g45n1svt w=(1.45e-07) l=4.5e-08 \
        nf=1 as=5.53e-14 ad=3.263e-14 ps=1.29e-06 pd=7.4e-07 nrd=1.16667 \
        nrs=1.16667 sa=3.57931e-07 sb=2.25e-07 sd=160n sca=13.9854 \
        scb=0.014728 scc=0.000819645 m=(1)
mn20_1__rcx (17 \4\:Eint \16\:VSS VSS) g45n1svt w=(2.6e-07) l=4.5e-08 \
        nf=1 as=4.16e-14 ad=3.25e-14 ps=8.4e-07 pd=7.7e-07 nrd=1.16667 \
        nrs=1.16667 sa=5.5e-07 sb=1.55e-06 sd=160n sca=8.36684 \
        scb=0.00633377 scc=0.000139167 m=(1)
mn21_1__rcx (\72\:ECKb \9\:CKbb 17 VSS) g45n1svt w=(2.6e-07) l=4.5e-08 \
        nf=1 as=3.25e-14 ad=4.16e-14 ps=7.7e-07 pd=8.4e-07 nrd=1.16667 \
        nrs=1.16667 sa=7.2e-07 sb=1.38e-06 sd=160n sca=8.36684 \
        scb=0.00633377 scc=0.000139167 m=(1)
mn21_2__rcx (\72\:ECKb \5\:CKbb 18 VSS) g45n1svt w=(2.6e-07) l=4.5e-08 \
        nf=1 as=1.56e-14 ad=4.16e-14 ps=6.4e-07 pd=8.4e-07 nrd=1.16667 \
        nrs=1.16667 sa=9.25e-07 sb=1.175e-06 sd=160n sca=8.36684 \
        scb=0.00633377 scc=0.000139167 m=(1)
mn20_2__rcx (18 \10\:Eint \40\:VSS VSS) g45n1svt w=(2.6e-07) l=4.5e-08 \
        nf=1 as=4.16e-14 ad=1.56e-14 ps=8.4e-07 pd=6.4e-07 nrd=1.16667 \
        nrs=1.16667 sa=1.03e-06 sb=1.07e-06 sd=160n sca=8.36684 \
        scb=0.00633377 scc=0.000139167 m=(1)
mn20_3__rcx (19 \11\:Eint \40\:VSS VSS) g45n1svt w=(2.6e-07) l=4.5e-08 \
        nf=1 as=4.16e-14 ad=1.56e-14 ps=8.4e-07 pd=6.4e-07 nrd=1.16667 \
        nrs=1.16667 sa=1.235e-06 sb=8.65e-07 sd=160n sca=8.36684 \
        scb=0.00633377 scc=0.000139167 m=(1)
mn21_3__rcx (\70\:ECKb \14\:CKbb 19 VSS) g45n1svt w=(2.6e-07) l=4.5e-08 \
        nf=1 as=1.56e-14 ad=4.16e-14 ps=6.4e-07 pd=8.4e-07 nrd=1.16667 \
        nrs=1.16667 sa=1.34e-06 sb=7.6e-07 sd=160n sca=8.36684 \
        scb=0.00633377 scc=0.000139167 m=(1)
mn21_4__rcx (\70\:ECKb \15\:CKbb 20 VSS) g45n1svt w=(2.6e-07) l=4.5e-08 \
        nf=1 as=1.56e-14 ad=4.16e-14 ps=6.4e-07 pd=8.4e-07 nrd=1.16667 \
        nrs=1.16667 sa=1.545e-06 sb=5.55e-07 sd=160n sca=8.36684 \
        scb=0.00633377 scc=0.000139167 m=(1)
mn20_4__rcx (20 \16\:Eint \38\:VSS VSS) g45n1svt w=(2.6e-07) l=4.5e-08 \
        nf=1 as=4.16e-14 ad=1.56e-14 ps=8.4e-07 pd=6.4e-07 nrd=1.16667 \
        nrs=1.16667 sa=1.65e-06 sb=4.5e-07 sd=160n sca=8.36684 \
        scb=0.00633377 scc=0.000139167 m=(1)
mn20 (21 \18\:Eint \38\:VSS VSS) g45n1svt w=(2.6e-07) l=4.5e-08 nf=1 \
        as=4.16e-14 ad=1.56e-14 ps=8.4e-07 pd=6.4e-07 nrd=1.16667 \
        nrs=1.16667 sa=1.855e-06 sb=2.45e-07 sd=160n sca=8.36684 \
        scb=0.00633377 scc=0.000139167 m=(1)
mn21 (\62\:ECKb \19\:CKbb 21 VSS) g45n1svt w=(2.6e-07) l=4.5e-08 nf=1 \
        as=1.56e-14 ad=3.64e-14 ps=6.4e-07 pd=8e-07 nrd=1.16667 \
        nrs=1.16667 sa=1.96e-06 sb=1.4e-07 sd=160n sca=8.36684 \
        scb=0.00633377 scc=0.000139167 m=(1)
mn10 (\23\:Eint n5 \16\:VSS VSS) g45n1svt w=(2.6e-07) l=4.5e-08 nf=1 \
        as=3.9e-14 ad=4.16e-14 ps=8.2e-07 pd=8.4e-07 nrd=1.16667 \
        nrs=1.16667 sa=1.4e-07 sb=1.96e-06 sd=160n sca=8.36684 \
        scb=0.00633377 scc=0.000139167 m=(2)
mn22_1__rcx (ECK ECKb \1\:VSS VSS) g45n1svt w=(3.05e-07) l=4.5e-08 nf=1 \
        as=4.844e-14 ad=4.844e-14 ps=9.2765e-07 pd=9.2765e-07 nrd=1.16667 \
        nrs=1.16667 sa=1.4e-07 sb=2e-06 sd=160n sca=16.121 scb=0.0155296 \
        scc=0.00139557 m=(17)
mp10 (\27\:Eint n5 \1\:VDD NW) g45p1svt w=(3.9e-07) l=4.5e-08 nf=1 \
        as=7.705e-14 ad=6.24e-14 ps=1.36e-06 pd=1.1e-06 nrd=1.16667 \
        nrs=1.16667 sa=1.08974e-07 sb=1.69577e-06 sd=160n sca=30.5009 \
        scb=0.0202006 scc=0.00336097 m=(2)
mp20_1__rcx (\53\:ECKb \5\:Eint \1\:VDD NW) g45p1svt w=(3.9e-07) \
        l=4.5e-08 nf=1 as=7.056e-14 ad=6.24e-14 ps=1.172e-06 pd=1.1e-06 \
        nrd=1.16667 nrs=1.16667 sa=5.42821e-07 sb=2e-06 sd=160n \
        sca=16.7336 scb=0.0149207 scc=0.00128056 m=(5)
mp21_1__rcx (\53\:ECKb \6\:CKbb \1\:VDD NW) g45p1svt w=(3.9e-07) \
        l=4.5e-08 nf=1 as=6.614e-14 ad=6.24e-14 ps=1.14e-06 pd=1.1e-06 \
        nrd=1.16667 nrs=1.16667 sa=7.47821e-07 sb=2e-06 sd=160n \
        sca=16.7336 scb=0.0149207 scc=0.00128056 m=(5)
mp22_1__rcx (ECK ECKb \1\:VDD NW) g45p1svt w=(4.6e-07) l=4.5e-08 nf=1 \
        as=7.405e-14 ad=7.36e-14 ps=1.24375e-06 pd=1.24e-06 nrd=1.16667 \
        nrs=1.16667 sa=1.71087e-06 sb=2e-06 sd=160n sca=27.3498 \
        scb=0.0181352 scc=0.00285625 m=(16)
mp22_16__rcx (ECK ECKb \1\:VDD NW) g45p1svt w=(4.55e-07) l=4.5e-08 nf=1 \
        as=7.33e-14 ad=6.37e-14 ps=1.24e-06 pd=1.19e-06 nrd=1.16667 \
        nrs=1.16667 sa=2e-06 sb=1.4e-07 sd=160n sca=33.0977 scb=0.0260038 \
        scc=0.00304396 m=(1)
ends TLATNTSCAX20
// End of subcircuit definition.
