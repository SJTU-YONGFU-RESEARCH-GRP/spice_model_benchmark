// Generated for: spectre (May  1 11:31:18 2013 )
// Library name: gsclib045_backbias
// Cell name: OAI211X4
// View name: extracted

simulator lang=spectre

subckt OAI211X4 A0 A1 B0 C0 NW VDD VSS Y
mp0_1__rcx (1 \1\:A0 \19\:VDD NW) g45p1svt w=(3.9e-07) l=4.5e-08 nf=1 \
        as=5.46e-14 ad=1.0335e-13 ps=1.06e-06 pd=1.31e-06 nrd=1.16667 \
        nrs=1.16667 sa=1.4e-07 sb=2e-06 sd=160n sca=24.4649 scb=0.024645 \
        scc=0.00179971 m=(1)
mp1_1__rcx (\9\:Y \5\:A1 1 NW) g45p1svt w=(3.9e-07) l=4.5e-08 nf=1 \
        as=1.0335e-13 ad=6.24e-14 ps=1.31e-06 pd=1.1e-06 nrd=1.16667 \
        nrs=1.16667 sa=4.5e-07 sb=2e-06 sd=160n sca=19.5407 scb=0.0166665 \
        scc=0.0015969 m=(1)
mp1_2__rcx (\9\:Y \1\:A1 5 NW) g45p1svt w=(3.9e-07) l=4.5e-08 nf=1 \
        as=3.9e-14 ad=6.24e-14 ps=9.8e-07 pd=1.1e-06 nrd=1.16667 \
        nrs=1.16667 sa=6.55e-07 sb=2e-06 sd=160n sca=18.6789 scb=0.0160714 \
        scc=0.00159617 m=(1)
mp0_2__rcx (5 \7\:A0 \17\:VDD NW) g45p1svt w=(3.9e-07) l=4.5e-08 nf=1 \
        as=6.24e-14 ad=3.9e-14 ps=1.1e-06 pd=9.8e-07 nrd=1.16667 \
        nrs=1.16667 sa=8e-07 sb=2e-06 sd=160n sca=18.3796 scb=0.0159892 \
        scc=0.00159615 m=(1)
mp0_3__rcx (3 \4\:A0 \17\:VDD NW) g45p1svt w=(3.9e-07) l=4.5e-08 nf=1 \
        as=6.24e-14 ad=2.34e-14 ps=1.1e-06 pd=9e-07 nrd=1.16667 \
        nrs=1.16667 sa=1.005e-06 sb=2e-06 sd=160n sca=18.3796 \
        scb=0.0159892 scc=0.00159615 m=(1)
mp1_3__rcx (\7\:Y \11\:A1 3 NW) g45p1svt w=(3.9e-07) l=4.5e-08 nf=1 \
        as=2.34e-14 ad=6.24e-14 ps=9e-07 pd=1.1e-06 nrd=1.16667 \
        nrs=1.16667 sa=1.11e-06 sb=2e-06 sd=160n sca=18.3796 scb=0.0159892 \
        scc=0.00159615 m=(1)
mp1 (\7\:Y \7\:A1 6 NW) g45p1svt w=(3.9e-07) l=4.5e-08 nf=1 as=4.485e-14 \
        ad=6.24e-14 ps=1.01e-06 pd=1.1e-06 nrd=1.16667 nrs=1.16667 \
        sa=1.315e-06 sb=2e-06 sd=160n sca=18.3796 scb=0.0159892 \
        scc=0.00159615 m=(1)
mp0 (6 \10\:A0 \1\:VDD NW) g45p1svt w=(3.9e-07) l=4.5e-08 nf=1 \
        as=8.58e-14 ad=4.485e-14 ps=1.22e-06 pd=1.01e-06 nrd=1.16667 \
        nrs=1.16667 sa=1.475e-06 sb=1.84e-06 sd=160n sca=18.3796 \
        scb=0.0159892 scc=0.00159615 m=(1)
mp3_1__rcx (\17\:Y C0 \1\:VDD NW) g45p1svt w=(3.9e-07) l=4.5e-08 nf=1 \
        as=6.045e-14 ad=6.24e-14 ps=1.09e-06 pd=1.1e-06 nrd=1.16667 \
        nrs=1.16667 sa=2e-06 sb=7.55e-07 sd=160n sca=18.3796 scb=0.0159892 \
        scc=0.00159615 m=(4)
mp2_1__rcx (Y B0 \1\:VDD NW) g45p1svt w=(3.9e-07) l=4.5e-08 nf=1 \
        as=6.825e-14 ad=6.24e-14 ps=1.13e-06 pd=1.1e-06 nrd=1.16667 \
        nrs=1.16667 sa=1.74e-06 sb=1.575e-06 sd=160n sca=18.3796 \
        scb=0.0159892 scc=0.00159615 m=(4)
C1 (B0 VSS) capacitor c=4.01851e-16
C2 (A0 VSS) capacitor c=1.85817e-17
C3 (Y VSS) capacitor c=3.0439e-16
C4 (NW VSS) capacitor c=4.58311e-16
C5 (C0 VSS) capacitor c=3.25457e-16
C6 (A1 VSS) capacitor c=4.34604e-16
C7 (VDD VSS) capacitor c=2.53371e-17
C8 (n0 VSS) capacitor c=2.05571e-16
C9 (n1 VSS) capacitor c=3.39171e-16
C10 (5 VSS) capacitor c=3.24837e-18
C11 (3 VSS) capacitor c=1.94902e-18
C12 (6 VSS) capacitor c=3.97122e-18
C13 (\10\:A0 VSS) capacitor c=6.09596e-17
C14 (\7\:A1 VSS) capacitor c=5.251e-17
C15 (\11\:A1 VSS) capacitor c=5.91911e-17
C16 (\4\:A0 VSS) capacitor c=7.73685e-17
C17 (\7\:A0 VSS) capacitor c=4.20583e-17
C18 (\1\:A1 VSS) capacitor c=5.8571e-17
C19 (\5\:A1 VSS) capacitor c=2.3106e-17
C20 (\1\:A0 VSS) capacitor c=3.39915e-17
C21 (\2\:A0 VSS) capacitor c=5.42918e-16
C22 (\1\:VDD VSS) capacitor c=4.7397e-16
C23 (\7\:Y VSS) capacitor c=1.11056e-16
C24 (\17\:VDD VSS) capacitor c=3.91937e-17
C25 (\9\:Y VSS) capacitor c=9.11103e-17
C26 (\19\:VDD VSS) capacitor c=3.10554e-17
C27 (\1\:Y VSS) capacitor c=2.36039e-16
C28 (\3\:n0 VSS) capacitor c=3.19787e-16
C29 (\5\:A0 VSS) capacitor c=2.59547e-17
C30 (\17\:Y VSS) capacitor c=1.49655e-16
C31 (\7\:VDD VSS) capacitor c=7.84849e-17
C32 (\8\:VDD VSS) capacitor c=4.81473e-17
Rk5 (\2\:A0 A0) resistor r=0.09652 c=0
Rk45 (\2\:VSS VSS) resistor r=0.6891 c=0
Rk16 (\1\:Y Y) resistor r=1.127 c=0
Rk17 (Y \8\:Y) resistor r=0.3902 c=0
Rk18 (\8\:Y \10\:Y) resistor r=0.5044 c=0
Rk19 (\10\:Y \11\:Y) resistor r=0.1464 c=0
Rk24 (\8\:Y \16\:Y) resistor r=0.1464 c=0
Rk25 (Y \17\:Y) resistor r=0.3091 c=0
Rk36 (\1\:VDD \7\:VDD) resistor r=0.338 c=0
Rk38 (\8\:VDD VDD) resistor r=0.0572 c=0
Rk37 (\7\:VDD \8\:VDD) resistor r=0.4332 c=0
Rk43 (\7\:VDD \18\:VDD) resistor r=0.2632 c=0
Rk44 (\8\:VDD \20\:VDD) resistor r=0.3314 c=0
Rk8 (n0 \3\:n0) resistor r=0.4755 c=0
Rl18 (\2\:A0 \10\:A0) resistor r=91.0764 c=0
Rl1 (\2\:A0 \1\:A0) resistor r=87.6944 c=0
Rl8 (\5\:A0 \4\:A0) resistor r=82.1768 c=0
Rl10 (\5\:A0 \7\:A0) resistor r=38.0255 c=0
Rl9 (\5\:A0 \2\:A0) resistor r=23.0585 c=0
Rl13 (A1 \7\:A1) resistor r=85.3597 c=0
Rl16 (A1 \11\:A1) resistor r=25.3108 c=0
Rl3 (A1 \1\:A1) resistor r=75.2759 c=0
Rl6 (A1 \5\:A1) resistor r=28.079 c=0
Ry18 (VSS \1\:VSS) resistor r=5.1667 c=0
Ry17 (\2\:VSS \1\:VSS) resistor r=8.8571 c=0
Ry2 (\8\:Y \7\:Y) resistor r=62 c=0
Ry3 (\10\:Y \9\:Y) resistor r=62 c=0
Ry4 (\11\:Y \9\:Y) resistor r=62 c=0
Ry7 (\16\:Y \7\:Y) resistor r=62 c=0
Ry15 (\18\:VDD \17\:VDD) resistor r=62 c=0
Ry16 (\20\:VDD \19\:VDD) resistor r=31 c=0
mn2_1__rcx (n1 B0 n0 VSS) g45n1svt w=(2.6e-07) l=4.5e-08 nf=1 as=4.16e-14 \
        ad=4.518e-14 ps=8.4e-07 pd=8.675e-07 nrd=1.16667 nrs=1.16667 \
        sa=1.55e-07 sb=1.605e-06 sd=160n sca=10.3222 scb=0.00938145 \
        scc=0.000353946 m=(4)
mn0_1__rcx (\3\:n0 \2\:A0 VSS VSS) g45n1svt w=(2.6e-07) l=4.5e-08 nf=1 \
        as=3.9e-14 ad=4.16e-14 ps=8.2e-07 pd=8.4e-07 nrd=1.16667 \
        nrs=1.16667 sa=1.4e-07 sb=1.575e-06 sd=160n sca=10.3222 \
        scb=0.00938145 scc=0.000353946 m=(4)
mn1_1__rcx (\3\:n0 A1 VSS VSS) g45n1svt w=(2.6e-07) l=4.5e-08 nf=1 \
        as=4.16e-14 ad=4.16e-14 ps=8.4e-07 pd=8.4e-07 nrd=1.16667 \
        nrs=1.16667 sa=3.45e-07 sb=1.37e-06 sd=160n sca=10.3222 \
        scb=0.00938145 scc=0.000353946 m=(4)
mn3_1__rcx (\1\:Y C0 n1 VSS) g45n1svt w=(2.6e-07) l=4.5e-08 nf=1 \
        as=4.03e-14 ad=4.16e-14 ps=8.3e-07 pd=8.4e-07 nrd=1.16667 \
        nrs=1.16667 sa=1.005e-06 sb=7.55e-07 sd=160n sca=10.3222 \
        scb=0.00938145 scc=0.000353946 m=(4)
ends OAI211X4
// End of subcircuit definition.
