// Generated for: spectre (May  1 11:31:30 2013 )
// Library name: gsclib045_backbias
// Cell name: OAI22X1
// View name: extracted

simulator lang=spectre

subckt OAI22X1 A0 A1 B0 B1 NW VDD VSS Y
mp0 (net93 \1\:A0 \3\:VDD NW) g45p1svt w=(3.9e-07) l=4.5e-08 nf=1 \
        as=5.46e-14 ad=4.485e-14 ps=1.06e-06 pd=1.01e-06 nrd=1.16667 \
        nrs=1.16667 sa=1.4e-07 sb=7.55e-07 sd=160n sca=25.383 \
        scb=0.0290112 scc=0.00169816 m=(1)
mp1 (\3\:Y \3\:A1 net93 NW) g45p1svt w=(3.9e-07) l=4.5e-08 nf=1 \
        as=4.485e-14 ad=8.97e-14 ps=1.01e-06 pd=1.24e-06 nrd=1.16667 \
        nrs=1.16667 sa=3e-07 sb=5.95e-07 sd=160n sca=16.6664 scb=0.0162415 \
        scc=0.000384527 m=(1)
mp3 (\3\:Y \1\:B1 net85 NW) g45p1svt w=(3.9e-07) l=4.5e-08 nf=1 \
        as=5.265e-14 ad=8.97e-14 ps=1.05e-06 pd=1.24e-06 nrd=1.16667 \
        nrs=1.16667 sa=5.75e-07 sb=3.2e-07 sd=160n sca=14.4478 \
        scb=0.0118157 scc=0.000294931 m=(1)
mp2 (net85 \3\:B0 \1\:VDD NW) g45p1svt w=(3.9e-07) l=4.5e-08 nf=1 \
        as=5.46e-14 ad=5.265e-14 ps=1.06e-06 pd=1.05e-06 nrd=1.16667 \
        nrs=1.16667 sa=7.55e-07 sb=1.4e-07 sd=160n sca=16.2261 \
        scb=0.0153801 scc=0.000356933 m=(1)
C1 (B0 VSS) capacitor c=3.38431e-17
C2 (A0 VSS) capacitor c=4.1469e-17
C3 (VDD VSS) capacitor c=8.29192e-17
C4 (B1 VSS) capacitor c=3.98993e-17
C5 (NW VSS) capacitor c=1.9968e-16
C6 (A1 VSS) capacitor c=4.44451e-17
C7 (net102 VSS) capacitor c=8.50143e-17
C8 (net93 VSS) capacitor c=2.04111e-18
C9 (net85 VSS) capacitor c=8.01381e-18
C10 (\3\:B0 VSS) capacitor c=4.74096e-17
C11 (\1\:B1 VSS) capacitor c=4.2266e-17
C12 (\3\:A1 VSS) capacitor c=4.78736e-17
C13 (\1\:A0 VSS) capacitor c=5.63727e-17
C14 (\4\:B0 VSS) capacitor c=3.61301e-17
C15 (\3\:B1 VSS) capacitor c=5.12448e-17
C16 (\1\:A1 VSS) capacitor c=5.4827e-17
C17 (\4\:A0 VSS) capacitor c=4.21655e-17
C18 (\1\:B0 VSS) capacitor c=1.24895e-17
C19 (\2\:B1 VSS) capacitor c=4.89426e-17
C20 (\2\:A1 VSS) capacitor c=4.89624e-17
C21 (\3\:A0 VSS) capacitor c=1.35136e-17
C22 (\1\:VDD VSS) capacitor c=1.14395e-16
C23 (\3\:Y VSS) capacitor c=1.2214e-16
C24 (\3\:VDD VSS) capacitor c=3.74307e-17
C25 (\1\:Y VSS) capacitor c=1.16486e-16
C26 (\3\:net102 VSS) capacitor c=1.07985e-16
C27 (\5\:net102 VSS) capacitor c=6.55637e-17
C28 (\2\:A0 VSS) capacitor c=2.66365e-17
C29 (\2\:B0 VSS) capacitor c=3.1057e-17
C30 (\5\:A0 VSS) capacitor c=4.11457e-17
C31 (\4\:A1 VSS) capacitor c=5.79297e-17
C32 (\4\:B1 VSS) capacitor c=5.67771e-17
C33 (\5\:B0 VSS) capacitor c=4.28416e-17
Rk6 (B0 \5\:B0) resistor r=0.1139 c=0
Rk1 (A0 \5\:A0) resistor r=0.08512 c=0
Rk9 (\2\:VDD VDD) resistor r=0.6434 c=0
Rk10 (VDD \4\:VDD) resistor r=0.2386 c=0
Rk5 (\4\:Y Y) resistor r=0.0929 c=0
Rk4 (\2\:Y \4\:Y) resistor r=0.6176 c=0
Rk12 (\3\:VSS VSS) resistor r=0.08728 c=0
Rk13 (\3\:VSS \5\:VSS) resistor r=0.2896 c=0
Rk3 (B1 \4\:B1) resistor r=0.1438 c=0
Rk2 (A1 \4\:A1) resistor r=0.1199 c=0
Rk7 (\2\:net102 \4\:net102) resistor r=0.5941 c=0
Rk8 (\4\:net102 \6\:net102) resistor r=0.4267 c=0
Rl9 (\2\:B0 \3\:B0) resistor r=70.7981 c=0
Rl10 (\2\:B0 \4\:B0) resistor r=64.7092 c=0
Rl8 (\1\:B0 \2\:B0) resistor r=2.0623 c=0
Rl1 (\1\:A0 \2\:A0) resistor r=106.572 c=0
Rl3 (\2\:A0 \4\:A0) resistor r=41.1873 c=0
Rl2 (\2\:A0 \3\:A0) resistor r=8.9604 c=0
Rl6 (\1\:B1 \2\:B1) resistor r=24.2328 c=0
Rl7 (\2\:B1 \3\:B1) resistor r=105.002 c=0
Rl5 (\2\:A1 \3\:A1) resistor r=24.7951 c=0
Rl4 (\1\:A1 \2\:A1) resistor r=105.746 c=0
Rz1 (\1\:Y \2\:Y) resistor r=37.5 c=0
Rz5 (\4\:VSS \5\:VSS) resistor r=75 c=0
Rz2 (net102 \2\:net102) resistor r=37.5 c=0
Rz3 (\3\:net102 \4\:net102) resistor r=37.5 c=0
Rz4 (\5\:net102 \6\:net102) resistor r=37.5 c=0
Ry2 (\1\:VDD \2\:VDD) resistor r=31 c=0
Ry3 (\3\:VDD \4\:VDD) resistor r=31 c=0
Ry1 (\3\:Y \4\:Y) resistor r=20.6667 c=0
Rx4 (\1\:B0 \5\:B0) resistor r=45 c=0
Rx1 (\3\:A0 \5\:A0) resistor r=45 c=0
Rx3 (\2\:B1 \4\:B1) resistor r=45 c=0
Rx2 (\2\:A1 \4\:A1) resistor r=45 c=0
mn0 (\5\:net102 \4\:A0 \4\:VSS VSS) g45n1svt w=(2.6e-07) l=4.5e-08 nf=1 \
        as=6.08e-14 ad=3.64e-14 ps=1.48e-06 pd=8e-07 nrd=1.16667 \
        nrs=1.16667 sa=1.4e-07 sb=7.8e-07 sd=160n sca=17.5885 \
        scb=0.0172826 scc=0.00162584 m=(1)
mn1 (\3\:net102 \1\:A1 \4\:VSS VSS) g45n1svt w=(2.6e-07) l=4.5e-08 nf=1 \
        as=6.08e-14 ad=4.81e-14 ps=1.48e-06 pd=8.9e-07 nrd=1.16667 \
        nrs=1.16667 sa=3.45e-07 sb=5.75e-07 sd=160n sca=17.5885 \
        scb=0.0172826 scc=0.00162584 m=(1)
mn3 (\1\:Y \3\:B1 \3\:net102 VSS) g45n1svt w=(2.6e-07) l=4.5e-08 nf=1 \
        as=4.81e-14 ad=4.16e-14 ps=8.9e-07 pd=8.4e-07 nrd=1.16667 \
        nrs=1.16667 sa=5.75e-07 sb=3.45e-07 sd=160n sca=17.5885 \
        scb=0.0172826 scc=0.00162584 m=(1)
mn2 (\1\:Y \4\:B0 net102 VSS) g45n1svt w=(2.6e-07) l=4.5e-08 nf=1 \
        as=3.64e-14 ad=4.16e-14 ps=8e-07 pd=8.4e-07 nrd=1.16667 \
        nrs=1.16667 sa=7.8e-07 sb=1.4e-07 sd=160n sca=17.5885 \
        scb=0.0172826 scc=0.00162584 m=(1)
ends OAI22X1
// End of subcircuit definition.
