// Generated for: spectre (May  1 11:31:17 2013 )
// Library name: gsclib045_backbias
// Cell name: OAI211X2
// View name: extracted

simulator lang=spectre

subckt OAI211X2 A0 A1 B0 C0 NW VDD VSS Y
mp0_1__rcx (1 \1\:A0 \10\:VDD NW) g45p1svt w=(3.9e-07) l=4.5e-08 nf=1 \
        as=5.46e-14 ad=2.535e-14 ps=1.06e-06 pd=9.1e-07 nrd=1.16667 \
        nrs=1.16667 sa=1.4e-07 sb=1.59e-06 sd=160n sca=21.5541 \
        scb=0.0195467 scc=0.00162283 m=(1)
mp1_1__rcx (\4\:Y \5\:A1 1 NW) g45p1svt w=(3.9e-07) l=4.5e-08 nf=1 \
        as=2.535e-14 ad=7.215e-14 ps=9.1e-07 pd=1.15e-06 nrd=1.16667 \
        nrs=1.16667 sa=2.5e-07 sb=1.48e-06 sd=160n sca=20.1813 \
        scb=0.0174167 scc=0.00159977 m=(1)
mp1 (\4\:Y \1\:A1 4 NW) g45p1svt w=(3.9e-07) l=4.5e-08 nf=1 as=2.34e-14 \
        ad=7.215e-14 ps=9e-07 pd=1.15e-06 nrd=1.16667 nrs=1.16667 \
        sa=4.8e-07 sb=1.25e-06 sd=160n sca=18.8666 scb=0.016155 \
        scc=0.0015962 m=(1)
mp0 (4 \6\:A0 \1\:VDD NW) g45p1svt w=(3.9e-07) l=4.5e-08 nf=1 \
        as=1.3455e-13 ad=2.34e-14 ps=1.47e-06 pd=9e-07 nrd=1.16667 \
        nrs=1.16667 sa=5.85e-07 sb=1.145e-06 sd=160n sca=18.5611 \
        scb=0.0160319 scc=0.00159616 m=(1)
mp3_1__rcx (\9\:Y \3\:C0 \1\:VDD NW) g45p1svt w=(3.9e-07) l=4.5e-08 nf=1 \
        as=5.85e-14 ad=6.24e-14 ps=1.08e-06 pd=1.1e-06 nrd=1.16667 \
        nrs=1.16667 sa=1.385e-06 sb=3.45e-07 sd=160n sca=19.0572 \
        scb=0.0162666 scc=0.00159628 m=(2)
mp2_1__rcx (\7\:Y \3\:B0 \1\:VDD NW) g45p1svt w=(3.9e-07) l=4.5e-08 nf=1 \
        as=9.848e-14 ad=6.24e-14 ps=1.285e-06 pd=1.1e-06 nrd=1.16667 \
        nrs=1.16667 sa=9.75e-07 sb=7.55e-07 sd=160n sca=18.3796 \
        scb=0.0159892 scc=0.00159615 m=(2)
C1 (NW VSS) capacitor c=3.16061e-16
C2 (C0 VSS) capacitor c=4.64526e-17
C3 (A1 VSS) capacitor c=4.03595e-17
C4 (Y VSS) capacitor c=9.86082e-17
C5 (A0 VSS) capacitor c=2.31726e-17
C6 (VDD VSS) capacitor c=3.20288e-17
C7 (n0 VSS) capacitor c=1.59858e-16
C8 (n1 VSS) capacitor c=1.71526e-16
C9 (1 VSS) capacitor c=5.82715e-18
C10 (4 VSS) capacitor c=2.26173e-18
C11 (\6\:A0 VSS) capacitor c=8.02403e-17
C12 (\1\:A1 VSS) capacitor c=7.77077e-17
C13 (\5\:A1 VSS) capacitor c=5.39823e-17
C14 (\1\:A0 VSS) capacitor c=6.39322e-17
C15 (\1\:C0 VSS) capacitor c=7.9291e-17
C16 (\1\:B0 VSS) capacitor c=7.87983e-17
C17 (\3\:B0 VSS) capacitor c=9.30659e-17
C18 (\2\:A1 VSS) capacitor c=2.27207e-17
C19 (\2\:A0 VSS) capacitor c=2.96758e-16
C20 (\1\:VDD VSS) capacitor c=3.43858e-16
C21 (\9\:Y VSS) capacitor c=8.34058e-17
C22 (\7\:Y VSS) capacitor c=2.90651e-17
C23 (\4\:Y VSS) capacitor c=7.5817e-17
C24 (\10\:VDD VSS) capacitor c=5.4753e-17
C25 (\1\:Y VSS) capacitor c=1.56178e-16
C26 (\5\:n0 VSS) capacitor c=1.24666e-16
C27 (\3\:A1 VSS) capacitor c=9.84836e-17
C28 (\3\:C0 VSS) capacitor c=9.81606e-17
C29 (\7\:A1 VSS) capacitor c=6.91462e-17
C30 (\8\:B0 VSS) capacitor c=6.02348e-17
C31 (\9\:B0 VSS) capacitor c=8.89714e-17
C32 (\3\:Y VSS) capacitor c=7.08057e-17
C33 (\7\:C0 VSS) capacitor c=3.10534e-17
C34 (\5\:VDD VSS) capacitor c=4.40029e-17
Rk17 (\7\:C0 C0) resistor r=0.1521 c=0
Rk1 (\7\:A1 A1) resistor r=0.1413 c=0
Rk9 (\2\:Y Y) resistor r=0.9513 c=0
Rk10 (Y \3\:Y) resistor r=0.009359 c=0
Rk11 (\3\:Y \5\:Y) resistor r=0.5137 c=0
Rk12 (\3\:Y \6\:Y) resistor r=0.0712 c=0
Rk13 (\6\:Y \8\:Y) resistor r=0.05921 c=0
Rk14 (\6\:Y \10\:Y) resistor r=0.3907 c=0
Rk6 (\7\:B0 \8\:B0) resistor r=0.002322 c=0
Rk7 (\9\:B0 B0) resistor r=0.002322 c=0
Rk8 (\8\:B0 \9\:B0) resistor r=0.06937 c=0
Rk3 (\2\:A0 A0) resistor r=0.01892 c=0
Rk28 (\3\:VSS VSS) resistor r=0.04968 c=0
Rk30 (\3\:VSS \9\:VSS) resistor r=0.2051 c=0
Rk21 (\5\:VDD VDD) resistor r=0.1148 c=0
Rk20 (\1\:VDD \5\:VDD) resistor r=0.3254 c=0
Rk24 (\5\:VDD \11\:VDD) resistor r=0.3309 c=0
Rk5 (n0 \6\:n0) resistor r=0.5755 c=0
Rl16 (\3\:C0 \1\:C0) resistor r=130.542 c=0
Rl3 (\2\:A1 \1\:A1) resistor r=94.9751 c=0
Rl6 (\2\:A1 \5\:A1) resistor r=25.3108 c=0
Rl4 (\3\:A1 \2\:A1) resistor r=10.2925 c=0
Rl11 (\3\:B0 \1\:B0) resistor r=42.0732 c=0
Rl9 (\2\:A0 \6\:A0) resistor r=97.5275 c=0
Rl1 (\2\:A0 \1\:A0) resistor r=53.8233 c=0
Rz4 (\2\:Y \1\:Y) resistor r=75 c=0
Rz9 (\9\:VSS \8\:VSS) resistor r=75 c=0
Rz3 (\6\:n0 \5\:n0) resistor r=75 c=0
Ry1 (\5\:Y \4\:Y) resistor r=31 c=0
Ry2 (\8\:Y \7\:Y) resistor r=31 c=0
Ry3 (\10\:Y \9\:Y) resistor r=31 c=0
Ry7 (\11\:VDD \10\:VDD) resistor r=31 c=0
Rx5 (\7\:C0 \1\:C0) resistor r=45 c=0
Rx1 (\7\:A1 \2\:A1) resistor r=45 c=0
Rx4 (\7\:B0 \3\:B0) resistor r=45 c=0
mn3_1__rcx (\1\:Y \1\:C0 n1 VSS) g45n1svt w=(2.6e-07) l=4.5e-08 nf=1 \
        as=4.42e-14 ad=4.16e-14 ps=8.6e-07 pd=8.4e-07 nrd=1.16667 \
        nrs=1.16667 sa=6.05e-07 sb=3.45e-07 sd=160n sca=9.50447 \
        scb=0.0081528 scc=0.00025289 m=(2)
mn2_1__rcx (n1 \1\:B0 \5\:n0 VSS) g45n1svt w=(2.6e-07) l=4.5e-08 nf=1 \
        as=4.16e-14 ad=4.615e-14 ps=8.4e-07 pd=8.75e-07 nrd=1.16667 \
        nrs=1.16667 sa=1.55e-07 sb=7.95e-07 sd=160n sca=9.50447 \
        scb=0.0081528 scc=0.00025289 m=(2)
mn0_1__rcx (n0 \2\:A0 \3\:VSS VSS) g45n1svt w=(2.6e-07) l=4.5e-08 nf=1 \
        as=3.64e-14 ad=4.615e-14 ps=8e-07 pd=8.75e-07 nrd=1.16667 \
        nrs=1.16667 sa=1.4e-07 sb=7.9e-07 sd=160n sca=9.50447 \
        scb=0.0081528 scc=0.00025289 m=(2)
mn1 (n0 \3\:A1 \8\:VSS VSS) g45n1svt w=(2.6e-07) l=4.5e-08 nf=1 \
        as=4.16e-14 ad=4.615e-14 ps=8.4e-07 pd=8.75e-07 nrd=1.16667 \
        nrs=1.16667 sa=3.8e-07 sb=5.5e-07 sd=160n sca=9.50447 \
        scb=0.0081528 scc=0.00025289 m=(2)
ends OAI211X2
// End of subcircuit definition.
