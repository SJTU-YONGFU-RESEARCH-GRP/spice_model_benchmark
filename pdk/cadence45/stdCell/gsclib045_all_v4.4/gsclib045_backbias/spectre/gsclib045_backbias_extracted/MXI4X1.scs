// Generated for: spectre (May  1 11:30:07 2013 )
// Library name: gsclib045_backbias
// Cell name: MXI4X1
// View name: extracted

simulator lang=spectre

subckt MXI4X1 A B C D NW S0 S1 VDD VSS Y
mp14 (\1\:Y \4\:n2 \13\:VDD NW) g45p1svt w=(3.9e-07) l=4.5e-08 nf=1 \
        as=7.115e-14 ad=5.46e-14 ps=1.3e-06 pd=1.06e-06 nrd=1.16667 \
        nrs=1.16667 sa=1.4e-07 sb=2.47885e-07 sd=160n sca=26.6306 \
        scb=0.0275086 scc=0.00208721 m=(1)
C1 (NW VSS) capacitor c=5.95032e-16
C2 (S0 VSS) capacitor c=2.55605e-17
C3 (Y VSS) capacitor c=1.46138e-17
C4 (C VSS) capacitor c=4.17375e-17
C5 (D VSS) capacitor c=6.47081e-17
C6 (A VSS) capacitor c=3.77742e-17
C7 (VDD VSS) capacitor c=3.74022e-17
C8 (S1 VSS) capacitor c=7.96316e-17
C9 (B VSS) capacitor c=5.78253e-17
C10 (n2 VSS) capacitor c=2.30724e-17
C11 (S1b VSS) capacitor c=6.77684e-17
C12 (n1 VSS) capacitor c=8.46543e-17
C13 (net329 VSS) capacitor c=1.53557e-18
C14 (n0 VSS) capacitor c=6.4958e-17
C15 (net377 VSS) capacitor c=2.8562e-18
C16 (S0b VSS) capacitor c=6.57428e-17
C17 (net361 VSS) capacitor c=4.41776e-18
C18 (net284 VSS) capacitor c=2.09059e-18
C19 (net280 VSS) capacitor c=3.76654e-18
C20 (net320 VSS) capacitor c=2.0124e-18
C21 (net312 VSS) capacitor c=1.92492e-18
C22 (net304 VSS) capacitor c=3.33862e-18
C23 (\11\:S0 VSS) capacitor c=3.9446e-17
C24 (\3\:A VSS) capacitor c=4.92549e-17
C25 (\4\:S0 VSS) capacitor c=6.68896e-17
C26 (\5\:S0b VSS) capacitor c=3.8971e-17
C27 (\3\:B VSS) capacitor c=4.56708e-17
C28 (\1\:C VSS) capacitor c=4.02686e-17
C29 (\1\:S0 VSS) capacitor c=4.41211e-17
C30 (\1\:D VSS) capacitor c=6.45318e-17
C31 (\6\:S1 VSS) capacitor c=4.74666e-17
C32 (\3\:S1b VSS) capacitor c=4.65181e-17
C33 (\2\:n1 VSS) capacitor c=5.22059e-17
C34 (\1\:S1 VSS) capacitor c=3.66554e-17
C35 (\4\:n2 VSS) capacitor c=4.14685e-17
C36 (\9\:S0 VSS) capacitor c=3.58917e-17
C37 (\1\:A VSS) capacitor c=6.34792e-17
C38 (\7\:S0b VSS) capacitor c=5.28648e-17
C39 (\8\:S0 VSS) capacitor c=4.07647e-17
C40 (\1\:B VSS) capacitor c=6.23532e-17
C41 (\3\:C VSS) capacitor c=7.19817e-17
C42 (\3\:S0b VSS) capacitor c=6.56938e-17
C43 (\3\:S0 VSS) capacitor c=4.16024e-17
C44 (\4\:D VSS) capacitor c=3.17803e-17
C45 (\2\:n0 VSS) capacitor c=4.89457e-17
C46 (\4\:S1 VSS) capacitor c=8.89925e-17
C47 (\3\:S1 VSS) capacitor c=2.87222e-17
C48 (\3\:n2 VSS) capacitor c=3.4542e-17
C49 (\10\:S0 VSS) capacitor c=3.89378e-17
C50 (\2\:A VSS) capacitor c=7.10012e-17
C51 (\5\:S0 VSS) capacitor c=5.35218e-17
C52 (\8\:S0b VSS) capacitor c=1.99946e-17
C53 (\6\:S0b VSS) capacitor c=4.14971e-17
C54 (\7\:S0 VSS) capacitor c=4.93964e-17
C55 (\2\:B VSS) capacitor c=7.57659e-17
C56 (\2\:C VSS) capacitor c=5.20885e-17
C57 (\2\:S0 VSS) capacitor c=5.32773e-17
C58 (\4\:S0b VSS) capacitor c=2.7012e-17
C59 (\2\:S0b VSS) capacitor c=3.25325e-17
C60 (\3\:D VSS) capacitor c=1.09913e-17
C61 (\3\:n0 VSS) capacitor c=2.49549e-17
C62 (\7\:S1 VSS) capacitor c=4.32568e-17
C63 (\5\:S1 VSS) capacitor c=3.19486e-17
C64 (\2\:S1b VSS) capacitor c=6.73739e-17
C65 (\3\:n1 VSS) capacitor c=2.66694e-17
C66 (\2\:S1 VSS) capacitor c=3.39904e-17
C67 (\16\:S0b VSS) capacitor c=5.87882e-17
C68 (\1\:VDD VSS) capacitor c=1.3658e-16
C69 (\5\:n0 VSS) capacitor c=1.9491e-16
C70 (\7\:VDD VSS) capacitor c=3.27721e-17
C71 (\6\:n1 VSS) capacitor c=1.67738e-16
C72 (\9\:VDD VSS) capacitor c=3.10191e-17
C73 (\9\:n2 VSS) capacitor c=1.82491e-16
C74 (\11\:VDD VSS) capacitor c=4.54609e-17
C75 (\6\:S1b VSS) capacitor c=2.34987e-17
C76 (\13\:VDD VSS) capacitor c=4.57353e-17
C77 (\1\:Y VSS) capacitor c=6.73309e-17
C78 (\14\:S0b VSS) capacitor c=8.43427e-17
C79 (\7\:n0 VSS) capacitor c=9.1188e-17
C80 (\4\:n1 VSS) capacitor c=9.45426e-17
C81 (\5\:n2 VSS) capacitor c=6.86669e-17
C82 (\8\:S1b VSS) capacitor c=4.0073e-17
C83 (\3\:Y VSS) capacitor c=4.1326e-17
C84 (\2\:n2 VSS) capacitor c=1.67701e-17
C85 (\2\:D VSS) capacitor c=3.35971e-17
C86 (\6\:S0 VSS) capacitor c=3.25537e-17
C87 (\4\:S1b VSS) capacitor c=5.77426e-17
C88 (\5\:S1b VSS) capacitor c=4.79769e-17
C89 (\8\:n2 VSS) capacitor c=1.39343e-16
C90 (\8\:S1 VSS) capacitor c=8.60886e-17
C91 (\9\:S1 VSS) capacitor c=1.17992e-16
C92 (\10\:S1 VSS) capacitor c=4.243e-17
C93 (\5\:D VSS) capacitor c=3.91002e-17
C94 (\8\:n1 VSS) capacitor c=1.30071e-16
C95 (\4\:C VSS) capacitor c=7.0806e-17
C96 (\5\:B VSS) capacitor c=3.38035e-17
C97 (\12\:S0 VSS) capacitor c=1.0591e-16
C98 (\13\:S0 VSS) capacitor c=8.99931e-17
C99 (\4\:n0 VSS) capacitor c=1.52103e-16
C100 (\4\:A VSS) capacitor c=7.85745e-17
C101 (\14\:S0 VSS) capacitor c=3.28367e-17
C102 (\15\:S0 VSS) capacitor c=4.21116e-17
C103 (\9\:S0b VSS) capacitor c=7.56424e-17
C104 (\10\:S0b VSS) capacitor c=1.31086e-16
C105 (\11\:S0b VSS) capacitor c=1.58793e-16
C106 (\12\:S0b VSS) capacitor c=1.01155e-16
C107 (\13\:S0b VSS) capacitor c=1.18523e-16
C108 (\3\:VDD VSS) capacitor c=1.11086e-16
C109 (\4\:VDD VSS) capacitor c=1.15127e-16
C110 (\5\:VDD VSS) capacitor c=7.66441e-17
C111 (\6\:VDD VSS) capacitor c=3.42194e-17
Rk19 (\12\:S0 \13\:S0) resistor r=0.4155 c=0
Rk23 (\14\:S0 S0) resistor r=0.08682 c=0
Rk24 (S0 \15\:S0) resistor r=0.1415 c=0
Rk2 (\4\:Y Y) resistor r=0.03725 c=0
Rk1 (\2\:Y \4\:Y) resistor r=0.3362 c=0
Rk15 (\4\:C C) resistor r=0.1378 c=0
Rk12 (\5\:D D) resistor r=0.1397 c=0
Rk22 (A \4\:A) resistor r=0.01935 c=0
Rk42 (\2\:VDD \3\:VDD) resistor r=0.6413 c=0
Rk43 (\3\:VDD \4\:VDD) resistor r=0.4752 c=0
Rk44 (\4\:VDD \5\:VDD) resistor r=0.5329 c=0
Rk46 (\6\:VDD VDD) resistor r=0.1275 c=0
Rk45 (\5\:VDD \6\:VDD) resistor r=0.2153 c=0
Rk47 (\3\:VDD \8\:VDD) resistor r=0.1296 c=0
Rk48 (\4\:VDD \10\:VDD) resistor r=0.04332 c=0
Rk49 (\5\:VDD \12\:VDD) resistor r=0.2679 c=0
Rk50 (\6\:VDD \14\:VDD) resistor r=0.2656 c=0
Rk31 (\2\:VSS \4\:VSS) resistor r=0.2958 c=0
Rk32 (\4\:VSS \5\:VSS) resistor r=0.2632 c=0
Rk33 (\5\:VSS \6\:VSS) resistor r=0.5414 c=0
Rk34 (\6\:VSS \7\:VSS) resistor r=0.2481 c=0
Rk35 (\7\:VSS \8\:VSS) resistor r=0.1493 c=0
Rk37 (\9\:VSS VSS) resistor r=0.1566 c=0
Rk36 (\8\:VSS \9\:VSS) resistor r=0.241 c=0
Rk38 (\5\:VSS \11\:VSS) resistor r=0.1952 c=0
Rk39 (\6\:VSS \13\:VSS) resistor r=0.3204 c=0
Rk40 (\8\:VSS \15\:VSS) resistor r=0.04332 c=0
Rk41 (\9\:VSS \17\:VSS) resistor r=0.04332 c=0
Rk10 (\9\:S1 S1) resistor r=0.5652 c=0
Rk9 (\8\:S1 \9\:S1) resistor r=0.5927 c=0
Rk11 (S1 \10\:S1) resistor r=0.2106 c=0
Rk16 (\4\:B \5\:B) resistor r=0.004455 c=0
Rk17 (\6\:B B) resistor r=0.004583 c=0
Rk18 (\5\:B \6\:B) resistor r=0.02633 c=0
Rk6 (\6\:n2 \7\:n2) resistor r=0.464 c=0
Rk7 (\7\:n2 \8\:n2) resistor r=0.9623 c=0
Rk8 (\7\:n2 \10\:n2) resistor r=0.04435 c=0
Rk3 (\4\:S1b \5\:S1b) resistor r=0.3065 c=0
Rk4 (\5\:S1b \7\:S1b) resistor r=0.07551 c=0
Rk5 (\5\:S1b \9\:S1b) resistor r=0.2355 c=0
Rk13 (\5\:n1 \7\:n1) resistor r=0.5786 c=0
Rk14 (\7\:n1 \8\:n1) resistor r=1.0167 c=0
Rk20 (\4\:n0 \6\:n0) resistor r=1.1895 c=0
Rk21 (\6\:n0 \8\:n0) resistor r=0.6104 c=0
Rk25 (\9\:S0b \10\:S0b) resistor r=0.3971 c=0
Rk26 (\10\:S0b \11\:S0b) resistor r=0.7041 c=0
Rk27 (\11\:S0b \12\:S0b) resistor r=0.7498 c=0
Rk28 (\10\:S0b \13\:S0b) resistor r=0.4034 c=0
Rk29 (\13\:S0b \15\:S0b) resistor r=0.6977 c=0
Rk30 (\15\:S0b \17\:S0b) resistor r=0.5124 c=0
Rl34 (\10\:S0 \11\:S0) resistor r=122.253 c=0
Rl33 (\9\:S0 \10\:S0) resistor r=59.6154 c=0
Rl27 (\4\:S0 \5\:S0) resistor r=112.694 c=0
Rl18 (\1\:S0 \2\:S0) resistor r=74.2328 c=0
Rl19 (\2\:S0 \3\:S0) resistor r=113.016 c=0
Rl30 (\6\:S0 \8\:S0) resistor r=91.9892 c=0
Rl28 (\5\:S0 \6\:S0) resistor r=82.6587 c=0
Rl29 (\6\:S0 \7\:S0) resistor r=92.233 c=0
Rl21 (\1\:C \2\:C) resistor r=39.1533 c=0
Rl22 (\2\:C \3\:C) resistor r=112.23 c=0
Rl14 (\1\:D \2\:D) resistor r=38.1757 c=0
Rl16 (\2\:D \4\:D) resistor r=130.483 c=0
Rl15 (\2\:D \3\:D) resistor r=1.2666 c=0
Rl32 (\2\:A \3\:A) resistor r=26.3736 c=0
Rl31 (\1\:A \2\:A) resistor r=186.538 c=0
Rl11 (\6\:S1 \7\:S1) resistor r=67.9995 c=0
Rl8 (\4\:S1 \5\:S1) resistor r=47.3097 c=0
Rl4 (\1\:S1 \2\:S1) resistor r=37.2302 c=0
Rl5 (\2\:S1 \3\:S1) resistor r=29.5379 c=0
Rl24 (\2\:B \3\:B) resistor r=74.4505 c=0
Rl23 (\1\:B \2\:B) resistor r=175.704 c=0
Rl3 (\2\:n2 \4\:n2) resistor r=53.5603 c=0
Rl2 (\2\:n2 \3\:n2) resistor r=49.7141 c=0
Rl1 (n2 \2\:n2) resistor r=1.2713 c=0
Rl10 (\2\:S1b \3\:S1b) resistor r=24.2328 c=0
Rl9 (S1b \2\:S1b) resistor r=158.735 c=0
Rl6 (n1 \2\:n1) resistor r=173.661 c=0
Rl7 (\2\:n1 \3\:n1) resistor r=24.2328 c=0
Rl12 (n0 \2\:n0) resistor r=173.077 c=0
Rl13 (n0 \3\:n0) resistor r=49.2328 c=0
Rl26 (\7\:S0b \8\:S0b) resistor r=77.6148 c=0
Rl25 (\5\:S0b \6\:S0b) resistor r=66.5405 c=0
Rl20 (\3\:S0b \4\:S0b) resistor r=86.8284 c=0
Rl17 (S0b \2\:S0b) resistor r=31.461 c=0
Rz1 (\3\:Y \4\:Y) resistor r=75 c=0
Rz7 (\1\:VSS \2\:VSS) resistor r=75 c=0
Rz8 (\10\:VSS \11\:VSS) resistor r=75 c=0
Rz9 (\12\:VSS \13\:VSS) resistor r=75 c=0
Rz10 (\14\:VSS \15\:VSS) resistor r=75 c=0
Rz11 (\16\:VSS \17\:VSS) resistor r=75 c=0
Rz3 (\5\:n2 \6\:n2) resistor r=75 c=0
Rz2 (\8\:S1b \9\:S1b) resistor r=75 c=0
Rz4 (\4\:n1 \5\:n1) resistor r=75 c=0
Rz5 (\7\:n0 \8\:n0) resistor r=75 c=0
Rz6 (\14\:S0b \15\:S0b) resistor r=75 c=0
Ry1 (\1\:Y \2\:Y) resistor r=20.6667 c=0
Ry9 (\1\:VDD \2\:VDD) resistor r=62 c=0
Ry10 (\7\:VDD \8\:VDD) resistor r=62 c=0
Ry11 (\9\:VDD \10\:VDD) resistor r=62 c=0
Ry12 (\11\:VDD \12\:VDD) resistor r=62 c=0
Ry13 (\13\:VDD \14\:VDD) resistor r=62 c=0
Ry7 (\3\:VSS \4\:VSS) resistor r=6.8889 c=0
Ry8 (\3\:VSS \7\:VSS) resistor r=5.1667 c=0
Ry3 (\9\:n2 \10\:n2) resistor r=62 c=0
Ry2 (\6\:S1b \7\:S1b) resistor r=62 c=0
Ry4 (\6\:n1 \7\:n1) resistor r=62 c=0
Ry5 (\5\:n0 \6\:n0) resistor r=62 c=0
Ry6 (\16\:S0b \17\:S0b) resistor r=62 c=0
Rx10 (\7\:S0 \12\:S0) resistor r=45 c=0
Rx11 (\2\:S0 \13\:S0) resistor r=45 c=0
Rx14 (\10\:S0 \14\:S0) resistor r=45 c=0
Rx15 (\5\:S0 \15\:S0) resistor r=45 c=0
Rx8 (\2\:C \4\:C) resistor r=45 c=0
Rx6 (\3\:D \5\:D) resistor r=45 c=0
Rx13 (\2\:A \4\:A) resistor r=45 c=0
Rx3 (\7\:S1 \8\:S1) resistor r=45 c=0
Rx4 (\5\:S1 \9\:S1) resistor r=45 c=0
Rx5 (\2\:S1 \10\:S1) resistor r=45 c=0
Rx9 (\2\:B \4\:B) resistor r=45 c=0
Rx2 (n2 \8\:n2) resistor r=45 c=0
Rx1 (\2\:S1b \4\:S1b) resistor r=45 c=0
Rx7 (\3\:n1 \8\:n1) resistor r=45 c=0
Rx12 (\3\:n0 \4\:n0) resistor r=45 c=0
Rx16 (\6\:S0b \9\:S0b) resistor r=45 c=0
Rx17 (\4\:S0b \11\:S0b) resistor r=45 c=0
Rx18 (\2\:S0b \12\:S0b) resistor r=45 c=0
Rx19 (\8\:S0b \13\:S0b) resistor r=45 c=0
mn14 (\3\:Y \3\:n2 \16\:VSS VSS) g45n1svt w=(2.6e-07) l=4.5e-08 nf=1 \
        as=6.635e-14 ad=3.64e-14 ps=1.72e-06 pd=8e-07 nrd=1.16667 \
        nrs=1.16667 sa=1.4e-07 sb=2.97981e-07 sd=160n sca=17.5885 \
        scb=0.0172826 scc=0.00162584 m=(1)
mn1 (\8\:S1b \3\:S1 \16\:VSS VSS) g45n1svt w=(1.45e-07) l=4.5e-08 nf=1 \
        as=6.635e-14 ad=2.9e-14 ps=1.72e-06 pd=6.9e-07 nrd=1.16667 \
        nrs=1.16667 sa=3.95e-07 sb=2e-07 sd=160n sca=23.279 scb=0.0230742 \
        scc=0.00267719 m=(1)
mn12 (net345 n1 \14\:VSS VSS) g45n1svt w=(1.45e-07) l=4.5e-08 nf=1 \
        as=6.725e-14 ad=8.7e-15 ps=1.34e-06 pd=4.1e-07 nrd=1.16667 \
        nrs=1.16667 sa=1.7e-07 sb=2e-06 sd=160n sca=13.6097 scb=0.014254 \
        scc=0.000755054 m=(1)
mn13 (\5\:n2 \4\:S1 net345 VSS) g45n1svt w=(1.45e-07) l=4.5e-08 nf=1 \
        as=8.7e-15 ad=2.32e-14 ps=4.1e-07 pd=6.1e-07 nrd=1.16667 \
        nrs=1.16667 sa=2.75e-07 sb=2e-06 sd=160n sca=13.6097 scb=0.014254 \
        scc=0.000755054 m=(1)
mn11 (\5\:n2 S1b net329 VSS) g45n1svt w=(1.45e-07) l=4.5e-08 nf=1 \
        as=2.972e-14 ad=2.32e-14 ps=7e-07 pd=6.1e-07 nrd=1.16667 \
        nrs=1.16667 sa=4.8e-07 sb=2e-06 sd=160n sca=13.6097 scb=0.014254 \
        scc=0.000755054 m=(1)
mn10 (net329 \2\:n0 \12\:VSS VSS) g45n1svt w=(1.45e-07) l=4.5e-08 nf=1 \
        as=5.002e-14 ad=2.972e-14 ps=9.8e-07 pd=7e-07 nrd=1.16667 \
        nrs=1.16667 sa=7.3e-07 sb=2e-06 sd=160n sca=13.6097 scb=0.014254 \
        scc=0.000755054 m=(1)
mn8 (net377 \4\:D \12\:VSS VSS) g45n1svt w=(1.45e-07) l=4.5e-08 nf=1 \
        as=5.002e-14 ad=3.625e-14 ps=9.8e-07 pd=7.9e-07 nrd=1.16667 \
        nrs=1.16667 sa=1.12e-06 sb=1.8869e-06 sd=160n sca=13.6097 \
        scb=0.014254 scc=0.000755054 m=(1)
mn9 (\4\:n1 \3\:S0 net377 VSS) g45n1svt w=(1.45e-07) l=4.5e-08 nf=1 \
        as=3.625e-14 ad=2.32e-14 ps=7.9e-07 pd=6.1e-07 nrd=1.16667 \
        nrs=1.16667 sa=1.415e-06 sb=1.63224e-06 sd=160n sca=13.6097 \
        scb=0.014254 scc=0.000755054 m=(1)
mn7 (\4\:n1 \3\:S0b net369 VSS) g45n1svt w=(1.45e-07) l=4.5e-08 nf=1 \
        as=8.7e-15 ad=2.32e-14 ps=4.1e-07 pd=6.1e-07 nrd=1.16667 \
        nrs=1.16667 sa=1.62e-06 sb=1.42724e-06 sd=160n sca=13.6097 \
        scb=0.014254 scc=0.000755054 m=(1)
mn6 (net369 \3\:C \10\:VSS VSS) g45n1svt w=(1.45e-07) l=4.5e-08 nf=1 \
        as=6.267e-14 ad=8.7e-15 ps=1.22e-06 pd=4.1e-07 nrd=1.16667 \
        nrs=1.16667 sa=1.725e-06 sb=1.32224e-06 sd=160n sca=13.6097 \
        scb=0.014254 scc=0.000755054 m=(1)
mn4 (net361 \1\:B \10\:VSS VSS) g45n1svt w=(1.45e-07) l=4.5e-08 nf=1 \
        as=6.267e-14 ad=3.625e-14 ps=1.22e-06 pd=7.9e-07 nrd=1.16667 \
        nrs=1.16667 sa=2e-06 sb=1.00224e-06 sd=160n sca=13.6097 \
        scb=0.014254 scc=0.000755054 m=(1)
mn5 (\7\:n0 \8\:S0 net361 VSS) g45n1svt w=(1.45e-07) l=4.5e-08 nf=1 \
        as=3.625e-14 ad=2.32e-14 ps=7.9e-07 pd=6.1e-07 nrd=1.16667 \
        nrs=1.16667 sa=2e-06 sb=7.07241e-07 sd=160n sca=13.6097 \
        scb=0.014254 scc=0.000755054 m=(1)
mn3 (\7\:n0 \7\:S0b net349 VSS) g45n1svt w=(1.45e-07) l=4.5e-08 nf=1 \
        as=2.247e-14 ad=2.32e-14 ps=6e-07 pd=6.1e-07 nrd=1.16667 \
        nrs=1.16667 sa=2e-06 sb=5.02241e-07 sd=160n sca=13.6097 \
        scb=0.014254 scc=0.000755054 m=(1)
mn2 (net349 \1\:A \1\:VSS VSS) g45n1svt w=(1.45e-07) l=4.5e-08 nf=1 \
        as=7.85e-14 ad=2.247e-14 ps=1.6e-06 pd=6e-07 nrd=1.16667 \
        nrs=1.16667 sa=2e-06 sb=3.02241e-07 sd=160n sca=13.6097 \
        scb=0.014254 scc=0.000755054 m=(1)
mn0 (\14\:S0b \9\:S0 \1\:VSS VSS) g45n1svt w=(1.45e-07) l=4.5e-08 nf=1 \
        as=7.85e-14 ad=2.9e-14 ps=1.6e-06 pd=6.9e-07 nrd=1.16667 \
        nrs=1.16667 sa=9.51724e-07 sb=2e-07 sd=160n sca=23.279 \
        scb=0.0230742 scc=0.00267719 m=(1)
mp1 (\6\:S1b \1\:S1 \13\:VDD NW) g45p1svt w=(2.15e-07) l=4.5e-08 nf=1 \
        as=7.115e-14 ad=3.01e-14 ps=1.3e-06 pd=7.1e-07 nrd=1.16667 \
        nrs=1.16667 sa=3.26395e-07 sb=1.4e-07 sd=160n sca=47.6387 \
        scb=0.0298205 scc=0.00588813 m=(1)
mp12 (net284 \2\:n1 \11\:VDD NW) g45p1svt w=(2.15e-07) l=4.5e-08 nf=1 \
        as=3.89e-14 ad=2.903e-14 ps=1.06e-06 pd=7e-07 nrd=1.16667 \
        nrs=1.16667 sa=1.27907e-07 sb=1.71581e-06 sd=160n sca=15.2551 \
        scb=0.0150251 scc=0.000885438 m=(1)
mp13 (\9\:n2 \3\:S1b net284 NW) g45p1svt w=(2.15e-07) l=4.5e-08 nf=1 \
        as=2.903e-14 ad=4.515e-14 ps=7e-07 pd=8.5e-07 nrd=1.16667 \
        nrs=1.16667 sa=3.07907e-07 sb=1.57767e-06 sd=160n sca=15.2551 \
        scb=0.0150251 scc=0.000885438 m=(1)
mp11 (\9\:n2 \6\:S1 net280 NW) g45p1svt w=(2.15e-07) l=4.5e-08 nf=1 \
        as=2.473e-14 ad=4.515e-14 ps=6.6e-07 pd=8.5e-07 nrd=1.16667 \
        nrs=1.16667 sa=5.62907e-07 sb=1.38198e-06 sd=160n sca=15.2551 \
        scb=0.0150251 scc=0.000885438 m=(1)
mp10 (net280 n0 \9\:VDD NW) g45p1svt w=(2.15e-07) l=4.5e-08 nf=1 \
        as=1.1842e-13 ad=2.473e-14 ps=1.89e-06 pd=6.6e-07 nrd=1.16667 \
        nrs=1.16667 sa=7.22907e-07 sb=1.25919e-06 sd=160n sca=15.2551 \
        scb=0.0150251 scc=0.000885438 m=(1)
mp8 (net320 \1\:D \9\:VDD NW) g45p1svt w=(2.15e-07) l=4.5e-08 nf=1 \
        as=1.1842e-13 ad=1.29e-14 ps=1.89e-06 pd=5.5e-07 nrd=1.16667 \
        nrs=1.16667 sa=1.07035e-06 sb=1.05942e-06 sd=160n sca=14.5646 \
        scb=0.0142004 scc=0.000753562 m=(1)
mp9 (\6\:n1 S0b net320 NW) g45p1svt w=(2.15e-07) l=4.5e-08 nf=1 \
        as=1.29e-14 ad=5.698e-14 ps=5.5e-07 pd=9.6e-07 nrd=1.16667 \
        nrs=1.16667 sa=1.17535e-06 sb=9.54419e-07 sd=160n sca=14.5646 \
        scb=0.0142004 scc=0.000753562 m=(1)
mp7 (\6\:n1 \1\:S0 net312 NW) g45p1svt w=(2.15e-07) l=4.5e-08 nf=1 \
        as=3.118e-14 ad=5.698e-14 ps=7.2e-07 pd=9.6e-07 nrd=1.16667 \
        nrs=1.16667 sa=1.48535e-06 sb=6.44419e-07 sd=160n sca=14.5646 \
        scb=0.0142004 scc=0.000753562 m=(1)
mp6 (net312 \1\:C \7\:VDD NW) g45p1svt w=(2.15e-07) l=4.5e-08 nf=1 \
        as=7.365e-14 ad=3.118e-14 ps=1.54e-06 pd=7.2e-07 nrd=1.16667 \
        nrs=1.16667 sa=1.67535e-06 sb=4.54419e-07 sd=160n sca=14.5646 \
        scb=0.0142004 scc=0.000753562 m=(1)
mp4 (net304 \3\:B \7\:VDD NW) g45p1svt w=(2.15e-07) l=4.5e-08 nf=1 \
        as=7.365e-14 ad=2.795e-14 ps=1.54e-06 pd=6.9e-07 nrd=1.16667 \
        nrs=1.16667 sa=6.38372e-07 sb=1.055e-06 sd=160n sca=10.1832 \
        scb=0.00742094 scc=7.76436e-05 m=(1)
mp5 (\5\:n0 \5\:S0b net304 NW) g45p1svt w=(2.15e-07) l=4.5e-08 nf=1 \
        as=2.795e-14 ad=6.558e-14 ps=6.9e-07 pd=1.04e-06 nrd=1.16667 \
        nrs=1.16667 sa=7.72674e-07 sb=8.8e-07 sd=160n sca=10.1832 \
        scb=0.00742094 scc=7.76436e-05 m=(1)
mp3 (\5\:n0 \4\:S0 net296 NW) g45p1svt w=(2.15e-07) l=4.5e-08 nf=1 \
        as=1.29e-14 ad=6.558e-14 ps=5.5e-07 pd=1.04e-06 nrd=1.16667 \
        nrs=1.16667 sa=1.04128e-06 sb=5.3e-07 sd=160n sca=10.6702 \
        scb=0.0075867 scc=7.76926e-05 m=(1)
mp2 (net296 \3\:A \1\:VDD NW) g45p1svt w=(2.15e-07) l=4.5e-08 nf=1 \
        as=5.16e-14 ad=1.29e-14 ps=9.1e-07 pd=5.5e-07 nrd=1.16667 \
        nrs=1.16667 sa=1.12186e-06 sb=4.25e-07 sd=160n sca=11.1175 \
        scb=0.00789061 scc=7.80015e-05 m=(1)
mp0 (\16\:S0b \11\:S0 \1\:VDD NW) g45p1svt w=(2.15e-07) l=4.5e-08 nf=1 \
        as=5.16e-14 ad=3.01e-14 ps=9.1e-07 pd=7.1e-07 nrd=1.16667 \
        nrs=1.16667 sa=1.34035e-06 sb=1.4e-07 sd=160n sca=14.3466 \
        scb=0.0127067 scc=0.000142758 m=(1)
ends MXI4X1
// End of subcircuit definition.
