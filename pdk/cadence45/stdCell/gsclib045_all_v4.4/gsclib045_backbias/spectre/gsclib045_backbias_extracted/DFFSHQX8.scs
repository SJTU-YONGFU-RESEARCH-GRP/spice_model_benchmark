// Generated for: spectre (May  1 11:28:56 2013 )
// Library name: gsclib045_backbias
// Cell name: DFFSHQX8
// View name: extracted

simulator lang=spectre

subckt DFFSHQX8 CK D NW Q SN VDD VSS
mp55_1__rcx (Q qbint \8\:VDD NW) g45p1svt w=(4.45e-07) l=4.5e-08 nf=1 \
        as=6.807e-14 ad=6.993e-14 ps=1.20429e-06 pd=1.20429e-06 \
        nrd=1.16667 nrs=1.16667 sa=1.4e-07 sb=1.34079e-06 sd=160n \
        sca=40.5428 scb=0.0363846 scc=0.00414682 m=(7)
C1 (SN VSS) capacitor c=1.85832e-16
C2 (NW VSS) capacitor c=7.52182e-16
C3 (VDD VSS) capacitor c=3.53956e-17
C4 (CK VSS) capacitor c=4.07855e-17
C5 (D VSS) capacitor c=6.84153e-17
C6 (Q VSS) capacitor c=5.04936e-16
C7 (qbint VSS) capacitor c=3.30871e-16
C8 (n35 VSS) capacitor c=2.39635e-16
C9 (n40 VSS) capacitor c=4.3373e-18
C10 (CKb VSS) capacitor c=4.47048e-17
C11 (mout VSS) capacitor c=8.68988e-17
C12 (CKbb VSS) capacitor c=6.13674e-17
C13 (n25 VSS) capacitor c=1.85903e-18
C14 (n20 VSS) capacitor c=4.62497e-17
C15 (n30 VSS) capacitor c=2.32266e-18
C16 (n41 VSS) capacitor c=6.75124e-17
C17 (n31 VSS) capacitor c=1.69238e-18
C18 (n22 VSS) capacitor c=6.76176e-18
C19 (\4\:CK VSS) capacitor c=4.32328e-17
C20 (\4\:D VSS) capacitor c=5.50143e-17
C21 (\5\:CKbb VSS) capacitor c=7.88366e-17
C22 (\10\:CKb VSS) capacitor c=7.35145e-17
C23 (\5\:SN VSS) capacitor c=6.71427e-17
C24 (\4\:CKb VSS) capacitor c=2.00032e-17
C25 (\9\:CKb VSS) capacitor c=2.78611e-17
C26 (\23\:qbint VSS) capacitor c=6.00812e-17
C27 (\4\:SN VSS) capacitor c=5.97706e-17
C28 (\3\:CK VSS) capacitor c=5.0508e-17
C29 (\3\:D VSS) capacitor c=8.36671e-17
C30 (\12\:CKb VSS) capacitor c=5.7906e-17
C31 (\7\:CKbb VSS) capacitor c=3.3384e-17
C32 (\4\:mout VSS) capacitor c=4.34124e-17
C33 (\3\:n20 VSS) capacitor c=8.19419e-17
C34 (\8\:SN VSS) capacitor c=4.39705e-17
C35 (\8\:CKb VSS) capacitor c=4.75995e-17
C36 (\3\:CKbb VSS) capacitor c=2.96839e-17
C37 (\25\:qbint VSS) capacitor c=3.03991e-17
C38 (\3\:SN VSS) capacitor c=5.80676e-17
C39 (\1\:CK VSS) capacitor c=1.43578e-17
C40 (\1\:D VSS) capacitor c=3.11926e-17
C41 (\13\:CKb VSS) capacitor c=4.5139e-17
C42 (\11\:CKb VSS) capacitor c=3.33694e-17
C43 (\6\:CKbb VSS) capacitor c=6.95451e-17
C44 (\3\:mout VSS) capacitor c=1.69826e-17
C45 (\2\:n20 VSS) capacitor c=4.63564e-17
C46 (\7\:SN VSS) capacitor c=2.42649e-17
C47 (\3\:CKb VSS) capacitor c=1.55178e-17
C48 (\4\:CKbb VSS) capacitor c=3.72783e-17
C49 (\7\:CKb VSS) capacitor c=4.44647e-17
C50 (\2\:CKb VSS) capacitor c=5.38528e-17
C51 (\24\:qbint VSS) capacitor c=5.53918e-17
C52 (\1\:SN VSS) capacitor c=2.7035e-17
C53 (\11\:qbint VSS) capacitor c=1.03996e-17
C54 (\16\:CKb VSS) capacitor c=5.45198e-17
C55 (\1\:VDD VSS) capacitor c=1.42277e-16
C56 (\4\:n20 VSS) capacitor c=4.34444e-17
C57 (\12\:VDD VSS) capacitor c=4.4755e-17
C58 (\14\:mout VSS) capacitor c=2.20529e-17
C59 (\14\:VDD VSS) capacitor c=1.94592e-17
C60 (\13\:CKbb VSS) capacitor c=4.06009e-17
C61 (\8\:mout VSS) capacitor c=1.45038e-16
C62 (\11\:n35 VSS) capacitor c=7.48015e-17
C63 (\16\:VDD VSS) capacitor c=3.74565e-17
C64 (\3\:n41 VSS) capacitor c=8.16492e-17
C65 (\20\:CKb VSS) capacitor c=6.30514e-17
C66 (\8\:n20 VSS) capacitor c=5.43979e-17
C67 (\12\:mout VSS) capacitor c=3.58699e-17
C68 (\10\:CKbb VSS) capacitor c=5.40019e-17
C69 (\10\:mout VSS) capacitor c=1.12109e-16
C70 (\15\:n35 VSS) capacitor c=8.39291e-17
C71 (\2\:SN VSS) capacitor c=4.52722e-17
C72 (\2\:CKbb VSS) capacitor c=5.08979e-17
C73 (\5\:CKb VSS) capacitor c=3.82173e-17
C74 (\6\:SN VSS) capacitor c=3.94948e-17
C75 (\2\:mout VSS) capacitor c=3.67171e-17
C76 (\2\:D VSS) capacitor c=4.01462e-17
C77 (\2\:CK VSS) capacitor c=5.71215e-17
C78 (\26\:qbint VSS) capacitor c=5.78477e-17
C79 (\27\:qbint VSS) capacitor c=2.39444e-16
C80 (\30\:qbint VSS) capacitor c=4.05649e-17
C81 (\13\:n35 VSS) capacitor c=1.49807e-16
C82 (\14\:n35 VSS) capacitor c=9.10821e-17
C83 (\14\:CKb VSS) capacitor c=5.41143e-17
C84 (\15\:CKb VSS) capacitor c=7.2374e-17
C85 (\9\:SN VSS) capacitor c=1.87737e-16
C86 (\10\:SN VSS) capacitor c=8.18554e-17
C87 (\5\:mout VSS) capacitor c=6.844e-17
C88 (\6\:mout VSS) capacitor c=5.3517e-17
C89 (\7\:mout VSS) capacitor c=1.1568e-16
C90 (\8\:CKbb VSS) capacitor c=1.92082e-16
C91 (\9\:CKbb VSS) capacitor c=1.95054e-16
C92 (\12\:CKbb VSS) capacitor c=4.45538e-17
C93 (\6\:n20 VSS) capacitor c=7.51591e-17
C94 (\7\:n20 VSS) capacitor c=6.03982e-17
C95 (\5\:D VSS) capacitor c=4.7375e-17
C96 (\18\:CKb VSS) capacitor c=8.92268e-17
C97 (\19\:CKb VSS) capacitor c=8.76953e-17
C98 (\22\:CKb VSS) capacitor c=1.25041e-16
C99 (\23\:CKb VSS) capacitor c=1.18295e-16
C100 (\5\:CK VSS) capacitor c=1.57313e-17
C101 (\3\:VDD VSS) capacitor c=7.56824e-17
C102 (\4\:VDD VSS) capacitor c=9.28204e-17
C103 (\5\:VDD VSS) capacitor c=9.16164e-17
C104 (\6\:VDD VSS) capacitor c=1.91382e-16
C105 (\8\:VDD VSS) capacitor c=4.80882e-16
Rk22 (\9\:SN SN) resistor r=1.3402 c=0
Rk23 (SN \10\:SN) resistor r=0.4368 c=0
Rk63 (\2\:VSS \4\:VSS) resistor r=0.2684 c=0
Rk64 (\4\:VSS \5\:VSS) resistor r=0.4034 c=0
Rk65 (\5\:VSS \6\:VSS) resistor r=0.3346 c=0
Rk66 (\6\:VSS \7\:VSS) resistor r=0.2119 c=0
Rk67 (\7\:VSS \8\:VSS) resistor r=0.5589 c=0
Rk74 (\10\:VSS VSS) resistor r=0.1074 c=0
Rk69 (\8\:VSS \10\:VSS) resistor r=0.2503 c=0
Rk75 (\5\:VSS \16\:VSS) resistor r=0.189 c=0
Rk76 (\6\:VSS \18\:VSS) resistor r=0.04329 c=0
Rk44 (\2\:VDD \3\:VDD) resistor r=0.6783 c=0
Rk45 (\3\:VDD \4\:VDD) resistor r=0.1466 c=0
Rk46 (\4\:VDD \5\:VDD) resistor r=0.7808 c=0
Rk47 (\5\:VDD \6\:VDD) resistor r=0.1901 c=0
Rk53 (\8\:VDD VDD) resistor r=0.1074 c=0
Rk49 (\6\:VDD \8\:VDD) resistor r=0.2653 c=0
Rk54 (\3\:VDD \13\:VDD) resistor r=0.2223 c=0
Rk55 (\4\:VDD \15\:VDD) resistor r=0.04329 c=0
Rk56 (\5\:VDD \17\:VDD) resistor r=0.2456 c=0
Rk43 (CK \5\:CK) resistor r=0.122 c=0
Rk37 (\5\:D D) resistor r=0.06086 c=0
Rk9 (\26\:qbint \27\:qbint) resistor r=0.3428 c=0
Rk12 (\27\:qbint \30\:qbint) resistor r=0.2264 c=0
Rk18 (\12\:n35 \13\:n35) resistor r=0.3856 c=0
Rk19 (\13\:n35 \14\:n35) resistor r=0.5675 c=0
Rk20 (\13\:n35 \16\:n35) resistor r=0.4287 c=0
Rk21 (\14\:CKb \15\:CKb) resistor r=0.1594 c=0
Rk38 (\17\:CKb \18\:CKb) resistor r=0.3565 c=0
Rk39 (\18\:CKb \19\:CKb) resistor r=0.3535 c=0
Rk40 (\19\:CKb \21\:CKb) resistor r=0.4129 c=0
Rk41 (\18\:CKb \22\:CKb) resistor r=0.3845 c=0
Rk42 (\22\:CKb \23\:CKb) resistor r=0.8752 c=0
Rk24 (\5\:mout \6\:mout) resistor r=0.289 c=0
Rk25 (\6\:mout \7\:mout) resistor r=0.2248 c=0
Rk26 (\7\:mout \9\:mout) resistor r=0.6607 c=0
Rk27 (\9\:mout \11\:mout) resistor r=0.6112 c=0
Rk28 (\6\:mout \13\:mout) resistor r=0.1048 c=0
Rk29 (\7\:mout \15\:mout) resistor r=0.04277 c=0
Rk30 (\8\:CKbb \9\:CKbb) resistor r=1.3642 c=0
Rk31 (\9\:CKbb \11\:CKbb) resistor r=0.3388 c=0
Rk32 (\11\:CKbb \12\:CKbb) resistor r=0.1426 c=0
Rk33 (\9\:CKbb \14\:CKbb) resistor r=0.1202 c=0
Rk34 (\5\:n20 \6\:n20) resistor r=0.2381 c=0
Rk35 (\6\:n20 \7\:n20) resistor r=0.3561 c=0
Rk36 (\6\:n20 \9\:n20) resistor r=0.3065 c=0
Rk17 (\2\:n41 \4\:n41) resistor r=0.4194 c=0
Rl33 (\2\:SN \4\:SN) resistor r=83.495 c=0
Rl32 (\2\:SN \3\:SN) resistor r=106.572 c=0
Rl31 (\1\:SN \2\:SN) resistor r=1.2334 c=0
Rl46 (\5\:SN \6\:SN) resistor r=141.588 c=0
Rl48 (\6\:SN \8\:SN) resistor r=34.3295 c=0
Rl47 (\6\:SN \7\:SN) resistor r=8.3038 c=0
Rl63 (\2\:CK \4\:CK) resistor r=77.7258 c=0
Rl62 (\2\:CK \3\:CK) resistor r=173.88 c=0
Rl61 (\1\:CK \2\:CK) resistor r=28.7005 c=0
Rl60 (\2\:D \4\:D) resistor r=73.8796 c=0
Rl59 (\2\:D \3\:D) resistor r=141.187 c=0
Rl58 (\1\:D \2\:D) resistor r=3.1216 c=0
Rl34 (\24\:qbint \23\:qbint) resistor r=144.613 c=0
Rl35 (\24\:qbint \25\:qbint) resistor r=24.2328 c=0
Rl10 (qbint \11\:qbint) resistor r=4.8851 c=0
Rl57 (\12\:CKb \13\:CKb) resistor r=58.8482 c=0
Rl54 (\10\:CKb \11\:CKb) resistor r=24.2328 c=0
Rl40 (\3\:CKb \4\:CKb) resistor r=50.6918 c=0
Rl36 (CKb \2\:CKb) resistor r=106.027 c=0
Rl41 (\4\:CKb \5\:CKb) resistor r=86.5163 c=0
Rl44 (\5\:CKb \8\:CKb) resistor r=82.3738 c=0
Rl45 (\6\:CKb \9\:CKb) resistor r=28.3689 c=0
Rl43 (\6\:CKb \7\:CKb) resistor r=7.5029 c=0
Rl42 (\5\:CKb \6\:CKb) resistor r=121.743 c=0
Rl51 (mout \2\:mout) resistor r=95.0334 c=0
Rl53 (\2\:mout \4\:mout) resistor r=62.3411 c=0
Rl52 (\2\:mout \3\:mout) resistor r=1.2301 c=0
Rl55 (\5\:CKbb \6\:CKbb) resistor r=228.389 c=0
Rl56 (\6\:CKbb \7\:CKbb) resistor r=24.7951 c=0
Rl37 (CKbb \2\:CKbb) resistor r=105.451 c=0
Rl38 (\2\:CKbb \3\:CKbb) resistor r=48.0548 c=0
Rl39 (\2\:CKbb \4\:CKbb) resistor r=125.67 c=0
Rl49 (n20 \2\:n20) resistor r=24.2328 c=0
Rl50 (\2\:n20 \3\:n20) resistor r=166.106 c=0
Rz13 (\2\:VSS \1\:VSS) resistor r=75 c=0
Rz14 (\16\:VSS \15\:VSS) resistor r=75 c=0
Rz15 (\18\:VSS \17\:VSS) resistor r=75 c=0
Rz7 (\16\:n35 \15\:n35) resistor r=75 c=0
Rz12 (\20\:CKb \21\:CKb) resistor r=75 c=0
Rz8 (\10\:mout \11\:mout) resistor r=75 c=0
Rz9 (\12\:mout \13\:mout) resistor r=75 c=0
Rz10 (\10\:CKbb \11\:CKbb) resistor r=75 c=0
Rz11 (\8\:n20 \9\:n20) resistor r=75 c=0
Ry25 (\4\:VSS \3\:VSS) resistor r=8.8571 c=0
Ry26 (\7\:VSS \3\:VSS) resistor r=5.1667 c=0
Ry27 (\10\:VSS \3\:VSS) resistor r=5.1667 c=0
Ry15 (\2\:VDD \1\:VDD) resistor r=62 c=0
Ry16 (\13\:VDD \12\:VDD) resistor r=62 c=0
Ry17 (\15\:VDD \14\:VDD) resistor r=62 c=0
Ry18 (\17\:VDD \16\:VDD) resistor r=62 c=0
Ry9 (\12\:n35 \11\:n35) resistor r=31 c=0
Ry14 (\16\:CKb \17\:CKb) resistor r=62 c=0
Ry10 (\8\:mout \9\:mout) resistor r=31 c=0
Ry11 (\14\:mout \15\:mout) resistor r=62 c=0
Ry12 (\13\:CKbb \14\:CKbb) resistor r=62 c=0
Ry13 (\4\:n20 \5\:n20) resistor r=62 c=0
Ry7 (n41 \2\:n41) resistor r=62 c=0
Ry8 (\3\:n41 \4\:n41) resistor r=62 c=0
Rx6 (\7\:SN \9\:SN) resistor r=45 c=0
Rx7 (\1\:SN \10\:SN) resistor r=45 c=0
Rx16 (\1\:CK \5\:CK) resistor r=45 c=0
Rx12 (\1\:D \5\:D) resistor r=45 c=0
Rx1 (\26\:qbint \24\:qbint) resistor r=45 c=0
Rx2 (\30\:qbint \11\:qbint) resistor r=45 c=0
Rx3 (\14\:n35 n35) resistor r=45 c=0
Rx4 (\7\:CKb \14\:CKb) resistor r=45 c=0
Rx5 (\2\:CKb \15\:CKb) resistor r=45 c=0
Rx13 (\13\:CKb \19\:CKb) resistor r=45 c=0
Rx14 (\11\:CKb \22\:CKb) resistor r=45 c=0
Rx15 (\3\:CKb \23\:CKb) resistor r=45 c=0
Rx8 (\3\:mout \5\:mout) resistor r=45 c=0
Rx9 (\6\:CKbb \8\:CKbb) resistor r=45 c=0
Rx10 (\4\:CKbb \12\:CKbb) resistor r=45 c=0
Rx11 (\2\:n20 \7\:n20) resistor r=45 c=0
mn55_1__rcx (Q qbint \10\:VSS VSS) g45n1svt w=(2.95e-07) l=4.5e-08 nf=1 \
        as=4.791e-14 ad=4.636e-14 ps=9.9429e-07 pd=9.0429e-07 nrd=1.16667 \
        nrs=1.16667 sa=1.4e-07 sb=1.33e-06 sd=160n sca=16.4223 \
        scb=0.0158966 scc=0.0014413 m=(7)
mn45 (\27\:qbint n35 \8\:VSS VSS) g45n1svt w=(2.6e-07) l=4.5e-08 nf=1 \
        as=4.05e-14 ad=3.987e-14 ps=8.4e-07 pd=9.2e-07 nrd=1.16667 \
        nrs=1.16667 sa=1.18462e-07 sb=9.55865e-07 sd=160n sca=17.5885 \
        scb=0.0172826 scc=0.00162584 m=(3)
mn50 (n42 \3\:SN \8\:VSS VSS) g45n1svt w=(2.05e-07) l=4.5e-08 nf=1 \
        as=3.83e-14 ad=2.973e-14 ps=8.4e-07 pd=7e-07 nrd=1.16667 \
        nrs=1.16667 sa=5.75e-07 sb=8.6e-07 sd=160n sca=9.90451 \
        scb=0.00881556 scc=0.00026609 m=(1)
mn51 (n40 \25\:qbint n42 VSS) g45n1svt w=(2.05e-07) l=4.5e-08 nf=1 \
        as=2.973e-14 ad=5.432e-14 ps=7e-07 pd=9.4e-07 nrd=1.16667 \
        nrs=1.16667 sa=7.65e-07 sb=6.7e-07 sd=160n sca=9.90451 \
        scb=0.00881556 scc=0.00026609 m=(1)
mn52 (\15\:n35 CKb n40 VSS) g45n1svt w=(2.05e-07) l=4.5e-08 nf=1 \
        as=5.432e-14 ad=3.588e-14 ps=9.4e-07 pd=7.6e-07 nrd=1.16667 \
        nrs=1.16667 sa=1.075e-06 sb=3.6e-07 sd=160n sca=9.90451 \
        scb=0.00881556 scc=0.00026609 m=(1)
mn40 (\15\:n35 \3\:CKbb \10\:mout VSS) g45n1svt w=(2.05e-07) l=4.5e-08 \
        nf=1 as=2.87e-14 ad=3.588e-14 ps=6.9e-07 pd=7.6e-07 nrd=1.16667 \
        nrs=1.16667 sa=1.295e-06 sb=1.4e-07 sd=160n sca=9.90451 \
        scb=0.00881556 scc=0.00026609 m=(1)
mn30 (n25 \8\:SN \17\:VSS VSS) g45n1svt w=(2.05e-07) l=4.5e-08 nf=1 \
        as=7.63e-14 ad=1.435e-14 ps=1.42e-06 pd=5.5e-07 nrd=1.16667 \
        nrs=1.16667 sa=3.3622e-07 sb=2.55e-07 sd=160n sca=11.535 \
        scb=0.0112489 scc=0.00047927 m=(1)
mn31 (\12\:mout \3\:n20 n25 VSS) g45n1svt w=(2.05e-07) l=4.5e-08 nf=1 \
        as=1.435e-14 ad=2.87e-14 ps=5.5e-07 pd=6.9e-07 nrd=1.16667 \
        nrs=1.16667 sa=4.5122e-07 sb=1.4e-07 sd=160n sca=11.535 \
        scb=0.0112489 scc=0.00047927 m=(1)
mn36 (n30 \4\:mout \15\:VSS VSS) g45n1svt w=(2.05e-07) l=4.5e-08 nf=1 \
        as=2.87e-14 ad=2.358e-14 ps=6.9e-07 pd=6.4e-07 nrd=1.16667 \
        nrs=1.16667 sa=1.4e-07 sb=9.03293e-07 sd=160n sca=7.77393 \
        scb=0.00528022 scc=7.94731e-05 m=(1)
mn35 (\8\:n20 \7\:CKbb n30 VSS) g45n1svt w=(2.05e-07) l=4.5e-08 nf=1 \
        as=2.358e-14 ad=6.458e-14 ps=6.4e-07 pd=1.04e-06 nrd=1.16667 \
        nrs=1.16667 sa=3e-07 sb=7.43293e-07 sd=160n sca=7.77393 \
        scb=0.00528022 scc=7.94731e-05 m=(1)
mn26 (\8\:n20 \12\:CKb n21 VSS) g45n1svt w=(2.05e-07) l=4.5e-08 nf=1 \
        as=1.333e-14 ad=6.458e-14 ps=5.4e-07 pd=1.04e-06 nrd=1.16667 \
        nrs=1.16667 sa=6.6e-07 sb=3.83293e-07 sd=160n sca=7.77393 \
        scb=0.00528022 scc=7.94731e-05 m=(1)
mn25 (n21 \3\:D \1\:VSS VSS) g45n1svt w=(2.05e-07) l=4.5e-08 nf=1 \
        as=2.92e-14 ad=1.333e-14 ps=7.3e-07 pd=5.4e-07 nrd=1.16667 \
        nrs=1.16667 sa=7.7e-07 sb=2.73293e-07 sd=160n sca=7.77393 \
        scb=0.00528022 scc=7.94731e-05 m=(1)
mn21 (\10\:CKbb \8\:CKb \17\:VSS VSS) g45n1svt w=(1.45e-07) l=4.5e-08 \
        nf=1 as=7.63e-14 ad=2.03e-14 ps=1.42e-06 pd=5.7e-07 nrd=1.16667 \
        nrs=1.16667 sa=1.4e-07 sb=5.2e-07 sd=160n sca=12.9138 \
        scb=0.0133404 scc=0.000640143 m=(1)
mn20 (\20\:CKb \3\:CK \1\:VSS VSS) g45n1svt w=(1.45e-07) l=4.5e-08 nf=1 \
        as=2.92e-14 ad=2.03e-14 ps=7.3e-07 pd=5.7e-07 nrd=1.16667 \
        nrs=1.16667 sa=9.75e-07 sb=1.4e-07 sd=160n sca=8.42104 \
        scb=0.00632542 scc=0.000106623 m=(1)
mp45_1__rcx (\27\:qbint n35 \6\:VDD NW) g45p1svt w=(3.9e-07) l=4.5e-08 \
        nf=1 as=6.08e-14 ad=5.62e-14 ps=1.1e-06 pd=1.08667e-06 nrd=1.16667 \
        nrs=1.16667 sa=1.12308e-07 sb=8.67692e-07 sd=160n sca=16.2669 \
        scb=0.0145797 scc=0.00118861 m=(3)
mp50 (\3\:n41 \4\:SN \6\:VDD NW) g45p1svt w=(3.1e-07) l=4.5e-08 nf=1 \
        as=5.76e-14 ad=4.96e-14 ps=1.1e-06 pd=9.4e-07 nrd=1.16667 \
        nrs=1.16667 sa=7.20161e-07 sb=3.45e-07 sd=160n sca=12.4967 \
        scb=0.0111079 scc=0.00042389 m=(1)
mp51 (\3\:n41 \23\:qbint \16\:VDD NW) g45p1svt w=(3.1e-07) l=4.5e-08 \
        nf=1 as=4.34e-14 ad=4.96e-14 ps=9e-07 pd=9.4e-07 nrd=1.16667 \
        nrs=1.16667 sa=9.25161e-07 sb=1.4e-07 sd=160n sca=12.4967 \
        scb=0.0111079 scc=0.00042389 m=(1)
mp52 (\11\:n35 CKbb n41 NW) g45p1svt w=(3.1e-07) l=4.5e-08 nf=1 \
        as=4.34e-14 ad=4.96e-14 ps=9e-07 pd=9.4e-07 nrd=1.16667 \
        nrs=1.16667 sa=1.4e-07 sb=3.45e-07 sd=160n sca=26.7199 \
        scb=0.0211429 scc=0.00304348 m=(1)
mp40 (\11\:n35 \9\:CKb \8\:mout NW) g45p1svt w=(3.1e-07) l=4.5e-08 nf=1 \
        as=4.34e-14 ad=4.96e-14 ps=9e-07 pd=9.4e-07 nrd=1.16667 \
        nrs=1.16667 sa=3.45e-07 sb=1.4e-07 sd=160n sca=26.7199 \
        scb=0.0211429 scc=0.00304348 m=(1)
mp30 (\14\:mout \5\:SN \14\:VDD NW) g45p1svt w=(3.1e-07) l=4.5e-08 nf=1 \
        as=1.239e-13 ad=4.96e-14 ps=2.51e-06 pd=9.4e-07 nrd=1.16667 \
        nrs=1.16667 sa=3.80887e-07 sb=1.00234e-06 sd=160n sca=35.6995 \
        scb=0.0234062 scc=0.00420468 m=(1)
mp31 (\14\:mout n20 \12\:VDD NW) g45p1svt w=(3.1e-07) l=4.5e-08 nf=1 \
        as=9.255e-14 ad=4.96e-14 ps=1.45e-06 pd=9.4e-07 nrd=1.16667 \
        nrs=1.16667 sa=5.85887e-07 sb=7.97339e-07 sd=160n sca=35.6995 \
        scb=0.0234062 scc=0.00420468 m=(1)
mp35 (n31 mout \12\:VDD NW) g45p1svt w=(3.1e-07) l=4.5e-08 nf=1 \
        as=9.255e-14 ad=1.86e-14 ps=1.45e-06 pd=7.4e-07 nrd=1.16667 \
        nrs=1.16667 sa=8.55887e-07 sb=5.27339e-07 sd=160n sca=35.6995 \
        scb=0.0234062 scc=0.00420468 m=(1)
mp36 (\4\:n20 \10\:CKb n31 NW) g45p1svt w=(3.1e-07) l=4.5e-08 nf=1 \
        as=1.86e-14 ad=6.92e-14 ps=7.4e-07 pd=1.41e-06 nrd=1.16667 \
        nrs=1.16667 sa=9.60887e-07 sb=4.22339e-07 sd=160n sca=35.6995 \
        scb=0.0234062 scc=0.00420468 m=(1)
mp26 (\4\:n20 \5\:CKbb n22 NW) g45p1svt w=(3.1e-07) l=4.5e-08 nf=1 \
        as=5.89e-14 ad=6.92e-14 ps=1e-06 pd=1.41e-06 nrd=1.16667 \
        nrs=1.16667 sa=7.12339e-07 sb=5.04919e-07 sd=160n sca=12.6932 \
        scb=0.0113709 scc=0.000458931 m=(1)
mp25 (n22 \4\:D \1\:VDD NW) g45p1svt w=(3.1e-07) l=4.5e-08 nf=1 \
        as=4.39e-14 ad=5.89e-14 ps=9.4e-07 pd=1e-06 nrd=1.16667 \
        nrs=1.16667 sa=9.47339e-07 sb=2.69919e-07 sd=160n sca=13.2902 \
        scb=0.0115979 scc=0.000459018 m=(1)
mp21 (\13\:CKbb \4\:CKb \14\:VDD NW) g45p1svt w=(2.15e-07) l=4.5e-08 \
        nf=1 as=1.239e-13 ad=3.01e-14 ps=2.51e-06 pd=7.1e-07 nrd=1.16667 \
        nrs=1.16667 sa=1.4e-07 sb=1.38442e-06 sd=160n sca=23.7894 \
        scb=0.0219499 scc=0.00260958 m=(1)
mp20 (\16\:CKb \4\:CK \1\:VDD NW) g45p1svt w=(2.15e-07) l=4.5e-08 nf=1 \
        as=4.39e-14 ad=3.01e-14 ps=9.4e-07 pd=7.1e-07 nrd=1.16667 \
        nrs=1.16667 sa=8.59535e-07 sb=1.4e-07 sd=160n sca=12.5661 \
        scb=0.00990908 scc=0.000142097 m=(1)
ends DFFSHQX8
// End of subcircuit definition.
