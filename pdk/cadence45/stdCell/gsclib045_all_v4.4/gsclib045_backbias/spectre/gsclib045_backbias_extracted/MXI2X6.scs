// Generated for: spectre (May  1 11:30:01 2013 )
// Library name: gsclib045_backbias
// Cell name: MXI2X6
// View name: extracted

simulator lang=spectre

subckt MXI2X6 A B NW S0 VDD VSS Y
mp0 (\8\:S0b \1\:S0 \13\:VDD NW) g45p1svt w=(2.15e-07) l=4.5e-08 nf=1 \
        as=3.44e-14 ad=4.837e-14 ps=7.5e-07 pd=8.8e-07 nrd=1.16667 \
        nrs=1.16667 sa=2.25e-07 sb=2e-06 sd=160n sca=15.1724 scb=0.0141966 \
        scc=0.000199699 m=(1)
mp1 (n4 \1\:A \13\:VDD NW) g45p1svt w=(2.15e-07) l=4.5e-08 nf=1 \
        as=3.44e-14 ad=4.945e-14 ps=7.5e-07 pd=8.9e-07 nrd=1.16667 \
        nrs=1.16667 sa=4.3e-07 sb=2e-06 sd=160n sca=12.0026 scb=0.00898843 \
        scc=0.000100961 m=(1)
mp2 (\7\:n0 \6\:S0 n4 NW) g45p1svt w=(2.15e-07) l=4.5e-08 nf=1 \
        as=4.945e-14 ad=4.515e-14 ps=8.9e-07 pd=8.5e-07 nrd=1.16667 \
        nrs=1.16667 sa=7.05e-07 sb=2e-06 sd=160n sca=10.6609 \
        scb=0.00786354 scc=9.84678e-05 m=(1)
mp4 (\7\:n0 \3\:S0b n6 NW) g45p1svt w=(2.15e-07) l=4.5e-08 nf=1 \
        as=2.687e-14 ad=4.515e-14 ps=6.8e-07 pd=8.5e-07 nrd=1.16667 \
        nrs=1.16667 sa=9.6e-07 sb=1.825e-06 sd=160n sca=10.3756 \
        scb=0.00778655 scc=9.84544e-05 m=(1)
mp3 (n6 \1\:B \1\:VDD NW) g45p1svt w=(2.15e-07) l=4.5e-08 nf=1 \
        as=5.835e-14 ad=2.687e-14 ps=1.16e-06 pd=6.8e-07 nrd=1.16667 \
        nrs=1.16667 sa=1.13e-06 sb=1.655e-06 sd=160n sca=10.3756 \
        scb=0.00778655 scc=9.84544e-05 m=(1)
C1 (NW VSS) capacitor c=4.23602e-16
C2 (B VSS) capacitor c=7.96888e-17
C3 (S0 VSS) capacitor c=3.46407e-17
C4 (Y VSS) capacitor c=5.20261e-16
C5 (VDD VSS) capacitor c=4.46194e-17
C6 (A VSS) capacitor c=4.13234e-17
C7 (S0b VSS) capacitor c=6.05487e-17
C8 (n0 VSS) capacitor c=2.15866e-16
C9 (n5 VSS) capacitor c=5.14908e-18
C10 (n1 VSS) capacitor c=3.17182e-16
C11 (n4 VSS) capacitor c=2.35833e-20
C12 (n6 VSS) capacitor c=1.6215e-18
C13 (\1\:B VSS) capacitor c=6.34296e-17
C14 (\3\:S0b VSS) capacitor c=4.15491e-17
C15 (\6\:S0 VSS) capacitor c=4.12835e-17
C16 (\1\:A VSS) capacitor c=5.09757e-17
C17 (\1\:S0 VSS) capacitor c=3.29336e-17
C18 (\3\:B VSS) capacitor c=4.46456e-17
C19 (\4\:S0 VSS) capacitor c=6.56187e-17
C20 (\3\:A VSS) capacitor c=7.86671e-17
C21 (\3\:S0 VSS) capacitor c=5.8575e-17
C22 (\7\:n1 VSS) capacitor c=1.70402e-17
C23 (\2\:B VSS) capacitor c=5.53429e-17
C24 (\4\:S0b VSS) capacitor c=4.59771e-17
C25 (\5\:S0 VSS) capacitor c=7.68369e-17
C26 (\2\:S0b VSS) capacitor c=4.9765e-17
C27 (\2\:A VSS) capacitor c=6.34185e-17
C28 (\2\:S0 VSS) capacitor c=5.46193e-17
C29 (\1\:VDD VSS) capacitor c=5.1868e-16
C30 (\21\:n1 VSS) capacitor c=9.0269e-17
C31 (\7\:n0 VSS) capacitor c=9.27529e-17
C32 (\13\:VDD VSS) capacitor c=2.49113e-17
C33 (\8\:S0b VSS) capacitor c=7.99197e-17
C34 (\19\:n1 VSS) capacitor c=3.97657e-17
C35 (\10\:n0 VSS) capacitor c=5.67127e-17
C36 (\10\:S0b VSS) capacitor c=3.37458e-17
C37 (\4\:A VSS) capacitor c=6.51288e-17
C38 (\7\:S0 VSS) capacitor c=6.93624e-17
C39 (\8\:S0 VSS) capacitor c=8.04948e-17
C40 (\5\:S0b VSS) capacitor c=8.77153e-17
C41 (\6\:S0b VSS) capacitor c=1.36273e-16
C42 (\7\:S0b VSS) capacitor c=5.51981e-17
C43 (\4\:B VSS) capacitor c=2.70692e-17
C44 (\9\:n0 VSS) capacitor c=1.37055e-16
C45 (\12\:n0 VSS) capacitor c=5.07046e-17
C46 (\17\:n1 VSS) capacitor c=1.98901e-17
C47 (\18\:n1 VSS) capacitor c=5.49041e-17
C48 (\6\:VDD VSS) capacitor c=6.97034e-17
Rk10 (\4\:B B) resistor r=0.02104 c=0
Rk3 (\8\:S0 S0) resistor r=0.03714 c=0
Rk2 (\7\:S0 \8\:S0) resistor r=0.5576 c=0
Rk30 (\6\:VDD VDD) resistor r=0.1802 c=0
Rk29 (\1\:VDD \6\:VDD) resistor r=0.4687 c=0
Rk34 (\6\:VDD \14\:VDD) resistor r=0.1747 c=0
Rk1 (A \4\:A) resistor r=0.007123 c=0
Rk39 (\1\:VSS \8\:VSS) resistor r=0.08259 c=0
Rk41 (\9\:VSS VSS) resistor r=0.1802 c=0
Rk40 (\8\:VSS \9\:VSS) resistor r=0.3711 c=0
Rk45 (\9\:VSS \17\:VSS) resistor r=0.2175 c=0
Rk4 (\5\:S0b \6\:S0b) resistor r=0.4999 c=0
Rk5 (\6\:S0b \7\:S0b) resistor r=0.4517 c=0
Rk6 (\7\:S0b \9\:S0b) resistor r=0.5592 c=0
Rk7 (\7\:S0b \11\:S0b) resistor r=0.2257 c=0
Rk11 (\8\:n0 \9\:n0) resistor r=0.6162 c=0
Rk12 (\9\:n0 \11\:n0) resistor r=0.3903 c=0
Rk13 (\9\:n0 \12\:n0) resistor r=0.2571 c=0
Rk14 (\17\:n1 \18\:n1) resistor r=0.1017 c=0
Rk15 (\18\:n1 \20\:n1) resistor r=0.2507 c=0
Rk16 (\18\:n1 \22\:n1) resistor r=0.4472 c=0
Rl9 (\1\:B \2\:B) resistor r=158.384 c=0
Rl10 (\2\:B \3\:B) resistor r=135.307 c=0
Rl7 (\5\:S0 \6\:S0) resistor r=80.0021 c=0
Rl6 (\4\:S0 \5\:S0) resistor r=239.939 c=0
Rl1 (\1\:S0 \2\:S0) resistor r=46.8456 c=0
Rl2 (\2\:S0 \3\:S0) resistor r=246.846 c=0
Rl3 (\1\:A \2\:A) resistor r=146.846 c=0
Rl4 (\2\:A \3\:A) resistor r=146.846 c=0
Rl8 (\3\:S0b \4\:S0b) resistor r=57.0048 c=0
Rl5 (S0b \2\:S0b) resistor r=66.8207 c=0
Rl21 (n1 \7\:n1) resistor r=9.5197 c=0
Rz11 (\17\:VSS \16\:VSS) resistor r=75 c=0
Rz1 (\10\:S0b \11\:S0b) resistor r=75 c=0
Rz2 (\11\:n0 \10\:n0) resistor r=75 c=0
Rz3 (\20\:n1 \19\:n1) resistor r=75 c=0
Ry11 (\14\:VDD \13\:VDD) resistor r=62 c=0
Ry12 (\1\:VSS \3\:VSS) resistor r=20.6667 c=0
Ry13 (\8\:VSS \3\:VSS) resistor r=5.1667 c=0
Ry1 (\8\:S0b \9\:S0b) resistor r=62 c=0
Ry2 (\8\:n0 \7\:n0) resistor r=62 c=0
Ry3 (\22\:n1 \21\:n1) resistor r=20.6667 c=0
Rx6 (\2\:B \4\:B) resistor r=45 c=0
Rx2 (\5\:S0 \7\:S0) resistor r=45 c=0
Rx3 (\2\:S0 \8\:S0) resistor r=45 c=0
Rx1 (\2\:A \4\:A) resistor r=45 c=0
Rx4 (\4\:S0b \5\:S0b) resistor r=45 c=0
Rx5 (\2\:S0b \6\:S0b) resistor r=45 c=0
Rx7 (\12\:n0 n0) resistor r=45 c=0
Rx8 (\17\:n1 \7\:n1) resistor r=45 c=0
mn0 (\10\:S0b \3\:S0 \16\:VSS VSS) g45n1svt w=(1.45e-07) l=4.5e-08 nf=1 \
        as=2.32e-14 ad=2.03e-14 ps=6.1e-07 pd=5.7e-07 nrd=1.16667 \
        nrs=1.16667 sa=1.4e-07 sb=2e-06 sd=160n sca=7.688 scb=0.00504888 \
        scc=6.29443e-05 m=(1)
mn1 (n3 \3\:A \16\:VSS VSS) g45n1svt w=(1.45e-07) l=4.5e-08 nf=1 \
        as=2.32e-14 ad=8.7e-15 ps=6.1e-07 pd=4.1e-07 nrd=1.16667 \
        nrs=1.16667 sa=3.45e-07 sb=2e-06 sd=160n sca=7.688 scb=0.00504888 \
        scc=6.29443e-05 m=(1)
mn2 (\10\:n0 S0b n3 VSS) g45n1svt w=(1.45e-07) l=4.5e-08 nf=1 as=8.7e-15 \
        ad=3.19e-14 ps=4.1e-07 pd=7.3e-07 nrd=1.16667 nrs=1.16667 \
        sa=4.5e-07 sb=2e-06 sd=160n sca=7.688 scb=0.00504888 \
        scc=6.29443e-05 m=(1)
mn4 (\10\:n0 \4\:S0 n5 VSS) g45n1svt w=(1.45e-07) l=4.5e-08 nf=1 \
        as=4.132e-14 ad=3.19e-14 ps=8.6e-07 pd=7.3e-07 nrd=1.16667 \
        nrs=1.16667 sa=7.15e-07 sb=1.985e-06 sd=160n sca=7.688 \
        scb=0.00504888 scc=6.29443e-05 m=(1)
mn3 (n5 \3\:B \1\:VSS VSS) g45n1svt w=(1.45e-07) l=4.5e-08 nf=1 \
        as=3.905e-14 ad=4.133e-14 ps=9e-07 pd=8.6e-07 nrd=1.16667 \
        nrs=1.16667 sa=1.045e-06 sb=1.655e-06 sd=160n sca=7.688 \
        scb=0.00504888 scc=6.29443e-05 m=(1)
mn5_1__rcx (\19\:n1 n0 \1\:VSS VSS) g45n1svt w=(2.6e-07) l=4.5e-08 nf=1 \
        as=4.933e-14 ad=4.16e-14 ps=9.7e-07 pd=8.4e-07 nrd=1.16667 \
        nrs=1.16667 sa=7.58077e-07 sb=1.42e-06 sd=160n sca=9.69565 \
        scb=0.00844644 scc=0.000275168 m=(2)
mn6_1__rcx (Y n1 \1\:VSS VSS) g45n1svt w=(3.1e-07) l=4.5e-08 nf=1 \
        as=5.16e-14 ad=4.836e-14 ps=9.6e-07 pd=9.32e-07 nrd=1.16667 \
        nrs=1.16667 sa=1.03774e-06 sb=9.6e-07 sd=160n sca=11.2536 \
        scb=0.0105131 scc=0.000532331 m=(5)
mp5_1__rcx (\21\:n1 n0 \1\:VDD NW) g45p1svt w=(3.9e-07) l=4.5e-08 nf=1 \
        as=7.412e-14 ad=6.24e-14 ps=1.26e-06 pd=1.1e-06 nrd=1.16667 \
        nrs=1.16667 sa=7.97372e-07 sb=1.42e-06 sd=160n sca=11.3866 \
        scb=0.00953811 scc=0.000231855 m=(2)
mp6_1__rcx (Y n1 \1\:VDD NW) g45p1svt w=(4.7e-07) l=4.5e-08 nf=1 \
        as=7.814e-14 ad=7.332e-14 ps=1.28e-06 pd=1.252e-06 nrd=1.16667 \
        nrs=1.16667 sa=1.06037e-06 sb=9.6e-07 sd=160n sca=13.3727 \
        scb=0.0119208 scc=0.000609828 m=(5)
ends MXI2X6
// End of subcircuit definition.
