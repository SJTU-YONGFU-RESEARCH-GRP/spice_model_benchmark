// Generated for: spectre (May  1 11:27:33 2013 )
// Library name: gsclib045_backbias
// Cell name: AOI221X2
// View name: extracted

simulator lang=spectre

subckt AOI221X2 A0 A1 B0 B1 C0 NW VDD VSS Y
mp2_1__rcx (net104 B0 net103 NW) g45p1svt w=(3.9e-07) l=4.5e-08 nf=1 \
        as=6.24e-14 ad=5.85e-14 ps=1.1e-06 pd=1.08e-06 nrd=1.16667 \
        nrs=1.16667 sa=1.4e-07 sb=1.165e-06 sd=160n sca=13.5671 \
        scb=0.012183 scc=0.000647513 m=(2)
mp0 (\5\:net103 \2\:A0 \1\:VDD NW) g45p1svt w=(3.9e-07) l=4.5e-08 nf=1 \
        as=5.46e-14 ad=6.24e-14 ps=1.06e-06 pd=1.1e-06 nrd=1.16667 \
        nrs=1.16667 sa=1.4e-07 sb=7.55e-07 sd=160n sca=22.5802 \
        scb=0.0254567 scc=0.001215 m=(2)
mp3 (\9\:net104 \1\:B1 net103 NW) g45p1svt w=(3.9e-07) l=4.5e-08 nf=1 \
        as=6.24e-14 ad=6.24e-14 ps=1.1e-06 pd=1.1e-06 nrd=1.16667 \
        nrs=1.16667 sa=3.45e-07 sb=9.6e-07 sd=160n sca=13.5671 \
        scb=0.012183 scc=0.000647513 m=(2)
mp1_1__rcx (\5\:net103 \4\:A1 \5\:VDD NW) g45p1svt w=(3.9e-07) l=4.5e-08 \
        nf=1 as=6.24e-14 ad=6.24e-14 ps=1.1e-06 pd=1.1e-06 nrd=1.16667 \
        nrs=1.16667 sa=3.45e-07 sb=5.5e-07 sd=160n sca=16.2799 \
        scb=0.0149716 scc=0.000663053 m=(2)
mp4_1__rcx (\8\:Y \1\:C0 net104 NW) g45p1svt w=(3.9e-07) l=4.5e-08 nf=1 \
        as=5.85e-14 ad=6.24e-14 ps=1.08e-06 pd=1.1e-06 nrd=1.16667 \
        nrs=1.16667 sa=9.6e-07 sb=3.45e-07 sd=160n sca=16.4248 \
        scb=0.0152088 scc=0.000666128 m=(2)
C1 (C0 VSS) capacitor c=3.55628e-17
C2 (B0 VSS) capacitor c=3.97171e-16
C3 (A1 VSS) capacitor c=5.18034e-17
C4 (Y VSS) capacitor c=1.70774e-16
C5 (VDD VSS) capacitor c=2.21884e-17
C6 (NW VSS) capacitor c=3.52236e-16
C7 (13 VSS) capacitor c=1.69916e-18
C8 (14 VSS) capacitor c=1.73762e-18
C9 (15 VSS) capacitor c=1.71625e-18
C10 (net103 VSS) capacitor c=2.03895e-16
C11 (net104 VSS) capacitor c=2.79214e-16
C12 (\1\:C0 VSS) capacitor c=9.33139e-17
C13 (\1\:B1 VSS) capacitor c=9.26737e-17
C14 (\6\:B0 VSS) capacitor c=6.98541e-17
C15 (\6\:B1 VSS) capacitor c=6.182e-17
C16 (\5\:B1 VSS) capacitor c=5.77349e-17
C17 (\3\:B0 VSS) capacitor c=5.68858e-17
C18 (\6\:A0 VSS) capacitor c=5.73917e-17
C19 (\1\:A1 VSS) capacitor c=4.71776e-17
C20 (\6\:A1 VSS) capacitor c=5.16238e-17
C21 (\1\:A0 VSS) capacitor c=6.89553e-17
C22 (\3\:B1 VSS) capacitor c=5.22545e-17
C23 (\3\:A1 VSS) capacitor c=2.04499e-17
C24 (\2\:A0 VSS) capacitor c=3.12194e-16
C25 (\8\:Y VSS) capacitor c=1.55811e-16
C26 (\9\:net104 VSS) capacitor c=3.92808e-18
C27 (\5\:net103 VSS) capacitor c=1.81233e-16
C28 (\5\:VDD VSS) capacitor c=4.06625e-17
C29 (\1\:VDD VSS) capacitor c=3.87115e-16
C30 (\1\:Y VSS) capacitor c=5.84242e-17
C31 (\3\:Y VSS) capacitor c=7.16823e-17
C32 (\6\:Y VSS) capacitor c=5.51949e-17
C33 (\2\:A1 VSS) capacitor c=4.17249e-17
C34 (\4\:A1 VSS) capacitor c=9.32633e-17
C35 (\3\:C0 VSS) capacitor c=8.59612e-17
C36 (\7\:B1 VSS) capacitor c=1.4094e-16
C37 (\5\:Y VSS) capacitor c=7.65051e-17
C38 (\7\:C0 VSS) capacitor c=5.49211e-17
Rk20 (C0 \7\:C0) resistor r=0.189 c=0
Rk3 (\2\:A0 A0) resistor r=0.002375 c=0
Rk1 (\8\:A1 A1) resistor r=0.002995 c=0
Rk10 (\2\:Y \4\:Y) resistor r=0.4227 c=0
Rk13 (\5\:Y Y) resistor r=0.2422 c=0
Rk11 (\4\:Y \5\:Y) resistor r=0.3149 c=0
Rk12 (\5\:Y \7\:Y) resistor r=0.3374 c=0
Rk14 (Y \9\:Y) resistor r=0.9701 c=0
Rk32 (\1\:VDD VDD) resistor r=0.02712 c=0
Rk34 (\1\:VDD \6\:VDD) resistor r=0.2206 c=0
Rk21 (\2\:VSS \3\:VSS) resistor r=0.09253 c=0
Rk23 (\3\:VSS \5\:VSS) resistor r=0.3231 c=0
Rk24 (\5\:VSS \6\:VSS) resistor r=0.1126 c=0
Rk26 (\7\:VSS VSS) resistor r=0.1274 c=0
Rk25 (\6\:VSS \7\:VSS) resistor r=0.3104 c=0
Rk29 (\6\:VSS \13\:VSS) resistor r=0.1885 c=0
Rk30 (\7\:VSS \15\:VSS) resistor r=0.213 c=0
Rk9 (B1 \7\:B1) resistor r=0.002695 c=0
Rk5 (net103 \5\:net103) resistor r=0.4835 c=0
Rk19 (net104 \10\:net104) resistor r=0.0153 c=0
Rl21 (\3\:C0 \1\:C0) resistor r=30.2393 c=0
Rl10 (\2\:A0 \6\:A0) resistor r=29.5379 c=0
Rl1 (\2\:A0 \1\:A0) resistor r=71.2234 c=0
Rl19 (B0 \6\:B0) resistor r=65.3618 c=0
Rl12 (B0 \3\:B0) resistor r=31.461 c=0
Rl3 (\2\:A1 \1\:A1) resistor r=54.3046 c=0
Rl7 (\2\:A1 \6\:A1) resistor r=73.5354 c=0
Rl4 (\2\:A1 \3\:A1) resistor r=24.2612 c=0
Rl5 (\4\:A1 \3\:A1) resistor r=8.9152 c=0
Rl14 (\1\:B1 \3\:B1) resistor r=9.4152 c=0
Rl17 (\3\:B1 \6\:B1) resistor r=129.041 c=0
Rl16 (\3\:B1 \5\:B1) resistor r=107.643 c=0
Rz1 (\2\:Y \1\:Y) resistor r=75 c=0
Rz2 (\4\:Y \3\:Y) resistor r=75 c=0
Rz3 (\7\:Y \6\:Y) resistor r=75 c=0
Rz6 (\13\:VSS \12\:VSS) resistor r=75 c=0
Rz7 (\15\:VSS \14\:VSS) resistor r=75 c=0
Ry5 (\9\:Y \8\:Y) resistor r=62 c=0
Ry13 (\6\:VDD \5\:VDD) resistor r=62 c=0
Ry10 (\2\:VSS \1\:VSS) resistor r=62 c=0
Ry11 (\5\:VSS \1\:VSS) resistor r=5.1667 c=0
Ry9 (\10\:net104 \9\:net104) resistor r=62 c=0
Rx7 (\7\:C0 \1\:C0) resistor r=45 c=0
Rx1 (\8\:A1 \3\:A1) resistor r=45 c=0
Rx6 (\7\:B1 \3\:B1) resistor r=45 c=0
mn0_1__rcx (12 \1\:A0 \14\:VSS VSS) g45n1svt w=(2.6e-07) l=4.5e-08 nf=1 \
        as=3.64e-14 ad=1.56e-14 ps=8e-07 pd=6.4e-07 nrd=1.16667 \
        nrs=1.16667 sa=1.4e-07 sb=1.895e-06 sd=160n sca=9.69565 \
        scb=0.00844644 scc=0.000275168 m=(1)
mn1_1__rcx (\6\:Y \6\:A1 12 VSS) g45n1svt w=(2.6e-07) l=4.5e-08 nf=1 \
        as=1.56e-14 ad=4.16e-14 ps=6.4e-07 pd=8.4e-07 nrd=1.16667 \
        nrs=1.16667 sa=2.45e-07 sb=1.79e-06 sd=160n sca=9.69565 \
        scb=0.00844644 scc=0.000275168 m=(1)
mn1 (\6\:Y \1\:A1 13 VSS) g45n1svt w=(2.6e-07) l=4.5e-08 nf=1 as=1.56e-14 \
        ad=4.16e-14 ps=6.4e-07 pd=8.4e-07 nrd=1.16667 nrs=1.16667 \
        sa=4.5e-07 sb=1.585e-06 sd=160n sca=9.69565 scb=0.00844644 \
        scc=0.000275168 m=(1)
mn0 (13 \6\:A0 \12\:VSS VSS) g45n1svt w=(2.6e-07) l=4.5e-08 nf=1 \
        as=1.102e-13 ad=1.56e-14 ps=1.4e-06 pd=6.4e-07 nrd=1.16667 \
        nrs=1.16667 sa=5.55e-07 sb=1.48e-06 sd=160n sca=9.69565 \
        scb=0.00844644 scc=0.000275168 m=(1)
mn2_1__rcx (\12\:VSS \3\:B0 14 VSS) g45n1svt w=(2.6e-07) l=4.5e-08 nf=1 \
        as=1.56e-14 ad=1.102e-13 ps=6.4e-07 pd=1.4e-06 nrd=1.16667 \
        nrs=1.16667 sa=1.01e-06 sb=1.025e-06 sd=160n sca=9.69565 \
        scb=0.00844644 scc=0.000275168 m=(1)
mn3_1__rcx (14 \5\:B1 \3\:Y VSS) g45n1svt w=(2.6e-07) l=4.5e-08 nf=1 \
        as=4.16e-14 ad=1.56e-14 ps=8.4e-07 pd=6.4e-07 nrd=1.16667 \
        nrs=1.16667 sa=1.115e-06 sb=9.2e-07 sd=160n sca=9.69565 \
        scb=0.00844644 scc=0.000275168 m=(1)
mn3 (15 \6\:B1 \3\:Y VSS) g45n1svt w=(2.6e-07) l=4.5e-08 nf=1 as=4.16e-14 \
        ad=1.56e-14 ps=8.4e-07 pd=6.4e-07 nrd=1.16667 nrs=1.16667 \
        sa=1.32e-06 sb=7.15e-07 sd=160n sca=9.69565 scb=0.00844644 \
        scc=0.000275168 m=(1)
mn2 (\3\:VSS \6\:B0 15 VSS) g45n1svt w=(2.6e-07) l=4.5e-08 nf=1 \
        as=1.56e-14 ad=6.08e-14 ps=6.4e-07 pd=1.02e-06 nrd=1.16667 \
        nrs=1.16667 sa=1.425e-06 sb=6.1e-07 sd=160n sca=9.69565 \
        scb=0.00844644 scc=0.000275168 m=(1)
mn4 (\1\:Y \3\:C0 \3\:VSS VSS) g45n1svt w=(2.6e-07) l=4.5e-08 nf=1 \
        as=4.86e-14 ad=4.16e-14 ps=9.1e-07 pd=8.4e-07 nrd=1.16667 \
        nrs=1.16667 sa=1.69e-06 sb=3.45e-07 sd=160n sca=9.69565 \
        scb=0.00844644 scc=0.000275168 m=(2)
ends AOI221X2
// End of subcircuit definition.
