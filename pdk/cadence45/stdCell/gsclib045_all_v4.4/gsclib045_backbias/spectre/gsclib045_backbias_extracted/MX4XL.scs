// Generated for: spectre (May  1 11:29:58 2013 )
// Library name: gsclib045_backbias
// Cell name: MX4XL
// View name: extracted

simulator lang=spectre

subckt MX4XL A B C D NW S0 S1 VDD VSS Y
mp12 (\3\:Y n2 \10\:VDD NW) g45p1svt w=(2.15e-07) l=4.5e-08 nf=1 \
        as=5.623e-14 ad=3.87e-14 ps=1.46e-06 pd=7.9e-07 nrd=1.16667 \
        nrs=1.16667 sa=1.8e-07 sb=4.35e-07 sd=160n sca=53.9205 \
        scb=0.0402944 scc=0.00632464 m=(1)
mp1 (\7\:S1b \4\:S1 \10\:VDD NW) g45p1svt w=(2.15e-07) l=4.5e-08 nf=1 \
        as=5.623e-14 ad=5.053e-14 ps=1.46e-06 pd=9e-07 nrd=1.16667 \
        nrs=1.16667 sa=3.8e-07 sb=2.35e-07 sd=160n sca=48.3666 \
        scb=0.0308994 scc=0.00589713 m=(1)
mp11 (\8\:n1 S1b \4\:n2 NW) g45p1svt w=(2.15e-07) l=4.5e-08 nf=1 \
        as=3.44e-14 ad=3.01e-14 ps=7.5e-07 pd=7.1e-07 nrd=1.16667 \
        nrs=1.16667 sa=1.4e-07 sb=4.6e-07 sd=160n sca=19.0975 \
        scb=0.0187686 scc=0.00166224 m=(1)
mp10 (\4\:n2 \1\:S1 \5\:n0 NW) g45p1svt w=(2.15e-07) l=4.5e-08 nf=1 \
        as=5.483e-14 ad=3.44e-14 ps=9.4e-07 pd=7.5e-07 nrd=1.16667 \
        nrs=1.16667 sa=3.45e-07 sb=2.55e-07 sd=160n sca=19.0975 \
        scb=0.0187686 scc=0.00166224 m=(1)
mp8 (n10 \4\:D \8\:VDD NW) g45p1svt w=(2.15e-07) l=4.5e-08 nf=1 \
        as=8.215e-14 ad=1.505e-14 ps=1.53e-06 pd=5.7e-07 nrd=1.16667 \
        nrs=1.16667 sa=1.7e-07 sb=1.985e-06 sd=160n sca=24.8095 \
        scb=0.0224988 scc=0.00280688 m=(1)
mp9 (\4\:n1 \2\:S0b n10 NW) g45p1svt w=(2.15e-07) l=4.5e-08 nf=1 \
        as=1.505e-14 ad=3.44e-14 ps=5.7e-07 pd=7.5e-07 nrd=1.16667 \
        nrs=1.16667 sa=2.85e-07 sb=1.87e-06 sd=160n sca=24.8095 \
        scb=0.0224988 scc=0.00280688 m=(1)
mp7 (\4\:n1 \2\:S0 n8 NW) g45p1svt w=(2.15e-07) l=4.5e-08 nf=1 \
        as=4.085e-14 ad=3.44e-14 ps=8.1e-07 pd=7.5e-07 nrd=1.16667 \
        nrs=1.16667 sa=4.9e-07 sb=1.665e-06 sd=160n sca=24.8095 \
        scb=0.0224988 scc=0.00280688 m=(1)
mp6 (n8 \3\:C \6\:VDD NW) g45p1svt w=(2.15e-07) l=4.5e-08 nf=1 \
        as=9.59e-14 ad=4.085e-14 ps=2.09e-06 pd=8.1e-07 nrd=1.16667 \
        nrs=1.16667 sa=7.25e-07 sb=1.43e-06 sd=160n sca=24.8095 \
        scb=0.0224988 scc=0.00280688 m=(1)
mp4 (n6 \1\:B \6\:VDD NW) g45p1svt w=(2.15e-07) l=4.5e-08 nf=1 \
        as=9.59e-14 ad=2.365e-14 ps=2.09e-06 pd=6.5e-07 nrd=1.16667 \
        nrs=1.16667 sa=1.07e-06 sb=1.085e-06 sd=160n sca=24.8095 \
        scb=0.0224988 scc=0.00280688 m=(1)
mp5 (\3\:n0 \5\:S0b n6 NW) g45p1svt w=(2.15e-07) l=4.5e-08 nf=1 \
        as=2.365e-14 ad=4.73e-14 ps=6.5e-07 pd=8.7e-07 nrd=1.16667 \
        nrs=1.16667 sa=1.225e-06 sb=9.3e-07 sd=160n sca=24.8095 \
        scb=0.0224988 scc=0.00280688 m=(1)
mp3 (\3\:n0 \7\:S0 n4 NW) g45p1svt w=(2.15e-07) l=4.5e-08 nf=1 \
        as=5.16e-14 ad=4.73e-14 ps=9.1e-07 pd=8.7e-07 nrd=1.16667 \
        nrs=1.16667 sa=1.49e-06 sb=6.65e-07 sd=160n sca=25.0948 \
        scb=0.0225758 scc=0.00280689 m=(1)
mp2 (n4 \1\:A \1\:VDD NW) g45p1svt w=(2.15e-07) l=4.5e-08 nf=1 \
        as=4.192e-14 ad=5.16e-14 ps=8.2e-07 pd=9.1e-07 nrd=1.16667 \
        nrs=1.16667 sa=1.775e-06 sb=3.8e-07 sd=160n sca=26.5217 \
        scb=0.023809 scc=0.00280989 m=(1)
mp0 (\13\:S0b \8\:S0 \1\:VDD NW) g45p1svt w=(2.15e-07) l=4.5e-08 nf=1 \
        as=4.192e-14 ad=3.01e-14 ps=8.2e-07 pd=7.1e-07 nrd=1.16667 \
        nrs=1.16667 sa=2e-06 sb=1.4e-07 sd=160n sca=31.0858 scb=0.0314787 \
        scc=0.00302884 m=(1)
C1 (Y VSS) capacitor c=2.43711e-17
C2 (S1 VSS) capacitor c=4.50705e-17
C3 (NW VSS) capacitor c=5.92086e-16
C4 (S0 VSS) capacitor c=2.8628e-17
C5 (VDD VSS) capacitor c=3.42042e-17
C6 (C VSS) capacitor c=6.55919e-17
C7 (D VSS) capacitor c=7.66563e-17
C8 (A VSS) capacitor c=9.15232e-17
C9 (n2 VSS) capacitor c=4.38006e-17
C10 (S1b VSS) capacitor c=4.88259e-17
C11 (n1 VSS) capacitor c=4.56115e-17
C12 (n0 VSS) capacitor c=8.60591e-17
C13 (n9 VSS) capacitor c=3.69657e-18
C14 (S0b VSS) capacitor c=5.79165e-17
C15 (n5 VSS) capacitor c=1.47257e-18
C16 (n3 VSS) capacitor c=3.08146e-20
C17 (n10 VSS) capacitor c=1.03247e-18
C18 (n8 VSS) capacitor c=8.51558e-19
C19 (n4 VSS) capacitor c=2.23739e-18
C20 (\8\:S0 VSS) capacitor c=2.65022e-17
C21 (\1\:A VSS) capacitor c=4.81467e-17
C22 (\7\:S0 VSS) capacitor c=2.62778e-17
C23 (\5\:S0b VSS) capacitor c=4.70601e-17
C24 (\1\:B VSS) capacitor c=4.34423e-17
C25 (\3\:C VSS) capacitor c=3.43759e-17
C26 (\2\:S0 VSS) capacitor c=6.48719e-17
C27 (\2\:S0b VSS) capacitor c=5.81515e-17
C28 (\4\:D VSS) capacitor c=4.71591e-17
C29 (\1\:S1 VSS) capacitor c=6.23696e-17
C30 (\4\:S1 VSS) capacitor c=3.26766e-17
C31 (\10\:S0 VSS) capacitor c=4.28489e-17
C32 (\3\:A VSS) capacitor c=5.76751e-17
C33 (\7\:S0b VSS) capacitor c=8.60641e-17
C34 (\6\:S0 VSS) capacitor c=5.66638e-17
C35 (\3\:B VSS) capacitor c=3.9343e-17
C36 (\1\:C VSS) capacitor c=6.64482e-17
C37 (\3\:S0b VSS) capacitor c=6.83801e-17
C38 (\1\:S0 VSS) capacitor c=8.51597e-17
C39 (\1\:D VSS) capacitor c=3.16554e-17
C40 (\3\:S1b VSS) capacitor c=3.82413e-17
C41 (\5\:S1 VSS) capacitor c=3.26768e-17
C42 (\6\:S1 VSS) capacitor c=3.33789e-17
C43 (\3\:n2 VSS) capacitor c=2.23488e-17
C44 (\9\:S0 VSS) capacitor c=3.92726e-17
C45 (\2\:A VSS) capacitor c=6.05779e-17
C46 (\4\:S0 VSS) capacitor c=3.37964e-17
C47 (\8\:S0b VSS) capacitor c=3.11579e-17
C48 (\6\:S0b VSS) capacitor c=4.0546e-17
C49 (\2\:B VSS) capacitor c=4.34067e-17
C50 (\2\:C VSS) capacitor c=6.04384e-17
C51 (\4\:S0b VSS) capacitor c=5.92279e-17
C52 (\3\:S0 VSS) capacitor c=2.69855e-17
C53 (\3\:D VSS) capacitor c=1.83359e-17
C54 (\4\:S1b VSS) capacitor c=3.6733e-17
C55 (\2\:S1b VSS) capacitor c=1.98895e-17
C56 (\3\:S1 VSS) capacitor c=4.0668e-17
C57 (\2\:n2 VSS) capacitor c=2.94039e-17
C58 (\13\:S0b VSS) capacitor c=6.04691e-17
C59 (\1\:VDD VSS) capacitor c=1.49615e-16
C60 (\3\:n0 VSS) capacitor c=2.56203e-16
C61 (\6\:VDD VSS) capacitor c=3.45288e-17
C62 (\4\:n1 VSS) capacitor c=8.07526e-17
C63 (\8\:VDD VSS) capacitor c=3.39864e-17
C64 (\5\:n0 VSS) capacitor c=1.98625e-16
C65 (\4\:n2 VSS) capacitor c=2.59748e-16
C66 (\8\:n1 VSS) capacitor c=7.47597e-17
C67 (\7\:S1b VSS) capacitor c=1.12629e-16
C68 (\10\:VDD VSS) capacitor c=2.36917e-17
C69 (\3\:Y VSS) capacitor c=2.268e-17
C70 (\9\:S0b VSS) capacitor c=1.21933e-17
C71 (\7\:n0 VSS) capacitor c=6.91849e-17
C72 (\7\:n2 VSS) capacitor c=6.51371e-17
C73 (\6\:n1 VSS) capacitor c=1.3198e-16
C74 (\9\:S1b VSS) capacitor c=8.94536e-17
C75 (\1\:Y VSS) capacitor c=6.03537e-17
C76 (\2\:S1 VSS) capacitor c=5.41315e-17
C77 (\2\:D VSS) capacitor c=4.20024e-17
C78 (\5\:S0 VSS) capacitor c=5.90507e-17
C79 (\7\:S1 VSS) capacitor c=6.78369e-17
C80 (\6\:n2 VSS) capacitor c=2.29154e-16
C81 (\5\:S1b VSS) capacitor c=1.22086e-16
C82 (\6\:S1b VSS) capacitor c=1.31767e-16
C83 (\5\:D VSS) capacitor c=3.70003e-17
C84 (\3\:n1 VSS) capacitor c=1.81031e-16
C85 (\4\:C VSS) capacitor c=4.32301e-17
C86 (\4\:B VSS) capacitor c=1.12813e-16
C87 (\11\:S0 VSS) capacitor c=3.30443e-17
C88 (\12\:S0 VSS) capacitor c=1.35372e-16
C89 (\13\:S0 VSS) capacitor c=2.09218e-16
C90 (\4\:A VSS) capacitor c=5.3019e-17
C91 (\11\:S0b VSS) capacitor c=1.1545e-16
C92 (\12\:S0b VSS) capacitor c=1.36198e-16
C93 (\15\:S0b VSS) capacitor c=7.83175e-17
C94 (\16\:S0b VSS) capacitor c=7.72241e-17
C95 (\17\:S0b VSS) capacitor c=5.65528e-17
C96 (\18\:S0b VSS) capacitor c=2.26852e-17
C97 (\3\:VDD VSS) capacitor c=1.41041e-16
C98 (\4\:VDD VSS) capacitor c=1.34565e-16
C99 (\5\:VDD VSS) capacitor c=9.86447e-17
Rk1 (\2\:Y Y) resistor r=0.2486 c=0
Rk2 (Y \4\:Y) resistor r=0.06089 c=0
Rk3 (\7\:S1 S1) resistor r=0.1247 c=0
Rk15 (B \4\:B) resistor r=0.008026 c=0
Rk20 (\11\:S0 S0) resistor r=0.02706 c=0
Rk19 (\11\:S0 \12\:S0) resistor r=0.2477 c=0
Rk21 (\12\:S0 \13\:S0) resistor r=1.314 c=0
Rk32 (\2\:VDD \3\:VDD) resistor r=0.8862 c=0
Rk33 (\3\:VDD \4\:VDD) resistor r=0.4452 c=0
Rk35 (\5\:VDD VDD) resistor r=0.1175 c=0
Rk34 (\4\:VDD \5\:VDD) resistor r=0.7898 c=0
Rk36 (\3\:VDD \7\:VDD) resistor r=0.04333 c=0
Rk37 (\4\:VDD \9\:VDD) resistor r=0.1278 c=0
Rk38 (\5\:VDD \11\:VDD) resistor r=0.225 c=0
Rk14 (C \4\:C) resistor r=0.1893 c=0
Rk9 (D \5\:D) resistor r=0.07516 c=0
Rk24 (\4\:A A) resistor r=0.05441 c=0
Rk39 (\2\:VSS \4\:VSS) resistor r=0.4194 c=0
Rk40 (\4\:VSS \5\:VSS) resistor r=0.2758 c=0
Rk41 (\5\:VSS \6\:VSS) resistor r=0.3809 c=0
Rk42 (\6\:VSS \7\:VSS) resistor r=0.3962 c=0
Rk44 (\8\:VSS VSS) resistor r=0.1175 c=0
Rk43 (\7\:VSS \8\:VSS) resistor r=0.4338 c=0
Rk45 (\5\:VSS \10\:VSS) resistor r=0.235 c=0
Rk46 (\6\:VSS \12\:VSS) resistor r=0.2303 c=0
Rk47 (\8\:VSS \14\:VSS) resistor r=0.07416 c=0
Rk4 (\5\:n2 \6\:n2) resistor r=1.721 c=0
Rk5 (\5\:n2 \8\:n2) resistor r=0.3677 c=0
Rk6 (\5\:S1b \6\:S1b) resistor r=0.6762 c=0
Rk7 (\6\:S1b \8\:S1b) resistor r=0.5886 c=0
Rk8 (\8\:S1b \10\:S1b) resistor r=0.4207 c=0
Rk10 (\2\:n1 \3\:n1) resistor r=0.3281 c=0
Rk11 (\3\:n1 \5\:n1) resistor r=0.4304 c=0
Rk12 (\3\:n1 \7\:n1) resistor r=0.944 c=0
Rk13 (\7\:n1 \9\:n1) resistor r=0.3878 c=0
Rk16 (\2\:n0 \4\:n0) resistor r=0.5144 c=0
Rk17 (\4\:n0 \6\:n0) resistor r=1.5187 c=0
Rk18 (\6\:n0 \8\:n0) resistor r=0.3984 c=0
Rk25 (\10\:S0b \11\:S0b) resistor r=0.04478 c=0
Rk26 (\11\:S0b \12\:S0b) resistor r=0.5759 c=0
Rk27 (\11\:S0b \14\:S0b) resistor r=0.5839 c=0
Rk28 (\12\:S0b \15\:S0b) resistor r=0.591 c=0
Rk29 (\15\:S0b \16\:S0b) resistor r=0.4074 c=0
Rk30 (\16\:S0b \17\:S0b) resistor r=0.2894 c=0
Rk31 (\15\:S0b \18\:S0b) resistor r=0.06119 c=0
Rl6 (\3\:S1 \4\:S1) resistor r=22.4021 c=0
Rl8 (\3\:S1 \6\:S1) resistor r=82.5403 c=0
Rl4 (\1\:S1 \2\:S1) resistor r=139.928 c=0
Rl7 (\2\:S1 \5\:S1) resistor r=30.4507 c=0
Rl5 (\2\:S1 \3\:S1) resistor r=219.844 c=0
Rl19 (\1\:B \2\:B) resistor r=29.5379 c=0
Rl20 (\2\:B \3\:B) resistor r=133.384 c=0
Rl14 (\1\:S0 \2\:S0) resistor r=193.864 c=0
Rl28 (\8\:S0 \9\:S0) resistor r=30.7692 c=0
Rl29 (\9\:S0 \10\:S0) resistor r=132.881 c=0
Rl15 (\2\:S0 \3\:S0) resistor r=98.7687 c=0
Rl25 (\5\:S0 \7\:S0) resistor r=34.3295 c=0
Rl24 (\5\:S0 \6\:S0) resistor r=197.357 c=0
Rl23 (\4\:S0 \5\:S0) resistor r=14.6916 c=0
Rl18 (\2\:C \3\:C) resistor r=37.6944 c=0
Rl17 (\1\:C \2\:C) resistor r=134.169 c=0
Rl12 (\2\:D \4\:D) resistor r=81.5719 c=0
Rl10 (\1\:D \2\:D) resistor r=109.984 c=0
Rl11 (\2\:D \3\:D) resistor r=10.9341 c=0
Rl26 (\1\:A \2\:A) resistor r=103.846 c=0
Rl27 (\2\:A \3\:A) resistor r=60.989 c=0
Rl1 (n2 \2\:n2) resistor r=79.5379 c=0
Rl2 (\2\:n2 \3\:n2) resistor r=29.5379 c=0
Rl9 (\3\:S1b \4\:S1b) resistor r=24.2328 c=0
Rl3 (S1b \2\:S1b) resistor r=60.3072 c=0
Rl22 (\7\:S0b \8\:S0b) resistor r=31.9251 c=0
Rl21 (\5\:S0b \6\:S0b) resistor r=71.8456 c=0
Rl16 (\3\:S0b \4\:S0b) resistor r=58.8482 c=0
Rl13 (S0b \2\:S0b) resistor r=60.819 c=0
Rz1 (\1\:Y \2\:Y) resistor r=75 c=0
Rz9 (\1\:VSS \2\:VSS) resistor r=75 c=0
Rz10 (\9\:VSS \10\:VSS) resistor r=75 c=0
Rz11 (\11\:VSS \12\:VSS) resistor r=75 c=0
Rz12 (\13\:VSS \14\:VSS) resistor r=75 c=0
Rz2 (\7\:n2 \8\:n2) resistor r=75 c=0
Rz3 (\9\:S1b \10\:S1b) resistor r=75 c=0
Rz4 (n1 \2\:n1) resistor r=75 c=0
Rz5 (\6\:n1 \7\:n1) resistor r=75 c=0
Rz6 (n0 \2\:n0) resistor r=75 c=0
Rz7 (\7\:n0 \8\:n0) resistor r=75 c=0
Rz8 (\9\:S0b \10\:S0b) resistor r=75 c=0
Ry1 (\3\:Y \4\:Y) resistor r=62 c=0
Ry9 (\1\:VDD \2\:VDD) resistor r=62 c=0
Ry10 (\6\:VDD \7\:VDD) resistor r=62 c=0
Ry11 (\8\:VDD \9\:VDD) resistor r=62 c=0
Ry12 (\10\:VDD \11\:VDD) resistor r=62 c=0
Ry13 (\3\:VSS \4\:VSS) resistor r=6.8889 c=0
Ry14 (\3\:VSS \7\:VSS) resistor r=5.1667 c=0
Ry2 (\4\:n2 \5\:n2) resistor r=62 c=0
Ry3 (\7\:S1b \8\:S1b) resistor r=62 c=0
Ry4 (\4\:n1 \5\:n1) resistor r=62 c=0
Ry5 (\8\:n1 \9\:n1) resistor r=62 c=0
Ry6 (\3\:n0 \4\:n0) resistor r=62 c=0
Ry7 (\5\:n0 \6\:n0) resistor r=62 c=0
Ry8 (\13\:S0b \14\:S0b) resistor r=62 c=0
Rx1 (\3\:S1 \7\:S1) resistor r=45 c=0
Rx7 (\2\:B \4\:B) resistor r=45 c=0
Rx8 (\9\:S0 \11\:S0) resistor r=45 c=0
Rx9 (\4\:S0 \12\:S0) resistor r=45 c=0
Rx10 (\3\:S0 \13\:S0) resistor r=45 c=0
Rx6 (\2\:C \4\:C) resistor r=45 c=0
Rx5 (\3\:D \5\:D) resistor r=45 c=0
Rx11 (\2\:A \4\:A) resistor r=45 c=0
Rx2 (\2\:n2 \6\:n2) resistor r=45 c=0
Rx3 (\4\:S1b \5\:S1b) resistor r=45 c=0
Rx4 (\2\:S1b \6\:S1b) resistor r=45 c=0
Rx12 (\8\:S0b \12\:S0b) resistor r=45 c=0
Rx13 (\4\:S0b \16\:S0b) resistor r=45 c=0
Rx14 (S0b \17\:S0b) resistor r=45 c=0
Rx15 (\6\:S0b \18\:S0b) resistor r=45 c=0
mn12 (\1\:Y \3\:n2 \13\:VSS VSS) g45n1svt w=(1.45e-07) l=4.5e-08 nf=1 \
        as=5.8e-14 ad=2.03e-14 ps=1.54e-06 pd=5.7e-07 nrd=1.16667 \
        nrs=1.16667 sa=1.4e-07 sb=4.35e-07 sd=160n sca=11.7118 \
        scb=0.0116498 scc=0.000458536 m=(1)
mn1 (\9\:S1b \6\:S1 \13\:VSS VSS) g45n1svt w=(1.45e-07) l=4.5e-08 nf=1 \
        as=5.8e-14 ad=2.32e-14 ps=1.54e-06 pd=6.1e-07 nrd=1.16667 \
        nrs=1.16667 sa=4.15e-07 sb=1.6e-07 sd=160n sca=11.7118 \
        scb=0.0116498 scc=0.000458536 m=(1)
mn11 (\7\:n2 \5\:S1 \6\:n1 VSS) g45n1svt w=(1.45e-07) l=4.5e-08 nf=1 \
        as=2.03e-14 ad=2.61e-14 ps=5.7e-07 pd=6.5e-07 nrd=1.16667 \
        nrs=1.16667 sa=1.4e-07 sb=4.6e-07 sd=160n sca=23.279 scb=0.0230742 \
        scc=0.00267719 m=(1)
mn10 (\7\:n2 \3\:S1b \7\:n0 VSS) g45n1svt w=(1.45e-07) l=4.5e-08 nf=1 \
        as=3.407e-14 ad=2.61e-14 ps=7.6e-07 pd=6.5e-07 nrd=1.16667 \
        nrs=1.16667 sa=3.65e-07 sb=2.35e-07 sd=160n sca=23.279 \
        scb=0.0230742 scc=0.00267719 m=(1)
mn8 (n9 \1\:D \11\:VSS VSS) g45n1svt w=(1.45e-07) l=4.5e-08 nf=1 \
        as=2.03e-14 ad=2.465e-14 ps=5.7e-07 pd=6.3e-07 nrd=1.16667 \
        nrs=1.16667 sa=1.4e-07 sb=1.855e-06 sd=160n sca=8.42104 \
        scb=0.00632542 scc=0.000106623 m=(1)
mn9 (n1 \1\:S0 n9 VSS) g45n1svt w=(1.45e-07) l=4.5e-08 nf=1 as=2.465e-14 \
        ad=2.32e-14 ps=6.3e-07 pd=6.1e-07 nrd=1.16667 nrs=1.16667 \
        sa=3.55e-07 sb=1.64e-06 sd=160n sca=8.42104 scb=0.00632542 \
        scc=0.000106623 m=(1)
mn7 (n1 \3\:S0b n7 VSS) g45n1svt w=(1.45e-07) l=4.5e-08 nf=1 as=8.7e-15 \
        ad=2.32e-14 ps=4.1e-07 pd=6.1e-07 nrd=1.16667 nrs=1.16667 \
        sa=5.6e-07 sb=1.435e-06 sd=160n sca=8.42104 scb=0.00632542 \
        scc=0.000106623 m=(1)
mn6 (n7 \1\:C \9\:VSS VSS) g45n1svt w=(1.45e-07) l=4.5e-08 nf=1 \
        as=3.625e-14 ad=8.7e-15 ps=7.9e-07 pd=4.1e-07 nrd=1.16667 \
        nrs=1.16667 sa=6.65e-07 sb=1.33e-06 sd=160n sca=8.42104 \
        scb=0.00632542 scc=0.000106623 m=(1)
mn4 (n5 \3\:B \9\:VSS VSS) g45n1svt w=(1.45e-07) l=4.5e-08 nf=1 \
        as=3.625e-14 ad=2.827e-14 ps=7.9e-07 pd=6.8e-07 nrd=1.16667 \
        nrs=1.16667 sa=9.6e-07 sb=1.035e-06 sd=160n sca=8.42104 \
        scb=0.00632542 scc=0.000106623 m=(1)
mn5 (n0 \6\:S0 n5 VSS) g45n1svt w=(1.45e-07) l=4.5e-08 nf=1 as=2.827e-14 \
        ad=3.48e-14 ps=6.8e-07 pd=7.7e-07 nrd=1.16667 nrs=1.16667 \
        sa=1.2e-06 sb=7.95e-07 sd=160n sca=8.42104 scb=0.00632542 \
        scc=0.000106623 m=(1)
mn3 (n0 \7\:S0b n3 VSS) g45n1svt w=(1.45e-07) l=4.5e-08 nf=1 as=8.7e-15 \
        ad=3.48e-14 ps=4.1e-07 pd=7.7e-07 nrd=1.16667 nrs=1.16667 \
        sa=1.485e-06 sb=5.1e-07 sd=160n sca=8.42104 scb=0.00632542 \
        scc=0.000106623 m=(1)
mn2 (n3 \3\:A \1\:VSS VSS) g45n1svt w=(1.45e-07) l=4.5e-08 nf=1 \
        as=3.73e-14 ad=8.7e-15 ps=8.2e-07 pd=4.1e-07 nrd=1.16667 \
        nrs=1.16667 sa=1.59e-06 sb=4.05e-07 sd=160n sca=8.42104 \
        scb=0.00632542 scc=0.000106623 m=(1)
mn0 (\9\:S0b \10\:S0 \1\:VSS VSS) g45n1svt w=(1.45e-07) l=4.5e-08 nf=1 \
        as=3.73e-14 ad=2.03e-14 ps=8.2e-07 pd=5.7e-07 nrd=1.16667 \
        nrs=1.16667 sa=1.855e-06 sb=1.4e-07 sd=160n sca=8.42104 \
        scb=0.00632542 scc=0.000106623 m=(1)
ends MX4XL
// End of subcircuit definition.
