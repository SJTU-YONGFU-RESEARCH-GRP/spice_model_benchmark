// Generated for: spectre (May  1 11:30:25 2013 )
// Library name: gsclib045_backbias
// Cell name: NAND3X4
// View name: extracted

simulator lang=spectre

subckt NAND3X4 A B C NW VDD VSS Y
mp0_1__rcx (\1\:Y \2\:A \1\:VDD NW) g45p1svt w=(3.9e-07) l=4.5e-08 nf=1 \
        as=5.85e-14 ad=6.24e-14 ps=1.08e-06 pd=1.1e-06 nrd=1.16667 \
        nrs=1.16667 sa=1.4e-07 sb=2e-06 sd=160n sca=18.8021 scb=0.0193662 \
        scc=0.00077923 m=(4)
mp1_1__rcx (\1\:Y B \1\:VDD NW) g45p1svt w=(3.9e-07) l=4.5e-08 nf=1 \
        as=6.24e-14 ad=6.24e-14 ps=1.1e-06 pd=1.1e-06 nrd=1.16667 \
        nrs=1.16667 sa=3.45e-07 sb=2e-06 sd=160n sca=15.3235 scb=0.0135506 \
        scc=0.000650815 m=(4)
mp2_1__rcx (\1\:Y C \1\:VDD NW) g45p1svt w=(3.9e-07) l=4.5e-08 nf=1 \
        as=6.24e-14 ad=6.24e-14 ps=1.1e-06 pd=1.1e-06 nrd=1.16667 \
        nrs=1.16667 sa=5.5e-07 sb=1.985e-06 sd=160n sca=14.1261 \
        scb=0.0123878 scc=0.000647585 m=(4)
C1 (VDD VSS) capacitor c=2.81686e-17
C2 (C VSS) capacitor c=5.40321e-16
C3 (NW VSS) capacitor c=3.6682e-16
C4 (A VSS) capacitor c=2.47861e-17
C5 (Y VSS) capacitor c=9.60564e-17
C6 (B VSS) capacitor c=8.57005e-16
C7 (10 VSS) capacitor c=2.1232e-18
C8 (11 VSS) capacitor c=4.14367e-18
C9 (12 VSS) capacitor c=3.48423e-18
C10 (13 VSS) capacitor c=6.12528e-18
C11 (14 VSS) capacitor c=4.99533e-18
C12 (15 VSS) capacitor c=2.08455e-18
C13 (\12\:A VSS) capacitor c=6.64188e-17
C14 (\12\:B VSS) capacitor c=5.70988e-17
C15 (\14\:C VSS) capacitor c=3.36994e-17
C16 (\13\:C VSS) capacitor c=2.12773e-17
C17 (\9\:B VSS) capacitor c=5.72621e-17
C18 (\4\:A VSS) capacitor c=4.15997e-17
C19 (\6\:A VSS) capacitor c=5.08815e-17
C20 (\6\:B VSS) capacitor c=7.94352e-17
C21 (\1\:C VSS) capacitor c=4.42879e-17
C22 (\4\:C VSS) capacitor c=1.93258e-17
C23 (\3\:B VSS) capacitor c=5.69242e-17
C24 (\1\:A VSS) capacitor c=7.57093e-17
C25 (\2\:A VSS) capacitor c=7.79241e-16
C26 (\1\:VDD VSS) capacitor c=6.011e-16
C27 (\1\:Y VSS) capacitor c=5.85321e-16
C28 (\10\:Y VSS) capacitor c=1.62405e-16
C29 (\12\:Y VSS) capacitor c=1.09172e-16
C30 (\5\:A VSS) capacitor c=3.05678e-17
Rk30 (\1\:VDD VDD) resistor r=0.06978 c=0
Rk10 (\2\:A A) resistor r=0.0486 c=0
Rk38 (\3\:VSS VSS) resistor r=0.1199 c=0
Rk37 (\2\:VSS \3\:VSS) resistor r=0.2313 c=0
Rk39 (\3\:VSS \5\:VSS) resistor r=0.4312 c=0
Rk40 (\5\:VSS \6\:VSS) resistor r=0.1127 c=0
Rk41 (\6\:VSS \8\:VSS) resistor r=0.1028 c=0
Rk42 (\6\:VSS \9\:VSS) resistor r=0.5896 c=0
Rk43 (\9\:VSS \11\:VSS) resistor r=0.09884 c=0
Rk17 (\1\:Y Y) resistor r=0.213 c=0
Rk18 (Y \11\:Y) resistor r=0.8581 c=0
Rk19 (\11\:Y \13\:Y) resistor r=0.8133 c=0
Rl25 (C \14\:C) resistor r=99.7716 c=0
Rl24 (C \13\:C) resistor r=62.5704 c=0
Rl5 (C \1\:C) resistor r=26.9231 c=0
Rl7 (C \4\:C) resistor r=69.2184 c=0
Rl29 (\2\:A \12\:A) resistor r=99.7951 c=0
Rl1 (\2\:A \1\:A) resistor r=111.211 c=0
Rl13 (\5\:A \4\:A) resistor r=61.5164 c=0
Rl14 (\5\:A \6\:A) resistor r=94.2087 c=0
Rl15 (\5\:A \2\:A) resistor r=69.7363 c=0
Rl27 (B \12\:B) resistor r=29.5379 c=0
Rl19 (B \9\:B) resistor r=87.6374 c=0
Rl12 (B \6\:B) resistor r=87.2302 c=0
Rl4 (B \3\:B) resistor r=44.9225 c=0
Rz3 (\1\:VSS \2\:VSS) resistor r=75 c=0
Rz4 (\7\:VSS \8\:VSS) resistor r=75 c=0
Rz5 (\10\:VSS \11\:VSS) resistor r=75 c=0
Rz1 (\11\:Y \10\:Y) resistor r=75 c=0
Rz2 (\13\:Y \12\:Y) resistor r=75 c=0
Ry14 (\4\:VSS \5\:VSS) resistor r=5.1667 c=0
Ry15 (\4\:VSS \9\:VSS) resistor r=31 c=0
mn0_1__rcx (8 \1\:A \1\:VSS VSS) g45n1svt w=(2.6e-07) l=4.5e-08 nf=1 \
        as=3.64e-14 ad=1.56e-14 ps=8e-07 pd=6.4e-07 nrd=1.16667 \
        nrs=1.16667 sa=1.4e-07 sb=2e-06 sd=160n sca=10.79 scb=0.0100512 \
        scc=0.000418069 m=(1)
mn1_1__rcx (8 \3\:B 9 VSS) g45n1svt w=(2.6e-07) l=4.5e-08 nf=1 \
        as=6.76e-14 ad=1.56e-14 ps=1.04e-06 pd=6.4e-07 nrd=1.16667 \
        nrs=1.16667 sa=2.45e-07 sb=2e-06 sd=160n sca=10.79 scb=0.0100512 \
        scc=0.000418069 m=(1)
mn2_1__rcx (\12\:Y \4\:C 9 VSS) g45n1svt w=(2.6e-07) l=4.5e-08 nf=1 \
        as=6.76e-14 ad=4.16e-14 ps=1.04e-06 pd=8.4e-07 nrd=1.16667 \
        nrs=1.16667 sa=5.5e-07 sb=1.815e-06 sd=160n sca=10.79 \
        scb=0.0100512 scc=0.000418069 m=(1)
mn2_2__rcx (\12\:Y \1\:C 10 VSS) g45n1svt w=(2.6e-07) l=4.5e-08 nf=1 \
        as=1.56e-14 ad=4.16e-14 ps=6.4e-07 pd=8.4e-07 nrd=1.16667 \
        nrs=1.16667 sa=7.55e-07 sb=1.61e-06 sd=160n sca=10.79 \
        scb=0.0100512 scc=0.000418069 m=(1)
mn1_2__rcx (10 \6\:B 11 VSS) g45n1svt w=(2.6e-07) l=4.5e-08 nf=1 \
        as=2.99e-14 ad=1.56e-14 ps=7.5e-07 pd=6.4e-07 nrd=1.16667 \
        nrs=1.16667 sa=8.6e-07 sb=1.505e-06 sd=160n sca=10.79 \
        scb=0.0100512 scc=0.000418069 m=(1)
mn0_2__rcx (11 \6\:A \7\:VSS VSS) g45n1svt w=(2.6e-07) l=4.5e-08 nf=1 \
        as=8.54e-14 ad=2.99e-14 ps=1.43e-06 pd=7.5e-07 nrd=1.16667 \
        nrs=1.16667 sa=1.02e-06 sb=1.345e-06 sd=160n sca=10.79 \
        scb=0.0100512 scc=0.000418069 m=(1)
mn0_3__rcx (12 \4\:A \7\:VSS VSS) g45n1svt w=(2.6e-07) l=4.5e-08 nf=1 \
        as=8.54e-14 ad=2.47e-14 ps=1.43e-06 pd=7.1e-07 nrd=1.16667 \
        nrs=1.16667 sa=1.285e-06 sb=1.08e-06 sd=160n sca=10.79 \
        scb=0.0100512 scc=0.000418069 m=(1)
mn1_3__rcx (12 \9\:B 13 VSS) g45n1svt w=(2.6e-07) l=4.5e-08 nf=1 \
        as=4.94e-14 ad=2.47e-14 ps=9e-07 pd=7.1e-07 nrd=1.16667 \
        nrs=1.16667 sa=1.425e-06 sb=9.4e-07 sd=160n sca=10.79 \
        scb=0.0100512 scc=0.000418069 m=(1)
mn2_3__rcx (\10\:Y \13\:C 13 VSS) g45n1svt w=(2.6e-07) l=4.5e-08 nf=1 \
        as=4.94e-14 ad=4.16e-14 ps=9e-07 pd=8.4e-07 nrd=1.16667 \
        nrs=1.16667 sa=1.66e-06 sb=7.05e-07 sd=160n sca=10.79 \
        scb=0.0100512 scc=0.000418069 m=(1)
mn2 (\10\:Y \14\:C 14 VSS) g45n1svt w=(2.6e-07) l=4.5e-08 nf=1 \
        as=4.68e-14 ad=4.16e-14 ps=8.8e-07 pd=8.4e-07 nrd=1.16667 \
        nrs=1.16667 sa=1.865e-06 sb=5e-07 sd=160n sca=10.79 scb=0.0100512 \
        scc=0.000418069 m=(1)
mn1 (14 \12\:B 15 VSS) g45n1svt w=(2.6e-07) l=4.5e-08 nf=1 as=1.56e-14 \
        ad=4.68e-14 ps=6.4e-07 pd=8.8e-07 nrd=1.16667 nrs=1.16667 sa=2e-06 \
        sb=2.75e-07 sd=160n sca=10.79 scb=0.0100512 scc=0.000418069 m=(1)
mn0 (15 \12\:A \10\:VSS VSS) g45n1svt w=(2.6e-07) l=4.5e-08 nf=1 \
        as=7.24e-14 ad=1.56e-14 ps=1.33e-06 pd=6.4e-07 nrd=1.16667 \
        nrs=1.16667 sa=2e-06 sb=1.7e-07 sd=160n sca=10.79 scb=0.0100512 \
        scc=0.000418069 m=(1)
ends NAND3X4
// End of subcircuit definition.
