// Verilog-AMS netlist generated by the AMS netlister, version  ICADV12.1-64b.341 .
// Cadence Design Systems, Inc.

`include "disciplines.vams"

(* cds_ams_schematic *)
module XOR3X1 ( Y,.VDD(\VDD! ),A,B,C,.NW(\NW! ),
.VSS(\VSS! ) );

output   Y;
input  (*
integer inh_conn_prop_name = "VDD";
integer
inh_conn_def_value = "cds_globals.\\VDD! ";
 *)
 \VDD! ;
input   A;

input   B;
input   C;
input  (*
integer inh_conn_prop_name = "NW";

integer inh_conn_def_value = "cds_globals.\\NW! ";
integer
supplySensitivity = "VDD";
 *)
 \NW! ;
input  (*
integer
inh_conn_prop_name = "VSS";
integer inh_conn_def_value
 = "cds_globals.\\VSS! ";
 *)
 \VSS! ;

wire Y;
wire (*
integer inh_conn_prop_name = "VSS";
integer inh_conn_def_value
 = "cds_globals.\\VSS! ";
 *)
\VSS! ;
wire n50;
wire n56;
wire A;
wire B;
wire C;
wire n44;
wire (*
integer inh_conn_prop_name = "VDD";
integer inh_conn_def_value
 = "cds_globals.\\VDD! ";
 *)
\VDD! ;

g45n1svt #(.ad(26.6f), .nrd(736.842m), .sca(174.14966), .pd(660n), .scc(0.02167),
 .scb(0.11032), .as(26.6f), .nrs(736.842m), .m(1), .ps(660n), .w(190n),
 .sa(140n), .nf(1), .sb(140n), .sd(160n), .l(45n)) (*
integer
library_binding = "gpdk045";
integer passed_mfactor = "m";
 *)
mn3 (
n56, n60, n50, \VSS!  );
g45n1svt #(.ad(28.7f), .nrd(682.927m), .sca(166.60249), .pd(690n), .scc(0.02069),
 .scb(0.10864), .as(28.7f), .nrs(682.927m), .m(1), .ps(690n), .w(205n),
 .sa(140n), .nf(1), .sb(140n), .sd(160n), .l(45n)) (*
integer
library_binding = "gpdk045";
integer passed_mfactor = "m";
 *)
mn10 (
n62, A, \VSS! , \VSS!  );
g45n1svt #(.ad(26.6f), .nrd(736.842m), .sca(174.14966), .pd(660n), .scc(0.02167),
 .scb(0.11032), .as(26.6f), .nrs(736.842m), .m(1), .ps(660n), .w(190n),
 .sa(140n), .nf(1), .sb(140n), .sd(160n), .l(45n)) (*
integer
library_binding = "gpdk045";
integer passed_mfactor = "m";
 *)
mn4 (
n44, C, n50, \VSS!  );
g45n1svt #(.ad(26.6f), .nrd(736.842m), .sca(174.14966), .pd(660n), .scc(0.02167),
 .scb(0.11032), .as(26.6f), .nrs(736.842m), .m(1), .ps(660n), .w(190n),
 .sa(140n), .nf(1), .sb(140n), .sd(160n), .l(45n)) (*
integer
library_binding = "gpdk045";
integer passed_mfactor = "m";
 *)
mn8 (
n60, C, \VSS! , \VSS!  );
g45n1svt #(.ad(26.6f), .nrd(736.842m), .sca(174.14966), .pd(660n), .scc(0.02167),
 .scb(0.11032), .as(26.6f), .nrs(736.842m), .m(1), .ps(660n), .w(190n),
 .sa(140n), .nf(1), .sb(140n), .sd(160n), .l(45n)) (*
integer
library_binding = "gpdk045";
integer passed_mfactor = "m";
 *)
mn9 (
n61, B, \VSS! , \VSS!  );
g45n1svt #(.ad(26.6f), .nrd(736.842m), .sca(174.14966), .pd(660n), .scc(0.02167),
 .scb(0.11032), .as(26.6f), .nrs(736.842m), .m(1), .ps(660n), .w(190n),
 .sa(140n), .nf(1), .sb(140n), .sd(160n), .l(45n)) (*
integer
library_binding = "gpdk045";
integer passed_mfactor = "m";
 *)
mn6 (
n56, B, n11, \VSS!  );
g45n1svt #(.ad(28.7f), .nrd(682.927m), .sca(166.60249), .pd(690n), .scc(0.02069),
 .scb(0.10864), .as(28.7f), .nrs(682.927m), .m(1), .ps(690n), .w(205n),
 .sa(140n), .nf(1), .sb(140n), .sd(160n), .l(45n)) (*
integer
library_binding = "gpdk045";
integer passed_mfactor = "m";
 *)
mn1 (
n62, B, n44, \VSS!  );
g45n1svt #(.ad(26.6f), .nrd(736.842m), .sca(174.14966), .pd(660n), .scc(0.02167),
 .scb(0.11032), .as(26.6f), .nrs(736.842m), .m(1), .ps(660n), .w(190n),
 .sa(140n), .nf(1), .sb(140n), .sd(160n), .l(45n)) (*
integer
library_binding = "gpdk045";
integer passed_mfactor = "m";
 *)
mn2 (
n11, n61, n44, \VSS!  );
g45n1svt #(.ad(26.6f), .nrd(736.842m), .sca(174.14966), .pd(660n), .scc(0.02167),
 .scb(0.11032), .as(26.6f), .nrs(736.842m), .m(1), .ps(660n), .w(190n),
 .sa(140n), .nf(1), .sb(140n), .sd(160n), .l(45n)) (*
integer
library_binding = "gpdk045";
integer passed_mfactor = "m";
 *)
mn0 (
n11, n62, \VSS! , \VSS!  );
g45n1svt #(.ad(28.7f), .nrd(682.927m), .sca(166.60249), .pd(690n), .scc(0.02069),
 .scb(0.10864), .as(28.7f), .nrs(682.927m), .m(1), .ps(690n), .w(205n),
 .sa(140n), .nf(1), .sb(140n), .sd(160n), .l(45n)) (*
integer
library_binding = "gpdk045";
integer passed_mfactor = "m";
 *)
mn5 (
n62, n61, n56, \VSS!  );
g45n1svt #(.ad(28.7f), .nrd(682.927m), .sca(166.60249), .pd(690n), .scc(0.02069),
 .scb(0.10864), .as(28.7f), .nrs(682.927m), .m(1), .ps(690n), .w(205n),
 .sa(140n), .nf(1), .sb(140n), .sd(160n), .l(45n)) (*
integer
library_binding = "gpdk045";
integer passed_mfactor = "m";
 *)
mn7 ( Y,
n50, \VSS! , \VSS!  );

g45p1svt #(.ad(54.6f), .nrd(358.974m), .sca(114.89040), .pd(1.06u), .scc(0.01377),
 .scb(0.09003), .as(54.6f), .nrs(358.974m), .m(1), .ps(1.06u), .w(390n),
 .sa(140n), .nf(1), .sb(140n), .sd(160n), .l(45n)) (*
integer
library_binding = "gpdk045";
integer passed_mfactor = "m";
 *)
mp10 (
n62, A, \VDD! , \NW!  );
g45p1svt #(.ad(54.6f), .nrd(358.974m), .sca(114.89040), .pd(1.06u), .scc(0.01377),
 .scb(0.09003), .as(54.6f), .nrs(358.974m), .m(1), .ps(1.06u), .w(390n),
 .sa(140n), .nf(1), .sb(140n), .sd(160n), .l(45n)) (*
integer
library_binding = "gpdk045";
integer passed_mfactor = "m";
 *)
mp1 (
n44, n61, n62, \NW!  );
g45p1svt #(.ad(54.6f), .nrd(358.974m), .sca(114.89040), .pd(1.06u), .scc(0.01377),
 .scb(0.09003), .as(54.6f), .nrs(358.974m), .m(1), .ps(1.06u), .w(390n),
 .sa(140n), .nf(1), .sb(140n), .sd(160n), .l(45n)) (*
integer
library_binding = "gpdk045";
integer passed_mfactor = "m";
 *)
mp7 ( Y,
n50, \VDD! , \NW!  );
g45p1svt #(.ad(43.4f), .nrd(451.613m), .sca(130.90642), .pd(900n), .scc(0.01590),
 .scb(0.09728), .as(43.4f), .nrs(451.613m), .m(1), .ps(900n), .w(310n),
 .sa(140n), .nf(1), .sb(140n), .sd(160n), .l(45n)) (*
integer
library_binding = "gpdk045";
integer passed_mfactor = "m";
 *)
mp2 (
n44, B, n11, \NW!  );
g45p1svt #(.ad(43.4f), .nrd(451.613m), .sca(130.90642), .pd(900n), .scc(0.01590),
 .scb(0.09728), .as(43.4f), .nrs(451.613m), .m(1), .ps(900n), .w(310n),
 .sa(140n), .nf(1), .sb(140n), .sd(160n), .l(45n)) (*
integer
library_binding = "gpdk045";
integer passed_mfactor = "m";
 *)
mp9 (
n61, B, \VDD! , \NW!  );
g45p1svt #(.ad(43.4f), .nrd(451.613m), .sca(130.90642), .pd(900n), .scc(0.01590),
 .scb(0.09728), .as(43.4f), .nrs(451.613m), .m(1), .ps(900n), .w(310n),
 .sa(140n), .nf(1), .sb(140n), .sd(160n), .l(45n)) (*
integer
library_binding = "gpdk045";
integer passed_mfactor = "m";
 *)
mp3 (
n50, C, n56, \NW!  );
g45p1svt #(.ad(43.4f), .nrd(451.613m), .sca(130.90642), .pd(900n), .scc(0.01590),
 .scb(0.09728), .as(43.4f), .nrs(451.613m), .m(1), .ps(900n), .w(310n),
 .sa(140n), .nf(1), .sb(140n), .sd(160n), .l(45n)) (*
integer
library_binding = "gpdk045";
integer passed_mfactor = "m";
 *)
mp8 (
n60, C, \VDD! , \NW!  );
g45p1svt #(.ad(43.4f), .nrd(451.613m), .sca(130.90642), .pd(900n), .scc(0.01590),
 .scb(0.09728), .as(43.4f), .nrs(451.613m), .m(1), .ps(900n), .w(310n),
 .sa(140n), .nf(1), .sb(140n), .sd(160n), .l(45n)) (*
integer
library_binding = "gpdk045";
integer passed_mfactor = "m";
 *)
mp4 (
n50, n60, n44, \NW!  );
g45p1svt #(.ad(43.4f), .nrd(451.613m), .sca(130.90642), .pd(900n), .scc(0.01590),
 .scb(0.09728), .as(43.4f), .nrs(451.613m), .m(1), .ps(900n), .w(310n),
 .sa(140n), .nf(1), .sb(140n), .sd(160n), .l(45n)) (*
integer
library_binding = "gpdk045";
integer passed_mfactor = "m";
 *)
mp0 (
n11, n62, \VDD! , \NW!  );
g45p1svt #(.ad(43.4f), .nrd(451.613m), .sca(130.90642), .pd(900n), .scc(0.01590),
 .scb(0.09728), .as(43.4f), .nrs(451.613m), .m(1), .ps(900n), .w(310n),
 .sa(140n), .nf(1), .sb(140n), .sd(160n), .l(45n)) (*
integer
library_binding = "gpdk045";
integer passed_mfactor = "m";
 *)
mp6 (
n11, n61, n56, \NW!  );
g45p1svt #(.ad(54.6f), .nrd(358.974m), .sca(114.89040), .pd(1.06u), .scc(0.01377),
 .scb(0.09003), .as(54.6f), .nrs(358.974m), .m(1), .ps(1.06u), .w(390n),
 .sa(140n), .nf(1), .sb(140n), .sd(160n), .l(45n)) (*
integer
library_binding = "gpdk045";
integer passed_mfactor = "m";
 *)
mp5 (
n56, B, n62, \NW!  );

endmodule
