// Verilog-AMS netlist generated by the AMS netlister, version  ICADV12.1-64b.341 .
// Cadence Design Systems, Inc.

`include "disciplines.vams"

(* cds_ams_schematic *)
module AND4X4 ( Y,.VDD(\VDD! ),A,B,C,D,.NW(
\NW! ),.VSS(\VSS! ) );

output   Y;
input  (*
integer inh_conn_prop_name = "VDD";
integer
inh_conn_def_value = "cds_globals.\\VDD! ";
 *)
 \VDD! ;
input   A;

input   B;
input   C;
input   D;
input  (*
integer inh_conn_prop_name
 = "NW";
integer inh_conn_def_value = "cds_globals.\\NW! ";
integer
supplySensitivity = "VDD";
 *)
 \NW! ;
input  (*
integer
inh_conn_prop_name = "VSS";
integer inh_conn_def_value
 = "cds_globals.\\VSS! ";
 *)
 \VSS! ;

wire Y;
wire (*
integer inh_conn_prop_name = "VSS";
integer inh_conn_def_value
 = "cds_globals.\\VSS! ";
 *)
\VSS! ;
wire net132;
wire A;
wire B;
wire C;
wire D;
wire net124;
wire net120;
wire (*
integer inh_conn_prop_name = "VDD";
integer inh_conn_def_value
 = "cds_globals.\\VDD! ";
 *)
\VDD! ;
wire net100;

g45n1svt #(.ad(36.4f), .nrd(538.462m), .sca(144.98299), .pd(800n), .scc(0.01780),
 .scb(0.10251), .as(36.4f), .nrs(538.462m), .m(1), .ps(800n), .w(260n),
 .sa(140n), .nf(1), .sb(140n), .sd(160n), .l(45n)) (*
integer
library_binding = "gpdk045";
integer passed_mfactor = "m";
 *)
mn3 (
net100, D, net132, \VSS!  );
g45n1svt #(.ad(36.4f), .nrd(538.462m), .sca(144.98299), .pd(800n), .scc(0.01780),
 .scb(0.10251), .as(36.4f), .nrs(538.462m), .m(1), .ps(800n), .w(260n),
 .sa(140n), .nf(1), .sb(140n), .sd(160n), .l(45n)) (*
integer
library_binding = "gpdk045";
integer passed_mfactor = "m";
 *)
mn2 (
net132, C, net124, \VSS!  );
g45n1svt #(.ad(145.6f), .nrd(134.615m), .sca(71.11936), .pd(2.36u), .scc(0.00848),
 .scb(0.06501), .as(145.6f), .nrs(134.615m), .m(1), .ps(2.36u), .w(1.04u),
 .sa(140n), .nf(1), .sb(140n), .sd(160n), .l(45n)) (*
integer
library_binding = "gpdk045";
integer passed_mfactor = "m";
 *)
mn4 ( Y,
net100, \VSS! , \VSS!  );
g45n1svt #(.ad(36.4f), .nrd(538.462m), .sca(144.98299), .pd(800n), .scc(0.01780),
 .scb(0.10251), .as(36.4f), .nrs(538.462m), .m(1), .ps(800n), .w(260n),
 .sa(140n), .nf(1), .sb(140n), .sd(160n), .l(45n)) (*
integer
library_binding = "gpdk045";
integer passed_mfactor = "m";
 *)
mn1 (
net124, B, net120, \VSS!  );
g45n1svt #(.ad(36.4f), .nrd(538.462m), .sca(144.98299), .pd(800n), .scc(0.01780),
 .scb(0.10251), .as(36.4f), .nrs(538.462m), .m(1), .ps(800n), .w(260n),
 .sa(140n), .nf(1), .sb(140n), .sd(160n), .l(45n)) (*
integer
library_binding = "gpdk045";
integer passed_mfactor = "m";
 *)
mn0 (
net120, A, \VSS! , \VSS!  );

g45p1svt #(.ad(54.6f), .nrd(358.974m), .sca(114.89040), .pd(1.06u), .scc(0.01377),
 .scb(0.09003), .as(54.6f), .nrs(358.974m), .m(1), .ps(1.06u), .w(390n),
 .sa(140n), .nf(1), .sb(140n), .sd(160n), .l(45n)) (*
integer
library_binding = "gpdk045";
integer passed_mfactor = "m";
 *)
mp3 (
net100, D, \VDD! , \NW!  );
g45p1svt #(.ad(54.6f), .nrd(358.974m), .sca(114.89040), .pd(1.06u), .scc(0.01377),
 .scb(0.09003), .as(54.6f), .nrs(358.974m), .m(1), .ps(1.06u), .w(390n),
 .sa(140n), .nf(1), .sb(140n), .sd(160n), .l(45n)) (*
integer
library_binding = "gpdk045";
integer passed_mfactor = "m";
 *)
mp2 (
net100, C, \VDD! , \NW!  );
g45p1svt #(.ad(54.6f), .nrd(358.974m), .sca(114.89040), .pd(1.06u), .scc(0.01377),
 .scb(0.09003), .as(54.6f), .nrs(358.974m), .m(1), .ps(1.06u), .w(390n),
 .sa(140n), .nf(1), .sb(140n), .sd(160n), .l(45n)) (*
integer
library_binding = "gpdk045";
integer passed_mfactor = "m";
 *)
mp1 (
net100, B, \VDD! , \NW!  );
g45p1svt #(.ad(218.4f), .nrd(89.7436m), .sca(61.39246), .pd(3.4u), .scc(0.00742),
 .scb(0.05939), .as(218.4f), .nrs(89.7436m), .m(1), .ps(3.4u), .w(1.56u),
 .sa(140n), .nf(1), .sb(140n), .sd(160n), .l(45n)) (*
integer
library_binding = "gpdk045";
integer passed_mfactor = "m";
 *)
mp4 ( Y,
net100, \VDD! , \NW!  );
g45p1svt #(.ad(54.6f), .nrd(358.974m), .sca(114.89040), .pd(1.06u), .scc(0.01377),
 .scb(0.09003), .as(54.6f), .nrs(358.974m), .m(1), .ps(1.06u), .w(390n),
 .sa(140n), .nf(1), .sb(140n), .sd(160n), .l(45n)) (*
integer
library_binding = "gpdk045";
integer passed_mfactor = "m";
 *)
mp0 (
net100, A, \VDD! , \NW!  );

endmodule
