// Verilog-AMS netlist generated by the AMS netlister, version  ICADV12.1-64b.341 .
// Cadence Design Systems, Inc.

`include "disciplines.vams"

(* cds_ams_schematic *)
module AND2XL ( Y,.VDD(\VDD! ),A,B,.NW(\NW! ),
.VSS(\VSS! ) );

output   Y;
input  (*
integer inh_conn_prop_name = "VDD";
integer
inh_conn_def_value = "cds_globals.\\VDD! ";
 *)
 \VDD! ;
input   A;

input   B;
input  (*
integer inh_conn_prop_name = "NW";
integer
inh_conn_def_value = "cds_globals.\\NW! ";
integer supplySensitivity
 = "VDD";
 *)
 \NW! ;
input  (*
integer inh_conn_prop_name = "VSS";

integer inh_conn_def_value = "cds_globals.\\VSS! ";
 *)
 \VSS! ;

wire Y;
wire (*
integer inh_conn_prop_name = "VSS";
integer inh_conn_def_value
 = "cds_globals.\\VSS! ";
 *)
\VSS! ;
wire A;
wire B;
wire net57;
wire (*
integer inh_conn_prop_name = "VDD";
integer inh_conn_def_value
 = "cds_globals.\\VDD! ";
 *)
\VDD! ;

g45n1svt #(.ad(20.3f), .nrd(965.517m), .sca(203.41795), .pd(570n), .scc(0.02523),
 .scb(0.11509), .as(20.3f), .nrs(965.517m), .m(1), .ps(570n), .w(145n),
 .sa(140n), .nf(1), .sb(140n), .sd(160n), .l(45n)) (*
integer
library_binding = "gpdk045";
integer passed_mfactor = "m";
 *)
mn2 ( Y,
net57, \VSS! , \VSS!  );
g45n1svt #(.ad(20.3f), .nrd(965.517m), .sca(203.41795), .pd(570n), .scc(0.02523),
 .scb(0.11509), .as(20.3f), .nrs(965.517m), .m(1), .ps(570n), .w(145n),
 .sa(140n), .nf(1), .sb(140n), .sd(160n), .l(45n)) (*
integer
library_binding = "gpdk045";
integer passed_mfactor = "m";
 *)
mn0 (
net73, A, \VSS! , \VSS!  );
g45n1svt #(.ad(20.3f), .nrd(965.517m), .sca(203.41795), .pd(570n), .scc(0.02523),
 .scb(0.11509), .as(20.3f), .nrs(965.517m), .m(1), .ps(570n), .w(145n),
 .sa(140n), .nf(1), .sb(140n), .sd(160n), .l(45n)) (*
integer
library_binding = "gpdk045";
integer passed_mfactor = "m";
 *)
mn1 (
net57, B, net73, \VSS!  );

g45p1svt #(.ad(30.1f), .nrd(651.163m), .sca(162.02845), .pd(710n), .scc(0.02009),
 .scb(0.10751), .as(30.1f), .nrs(651.163m), .m(1), .ps(710n), .w(215n),
 .sa(140n), .nf(1), .sb(140n), .sd(160n), .l(45n)) (*
integer
library_binding = "gpdk045";
integer passed_mfactor = "m";
 *)
mp1 (
net57, B, \VDD! , \NW!  );
g45p1svt #(.ad(30.1f), .nrd(651.163m), .sca(162.02845), .pd(710n), .scc(0.02009),
 .scb(0.10751), .as(30.1f), .nrs(651.163m), .m(1), .ps(710n), .w(215n),
 .sa(140n), .nf(1), .sb(140n), .sd(160n), .l(45n)) (*
integer
library_binding = "gpdk045";
integer passed_mfactor = "m";
 *)
mp0 (
net57, A, \VDD! , \NW!  );
g45p1svt #(.ad(30.1f), .nrd(651.163m), .sca(162.02845), .pd(710n), .scc(0.02009),
 .scb(0.10751), .as(30.1f), .nrs(651.163m), .m(1), .ps(710n), .w(215n),
 .sa(140n), .nf(1), .sb(140n), .sd(160n), .l(45n)) (*
integer
library_binding = "gpdk045";
integer passed_mfactor = "m";
 *)
mp2 ( Y,
net57, \VDD! , \NW!  );

endmodule
