// Verilog-AMS netlist generated by the AMS netlister, version  ICADV12.1-64b.341 .
// Cadence Design Systems, Inc.

`include "disciplines.vams"

(* cds_ams_schematic *)
module MXI4X4 ( Y,.VDD(\VDD! ),S1,A,S0,B,C,D,.
NW(\NW! ),.VSS(\VSS! ) );

output   Y;
input  (*
integer inh_conn_prop_name = "VDD";
integer
inh_conn_def_value = "cds_globals.\\VDD! ";
 *)
 \VDD! ;
input   S1;

input   A;
input   S0;
input   B;
input   C;
input   D;
input  (*

integer inh_conn_prop_name = "NW";
integer inh_conn_def_value
 = "cds_globals.\\NW! ";
integer supplySensitivity = "VDD";
 *)

 \NW! ;
input  (*
integer inh_conn_prop_name = "VSS";
integer
inh_conn_def_value = "cds_globals.\\VSS! ";
 *)
 \VSS! ;

wire Y;
wire net329;
wire n1;
wire (*
integer inh_conn_prop_name = "VSS";
integer inh_conn_def_value
 = "cds_globals.\\VSS! ";
 *)
\VSS! ;
wire n0;
wire n2;
wire net304;
wire net320;
wire S1;
wire S0b;
wire A;
wire S0;
wire B;
wire C;
wire D;
wire net280;
wire net312;
wire (*
integer inh_conn_prop_name = "VDD";
integer inh_conn_def_value
 = "cds_globals.\\VDD! ";
 *)
\VDD! ;
wire S1b;
wire net296;
wire net349;

g45n1svt #(.ad(20.3f), .nrd(965.517m), .sca(203.41795), .pd(570n), .scc(0.02523),
 .scb(0.11509), .as(20.3f), .nrs(965.517m), .m(1), .ps(570n), .w(145n),
 .sa(140n), .nf(1), .sb(140n), .sd(160n), .l(45n)) (*
integer
library_binding = "gpdk045";
integer passed_mfactor = "m";
 *)
mn8 (
net377, D, \VSS! , \VSS!  );
g45n1svt #(.ad(20.3f), .nrd(965.517m), .sca(203.41795), .pd(570n), .scc(0.02523),
 .scb(0.11509), .as(20.3f), .nrs(965.517m), .m(1), .ps(570n), .w(145n),
 .sa(140n), .nf(1), .sb(140n), .sd(160n), .l(45n)) (*
integer
library_binding = "gpdk045";
integer passed_mfactor = "m";
 *)
mn9 (
n1, S0, net377, \VSS!  );
g45n1svt #(.ad(20.3f), .nrd(965.517m), .sca(203.41795), .pd(570n), .scc(0.02523),
 .scb(0.11509), .as(20.3f), .nrs(965.517m), .m(1), .ps(570n), .w(145n),
 .sa(140n), .nf(1), .sb(140n), .sd(160n), .l(45n)) (*
integer
library_binding = "gpdk045";
integer passed_mfactor = "m";
 *)
mn6 (
net369, C, \VSS! , \VSS!  );
g45n1svt #(.ad(20.3f), .nrd(965.517m), .sca(203.41795), .pd(570n), .scc(0.02523),
 .scb(0.11509), .as(20.3f), .nrs(965.517m), .m(1), .ps(570n), .w(145n),
 .sa(140n), .nf(1), .sb(140n), .sd(160n), .l(45n)) (*
integer
library_binding = "gpdk045";
integer passed_mfactor = "m";
 *)
mn7 (
n1, S0b, net369, \VSS!  );
g45n1svt #(.ad(20.3f), .nrd(965.517m), .sca(203.41795), .pd(570n), .scc(0.02523),
 .scb(0.11509), .as(20.3f), .nrs(965.517m), .m(1), .ps(570n), .w(145n),
 .sa(140n), .nf(1), .sb(140n), .sd(160n), .l(45n)) (*
integer
library_binding = "gpdk045";
integer passed_mfactor = "m";
 *)
mn4 (
net361, B, \VSS! , \VSS!  );
g45n1svt #(.ad(20.3f), .nrd(965.517m), .sca(203.41795), .pd(570n), .scc(0.02523),
 .scb(0.11509), .as(20.3f), .nrs(965.517m), .m(1), .ps(570n), .w(145n),
 .sa(140n), .nf(1), .sb(140n), .sd(160n), .l(45n)) (*
integer
library_binding = "gpdk045";
integer passed_mfactor = "m";
 *)
mn5 (
n0, S0, net361, \VSS!  );
g45n1svt #(.ad(20.3f), .nrd(965.517m), .sca(203.41795), .pd(570n), .scc(0.02523),
 .scb(0.11509), .as(20.3f), .nrs(965.517m), .m(1), .ps(570n), .w(145n),
 .sa(140n), .nf(1), .sb(140n), .sd(160n), .l(45n)) (*
integer
library_binding = "gpdk045";
integer passed_mfactor = "m";
 *)
mn3 (
n0, S0b, net349, \VSS!  );
g45n1svt #(.ad(20.3f), .nrd(965.517m), .sca(203.41795), .pd(570n), .scc(0.02523),
 .scb(0.11509), .as(20.3f), .nrs(965.517m), .m(1), .ps(570n), .w(145n),
 .sa(140n), .nf(1), .sb(140n), .sd(160n), .l(45n)) (*
integer
library_binding = "gpdk045";
integer passed_mfactor = "m";
 *)
mn2 (
net349, A, \VSS! , \VSS!  );
g45n1svt #(.ad(28.7f), .nrd(682.927m), .sca(166.60249), .pd(690n), .scc(0.02069),
 .scb(0.10864), .as(28.7f), .nrs(682.927m), .m(1), .ps(690n), .w(205n),
 .sa(140n), .nf(1), .sb(140n), .sd(160n), .l(45n)) (*
integer
library_binding = "gpdk045";
integer passed_mfactor = "m";
 *)
mn12 (
net345, n1, \VSS! , \VSS!  );
g45n1svt #(.ad(28.7f), .nrd(682.927m), .sca(166.60249), .pd(690n), .scc(0.02069),
 .scb(0.10864), .as(28.7f), .nrs(682.927m), .m(1), .ps(690n), .w(205n),
 .sa(140n), .nf(1), .sb(140n), .sd(160n), .l(45n)) (*
integer
library_binding = "gpdk045";
integer passed_mfactor = "m";
 *)
mn13 (
n2, S1, net345, \VSS!  );
g45n1svt #(.ad(28.7f), .nrd(682.927m), .sca(166.60249), .pd(690n), .scc(0.02069),
 .scb(0.10864), .as(28.7f), .nrs(682.927m), .m(1), .ps(690n), .w(205n),
 .sa(140n), .nf(1), .sb(140n), .sd(160n), .l(45n)) (*
integer
library_binding = "gpdk045";
integer passed_mfactor = "m";
 *)
mn11 (
n2, S1b, net329, \VSS!  );
g45n1svt #(.ad(20.3f), .nrd(965.517m), .sca(203.41795), .pd(570n), .scc(0.02523),
 .scb(0.11509), .as(20.3f), .nrs(965.517m), .m(1), .ps(570n), .w(145n),
 .sa(140n), .nf(1), .sb(140n), .sd(160n), .l(45n)) (*
integer
library_binding = "gpdk045";
integer passed_mfactor = "m";
 *)
mn1 (
S1b, S1, \VSS! , \VSS!  );
g45n1svt #(.ad(28.7f), .nrd(682.927m), .sca(166.60249), .pd(690n), .scc(0.02069),
 .scb(0.10864), .as(28.7f), .nrs(682.927m), .m(1), .ps(690n), .w(205n),
 .sa(140n), .nf(1), .sb(140n), .sd(160n), .l(45n)) (*
integer
library_binding = "gpdk045";
integer passed_mfactor = "m";
 *)
mn10 (
net329, n0, \VSS! , \VSS!  );
g45n1svt #(.ad(145.6f), .nrd(134.615m), .sca(71.11936), .pd(2.36u), .scc(0.00848),
 .scb(0.06501), .as(145.6f), .nrs(134.615m), .m(1), .ps(2.36u), .w(1.04u),
 .sa(140n), .nf(1), .sb(140n), .sd(160n), .l(45n)) (*
integer
library_binding = "gpdk045";
integer passed_mfactor = "m";
 *)
mn14 (
Y, n2, \VSS! , \VSS!  );
g45n1svt #(.ad(20.3f), .nrd(965.517m), .sca(203.41795), .pd(570n), .scc(0.02523),
 .scb(0.11509), .as(20.3f), .nrs(965.517m), .m(1), .ps(570n), .w(145n),
 .sa(140n), .nf(1), .sb(140n), .sd(160n), .l(45n)) (*
integer
library_binding = "gpdk045";
integer passed_mfactor = "m";
 *)
mn0 (
S0b, S0, \VSS! , \VSS!  );

g45p1svt #(.ad(30.1f), .nrd(651.163m), .sca(162.02845), .pd(710n), .scc(0.02009),
 .scb(0.10751), .as(30.1f), .nrs(651.163m), .m(1), .ps(710n), .w(215n),
 .sa(140n), .nf(1), .sb(140n), .sd(160n), .l(45n)) (*
integer
library_binding = "gpdk045";
integer passed_mfactor = "m";
 *)
mp9 (
n1, S0b, net320, \NW!  );
g45p1svt #(.ad(30.1f), .nrd(651.163m), .sca(162.02845), .pd(710n), .scc(0.02009),
 .scb(0.10751), .as(30.1f), .nrs(651.163m), .m(1), .ps(710n), .w(215n),
 .sa(140n), .nf(1), .sb(140n), .sd(160n), .l(45n)) (*
integer
library_binding = "gpdk045";
integer passed_mfactor = "m";
 *)
mp8 (
net320, D, \VDD! , \NW!  );
g45p1svt #(.ad(30.1f), .nrd(651.163m), .sca(162.02845), .pd(710n), .scc(0.02009),
 .scb(0.10751), .as(30.1f), .nrs(651.163m), .m(1), .ps(710n), .w(215n),
 .sa(140n), .nf(1), .sb(140n), .sd(160n), .l(45n)) (*
integer
library_binding = "gpdk045";
integer passed_mfactor = "m";
 *)
mp7 (
n1, S0, net312, \NW!  );
g45p1svt #(.ad(30.1f), .nrd(651.163m), .sca(162.02845), .pd(710n), .scc(0.02009),
 .scb(0.10751), .as(30.1f), .nrs(651.163m), .m(1), .ps(710n), .w(215n),
 .sa(140n), .nf(1), .sb(140n), .sd(160n), .l(45n)) (*
integer
library_binding = "gpdk045";
integer passed_mfactor = "m";
 *)
mp6 (
net312, C, \VDD! , \NW!  );
g45p1svt #(.ad(30.1f), .nrd(651.163m), .sca(162.02845), .pd(710n), .scc(0.02009),
 .scb(0.10751), .as(30.1f), .nrs(651.163m), .m(1), .ps(710n), .w(215n),
 .sa(140n), .nf(1), .sb(140n), .sd(160n), .l(45n)) (*
integer
library_binding = "gpdk045";
integer passed_mfactor = "m";
 *)
mp5 (
n0, S0b, net304, \NW!  );
g45p1svt #(.ad(30.1f), .nrd(651.163m), .sca(162.02845), .pd(710n), .scc(0.02009),
 .scb(0.10751), .as(30.1f), .nrs(651.163m), .m(1), .ps(710n), .w(215n),
 .sa(140n), .nf(1), .sb(140n), .sd(160n), .l(45n)) (*
integer
library_binding = "gpdk045";
integer passed_mfactor = "m";
 *)
mp4 (
net304, B, \VDD! , \NW!  );
g45p1svt #(.ad(30.1f), .nrd(651.163m), .sca(162.02845), .pd(710n), .scc(0.02009),
 .scb(0.10751), .as(30.1f), .nrs(651.163m), .m(1), .ps(710n), .w(215n),
 .sa(140n), .nf(1), .sb(140n), .sd(160n), .l(45n)) (*
integer
library_binding = "gpdk045";
integer passed_mfactor = "m";
 *)
mp3 (
n0, S0, net296, \NW!  );
g45p1svt #(.ad(30.1f), .nrd(651.163m), .sca(162.02845), .pd(710n), .scc(0.02009),
 .scb(0.10751), .as(30.1f), .nrs(651.163m), .m(1), .ps(710n), .w(215n),
 .sa(140n), .nf(1), .sb(140n), .sd(160n), .l(45n)) (*
integer
library_binding = "gpdk045";
integer passed_mfactor = "m";
 *)
mp2 (
net296, A, \VDD! , \NW!  );
g45p1svt #(.ad(43.4f), .nrd(451.613m), .sca(130.90642), .pd(900n), .scc(0.01590),
 .scb(0.09728), .as(43.4f), .nrs(451.613m), .m(1), .ps(900n), .w(310n),
 .sa(140n), .nf(1), .sb(140n), .sd(160n), .l(45n)) (*
integer
library_binding = "gpdk045";
integer passed_mfactor = "m";
 *)
mp12 (
net284, n1, \VDD! , \NW!  );
g45p1svt #(.ad(43.4f), .nrd(451.613m), .sca(130.90642), .pd(900n), .scc(0.01590),
 .scb(0.09728), .as(43.4f), .nrs(451.613m), .m(1), .ps(900n), .w(310n),
 .sa(140n), .nf(1), .sb(140n), .sd(160n), .l(45n)) (*
integer
library_binding = "gpdk045";
integer passed_mfactor = "m";
 *)
mp13 (
n2, S1b, net284, \NW!  );
g45p1svt #(.ad(43.4f), .nrd(451.613m), .sca(130.90642), .pd(900n), .scc(0.01590),
 .scb(0.09728), .as(43.4f), .nrs(451.613m), .m(1), .ps(900n), .w(310n),
 .sa(140n), .nf(1), .sb(140n), .sd(160n), .l(45n)) (*
integer
library_binding = "gpdk045";
integer passed_mfactor = "m";
 *)
mp11 (
n2, S1, net280, \NW!  );
g45p1svt #(.ad(43.4f), .nrd(451.613m), .sca(130.90642), .pd(900n), .scc(0.01590),
 .scb(0.09728), .as(43.4f), .nrs(451.613m), .m(1), .ps(900n), .w(310n),
 .sa(140n), .nf(1), .sb(140n), .sd(160n), .l(45n)) (*
integer
library_binding = "gpdk045";
integer passed_mfactor = "m";
 *)
mp10 (
net280, n0, \VDD! , \NW!  );
g45p1svt #(.ad(30.1f), .nrd(651.163m), .sca(162.02845), .pd(710n), .scc(0.02009),
 .scb(0.10751), .as(30.1f), .nrs(651.163m), .m(1), .ps(710n), .w(215n),
 .sa(140n), .nf(1), .sb(140n), .sd(160n), .l(45n)) (*
integer
library_binding = "gpdk045";
integer passed_mfactor = "m";
 *)
mp0 (
S0b, S0, \VDD! , \NW!  );
g45p1svt #(.ad(218.4f), .nrd(89.7436m), .sca(61.39246), .pd(3.4u), .scc(0.00742),
 .scb(0.05939), .as(218.4f), .nrs(89.7436m), .m(1), .ps(3.4u), .w(1.56u),
 .sa(140n), .nf(1), .sb(140n), .sd(160n), .l(45n)) (*
integer
library_binding = "gpdk045";
integer passed_mfactor = "m";
 *)
mp14 (
Y, n2, \VDD! , \NW!  );
g45p1svt #(.ad(30.1f), .nrd(651.163m), .sca(162.02845), .pd(710n), .scc(0.02009),
 .scb(0.10751), .as(30.1f), .nrs(651.163m), .m(1), .ps(710n), .w(215n),
 .sa(140n), .nf(1), .sb(140n), .sd(160n), .l(45n)) (*
integer
library_binding = "gpdk045";
integer passed_mfactor = "m";
 *)
mp1 (
S1b, S1, \VDD! , \NW!  );

endmodule
