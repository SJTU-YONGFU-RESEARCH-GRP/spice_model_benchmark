// Verilog-AMS netlist generated by the AMS netlister, version  ICADV12.1-64b.341 .
// Cadence Design Systems, Inc.

`include "disciplines.vams"

(* cds_ams_schematic *)
module TBUFX12 ( Y,.VDD(\VDD! ),A,.NW(\NW! ),
OE,.VSS(\VSS! ) );

output   Y;
input  (*
integer inh_conn_prop_name = "VDD";
integer
inh_conn_def_value = "cds_globals.\\VDD! ";
 *)
 \VDD! ;
input   A;

input  (*
integer inh_conn_prop_name = "NW";
integer
inh_conn_def_value = "cds_globals.\\NW! ";
integer supplySensitivity
 = "VDD";
 *)
 \NW! ;
input   OE;
input  (*
integer inh_conn_prop_name
 = "VSS";
integer inh_conn_def_value = "cds_globals.\\VSS! ";
 *)

 \VSS! ;

wire Y;
wire (*
integer inh_conn_prop_name = "VSS";
integer inh_conn_def_value
 = "cds_globals.\\VSS! ";
 *)
\VSS! ;
wire pon;
wire A;
wire OE;
wire net127;
wire (*
integer inh_conn_prop_name = "VDD";
integer inh_conn_def_value
 = "cds_globals.\\VDD! ";
 *)
\VDD! ;

g45n1svt #(.ad(436.8f), .nrd(44.8718m), .sca(51.29851), .pd(6.52u), .scc(0.00636),
 .scb(0.05376), .as(436.8f), .nrs(44.8718m), .m(1), .ps(6.52u), .w(3.12u),
 .sa(140n), .nf(1), .sb(140n), .sd(160n), .l(45n)) (*
integer
library_binding = "gpdk045";
integer passed_mfactor = "m";
 *)
mn5 ( Y,
non, \VSS! , \VSS!  );
g45n1svt #(.ad(107.8f), .nrd(181.818m), .sca(80.97697), .pd(1.82u), .scc(0.00960),
 .scb(0.07088), .as(107.8f), .nrs(181.818m), .m(1), .ps(1.82u), .w(770n),
 .sa(140n), .nf(1), .sb(140n), .sd(160n), .l(45n)) (*
integer
library_binding = "gpdk045";
integer passed_mfactor = "m";
 *)
mn3 (
net144, A, \VSS! , \VSS!  );
g45n1svt #(.ad(36.4f), .nrd(538.462m), .sca(144.98299), .pd(800n), .scc(0.01780),
 .scb(0.10251), .as(36.4f), .nrs(538.462m), .m(1), .ps(800n), .w(260n),
 .sa(140n), .nf(1), .sb(140n), .sd(160n), .l(45n)) (*
integer
library_binding = "gpdk045";
integer passed_mfactor = "m";
 *)
mn0 (
OEb, OE, \VSS! , \VSS!  );
g45n1svt #(.ad(107.8f), .nrd(181.818m), .sca(80.97697), .pd(1.82u), .scc(0.00960),
 .scb(0.07088), .as(107.8f), .nrs(181.818m), .m(1), .ps(1.82u), .w(770n),
 .sa(140n), .nf(1), .sb(140n), .sd(160n), .l(45n)) (*
integer
library_binding = "gpdk045";
integer passed_mfactor = "m";
 *)
mn4 (
pon, OE, net144, \VSS!  );
g45n1svt #(.ad(107.8f), .nrd(181.818m), .sca(80.97697), .pd(1.82u), .scc(0.00960),
 .scb(0.07088), .as(107.8f), .nrs(181.818m), .m(1), .ps(1.82u), .w(770n),
 .sa(140n), .nf(1), .sb(140n), .sd(160n), .l(45n)) (*
integer
library_binding = "gpdk045";
integer passed_mfactor = "m";
 *)
mn2 (
non, OEb, \VSS! , \VSS!  );
g45n1svt #(.ad(107.8f), .nrd(181.818m), .sca(80.97697), .pd(1.82u), .scc(0.00960),
 .scb(0.07088), .as(107.8f), .nrs(181.818m), .m(1), .ps(1.82u), .w(770n),
 .sa(140n), .nf(1), .sb(140n), .sd(160n), .l(45n)) (*
integer
library_binding = "gpdk045";
integer passed_mfactor = "m";
 *)
mn1 (
non, A, \VSS! , \VSS!  );

g45p1svt #(.ad(163.8f), .nrd(119.658m), .sca(67.91660), .pd(2.62u), .scc(0.00813),
 .scb(0.06314), .as(163.8f), .nrs(119.658m), .m(1), .ps(2.62u), .w(1.17u),
 .sa(140n), .nf(1), .sb(140n), .sd(160n), .l(45n)) (*
integer
library_binding = "gpdk045";
integer passed_mfactor = "m";
 *)
mp2 (
non, OEb, net127, \NW!  );
g45p1svt #(.ad(163.8f), .nrd(119.658m), .sca(67.91660), .pd(2.62u), .scc(0.00813),
 .scb(0.06314), .as(163.8f), .nrs(119.658m), .m(1), .ps(2.62u), .w(1.17u),
 .sa(140n), .nf(1), .sb(140n), .sd(160n), .l(45n)) (*
integer
library_binding = "gpdk045";
integer passed_mfactor = "m";
 *)
mp1 (
net127, A, \VDD! , \NW!  );
g45p1svt #(.ad(655.2f), .nrd(29.9145m), .sca(47.84868), .pd(9.64u), .scc(0.00600),
 .scb(0.05188), .as(655.2f), .nrs(29.9145m), .m(1), .ps(9.64u), .w(4.68u),
 .sa(140n), .nf(1), .sb(140n), .sd(160n), .l(45n)) (*
integer
library_binding = "gpdk045";
integer passed_mfactor = "m";
 *)
mp5 ( Y,
pon, \VDD! , \NW!  );
g45p1svt #(.ad(163.8f), .nrd(119.658m), .sca(67.91660), .pd(2.62u), .scc(0.00813),
 .scb(0.06314), .as(163.8f), .nrs(119.658m), .m(1), .ps(2.62u), .w(1.17u),
 .sa(140n), .nf(1), .sb(140n), .sd(160n), .l(45n)) (*
integer
library_binding = "gpdk045";
integer passed_mfactor = "m";
 *)
mp3 (
pon, A, \VDD! , \NW!  );
g45p1svt #(.ad(163.8f), .nrd(119.658m), .sca(67.91660), .pd(2.62u), .scc(0.00813),
 .scb(0.06314), .as(163.8f), .nrs(119.658m), .m(1), .ps(2.62u), .w(1.17u),
 .sa(140n), .nf(1), .sb(140n), .sd(160n), .l(45n)) (*
integer
library_binding = "gpdk045";
integer passed_mfactor = "m";
 *)
mp4 (
pon, OE, \VDD! , \NW!  );
g45p1svt #(.ad(54.6f), .nrd(358.974m), .sca(114.89040), .pd(1.06u), .scc(0.01377),
 .scb(0.09003), .as(54.6f), .nrs(358.974m), .m(1), .ps(1.06u), .w(390n),
 .sa(140n), .nf(1), .sb(140n), .sd(160n), .l(45n)) (*
integer
library_binding = "gpdk045";
integer passed_mfactor = "m";
 *)
mp0 (
OEb, OE, \VDD! , \NW!  );

endmodule
