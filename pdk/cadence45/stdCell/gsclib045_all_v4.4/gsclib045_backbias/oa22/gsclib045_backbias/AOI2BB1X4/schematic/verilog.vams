// Verilog-AMS netlist generated by the AMS netlister, version  ICADV12.1-64b.341 .
// Cadence Design Systems, Inc.

`include "disciplines.vams"

(* cds_ams_schematic *)
module AOI2BB1X4 ( Y,B0,.VDD(\VDD! ),A1N,.NW(
\NW! ),.VSS(\VSS! ),A0N );

output   Y;
input   B0;
input  (*
integer inh_conn_prop_name
 = "VDD";
integer inh_conn_def_value = "cds_globals.\\VDD! ";
 *)

 \VDD! ;
input   A1N;
input  (*
integer inh_conn_prop_name = "NW";

integer inh_conn_def_value = "cds_globals.\\NW! ";
integer
supplySensitivity = "VDD";
 *)
 \NW! ;
input  (*
integer
inh_conn_prop_name = "VSS";
integer inh_conn_def_value
 = "cds_globals.\\VSS! ";
 *)
 \VSS! ;
input   A0N;

wire Y;
wire B0;
wire (*
integer inh_conn_prop_name = "VSS";
integer inh_conn_def_value
 = "cds_globals.\\VSS! ";
 *)
\VSS! ;
wire A1N;
wire A0N;
wire (*
integer inh_conn_prop_name = "VDD";
integer inh_conn_def_value
 = "cds_globals.\\VDD! ";
 *)
\VDD! ;

g45n1svt #(.ad(145.6f), .nrd(134.615m), .sca(71.11936), .pd(2.36u), .scc(0.00848),
 .scb(0.06501), .as(145.6f), .nrs(134.615m), .m(1), .ps(2.36u), .w(1.04u),
 .sa(140n), .nf(1), .sb(140n), .sd(160n), .l(45n)) (*
integer
library_binding = "gpdk045";
integer passed_mfactor = "m";
 *)
mn2 ( Y,
B0, \VSS! , \VSS!  );
g45n1svt #(.ad(36.4f), .nrd(538.462m), .sca(144.98299), .pd(800n), .scc(0.01780),
 .scb(0.10251), .as(36.4f), .nrs(538.462m), .m(1), .ps(800n), .w(260n),
 .sa(140n), .nf(1), .sb(140n), .sd(160n), .l(45n)) (*
integer
library_binding = "gpdk045";
integer passed_mfactor = "m";
 *)
mn1 (
net104, A1N, \VSS! , \VSS!  );
g45n1svt #(.ad(145.6f), .nrd(134.615m), .sca(71.11936), .pd(2.36u), .scc(0.00848),
 .scb(0.06501), .as(145.6f), .nrs(134.615m), .m(1), .ps(2.36u), .w(1.04u),
 .sa(140n), .nf(1), .sb(140n), .sd(160n), .l(45n)) (*
integer
library_binding = "gpdk045";
integer passed_mfactor = "m";
 *)
mn3 ( Y,
net104, \VSS! , \VSS!  );
g45n1svt #(.ad(36.4f), .nrd(538.462m), .sca(144.98299), .pd(800n), .scc(0.01780),
 .scb(0.10251), .as(36.4f), .nrs(538.462m), .m(1), .ps(800n), .w(260n),
 .sa(140n), .nf(1), .sb(140n), .sd(160n), .l(45n)) (*
integer
library_binding = "gpdk045";
integer passed_mfactor = "m";
 *)
mn0 (
net104, A0N, \VSS! , \VSS!  );

g45p1svt #(.ad(218.4f), .nrd(89.7436m), .sca(61.39246), .pd(3.4u), .scc(0.00742),
 .scb(0.05939), .as(218.4f), .nrs(89.7436m), .m(1), .ps(3.4u), .w(1.56u),
 .sa(140n), .nf(1), .sb(140n), .sd(160n), .l(45n)) (*
integer
library_binding = "gpdk045";
integer passed_mfactor = "m";
 *)
mp3 ( Y,
net104, net79, \NW!  );
g45p1svt #(.ad(218.4f), .nrd(89.7436m), .sca(61.39246), .pd(3.4u), .scc(0.00742),
 .scb(0.05939), .as(218.4f), .nrs(89.7436m), .m(1), .ps(3.4u), .w(1.56u),
 .sa(140n), .nf(1), .sb(140n), .sd(160n), .l(45n)) (*
integer
library_binding = "gpdk045";
integer passed_mfactor = "m";
 *)
mp2 (
net79, B0, \VDD! , \NW!  );
g45p1svt #(.ad(54.6f), .nrd(358.974m), .sca(114.89040), .pd(1.06u), .scc(0.01377),
 .scb(0.09003), .as(54.6f), .nrs(358.974m), .m(1), .ps(1.06u), .w(390n),
 .sa(140n), .nf(1), .sb(140n), .sd(160n), .l(45n)) (*
integer
library_binding = "gpdk045";
integer passed_mfactor = "m";
 *)
mp1 (
net104, A1N, net87, \NW!  );
g45p1svt #(.ad(54.6f), .nrd(358.974m), .sca(114.89040), .pd(1.06u), .scc(0.01377),
 .scb(0.09003), .as(54.6f), .nrs(358.974m), .m(1), .ps(1.06u), .w(390n),
 .sa(140n), .nf(1), .sb(140n), .sd(160n), .l(45n)) (*
integer
library_binding = "gpdk045";
integer passed_mfactor = "m";
 *)
mp0 (
net87, A0N, \VDD! , \NW!  );

endmodule
