// Generated for: spectre (May  1 09:12:24 2013 )
// Library name: gsclib045_hvt
// Cell name: ANTENNA
// View name: extracted

simulator lang=spectre

subckt ANTENNA A VDD VSS
D1 (\3\:A VDD) g45pd1hvt area=1.888e-13 pj=1.82e-06 m=1
C1 (VDD VSS) capacitor c=9.59227e-18
C2 (A VSS) capacitor c=1.3745e-17
C3 (\3\:A VSS) capacitor c=1.26921e-17
Rk1 (A \2\:A) resistor r=0.02915 c=0
Rk2 (\2\:A \4\:A) resistor r=0.3207 c=0
Rz1 (\1\:A \2\:A) resistor r=37.5 c=0
Ry1 (\3\:A \4\:A) resistor r=20.6667 c=0
D0 (VSS \1\:A) g45nd1hvt area=1.551e-13 pj=1.6e-06 m=1
ends ANTENNA
// End of subcircuit definition.
