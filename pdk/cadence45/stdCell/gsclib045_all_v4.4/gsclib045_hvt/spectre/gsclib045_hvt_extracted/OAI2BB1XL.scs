// Generated for: spectre (May  1 09:19:10 2013 )
// Library name: gsclib045_hvt
// Cell name: OAI2BB1XL
// View name: extracted

simulator lang=spectre

subckt OAI2BB1XL A0N A1N B0 VDD VSS Y
mp3 (\3\:Y \3\:n0 \9\:VDD VDD) g45p1hvt w=(2.15e-07) l=4.5e-08 nf=1 \
        as=4.44e-14 ad=3.44e-14 ps=1.35e-06 pd=7.5e-07 nrd=1.16667 \
        nrs=1.16667 sa=1e-07 sb=7.35e-07 sd=160n sca=16.7249 scb=0.0166366 \
        scc=0.000331722 m=(1)
mp2 (\3\:Y \1\:B0 \7\:VDD VDD) g45p1hvt w=(2.15e-07) l=4.5e-08 nf=1 \
        as=5.515e-14 ad=3.44e-14 ps=1.45e-06 pd=7.5e-07 nrd=1.16667 \
        nrs=1.16667 sa=3.05e-07 sb=5.3e-07 sd=160n sca=13.903 \
        scb=0.0110664 scc=0.000192019 m=(1)
mp0 (\8\:n0 \1\:A0N \7\:VDD VDD) g45p1hvt w=(2.15e-07) l=4.5e-08 nf=1 \
        as=5.515e-14 ad=4.085e-14 ps=1.45e-06 pd=8.1e-07 nrd=1.16667 \
        nrs=1.16667 sa=5e-07 sb=3.35e-07 sd=160n sca=14.4432 scb=0.0121509 \
        scc=0.000203603 m=(1)
mp1 (\8\:n0 \1\:A1N \1\:VDD VDD) g45p1hvt w=(2.15e-07) l=4.5e-08 nf=1 \
        as=4.44e-14 ad=4.085e-14 ps=1.35e-06 pd=8.1e-07 nrd=1.16667 \
        nrs=1.16667 sa=7.35e-07 sb=1e-07 sd=160n sca=22.3297 scb=0.0253475 \
        scc=0.00112325 m=(1)
C1 (A0N VSS) capacitor c=2.86749e-17
C2 (B0 VSS) capacitor c=1.31273e-16
C3 (VDD VSS) capacitor c=1.01774e-16
C4 (Y VSS) capacitor c=8.9755e-17
C5 (A1N VSS) capacitor c=1.99336e-17
C6 (n0 VSS) capacitor c=4.2695e-17
C7 (\1\:A1N VSS) capacitor c=2.48303e-17
C8 (\1\:A0N VSS) capacitor c=4.0278e-17
C9 (\1\:B0 VSS) capacitor c=5.46577e-17
C10 (\3\:n0 VSS) capacitor c=5.84576e-17
C11 (\3\:A1N VSS) capacitor c=8.94183e-17
C12 (\3\:A0N VSS) capacitor c=9.29924e-17
C13 (\3\:B0 VSS) capacitor c=7.6877e-17
C14 (\4\:A1N VSS) capacitor c=1.43194e-17
C15 (\2\:A0N VSS) capacitor c=7.98431e-17
C16 (\2\:B0 VSS) capacitor c=6.64335e-17
C17 (\2\:n0 VSS) capacitor c=5.85456e-17
C18 (\1\:VDD VSS) capacitor c=1.16316e-17
C19 (\8\:n0 VSS) capacitor c=7.77789e-17
C20 (\7\:VDD VSS) capacitor c=4.86638e-18
C21 (\3\:Y VSS) capacitor c=8.43362e-17
C22 (\9\:VDD VSS) capacitor c=1.38226e-17
C23 (\4\:n0 VSS) capacitor c=1.81915e-17
C24 (\1\:Y VSS) capacitor c=3.40675e-17
C25 (\2\:A1N VSS) capacitor c=6.03497e-17
C26 (\4\:A0N VSS) capacitor c=1.03314e-16
C27 (\6\:n0 VSS) capacitor c=9.85557e-17
C28 (\7\:n0 VSS) capacitor c=5.48666e-17
C29 (\5\:A1N VSS) capacitor c=5.66004e-17
C30 (\3\:VDD VSS) capacitor c=5.1612e-18
C31 (\5\:VDD VSS) capacitor c=8.51965e-18
C32 (\6\:VDD VSS) capacitor c=5.30053e-18
Rk20 (\4\:VSS VSS) resistor r=0.25 c=0
Rk19 (\2\:VSS \4\:VSS) resistor r=0.2453 c=0
Rk6 (\4\:A0N A0N) resistor r=0.01793 c=0
Rk3 (\4\:B0 B0) resistor r=0.002989 c=0
Rk13 (\2\:VDD \3\:VDD) resistor r=0.2534 c=0
Rk14 (\3\:VDD \5\:VDD) resistor r=0.03734 c=0
Rk16 (\6\:VDD VDD) resistor r=0.08714 c=0
Rk15 (\5\:VDD \6\:VDD) resistor r=0.1625 c=0
Rk17 (\3\:VDD \8\:VDD) resistor r=0.07311 c=0
Rk18 (\6\:VDD \10\:VDD) resistor r=0.07311 c=0
Rk1 (\2\:Y Y) resistor r=0.2199 c=0
Rk2 (Y \4\:Y) resistor r=0.7547 c=0
Rk12 (\5\:A1N A1N) resistor r=0.01793 c=0
Rk7 (\5\:n0 \6\:n0) resistor r=0.1651 c=0
Rk8 (\6\:n0 \7\:n0) resistor r=0.3581 c=0
Rk9 (\6\:n0 \9\:n0) resistor r=0.5336 c=0
Rl5 (\1\:A0N \2\:A0N) resistor r=29.5379 c=0
Rl6 (\2\:A0N \3\:A0N) resistor r=229.538 c=0
Rl3 (\1\:B0 \2\:B0) resistor r=97.8081 c=0
Rl4 (\2\:B0 \3\:B0) resistor r=162.637 c=0
Rl7 (\1\:A1N \2\:A1N) resistor r=24.4619 c=0
Rl8 (\2\:A1N \3\:A1N) resistor r=270.663 c=0
Rl9 (\2\:A1N \4\:A1N) resistor r=12.2705 c=0
Rl2 (\2\:n0 \3\:n0) resistor r=232.143 c=0
Rl1 (n0 \2\:n0) resistor r=28.8462 c=0
Rz4 (\1\:VSS \2\:VSS) resistor r=75 c=0
Rz1 (\1\:Y \2\:Y) resistor r=75 c=0
Rz2 (\4\:n0 \5\:n0) resistor r=75 c=0
Ry3 (\1\:VDD \2\:VDD) resistor r=62 c=0
Ry4 (\7\:VDD \8\:VDD) resistor r=62 c=0
Ry5 (\9\:VDD \10\:VDD) resistor r=62 c=0
Ry1 (\3\:Y \4\:Y) resistor r=62 c=0
Ry2 (\8\:n0 \9\:n0) resistor r=62 c=0
Rx2 (\2\:A0N \4\:A0N) resistor r=45 c=0
Rx1 (\2\:B0 \4\:B0) resistor r=45 c=0
Rx4 (\4\:A1N \5\:A1N) resistor r=45 c=0
Rx3 (\2\:n0 \7\:n0) resistor r=45 c=0
mn3 (\1\:Y n0 n2 VSS) g45n1hvt w=(1.45e-07) l=4.5e-08 nf=1 as=8.7e-15 \
        ad=2.03e-14 ps=4.1e-07 pd=5.7e-07 nrd=1.16667 nrs=1.16667 \
        sa=1.4e-07 sb=5.7e-07 sd=160n sca=6.75077 scb=0.00344229 \
        scc=2.58723e-05 m=(1)
mn2 (n2 \3\:B0 \1\:VSS VSS) g45n1hvt w=(1.45e-07) l=4.5e-08 nf=1 \
        as=2.538e-14 ad=8.7e-15 ps=6.4e-07 pd=4.1e-07 nrd=1.16667 \
        nrs=1.16667 sa=2.45e-07 sb=4.65e-07 sd=160n sca=6.75077 \
        scb=0.00344229 scc=2.58723e-05 m=(1)
mn0 (n1 \3\:A0N \1\:VSS VSS) g45n1hvt w=(1.45e-07) l=4.5e-08 nf=1 \
        as=2.538e-14 ad=8.7e-15 ps=6.4e-07 pd=4.1e-07 nrd=1.16667 \
        nrs=1.16667 sa=4.65e-07 sb=2.45e-07 sd=160n sca=6.75077 \
        scb=0.00344229 scc=2.58723e-05 m=(1)
mn1 (\4\:n0 \3\:A1N n1 VSS) g45n1hvt w=(1.45e-07) l=4.5e-08 nf=1 \
        as=8.7e-15 ad=2.03e-14 ps=4.1e-07 pd=5.7e-07 nrd=1.16667 \
        nrs=1.16667 sa=5.7e-07 sb=1.4e-07 sd=160n sca=6.75077 \
        scb=0.00344229 scc=2.58723e-05 m=(1)
ends OAI2BB1XL
// End of subcircuit definition.
