// Generated for: spectre (May  1 09:18:40 2013 )
// Library name: gsclib045_hvt
// Cell name: OA22X4
// View name: extracted

simulator lang=spectre

subckt OA22X4 A0 A1 B0 B1 VDD VSS Y
mp0 (net119 \1\:A0 \12\:VDD VDD) g45p1hvt w=(3.9e-07) l=4.5e-08 nf=1 \
        as=5.46e-14 ad=4.485e-14 ps=1.06e-06 pd=1.01e-06 nrd=1.16667 \
        nrs=1.16667 sa=1.4e-07 sb=1.525e-06 sd=160n sca=16.0461 \
        scb=0.0153344 scc=0.000433465 m=(1)
mp1 (\17\:net128 \1\:A1 net119 VDD) g45p1hvt w=(3.9e-07) l=4.5e-08 nf=1 \
        as=4.485e-14 ad=6.24e-14 ps=1.01e-06 pd=1.1e-06 nrd=1.16667 \
        nrs=1.16667 sa=3e-07 sb=1.365e-06 sd=160n sca=13.8829 \
        scb=0.0118891 scc=0.000386328 m=(1)
mp3 (\17\:net128 \1\:B1 net115 VDD) g45p1hvt w=(3.9e-07) l=4.5e-08 nf=1 \
        as=6.045e-14 ad=6.24e-14 ps=1.09e-06 pd=1.1e-06 nrd=1.16667 \
        nrs=1.16667 sa=5.05e-07 sb=1.16e-06 sd=160n sca=12.7362 \
        scb=0.0108186 scc=0.000383639 m=(1)
mp2 (net115 \3\:B0 \1\:VDD VDD) g45p1hvt w=(3.9e-07) l=4.5e-08 nf=1 \
        as=6.24e-14 ad=6.045e-14 ps=1.1e-06 pd=1.09e-06 nrd=1.16667 \
        nrs=1.16667 sa=7.05e-07 sb=9.6e-07 sd=160n sca=12.2138 \
        scb=0.0106342 scc=0.00038358 m=(1)
mp4_1__rcx (\4\:Y net128 \1\:VDD VDD) g45p1hvt w=(3.9e-07) l=4.5e-08 \
        nf=1 as=6.045e-14 ad=6.24e-14 ps=1.09e-06 pd=1.1e-06 nrd=1.16667 \
        nrs=1.16667 sa=9.1e-07 sb=7.55e-07 sd=160n sca=12.2138 \
        scb=0.0106342 scc=0.00038358 m=(4)
C1 (B0 VSS) capacitor c=8.04933e-17
C2 (A0 VSS) capacitor c=7.40948e-17
C3 (Y VSS) capacitor c=2.12751e-17
C4 (VDD VSS) capacitor c=1.17329e-16
C5 (B1 VSS) capacitor c=8.82803e-17
C6 (net124 VSS) capacitor c=6.82653e-17
C7 (net128 VSS) capacitor c=3.59045e-16
C8 (net119 VSS) capacitor c=2.70639e-18
C9 (net115 VSS) capacitor c=8.08886e-18
C10 (\3\:B0 VSS) capacitor c=5.24202e-17
C11 (\1\:B1 VSS) capacitor c=5.74489e-17
C12 (\1\:A1 VSS) capacitor c=5.3171e-17
C13 (\1\:A0 VSS) capacitor c=5.35262e-17
C14 (\1\:B0 VSS) capacitor c=4.53683e-17
C15 (\4\:B1 VSS) capacitor c=4.57078e-17
C16 (\3\:A1 VSS) capacitor c=5.82862e-17
C17 (\3\:A0 VSS) capacitor c=3.6662e-17
C18 (\3\:B1 VSS) capacitor c=5.03437e-17
C19 (\2\:A1 VSS) capacitor c=5.53076e-17
C20 (\2\:A0 VSS) capacitor c=4.73593e-17
C21 (\1\:VDD VSS) capacitor c=2.02082e-16
C22 (\17\:net128 VSS) capacitor c=1.05144e-16
C23 (\12\:VDD VSS) capacitor c=3.68664e-17
C24 (\1\:Y VSS) capacitor c=1.22571e-16
C25 (\14\:net128 VSS) capacitor c=3.26989e-17
C26 (\3\:net124 VSS) capacitor c=9.61831e-17
C27 (\5\:net124 VSS) capacitor c=5.7454e-17
C28 (\2\:B0 VSS) capacitor c=4.13032e-17
C29 (\4\:A0 VSS) capacitor c=2.43437e-17
C30 (\4\:A1 VSS) capacitor c=1.308e-16
C31 (\5\:B1 VSS) capacitor c=6.45405e-17
C32 (\5\:B0 VSS) capacitor c=3.67844e-17
C33 (\16\:net128 VSS) capacitor c=1.33615e-16
C34 (\3\:Y VSS) capacitor c=3.81021e-17
C35 (\4\:Y VSS) capacitor c=1.77672e-16
C36 (\7\:VDD VSS) capacitor c=1.88839e-17
Rk4 (\4\:A1 A1) resistor r=0.003676 c=0
Rk21 (\1\:VSS \6\:VSS) resistor r=0.07243 c=0
Rk23 (\7\:VSS VSS) resistor r=0.1774 c=0
Rk22 (\6\:VSS \7\:VSS) resistor r=0.373 c=0
Rk26 (\7\:VSS \13\:VSS) resistor r=0.2573 c=0
Rk8 (B0 \5\:B0) resistor r=0.1375 c=0
Rk3 (\4\:A0 A0) resistor r=0.04486 c=0
Rk17 (\3\:Y Y) resistor r=0.06291 c=0
Rk13 (\1\:Y \3\:Y) resistor r=0.3638 c=0
Rk14 (\3\:Y \4\:Y) resistor r=0.2258 c=0
Rk31 (\7\:VDD VDD) resistor r=0.09723 c=0
Rk30 (\1\:VDD \7\:VDD) resistor r=0.3853 c=0
Rk34 (\7\:VDD \13\:VDD) resistor r=0.1991 c=0
Rk5 (B1 \5\:B1) resistor r=0.1585 c=0
Rk6 (\2\:net124 \4\:net124) resistor r=0.4671 c=0
Rk7 (\4\:net124 \6\:net124) resistor r=0.4212 c=0
Rk11 (\16\:net128 net128) resistor r=0.3532 c=0
Rk9 (\15\:net128 \16\:net128) resistor r=0.1366 c=0
Rk10 (\16\:net128 \18\:net128) resistor r=0.6444 c=0
Rl3 (\1\:A1 \2\:A1) resistor r=29.5379 c=0
Rl4 (\2\:A1 \3\:A1) resistor r=117.999 c=0
Rl9 (\2\:B0 \3\:B0) resistor r=77.3776 c=0
Rl8 (\1\:B0 \2\:B0) resistor r=88.9161 c=0
Rl10 (\2\:B0 \4\:B0) resistor r=5.0149 c=0
Rl1 (\1\:A0 \2\:A0) resistor r=96.3069 c=0
Rl2 (\2\:A0 \3\:A0) resistor r=53.0211 c=0
Rl5 (\1\:B1 \2\:B1) resistor r=99.7141 c=0
Rl7 (\2\:B1 \4\:B1) resistor r=65.0987 c=0
Rl6 (\2\:B1 \3\:B1) resistor r=0.5166 c=0
Rz10 (\13\:VSS \12\:VSS) resistor r=75 c=0
Rz1 (net124 \2\:net124) resistor r=75 c=0
Rz2 (\3\:net124 \4\:net124) resistor r=75 c=0
Rz3 (\5\:net124 \6\:net124) resistor r=75 c=0
Rz4 (\15\:net128 \14\:net128) resistor r=75 c=0
Ry8 (\13\:VDD \12\:VDD) resistor r=62 c=0
Ry1 (\18\:net128 \17\:net128) resistor r=62 c=0
Rx2 (\2\:A1 \4\:A1) resistor r=45 c=0
Rx4 (\4\:B0 \5\:B0) resistor r=45 c=0
Rx1 (\2\:A0 \4\:A0) resistor r=45 c=0
Rx3 (\3\:B1 \5\:B1) resistor r=45 c=0
mn0 (\5\:net124 \3\:A0 \12\:VSS VSS) g45n1hvt w=(2.6e-07) l=4.5e-08 nf=1 \
        as=4.16e-14 ad=3.64e-14 ps=8.4e-07 pd=8e-07 nrd=1.16667 \
        nrs=1.16667 sa=1.4e-07 sb=7.6e-07 sd=160n sca=12.1772 \
        scb=0.0118935 scc=0.000630577 m=(1)
mn1 (\3\:net124 \3\:A1 \12\:VSS VSS) g45n1hvt w=(2.6e-07) l=4.5e-08 nf=1 \
        as=4.16e-14 ad=4.16e-14 ps=8.4e-07 pd=8.4e-07 nrd=1.16667 \
        nrs=1.16667 sa=3.45e-07 sb=5.55e-07 sd=160n sca=12.1772 \
        scb=0.0118935 scc=0.000630577 m=(1)
mn3 (\14\:net128 \4\:B1 \3\:net124 VSS) g45n1hvt w=(2.6e-07) l=4.5e-08 \
        nf=1 as=4.16e-14 ad=4.29e-14 ps=8.4e-07 pd=8.5e-07 nrd=1.16667 \
        nrs=1.16667 sa=5.5e-07 sb=3.5e-07 sd=160n sca=12.1772 \
        scb=0.0118935 scc=0.000630577 m=(1)
mn2 (\14\:net128 \1\:B0 net124 VSS) g45n1hvt w=(2.6e-07) l=4.5e-08 nf=1 \
        as=3.64e-14 ad=4.29e-14 ps=8e-07 pd=8.5e-07 nrd=1.16667 \
        nrs=1.16667 sa=7.6e-07 sb=1.4e-07 sd=160n sca=12.1772 \
        scb=0.0118935 scc=0.000630577 m=(1)
mn4_1__rcx (\1\:Y net128 \1\:VSS VSS) g45n1hvt w=(2.6e-07) l=4.5e-08 \
        nf=1 as=4.095e-14 ad=4.16e-14 ps=8.35e-07 pd=8.4e-07 nrd=1.16667 \
        nrs=1.16667 sa=1.4e-07 sb=7.7e-07 sd=160n sca=8.97712 \
        scb=0.00732387 scc=0.000196032 m=(4)
ends OA22X4
// End of subcircuit definition.
