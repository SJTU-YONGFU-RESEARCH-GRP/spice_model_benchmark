// Generated for: spectre (May  1 09:18:18 2013 )
// Library name: gsclib045_hvt
// Cell name: NOR4BBX1
// View name: extracted

simulator lang=spectre

subckt NOR4BBX1 AN BN C D VDD VSS Y
mp1 (\8\:n1 \1\:BN \5\:VDD VDD) g45p1hvt w=(2.15e-07) l=4.5e-08 nf=1 \
        as=4.44e-14 ad=3.01e-14 ps=1.35e-06 pd=7.1e-07 nrd=1.16667 \
        nrs=1.16667 sa=1e-07 sb=1.4e-07 sd=160n sca=65.2419 scb=0.0523585 \
        scc=0.00853102 m=(1)
mp0 (\4\:n0 \1\:AN \1\:VDD VDD) g45p1hvt w=(2.15e-07) l=4.5e-08 nf=1 \
        as=7.18e-14 ad=3.01e-14 ps=1.22e-06 pd=7.1e-07 nrd=1.16667 \
        nrs=1.16667 sa=9.55e-07 sb=1.4e-07 sd=160n sca=25.3128 \
        scb=0.0295551 scc=0.00162105 m=(1)
C1 (BN VSS) capacitor c=4.32601e-17
C2 (VDD VSS) capacitor c=1.07712e-16
C3 (C VSS) capacitor c=3.59346e-17
C4 (D VSS) capacitor c=5.22573e-17
C5 (Y VSS) capacitor c=2.9192e-17
C6 (n1 VSS) capacitor c=4.1135e-17
C7 (n0 VSS) capacitor c=4.08638e-17
C8 (n4 VSS) capacitor c=2.13646e-18
C9 (n3 VSS) capacitor c=4.76912e-18
C10 (n2 VSS) capacitor c=9.08344e-18
C11 (\1\:AN VSS) capacitor c=3.65818e-17
C12 (\3\:n0 VSS) capacitor c=5.6396e-17
C13 (\3\:n1 VSS) capacitor c=6.464e-17
C14 (\3\:C VSS) capacitor c=8.9555e-17
C15 (\1\:D VSS) capacitor c=7.66177e-17
C16 (\1\:BN VSS) capacitor c=2.47395e-17
C17 (\3\:AN VSS) capacitor c=4.58743e-17
C18 (\1\:C VSS) capacitor c=5.30212e-17
C19 (\3\:D VSS) capacitor c=4.325e-17
C20 (\4\:BN VSS) capacitor c=2.54038e-17
C21 (\2\:AN VSS) capacitor c=3.67256e-17
C22 (\2\:n0 VSS) capacitor c=4.88786e-17
C23 (\2\:n1 VSS) capacitor c=6.2581e-17
C24 (\2\:C VSS) capacitor c=7.40308e-17
C25 (\2\:D VSS) capacitor c=5.70246e-17
C26 (\3\:BN VSS) capacitor c=1.09736e-17
C27 (\4\:n0 VSS) capacitor c=7.83607e-17
C28 (\1\:VDD VSS) capacitor c=7.11778e-17
C29 (\2\:Y VSS) capacitor c=9.13166e-17
C30 (\8\:n1 VSS) capacitor c=4.81494e-17
C31 (\5\:VDD VSS) capacitor c=3.56196e-17
C32 (\7\:n0 VSS) capacitor c=4.63326e-17
C33 (\5\:Y VSS) capacitor c=3.63625e-17
C34 (\7\:Y VSS) capacitor c=6.80733e-17
C35 (\6\:n1 VSS) capacitor c=1.11939e-17
C36 (\2\:BN VSS) capacitor c=9.76106e-18
C37 (\5\:BN VSS) capacitor c=4.57809e-17
C38 (\4\:D VSS) capacitor c=6.53066e-17
C39 (\4\:C VSS) capacitor c=4.9798e-17
C40 (\4\:n1 VSS) capacitor c=8.13214e-17
C41 (\5\:n1 VSS) capacitor c=7.20774e-17
C42 (\1\:Y VSS) capacitor c=1.03835e-16
C43 (\4\:Y VSS) capacitor c=7.71986e-17
C44 (\6\:n0 VSS) capacitor c=1.07138e-16
C45 (\4\:AN VSS) capacitor c=7.97252e-17
C46 (\4\:VDD VSS) capacitor c=4.60102e-17
Rk1 (BN \5\:BN) resistor r=0.1688 c=0
Rk14 (AN \4\:AN) resistor r=0.03886 c=0
Rk22 (\4\:VDD VDD) resistor r=0.3513 c=0
Rk21 (\2\:VDD \4\:VDD) resistor r=0.4528 c=0
Rk23 (VDD \6\:VDD) resistor r=0.2334 c=0
Rk3 (C \4\:C) resistor r=0.1 c=0
Rk2 (D \4\:D) resistor r=0.09253 c=0
Rk7 (Y \1\:Y) resistor r=0.002903 c=0
Rk8 (\1\:Y \3\:Y) resistor r=0.6634 c=0
Rk9 (\1\:Y \4\:Y) resistor r=0.4046 c=0
Rk10 (\4\:Y \6\:Y) resistor r=0.09051 c=0
Rk11 (\4\:Y \8\:Y) resistor r=0.3707 c=0
Rk15 (\2\:VSS \4\:VSS) resistor r=0.557 c=0
Rk17 (\5\:VSS VSS) resistor r=0.1479 c=0
Rk16 (\4\:VSS \5\:VSS) resistor r=0.203 c=0
Rk18 (\4\:VSS \7\:VSS) resistor r=0.2731 c=0
Rk19 (\5\:VSS \9\:VSS) resistor r=0.1378 c=0
Rk20 (VSS \11\:VSS) resistor r=0.1698 c=0
Rk4 (\4\:n1 \5\:n1) resistor r=0.4557 c=0
Rk5 (\5\:n1 \7\:n1) resistor r=0.08791 c=0
Rk6 (\5\:n1 \9\:n1) resistor r=0.2055 c=0
Rk12 (\5\:n0 \6\:n0) resistor r=0.5646 c=0
Rk13 (\6\:n0 \8\:n0) resistor r=0.3162 c=0
Rl1 (\1\:BN \2\:BN) resistor r=49.7141 c=0
Rl3 (\2\:BN \4\:BN) resistor r=34.3295 c=0
Rl2 (\2\:BN \3\:BN) resistor r=1.2666 c=0
Rl12 (\1\:AN \2\:AN) resistor r=74.2328 c=0
Rl13 (\2\:AN \3\:AN) resistor r=97.3098 c=0
Rl7 (\2\:C \3\:C) resistor r=68.4066 c=0
Rl6 (\1\:C \2\:C) resistor r=107.692 c=0
Rl4 (\1\:D \2\:D) resistor r=71.131 c=0
Rl5 (\2\:D \3\:D) resistor r=101.718 c=0
Rl9 (\2\:n1 \3\:n1) resistor r=126.374 c=0
Rl8 (n1 \2\:n1) resistor r=56.1096 c=0
Rl11 (\2\:n0 \3\:n0) resistor r=155.689 c=0
Rl10 (n0 \2\:n0) resistor r=26.098 c=0
Rz2 (\5\:Y \6\:Y) resistor r=37.5 c=0
Rz3 (\7\:Y \8\:Y) resistor r=37.5 c=0
Rz5 (\1\:VSS \2\:VSS) resistor r=75 c=0
Rz6 (\6\:VSS \7\:VSS) resistor r=75 c=0
Rz7 (\8\:VSS \9\:VSS) resistor r=75 c=0
Rz8 (\10\:VSS \11\:VSS) resistor r=75 c=0
Rz1 (\6\:n1 \7\:n1) resistor r=75 c=0
Rz4 (\7\:n0 \8\:n0) resistor r=75 c=0
Ry5 (\1\:VDD \2\:VDD) resistor r=31 c=0
Ry6 (\5\:VDD \6\:VDD) resistor r=62 c=0
Ry2 (\2\:Y \3\:Y) resistor r=31 c=0
Ry1 (\8\:n1 \9\:n1) resistor r=62 c=0
Ry3 (\4\:n0 \5\:n0) resistor r=62 c=0
Rx1 (\3\:BN \5\:BN) resistor r=45 c=0
Rx6 (\2\:AN \4\:AN) resistor r=45 c=0
Rx3 (\2\:C \4\:C) resistor r=45 c=0
Rx2 (\2\:D \4\:D) resistor r=45 c=0
Rx4 (\2\:n1 \4\:n1) resistor r=45 c=0
Rx5 (\2\:n0 \6\:n0) resistor r=45 c=0
mn1 (\6\:n1 \4\:BN \10\:VSS VSS) g45n1hvt w=(1.45e-07) l=4.5e-08 nf=1 \
        as=5.295e-14 ad=2.03e-14 ps=1.5e-06 pd=5.7e-07 nrd=1.16667 \
        nrs=1.16667 sa=1e-07 sb=1.4e-07 sd=160n sca=23.279 scb=0.0230742 \
        scc=0.00267719 m=(1)
mn0 (\7\:n0 \3\:AN \1\:VSS VSS) g45n1hvt w=(1.45e-07) l=4.5e-08 nf=1 \
        as=3.47e-14 ad=2.03e-14 ps=8.4e-07 pd=5.7e-07 nrd=1.16667 \
        nrs=1.16667 sa=9.6e-07 sb=1.4e-07 sd=160n sca=11.9911 \
        scb=0.0120555 scc=0.000498628 m=(1)
mn5 (\7\:Y \3\:D \8\:VSS VSS) g45n1hvt w=(2.6e-07) l=4.5e-08 nf=1 \
        as=5.18e-14 ad=4.16e-14 ps=1.29e-06 pd=8.4e-07 nrd=1.16667 \
        nrs=1.16667 sa=1e-07 sb=8.91635e-07 sd=160n sca=9.89531 \
        scb=0.00874901 scc=0.000299334 m=(1)
mn4 (\7\:Y \1\:C \6\:VSS VSS) g45n1hvt w=(2.6e-07) l=4.5e-08 nf=1 \
        as=4.55e-14 ad=4.16e-14 ps=8.7e-07 pd=8.4e-07 nrd=1.16667 \
        nrs=1.16667 sa=3.05e-07 sb=6.86635e-07 sd=160n sca=9.89531 \
        scb=0.00874901 scc=0.000299334 m=(1)
mn3 (\5\:Y n1 \6\:VSS VSS) g45n1hvt w=(2.6e-07) l=4.5e-08 nf=1 \
        as=4.55e-14 ad=4.81e-14 ps=8.7e-07 pd=8.9e-07 nrd=1.16667 \
        nrs=1.16667 sa=5.25e-07 sb=4.66635e-07 sd=160n sca=9.89531 \
        scb=0.00874901 scc=0.000299334 m=(1)
mn2 (\5\:Y n0 \1\:VSS VSS) g45n1hvt w=(2.6e-07) l=4.5e-08 nf=1 \
        as=3.47e-14 ad=4.81e-14 ps=8.4e-07 pd=8.9e-07 nrd=1.16667 \
        nrs=1.16667 sa=7.55e-07 sb=2.36635e-07 sd=160n sca=9.89531 \
        scb=0.00874901 scc=0.000299334 m=(1)
mp5 (\2\:Y \1\:D n4 VDD) g45p1hvt w=(3.9e-07) l=4.5e-08 nf=1 as=2.34e-14 \
        ad=5.46e-14 ps=9e-07 pd=1.06e-06 nrd=1.16667 nrs=1.16667 \
        sa=1.4e-07 sb=8.3609e-07 sd=160n sca=13.1685 scb=0.0109658 \
        scc=0.000276178 m=(1)
mp4 (n4 \3\:C n3 VDD) g45p1hvt w=(3.9e-07) l=4.5e-08 nf=1 as=4.485e-14 \
        ad=2.34e-14 ps=1.01e-06 pd=9e-07 nrd=1.16667 nrs=1.16667 \
        sa=2.45e-07 sb=7.3109e-07 sd=160n sca=12.5855 scb=0.0103077 \
        scc=0.000274391 m=(1)
mp3 (n3 \3\:n1 n2 VDD) g45p1hvt w=(3.9e-07) l=4.5e-08 nf=1 as=9.36e-14 \
        ad=4.485e-14 ps=1.26e-06 pd=1.01e-06 nrd=1.16667 nrs=1.16667 \
        sa=4.05e-07 sb=5.7109e-07 sd=160n sca=12.4303 scb=0.0101252 \
        scc=0.000274165 m=(1)
mp2 (n2 \3\:n0 \1\:VDD VDD) g45p1hvt w=(3.9e-07) l=4.5e-08 nf=1 \
        as=7.18e-14 ad=9.36e-14 ps=1.22e-06 pd=1.26e-06 nrd=1.16667 \
        nrs=1.16667 sa=6.9e-07 sb=2.8609e-07 sd=160n sca=14.1331 \
        scb=0.0123288 scc=0.000285937 m=(1)
ends NOR4BBX1
// End of subcircuit definition.
