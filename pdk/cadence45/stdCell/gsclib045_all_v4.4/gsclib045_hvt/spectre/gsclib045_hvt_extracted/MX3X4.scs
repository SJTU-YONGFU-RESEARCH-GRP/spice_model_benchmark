// Generated for: spectre (May  1 09:16:55 2013 )
// Library name: gsclib045_hvt
// Cell name: MX3X4
// View name: extracted

simulator lang=spectre

subckt MX3X4 A B C S0 S1 VDD VSS Y
mp7 (net202 \1\:C \5\:VDD VDD) g45p1hvt w=(3.9e-07) l=4.5e-08 nf=1 \
        as=6.825e-14 ad=3.12e-14 ps=1.13e-06 pd=9.4e-07 nrd=1.16667 \
        nrs=1.16667 sa=1.065e-06 sb=6.15e-07 sd=160n sca=13.3279 \
        scb=0.011929 scc=0.000599966 m=(1)
mp8 (\17\:n1 \2\:S1b net202 VDD) g45p1hvt w=(3.9e-07) l=4.5e-08 nf=1 \
        as=3.12e-14 ad=1.1895e-13 ps=9.4e-07 pd=1.39e-06 nrd=1.16667 \
        nrs=1.16667 sa=1.19e-06 sb=4.9e-07 sd=160n sca=13.3279 \
        scb=0.011929 scc=0.000599966 m=(1)
mp6 (\5\:n0 \6\:S1 \17\:n1 VDD) g45p1hvt w=(3.9e-07) l=4.5e-08 nf=1 \
        as=1.1895e-13 ad=5.46e-14 ps=1.39e-06 pd=1.06e-06 nrd=1.16667 \
        nrs=1.16667 sa=1.54e-06 sb=1.4e-07 sd=160n sca=13.3279 \
        scb=0.011929 scc=0.000599966 m=(1)
mp9_1__rcx (\1\:Y n1 \5\:VDD VDD) g45p1hvt w=(3.9e-07) l=4.5e-08 nf=1 \
        as=6.289e-14 ad=7.8e-14 ps=1.1025e-06 pd=1.18e-06 nrd=1.16667 \
        nrs=1.16667 sa=1.5e-07 sb=1.53e-06 sd=160n sca=16.3392 \
        scb=0.0152106 scc=0.000622257 m=(4)
C1 (A VSS) capacitor c=3.16474e-17
C2 (C VSS) capacitor c=5.55387e-17
C3 (Y VSS) capacitor c=1.88538e-17
C4 (B VSS) capacitor c=8.65368e-17
C5 (VDD VSS) capacitor c=2.25499e-16
C6 (S1 VSS) capacitor c=7.49696e-17
C7 (n1 VSS) capacitor c=2.49769e-16
C8 (net245 VSS) capacitor c=5.3414e-18
C9 (n0 VSS) capacitor c=1.07511e-16
C10 (S1b VSS) capacitor c=5.03697e-17
C11 (net234 VSS) capacitor c=1.83395e-19
C12 (S0b VSS) capacitor c=4.40057e-17
C13 (net190 VSS) capacitor c=3.7823e-18
C14 (\4\:S0 VSS) capacitor c=2.69357e-17
C15 (\1\:A VSS) capacitor c=5.19035e-17
C16 (\1\:S0 VSS) capacitor c=3.1483e-17
C17 (\1\:B VSS) capacitor c=6.17388e-17
C18 (\5\:S1 VSS) capacitor c=3.68566e-17
C19 (\6\:S1 VSS) capacitor c=3.10166e-17
C20 (\2\:S1b VSS) capacitor c=7.28281e-17
C21 (\1\:C VSS) capacitor c=6.86517e-17
C22 (\6\:S0 VSS) capacitor c=5.06667e-17
C23 (\3\:A VSS) capacitor c=5.52631e-17
C24 (\3\:S0b VSS) capacitor c=5.98772e-17
C25 (\3\:S0 VSS) capacitor c=6.07972e-17
C26 (\3\:B VSS) capacitor c=3.43427e-17
C27 (\1\:S1 VSS) capacitor c=5.36219e-17
C28 (\3\:S1b VSS) capacitor c=3.10794e-17
C29 (\4\:S1 VSS) capacitor c=6.53992e-17
C30 (\3\:C VSS) capacitor c=3.60855e-17
C31 (\5\:S0 VSS) capacitor c=4.51536e-17
C32 (\2\:A VSS) capacitor c=6.16135e-17
C33 (\4\:S0b VSS) capacitor c=4.96142e-17
C34 (\2\:S0 VSS) capacitor c=7.99977e-17
C35 (\2\:S0b VSS) capacitor c=4.69517e-17
C36 (\2\:B VSS) capacitor c=5.36086e-17
C37 (\2\:S1 VSS) capacitor c=5.83464e-17
C38 (\4\:S1b VSS) capacitor c=4.6545e-17
C39 (\2\:C VSS) capacitor c=4.06854e-17
C40 (\10\:S0b VSS) capacitor c=5.0353e-17
C41 (\7\:VDD VSS) capacitor c=2.44838e-17
C42 (\7\:n0 VSS) capacitor c=2.51479e-17
C43 (\1\:VDD VSS) capacitor c=3.81688e-17
C44 (\5\:S1b VSS) capacitor c=8.88547e-17
C45 (\5\:n0 VSS) capacitor c=4.34479e-17
C46 (\17\:n1 VSS) capacitor c=1.04432e-16
C47 (\1\:Y VSS) capacitor c=1.60756e-16
C48 (\4\:VDD VSS) capacitor c=6.93186e-17
C49 (\5\:S0b VSS) capacitor c=1.95372e-17
C50 (\10\:S1b VSS) capacitor c=7.427e-17
C51 (\9\:n0 VSS) capacitor c=9.88784e-17
C52 (\13\:n1 VSS) capacitor c=4.12737e-17
C53 (\4\:Y VSS) capacitor c=9.7259e-17
C54 (\3\:S1 VSS) capacitor c=7.46894e-17
C55 (\4\:C VSS) capacitor c=4.65908e-17
C56 (\15\:n1 VSS) capacitor c=6.81845e-17
C57 (\16\:n1 VSS) capacitor c=6.4717e-17
C58 (\8\:S1b VSS) capacitor c=9.4616e-17
C59 (\9\:S1b VSS) capacitor c=8.16163e-17
C60 (\12\:S1b VSS) capacitor c=2.26346e-17
C61 (\7\:S1 VSS) capacitor c=5.61468e-17
C62 (\4\:B VSS) capacitor c=3.62572e-17
C63 (\3\:n0 VSS) capacitor c=1.40708e-16
C64 (\4\:n0 VSS) capacitor c=9.12829e-17
C65 (\7\:S0 VSS) capacitor c=6.85764e-17
C66 (\8\:S0 VSS) capacitor c=4.57614e-17
C67 (\4\:A VSS) capacitor c=8.53788e-17
C68 (\7\:S0b VSS) capacitor c=8.16688e-17
C69 (\8\:S0b VSS) capacitor c=1.11669e-16
C70 (\9\:S0b VSS) capacitor c=6.81104e-17
C71 (\3\:VDD VSS) capacitor c=3.71858e-17
C72 (\5\:VDD VSS) capacitor c=1.68419e-16
Rk26 (A \4\:A) resistor r=0.07281 c=0
Rk6 (C \4\:C) resistor r=0.03635 c=0
Rk2 (\1\:Y Y) resistor r=0.265 c=0
Rk3 (Y \4\:Y) resistor r=0.04446 c=0
Rk18 (\4\:B B) resistor r=0.01496 c=0
Rk24 (S0 \7\:S0) resistor r=0.005081 c=0
Rk25 (\7\:S0 \8\:S0) resistor r=0.2852 c=0
Rk31 (\2\:VSS \4\:VSS) resistor r=0.325 c=0
Rk32 (\4\:VSS \5\:VSS) resistor r=0.3281 c=0
Rk37 (\6\:VSS VSS) resistor r=0.1198 c=0
Rk33 (\5\:VSS \6\:VSS) resistor r=0.6243 c=0
Rk34 (\5\:VSS \8\:VSS) resistor r=0.2005 c=0
Rk41 (\2\:VDD \3\:VDD) resistor r=0.2492 c=0
Rk50 (\5\:VDD VDD) resistor r=0.1148 c=0
Rk42 (\3\:VDD \5\:VDD) resistor r=0.6218 c=0
Rk43 (\3\:VDD \6\:VDD) resistor r=0.3306 c=0
Rk44 (\6\:VDD \8\:VDD) resistor r=0.3771 c=0
Rk15 (S1 \7\:S1) resistor r=0.1437 c=0
Rk7 (\14\:n1 \15\:n1) resistor r=0.1246 c=0
Rk8 (\15\:n1 \16\:n1) resistor r=0.3577 c=0
Rk9 (\15\:n1 \18\:n1) resistor r=0.4624 c=0
Rk19 (\2\:n0 \3\:n0) resistor r=0.7805 c=0
Rk20 (\3\:n0 \4\:n0) resistor r=0.3842 c=0
Rk21 (\4\:n0 \6\:n0) resistor r=0.1486 c=0
Rk22 (\3\:n0 \8\:n0) resistor r=0.2267 c=0
Rk23 (\4\:n0 \10\:n0) resistor r=0.4084 c=0
Rk10 (\6\:S1b \7\:S1b) resistor r=0.5988 c=0
Rk11 (\7\:S1b \8\:S1b) resistor r=0.04598 c=0
Rk12 (\7\:S1b \9\:S1b) resistor r=0.1976 c=0
Rk13 (\9\:S1b \11\:S1b) resistor r=0.5988 c=0
Rk14 (\9\:S1b \12\:S1b) resistor r=0.02782 c=0
Rk27 (\6\:S0b \7\:S0b) resistor r=0.1368 c=0
Rk28 (\7\:S0b \8\:S0b) resistor r=0.4793 c=0
Rk29 (\8\:S0b \9\:S0b) resistor r=0.3825 c=0
Rk30 (\7\:S0b \11\:S0b) resistor r=0.4507 c=0
Rl27 (\1\:A \2\:A) resistor r=160.307 c=0
Rl28 (\2\:A \3\:A) resistor r=98.7687 c=0
Rl12 (\1\:C \2\:C) resistor r=74.2328 c=0
Rl13 (\2\:C \3\:C) resistor r=43.4636 c=0
Rl21 (\1\:B \2\:B) resistor r=181.925 c=0
Rl22 (\2\:B \3\:B) resistor r=74.2328 c=0
Rl29 (\4\:S0 \5\:S0) resistor r=29.5379 c=0
Rl30 (\5\:S0 \6\:S0) resistor r=229.538 c=0
Rl24 (\1\:S0 \2\:S0) resistor r=24.2328 c=0
Rl25 (\2\:S0 \3\:S0) resistor r=233.414 c=0
Rl19 (\2\:S1 \5\:S1) resistor r=77.6559 c=0
Rl16 (\1\:S1 \2\:S1) resistor r=171.32 c=0
Rl20 (\3\:S1 \6\:S1) resistor r=28.0797 c=0
Rl18 (\3\:S1 \4\:S1) resistor r=179.568 c=0
Rl17 (\2\:S1 \3\:S1) resistor r=162.376 c=0
Rl15 (\3\:S1b \4\:S1b) resistor r=48.7687 c=0
Rl14 (S1b \2\:S1b) resistor r=98.0541 c=0
Rl26 (\3\:S0b \4\:S0b) resistor r=80.0021 c=0
Rl23 (S0b \2\:S0b) resistor r=90.1003 c=0
Rz8 (\2\:VSS \1\:VSS) resistor r=75 c=0
Rz9 (\8\:VSS \7\:VSS) resistor r=75 c=0
Rz13 (\5\:VDD \4\:VDD) resistor r=6.25 c=0
Rz14 (\6\:VDD \4\:VDD) resistor r=10.7143 c=0
Rz3 (\14\:n1 \13\:n1) resistor r=75 c=0
Rz5 (n0 \2\:n0) resistor r=75 c=0
Rz6 (\9\:n0 \10\:n0) resistor r=75 c=0
Rz4 (\10\:S1b \11\:S1b) resistor r=75 c=0
Rz7 (\5\:S0b \6\:S0b) resistor r=75 c=0
Ry8 (\4\:VSS \3\:VSS) resistor r=8.8571 c=0
Ry9 (\6\:VSS \3\:VSS) resistor r=5.1667 c=0
Ry10 (\2\:VDD \1\:VDD) resistor r=62 c=0
Ry11 (\8\:VDD \7\:VDD) resistor r=62 c=0
Ry3 (\18\:n1 \17\:n1) resistor r=20.6667 c=0
Ry5 (\5\:n0 \6\:n0) resistor r=62 c=0
Ry6 (\7\:n0 \8\:n0) resistor r=62 c=0
Ry4 (\5\:S1b \6\:S1b) resistor r=62 c=0
Ry7 (\10\:S0b \11\:S0b) resistor r=62 c=0
Rx9 (\2\:A \4\:A) resistor r=45 c=0
Rx1 (\2\:C \4\:C) resistor r=45 c=0
Rx6 (\2\:B \4\:B) resistor r=45 c=0
Rx7 (\5\:S0 \7\:S0) resistor r=45 c=0
Rx8 (\2\:S0 \8\:S0) resistor r=45 c=0
Rx5 (\2\:S1 \7\:S1) resistor r=45 c=0
Rx2 (\16\:n1 n1) resistor r=45 c=0
Rx3 (S1b \8\:S1b) resistor r=45 c=0
Rx4 (\4\:S1b \12\:S1b) resistor r=45 c=0
Rx10 (\4\:S0b \8\:S0b) resistor r=45 c=0
Rx11 (\2\:S0b \9\:S0b) resistor r=45 c=0
mn7 (net245 \3\:C \6\:VSS VSS) g45n1hvt w=(2.6e-07) l=4.5e-08 nf=1 \
        as=4.55e-14 ad=5.59e-14 ps=8.7e-07 pd=9.5e-07 nrd=1.16667 \
        nrs=1.16667 sa=1.055e-06 sb=7.2e-07 sd=160n sca=15.3338 \
        scb=0.0153436 scc=0.00119435 m=(1)
mn8 (\13\:n1 \4\:S1 net245 VSS) g45n1hvt w=(2.6e-07) l=4.5e-08 nf=1 \
        as=5.59e-14 ad=7.15e-14 ps=9.5e-07 pd=1.07e-06 nrd=1.16667 \
        nrs=1.16667 sa=1.315e-06 sb=4.6e-07 sd=160n sca=15.3338 \
        scb=0.0153436 scc=0.00119435 m=(1)
mn6 (\13\:n1 \3\:S1b \9\:n0 VSS) g45n1hvt w=(2.6e-07) l=4.5e-08 nf=1 \
        as=3.64e-14 ad=7.15e-14 ps=8e-07 pd=1.07e-06 nrd=1.16667 \
        nrs=1.16667 sa=1.635e-06 sb=1.4e-07 sd=160n sca=15.3338 \
        scb=0.0153436 scc=0.00119435 m=(1)
mn9_1__rcx (\4\:Y n1 \6\:VSS VSS) g45n1hvt w=(2.6e-07) l=4.5e-08 nf=1 \
        as=4.127e-14 ad=5.2e-14 ps=8.375e-07 pd=9.2e-07 nrd=1.16667 \
        nrs=1.16667 sa=1.4e-07 sb=1.635e-06 sd=160n sca=15.3338 \
        scb=0.0153436 scc=0.00119435 m=(4)
mn1 (\10\:S1b \1\:S1 \7\:VSS VSS) g45n1hvt w=(1.45e-07) l=4.5e-08 nf=1 \
        as=2.32e-14 ad=2.03e-14 ps=6.1e-07 pd=5.7e-07 nrd=1.16667 \
        nrs=1.16667 sa=1.4e-07 sb=1.365e-06 sd=160n sca=7.18188 \
        scb=0.00417289 scc=4.04165e-05 m=(1)
mn4 (net234 \3\:B \7\:VSS VSS) g45n1hvt w=(1.45e-07) l=4.5e-08 nf=1 \
        as=2.32e-14 ad=4.785e-14 ps=6.1e-07 pd=9.5e-07 nrd=1.16667 \
        nrs=1.16667 sa=3.45e-07 sb=1.16e-06 sd=160n sca=7.18188 \
        scb=0.00417289 scc=4.04165e-05 m=(1)
mn5 (n0 \3\:S0 net234 VSS) g45n1hvt w=(1.45e-07) l=4.5e-08 nf=1 \
        as=4.785e-14 ad=2.32e-14 ps=9.5e-07 pd=6.1e-07 nrd=1.16667 \
        nrs=1.16667 sa=7.2e-07 sb=7.85e-07 sd=160n sca=7.18188 \
        scb=0.00417289 scc=4.04165e-05 m=(1)
mn3 (n0 \3\:S0b net229 VSS) g45n1hvt w=(1.45e-07) l=4.5e-08 nf=1 \
        as=1.16e-14 ad=2.32e-14 ps=4.5e-07 pd=6.1e-07 nrd=1.16667 \
        nrs=1.16667 sa=9.25e-07 sb=5.8e-07 sd=160n sca=7.18188 \
        scb=0.00417289 scc=4.04165e-05 m=(1)
mn2 (net229 \3\:A \1\:VSS VSS) g45n1hvt w=(1.45e-07) l=4.5e-08 nf=1 \
        as=3.19e-14 ad=1.16e-14 ps=7.3e-07 pd=4.5e-07 nrd=1.16667 \
        nrs=1.16667 sa=1.05e-06 sb=4.55e-07 sd=160n sca=7.18188 \
        scb=0.00417289 scc=4.04165e-05 m=(1)
mn0 (\5\:S0b \6\:S0 \1\:VSS VSS) g45n1hvt w=(1.45e-07) l=4.5e-08 nf=1 \
        as=3.19e-14 ad=2.755e-14 ps=7.3e-07 pd=6.7e-07 nrd=1.16667 \
        nrs=1.16667 sa=1.315e-06 sb=1.9e-07 sd=160n sca=7.18188 \
        scb=0.00417289 scc=4.04165e-05 m=(1)
mp1 (\5\:S1b \5\:S1 \1\:VDD VDD) g45p1hvt w=(2.15e-07) l=4.5e-08 nf=1 \
        as=3.548e-14 ad=3.01e-14 ps=7.6e-07 pd=7.1e-07 nrd=1.16667 \
        nrs=1.16667 sa=1.4e-07 sb=1.4e-06 sd=160n sca=10.6366 \
        scb=0.00827102 scc=0.000128406 m=(1)
mp4 (net190 \1\:B \1\:VDD VDD) g45p1hvt w=(2.15e-07) l=4.5e-08 nf=1 \
        as=3.548e-14 ad=3.762e-14 ps=7.6e-07 pd=7.8e-07 nrd=1.16667 \
        nrs=1.16667 sa=3.5e-07 sb=1.19e-06 sd=160n sca=10.6366 \
        scb=0.00827102 scc=0.000128406 m=(1)
mp5 (\7\:n0 S0b net190 VDD) g45p1hvt w=(2.15e-07) l=4.5e-08 nf=1 \
        as=3.762e-14 ad=3.44e-14 ps=7.8e-07 pd=7.5e-07 nrd=1.16667 \
        nrs=1.16667 sa=5.7e-07 sb=9.7e-07 sd=160n sca=10.6366 \
        scb=0.00827102 scc=0.000128406 m=(1)
mp3 (\7\:n0 \1\:S0 net189 VDD) g45p1hvt w=(2.15e-07) l=4.5e-08 nf=1 \
        as=5.052e-14 ad=3.44e-14 ps=9e-07 pd=7.5e-07 nrd=1.16667 \
        nrs=1.16667 sa=7.75e-07 sb=7.65e-07 sd=160n sca=10.9501 \
        scb=0.00835862 scc=0.000128423 m=(1)
mp2 (net189 \1\:A \7\:VDD VDD) g45p1hvt w=(2.15e-07) l=4.5e-08 nf=1 \
        as=4.73e-14 ad=5.052e-14 ps=8.7e-07 pd=9e-07 nrd=1.16667 \
        nrs=1.16667 sa=1.055e-06 sb=4.85e-07 sd=160n sca=12.393 \
        scb=0.00963865 scc=0.000131709 m=(1)
mp0 (\10\:S0b \4\:S0 \7\:VDD VDD) g45p1hvt w=(2.15e-07) l=4.5e-08 nf=1 \
        as=4.73e-14 ad=4.73e-14 ps=8.7e-07 pd=8.7e-07 nrd=1.16667 \
        nrs=1.16667 sa=1.32e-06 sb=2.2e-07 sd=160n sca=18.2413 \
        scb=0.0194209 scc=0.000499991 m=(1)
ends MX3X4
// End of subcircuit definition.
