// Generated for: spectre (May  1 09:16:05 2013 )
// Library name: gsclib045_hvt
// Cell name: SDFFTRX4
// View name: extracted

simulator lang=spectre

subckt SDFFTRX4 CK D Q QN RN SE SI VDD VSS
mp1 (\5\:Db \4\:D \37\:VDD VDD) g45p1hvt w=(2.15e-07) l=4.5e-08 nf=1 \
        as=3.01e-14 ad=4.085e-14 ps=7.1e-07 pd=8.1e-07 nrd=1.16667 \
        nrs=1.16667 sa=1.4e-07 sb=6.4e-07 sd=160n sca=36.2105 \
        scb=0.0289447 scc=0.0042917 m=(1)
mp0 (\5\:Db \1\:RN \35\:VDD VDD) g45p1hvt w=(2.15e-07) l=4.5e-08 nf=1 \
        as=8.45e-14 ad=4.085e-14 ps=1.49e-06 pd=8.1e-07 nrd=1.16667 \
        nrs=1.16667 sa=3.75e-07 sb=4.05e-07 sd=160n sca=34.1358 \
        scb=0.0262014 scc=0.0042716 m=(1)
mp10 (\9\:SEb \6\:SE \35\:VDD VDD) g45p1hvt w=(2.15e-07) l=4.5e-08 nf=1 \
        as=8.45e-14 ad=3.01e-14 ps=1.49e-06 pd=7.1e-07 nrd=1.16667 \
        nrs=1.16667 sa=6.4e-07 sb=1.4e-07 sd=160n sca=33.3059 \
        scb=0.0257988 scc=0.00427133 m=(1)
mp11 (\9\:Dbp \5\:SE \3\:Db VDD) g45p1hvt w=(2.15e-07) l=4.5e-08 nf=1 \
        as=3.01e-14 ad=5.268e-14 ps=7.1e-07 pd=9.2e-07 nrd=1.16667 \
        nrs=1.16667 sa=1.4e-07 sb=9.05e-07 sd=160n sca=10.3756 \
        scb=0.00778655 scc=9.84544e-05 m=(1)
mp13 (\9\:Dbp \3\:SEb net411 VDD) g45p1hvt w=(2.15e-07) l=4.5e-08 nf=1 \
        as=1.72e-14 ad=5.268e-14 ps=5.9e-07 pd=9.2e-07 nrd=1.16667 \
        nrs=1.16667 sa=4.3e-07 sb=6.15e-07 sd=160n sca=10.3756 \
        scb=0.00778655 scc=9.84544e-05 m=(1)
mp12 (net411 \1\:SI \33\:VDD VDD) g45p1hvt w=(2.15e-07) l=4.5e-08 nf=1 \
        as=4.515e-14 ad=1.72e-14 ps=8.5e-07 pd=5.9e-07 nrd=1.16667 \
        nrs=1.16667 sa=5.55e-07 sb=4.9e-07 sd=160n sca=10.3756 \
        scb=0.00778655 scc=9.84544e-05 m=(1)
mp20 (\14\:CKb \1\:CK \33\:VDD VDD) g45p1hvt w=(2.15e-07) l=4.5e-08 nf=1 \
        as=4.515e-14 ad=5.053e-14 ps=8.5e-07 pd=9e-07 nrd=1.16667 \
        nrs=1.16667 sa=8.1e-07 sb=2.35e-07 sd=160n sca=10.3756 \
        scb=0.00778655 scc=9.84544e-05 m=(1)
mp21 (\17\:CKbb \8\:CKb \31\:VDD VDD) g45p1hvt w=(2.15e-07) l=4.5e-08 \
        nf=1 as=4.8e-14 ad=3.01e-14 ps=1.41e-06 pd=7.1e-07 nrd=1.16667 \
        nrs=1.16667 sa=1e-07 sb=1.4e-07 sd=160n sca=45.7906 scb=0.0283307 \
        scc=0.00588417 m=(1)
mp25 (\8\:n20 CKbb Dbp VDD) g45p1hvt w=(2.15e-07) l=4.5e-08 nf=1 \
        as=3.01e-14 ad=4.515e-14 ps=7.1e-07 pd=8.5e-07 nrd=1.16667 \
        nrs=1.16667 sa=1.4e-07 sb=2e-06 sd=160n sca=20.4333 scb=0.0198015 \
        scc=0.00193653 m=(1)
mp36 (\8\:n20 \3\:CKb net375 VDD) g45p1hvt w=(2.15e-07) l=4.5e-08 nf=1 \
        as=1.29e-14 ad=4.515e-14 ps=5.5e-07 pd=8.5e-07 nrd=1.16667 \
        nrs=1.16667 sa=3.95e-07 sb=2e-06 sd=160n sca=20.4333 scb=0.0198015 \
        scc=0.00193653 m=(1)
mp35 (net375 mout \29\:VDD VDD) g45p1hvt w=(2.15e-07) l=4.5e-08 nf=1 \
        as=4.085e-14 ad=1.29e-14 ps=8.1e-07 pd=5.5e-07 nrd=1.16667 \
        nrs=1.16667 sa=5e-07 sb=2e-06 sd=160n sca=20.4333 scb=0.0198015 \
        scc=0.00193653 m=(1)
mp30 (\4\:mout n20 \29\:VDD VDD) g45p1hvt w=(2.15e-07) l=4.5e-08 nf=1 \
        as=4.085e-14 ad=7.848e-14 ps=8.1e-07 pd=1.16e-06 nrd=1.16667 \
        nrs=1.16667 sa=7.35e-07 sb=2e-06 sd=160n sca=20.4333 scb=0.0198015 \
        scc=0.00193653 m=(1)
mp40 (\10\:n30 \2\:CKb \4\:mout VDD) g45p1hvt w=(2.15e-07) l=4.5e-08 nf=1 \
        as=7.848e-14 ad=3.44e-14 ps=1.16e-06 pd=7.5e-07 nrd=1.16667 \
        nrs=1.16667 sa=1.145e-06 sb=2e-06 sd=160n sca=20.4333 \
        scb=0.0198015 scc=0.00193653 m=(1)
mp51 (\10\:n30 \7\:CKbb net395 VDD) g45p1hvt w=(2.15e-07) l=4.5e-08 nf=1 \
        as=3.118e-14 ad=3.44e-14 ps=7.2e-07 pd=7.5e-07 nrd=1.16667 \
        nrs=1.16667 sa=1.35e-06 sb=2e-06 sd=160n sca=20.4333 scb=0.0198015 \
        scc=0.00193653 m=(1)
mp50 (net395 \4\:qbint \3\:VDD VDD) g45p1hvt w=(2.15e-07) l=4.5e-08 nf=1 \
        as=5.415e-14 ad=3.118e-14 ps=1e-06 pd=7.2e-07 nrd=1.16667 \
        nrs=1.16667 sa=1.54e-06 sb=2e-06 sd=160n sca=20.4333 scb=0.0198015 \
        scc=0.00193653 m=(1)
C1 (Q VSS) capacitor c=2.39715e-17
C2 (CK VSS) capacitor c=7.11322e-17
C3 (D VSS) capacitor c=2.84813e-17
C4 (SI VSS) capacitor c=6.60778e-17
C5 (QN VSS) capacitor c=1.56514e-17
C6 (VDD VSS) capacitor c=3.61065e-16
C7 (SE VSS) capacitor c=6.19716e-17
C8 (Db VSS) capacitor c=1.05934e-16
C9 (SEb VSS) capacitor c=4.99404e-17
C10 (Dbp VSS) capacitor c=2.13729e-17
C11 (net484 VSS) capacitor c=1.46245e-18
C12 (CKb VSS) capacitor c=7.82702e-17
C13 (CKbb VSS) capacitor c=3.49543e-17
C14 (n20 VSS) capacitor c=5.1853e-17
C15 (mout VSS) capacitor c=6.22266e-17
C16 (n30 VSS) capacitor c=2.16145e-16
C17 (qbint VSS) capacitor c=2.97843e-17
C18 (net436 VSS) capacitor c=2.78527e-16
C19 (net395 VSS) capacitor c=5.26647e-18
C20 (\22\:qbint VSS) capacitor c=4.66957e-17
C21 (\5\:qbint VSS) capacitor c=2.67001e-16
C22 (\4\:qbint VSS) capacitor c=3.89633e-17
C23 (\7\:CKbb VSS) capacitor c=5.08373e-17
C24 (\2\:CKb VSS) capacitor c=1.0612e-16
C25 (\3\:CKb VSS) capacitor c=1.20261e-16
C26 (\8\:CKb VSS) capacitor c=2.6888e-17
C27 (\1\:CK VSS) capacitor c=5.81466e-17
C28 (\1\:SI VSS) capacitor c=8.528e-17
C29 (\3\:SEb VSS) capacitor c=5.53599e-17
C30 (\5\:SE VSS) capacitor c=3.62243e-17
C31 (\6\:SE VSS) capacitor c=2.76079e-17
C32 (\1\:RN VSS) capacitor c=4.01302e-17
C33 (\4\:D VSS) capacitor c=2.85192e-17
C34 (\20\:qbint VSS) capacitor c=3.58492e-17
C35 (\3\:qbint VSS) capacitor c=6.35779e-17
C36 (\5\:CKbb VSS) capacitor c=3.60884e-17
C37 (\3\:n20 VSS) capacitor c=3.32006e-17
C38 (\3\:mout VSS) capacitor c=6.90811e-17
C39 (\3\:CKbb VSS) capacitor c=8.18547e-17
C40 (\7\:CKb VSS) capacitor c=3.33095e-17
C41 (\9\:CKb VSS) capacitor c=1.44712e-17
C42 (\3\:CK VSS) capacitor c=2.4821e-17
C43 (\3\:SI VSS) capacitor c=3.11533e-17
C44 (\1\:SE VSS) capacitor c=6.68987e-17
C45 (\4\:SE VSS) capacitor c=2.69914e-17
C46 (\3\:RN VSS) capacitor c=4.57301e-17
C47 (\1\:D VSS) capacitor c=5.14324e-17
C48 (\21\:qbint VSS) capacitor c=4.06637e-17
C49 (\8\:CKbb VSS) capacitor c=4.00883e-17
C50 (\6\:CKbb VSS) capacitor c=3.39314e-17
C51 (\2\:n20 VSS) capacitor c=3.63214e-17
C52 (\2\:mout VSS) capacitor c=5.71191e-17
C53 (\4\:CKbb VSS) capacitor c=2.53154e-17
C54 (\2\:CKbb VSS) capacitor c=4.15301e-17
C55 (\6\:CKb VSS) capacitor c=1.01851e-17
C56 (\2\:CK VSS) capacitor c=4.22267e-17
C57 (\2\:SI VSS) capacitor c=5.29796e-17
C58 (\4\:SEb VSS) capacitor c=4.269e-17
C59 (\2\:SEb VSS) capacitor c=2.34315e-17
C60 (\3\:SE VSS) capacitor c=4.54854e-17
C61 (\2\:RN VSS) capacitor c=4.31006e-17
C62 (\3\:D VSS) capacitor c=1.27384e-17
C63 (\19\:net436 VSS) capacitor c=3.4963e-17
C64 (\1\:Q VSS) capacitor c=1.52323e-16
C65 (\30\:qbint VSS) capacitor c=5.96205e-17
C66 (\10\:n30 VSS) capacitor c=5.85094e-17
C67 (\4\:mout VSS) capacitor c=2.33674e-17
C68 (\29\:VDD VSS) capacitor c=3.44902e-17
C69 (\8\:n20 VSS) capacitor c=3.53941e-17
C70 (\17\:CKbb VSS) capacitor c=5.18792e-17
C71 (\31\:VDD VSS) capacitor c=3.26324e-17
C72 (\14\:CKb VSS) capacitor c=7.15198e-17
C73 (\33\:VDD VSS) capacitor c=4.21129e-17
C74 (\9\:Dbp VSS) capacitor c=1.88317e-17
C75 (\3\:Db VSS) capacitor c=1.65037e-16
C76 (\9\:SEb VSS) capacitor c=1.2863e-16
C77 (\35\:VDD VSS) capacitor c=2.27971e-17
C78 (\5\:Db VSS) capacitor c=1.51626e-16
C79 (\37\:VDD VSS) capacitor c=3.61567e-17
C80 (\1\:VDD VSS) capacitor c=6.37105e-17
C81 (\15\:net436 VSS) capacitor c=4.45306e-17
C82 (\1\:QN VSS) capacitor c=1.19111e-16
C83 (\24\:qbint VSS) capacitor c=2.14646e-16
C84 (\8\:n30 VSS) capacitor c=6.5001e-17
C85 (\8\:mout VSS) capacitor c=5.26876e-17
C86 (\6\:n20 VSS) capacitor c=3.73304e-17
C87 (\7\:Dbp VSS) capacitor c=1.00578e-16
C88 (\12\:CKbb VSS) capacitor c=8.58798e-17
C89 (\12\:CKb VSS) capacitor c=6.47604e-17
C90 (\5\:Dbp VSS) capacitor c=9.45701e-17
C91 (\7\:SEb VSS) capacitor c=1.35942e-16
C92 (\7\:Db VSS) capacitor c=5.283e-17
C93 (\2\:D VSS) capacitor c=3.00815e-17
C94 (\2\:SE VSS) capacitor c=8.14967e-17
C95 (\4\:CKb VSS) capacitor c=7.30706e-17
C96 (\5\:CKb VSS) capacitor c=2.17849e-17
C97 (\2\:qbint VSS) capacitor c=3.38498e-17
C98 (\5\:D VSS) capacitor c=5.55107e-17
C99 (\4\:RN VSS) capacitor c=1.20683e-16
C100 (\7\:SE VSS) capacitor c=6.17995e-17
C101 (\5\:SEb VSS) capacitor c=1.22683e-16
C102 (\6\:SEb VSS) capacitor c=1.56075e-16
C103 (\4\:SI VSS) capacitor c=5.01263e-17
C104 (\4\:CK VSS) capacitor c=4.6089e-17
C105 (\10\:CKb VSS) capacitor c=3.03577e-17
C106 (\11\:CKb VSS) capacitor c=7.77925e-17
C107 (\3\:Dbp VSS) capacitor c=1.85125e-16
C108 (\4\:Dbp VSS) capacitor c=2.10498e-16
C109 (\4\:n20 VSS) capacitor c=5.85191e-17
C110 (\5\:n20 VSS) capacitor c=5.11866e-17
C111 (\6\:mout VSS) capacitor c=5.44423e-17
C112 (\7\:mout VSS) capacitor c=4.49937e-17
C113 (\9\:CKbb VSS) capacitor c=2.17305e-17
C114 (\10\:CKbb VSS) capacitor c=9.53747e-17
C115 (\11\:CKbb VSS) capacitor c=8.01948e-17
C116 (\14\:CKbb VSS) capacitor c=1.27234e-16
C117 (\15\:CKbb VSS) capacitor c=6.37725e-17
C118 (\16\:CKbb VSS) capacitor c=7.63083e-17
C119 (\6\:n30 VSS) capacitor c=5.19167e-17
C120 (\7\:n30 VSS) capacitor c=8.56421e-17
C121 (\4\:Q VSS) capacitor c=1.22159e-16
C122 (\5\:QN VSS) capacitor c=1.65428e-16
C123 (\23\:qbint VSS) capacitor c=2.438e-16
C124 (\26\:qbint VSS) capacitor c=3.24092e-17
C125 (\27\:qbint VSS) capacitor c=2.28718e-17
C126 (\28\:qbint VSS) capacitor c=4.72822e-17
C127 (\29\:qbint VSS) capacitor c=2.98427e-17
C128 (\17\:net436 VSS) capacitor c=3.5483e-17
C129 (\18\:net436 VSS) capacitor c=3.78918e-17
C130 (\3\:VDD VSS) capacitor c=4.7804e-16
C131 (\10\:VDD VSS) capacitor c=2.00054e-17
C132 (\12\:VDD VSS) capacitor c=2.60623e-17
C133 (\13\:VDD VSS) capacitor c=3.55335e-17
C134 (\15\:VDD VSS) capacitor c=1.22526e-17
C135 (\16\:VDD VSS) capacitor c=7.72461e-18
Rk2 (\4\:RN RN) resistor r=0.01002 c=0
Rk37 (\1\:Q Q) resistor r=0.04991 c=0
Rk38 (Q \4\:Q) resistor r=0.2128 c=0
Rk11 (CK \4\:CK) resistor r=0.1608 c=0
Rk1 (\5\:D D) resistor r=0.1911 c=0
Rk10 (SI \4\:SI) resistor r=0.1745 c=0
Rk43 (\1\:QN QN) resistor r=0.217 c=0
Rk44 (QN \5\:QN) resistor r=0.04798 c=0
Rk80 (\2\:VDD \3\:VDD) resistor r=0.2254 c=0
Rk87 (\3\:VDD \10\:VDD) resistor r=0.5361 c=0
Rk88 (\10\:VDD \11\:VDD) resistor r=0.08755 c=0
Rk89 (\11\:VDD \12\:VDD) resistor r=0.4059 c=0
Rk90 (\12\:VDD \13\:VDD) resistor r=0.3506 c=0
Rk91 (\13\:VDD \14\:VDD) resistor r=0.446 c=0
Rk92 (\14\:VDD \15\:VDD) resistor r=0.1928 c=0
Rk94 (\16\:VDD VDD) resistor r=0.1224 c=0
Rk93 (\15\:VDD \16\:VDD) resistor r=0.2353 c=0
Rk101 (\10\:VDD \30\:VDD) resistor r=0.3636 c=0
Rk102 (\12\:VDD \32\:VDD) resistor r=0.2292 c=0
Rk103 (\13\:VDD \34\:VDD) resistor r=0.244 c=0
Rk104 (\15\:VDD \36\:VDD) resistor r=0.1936 c=0
Rk105 (\16\:VDD \38\:VDD) resistor r=0.4113 c=0
Rk56 (\2\:VSS \3\:VSS) resistor r=0.1252 c=0
Rk63 (\3\:VSS \10\:VSS) resistor r=0.4775 c=0
Rk64 (\10\:VSS \11\:VSS) resistor r=0.07908 c=0
Rk65 (\11\:VSS \12\:VSS) resistor r=0.4786 c=0
Rk66 (\12\:VSS \13\:VSS) resistor r=0.2779 c=0
Rk67 (\13\:VSS \14\:VSS) resistor r=0.446 c=0
Rk69 (\15\:VSS VSS) resistor r=0.343 c=0
Rk68 (\14\:VSS \15\:VSS) resistor r=0.2079 c=0
Rk76 (\10\:VSS \29\:VSS) resistor r=0.04329 c=0
Rk77 (\12\:VSS \31\:VSS) resistor r=0.3791 c=0
Rk78 (\13\:VSS \33\:VSS) resistor r=0.236 c=0
Rk79 (\15\:VSS \35\:VSS) resistor r=0.2903 c=0
Rk3 (\7\:SE SE) resistor r=0.02806 c=0
Rk4 (\2\:Db \4\:Db) resistor r=0.6735 c=0
Rk5 (\4\:Db \6\:Db) resistor r=0.8044 c=0
Rk6 (\6\:Db \8\:Db) resistor r=0.3895 c=0
Rk7 (\5\:SEb \6\:SEb) resistor r=0.8129 c=0
Rk8 (\6\:SEb \8\:SEb) resistor r=0.5887 c=0
Rk9 (\8\:SEb \10\:SEb) resistor r=0.7909 c=0
Rk15 (\2\:Dbp \3\:Dbp) resistor r=0.07204 c=0
Rk16 (\3\:Dbp \4\:Dbp) resistor r=1.3455 c=0
Rk17 (\4\:Dbp \6\:Dbp) resistor r=0.667 c=0
Rk18 (\3\:Dbp \8\:Dbp) resistor r=0.4975 c=0
Rk19 (\4\:Dbp \10\:Dbp) resistor r=0.05258 c=0
Rk12 (\10\:CKb \11\:CKb) resistor r=0.1655 c=0
Rk13 (\11\:CKb \13\:CKb) resistor r=0.3674 c=0
Rk14 (\11\:CKb \15\:CKb) resistor r=0.3375 c=0
Rk26 (\9\:CKbb \10\:CKbb) resistor r=0.02533 c=0
Rk27 (\10\:CKbb \11\:CKbb) resistor r=0.2134 c=0
Rk28 (\11\:CKbb \13\:CKbb) resistor r=0.3986 c=0
Rk29 (\10\:CKbb \14\:CKbb) resistor r=0.771 c=0
Rk30 (\14\:CKbb \15\:CKbb) resistor r=0.3035 c=0
Rk31 (\11\:CKbb \16\:CKbb) resistor r=0.404 c=0
Rk32 (\13\:CKbb \18\:CKbb) resistor r=0.2928 c=0
Rk20 (\4\:n20 \5\:n20) resistor r=0.2802 c=0
Rk21 (\5\:n20 \7\:n20) resistor r=0.1273 c=0
Rk22 (\5\:n20 \9\:n20) resistor r=0.2615 c=0
Rk23 (\5\:mout \6\:mout) resistor r=0.1407 c=0
Rk24 (\6\:mout \7\:mout) resistor r=0.2414 c=0
Rk25 (\6\:mout \9\:mout) resistor r=0.2584 c=0
Rk33 (\6\:n30 \7\:n30) resistor r=0.2587 c=0
Rk34 (\7\:n30 \9\:n30) resistor r=0.3143 c=0
Rk35 (\7\:n30 \11\:n30) resistor r=0.4203 c=0
Rk47 (\23\:qbint \25\:qbint) resistor r=1.8791 c=0
Rk48 (\25\:qbint \26\:qbint) resistor r=0.4293 c=0
Rk49 (\26\:qbint \27\:qbint) resistor r=0.1058 c=0
Rk50 (\27\:qbint \28\:qbint) resistor r=0.1785 c=0
Rk51 (\26\:qbint \29\:qbint) resistor r=0.06834 c=0
Rk52 (\27\:qbint \31\:qbint) resistor r=0.1976 c=0
Rk53 (\16\:net436 \17\:net436) resistor r=0.3545 c=0
Rk54 (\17\:net436 \18\:net436) resistor r=0.2072 c=0
Rk55 (\17\:net436 \20\:net436) resistor r=0.1266 c=0
Rl4 (\1\:RN \2\:RN) resistor r=78.079 c=0
Rl5 (\2\:RN \3\:RN) resistor r=37.6944 c=0
Rl15 (\1\:CK \2\:CK) resistor r=212.23 c=0
Rl16 (\2\:CK \3\:CK) resistor r=39.1533 c=0
Rl3 (\2\:D \4\:D) resistor r=66.0479 c=0
Rl1 (\1\:D \2\:D) resistor r=94.5391 c=0
Rl2 (\2\:D \3\:D) resistor r=12.1383 c=0
Rl13 (\1\:SI \2\:SI) resistor r=210.771 c=0
Rl14 (\2\:SI \3\:SI) resistor r=37.6944 c=0
Rl11 (\3\:SE \6\:SE) resistor r=33.4251 c=0
Rl9 (\3\:SE \4\:SE) resistor r=76.7181 c=0
Rl10 (\2\:SE \5\:SE) resistor r=122.758 c=0
Rl7 (\1\:SE \2\:SE) resistor r=215.363 c=0
Rl8 (\2\:SE \3\:SE) resistor r=213.851 c=0
Rl12 (\3\:SEb \4\:SEb) resistor r=62.2302 c=0
Rl6 (SEb \2\:SEb) resistor r=29.5379 c=0
Rl25 (\2\:CKb \3\:CKb) resistor r=408.747 c=0
Rl24 (CKb \2\:CKb) resistor r=187.593 c=0
Rl31 (\6\:CKb \9\:CKb) resistor r=26.1559 c=0
Rl26 (\3\:CKb \4\:CKb) resistor r=143.774 c=0
Rl29 (\4\:CKb \7\:CKb) resistor r=55.4507 c=0
Rl30 (\5\:CKb \8\:CKb) resistor r=37.2017 c=0
Rl28 (\5\:CKb \6\:CKb) resistor r=9.8883 c=0
Rl27 (\4\:CKb \5\:CKb) resistor r=206.49 c=0
Rl32 (\7\:CKbb \8\:CKbb) resistor r=29.5379 c=0
Rl23 (\5\:CKbb \6\:CKbb) resistor r=29.5379 c=0
Rl18 (\3\:CKbb \4\:CKbb) resistor r=58.3841 c=0
Rl17 (CKbb \2\:CKbb) resistor r=28.079 c=0
Rl21 (n20 \2\:n20) resistor r=100.692 c=0
Rl22 (\2\:n20 \3\:n20) resistor r=29.5379 c=0
Rl19 (mout \2\:mout) resistor r=37.6944 c=0
Rl20 (\2\:mout \3\:mout) resistor r=89.6174 c=0
Rl68 (\21\:qbint \22\:qbint) resistor r=62.6944 c=0
Rl67 (\21\:qbint \20\:qbint) resistor r=69.7702 c=0
Rl35 (\2\:qbint \4\:qbint) resistor r=37.3411 c=0
Rl34 (\2\:qbint \3\:qbint) resistor r=129.214 c=0
Rl33 (\2\:qbint qbint) resistor r=6.99 c=0
Rz27 (\2\:VDD \1\:VDD) resistor r=37.5 c=0
Rz28 (\3\:VDD \1\:VDD) resistor r=6.25 c=0
Rz29 (\11\:VDD \1\:VDD) resistor r=6.25 c=0
Rz30 (\14\:VDD \1\:VDD) resistor r=6.25 c=0
Rz23 (\29\:VSS \28\:VSS) resistor r=75 c=0
Rz24 (\31\:VSS \30\:VSS) resistor r=75 c=0
Rz25 (\33\:VSS \32\:VSS) resistor r=75 c=0
Rz26 (\35\:VSS \34\:VSS) resistor r=75 c=0
Rz1 (Db \2\:Db) resistor r=75 c=0
Rz2 (\7\:Db \8\:Db) resistor r=75 c=0
Rz3 (\7\:SEb \8\:SEb) resistor r=75 c=0
Rz5 (\5\:Dbp \6\:Dbp) resistor r=75 c=0
Rz6 (\7\:Dbp \8\:Dbp) resistor r=75 c=0
Rz4 (\12\:CKb \13\:CKb) resistor r=75 c=0
Rz9 (\12\:CKbb \13\:CKbb) resistor r=75 c=0
Rz7 (\6\:n20 \7\:n20) resistor r=75 c=0
Rz8 (\8\:mout \9\:mout) resistor r=75 c=0
Rz10 (\9\:n30 \8\:n30) resistor r=75 c=0
Rz15 (\25\:qbint \24\:qbint) resistor r=75 c=0
Rz16 (\16\:net436 \15\:net436) resistor r=75 c=0
Ry27 (\30\:VDD \29\:VDD) resistor r=62 c=0
Ry28 (\32\:VDD \31\:VDD) resistor r=62 c=0
Ry29 (\34\:VDD \33\:VDD) resistor r=62 c=0
Ry30 (\36\:VDD \35\:VDD) resistor r=62 c=0
Ry31 (\38\:VDD \37\:VDD) resistor r=62 c=0
Ry17 (\2\:VSS \1\:VSS) resistor r=31 c=0
Ry18 (\3\:VSS \1\:VSS) resistor r=5.1667 c=0
Ry19 (\11\:VSS \1\:VSS) resistor r=5.1667 c=0
Ry20 (\14\:VSS \1\:VSS) resistor r=5.1667 c=0
Ry1 (\3\:Db \4\:Db) resistor r=62 c=0
Ry2 (\5\:Db \6\:Db) resistor r=62 c=0
Ry3 (\9\:SEb \10\:SEb) resistor r=62 c=0
Ry5 (Dbp \2\:Dbp) resistor r=62 c=0
Ry6 (\9\:Dbp \10\:Dbp) resistor r=62 c=0
Ry4 (\14\:CKb \15\:CKb) resistor r=62 c=0
Ry9 (\17\:CKbb \18\:CKbb) resistor r=62 c=0
Ry7 (\8\:n20 \9\:n20) resistor r=62 c=0
Ry8 (\4\:mout \5\:mout) resistor r=62 c=0
Ry10 (\11\:n30 \10\:n30) resistor r=62 c=0
Ry15 (\31\:qbint \30\:qbint) resistor r=31 c=0
Ry16 (\20\:net436 \19\:net436) resistor r=20.6667 c=0
Rx2 (\2\:RN \4\:RN) resistor r=45 c=0
Rx7 (\2\:CK \4\:CK) resistor r=45 c=0
Rx1 (\3\:D \5\:D) resistor r=45 c=0
Rx6 (\2\:SI \4\:SI) resistor r=45 c=0
Rx3 (\3\:SE \7\:SE) resistor r=45 c=0
Rx4 (\4\:SEb \5\:SEb) resistor r=45 c=0
Rx5 (\2\:SEb \6\:SEb) resistor r=45 c=0
Rx8 (\6\:CKb \10\:CKb) resistor r=45 c=0
Rx11 (\4\:CKbb \9\:CKbb) resistor r=45 c=0
Rx12 (\6\:CKbb \14\:CKbb) resistor r=45 c=0
Rx13 (\8\:CKbb \15\:CKbb) resistor r=45 c=0
Rx14 (\2\:CKbb \16\:CKbb) resistor r=45 c=0
Rx9 (\2\:n20 \4\:n20) resistor r=45 c=0
Rx10 (\2\:mout \7\:mout) resistor r=45 c=0
Rx15 (\6\:n30 n30) resistor r=45 c=0
Rx16 (\23\:qbint \21\:qbint) resistor r=45 c=0
Rx17 (\28\:qbint qbint) resistor r=45 c=0
Rx18 (\29\:qbint \5\:qbint) resistor r=45 c=0
Rx19 (\18\:net436 net436) resistor r=45 c=0
mn1 (\7\:Db \1\:D net476 VSS) g45n1hvt w=(1.45e-07) l=4.5e-08 nf=1 \
        as=8.7e-15 ad=2.03e-14 ps=4.1e-07 pd=5.7e-07 nrd=1.16667 \
        nrs=1.16667 sa=1.4e-07 sb=5.1e-07 sd=160n sca=11.7118 \
        scb=0.0116498 scc=0.000458536 m=(1)
mn0 (net476 \3\:RN \34\:VSS VSS) g45n1hvt w=(1.45e-07) l=4.5e-08 nf=1 \
        as=3.19e-14 ad=8.7e-15 ps=7.3e-07 pd=4.1e-07 nrd=1.16667 \
        nrs=1.16667 sa=2.45e-07 sb=4.05e-07 sd=160n sca=11.7118 \
        scb=0.0116498 scc=0.000458536 m=(1)
mn10 (\7\:SEb \4\:SE \34\:VSS VSS) g45n1hvt w=(1.45e-07) l=4.5e-08 nf=1 \
        as=3.19e-14 ad=2.03e-14 ps=7.3e-07 pd=5.7e-07 nrd=1.16667 \
        nrs=1.16667 sa=5.1e-07 sb=1.4e-07 sd=160n sca=11.7118 \
        scb=0.0116498 scc=0.000458536 m=(1)
mn11 (Db SEb \5\:Dbp VSS) g45n1hvt w=(1.45e-07) l=4.5e-08 nf=1 \
        as=2.32e-14 ad=2.03e-14 ps=6.1e-07 pd=5.7e-07 nrd=1.16667 \
        nrs=1.16667 sa=1.4e-07 sb=8.1e-07 sd=160n sca=8.0352 \
        scb=0.00565402 scc=8.19771e-05 m=(1)
mn13 (\5\:Dbp \1\:SE net484 VSS) g45n1hvt w=(1.45e-07) l=4.5e-08 nf=1 \
        as=2.392e-14 ad=2.32e-14 ps=6.2e-07 pd=6.1e-07 nrd=1.16667 \
        nrs=1.16667 sa=3.45e-07 sb=6.05e-07 sd=160n sca=8.0352 \
        scb=0.00565402 scc=8.19771e-05 m=(1)
mn12 (net484 \3\:SI \32\:VSS VSS) g45n1hvt w=(1.45e-07) l=4.5e-08 nf=1 \
        as=3.045e-14 ad=2.392e-14 ps=7.1e-07 pd=6.2e-07 nrd=1.16667 \
        nrs=1.16667 sa=5.55e-07 sb=3.95e-07 sd=160n sca=8.0352 \
        scb=0.00565402 scc=8.19771e-05 m=(1)
mn20 (\12\:CKb \3\:CK \32\:VSS VSS) g45n1hvt w=(1.45e-07) l=4.5e-08 nf=1 \
        as=3.045e-14 ad=2.03e-14 ps=7.1e-07 pd=5.7e-07 nrd=1.16667 \
        nrs=1.16667 sa=8.1e-07 sb=1.4e-07 sd=160n sca=8.0352 \
        scb=0.00565402 scc=8.19771e-05 m=(1)
mn21 (\12\:CKbb \9\:CKb \30\:VSS VSS) g45n1hvt w=(1.45e-07) l=4.5e-08 \
        nf=1 as=2.03e-14 ad=2.973e-14 ps=5.7e-07 pd=7e-07 nrd=1.16667 \
        nrs=1.16667 sa=1.4e-07 sb=2.05e-07 sd=160n sca=23.279 \
        scb=0.0230742 scc=0.00267719 m=(1)
mn25 (\7\:Dbp \7\:CKb \6\:n20 VSS) g45n1hvt w=(1.45e-07) l=4.5e-08 nf=1 \
        as=2.32e-14 ad=4.133e-14 ps=6.1e-07 pd=8.6e-07 nrd=1.16667 \
        nrs=1.16667 sa=2.85e-07 sb=2e-06 sd=160n sca=13.253 scb=0.0137915 \
        scc=0.000695334 m=(1)
mn36 (\6\:n20 \3\:CKbb net452 VSS) g45n1hvt w=(1.45e-07) l=4.5e-08 nf=1 \
        as=8.7e-15 ad=2.32e-14 ps=4.1e-07 pd=6.1e-07 nrd=1.16667 \
        nrs=1.16667 sa=4.9e-07 sb=2e-06 sd=160n sca=13.253 scb=0.0137915 \
        scc=0.000695334 m=(1)
mn35 (net452 \3\:mout \28\:VSS VSS) g45n1hvt w=(1.45e-07) l=4.5e-08 nf=1 \
        as=5.345e-14 ad=8.7e-15 ps=1.51e-06 pd=4.1e-07 nrd=1.16667 \
        nrs=1.16667 sa=5.95e-07 sb=2e-06 sd=160n sca=13.253 scb=0.0137915 \
        scc=0.000695334 m=(1)
mn30 (\8\:mout \3\:n20 \28\:VSS VSS) g45n1hvt w=(1.45e-07) l=4.5e-08 \
        nf=1 as=5.345e-14 ad=3.625e-14 ps=1.51e-06 pd=7.9e-07 nrd=1.16667 \
        nrs=1.16667 sa=8.3e-07 sb=2e-06 sd=160n sca=13.253 scb=0.0137915 \
        scc=0.000695334 m=(1)
mn40 (\8\:n30 \5\:CKbb \8\:mout VSS) g45n1hvt w=(1.45e-07) l=4.5e-08 nf=1 \
        as=3.625e-14 ad=3.553e-14 ps=7.9e-07 pd=7.8e-07 nrd=1.16667 \
        nrs=1.16667 sa=1.125e-06 sb=2e-06 sd=160n sca=13.253 scb=0.0137915 \
        scc=0.000695334 m=(1)
mn51 (\8\:n30 CKb net460 VSS) g45n1hvt w=(1.45e-07) l=4.5e-08 nf=1 \
        as=1.088e-14 ad=3.553e-14 ps=4.4e-07 pd=7.8e-07 nrd=1.16667 \
        nrs=1.16667 sa=1.415e-06 sb=2e-06 sd=160n sca=13.253 scb=0.0137915 \
        scc=0.000695334 m=(1)
mn50 (net460 \3\:qbint \3\:VSS VSS) g45n1hvt w=(1.45e-07) l=4.5e-08 nf=1 \
        as=2.92e-14 ad=1.088e-14 ps=7.3e-07 pd=4.4e-07 nrd=1.16667 \
        nrs=1.16667 sa=1.535e-06 sb=2e-06 sd=160n sca=13.253 scb=0.0137915 \
        scc=0.000695334 m=(1)
mn45_1__rcx (\24\:qbint n30 \3\:VSS VSS) g45n1hvt w=(2.05e-07) l=4.5e-08 \
        nf=1 as=5.593e-14 ad=3.28e-14 ps=1.08e-06 pd=7.3e-07 nrd=1.16667 \
        nrs=1.16667 sa=1.26e-06 sb=2e-06 sd=160n sca=11.814 scb=0.0116374 \
        scc=0.000520744 m=(2)
mn56 (\15\:net436 \20\:qbint \3\:VSS VSS) g45n1hvt w=(2.6e-07) l=4.5e-08 \
        nf=1 as=6.76e-14 ad=3.64e-14 ps=1.04e-06 pd=8e-07 nrd=1.16667 \
        nrs=1.16667 sa=2e-06 sb=1.4e-07 sd=160n sca=10.79 scb=0.0100512 \
        scc=0.000418069 m=(1)
mn55_1__rcx (\4\:Q \5\:qbint \3\:VSS VSS) g45n1hvt w=(2.6e-07) l=4.5e-08 \
        nf=1 as=8.471e-14 ad=4.16e-14 ps=1.43e-06 pd=8.4e-07 nrd=1.16667 \
        nrs=1.16667 sa=1.28288e-06 sb=2e-06 sd=160n sca=10.79 \
        scb=0.0100512 scc=0.000418069 m=(4)
mn57_1__rcx (\1\:QN net436 \3\:VSS VSS) g45n1hvt w=(2.6e-07) l=4.5e-08 \
        nf=1 as=8.095e-14 ad=4.745e-14 ps=1.3325e-06 pd=8.85e-07 \
        nrd=1.16667 nrs=1.16667 sa=1.69865e-06 sb=1.165e-06 sd=160n \
        sca=10.79 scb=0.0100512 scc=0.000418069 m=(4)
mp45 (\30\:qbint n30 \3\:VDD VDD) g45p1hvt w=(3.1e-07) l=4.5e-08 nf=1 \
        as=6.213e-14 ad=4.96e-14 ps=1.08e-06 pd=9.4e-07 nrd=1.16667 \
        nrs=1.16667 sa=1.27395e-06 sb=2e-06 sd=160n sca=17.3904 \
        scb=0.0162056 scc=0.00137566 m=(2)
mp56 (\19\:net436 \22\:qbint \3\:VDD VDD) g45p1hvt w=(3.9e-07) l=4.5e-08 \
        nf=1 as=6.24e-14 ad=5.46e-14 ps=1.1e-06 pd=1.06e-06 nrd=1.16667 \
        nrs=1.16667 sa=1.96e-06 sb=1.4e-07 sd=160n sca=32.2573 \
        scb=0.0215683 scc=0.00336427 m=(1)
mp57 (\5\:QN net436 \3\:VDD VDD) g45p1hvt w=(3.9e-07) l=4.5e-08 nf=1 \
        as=6.24e-14 ad=6.728e-14 ps=1.1e-06 pd=1.125e-06 nrd=1.16667 \
        nrs=1.16667 sa=1.64051e-06 sb=9.85e-07 sd=160n sca=30.5009 \
        scb=0.0202006 scc=0.00336097 m=(4)
mp55_1__rcx (\1\:Q \5\:qbint \3\:VDD VDD) g45p1hvt w=(3.9e-07) l=4.5e-08 \
        nf=1 as=6.433e-14 ad=6.24e-14 ps=1.115e-06 pd=1.1e-06 nrd=1.16667 \
        nrs=1.16667 sa=1.27256e-06 sb=1.805e-06 sd=160n sca=30.5009 \
        scb=0.0202006 scc=0.00336097 m=(4)
ends SDFFTRX4
// End of subcircuit definition.
