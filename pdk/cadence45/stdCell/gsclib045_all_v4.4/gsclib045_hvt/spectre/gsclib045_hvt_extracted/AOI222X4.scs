// Generated for: spectre (May  1 09:12:49 2013 )
// Library name: gsclib045_hvt
// Cell name: AOI222X4
// View name: extracted

simulator lang=spectre

subckt AOI222X4 A0 A1 B0 B1 C0 C1 VDD VSS Y
mp2_1__rcx (net122 \1\:B0 net130 VDD) g45p1hvt w=(3.9e-07) l=4.5e-08 nf=1 \
        as=6.24e-14 ad=6.045e-14 ps=1.1e-06 pd=1.09e-06 nrd=1.16667 \
        nrs=1.16667 sa=1.4e-07 sb=2e-06 sd=160n sca=13.5671 scb=0.012183 \
        scc=0.000647513 m=(4)
mp3_1__rcx (net122 B1 net130 VDD) g45p1hvt w=(3.9e-07) l=4.5e-08 nf=1 \
        as=6.24e-14 ad=6.24e-14 ps=1.1e-06 pd=1.1e-06 nrd=1.16667 \
        nrs=1.16667 sa=3.45e-07 sb=2e-06 sd=160n sca=13.5671 scb=0.012183 \
        scc=0.000647513 m=(4)
mp4_1__rcx (\15\:Y C0 net122 VDD) g45p1hvt w=(3.9e-07) l=4.5e-08 nf=1 \
        as=6.045e-14 ad=6.24e-14 ps=1.09e-06 pd=1.1e-06 nrd=1.16667 \
        nrs=1.16667 sa=1.78e-06 sb=1.575e-06 sd=160n sca=13.5671 \
        scb=0.012183 scc=0.000647513 m=(4)
mp5_1__rcx (\15\:Y C1 net122 VDD) g45p1hvt w=(3.9e-07) l=4.5e-08 nf=1 \
        as=6.24e-14 ad=6.24e-14 ps=1.1e-06 pd=1.1e-06 nrd=1.16667 \
        nrs=1.16667 sa=1.985e-06 sb=1.37e-06 sd=160n sca=13.5671 \
        scb=0.012183 scc=0.000647513 m=(4)
mp0_1__rcx (\9\:net130 A0 \4\:VDD VDD) g45p1hvt w=(3.9e-07) l=4.5e-08 \
        nf=1 as=5.85e-14 ad=6.24e-14 ps=1.08e-06 pd=1.1e-06 nrd=1.16667 \
        nrs=1.16667 sa=1.4e-07 sb=1.575e-06 sd=160n sca=21.9778 \
        scb=0.0245713 scc=0.00112692 m=(4)
mp1_1__rcx (\9\:net130 \3\:A1 \4\:VDD VDD) g45p1hvt w=(3.9e-07) \
        l=4.5e-08 nf=1 as=6.24e-14 ad=6.24e-14 ps=1.1e-06 pd=1.1e-06 \
        nrd=1.16667 nrs=1.16667 sa=3.45e-07 sb=1.37e-06 sd=160n \
        sca=16.1431 scb=0.0147518 scc=0.000660481 m=(4)
C1 (C0 VSS) capacitor c=6.53123e-16
C2 (B1 VSS) capacitor c=4.29417e-16
C3 (A0 VSS) capacitor c=6.45907e-16
C4 (C1 VSS) capacitor c=4.35886e-16
C5 (Y VSS) capacitor c=1.08197e-17
C6 (B0 VSS) capacitor c=3.8249e-17
C7 (A1 VSS) capacitor c=2.1242e-17
C8 (VDD VSS) capacitor c=2.94936e-16
C9 (13 VSS) capacitor c=1.75543e-18
C10 (14 VSS) capacitor c=1.75543e-18
C11 (15 VSS) capacitor c=1.75543e-18
C12 (16 VSS) capacitor c=3.05999e-18
C13 (17 VSS) capacitor c=1.75543e-18
C14 (18 VSS) capacitor c=9.92029e-18
C15 (19 VSS) capacitor c=4.50319e-18
C16 (20 VSS) capacitor c=3.05317e-18
C17 (21 VSS) capacitor c=1.75543e-18
C18 (22 VSS) capacitor c=2.07885e-18
C19 (net130 VSS) capacitor c=4.00474e-16
C20 (net122 VSS) capacitor c=6.1325e-16
C21 (\1\:B0 VSS) capacitor c=6.62173e-16
C22 (\12\:C0 VSS) capacitor c=7.08418e-17
C23 (\13\:C1 VSS) capacitor c=4.71552e-17
C24 (\11\:C1 VSS) capacitor c=6.61577e-17
C25 (\8\:C0 VSS) capacitor c=4.85519e-17
C26 (\9\:C0 VSS) capacitor c=6.53982e-17
C27 (\4\:C1 VSS) capacitor c=5.37114e-17
C28 (\6\:C1 VSS) capacitor c=4.67028e-17
C29 (\3\:C0 VSS) capacitor c=4.56304e-17
C30 (\12\:B0 VSS) capacitor c=3.92575e-17
C31 (\13\:B1 VSS) capacitor c=3.80217e-17
C32 (\12\:B1 VSS) capacitor c=1.8349e-17
C33 (\8\:B0 VSS) capacitor c=2.10939e-17
C34 (\9\:B0 VSS) capacitor c=6.64266e-17
C35 (\6\:B1 VSS) capacitor c=4.59948e-17
C36 (\4\:B1 VSS) capacitor c=4.92754e-17
C37 (\3\:B0 VSS) capacitor c=3.45806e-17
C38 (\12\:A0 VSS) capacitor c=5.00574e-17
C39 (\8\:A1 VSS) capacitor c=6.09819e-17
C40 (\11\:A1 VSS) capacitor c=5.38719e-17
C41 (\4\:A0 VSS) capacitor c=6.62894e-17
C42 (\8\:A0 VSS) capacitor c=4.68283e-17
C43 (\1\:A1 VSS) capacitor c=6.52722e-17
C44 (\4\:A1 VSS) capacitor c=4.69371e-17
C45 (\1\:A0 VSS) capacitor c=5.72869e-17
C46 (\3\:A1 VSS) capacitor c=3.77636e-16
C47 (\15\:Y VSS) capacitor c=4.34641e-16
C48 (\9\:net130 VSS) capacitor c=3.93281e-16
C49 (\1\:VDD VSS) capacitor c=2.3988e-16
C50 (\12\:Y VSS) capacitor c=6.83758e-17
C51 (\1\:Y VSS) capacitor c=1.3125e-16
C52 (\3\:Y VSS) capacitor c=1.4248e-16
C53 (\5\:Y VSS) capacitor c=1.27548e-16
C54 (\8\:Y VSS) capacitor c=1.07071e-16
C55 (\10\:Y VSS) capacitor c=7.54023e-17
C56 (\2\:A1 VSS) capacitor c=2.80048e-17
C57 (\9\:A1 VSS) capacitor c=3.24257e-17
C58 (\3\:B1 VSS) capacitor c=2.40494e-17
C59 (\11\:B1 VSS) capacitor c=1.46614e-17
C60 (\3\:C1 VSS) capacitor c=3.60096e-17
C61 (\10\:C1 VSS) capacitor c=2.77305e-17
C62 (\7\:Y VSS) capacitor c=6.30303e-17
C63 (\14\:Y VSS) capacitor c=2.45895e-16
C64 (\4\:VDD VSS) capacitor c=3.00594e-16
Rk21 (\2\:Y \4\:Y) resistor r=0.5586 c=0
Rk22 (\4\:Y \6\:Y) resistor r=0.641 c=0
Rk23 (\6\:Y \7\:Y) resistor r=0.3405 c=0
Rk24 (\7\:Y \9\:Y) resistor r=0.3668 c=0
Rk25 (\9\:Y \11\:Y) resistor r=0.4668 c=0
Rk26 (\2\:Y \13\:Y) resistor r=0.4605 c=0
Rk28 (\14\:Y Y) resistor r=0.00307 c=0
Rk29 (\14\:Y \15\:Y) resistor r=1.6097 c=0
Rk27 (\7\:Y \14\:Y) resistor r=0.2256 c=0
Rk18 (\1\:B0 B0) resistor r=0.1119 c=0
Rk2 (\3\:A1 A1) resistor r=0.02665 c=0
Rk51 (\2\:VSS \3\:VSS) resistor r=0.1151 c=0
Rk52 (\3\:VSS \4\:VSS) resistor r=0.3254 c=0
Rk53 (\4\:VSS \5\:VSS) resistor r=0.3613 c=0
Rk54 (\3\:VSS \7\:VSS) resistor r=0.223 c=0
Rk55 (\4\:VSS \9\:VSS) resistor r=0.2184 c=0
Rk56 (\5\:VSS \10\:VSS) resistor r=0.4584 c=0
Rk57 (\10\:VSS \11\:VSS) resistor r=0.4833 c=0
Rk58 (\11\:VSS \12\:VSS) resistor r=0.2604 c=0
Rk59 (\12\:VSS \13\:VSS) resistor r=0.04993 c=0
Rk61 (\14\:VSS VSS) resistor r=0.2051 c=0
Rk60 (\13\:VSS \14\:VSS) resistor r=0.2953 c=0
Rk62 (\5\:VSS \16\:VSS) resistor r=0.2645 c=0
Rk63 (\10\:VSS \18\:VSS) resistor r=0.2184 c=0
Rk64 (\11\:VSS \20\:VSS) resistor r=0.2184 c=0
Rk65 (\13\:VSS \22\:VSS) resistor r=0.2184 c=0
Rk66 (\14\:VSS \24\:VSS) resistor r=0.223 c=0
Rk67 (\2\:VDD \3\:VDD) resistor r=0.802 c=0
Rk74 (\4\:VDD VDD) resistor r=0.03213 c=0
Rk68 (\3\:VDD \4\:VDD) resistor r=0.9146 c=0
Rk11 (net130 \9\:net130) resistor r=0.501 c=0
Rl60 (C0 \12\:C0) resistor r=101.421 c=0
Rl51 (C0 \8\:C0) resistor r=28.5806 c=0
Rl52 (C0 \9\:C0) resistor r=84.3341 c=0
Rl42 (C0 \3\:C0) resistor r=29.9442 c=0
Rl24 (\3\:B1 B1) resistor r=48.1957 c=0
Rl27 (\3\:B1 \6\:B1) resistor r=34.9276 c=0
Rl25 (\3\:B1 \4\:B1) resistor r=97.2646 c=0
Rl36 (\11\:B1 B1) resistor r=55.6945 c=0
Rl38 (\11\:B1 \13\:B1) resistor r=100.426 c=0
Rl37 (\11\:B1 \12\:B1) resistor r=35.772 c=0
Rl20 (A0 \12\:A0) resistor r=33.7912 c=0
Rl9 (A0 \4\:A0) resistor r=82.4994 c=0
Rl12 (A0 \8\:A0) resistor r=33.1976 c=0
Rl1 (A0 \1\:A0) resistor r=67.0977 c=0
Rl44 (\3\:C1 C1) resistor r=6.3032 c=0
Rl45 (\3\:C1 \4\:C1) resistor r=76.9865 c=0
Rl47 (\3\:C1 \6\:C1) resistor r=126.408 c=0
Rl55 (\10\:C1 C1) resistor r=24.9043 c=0
Rl58 (\10\:C1 \13\:C1) resistor r=32.7557 c=0
Rl56 (\10\:C1 \11\:C1) resistor r=82.1768 c=0
Rl40 (\1\:B0 \12\:B0) resistor r=33.3841 c=0
Rl31 (\1\:B0 \8\:B0) resistor r=28.5806 c=0
Rl32 (\1\:B0 \9\:B0) resistor r=84.3341 c=0
Rl22 (\1\:B0 \3\:B0) resistor r=33.3841 c=0
Rl3 (\2\:A1 \1\:A1) resistor r=82.1768 c=0
Rl5 (\2\:A1 \4\:A1) resistor r=32.7557 c=0
Rl4 (\2\:A1 \3\:A1) resistor r=24.6542 c=0
Rl14 (\9\:A1 \8\:A1) resistor r=126.408 c=0
Rl16 (\9\:A1 \11\:A1) resistor r=76.9865 c=0
Rl15 (\9\:A1 \3\:A1) resistor r=6.3032 c=0
Rz1 (\2\:Y \1\:Y) resistor r=75 c=0
Rz2 (\4\:Y \3\:Y) resistor r=75 c=0
Rz3 (\6\:Y \5\:Y) resistor r=75 c=0
Rz4 (\9\:Y \8\:Y) resistor r=75 c=0
Rz5 (\11\:Y \10\:Y) resistor r=75 c=0
Rz6 (\13\:Y \12\:Y) resistor r=75 c=0
Rz7 (\6\:VSS \7\:VSS) resistor r=75 c=0
Rz8 (\8\:VSS \9\:VSS) resistor r=75 c=0
Rz9 (\15\:VSS \16\:VSS) resistor r=75 c=0
Rz10 (\17\:VSS \18\:VSS) resistor r=75 c=0
Rz11 (\19\:VSS \20\:VSS) resistor r=75 c=0
Rz12 (\21\:VSS \22\:VSS) resistor r=75 c=0
Rz13 (\23\:VSS \24\:VSS) resistor r=75 c=0
Rz14 (\2\:VDD \1\:VDD) resistor r=18.75 c=0
Rz15 (\3\:VDD \1\:VDD) resistor r=6.25 c=0
Rz16 (\4\:VDD \1\:VDD) resistor r=6.25 c=0
Ry22 (\1\:VSS \2\:VSS) resistor r=15.5 c=0
Ry23 (\1\:VSS \5\:VSS) resistor r=5.1667 c=0
Ry24 (\1\:VSS \12\:VSS) resistor r=5.1667 c=0
mn0_1__rcx (12 \1\:A0 \23\:VSS VSS) g45n1hvt w=(2.6e-07) l=4.5e-08 nf=1 \
        as=3.64e-14 ad=1.56e-14 ps=8e-07 pd=6.4e-07 nrd=1.16667 \
        nrs=1.16667 sa=1.4e-07 sb=2e-06 sd=160n sca=10.3222 scb=0.00938145 \
        scc=0.000353946 m=(1)
mn1_1__rcx (\10\:Y \4\:A1 12 VSS) g45n1hvt w=(2.6e-07) l=4.5e-08 nf=1 \
        as=1.56e-14 ad=4.16e-14 ps=6.4e-07 pd=8.4e-07 nrd=1.16667 \
        nrs=1.16667 sa=2.45e-07 sb=2e-06 sd=160n sca=10.3222 \
        scb=0.00938145 scc=0.000353946 m=(1)
mn1_2__rcx (\10\:Y \1\:A1 13 VSS) g45n1hvt w=(2.6e-07) l=4.5e-08 nf=1 \
        as=1.56e-14 ad=4.16e-14 ps=6.4e-07 pd=8.4e-07 nrd=1.16667 \
        nrs=1.16667 sa=4.5e-07 sb=2e-06 sd=160n sca=10.3222 scb=0.00938145 \
        scc=0.000353946 m=(1)
mn0_2__rcx (13 \8\:A0 \21\:VSS VSS) g45n1hvt w=(2.6e-07) l=4.5e-08 nf=1 \
        as=4.16e-14 ad=1.56e-14 ps=8.4e-07 pd=6.4e-07 nrd=1.16667 \
        nrs=1.16667 sa=5.55e-07 sb=2e-06 sd=160n sca=10.3222 \
        scb=0.00938145 scc=0.000353946 m=(1)
mn0_3__rcx (14 \4\:A0 \21\:VSS VSS) g45n1hvt w=(2.6e-07) l=4.5e-08 nf=1 \
        as=4.16e-14 ad=1.56e-14 ps=8.4e-07 pd=6.4e-07 nrd=1.16667 \
        nrs=1.16667 sa=7.6e-07 sb=2e-06 sd=160n sca=10.3222 scb=0.00938145 \
        scc=0.000353946 m=(1)
mn1_3__rcx (\8\:Y \11\:A1 14 VSS) g45n1hvt w=(2.6e-07) l=4.5e-08 nf=1 \
        as=1.56e-14 ad=4.16e-14 ps=6.4e-07 pd=8.4e-07 nrd=1.16667 \
        nrs=1.16667 sa=8.65e-07 sb=2e-06 sd=160n sca=10.3222 \
        scb=0.00938145 scc=0.000353946 m=(1)
mn1 (\8\:Y \8\:A1 15 VSS) g45n1hvt w=(2.6e-07) l=4.5e-08 nf=1 as=1.56e-14 \
        ad=4.16e-14 ps=6.4e-07 pd=8.4e-07 nrd=1.16667 nrs=1.16667 \
        sa=1.07e-06 sb=2e-06 sd=160n sca=10.3222 scb=0.00938145 \
        scc=0.000353946 m=(1)
mn0 (15 \12\:A0 \19\:VSS VSS) g45n1hvt w=(2.6e-07) l=4.5e-08 nf=1 \
        as=1.17e-13 ad=1.56e-14 ps=1.42e-06 pd=6.4e-07 nrd=1.16667 \
        nrs=1.16667 sa=1.175e-06 sb=2e-06 sd=160n sca=10.3222 \
        scb=0.00938145 scc=0.000353946 m=(1)
mn2_1__rcx (16 \3\:B0 \19\:VSS VSS) g45n1hvt w=(2.6e-07) l=4.5e-08 nf=1 \
        as=1.17e-13 ad=2.99e-14 ps=1.42e-06 pd=7.5e-07 nrd=1.16667 \
        nrs=1.16667 sa=1.67e-06 sb=2e-06 sd=160n sca=10.3222 \
        scb=0.00938145 scc=0.000353946 m=(1)
mn3_1__rcx (\5\:Y \4\:B1 16 VSS) g45n1hvt w=(2.6e-07) l=4.5e-08 nf=1 \
        as=2.99e-14 ad=4.16e-14 ps=7.5e-07 pd=8.4e-07 nrd=1.16667 \
        nrs=1.16667 sa=1.83e-06 sb=2e-06 sd=160n sca=10.3222 \
        scb=0.00938145 scc=0.000353946 m=(1)
mn3_2__rcx (\5\:Y \6\:B1 17 VSS) g45n1hvt w=(2.6e-07) l=4.5e-08 nf=1 \
        as=1.56e-14 ad=4.16e-14 ps=6.4e-07 pd=8.4e-07 nrd=1.16667 \
        nrs=1.16667 sa=2e-06 sb=2e-06 sd=160n sca=10.3222 scb=0.00938145 \
        scc=0.000353946 m=(1)
mn2_2__rcx (17 \9\:B0 \17\:VSS VSS) g45n1hvt w=(2.6e-07) l=4.5e-08 nf=1 \
        as=4.16e-14 ad=1.56e-14 ps=8.4e-07 pd=6.4e-07 nrd=1.16667 \
        nrs=1.16667 sa=2e-06 sb=2e-06 sd=160n sca=10.3222 scb=0.00938145 \
        scc=0.000353946 m=(1)
mn2_3__rcx (18 \8\:B0 \17\:VSS VSS) g45n1hvt w=(2.6e-07) l=4.5e-08 nf=1 \
        as=4.16e-14 ad=7.93e-14 ps=8.4e-07 pd=1.13e-06 nrd=1.16667 \
        nrs=1.16667 sa=2e-06 sb=2e-06 sd=160n sca=10.3222 scb=0.00938145 \
        scc=0.000353946 m=(1)
mn3_3__rcx (\3\:Y \12\:B1 18 VSS) g45n1hvt w=(2.6e-07) l=4.5e-08 nf=1 \
        as=7.93e-14 ad=4.16e-14 ps=1.13e-06 pd=8.4e-07 nrd=1.16667 \
        nrs=1.16667 sa=2e-06 sb=1.84e-06 sd=160n sca=10.3222 \
        scb=0.00938145 scc=0.000353946 m=(1)
mn3 (\3\:Y \13\:B1 19 VSS) g45n1hvt w=(2.6e-07) l=4.5e-08 nf=1 \
        as=4.16e-14 ad=4.16e-14 ps=8.4e-07 pd=8.4e-07 nrd=1.16667 \
        nrs=1.16667 sa=2e-06 sb=1.635e-06 sd=160n sca=10.3222 \
        scb=0.00938145 scc=0.000353946 m=(1)
mn2 (19 \12\:B0 \15\:VSS VSS) g45n1hvt w=(2.6e-07) l=4.5e-08 nf=1 \
        as=4.16e-14 ad=4.16e-14 ps=8.4e-07 pd=8.4e-07 nrd=1.16667 \
        nrs=1.16667 sa=2e-06 sb=1.43e-06 sd=160n sca=10.3222 \
        scb=0.00938145 scc=0.000353946 m=(1)
mn4_1__rcx (20 \3\:C0 \15\:VSS VSS) g45n1hvt w=(2.6e-07) l=4.5e-08 nf=1 \
        as=4.16e-14 ad=2.86e-14 ps=8.4e-07 pd=7.4e-07 nrd=1.16667 \
        nrs=1.16667 sa=2e-06 sb=1.225e-06 sd=160n sca=10.3222 \
        scb=0.00938145 scc=0.000353946 m=(1)
mn5_1__rcx (\1\:Y \6\:C1 20 VSS) g45n1hvt w=(2.6e-07) l=4.5e-08 nf=1 \
        as=2.86e-14 ad=4.16e-14 ps=7.4e-07 pd=8.4e-07 nrd=1.16667 \
        nrs=1.16667 sa=2e-06 sb=1.07e-06 sd=160n sca=10.3222 \
        scb=0.00938145 scc=0.000353946 m=(1)
mn5_2__rcx (\1\:Y \4\:C1 21 VSS) g45n1hvt w=(2.6e-07) l=4.5e-08 nf=1 \
        as=1.56e-14 ad=4.16e-14 ps=6.4e-07 pd=8.4e-07 nrd=1.16667 \
        nrs=1.16667 sa=2e-06 sb=8.65e-07 sd=160n sca=10.3222 \
        scb=0.00938145 scc=0.000353946 m=(1)
mn4_2__rcx (21 \9\:C0 \8\:VSS VSS) g45n1hvt w=(2.6e-07) l=4.5e-08 nf=1 \
        as=4.16e-14 ad=1.56e-14 ps=8.4e-07 pd=6.4e-07 nrd=1.16667 \
        nrs=1.16667 sa=2e-06 sb=7.6e-07 sd=160n sca=10.3222 scb=0.00938145 \
        scc=0.000353946 m=(1)
mn4_3__rcx (22 \8\:C0 \8\:VSS VSS) g45n1hvt w=(2.6e-07) l=4.5e-08 nf=1 \
        as=4.16e-14 ad=1.56e-14 ps=8.4e-07 pd=6.4e-07 nrd=1.16667 \
        nrs=1.16667 sa=2e-06 sb=5.55e-07 sd=160n sca=10.3222 \
        scb=0.00938145 scc=0.000353946 m=(1)
mn5_3__rcx (\12\:Y \11\:C1 22 VSS) g45n1hvt w=(2.6e-07) l=4.5e-08 nf=1 \
        as=1.56e-14 ad=4.16e-14 ps=6.4e-07 pd=8.4e-07 nrd=1.16667 \
        nrs=1.16667 sa=2e-06 sb=4.5e-07 sd=160n sca=10.3222 scb=0.00938145 \
        scc=0.000353946 m=(1)
mn5 (\12\:Y \13\:C1 23 VSS) g45n1hvt w=(2.6e-07) l=4.5e-08 nf=1 \
        as=1.56e-14 ad=4.16e-14 ps=6.4e-07 pd=8.4e-07 nrd=1.16667 \
        nrs=1.16667 sa=2e-06 sb=2.45e-07 sd=160n sca=10.3222 \
        scb=0.00938145 scc=0.000353946 m=(1)
mn4 (23 \12\:C0 \6\:VSS VSS) g45n1hvt w=(2.6e-07) l=4.5e-08 nf=1 \
        as=3.64e-14 ad=1.56e-14 ps=8e-07 pd=6.4e-07 nrd=1.16667 \
        nrs=1.16667 sa=2e-06 sb=1.4e-07 sd=160n sca=10.3222 scb=0.00938145 \
        scc=0.000353946 m=(1)
ends AOI222X4
// End of subcircuit definition.
