// Generated for: spectre (May  1 09:15:59 2013 )
// Library name: gsclib045_hvt
// Cell name: SDFFSX1
// View name: extracted

simulator lang=spectre

subckt SDFFSX1 CK D Q QN SE SI SN VDD VSS
mp57 (\3\:QN net492 \25\:VDD VDD) g45p1hvt w=(3.9e-07) l=4.5e-08 nf=1 \
        as=5.46e-14 ad=5.46e-14 ps=1.06e-06 pd=1.06e-06 nrd=1.16667 \
        nrs=1.16667 sa=1.4e-07 sb=1.4e-07 sd=160n sca=35.5844 \
        scb=0.0271174 scc=0.00348165 m=(1)
mp55 (\3\:Q qbint \23\:VDD VDD) g45p1hvt w=(3.9e-07) l=4.5e-08 nf=1 \
        as=6.535e-14 ad=5.46e-14 ps=1.16e-06 pd=1.06e-06 nrd=1.16667 \
        nrs=1.16667 sa=2.69551e-07 sb=1.4e-07 sd=160n sca=30.5009 \
        scb=0.0202006 scc=0.00336097 m=(1)
C1 (QN VSS) capacitor c=4.85633e-17
C2 (SE VSS) capacitor c=2.76632e-17
C3 (SN VSS) capacitor c=2.4792e-17
C4 (Q VSS) capacitor c=4.41187e-17
C5 (SI VSS) capacitor c=5.34796e-17
C6 (VDD VSS) capacitor c=4.42897e-16
C7 (D VSS) capacitor c=6.77682e-17
C8 (net492 VSS) capacitor c=3.25785e-17
C9 (qbint VSS) capacitor c=2.68515e-17
C10 (n35 VSS) capacitor c=4.34022e-17
C11 (net518 VSS) capacitor c=2.03266e-18
C12 (CKb VSS) capacitor c=1.7001e-17
C13 (mout VSS) capacitor c=7.6104e-17
C14 (CKbb VSS) capacitor c=3.55676e-17
C15 (net442 VSS) capacitor c=2.03427e-18
C16 (n20 VSS) capacitor c=3.65443e-17
C17 (net478 VSS) capacitor c=3.30288e-18
C18 (Db VSS) capacitor c=9.38948e-17
C19 (net494 VSS) capacitor c=8.1769e-18
C20 (SEb VSS) capacitor c=3.41555e-17
C21 (net506 VSS) capacitor c=1.52608e-20
C22 (net405 VSS) capacitor c=7.16811e-17
C23 (\7\:SE VSS) capacitor c=5.38233e-17
C24 (\3\:SI VSS) capacitor c=5.05263e-17
C25 (\1\:SE VSS) capacitor c=4.38756e-17
C26 (\1\:D VSS) capacitor c=5.75849e-17
C27 (\1\:CK VSS) capacitor c=7.21717e-17
C28 (\5\:CKbb VSS) capacitor c=4.45745e-17
C29 (\7\:CKb VSS) capacitor c=7.38706e-17
C30 (\4\:SN VSS) capacitor c=8.0898e-17
C31 (\2\:CKb VSS) capacitor c=4.85088e-17
C32 (\4\:CKb VSS) capacitor c=1.1109e-16
C33 (\4\:CKbb VSS) capacitor c=6.62181e-17
C34 (\7\:qbint VSS) capacitor c=6.30751e-17
C35 (\3\:SN VSS) capacitor c=5.35785e-17
C36 (\3\:n35 VSS) capacitor c=3.78019e-17
C37 (\6\:qbint VSS) capacitor c=1.73213e-17
C38 (\5\:SE VSS) capacitor c=3.30566e-17
C39 (\1\:SI VSS) capacitor c=8.04732e-17
C40 (\3\:SE VSS) capacitor c=6.57789e-17
C41 (\3\:SEb VSS) capacitor c=6.41928e-17
C42 (\4\:D VSS) capacitor c=3.09878e-17
C43 (\3\:CK VSS) capacitor c=2.50835e-17
C44 (\9\:CKb VSS) capacitor c=3.94039e-17
C45 (\7\:CKbb VSS) capacitor c=2.99513e-17
C46 (\4\:mout VSS) capacitor c=3.07657e-17
C47 (\3\:n20 VSS) capacitor c=5.94784e-17
C48 (\5\:SN VSS) capacitor c=4.31214e-17
C49 (\6\:CKb VSS) capacitor c=3.52346e-17
C50 (\3\:CKbb VSS) capacitor c=3.20094e-17
C51 (\5\:CKb VSS) capacitor c=1.1234e-16
C52 (\9\:qbint VSS) capacitor c=3.93795e-17
C53 (\1\:SN VSS) capacitor c=6.00336e-17
C54 (\5\:qbint VSS) capacitor c=1.85269e-17
C55 (\4\:qbint VSS) capacitor c=1.7588e-17
C56 (\3\:net492 VSS) capacitor c=2.233e-17
C57 (\6\:SE VSS) capacitor c=5.6425e-17
C58 (\2\:SI VSS) capacitor c=7.46052e-17
C59 (\4\:SE VSS) capacitor c=5.65527e-17
C60 (\2\:SEb VSS) capacitor c=6.87443e-17
C61 (\2\:SE VSS) capacitor c=4.51363e-17
C62 (\3\:D VSS) capacitor c=2.06349e-17
C63 (\2\:CK VSS) capacitor c=5.12343e-17
C64 (\10\:CKb VSS) capacitor c=2.02728e-17
C65 (\8\:CKb VSS) capacitor c=2.68339e-17
C66 (\6\:CKbb VSS) capacitor c=5.79845e-17
C67 (\3\:mout VSS) capacitor c=1.7763e-17
C68 (\2\:n20 VSS) capacitor c=4.41353e-17
C69 (\6\:SN VSS) capacitor c=2.42018e-17
C70 (\8\:qbint VSS) capacitor c=6.10942e-17
C71 (\2\:SN VSS) capacitor c=7.75423e-17
C72 (\2\:n35 VSS) capacitor c=5.39574e-17
C73 (\2\:qbint VSS) capacitor c=1.19862e-17
C74 (\2\:net492 VSS) capacitor c=1.79567e-17
C75 (\8\:SEb VSS) capacitor c=1.51781e-17
C76 (\1\:VDD VSS) capacitor c=4.64672e-17
C77 (\8\:Db VSS) capacitor c=4.26463e-17
C78 (\13\:VDD VSS) capacitor c=4.0741e-17
C79 (\11\:CKb VSS) capacitor c=8.1628e-17
C80 (\4\:Db VSS) capacitor c=1.33702e-16
C81 (\8\:n20 VSS) capacitor c=2.41164e-17
C82 (\15\:VDD VSS) capacitor c=1.21598e-17
C83 (\7\:mout VSS) capacitor c=1.10291e-16
C84 (\17\:VDD VSS) capacitor c=1.60511e-17
C85 (\8\:CKbb VSS) capacitor c=4.29339e-17
C86 (\11\:mout VSS) capacitor c=1.27976e-16
C87 (\4\:n35 VSS) capacitor c=4.22472e-17
C88 (\19\:VDD VSS) capacitor c=3.25086e-17
C89 (\3\:net405 VSS) capacitor c=8.24481e-17
C90 (\21\:VDD VSS) capacitor c=1.53185e-17
C91 (\14\:qbint VSS) capacitor c=5.18087e-17
C92 (\3\:Q VSS) capacitor c=4.03106e-17
C93 (\23\:VDD VSS) capacitor c=8.13269e-17
C94 (\4\:net492 VSS) capacitor c=5.48791e-17
C95 (\3\:QN VSS) capacitor c=7.89681e-17
C96 (\25\:VDD VSS) capacitor c=5.39873e-17
C97 (\3\:VDD VSS) capacitor c=7.38747e-17
C98 (\4\:SEb VSS) capacitor c=5.86398e-17
C99 (\17\:CKb VSS) capacitor c=7.64495e-17
C100 (\6\:Db VSS) capacitor c=6.92717e-17
C101 (\4\:n20 VSS) capacitor c=6.13737e-17
C102 (\9\:mout VSS) capacitor c=3.41445e-17
C103 (\13\:CKbb VSS) capacitor c=3.06337e-17
C104 (\13\:mout VSS) capacitor c=1.05459e-16
C105 (\8\:n35 VSS) capacitor c=7.44378e-17
C106 (\12\:qbint VSS) capacitor c=7.6772e-17
C107 (\1\:Q VSS) capacitor c=6.85671e-17
C108 (\6\:net492 VSS) capacitor c=9.36717e-17
C109 (\1\:QN VSS) capacitor c=5.13801e-17
C110 (\3\:qbint VSS) capacitor c=6.94434e-18
C111 (\2\:CKbb VSS) capacitor c=2.70326e-17
C112 (\3\:CKb VSS) capacitor c=5.04857e-17
C113 (\2\:mout VSS) capacitor c=3.91255e-17
C114 (\2\:D VSS) capacitor c=4.0258e-17
C115 (\8\:net492 VSS) capacitor c=7.62223e-17
C116 (\10\:qbint VSS) capacitor c=7.28496e-17
C117 (\11\:qbint VSS) capacitor c=5.47709e-17
C118 (\16\:qbint VSS) capacitor c=1.11438e-16
C119 (\6\:n35 VSS) capacitor c=1.30236e-16
C120 (\7\:n35 VSS) capacitor c=1.01037e-16
C121 (\7\:SN VSS) capacitor c=6.99845e-17
C122 (\8\:SN VSS) capacitor c=1.56703e-16
C123 (\9\:SN VSS) capacitor c=1.51963e-16
C124 (\5\:mout VSS) capacitor c=6.75255e-17
C125 (\6\:mout VSS) capacitor c=4.84768e-17
C126 (\10\:CKbb VSS) capacitor c=1.40588e-16
C127 (\11\:CKbb VSS) capacitor c=5.98938e-17
C128 (\12\:CKbb VSS) capacitor c=1.63051e-16
C129 (\6\:n20 VSS) capacitor c=7.60433e-17
C130 (\7\:n20 VSS) capacitor c=6.44585e-17
C131 (\4\:CK VSS) capacitor c=3.65807e-17
C132 (\6\:CK VSS) capacitor c=7.0808e-17
C133 (\13\:CKb VSS) capacitor c=1.00166e-16
C134 (\14\:CKb VSS) capacitor c=8.43951e-17
C135 (\15\:CKb VSS) capacitor c=1.03693e-16
C136 (\16\:CKb VSS) capacitor c=1.24106e-16
C137 (\5\:D VSS) capacitor c=3.26844e-17
C138 (\3\:Db VSS) capacitor c=1.42136e-16
C139 (\4\:SI VSS) capacitor c=8.42165e-17
C140 (\8\:SE VSS) capacitor c=4.11505e-17
C141 (\9\:SE VSS) capacitor c=5.3872e-17
C142 (\10\:SE VSS) capacitor c=6.98365e-17
C143 (\6\:SEb VSS) capacitor c=8.71388e-17
C144 (\7\:SEb VSS) capacitor c=4.67955e-17
C145 (\5\:VDD VSS) capacitor c=3.62206e-17
C146 (\6\:VDD VSS) capacitor c=5.04602e-17
C147 (\8\:VDD VSS) capacitor c=3.58924e-17
C148 (\9\:VDD VSS) capacitor c=1.82797e-17
C149 (\11\:VDD VSS) capacitor c=9.79641e-18
C150 (\12\:VDD VSS) capacitor c=9.82019e-18
Rk1 (\2\:QN QN) resistor r=0.03635 c=0
Rk2 (QN \4\:QN) resistor r=0.2589 c=0
Rk30 (\4\:CK \5\:CK) resistor r=0.002015 c=0
Rk31 (CK \6\:CK) resistor r=0.001948 c=0
Rk32 (\4\:CK \6\:CK) resistor r=0.02971 c=0
Rk44 (\8\:SE SE) resistor r=0.1311 c=0
Rk45 (SE \9\:SE) resistor r=0.06361 c=0
Rk46 (\9\:SE \10\:SE) resistor r=0.3431 c=0
Rk16 (\8\:SN SN) resistor r=0.02617 c=0
Rk15 (\7\:SN \8\:SN) resistor r=0.283 c=0
Rk17 (\8\:SN \9\:SN) resistor r=1.1609 c=0
Rk5 (\2\:Q Q) resistor r=0.2831 c=0
Rk6 (Q \4\:Q) resistor r=0.02993 c=0
Rk43 (SI \4\:SI) resistor r=0.1108 c=0
Rk66 (\2\:VDD \4\:VDD) resistor r=0.5769 c=0
Rk67 (\4\:VDD \5\:VDD) resistor r=0.08249 c=0
Rk68 (\5\:VDD \6\:VDD) resistor r=0.819 c=0
Rk69 (\6\:VDD \7\:VDD) resistor r=0.2507 c=0
Rk70 (\7\:VDD \8\:VDD) resistor r=0.7124 c=0
Rk71 (\8\:VDD \9\:VDD) resistor r=0.1976 c=0
Rk72 (\9\:VDD \10\:VDD) resistor r=0.293 c=0
Rk73 (\10\:VDD \11\:VDD) resistor r=0.1476 c=0
Rk75 (\12\:VDD VDD) resistor r=0.07222 c=0
Rk74 (\11\:VDD \12\:VDD) resistor r=0.3304 c=0
Rk76 (\5\:VDD \14\:VDD) resistor r=0.2448 c=0
Rk77 (\6\:VDD \16\:VDD) resistor r=0.07334 c=0
Rk78 (\7\:VDD \18\:VDD) resistor r=0.07141 c=0
Rk79 (\8\:VDD \20\:VDD) resistor r=0.2048 c=0
Rk80 (\9\:VDD \22\:VDD) resistor r=0.2094 c=0
Rk81 (\11\:VDD \24\:VDD) resistor r=0.4029 c=0
Rk82 (\12\:VDD \26\:VDD) resistor r=0.3992 c=0
Rk38 (\5\:D D) resistor r=0.1597 c=0
Rk50 (\2\:VSS \4\:VSS) resistor r=0.5792 c=0
Rk51 (\4\:VSS \5\:VSS) resistor r=0.2053 c=0
Rk52 (\5\:VSS \6\:VSS) resistor r=0.6837 c=0
Rk53 (\6\:VSS \7\:VSS) resistor r=0.2629 c=0
Rk54 (\7\:VSS \8\:VSS) resistor r=0.1677 c=0
Rk55 (\8\:VSS \9\:VSS) resistor r=0.7137 c=0
Rk56 (\9\:VSS \10\:VSS) resistor r=0.3205 c=0
Rk57 (\10\:VSS \11\:VSS) resistor r=0.1476 c=0
Rk59 (\12\:VSS VSS) resistor r=0.05719 c=0
Rk58 (\11\:VSS \12\:VSS) resistor r=0.3454 c=0
Rk60 (\5\:VSS \14\:VSS) resistor r=0.2181 c=0
Rk61 (\6\:VSS \16\:VSS) resistor r=0.1895 c=0
Rk62 (\8\:VSS \18\:VSS) resistor r=0.1219 c=0
Rk63 (\9\:VSS \20\:VSS) resistor r=0.3303 c=0
Rk64 (\11\:VSS \22\:VSS) resistor r=0.2956 c=0
Rk65 (\12\:VSS \24\:VSS) resistor r=0.07334 c=0
Rk3 (\5\:net492 \7\:net492) resistor r=0.2864 c=0
Rk4 (\7\:net492 \8\:net492) resistor r=0.6045 c=0
Rk7 (\10\:qbint \11\:qbint) resistor r=0.3563 c=0
Rk8 (\11\:qbint \13\:qbint) resistor r=0.1822 c=0
Rk9 (\11\:qbint \15\:qbint) resistor r=0.3855 c=0
Rk10 (\13\:qbint \16\:qbint) resistor r=0.8134 c=0
Rk12 (\5\:n35 \6\:n35) resistor r=0.1972 c=0
Rk13 (\6\:n35 \7\:n35) resistor r=0.5928 c=0
Rk14 (\6\:n35 \9\:n35) resistor r=0.3511 c=0
Rk33 (\12\:CKb \13\:CKb) resistor r=0.5836 c=0
Rk34 (\13\:CKb \14\:CKb) resistor r=0.2416 c=0
Rk35 (\14\:CKb \15\:CKb) resistor r=0.6821 c=0
Rk36 (\13\:CKb \16\:CKb) resistor r=0.4519 c=0
Rk37 (\16\:CKb \18\:CKb) resistor r=0.5856 c=0
Rk18 (\5\:mout \6\:mout) resistor r=0.2656 c=0
Rk19 (\6\:mout \8\:mout) resistor r=0.2503 c=0
Rk20 (\6\:mout \10\:mout) resistor r=0.09662 c=0
Rk21 (\8\:mout \12\:mout) resistor r=0.7557 c=0
Rk22 (\12\:mout \14\:mout) resistor r=0.5767 c=0
Rk23 (\9\:CKbb \10\:CKbb) resistor r=0.1723 c=0
Rk24 (\10\:CKbb \11\:CKbb) resistor r=0.3743 c=0
Rk25 (\10\:CKbb \12\:CKbb) resistor r=1.1436 c=0
Rk26 (\11\:CKbb \14\:CKbb) resistor r=0.1073 c=0
Rk27 (\5\:n20 \6\:n20) resistor r=0.3448 c=0
Rk28 (\6\:n20 \7\:n20) resistor r=0.3477 c=0
Rk29 (\6\:n20 \9\:n20) resistor r=0.09725 c=0
Rk39 (\2\:Db \3\:Db) resistor r=0.7577 c=0
Rk40 (\3\:Db \5\:Db) resistor r=0.6966 c=0
Rk41 (\5\:Db \7\:Db) resistor r=0.4248 c=0
Rk42 (\3\:Db \9\:Db) resistor r=0.2444 c=0
Rk47 (\5\:SEb \6\:SEb) resistor r=0.5398 c=0
Rk48 (\6\:SEb \7\:SEb) resistor r=0.3964 c=0
Rk49 (\6\:SEb \9\:SEb) resistor r=0.0873 c=0
Rk11 (\2\:net405 \4\:net405) resistor r=0.3375 c=0
Rl33 (\1\:CK \2\:CK) resistor r=286.796 c=0
Rl34 (\2\:CK \3\:CK) resistor r=52.6149 c=0
Rl45 (\6\:SE \7\:SE) resistor r=185.714 c=0
Rl44 (\5\:SE \6\:SE) resistor r=67.3077 c=0
Rl41 (\3\:SE \4\:SE) resistor r=66.0764 c=0
Rl38 (\1\:SE \2\:SE) resistor r=87.2302 c=0
Rl22 (\4\:SN \5\:SN) resistor r=170.72 c=0
Rl23 (\5\:SN \6\:SN) resistor r=35.6938 c=0
Rl11 (\2\:SN \3\:SN) resistor r=120.33 c=0
Rl10 (\1\:SN \2\:SN) resistor r=92.3077 c=0
Rl43 (\2\:SI \3\:SI) resistor r=97.2527 c=0
Rl42 (\1\:SI \2\:SI) resistor r=155.769 c=0
Rl35 (\1\:D \2\:D) resistor r=145.387 c=0
Rl37 (\2\:D \4\:D) resistor r=128.08 c=0
Rl36 (\2\:D \3\:D) resistor r=34.9887 c=0
Rl1 (net492 \2\:net492) resistor r=31.9251 c=0
Rl2 (\2\:net492 \3\:net492) resistor r=31.9251 c=0
Rl12 (\7\:qbint \8\:qbint) resistor r=178.021 c=0
Rl13 (\8\:qbint \9\:qbint) resistor r=26.098 c=0
Rl3 (qbint \2\:qbint) resistor r=39.6174 c=0
Rl6 (\2\:qbint \5\:qbint) resistor r=24.2328 c=0
Rl7 (\3\:qbint \6\:qbint) resistor r=60.772 c=0
Rl5 (\3\:qbint \4\:qbint) resistor r=28.0797 c=0
Rl4 (\2\:qbint \3\:qbint) resistor r=51.1361 c=0
Rl9 (\2\:n35 \3\:n35) resistor r=81.0888 c=0
Rl8 (n35 \2\:n35) resistor r=151.156 c=0
Rl20 (\4\:CKb \5\:CKb) resistor r=557.258 c=0
Rl32 (\9\:CKb \10\:CKb) resistor r=29.5379 c=0
Rl29 (\7\:CKb \8\:CKb) resistor r=60.3072 c=0
Rl17 (CKb \2\:CKb) resistor r=50.6918 c=0
Rl18 (\2\:CKb \3\:CKb) resistor r=155.747 c=0
Rl19 (\3\:CKb \4\:CKb) resistor r=178.824 c=0
Rl21 (\3\:CKb \6\:CKb) resistor r=82.3738 c=0
Rl26 (mout \2\:mout) resistor r=98.8796 c=0
Rl28 (\2\:mout \4\:mout) resistor r=37.3411 c=0
Rl27 (\2\:mout \3\:mout) resistor r=5.013 c=0
Rl30 (\5\:CKbb \6\:CKbb) resistor r=134.593 c=0
Rl31 (\6\:CKbb \7\:CKbb) resistor r=24.7951 c=0
Rl16 (\2\:CKbb \4\:CKbb) resistor r=116.916 c=0
Rl15 (\2\:CKbb \3\:CKbb) resistor r=51.9908 c=0
Rl14 (CKbb \2\:CKbb) resistor r=80.5242 c=0
Rl24 (n20 \2\:n20) resistor r=29.5379 c=0
Rl25 (\2\:n20 \3\:n20) resistor r=156.027 c=0
Rl39 (SEb \2\:SEb) resistor r=26.9231 c=0
Rl40 (\2\:SEb \3\:SEb) resistor r=226.374 c=0
Rz1 (\1\:QN \2\:QN) resistor r=75 c=0
Rz3 (\1\:Q \2\:Q) resistor r=75 c=0
Rz21 (\3\:VDD \4\:VDD) resistor r=6.8182 c=0
Rz22 (\3\:VDD \7\:VDD) resistor r=6.25 c=0
Rz23 (\3\:VDD \10\:VDD) resistor r=6.25 c=0
Rz14 (\1\:VSS \2\:VSS) resistor r=75 c=0
Rz15 (\13\:VSS \14\:VSS) resistor r=75 c=0
Rz16 (\15\:VSS \16\:VSS) resistor r=75 c=0
Rz17 (\17\:VSS \18\:VSS) resistor r=75 c=0
Rz18 (\19\:VSS \20\:VSS) resistor r=75 c=0
Rz19 (\21\:VSS \22\:VSS) resistor r=75 c=0
Rz20 (\23\:VSS \24\:VSS) resistor r=75 c=0
Rz2 (\6\:net492 \7\:net492) resistor r=75 c=0
Rz4 (\12\:qbint \13\:qbint) resistor r=75 c=0
Rz5 (\8\:n35 \9\:n35) resistor r=75 c=0
Rz10 (\17\:CKb \18\:CKb) resistor r=75 c=0
Rz6 (\9\:mout \10\:mout) resistor r=75 c=0
Rz7 (\13\:mout \14\:mout) resistor r=75 c=0
Rz8 (\13\:CKbb \14\:CKbb) resistor r=75 c=0
Rz9 (\4\:n20 \5\:n20) resistor r=75 c=0
Rz11 (Db \2\:Db) resistor r=75 c=0
Rz12 (\6\:Db \7\:Db) resistor r=75 c=0
Rz13 (\4\:SEb \5\:SEb) resistor r=75 c=0
Ry1 (\3\:QN \4\:QN) resistor r=20.6667 c=0
Ry3 (\3\:Q \4\:Q) resistor r=20.6667 c=0
Ry19 (\1\:VDD \2\:VDD) resistor r=62 c=0
Ry20 (\13\:VDD \14\:VDD) resistor r=62 c=0
Ry21 (\15\:VDD \16\:VDD) resistor r=62 c=0
Ry22 (\17\:VDD \18\:VDD) resistor r=62 c=0
Ry23 (\19\:VDD \20\:VDD) resistor r=62 c=0
Ry24 (\21\:VDD \22\:VDD) resistor r=62 c=0
Ry25 (\23\:VDD \24\:VDD) resistor r=20.6667 c=0
Ry26 (\25\:VDD \26\:VDD) resistor r=20.6667 c=0
Ry16 (\3\:VSS \4\:VSS) resistor r=5.6364 c=0
Ry17 (\3\:VSS \7\:VSS) resistor r=5.1667 c=0
Ry18 (\3\:VSS \10\:VSS) resistor r=5.1667 c=0
Ry2 (\4\:net492 \5\:net492) resistor r=62 c=0
Ry4 (\14\:qbint \15\:qbint) resistor r=62 c=0
Ry7 (\4\:n35 \5\:n35) resistor r=62 c=0
Ry12 (\11\:CKb \12\:CKb) resistor r=62 c=0
Ry8 (\7\:mout \8\:mout) resistor r=62 c=0
Ry9 (\11\:mout \12\:mout) resistor r=62 c=0
Ry10 (\8\:CKbb \9\:CKbb) resistor r=62 c=0
Ry11 (\8\:n20 \9\:n20) resistor r=62 c=0
Ry13 (\4\:Db \5\:Db) resistor r=62 c=0
Ry14 (\8\:Db \9\:Db) resistor r=62 c=0
Ry15 (\8\:SEb \9\:SEb) resistor r=62 c=0
Ry5 (net405 \2\:net405) resistor r=62 c=0
Ry6 (\3\:net405 \4\:net405) resistor r=62 c=0
Rx11 (\2\:CK \5\:CK) resistor r=45 c=0
Rx17 (\6\:SE \8\:SE) resistor r=45 c=0
Rx18 (\4\:SE \9\:SE) resistor r=45 c=0
Rx19 (\2\:SE \10\:SE) resistor r=45 c=0
Rx5 (\2\:SN \7\:SN) resistor r=45 c=0
Rx6 (\6\:SN \9\:SN) resistor r=45 c=0
Rx16 (\2\:SI \4\:SI) resistor r=45 c=0
Rx15 (\3\:D \5\:D) resistor r=45 c=0
Rx1 (\2\:net492 \8\:net492) resistor r=45 c=0
Rx2 (\8\:qbint \10\:qbint) resistor r=45 c=0
Rx3 (\2\:qbint \16\:qbint) resistor r=45 c=0
Rx4 (\2\:n35 \7\:n35) resistor r=45 c=0
Rx12 (\8\:CKb \14\:CKb) resistor r=45 c=0
Rx13 (CKb \15\:CKb) resistor r=45 c=0
Rx14 (\10\:CKb \16\:CKb) resistor r=45 c=0
Rx7 (\3\:mout \5\:mout) resistor r=45 c=0
Rx8 (CKbb \11\:CKbb) resistor r=45 c=0
Rx9 (\6\:CKbb \12\:CKbb) resistor r=45 c=0
Rx10 (\2\:n20 \7\:n20) resistor r=45 c=0
Rx20 (\2\:SEb \7\:SEb) resistor r=45 c=0
mn57 (\1\:QN \3\:net492 \23\:VSS VSS) g45n1hvt w=(2.6e-07) l=4.5e-08 \
        nf=1 as=8.26e-14 ad=3.64e-14 ps=1.5e-06 pd=8e-07 nrd=1.16667 \
        nrs=1.16667 sa=1.7e-07 sb=1.4e-07 sd=160n sca=17.5885 \
        scb=0.0172826 scc=0.00162584 m=(1)
mn55 (\1\:Q \5\:qbint \21\:VSS VSS) g45n1hvt w=(2.6e-07) l=4.5e-08 nf=1 \
        as=4.365e-14 ad=6.63e-14 ps=9e-07 pd=1.03e-06 nrd=1.16667 \
        nrs=1.16667 sa=2.71058e-07 sb=2.55e-07 sd=160n sca=17.5885 \
        scb=0.0172826 scc=0.00162584 m=(1)
mn56 (\6\:net492 \4\:qbint \21\:VSS VSS) g45n1hvt w=(1.45e-07) l=4.5e-08 \
        nf=1 as=4.365e-14 ad=2.03e-14 ps=9e-07 pd=5.7e-07 nrd=1.16667 \
        nrs=1.16667 sa=1.4e-07 sb=4.9e-07 sd=160n sca=23.279 scb=0.0230742 \
        scc=0.00267719 m=(1)
mn45 (\12\:qbint n35 \19\:VSS VSS) g45n1hvt w=(1.45e-07) l=4.5e-08 nf=1 \
        as=2.32e-14 ad=2.03e-14 ps=6.1e-07 pd=5.7e-07 nrd=1.16667 \
        nrs=1.16667 sa=1.4e-07 sb=9.85e-07 sd=160n sca=14.7993 \
        scb=0.0157101 scc=0.000964917 m=(1)
mn50 (net521 \1\:SN \19\:VSS VSS) g45n1hvt w=(1.45e-07) l=4.5e-08 nf=1 \
        as=2.32e-14 ad=8.7e-15 ps=6.1e-07 pd=4.1e-07 nrd=1.16667 \
        nrs=1.16667 sa=3.45e-07 sb=7.8e-07 sd=160n sca=14.7993 \
        scb=0.0157101 scc=0.000964917 m=(1)
mn51 (net518 \9\:qbint net521 VSS) g45n1hvt w=(1.45e-07) l=4.5e-08 nf=1 \
        as=8.7e-15 ad=3.915e-14 ps=4.1e-07 pd=8.3e-07 nrd=1.16667 \
        nrs=1.16667 sa=4.5e-07 sb=6.75e-07 sd=160n sca=14.7993 \
        scb=0.0157101 scc=0.000964917 m=(1)
mn52 (\8\:n35 \5\:CKb net518 VSS) g45n1hvt w=(1.45e-07) l=4.5e-08 nf=1 \
        as=3.915e-14 ad=2.538e-14 ps=8.3e-07 pd=6.4e-07 nrd=1.16667 \
        nrs=1.16667 sa=7.65e-07 sb=3.6e-07 sd=160n sca=14.7993 \
        scb=0.0157101 scc=0.000964917 m=(1)
mn40 (\8\:n35 \3\:CKbb \13\:mout VSS) g45n1hvt w=(1.45e-07) l=4.5e-08 \
        nf=1 as=2.03e-14 ad=2.538e-14 ps=5.7e-07 pd=6.4e-07 nrd=1.16667 \
        nrs=1.16667 sa=9.85e-07 sb=1.4e-07 sd=160n sca=14.7993 \
        scb=0.0157101 scc=0.000964917 m=(1)
mn21 (\13\:CKbb \6\:CKb \17\:VSS VSS) g45n1hvt w=(1.45e-07) l=4.5e-08 \
        nf=1 as=9.328e-14 ad=3.698e-14 ps=1.68e-06 pd=8e-07 nrd=1.16667 \
        nrs=1.16667 sa=2.55e-07 sb=7.4e-07 sd=160n sca=15.7071 \
        scb=0.0167369 scc=0.00113434 m=(1)
mn30 (net442 \5\:SN \17\:VSS VSS) g45n1hvt w=(1.45e-07) l=4.5e-08 nf=1 \
        as=9.328e-14 ad=1.668e-14 ps=1.68e-06 pd=5.2e-07 nrd=1.16667 \
        nrs=1.16667 sa=6.95e-07 sb=3e-07 sd=160n sca=15.7071 scb=0.0167369 \
        scc=0.00113434 m=(1)
mn31 (\9\:mout \3\:n20 net442 VSS) g45n1hvt w=(1.45e-07) l=4.5e-08 nf=1 \
        as=1.668e-14 ad=2.03e-14 ps=5.2e-07 pd=5.7e-07 nrd=1.16667 \
        nrs=1.16667 sa=8.55e-07 sb=1.4e-07 sd=160n sca=15.7071 \
        scb=0.0167369 scc=0.00113434 m=(1)
mn35 (net478 \4\:mout \15\:VSS VSS) g45n1hvt w=(1.45e-07) l=4.5e-08 nf=1 \
        as=4.325e-14 ad=1.668e-14 ps=9.4e-07 pd=5.2e-07 nrd=1.16667 \
        nrs=1.16667 sa=1.7e-07 sb=7.1e-07 sd=160n sca=11.9911 \
        scb=0.0120555 scc=0.000498628 m=(1)
mn36 (\4\:n20 \7\:CKbb net478 VSS) g45n1hvt w=(1.45e-07) l=4.5e-08 nf=1 \
        as=1.668e-14 ad=3.625e-14 ps=5.2e-07 pd=7.9e-07 nrd=1.16667 \
        nrs=1.16667 sa=3.3e-07 sb=5.5e-07 sd=160n sca=11.9911 \
        scb=0.0120555 scc=0.000498628 m=(1)
mn25 (\6\:Db \9\:CKb \4\:n20 VSS) g45n1hvt w=(1.45e-07) l=4.5e-08 nf=1 \
        as=3.625e-14 ad=3.698e-14 ps=7.9e-07 pd=8e-07 nrd=1.16667 \
        nrs=1.16667 sa=6.25e-07 sb=2.55e-07 sd=160n sca=11.9911 \
        scb=0.0120555 scc=0.000498628 m=(1)
mn20 (\17\:CKb \3\:CK \13\:VSS VSS) g45n1hvt w=(1.45e-07) l=4.5e-08 nf=1 \
        as=6.308e-14 ad=2.03e-14 ps=1.16e-06 pd=5.7e-07 nrd=1.16667 \
        nrs=1.16667 sa=1.4e-07 sb=1.535e-06 sd=160n sca=7.79977 \
        scb=0.00524357 scc=6.87485e-05 m=(1)
mn11 (net494 \4\:D \13\:VSS VSS) g45n1hvt w=(1.45e-07) l=4.5e-08 nf=1 \
        as=6.308e-14 ad=4.713e-14 ps=1.16e-06 pd=9.4e-07 nrd=1.16667 \
        nrs=1.16667 sa=6.2e-07 sb=1.055e-06 sd=160n sca=7.79977 \
        scb=0.00524357 scc=6.87485e-05 m=(1)
mn12 (Db \3\:SEb net494 VSS) g45n1hvt w=(1.45e-07) l=4.5e-08 nf=1 \
        as=4.713e-14 ad=2.32e-14 ps=9.4e-07 pd=6.1e-07 nrd=1.16667 \
        nrs=1.16667 sa=9.9e-07 sb=6.85e-07 sd=160n sca=7.79977 \
        scb=0.00524357 scc=6.87485e-05 m=(1)
mn14 (Db \3\:SE net506 VSS) g45n1hvt w=(1.45e-07) l=4.5e-08 nf=1 \
        as=8.7e-15 ad=2.32e-14 ps=4.1e-07 pd=6.1e-07 nrd=1.16667 \
        nrs=1.16667 sa=1.195e-06 sb=4.8e-07 sd=160n sca=7.79977 \
        scb=0.00524357 scc=6.87485e-05 m=(1)
mn13 (net506 \1\:SI \1\:VSS VSS) g45n1hvt w=(1.45e-07) l=4.5e-08 nf=1 \
        as=2.32e-14 ad=8.7e-15 ps=6.1e-07 pd=4.1e-07 nrd=1.16667 \
        nrs=1.16667 sa=1.3e-06 sb=3.75e-07 sd=160n sca=7.79977 \
        scb=0.00524357 scc=6.87485e-05 m=(1)
mn10 (\4\:SEb \5\:SE \1\:VSS VSS) g45n1hvt w=(1.45e-07) l=4.5e-08 nf=1 \
        as=2.32e-14 ad=2.465e-14 ps=6.1e-07 pd=6.3e-07 nrd=1.16667 \
        nrs=1.16667 sa=1.505e-06 sb=1.7e-07 sd=160n sca=7.79977 \
        scb=0.00524357 scc=6.87485e-05 m=(1)
mp56 (\4\:net492 \6\:qbint \23\:VDD VDD) g45p1hvt w=(2.15e-07) l=4.5e-08 \
        nf=1 as=6.535e-14 ad=3.01e-14 ps=1.16e-06 pd=7.1e-07 nrd=1.16667 \
        nrs=1.16667 sa=1.4e-07 sb=3.75e-07 sd=160n sca=46.2776 \
        scb=0.0284965 scc=0.00588421 m=(1)
mp45 (\14\:qbint \3\:n35 \21\:VDD VDD) g45p1hvt w=(2.15e-07) l=4.5e-08 \
        nf=1 as=3.44e-14 ad=4.193e-14 ps=7.5e-07 pd=8.2e-07 nrd=1.16667 \
        nrs=1.16667 sa=1.95e-07 sb=5.65e-07 sd=160n sca=10.1345 \
        scb=0.00732736 scc=7.25592e-05 m=(1)
mp50 (\3\:net405 \3\:SN \21\:VDD VDD) g45p1hvt w=(2.15e-07) l=4.5e-08 \
        nf=1 as=3.44e-14 ad=3.44e-14 ps=7.5e-07 pd=7.5e-07 nrd=1.16667 \
        nrs=1.16667 sa=4e-07 sb=3.6e-07 sd=160n sca=10.1345 scb=0.00732736 \
        scc=7.25592e-05 m=(1)
mp51 (\3\:net405 \7\:qbint \19\:VDD VDD) g45p1hvt w=(2.15e-07) l=4.5e-08 \
        nf=1 as=3.333e-14 ad=3.44e-14 ps=7.4e-07 pd=7.5e-07 nrd=1.16667 \
        nrs=1.16667 sa=6.05e-07 sb=1.55e-07 sd=160n sca=10.1345 \
        scb=0.00732736 scc=7.25592e-05 m=(1)
mp52 (\4\:n35 \4\:CKbb net405 VDD) g45p1hvt w=(2.15e-07) l=4.5e-08 nf=1 \
        as=3.01e-14 ad=3.44e-14 ps=7.1e-07 pd=7.5e-07 nrd=1.16667 \
        nrs=1.16667 sa=1.4e-07 sb=3.45e-07 sd=160n sca=15.2551 \
        scb=0.0150251 scc=0.000885438 m=(1)
mp40 (\4\:n35 \4\:CKb \11\:mout VDD) g45p1hvt w=(2.15e-07) l=4.5e-08 nf=1 \
        as=3.01e-14 ad=3.44e-14 ps=7.1e-07 pd=7.5e-07 nrd=1.16667 \
        nrs=1.16667 sa=3.45e-07 sb=1.4e-07 sd=160n sca=15.2551 \
        scb=0.0150251 scc=0.000885438 m=(1)
mp21 (\8\:CKbb \2\:CKb \17\:VDD VDD) g45p1hvt w=(2.15e-07) l=4.5e-08 \
        nf=1 as=1.049e-13 ad=3.01e-14 ps=1.83e-06 pd=7.1e-07 nrd=1.16667 \
        nrs=1.16667 sa=1.4e-07 sb=1.53e-06 sd=160n sca=29.9075 \
        scb=0.0247057 scc=0.00372713 m=(1)
mp30 (\7\:mout \4\:SN \17\:VDD VDD) g45p1hvt w=(2.15e-07) l=4.5e-08 nf=1 \
        as=1.049e-13 ad=4.73e-14 ps=1.83e-06 pd=8.7e-07 nrd=1.16667 \
        nrs=1.16667 sa=4.05e-07 sb=1.265e-06 sd=160n sca=29.9075 \
        scb=0.0247057 scc=0.00372713 m=(1)
mp31 (\7\:mout n20 \15\:VDD VDD) g45p1hvt w=(2.15e-07) l=4.5e-08 nf=1 \
        as=1.1028e-13 ad=4.73e-14 ps=1.88e-06 pd=8.7e-07 nrd=1.16667 \
        nrs=1.16667 sa=6.7e-07 sb=1e-06 sd=160n sca=29.9075 scb=0.0247057 \
        scc=0.00372713 m=(1)
mp35 (net417 mout \15\:VDD VDD) g45p1hvt w=(2.15e-07) l=4.5e-08 nf=1 \
        as=1.1028e-13 ad=1.29e-14 ps=1.88e-06 pd=5.5e-07 nrd=1.16667 \
        nrs=1.16667 sa=9.6e-07 sb=7.1e-07 sd=160n sca=29.9075 \
        scb=0.0247057 scc=0.00372713 m=(1)
mp36 (\8\:n20 \7\:CKb net417 VDD) g45p1hvt w=(2.15e-07) l=4.5e-08 nf=1 \
        as=1.29e-14 ad=3.44e-14 ps=5.5e-07 pd=7.5e-07 nrd=1.16667 \
        nrs=1.16667 sa=1.065e-06 sb=6.05e-07 sd=160n sca=29.9075 \
        scb=0.0247057 scc=0.00372713 m=(1)
mp25 (\8\:n20 \5\:CKbb \4\:Db VDD) g45p1hvt w=(2.15e-07) l=4.5e-08 nf=1 \
        as=8.6e-14 ad=3.44e-14 ps=1.23e-06 pd=7.5e-07 nrd=1.16667 \
        nrs=1.16667 sa=1.27e-06 sb=4e-07 sd=160n sca=29.9075 scb=0.0247057 \
        scc=0.00372713 m=(1)
mp20 (\11\:CKb \1\:CK \13\:VDD VDD) g45p1hvt w=(2.15e-07) l=4.5e-08 nf=1 \
        as=3.44e-14 ad=3.01e-14 ps=7.5e-07 pd=7.1e-07 nrd=1.16667 \
        nrs=1.16667 sa=1.4e-07 sb=1.175e-06 sd=160n sca=10.4936 \
        scb=0.00800718 scc=0.000111754 m=(1)
mp11 (net433 \1\:D \13\:VDD VDD) g45p1hvt w=(2.15e-07) l=4.5e-08 nf=1 \
        as=3.44e-14 ad=3.548e-14 ps=7.5e-07 pd=7.6e-07 nrd=1.16667 \
        nrs=1.16667 sa=3.45e-07 sb=9.7e-07 sd=160n sca=10.4936 \
        scb=0.00800718 scc=0.000111754 m=(1)
mp12 (\8\:Db \1\:SE net433 VDD) g45p1hvt w=(2.15e-07) l=4.5e-08 nf=1 \
        as=3.548e-14 ad=4.085e-14 ps=7.6e-07 pd=8.1e-07 nrd=1.16667 \
        nrs=1.16667 sa=5.55e-07 sb=7.6e-07 sd=160n sca=10.5126 \
        scb=0.0080107 scc=0.000111754 m=(1)
mp14 (\8\:Db SEb net441 VDD) g45p1hvt w=(2.15e-07) l=4.5e-08 nf=1 \
        as=2.903e-14 ad=4.085e-14 ps=7e-07 pd=8.1e-07 nrd=1.16667 \
        nrs=1.16667 sa=7.9e-07 sb=5.25e-07 sd=160n sca=11.1923 \
        scb=0.00829854 scc=0.000111894 m=(1)
mp13 (net441 \3\:SI \1\:VDD VDD) g45p1hvt w=(2.15e-07) l=4.5e-08 nf=1 \
        as=3.44e-14 ad=2.903e-14 ps=7.5e-07 pd=7e-07 nrd=1.16667 \
        nrs=1.16667 sa=9.7e-07 sb=3.45e-07 sd=160n sca=12.3417 \
        scb=0.00949694 scc=0.000115721 m=(1)
mp10 (\8\:SEb \7\:SE \1\:VDD VDD) g45p1hvt w=(2.15e-07) l=4.5e-08 nf=1 \
        as=3.44e-14 ad=3.01e-14 ps=7.5e-07 pd=7.1e-07 nrd=1.16667 \
        nrs=1.16667 sa=1.175e-06 sb=1.4e-07 sd=160n sca=16.0492 \
        scb=0.0157507 scc=0.000268603 m=(1)
ends SDFFSX1
// End of subcircuit definition.
