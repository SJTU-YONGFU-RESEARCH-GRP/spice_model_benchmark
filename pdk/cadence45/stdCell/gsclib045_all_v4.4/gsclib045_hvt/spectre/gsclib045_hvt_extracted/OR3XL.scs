// Generated for: spectre (May  1 09:19:42 2013 )
// Library name: gsclib045_hvt
// Cell name: OR3XL
// View name: extracted

simulator lang=spectre

subckt OR3XL A B C VDD VSS Y
mp2 (\4\:n0 \1\:C n2 VDD) g45p1hvt w=(2.15e-07) l=4.5e-08 nf=1 \
        as=3.44e-14 ad=3.01e-14 ps=7.5e-07 pd=7.1e-07 nrd=1.16667 \
        nrs=1.16667 sa=1.4e-07 sb=7.45e-07 sd=160n sca=25.7873 \
        scb=0.0298129 scc=0.00173847 m=(1)
mp1 (n2 \1\:B n1 VDD) g45p1hvt w=(2.15e-07) l=4.5e-08 nf=1 as=3.225e-14 \
        ad=3.44e-14 ps=7.3e-07 pd=7.5e-07 nrd=1.16667 nrs=1.16667 \
        sa=3.45e-07 sb=5.4e-07 sd=160n sca=16.1735 scb=0.0152732 \
        scc=0.000373884 m=(1)
mp0 (n1 \3\:A \1\:VDD VDD) g45p1hvt w=(2.15e-07) l=4.5e-08 nf=1 \
        as=3.44e-14 ad=3.225e-14 ps=7.5e-07 pd=7.3e-07 nrd=1.16667 \
        nrs=1.16667 sa=5.4e-07 sb=3.45e-07 sd=160n sca=14.8074 \
        scb=0.0125288 scc=0.000334622 m=(1)
mp3 (\3\:Y \3\:n0 \1\:VDD VDD) g45p1hvt w=(2.15e-07) l=4.5e-08 nf=1 \
        as=3.44e-14 ad=3.01e-14 ps=7.5e-07 pd=7.1e-07 nrd=1.16667 \
        nrs=1.16667 sa=7.45e-07 sb=1.4e-07 sd=160n sca=16.4362 \
        scb=0.0157971 scc=0.000386659 m=(1)
C1 (VDD VSS) capacitor c=1.00891e-16
C2 (C VSS) capacitor c=7.00447e-17
C3 (A VSS) capacitor c=7.46347e-17
C4 (Y VSS) capacitor c=1.9082e-17
C5 (n0 VSS) capacitor c=2.92326e-17
C6 (n2 VSS) capacitor c=5.37616e-18
C7 (n1 VSS) capacitor c=7.71032e-18
C8 (\3\:n0 VSS) capacitor c=5.46482e-17
C9 (\3\:A VSS) capacitor c=5.21702e-17
C10 (\1\:B VSS) capacitor c=5.49365e-17
C11 (\1\:C VSS) capacitor c=4.652e-17
C12 (\1\:A VSS) capacitor c=4.71051e-17
C13 (\3\:B VSS) capacitor c=4.59444e-17
C14 (\4\:C VSS) capacitor c=3.86287e-17
C15 (\2\:n0 VSS) capacitor c=5.50096e-17
C16 (\4\:A VSS) capacitor c=6.96697e-17
C17 (\2\:B VSS) capacitor c=6.37842e-17
C18 (\3\:C VSS) capacitor c=1.76132e-17
C19 (\3\:Y VSS) capacitor c=6.99859e-17
C20 (\1\:VDD VSS) capacitor c=4.37369e-17
C21 (\4\:n0 VSS) capacitor c=8.11034e-17
C22 (\1\:Y VSS) capacitor c=7.81672e-17
C23 (\9\:n0 VSS) capacitor c=2.6825e-17
C24 (\7\:n0 VSS) capacitor c=6.18603e-17
C25 (\2\:C VSS) capacitor c=4.44068e-17
C26 (\5\:B VSS) capacitor c=5.75461e-17
C27 (\6\:B VSS) capacitor c=3.84784e-17
C28 (\5\:A VSS) capacitor c=5.5298e-17
C29 (\6\:n0 VSS) capacitor c=1.51718e-16
C30 (\11\:n0 VSS) capacitor c=5.33365e-17
C31 (\4\:VDD VSS) capacitor c=2.70531e-17
Rk12 (\2\:VSS \4\:VSS) resistor r=0.2459 c=0
Rk14 (\5\:VSS VSS) resistor r=0.1024 c=0
Rk13 (\4\:VSS \5\:VSS) resistor r=0.1477 c=0
Rk15 (\5\:VSS \7\:VSS) resistor r=0.1831 c=0
Rk17 (\4\:VDD VDD) resistor r=0.2505 c=0
Rk16 (\2\:VDD \4\:VDD) resistor r=0.3523 c=0
Rk1 (C \5\:C) resistor r=0.005129 c=0
Rk5 (\5\:A A) resistor r=0.1712 c=0
Rk11 (\4\:Y Y) resistor r=0.04601 c=0
Rk10 (\2\:Y \4\:Y) resistor r=0.4975 c=0
Rk2 (\4\:B \5\:B) resistor r=0.008389 c=0
Rk3 (B \6\:B) resistor r=0.008277 c=0
Rk4 (\4\:B \6\:B) resistor r=0.0651 c=0
Rk6 (\5\:n0 \6\:n0) resistor r=0.8776 c=0
Rk7 (\6\:n0 \8\:n0) resistor r=0.4127 c=0
Rk8 (\6\:n0 \10\:n0) resistor r=0.1271 c=0
Rk9 (\6\:n0 \11\:n0) resistor r=0.2034 c=0
Rl1 (\1\:C \2\:C) resistor r=154.649 c=0
Rl3 (\2\:C \4\:C) resistor r=108.495 c=0
Rl2 (\2\:C \3\:C) resistor r=5.6709 c=0
Rl7 (\2\:A \3\:A) resistor r=144.685 c=0
Rl6 (\1\:A \2\:A) resistor r=121.608 c=0
Rl8 (\2\:A \4\:A) resistor r=3.0741 c=0
Rl4 (\1\:B \2\:B) resistor r=133.79 c=0
Rl5 (\2\:B \3\:B) resistor r=106.867 c=0
Rl10 (\2\:n0 \3\:n0) resistor r=204.944 c=0
Rl9 (n0 \2\:n0) resistor r=35.7134 c=0
Rz4 (\1\:VSS \2\:VSS) resistor r=75 c=0
Rz5 (\6\:VSS \7\:VSS) resistor r=75 c=0
Rz3 (\1\:Y \2\:Y) resistor r=75 c=0
Rz1 (\7\:n0 \8\:n0) resistor r=75 c=0
Rz2 (\9\:n0 \10\:n0) resistor r=75 c=0
Ry4 (\1\:VDD \2\:VDD) resistor r=62 c=0
Ry2 (\3\:Y \4\:Y) resistor r=62 c=0
Ry1 (\4\:n0 \5\:n0) resistor r=62 c=0
Rx1 (\3\:C \5\:C) resistor r=45 c=0
Rx3 (\4\:A \5\:A) resistor r=45 c=0
Rx2 (\2\:B \5\:B) resistor r=45 c=0
Rx4 (\2\:n0 \11\:n0) resistor r=45 c=0
mn2 (\7\:n0 \4\:C \6\:VSS VSS) g45n1hvt w=(1.45e-07) l=4.5e-08 nf=1 \
        as=2.32e-14 ad=2.03e-14 ps=6.1e-07 pd=5.7e-07 nrd=1.16667 \
        nrs=1.16667 sa=1.4e-07 sb=7.6e-07 sd=160n sca=6.67224 \
        scb=0.00331168 scc=2.36561e-05 m=(1)
mn1 (\9\:n0 \3\:B \6\:VSS VSS) g45n1hvt w=(1.45e-07) l=4.5e-08 nf=1 \
        as=2.32e-14 ad=2.32e-14 ps=6.1e-07 pd=6.1e-07 nrd=1.16667 \
        nrs=1.16667 sa=3.45e-07 sb=5.55e-07 sd=160n sca=6.67224 \
        scb=0.00331168 scc=2.36561e-05 m=(1)
mn0 (\9\:n0 \1\:A \1\:VSS VSS) g45n1hvt w=(1.45e-07) l=4.5e-08 nf=1 \
        as=2.392e-14 ad=2.32e-14 ps=6.2e-07 pd=6.1e-07 nrd=1.16667 \
        nrs=1.16667 sa=5.5e-07 sb=3.5e-07 sd=160n sca=6.67224 \
        scb=0.00331168 scc=2.36561e-05 m=(1)
mn3 (\1\:Y n0 \1\:VSS VSS) g45n1hvt w=(1.45e-07) l=4.5e-08 nf=1 \
        as=2.392e-14 ad=2.03e-14 ps=6.2e-07 pd=5.7e-07 nrd=1.16667 \
        nrs=1.16667 sa=7.6e-07 sb=1.4e-07 sd=160n sca=6.67224 \
        scb=0.00331168 scc=2.36561e-05 m=(1)
ends OR3XL
// End of subcircuit definition.
