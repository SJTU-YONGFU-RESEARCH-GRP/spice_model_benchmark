// Generated for: spectre (May  1 09:12:48 2013 )
// Library name: gsclib045_hvt
// Cell name: AOI222X2
// View name: extracted

simulator lang=spectre

subckt AOI222X2 A0 A1 B0 B1 C0 C1 VDD VSS Y
mp2 (net134 B0 \5\:net126 VDD) g45p1hvt w=(3.9e-07) l=4.5e-08 nf=1 \
        as=6.435e-14 ad=5.85e-14 ps=1.11e-06 pd=1.08e-06 nrd=1.16667 \
        nrs=1.16667 sa=1.4e-07 sb=1.585e-06 sd=160n sca=13.5671 \
        scb=0.012183 scc=0.000647513 m=(2)
mp5_1__rcx (\8\:Y \1\:C1 \8\:net134 VDD) g45p1hvt w=(3.9e-07) l=4.5e-08 \
        nf=1 as=6.24e-14 ad=6.24e-14 ps=1.1e-06 pd=1.1e-06 nrd=1.16667 \
        nrs=1.16667 sa=1.175e-06 sb=5.5e-07 sd=160n sca=14.7281 \
        scb=0.0128603 scc=0.000648267 m=(2)
mp4 (\8\:Y \1\:C0 net134 VDD) g45p1hvt w=(3.9e-07) l=4.5e-08 nf=1 \
        as=5.85e-14 ad=6.24e-14 ps=1.08e-06 pd=1.1e-06 nrd=1.16667 \
        nrs=1.16667 sa=9.7e-07 sb=7.55e-07 sd=160n sca=13.8663 \
        scb=0.0122652 scc=0.000647528 m=(2)
mp1_1__rcx (net126 \4\:A1 \9\:VDD VDD) g45p1hvt w=(3.9e-07) l=4.5e-08 \
        nf=1 as=6.24e-14 ad=6.24e-14 ps=1.1e-06 pd=1.1e-06 nrd=1.16667 \
        nrs=1.16667 sa=3.45e-07 sb=5.5e-07 sd=160n sca=15.1941 \
        scb=0.0133849 scc=0.00065002 m=(2)
mp3_1__rcx (\12\:net134 \1\:B1 \5\:net126 VDD) g45p1hvt w=(3.9e-07) \
        l=4.5e-08 nf=1 as=6.435e-14 ad=6.24e-14 ps=1.11e-06 pd=1.1e-06 \
        nrd=1.16667 nrs=1.16667 sa=3.55e-07 sb=1.37e-06 sd=160n \
        sca=13.5671 scb=0.012183 scc=0.000647513 m=(2)
mp0_1__rcx (net126 \2\:A0 \4\:VDD VDD) g45p1hvt w=(3.9e-07) l=4.5e-08 \
        nf=1 as=5.46e-14 ad=6.24e-14 ps=1.06e-06 pd=1.1e-06 nrd=1.16667 \
        nrs=1.16667 sa=1.4e-07 sb=7.55e-07 sd=160n sca=18.3639 \
        scb=0.0185931 scc=0.000748758 m=(2)
C1 (C0 VSS) capacitor c=2.82341e-17
C2 (B1 VSS) capacitor c=3.46974e-17
C3 (A0 VSS) capacitor c=2.46253e-17
C4 (C1 VSS) capacitor c=5.94513e-17
C5 (Y VSS) capacitor c=1.62918e-16
C6 (B0 VSS) capacitor c=3.73781e-16
C7 (A1 VSS) capacitor c=6.10716e-17
C8 (VDD VSS) capacitor c=1.67067e-16
C9 (13 VSS) capacitor c=1.68035e-18
C10 (14 VSS) capacitor c=3.13109e-18
C11 (15 VSS) capacitor c=2.99523e-18
C12 (16 VSS) capacitor c=2.87924e-18
C13 (net126 VSS) capacitor c=2.1306e-16
C14 (net134 VSS) capacitor c=3.21612e-16
C15 (\1\:C1 VSS) capacitor c=1.06178e-16
C16 (\1\:C0 VSS) capacitor c=3.13149e-16
C17 (\1\:B1 VSS) capacitor c=8.74262e-17
C18 (\6\:C0 VSS) capacitor c=5.62162e-17
C19 (\4\:C1 VSS) capacitor c=4.71963e-17
C20 (\6\:C1 VSS) capacitor c=4.68199e-17
C21 (\3\:C0 VSS) capacitor c=4.79172e-17
C22 (\6\:B0 VSS) capacitor c=4.78464e-17
C23 (\7\:B1 VSS) capacitor c=4.54012e-17
C24 (\5\:B1 VSS) capacitor c=3.08947e-17
C25 (\3\:B0 VSS) capacitor c=3.98643e-17
C26 (\6\:A0 VSS) capacitor c=5.56546e-17
C27 (\1\:A1 VSS) capacitor c=5.06685e-17
C28 (\6\:A1 VSS) capacitor c=4.79998e-17
C29 (\1\:A0 VSS) capacitor c=5.36335e-17
C30 (\3\:B1 VSS) capacitor c=1.81999e-17
C31 (\3\:A1 VSS) capacitor c=1.68451e-17
C32 (\2\:A0 VSS) capacitor c=3.22352e-16
C33 (\8\:net134 VSS) capacitor c=2.96264e-18
C34 (\8\:Y VSS) capacitor c=2.15215e-16
C35 (\12\:net134 VSS) capacitor c=4.09942e-18
C36 (\5\:net126 VSS) capacitor c=2.2626e-16
C37 (\9\:VDD VSS) capacitor c=4.27304e-17
C38 (\1\:VDD VSS) capacitor c=1.29749e-16
C39 (\1\:Y VSS) capacitor c=8.71951e-17
C40 (\3\:Y VSS) capacitor c=1.05461e-16
C41 (\6\:Y VSS) capacitor c=6.45148e-17
C42 (\2\:A1 VSS) capacitor c=4.05585e-17
C43 (\4\:A1 VSS) capacitor c=9.20292e-17
C44 (\4\:B1 VSS) capacitor c=3.37444e-17
C45 (\3\:C1 VSS) capacitor c=2.79323e-17
C46 (\9\:B1 VSS) capacitor c=1.08417e-16
C47 (\5\:Y VSS) capacitor c=7.31226e-17
C48 (\4\:VDD VSS) capacitor c=1.21989e-16
Rk20 (\1\:C0 C0) resistor r=0.02444 c=0
Rk11 (B1 \9\:B1) resistor r=0.01466 c=0
Rk3 (\2\:A0 A0) resistor r=0.1022 c=0
Rk12 (\7\:C1 C1) resistor r=0.005083 c=0
Rk17 (Y \8\:Y) resistor r=0.9775 c=0
Rk13 (\2\:Y \4\:Y) resistor r=0.6027 c=0
Rk16 (\5\:Y Y) resistor r=0.234 c=0
Rk14 (\4\:Y \5\:Y) resistor r=0.3576 c=0
Rk15 (\5\:Y \7\:Y) resistor r=0.4032 c=0
Rk1 (A1 \8\:A1) resistor r=0.004597 c=0
Rk28 (\2\:VSS \4\:VSS) resistor r=0.2926 c=0
Rk29 (\4\:VSS \5\:VSS) resistor r=0.3256 c=0
Rk30 (\5\:VSS \6\:VSS) resistor r=0.4759 c=0
Rk31 (\6\:VSS \7\:VSS) resistor r=0.06245 c=0
Rk33 (\8\:VSS VSS) resistor r=0.1775 c=0
Rk32 (\7\:VSS \8\:VSS) resistor r=0.3103 c=0
Rk34 (\5\:VSS \10\:VSS) resistor r=0.1882 c=0
Rk35 (\7\:VSS \12\:VSS) resistor r=0.1882 c=0
Rk36 (\8\:VSS \14\:VSS) resistor r=0.2293 c=0
Rk37 (\2\:VDD \3\:VDD) resistor r=0.8018 c=0
Rk41 (\4\:VDD VDD) resistor r=0.07723 c=0
Rk38 (\3\:VDD \4\:VDD) resistor r=0.07748 c=0
Rk43 (\4\:VDD \10\:VDD) resistor r=0.2216 c=0
Rk5 (net126 \5\:net126) resistor r=0.5745 c=0
Rk25 (net134 \9\:net134) resistor r=0.0153 c=0
Rk27 (net134 \13\:net134) resistor r=0.0153 c=0
Rl29 (\1\:C0 \6\:C0) resistor r=65.3618 c=0
Rl22 (\1\:C0 \3\:C0) resistor r=29.5379 c=0
Rl14 (\1\:B1 \3\:B1) resistor r=9.6652 c=0
Rl18 (\4\:B1 \7\:B1) resistor r=82.1768 c=0
Rl16 (\4\:B1 \5\:B1) resistor r=32.7557 c=0
Rl15 (\4\:B1 \3\:B1) resistor r=23.3085 c=0
Rl10 (\2\:A0 \6\:A0) resistor r=29.5379 c=0
Rl1 (\2\:A0 \1\:A0) resistor r=49.5597 c=0
Rl24 (\3\:C1 \1\:C1) resistor r=23.8563 c=0
Rl25 (\3\:C1 \4\:C1) resistor r=32.7557 c=0
Rl27 (\3\:C1 \6\:C1) resistor r=82.1768 c=0
Rl20 (B0 \6\:B0) resistor r=24.7951 c=0
Rl12 (B0 \3\:B0) resistor r=29.5379 c=0
Rl3 (\2\:A1 \1\:A1) resistor r=64.2686 c=0
Rl7 (\2\:A1 \6\:A1) resistor r=31.8259 c=0
Rl4 (\2\:A1 \3\:A1) resistor r=19.3454 c=0
Rl5 (\4\:A1 \3\:A1) resistor r=5.8921 c=0
Rz1 (\2\:Y \1\:Y) resistor r=75 c=0
Rz2 (\4\:Y \3\:Y) resistor r=75 c=0
Rz3 (\7\:Y \6\:Y) resistor r=75 c=0
Rz4 (\1\:VSS \2\:VSS) resistor r=75 c=0
Rz5 (\9\:VSS \10\:VSS) resistor r=75 c=0
Rz6 (\11\:VSS \12\:VSS) resistor r=75 c=0
Rz7 (\13\:VSS \14\:VSS) resistor r=75 c=0
Rz8 (\2\:VDD \1\:VDD) resistor r=18.75 c=0
Rz9 (\3\:VDD \1\:VDD) resistor r=6.25 c=0
Ry12 (\3\:VSS \4\:VSS) resistor r=15.5 c=0
Ry13 (\3\:VSS \6\:VSS) resistor r=5.1667 c=0
Ry15 (\10\:VDD \9\:VDD) resistor r=62 c=0
Ry9 (\9\:net134 \8\:net134) resistor r=62 c=0
Ry11 (\13\:net134 \12\:net134) resistor r=62 c=0
Rx6 (\9\:B1 \3\:B1) resistor r=45 c=0
Rx7 (\7\:C1 \1\:C1) resistor r=45 c=0
Rx1 (\8\:A1 \3\:A1) resistor r=45 c=0
mn0_1__rcx (12 \1\:A0 \13\:VSS VSS) g45n1hvt w=(2.6e-07) l=4.5e-08 nf=1 \
        as=3.64e-14 ad=1.56e-14 ps=8e-07 pd=6.4e-07 nrd=1.16667 \
        nrs=1.16667 sa=1.4e-07 sb=2e-06 sd=160n sca=10.79 scb=0.0100512 \
        scc=0.000418069 m=(1)
mn1_1__rcx (\6\:Y \6\:A1 12 VSS) g45n1hvt w=(2.6e-07) l=4.5e-08 nf=1 \
        as=1.56e-14 ad=4.16e-14 ps=6.4e-07 pd=8.4e-07 nrd=1.16667 \
        nrs=1.16667 sa=2.45e-07 sb=2e-06 sd=160n sca=10.79 scb=0.0100512 \
        scc=0.000418069 m=(1)
mn1 (\6\:Y \1\:A1 13 VSS) g45n1hvt w=(2.6e-07) l=4.5e-08 nf=1 as=1.56e-14 \
        ad=4.16e-14 ps=6.4e-07 pd=8.4e-07 nrd=1.16667 nrs=1.16667 \
        sa=4.5e-07 sb=2e-06 sd=160n sca=10.79 scb=0.0100512 \
        scc=0.000418069 m=(1)
mn0 (13 \6\:A0 \11\:VSS VSS) g45n1hvt w=(2.6e-07) l=4.5e-08 nf=1 \
        as=1.418e-13 ad=1.56e-14 ps=1.67e-06 pd=6.4e-07 nrd=1.16667 \
        nrs=1.16667 sa=5.55e-07 sb=1.99e-06 sd=160n sca=10.79 \
        scb=0.0100512 scc=0.000418069 m=(1)
mn2_1__rcx (14 \3\:B0 \11\:VSS VSS) g45n1hvt w=(2.6e-07) l=4.5e-08 nf=1 \
        as=1.418e-13 ad=2.99e-14 ps=1.67e-06 pd=7.5e-07 nrd=1.16667 \
        nrs=1.16667 sa=1.12e-06 sb=1.425e-06 sd=160n sca=10.79 \
        scb=0.0100512 scc=0.000418069 m=(1)
mn3_1__rcx (\3\:Y \5\:B1 14 VSS) g45n1hvt w=(2.6e-07) l=4.5e-08 nf=1 \
        as=2.99e-14 ad=4.16e-14 ps=7.5e-07 pd=8.4e-07 nrd=1.16667 \
        nrs=1.16667 sa=1.28e-06 sb=1.265e-06 sd=160n sca=10.79 \
        scb=0.0100512 scc=0.000418069 m=(1)
mn3 (\3\:Y \7\:B1 15 VSS) g45n1hvt w=(2.6e-07) l=4.5e-08 nf=1 as=2.6e-14 \
        ad=4.16e-14 ps=7.2e-07 pd=8.4e-07 nrd=1.16667 nrs=1.16667 \
        sa=1.485e-06 sb=1.06e-06 sd=160n sca=10.79 scb=0.0100512 \
        scc=0.000418069 m=(1)
mn2 (15 \6\:B0 \9\:VSS VSS) g45n1hvt w=(2.6e-07) l=4.5e-08 nf=1 \
        as=7.81e-14 ad=2.6e-14 ps=1.18e-06 pd=7.2e-07 nrd=1.16667 \
        nrs=1.16667 sa=1.63e-06 sb=9.15e-07 sd=160n sca=10.79 \
        scb=0.0100512 scc=0.000418069 m=(1)
mn4_1__rcx (16 \3\:C0 \9\:VSS VSS) g45n1hvt w=(2.6e-07) l=4.5e-08 nf=1 \
        as=7.81e-14 ad=2.6e-14 ps=1.18e-06 pd=7.2e-07 nrd=1.16667 \
        nrs=1.16667 sa=1.95e-06 sb=5.95e-07 sd=160n sca=10.79 \
        scb=0.0100512 scc=0.000418069 m=(1)
mn5_1__rcx (\1\:Y \6\:C1 16 VSS) g45n1hvt w=(2.6e-07) l=4.5e-08 nf=1 \
        as=2.6e-14 ad=4.16e-14 ps=7.2e-07 pd=8.4e-07 nrd=1.16667 \
        nrs=1.16667 sa=2e-06 sb=4.5e-07 sd=160n sca=10.79 scb=0.0100512 \
        scc=0.000418069 m=(1)
mn5 (\1\:Y \4\:C1 17 VSS) g45n1hvt w=(2.6e-07) l=4.5e-08 nf=1 as=1.56e-14 \
        ad=4.16e-14 ps=6.4e-07 pd=8.4e-07 nrd=1.16667 nrs=1.16667 sa=2e-06 \
        sb=2.45e-07 sd=160n sca=10.79 scb=0.0100512 scc=0.000418069 m=(1)
mn4 (17 \6\:C0 \1\:VSS VSS) g45n1hvt w=(2.6e-07) l=4.5e-08 nf=1 \
        as=3.64e-14 ad=1.56e-14 ps=8e-07 pd=6.4e-07 nrd=1.16667 \
        nrs=1.16667 sa=2e-06 sb=1.4e-07 sd=160n sca=10.79 scb=0.0100512 \
        scc=0.000418069 m=(1)
ends AOI222X2
// End of subcircuit definition.
