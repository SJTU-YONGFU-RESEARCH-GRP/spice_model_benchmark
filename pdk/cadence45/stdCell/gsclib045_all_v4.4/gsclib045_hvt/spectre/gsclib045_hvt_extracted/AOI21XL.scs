// Generated for: spectre (May  1 09:12:42 2013 )
// Library name: gsclib045_hvt
// Cell name: AOI21XL
// View name: extracted

simulator lang=spectre

subckt AOI21XL A0 A1 B0 VDD VSS Y
mp0 (net70 \3\:A0 \4\:VDD VDD) g45p1hvt w=(2.15e-07) l=4.5e-08 nf=1 \
        as=6.89e-14 ad=3.01e-14 ps=1.23e-06 pd=7.1e-07 nrd=1.16667 \
        nrs=1.16667 sa=1.4e-07 sb=6.1e-07 sd=160n sca=17.8246 \
        scb=0.0177319 scc=0.000363007 m=(1)
mp1 (\3\:net70 \1\:A1 \4\:VDD VDD) g45p1hvt w=(2.15e-07) l=4.5e-08 nf=1 \
        as=6.89e-14 ad=3.44e-14 ps=1.23e-06 pd=7.5e-07 nrd=1.16667 \
        nrs=1.16667 sa=4.05e-07 sb=3.45e-07 sd=160n sca=14.8802 \
        scb=0.0119982 scc=0.000102266 m=(1)
mp2 (\3\:Y \4\:B0 \3\:net70 VDD) g45p1hvt w=(2.15e-07) l=4.5e-08 nf=1 \
        as=3.44e-14 ad=3.01e-14 ps=7.5e-07 pd=7.1e-07 nrd=1.16667 \
        nrs=1.16667 sa=6.1e-07 sb=1.4e-07 sd=160n sca=21.4669 \
        scb=0.0232556 scc=0.000936595 m=(1)
C1 (A1 VSS) capacitor c=5.1829e-17
C2 (Y VSS) capacitor c=7.21436e-17
C3 (A0 VSS) capacitor c=3.94428e-17
C4 (VDD VSS) capacitor c=1.23011e-16
C5 (B0 VSS) capacitor c=7.66654e-17
C6 (net70 VSS) capacitor c=3.50324e-17
C7 (\4\:B0 VSS) capacitor c=4.71515e-17
C8 (\1\:A1 VSS) capacitor c=7.1343e-17
C9 (\3\:A0 VSS) capacitor c=5.79369e-17
C10 (\1\:B0 VSS) capacitor c=3.12685e-17
C11 (\3\:A1 VSS) capacitor c=4.05455e-17
C12 (\1\:A0 VSS) capacitor c=4.55908e-17
C13 (\3\:B0 VSS) capacitor c=5.6704e-17
C14 (\2\:A1 VSS) capacitor c=7.48503e-17
C15 (\2\:A0 VSS) capacitor c=4.68697e-17
C16 (\3\:Y VSS) capacitor c=5.84132e-17
C17 (\3\:net70 VSS) capacitor c=5.59033e-17
C18 (\4\:VDD VSS) capacitor c=2.68757e-17
C19 (\1\:Y VSS) capacitor c=7.57838e-17
C20 (\4\:A0 VSS) capacitor c=3.73037e-17
C21 (\4\:A1 VSS) capacitor c=6.52974e-17
C22 (\5\:B0 VSS) capacitor c=2.90975e-17
C23 (\3\:VDD VSS) capacitor c=3.68269e-17
Rk2 (A1 \4\:A1) resistor r=0.2094 c=0
Rk7 (\2\:Y Y) resistor r=0.2871 c=0
Rk8 (Y \4\:Y) resistor r=0.4296 c=0
Rk1 (\4\:A0 A0) resistor r=0.09189 c=0
Rk10 (\3\:VSS VSS) resistor r=0.08721 c=0
Rk9 (\2\:VSS \3\:VSS) resistor r=0.2882 c=0
Rk11 (\3\:VSS \5\:VSS) resistor r=0.1125 c=0
Rk12 (\5\:VSS \7\:VSS) resistor r=0.4421 c=0
Rk14 (\3\:VDD VDD) resistor r=0.1648 c=0
Rk15 (\3\:VDD \5\:VDD) resistor r=0.07323 c=0
Rk6 (\5\:B0 B0) resistor r=0.03888 c=0
Rk3 (\2\:net70 \4\:net70) resistor r=0.2768 c=0
Rl3 (\1\:A1 \2\:A1) resistor r=218.312 c=0
Rl4 (\2\:A1 \3\:A1) resistor r=29.9451 c=0
Rl2 (\2\:A0 \3\:A0) resistor r=203.641 c=0
Rl1 (\1\:A0 \2\:A0) resistor r=55.7464 c=0
Rl7 (\2\:B0 \4\:B0) resistor r=168.236 c=0
Rl5 (\1\:B0 \2\:B0) resistor r=98.4889 c=0
Rl6 (\2\:B0 \3\:B0) resistor r=2.0644 c=0
Rz1 (\1\:Y \2\:Y) resistor r=75 c=0
Rz2 (\1\:VSS \2\:VSS) resistor r=75 c=0
Rz3 (\6\:VSS \7\:VSS) resistor r=75 c=0
Ry3 (\3\:Y \4\:Y) resistor r=62 c=0
Ry5 (\4\:VDD \5\:VDD) resistor r=62 c=0
Ry1 (net70 \2\:net70) resistor r=62 c=0
Ry2 (\3\:net70 \4\:net70) resistor r=62 c=0
Rx2 (\2\:A1 \4\:A1) resistor r=45 c=0
Rx1 (\2\:A0 \4\:A0) resistor r=45 c=0
Rx3 (\3\:B0 \5\:B0) resistor r=45 c=0
mn0 (net74 \1\:A0 \1\:VSS VSS) g45n1hvt w=(1.45e-07) l=4.5e-08 nf=1 \
        as=2.03e-14 ad=8.7e-15 ps=5.7e-07 pd=4.1e-07 nrd=1.16667 \
        nrs=1.16667 sa=1.4e-07 sb=5.35e-07 sd=160n sca=10.4914 \
        scb=0.00978575 scc=0.000300434 m=(1)
mn1 (\1\:Y \3\:A1 net74 VSS) g45n1hvt w=(1.45e-07) l=4.5e-08 nf=1 \
        as=8.7e-15 ad=3.553e-14 ps=4.1e-07 pd=7.8e-07 nrd=1.16667 \
        nrs=1.16667 sa=2.45e-07 sb=4.3e-07 sd=160n sca=10.4914 \
        scb=0.00978575 scc=0.000300434 m=(1)
mn2 (\1\:Y \1\:B0 \6\:VSS VSS) g45n1hvt w=(1.45e-07) l=4.5e-08 nf=1 \
        as=2.03e-14 ad=3.553e-14 ps=5.7e-07 pd=7.8e-07 nrd=1.16667 \
        nrs=1.16667 sa=5.35e-07 sb=1.4e-07 sd=160n sca=10.4914 \
        scb=0.00978575 scc=0.000300434 m=(1)
ends AOI21XL
// End of subcircuit definition.
