// Generated for: spectre (May  1 09:15:43 2013 )
// Library name: gsclib045_hvt
// Cell name: SDFFRX2
// View name: extracted

simulator lang=spectre

subckt SDFFRX2 CK D Q QN RN SE SI VDD VSS
mp56 (\11\:qint \3\:qbint \20\:VDD VDD) g45p1hvt w=(2.15e-07) l=4.5e-08 \
        nf=1 as=8.305e-14 ad=3.01e-14 ps=1.32e-06 pd=7.1e-07 nrd=1.16667 \
        nrs=1.16667 sa=1.4e-07 sb=1.45721e-06 sd=160n sca=57.0065 \
        scb=0.0445545 scc=0.00681945 m=(1)
mp20 (\17\:CKb \3\:CK \20\:VDD VDD) g45p1hvt w=(2.15e-07) l=4.5e-08 nf=1 \
        as=7.572e-14 ad=4.67e-14 ps=1.56e-06 pd=1.05e-06 nrd=1.16667 \
        nrs=1.16667 sa=1.38e-06 sb=2.17209e-07 sd=160n sca=45.7906 \
        scb=0.0283307 scc=0.00588417 m=(1)
mp50 (n8 \12\:qbint \15\:VDD VDD) g45p1hvt w=(2.15e-07) l=4.5e-08 nf=1 \
        as=7.303e-14 ad=4.3e-14 ps=1.81e-06 pd=8.3e-07 nrd=1.16667 \
        nrs=1.16667 sa=5.25e-07 sb=1.435e-06 sd=160n sca=21.9815 \
        scb=0.0208641 scc=0.00225088 m=(1)
mp51 (\4\:n30 Ckbb n8 VDD) g45p1hvt w=(2.15e-07) l=4.5e-08 nf=1 \
        as=4.3e-14 ad=5.482e-14 ps=8.3e-07 pd=9.4e-07 nrd=1.16667 \
        nrs=1.16667 sa=7.7e-07 sb=1.19e-06 sd=160n sca=21.9815 \
        scb=0.0208641 scc=0.00225088 m=(1)
mp40 (\4\:n30 \3\:CKb \4\:mout VDD) g45p1hvt w=(2.15e-07) l=4.5e-08 nf=1 \
        as=5.912e-14 ad=5.483e-14 ps=9.8e-07 pd=9.4e-07 nrd=1.16667 \
        nrs=1.16667 sa=1.07e-06 sb=8.9e-07 sd=160n sca=21.9815 \
        scb=0.0208641 scc=0.00225088 m=(1)
mp30 (\4\:mout \4\:n20 \12\:VDD VDD) g45p1hvt w=(2.15e-07) l=4.5e-08 \
        nf=1 as=6.29e-14 ad=5.913e-14 ps=1.76e-06 pd=9.8e-07 nrd=1.16667 \
        nrs=1.16667 sa=1.39e-06 sb=5.7e-07 sd=160n sca=21.9815 \
        scb=0.0208641 scc=0.00225088 m=(1)
mp35 (\3\:n6 \5\:RN \12\:VDD VDD) g45p1hvt w=(2.15e-07) l=4.5e-08 nf=1 \
        as=6.29e-14 ad=3.44e-14 ps=1.76e-06 pd=7.5e-07 nrd=1.16667 \
        nrs=1.16667 sa=1.585e-06 sb=3.75e-07 sd=160n sca=21.9815 \
        scb=0.0208641 scc=0.00225088 m=(1)
mp36 (\3\:n6 mout \10\:VDD VDD) g45p1hvt w=(2.15e-07) l=4.5e-08 nf=1 \
        as=7.075e-14 ad=3.44e-14 ps=1.34e-06 pd=7.5e-07 nrd=1.16667 \
        nrs=1.16667 sa=1.79e-06 sb=1.7e-07 sd=160n sca=21.9815 \
        scb=0.0208641 scc=0.00225088 m=(1)
mp37 (\8\:n20 \6\:CKb n6 VDD) g45p1hvt w=(2.15e-07) l=4.5e-08 nf=1 \
        as=3.01e-14 ad=3.44e-14 ps=7.1e-07 pd=7.5e-07 nrd=1.16667 \
        nrs=1.16667 sa=1.4e-07 sb=3.45e-07 sd=160n sca=37.431 \
        scb=0.0268495 scc=0.00487383 m=(1)
mp25 (\8\:n20 \7\:Ckbb \5\:Db VDD) g45p1hvt w=(2.15e-07) l=4.5e-08 nf=1 \
        as=3.01e-14 ad=3.44e-14 ps=7.1e-07 pd=7.5e-07 nrd=1.16667 \
        nrs=1.16667 sa=3.45e-07 sb=1.4e-07 sd=160n sca=37.431 \
        scb=0.0268495 scc=0.00487383 m=(1)
mp21 (\14\:Ckbb \8\:CKb \8\:VDD VDD) g45p1hvt w=(2.15e-07) l=4.5e-08 \
        nf=1 as=7.042e-14 ad=3.01e-14 ps=1.92e-06 pd=7.1e-07 nrd=1.16667 \
        nrs=1.16667 sa=1.4e-07 sb=1.2e-06 sd=160n sca=35.2411 \
        scb=0.0263265 scc=0.00456529 m=(1)
mp13 (n4 \1\:SI \8\:VDD VDD) g45p1hvt w=(2.15e-07) l=4.5e-08 nf=1 \
        as=7.042e-14 ad=1.29e-14 ps=1.92e-06 pd=5.5e-07 nrd=1.16667 \
        nrs=1.16667 sa=3.5e-07 sb=9.9e-07 sd=160n sca=35.2411 \
        scb=0.0263265 scc=0.00456529 m=(1)
mp14 (\3\:Db SEb n4 VDD) g45p1hvt w=(2.15e-07) l=4.5e-08 nf=1 as=1.29e-14 \
        ad=5.698e-14 ps=5.5e-07 pd=9.6e-07 nrd=1.16667 nrs=1.16667 \
        sa=4.55e-07 sb=8.85e-07 sd=160n sca=35.2411 scb=0.0263265 \
        scc=0.00456529 m=(1)
mp12 (\3\:Db \1\:SE n2 VDD) g45p1hvt w=(2.15e-07) l=4.5e-08 nf=1 \
        as=3.763e-14 ad=5.698e-14 ps=7.8e-07 pd=9.6e-07 nrd=1.16667 \
        nrs=1.16667 sa=7.65e-07 sb=5.75e-07 sd=160n sca=35.7281 \
        scb=0.0264923 scc=0.00456533 m=(1)
mp11 (n2 \1\:D \1\:VDD VDD) g45p1hvt w=(2.15e-07) l=4.5e-08 nf=1 \
        as=6.97e-14 ad=3.763e-14 ps=1.9e-06 pd=7.8e-07 nrd=1.16667 \
        nrs=1.16667 sa=9.85e-07 sb=3.55e-07 sd=160n sca=36.9533 \
        scb=0.0276367 scc=0.0045683 m=(1)
mp10 (\5\:SEb \6\:SE \1\:VDD VDD) g45p1hvt w=(2.15e-07) l=4.5e-08 nf=1 \
        as=6.97e-14 ad=3.01e-14 ps=1.9e-06 pd=7.1e-07 nrd=1.16667 \
        nrs=1.16667 sa=1.2e-06 sb=1.4e-07 sd=160n sca=40.6333 \
        scb=0.0337853 scc=0.00470903 m=(1)
C1 (RN VSS) capacitor c=1.54732e-16
C2 (QN VSS) capacitor c=4.95e-17
C3 (D VSS) capacitor c=5.67399e-17
C4 (Q VSS) capacitor c=4.41528e-17
C5 (VDD VSS) capacitor c=3.53572e-16
C6 (CK VSS) capacitor c=1.1017e-16
C7 (SI VSS) capacitor c=8.05007e-17
C8 (qbint VSS) capacitor c=3.20039e-17
C9 (qint VSS) capacitor c=1.65439e-16
C10 (CKb VSS) capacitor c=5.73565e-17
C11 (n30 VSS) capacitor c=5.17651e-17
C12 (mout VSS) capacitor c=4.77573e-17
C13 (Ckbb VSS) capacitor c=7.9265e-17
C14 (n20 VSS) capacitor c=2.57669e-17
C15 (n5 VSS) capacitor c=2.08302e-19
C16 (Db VSS) capacitor c=1.07702e-16
C17 (n3 VSS) capacitor c=2.93728e-18
C18 (SEb VSS) capacitor c=6.51553e-17
C19 (n8 VSS) capacitor c=3.9157e-18
C20 (n6 VSS) capacitor c=8.54235e-17
C21 (n4 VSS) capacitor c=1.17072e-18
C22 (n2 VSS) capacitor c=5.77736e-18
C23 (\6\:SE VSS) capacitor c=4.0133e-17
C24 (\1\:D VSS) capacitor c=3.58651e-17
C25 (\1\:SE VSS) capacitor c=3.06742e-17
C26 (\1\:SI VSS) capacitor c=7.62428e-17
C27 (\8\:CKb VSS) capacitor c=4.39624e-17
C28 (\7\:Ckbb VSS) capacitor c=5.05322e-17
C29 (\6\:CKb VSS) capacitor c=3.98066e-17
C30 (\5\:RN VSS) capacitor c=6.79302e-17
C31 (\4\:n20 VSS) capacitor c=4.43633e-17
C32 (\3\:CKb VSS) capacitor c=3.65943e-17
C33 (\12\:qbint VSS) capacitor c=4.33275e-17
C34 (\1\:RN VSS) capacitor c=4.64919e-17
C35 (\3\:n30 VSS) capacitor c=3.86229e-17
C36 (\3\:CK VSS) capacitor c=4.17518e-17
C37 (\4\:qbint VSS) capacitor c=4.56851e-16
C38 (\3\:qbint VSS) capacitor c=1.8311e-17
C39 (\4\:SE VSS) capacitor c=2.79368e-17
C40 (\3\:D VSS) capacitor c=6.78313e-17
C41 (\3\:SEb VSS) capacitor c=7.58337e-17
C42 (\3\:SE VSS) capacitor c=5.02815e-17
C43 (\3\:SI VSS) capacitor c=2.81345e-17
C44 (\10\:CKb VSS) capacitor c=5.24808e-17
C45 (\5\:CKb VSS) capacitor c=4.55779e-17
C46 (\4\:Ckbb VSS) capacitor c=5.81278e-17
C47 (\3\:mout VSS) capacitor c=4.72287e-17
C48 (\4\:RN VSS) capacitor c=8.68045e-17
C49 (\3\:n20 VSS) capacitor c=4.1549e-17
C50 (\2\:Ckbb VSS) capacitor c=4.61938e-17
C51 (\13\:qbint VSS) capacitor c=7.86107e-17
C52 (\3\:RN VSS) capacitor c=6.69554e-17
C53 (\1\:CK VSS) capacitor c=2.42917e-17
C54 (\5\:SE VSS) capacitor c=3.48063e-17
C55 (\2\:D VSS) capacitor c=4.79009e-17
C56 (\4\:SEb VSS) capacitor c=3.24254e-17
C57 (\2\:SE VSS) capacitor c=4.02778e-17
C58 (\2\:SEb VSS) capacitor c=3.63486e-17
C59 (\2\:SI VSS) capacitor c=4.60945e-17
C60 (\9\:CKb VSS) capacitor c=2.32286e-17
C61 (\6\:Ckbb VSS) capacitor c=3.57689e-17
C62 (\7\:CKb VSS) capacitor c=1.94546e-17
C63 (\5\:Ckbb VSS) capacitor c=2.43371e-17
C64 (\2\:mout VSS) capacitor c=4.42658e-17
C65 (\6\:RN VSS) capacitor c=2.90731e-17
C66 (\3\:Ckbb VSS) capacitor c=1.97342e-17
C67 (\4\:CKb VSS) capacitor c=4.38315e-17
C68 (\2\:CKb VSS) capacitor c=2.4687e-17
C69 (\14\:qbint VSS) capacitor c=2.48061e-17
C70 (\2\:RN VSS) capacitor c=5.07775e-17
C71 (\2\:n30 VSS) capacitor c=3.63112e-17
C72 (\2\:CK VSS) capacitor c=2.87764e-17
C73 (\2\:qbint VSS) capacitor c=3.22956e-17
C74 (\5\:SEb VSS) capacitor c=4.74892e-17
C75 (\1\:VDD VSS) capacitor c=1.96932e-17
C76 (\3\:Db VSS) capacitor c=1.25718e-16
C77 (\8\:VDD VSS) capacitor c=1.07438e-17
C78 (\14\:Ckbb VSS) capacitor c=5.65337e-17
C79 (\5\:Db VSS) capacitor c=1.62075e-16
C80 (\8\:n20 VSS) capacitor c=5.64975e-17
C81 (\10\:VDD VSS) capacitor c=3.63875e-17
C82 (\3\:n6 VSS) capacitor c=8.55685e-17
C83 (\12\:VDD VSS) capacitor c=2.36571e-17
C84 (\4\:mout VSS) capacitor c=4.96943e-17
C85 (\4\:n30 VSS) capacitor c=7.47582e-17
C86 (\15\:VDD VSS) capacitor c=1.06411e-17
C87 (\21\:qbint VSS) capacitor c=5.58274e-17
C88 (\18\:VDD VSS) capacitor c=3.11369e-17
C89 (\17\:CKb VSS) capacitor c=6.18117e-17
C90 (\3\:Q VSS) capacitor c=6.57105e-17
C91 (\3\:QN VSS) capacitor c=5.60056e-17
C92 (\11\:qint VSS) capacitor c=4.11335e-17
C93 (\3\:VDD VSS) capacitor c=6.75779e-17
C94 (\7\:SEb VSS) capacitor c=8.31076e-17
C95 (\8\:Ckbb VSS) capacitor c=2.12363e-17
C96 (\7\:Db VSS) capacitor c=6.85489e-17
C97 (\5\:n20 VSS) capacitor c=4.12944e-17
C98 (\7\:mout VSS) capacitor c=2.72524e-17
C99 (\8\:n30 VSS) capacitor c=3.17713e-17
C100 (\15\:qbint VSS) capacitor c=6.87022e-17
C101 (\15\:CKb VSS) capacitor c=1.20984e-16
C102 (\1\:Q VSS) capacitor c=1.57682e-17
C103 (\1\:QN VSS) capacitor c=1.84319e-17
C104 (\9\:qint VSS) capacitor c=4.9684e-17
C105 (\2\:n20 VSS) capacitor c=1.95403e-17
C106 (\8\:qint VSS) capacitor c=6.43432e-17
C107 (\17\:qbint VSS) capacitor c=7.93395e-17
C108 (\20\:qbint VSS) capacitor c=1.0094e-16
C109 (\23\:qbint VSS) capacitor c=6.16674e-17
C110 (\6\:n30 VSS) capacitor c=5.07184e-17
C111 (\7\:n30 VSS) capacitor c=8.31714e-17
C112 (\7\:RN VSS) capacitor c=1.63976e-16
C113 (\8\:RN VSS) capacitor c=4.05891e-17
C114 (\6\:mout VSS) capacitor c=5.9034e-17
C115 (\9\:mout VSS) capacitor c=6.87998e-17
C116 (\7\:n20 VSS) capacitor c=8.79092e-17
C117 (\10\:n20 VSS) capacitor c=9.77046e-17
C118 (\10\:Ckbb VSS) capacitor c=2.85133e-17
C119 (\11\:Ckbb VSS) capacitor c=6.47126e-17
C120 (\12\:Ckbb VSS) capacitor c=1.11356e-16
C121 (\13\:Ckbb VSS) capacitor c=8.37625e-17
C122 (\11\:CKb VSS) capacitor c=7.40409e-17
C123 (\12\:CKb VSS) capacitor c=2.09217e-16
C124 (\13\:CKb VSS) capacitor c=2.18615e-16
C125 (\14\:CKb VSS) capacitor c=1.50524e-16
C126 (\4\:SI VSS) capacitor c=3.89008e-17
C127 (\4\:D VSS) capacitor c=5.37892e-17
C128 (\7\:SE VSS) capacitor c=8.72676e-17
C129 (\8\:SE VSS) capacitor c=6.48903e-17
C130 (\9\:SEb VSS) capacitor c=1.08554e-16
C131 (\10\:SEb VSS) capacitor c=2.64404e-17
C132 (\11\:SEb VSS) capacitor c=1.01341e-16
C133 (\5\:VDD VSS) capacitor c=3.11171e-17
C134 (\6\:VDD VSS) capacitor c=2.9874e-17
C135 (\14\:VDD VSS) capacitor c=3.60573e-17
C136 (\17\:VDD VSS) capacitor c=1.35573e-17
C137 (\20\:VDD VSS) capacitor c=1.24458e-16
Rk19 (\7\:RN RN) resistor r=1.1013 c=0
Rk20 (RN \8\:RN) resistor r=0.1094 c=0
Rk3 (\2\:QN QN) resistor r=0.06657 c=0
Rk4 (QN \4\:QN) resistor r=0.1965 c=0
Rk49 (\2\:VSS \4\:VSS) resistor r=0.2366 c=0
Rk50 (\4\:VSS \5\:VSS) resistor r=0.248 c=0
Rk51 (\5\:VSS \6\:VSS) resistor r=0.7551 c=0
Rk52 (\6\:VSS \7\:VSS) resistor r=0.5416 c=0
Rk57 (\8\:VSS VSS) resistor r=0.1875 c=0
Rk53 (\7\:VSS \8\:VSS) resistor r=0.6012 c=0
Rk58 (\5\:VSS \13\:VSS) resistor r=0.28 c=0
Rk59 (\6\:VSS \15\:VSS) resistor r=0.07144 c=0
Rk60 (\7\:VSS \17\:VSS) resistor r=0.1288 c=0
Rk44 (\8\:SE SE) resistor r=0.005081 c=0
Rk43 (\7\:SE \8\:SE) resistor r=0.3449 c=0
Rk42 (D \4\:D) resistor r=0.2151 c=0
Rk5 (\2\:Q Q) resistor r=0.06768 c=0
Rk6 (Q \4\:Q) resistor r=0.1712 c=0
Rk64 (\2\:VDD \4\:VDD) resistor r=0.2302 c=0
Rk65 (\4\:VDD \5\:VDD) resistor r=0.2179 c=0
Rk66 (\5\:VDD \6\:VDD) resistor r=0.5887 c=0
Rk67 (\6\:VDD \7\:VDD) resistor r=0.1953 c=0
Rk68 (\5\:VDD \9\:VDD) resistor r=0.07358 c=0
Rk69 (\6\:VDD \11\:VDD) resistor r=0.1754 c=0
Rk70 (\7\:VDD \13\:VDD) resistor r=0.07144 c=0
Rk71 (\7\:VDD \14\:VDD) resistor r=0.5699 c=0
Rk72 (\14\:VDD \16\:VDD) resistor r=0.07358 c=0
Rk73 (\14\:VDD \17\:VDD) resistor r=0.2001 c=0
Rk74 (\17\:VDD \19\:VDD) resistor r=0.2466 c=0
Rk82 (\20\:VDD VDD) resistor r=0.1149 c=0
Rk75 (\17\:VDD \20\:VDD) resistor r=0.358 c=0
Rk7 (\4\:CK CK) resistor r=0.002516 c=0
Rk38 (\4\:SI SI) resistor r=0.1283 c=0
Rk9 (\17\:qbint \4\:qbint) resistor r=0.589 c=0
Rk8 (\16\:qbint \17\:qbint) resistor r=0.3283 c=0
Rk11 (\4\:qbint \20\:qbint) resistor r=0.6832 c=0
Rk12 (\17\:qbint \22\:qbint) resistor r=0.2401 c=0
Rk13 (\22\:qbint \23\:qbint) resistor r=0.3138 c=0
Rk1 (\8\:qint \10\:qint) resistor r=0.3054 c=0
Rk2 (\10\:qint \12\:qint) resistor r=0.3041 c=0
Rk33 (\11\:CKb \12\:CKb) resistor r=0.5151 c=0
Rk34 (\12\:CKb \13\:CKb) resistor r=1.1438 c=0
Rk35 (\13\:CKb \14\:CKb) resistor r=0.698 c=0
Rk36 (\14\:CKb \16\:CKb) resistor r=0.8379 c=0
Rk37 (\16\:CKb \18\:CKb) resistor r=0.3148 c=0
Rk16 (\5\:n30 \6\:n30) resistor r=0.3183 c=0
Rk17 (\6\:n30 \7\:n30) resistor r=0.4182 c=0
Rk18 (\6\:n30 \9\:n30) resistor r=0.09782 c=0
Rk21 (\5\:mout \6\:mout) resistor r=0.2475 c=0
Rk22 (\6\:mout \8\:mout) resistor r=0.09265 c=0
Rk23 (\6\:mout \9\:mout) resistor r=0.3876 c=0
Rk28 (\9\:Ckbb \10\:Ckbb) resistor r=0.1486 c=0
Rk29 (\10\:Ckbb \11\:Ckbb) resistor r=0.09296 c=0
Rk30 (\11\:Ckbb \12\:Ckbb) resistor r=0.6378 c=0
Rk31 (\12\:Ckbb \13\:Ckbb) resistor r=0.5953 c=0
Rk32 (\10\:Ckbb \15\:Ckbb) resistor r=0.2417 c=0
Rk25 (\6\:n20 \7\:n20) resistor r=0.2085 c=0
Rk26 (\7\:n20 \9\:n20) resistor r=0.265 c=0
Rk27 (\7\:n20 \10\:n20) resistor r=0.5262 c=0
Rk39 (\2\:Db \4\:Db) resistor r=0.5576 c=0
Rk40 (\4\:Db \6\:Db) resistor r=0.7767 c=0
Rk41 (\6\:Db \8\:Db) resistor r=0.3995 c=0
Rk45 (\6\:SEb \8\:SEb) resistor r=0.4707 c=0
Rk46 (\8\:SEb \9\:SEb) resistor r=0.4755 c=0
Rk47 (\9\:SEb \10\:SEb) resistor r=0.04287 c=0
Rk48 (\9\:SEb \11\:SEb) resistor r=0.5881 c=0
Rk24 (\2\:n6 \4\:n6) resistor r=0.2607 c=0
Rl30 (\4\:RN \5\:RN) resistor r=136.104 c=0
Rl31 (\5\:RN \6\:RN) resistor r=73.7687 c=0
Rl19 (\1\:RN \2\:RN) resistor r=24.2328 c=0
Rl20 (\2\:RN \3\:RN) resistor r=84.9195 c=0
Rl49 (\5\:SE \6\:SE) resistor r=87.6374 c=0
Rl48 (\4\:SE \5\:SE) resistor r=39.3036 c=0
Rl43 (\1\:SE \2\:SE) resistor r=24.2328 c=0
Rl44 (\2\:SE \3\:SE) resistor r=116.106 c=0
Rl46 (\1\:D \2\:D) resistor r=29.5379 c=0
Rl47 (\2\:D \3\:D) resistor r=96.8456 c=0
Rl16 (\2\:CK \3\:CK) resistor r=74.1758 c=0
Rl15 (\1\:CK \2\:CK) resistor r=30.7692 c=0
Rl40 (\1\:SI \2\:SI) resistor r=85.7713 c=0
Rl41 (\2\:SI \3\:SI) resistor r=37.6944 c=0
Rl21 (\13\:qbint \12\:qbint) resistor r=126.923 c=0
Rl22 (\14\:qbint \12\:qbint) resistor r=29.5379 c=0
Rl2 (\2\:qbint \3\:qbint) resistor r=31.4748 c=0
Rl1 (\2\:qbint qbint) resistor r=57.6923 c=0
Rl39 (\8\:CKb \10\:CKb) resistor r=151.923 c=0
Rl35 (\5\:CKb \6\:CKb) resistor r=102.735 c=0
Rl38 (\8\:CKb \9\:CKb) resistor r=56.461 c=0
Rl36 (\6\:CKb \7\:CKb) resistor r=44.9225 c=0
Rl24 (\3\:CKb \4\:CKb) resistor r=24.2328 c=0
Rl23 (CKb \2\:CKb) resistor r=81.9251 c=0
Rl18 (\2\:n30 \3\:n30) resistor r=64.5604 c=0
Rl17 (n30 \2\:n30) resistor r=38.4615 c=0
Rl32 (mout \2\:mout) resistor r=69.2107 c=0
Rl33 (\2\:mout \3\:mout) resistor r=29.5379 c=0
Rl25 (Ckbb \2\:Ckbb) resistor r=224.131 c=0
Rl37 (\6\:Ckbb \7\:Ckbb) resistor r=136.052 c=0
Rl34 (\4\:Ckbb \5\:Ckbb) resistor r=31.9251 c=0
Rl26 (\2\:Ckbb \3\:Ckbb) resistor r=31.9251 c=0
Rl29 (\2\:n20 \4\:n20) resistor r=34.3295 c=0
Rl28 (\2\:n20 \3\:n20) resistor r=84.3295 c=0
Rl27 (n20 \2\:n20) resistor r=0.5213 c=0
Rl45 (\3\:SEb \4\:SEb) resistor r=65.6003 c=0
Rl42 (SEb \2\:SEb) resistor r=46.8456 c=0
Rz2 (\2\:QN \1\:QN) resistor r=75 c=0
Rz13 (\2\:VSS \1\:VSS) resistor r=75 c=0
Rz14 (\13\:VSS \12\:VSS) resistor r=75 c=0
Rz15 (\15\:VSS \14\:VSS) resistor r=75 c=0
Rz16 (\17\:VSS \16\:VSS) resistor r=75 c=0
Rz3 (\2\:Q \1\:Q) resistor r=75 c=0
Rz20 (\4\:VDD \3\:VDD) resistor r=9.375 c=0
Rz21 (\7\:VDD \3\:VDD) resistor r=6.25 c=0
Rz22 (\20\:VDD \3\:VDD) resistor r=6.25 c=0
Rz4 (\16\:qbint \15\:qbint) resistor r=75 c=0
Rz1 (\10\:qint \9\:qint) resistor r=75 c=0
Rz9 (\15\:CKb \16\:CKb) resistor r=75 c=0
Rz5 (\8\:n30 \9\:n30) resistor r=75 c=0
Rz6 (\7\:mout \8\:mout) resistor r=75 c=0
Rz8 (\8\:Ckbb \9\:Ckbb) resistor r=75 c=0
Rz7 (\5\:n20 \6\:n20) resistor r=75 c=0
Rz10 (Db \2\:Db) resistor r=75 c=0
Rz11 (\7\:Db \8\:Db) resistor r=75 c=0
Rz12 (\7\:SEb \8\:SEb) resistor r=75 c=0
Ry2 (\4\:QN \3\:QN) resistor r=62 c=0
Ry15 (\4\:VSS \3\:VSS) resistor r=7.75 c=0
Ry16 (\6\:VSS \3\:VSS) resistor r=5.1667 c=0
Ry17 (\8\:VSS \3\:VSS) resistor r=5.1667 c=0
Ry3 (\4\:Q \3\:Q) resistor r=62 c=0
Ry18 (\2\:VDD \1\:VDD) resistor r=62 c=0
Ry19 (\9\:VDD \8\:VDD) resistor r=62 c=0
Ry20 (\11\:VDD \10\:VDD) resistor r=62 c=0
Ry21 (\13\:VDD \12\:VDD) resistor r=62 c=0
Ry22 (\16\:VDD \15\:VDD) resistor r=62 c=0
Ry23 (\19\:VDD \18\:VDD) resistor r=62 c=0
Ry4 (\22\:qbint \21\:qbint) resistor r=31 c=0
Ry1 (\12\:qint \11\:qint) resistor r=62 c=0
Ry11 (\17\:CKb \18\:CKb) resistor r=62 c=0
Ry5 (\4\:n30 \5\:n30) resistor r=62 c=0
Ry6 (\4\:mout \5\:mout) resistor r=62 c=0
Ry10 (\14\:Ckbb \15\:Ckbb) resistor r=62 c=0
Ry9 (\8\:n20 \9\:n20) resistor r=62 c=0
Ry12 (\3\:Db \4\:Db) resistor r=62 c=0
Ry13 (\5\:Db \6\:Db) resistor r=62 c=0
Ry14 (\5\:SEb \6\:SEb) resistor r=62 c=0
Ry7 (n6 \2\:n6) resistor r=62 c=0
Ry8 (\3\:n6 \4\:n6) resistor r=62 c=0
Rx8 (\6\:RN \7\:RN) resistor r=45 c=0
Rx9 (\2\:RN \8\:RN) resistor r=45 c=0
Rx21 (\2\:SE \7\:SE) resistor r=45 c=0
Rx22 (\5\:SE \8\:SE) resistor r=45 c=0
Rx20 (\2\:D \4\:D) resistor r=45 c=0
Rx2 (\2\:CK \4\:CK) resistor r=45 c=0
Rx19 (\2\:SI \4\:SI) resistor r=45 c=0
Rx3 (\20\:qbint \2\:qbint) resistor r=45 c=0
Rx4 (\23\:qbint \14\:qbint) resistor r=45 c=0
Rx1 (\8\:qint qint) resistor r=45 c=0
Rx15 (\9\:CKb \11\:CKb) resistor r=45 c=0
Rx16 (\7\:CKb \12\:CKb) resistor r=45 c=0
Rx17 (\4\:CKb \13\:CKb) resistor r=45 c=0
Rx18 (\2\:CKb \14\:CKb) resistor r=45 c=0
Rx7 (\2\:n30 \7\:n30) resistor r=45 c=0
Rx10 (\2\:mout \9\:mout) resistor r=45 c=0
Rx12 (\6\:Ckbb \11\:Ckbb) resistor r=45 c=0
Rx13 (\5\:Ckbb \12\:Ckbb) resistor r=45 c=0
Rx14 (\3\:Ckbb \13\:Ckbb) resistor r=45 c=0
Rx11 (n20 \10\:n20) resistor r=45 c=0
Rx23 (\4\:SEb \10\:SEb) resistor r=45 c=0
Rx24 (\2\:SEb \11\:SEb) resistor r=45 c=0
mn56 (\9\:qint qbint \8\:VSS VSS) g45n1hvt w=(1.45e-07) l=4.5e-08 nf=1 \
        as=4.8e-14 ad=2.03e-14 ps=9.6e-07 pd=5.7e-07 nrd=1.16667 \
        nrs=1.16667 sa=1.4e-07 sb=1.34293e-06 sd=160n sca=16.2011 \
        scb=0.0172667 scc=0.0012292 m=(1)
mn20 (\15\:CKb \1\:CK \8\:VSS VSS) g45n1hvt w=(1.45e-07) l=4.5e-08 nf=1 \
        as=5.2e-14 ad=4.133e-14 ps=1.04e-06 pd=8.6e-07 nrd=1.16667 \
        nrs=1.16667 sa=1.26776e-06 sb=2.85e-07 sd=160n sca=12.5912 \
        scb=0.0129007 scc=0.000589158 m=(1)
mn50 (n11 \13\:qbint \16\:VSS VSS) g45n1hvt w=(1.45e-07) l=4.5e-08 nf=1 \
        as=7.39e-14 ad=8.7e-15 ps=1.38e-06 pd=4.1e-07 nrd=1.16667 \
        nrs=1.16667 sa=5.65e-07 sb=1.825e-06 sd=160n sca=19.8813 \
        scb=0.0206549 scc=0.00197265 m=(1)
mn51 (\8\:n30 CKb n11 VSS) g45n1hvt w=(1.45e-07) l=4.5e-08 nf=1 \
        as=8.7e-15 ad=6.38e-14 ps=4.1e-07 pd=1.17e-06 nrd=1.16667 \
        nrs=1.16667 sa=6.7e-07 sb=1.72e-06 sd=160n sca=19.8813 \
        scb=0.0206549 scc=0.00197265 m=(1)
mn40 (\7\:mout \2\:Ckbb \8\:n30 VSS) g45n1hvt w=(1.45e-07) l=4.5e-08 nf=1 \
        as=6.38e-14 ad=3.335e-14 ps=1.17e-06 pd=7.5e-07 nrd=1.16667 \
        nrs=1.16667 sa=1.155e-06 sb=1.235e-06 sd=160n sca=19.8813 \
        scb=0.0206549 scc=0.00197265 m=(1)
mn30 (\7\:mout \3\:n20 \14\:VSS VSS) g45n1hvt w=(1.45e-07) l=4.5e-08 \
        nf=1 as=8.17e-14 ad=3.335e-14 ps=1.56e-06 pd=7.5e-07 nrd=1.16667 \
        nrs=1.16667 sa=1.43e-06 sb=9.6e-07 sd=160n sca=19.8813 \
        scb=0.0206549 scc=0.00197265 m=(1)
mn35 (n7 \4\:RN \14\:VSS VSS) g45n1hvt w=(1.45e-07) l=4.5e-08 nf=1 \
        as=8.17e-14 ad=8.7e-15 ps=1.56e-06 pd=4.1e-07 nrd=1.16667 \
        nrs=1.16667 sa=1.695e-06 sb=6.95e-07 sd=160n sca=19.8813 \
        scb=0.0206549 scc=0.00197265 m=(1)
mn36 (n5 \3\:mout n7 VSS) g45n1hvt w=(1.45e-07) l=4.5e-08 nf=1 as=8.7e-15 \
        ad=2.682e-14 ps=4.1e-07 pd=6.6e-07 nrd=1.16667 nrs=1.16667 \
        sa=1.8e-06 sb=5.9e-07 sd=160n sca=19.8813 scb=0.0206549 \
        scc=0.00197265 m=(1)
mn37 (\5\:n20 \4\:Ckbb n5 VSS) g45n1hvt w=(1.45e-07) l=4.5e-08 nf=1 \
        as=2.682e-14 ad=2.537e-14 ps=6.6e-07 pd=6.4e-07 nrd=1.16667 \
        nrs=1.16667 sa=2e-06 sb=3.6e-07 sd=160n sca=19.8813 scb=0.0206549 \
        scc=0.00197265 m=(1)
mn25 (\7\:Db \5\:CKb \5\:n20 VSS) g45n1hvt w=(1.45e-07) l=4.5e-08 nf=1 \
        as=2.537e-14 ad=2.03e-14 ps=6.4e-07 pd=5.7e-07 nrd=1.16667 \
        nrs=1.16667 sa=2e-06 sb=1.4e-07 sd=160n sca=19.8813 scb=0.0206549 \
        scc=0.00197265 m=(1)
mn21 (\8\:Ckbb \10\:CKb \12\:VSS VSS) g45n1hvt w=(1.45e-07) l=4.5e-08 \
        nf=1 as=2.392e-14 ad=2.03e-14 ps=6.2e-07 pd=5.7e-07 nrd=1.16667 \
        nrs=1.16667 sa=1.4e-07 sb=1.25e-06 sd=160n sca=10.4914 \
        scb=0.00978575 scc=0.000300434 m=(1)
mn13 (n3 \3\:SI \12\:VSS VSS) g45n1hvt w=(1.45e-07) l=4.5e-08 nf=1 \
        as=2.392e-14 ad=4.06e-14 ps=6.2e-07 pd=8.5e-07 nrd=1.16667 \
        nrs=1.16667 sa=3.5e-07 sb=1.04e-06 sd=160n sca=10.4914 \
        scb=0.00978575 scc=0.000300434 m=(1)
mn14 (Db \3\:SE n3 VSS) g45n1hvt w=(1.45e-07) l=4.5e-08 nf=1 as=4.06e-14 \
        ad=2.32e-14 ps=8.5e-07 pd=6.1e-07 nrd=1.16667 nrs=1.16667 \
        sa=6.75e-07 sb=7.15e-07 sd=160n sca=10.4914 scb=0.00978575 \
        scc=0.000300434 m=(1)
mn12 (Db \3\:SEb n1 VSS) g45n1hvt w=(1.45e-07) l=4.5e-08 nf=1 as=8.7e-15 \
        ad=2.32e-14 ps=4.1e-07 pd=6.1e-07 nrd=1.16667 nrs=1.16667 \
        sa=8.8e-07 sb=5.1e-07 sd=160n sca=10.4914 scb=0.00978575 \
        scc=0.000300434 m=(1)
mn11 (n1 \3\:D \1\:VSS VSS) g45n1hvt w=(1.45e-07) l=4.5e-08 nf=1 \
        as=6.79e-14 ad=8.7e-15 ps=1.33e-06 pd=4.1e-07 nrd=1.16667 \
        nrs=1.16667 sa=9.85e-07 sb=4.05e-07 sd=160n sca=10.4914 \
        scb=0.00978575 scc=0.000300434 m=(1)
mn10 (\7\:SEb \4\:SE \1\:VSS VSS) g45n1hvt w=(1.45e-07) l=4.5e-08 nf=1 \
        as=6.79e-14 ad=2.03e-14 ps=1.33e-06 pd=5.7e-07 nrd=1.16667 \
        nrs=1.16667 sa=1.25e-06 sb=1.4e-07 sd=160n sca=10.4914 \
        scb=0.00978575 scc=0.000300434 m=(1)
mn57 (\1\:QN qint \8\:VSS VSS) g45n1hvt w=(2.6e-07) l=4.5e-08 nf=1 \
        as=4.48e-14 ad=4.16e-14 ps=9e-07 pd=8.4e-07 nrd=1.16667 \
        nrs=1.16667 sa=2.87788e-07 sb=1.02404e-06 sd=160n sca=12.8392 \
        scb=0.0126987 scc=0.00074151 m=(2)
mn55_1__rcx (\1\:Q \4\:qbint \8\:VSS VSS) g45n1hvt w=(2.6e-07) l=4.5e-08 \
        nf=1 as=4.68e-14 ad=4.81e-14 ps=9.4e-07 pd=8.9e-07 nrd=1.16667 \
        nrs=1.16667 sa=6.97788e-07 sb=6.14038e-07 sd=160n sca=12.8392 \
        scb=0.0126987 scc=0.00074151 m=(2)
mn46 (\15\:qbint n30 n9 VSS) g45n1hvt w=(2.05e-07) l=4.5e-08 nf=1 \
        as=1.23e-14 ad=3.998e-14 ps=5.3e-07 pd=8e-07 nrd=1.16667 \
        nrs=1.16667 sa=1.95e-07 sb=1.49512e-06 sd=160n sca=17.1738 \
        scb=0.0176382 scc=0.00148475 m=(1)
mn45 (n9 \3\:RN \16\:VSS VSS) g45n1hvt w=(2.05e-07) l=4.5e-08 nf=1 \
        as=7.39e-14 ad=1.23e-14 ps=1.38e-06 pd=5.3e-07 nrd=1.16667 \
        nrs=1.16667 sa=3e-07 sb=1.46439e-06 sd=160n sca=17.1738 \
        scb=0.0176382 scc=0.00148475 m=(1)
mp57_1__rcx (\3\:QN qint \20\:VDD VDD) g45p1hvt w=(3.9e-07) l=4.5e-08 \
        nf=1 as=8.742e-14 ad=7.215e-14 ps=1.32e-06 pd=1.15e-06 nrd=1.16667 \
        nrs=1.16667 sa=2.99551e-07 sb=1.02833e-06 sd=160n sca=32.8253 \
        scb=0.0223774 scc=0.00336999 m=(2)
mp55_1__rcx (\3\:Q \4\:qbint \20\:VDD VDD) g45p1hvt w=(3.9e-07) \
        l=4.5e-08 nf=1 as=8.376e-14 ad=7.215e-14 ps=1.44e-06 pd=1.15e-06 \
        nrd=1.16667 nrs=1.16667 sa=7.94551e-07 sb=5.33333e-07 sd=160n \
        sca=30.5009 scb=0.0202006 scc=0.00336097 m=(2)
mp46 (\21\:qbint \3\:n30 \18\:VDD VDD) g45p1hvt w=(3.1e-07) l=4.5e-08 \
        nf=1 as=4.39e-14 ad=4.96e-14 ps=1.14e-06 pd=9.4e-07 nrd=1.16667 \
        nrs=1.16667 sa=1.06774e-07 sb=1.38347e-06 sd=160n sca=18.5208 \
        scb=0.0170531 scc=0.00159934 m=(1)
mp45 (\21\:qbint \1\:RN \15\:VDD VDD) g45p1hvt w=(3.1e-07) l=4.5e-08 \
        nf=1 as=7.303e-14 ad=4.96e-14 ps=1.81e-06 pd=9.4e-07 nrd=1.16667 \
        nrs=1.16667 sa=3.11774e-07 sb=1.17847e-06 sd=160n sca=18.5208 \
        scb=0.0170531 scc=0.00159934 m=(1)
ends SDFFRX2
// End of subcircuit definition.
