// Generated for: spectre (May  1 09:19:00 2013 )
// Library name: gsclib045_hvt
// Cell name: OAI222XL
// View name: extracted

simulator lang=spectre

subckt OAI222XL A0 A1 B0 B1 C0 C1 VDD VSS Y
mp0 (n2 \1\:A0 \6\:VDD VDD) g45p1hvt w=(2.15e-07) l=4.5e-08 nf=1 \
        as=3.01e-14 ad=1.29e-14 ps=7.1e-07 pd=5.5e-07 nrd=1.16667 \
        nrs=1.16667 sa=1.4e-07 sb=1.15e-06 sd=160n sca=18.9152 \
        scb=0.020298 scc=0.000602167 m=(1)
mp1 (\5\:Y \1\:A1 n2 VDD) g45p1hvt w=(2.15e-07) l=4.5e-08 nf=1 \
        as=1.29e-14 ad=6.88e-14 ps=5.5e-07 pd=1.07e-06 nrd=1.16667 \
        nrs=1.16667 sa=2.45e-07 sb=1.045e-06 sd=160n sca=14.7404 \
        scb=0.0134098 scc=0.000165408 m=(1)
mp3 (\5\:Y \1\:B1 n3 VDD) g45p1hvt w=(2.15e-07) l=4.5e-08 nf=1 \
        as=2.903e-14 ad=6.88e-14 ps=7e-07 pd=1.07e-06 nrd=1.16667 \
        nrs=1.16667 sa=6.1e-07 sb=6.8e-07 sd=160n sca=11.0531 \
        scb=0.00777426 scc=8.06272e-05 m=(1)
mp2 (n3 \3\:B0 \1\:VDD VDD) g45p1hvt w=(2.15e-07) l=4.5e-08 nf=1 \
        as=4.515e-14 ad=2.903e-14 ps=8.5e-07 pd=7e-07 nrd=1.16667 \
        nrs=1.16667 sa=7.9e-07 sb=5e-07 sd=160n sca=11.1457 scb=0.00788341 \
        scc=8.07632e-05 m=(1)
mp4 (n4 \1\:C0 \1\:VDD VDD) g45p1hvt w=(2.15e-07) l=4.5e-08 nf=1 \
        as=4.515e-14 ad=1.29e-14 ps=8.5e-07 pd=5.5e-07 nrd=1.16667 \
        nrs=1.16667 sa=1.045e-06 sb=2.45e-07 sd=160n sca=13.3848 \
        scb=0.0110305 scc=0.000107196 m=(1)
mp5 (\3\:Y \3\:C1 n4 VDD) g45p1hvt w=(2.15e-07) l=4.5e-08 nf=1 \
        as=1.29e-14 ad=3.01e-14 ps=5.5e-07 pd=7.1e-07 nrd=1.16667 \
        nrs=1.16667 sa=1.15e-06 sb=1.4e-07 sd=160n sca=15.9357 \
        scb=0.0155108 scc=0.000251633 m=(1)
C1 (B0 VSS) capacitor c=8.60203e-17
C2 (A0 VSS) capacitor c=1.67728e-17
C3 (C1 VSS) capacitor c=4.01412e-17
C4 (VDD VSS) capacitor c=1.70879e-16
C5 (C0 VSS) capacitor c=5.01366e-17
C6 (Y VSS) capacitor c=7.07251e-17
C7 (n1 VSS) capacitor c=9.7052e-17
C8 (n0 VSS) capacitor c=9.58396e-17
C9 (n3 VSS) capacitor c=3.04162e-18
C10 (n4 VSS) capacitor c=1.35183e-18
C11 (\3\:C1 VSS) capacitor c=7.01833e-17
C12 (\1\:C0 VSS) capacitor c=7.58691e-17
C13 (\3\:B0 VSS) capacitor c=5.252e-17
C14 (\1\:B1 VSS) capacitor c=3.78216e-17
C15 (\1\:A1 VSS) capacitor c=6.98184e-17
C16 (\1\:A0 VSS) capacitor c=5.03375e-17
C17 (\1\:C1 VSS) capacitor c=3.18284e-17
C18 (\3\:C0 VSS) capacitor c=3.72922e-17
C19 (\1\:B0 VSS) capacitor c=3.7119e-17
C20 (\3\:B1 VSS) capacitor c=4.52182e-17
C21 (\3\:A1 VSS) capacitor c=3.7131e-17
C22 (\3\:A0 VSS) capacitor c=4.87738e-17
C23 (\2\:C1 VSS) capacitor c=6.611e-17
C24 (\2\:C0 VSS) capacitor c=7.19886e-17
C25 (\2\:B0 VSS) capacitor c=5.9995e-17
C26 (\2\:B1 VSS) capacitor c=5.16822e-17
C27 (\2\:A1 VSS) capacitor c=4.49243e-17
C28 (\2\:A0 VSS) capacitor c=5.58901e-17
C29 (\3\:Y VSS) capacitor c=7.40153e-17
C30 (\1\:VDD VSS) capacitor c=3.81683e-17
C31 (\5\:Y VSS) capacitor c=1.03603e-16
C32 (\6\:VDD VSS) capacitor c=1.94932e-17
C33 (\5\:n0 VSS) capacitor c=7.00565e-17
C34 (\1\:Y VSS) capacitor c=1.05355e-16
C35 (\3\:n0 VSS) capacitor c=1.13961e-16
C36 (\3\:n1 VSS) capacitor c=5.99285e-17
C37 (\4\:A0 VSS) capacitor c=2.23006e-17
C38 (\5\:A1 VSS) capacitor c=1.3255e-17
C39 (\6\:A1 VSS) capacitor c=3.70873e-17
C40 (\4\:B1 VSS) capacitor c=8.22906e-17
C41 (\6\:B1 VSS) capacitor c=4.10427e-17
C42 (\4\:B0 VSS) capacitor c=4.44809e-17
C43 (\4\:C0 VSS) capacitor c=7.06709e-17
C44 (\4\:C1 VSS) capacitor c=7.43714e-17
C45 (\4\:VDD VSS) capacitor c=4.12883e-17
C46 (\5\:VDD VSS) capacitor c=1.19242e-17
Rk9 (\4\:B0 B0) resistor r=0.01901 c=0
Rk1 (A0 \4\:A0) resistor r=0.03137 c=0
Rk11 (C1 \4\:C1) resistor r=0.1316 c=0
Rk17 (\2\:VDD \4\:VDD) resistor r=0.2672 c=0
Rk19 (\5\:VDD VDD) resistor r=0.02964 c=0
Rk18 (\4\:VDD \5\:VDD) resistor r=0.3208 c=0
Rk20 (\5\:VDD \7\:VDD) resistor r=0.224 c=0
Rk23 (\4\:VSS VSS) resistor r=0.0151 c=0
Rk22 (\3\:VSS \4\:VSS) resistor r=0.1852 c=0
Rk24 (\3\:VSS \6\:VSS) resistor r=0.07381 c=0
Rk25 (\4\:VSS \8\:VSS) resistor r=0.07381 c=0
Rk5 (\4\:B1 \5\:B1) resistor r=0.002784 c=0
Rk6 (B1 \6\:B1) resistor r=0.002691 c=0
Rk7 (\4\:B1 \6\:B1) resistor r=0.02706 c=0
Rk10 (C0 \4\:C0) resistor r=0.1479 c=0
Rk2 (\4\:A1 \5\:A1) resistor r=0.004738 c=0
Rk3 (\6\:A1 A1) resistor r=0.004738 c=0
Rk4 (\5\:A1 \6\:A1) resistor r=0.03868 c=0
Rk12 (\2\:Y Y) resistor r=0.6481 c=0
Rk13 (Y \4\:Y) resistor r=0.04934 c=0
Rk14 (\4\:Y \6\:Y) resistor r=0.5229 c=0
Rk8 (\2\:n1 \4\:n1) resistor r=0.6051 c=0
Rk15 (\2\:n0 \4\:n0) resistor r=0.4682 c=0
Rk16 (\4\:n0 \6\:n0) resistor r=0.4818 c=0
Rl8 (\2\:B0 \3\:B0) resistor r=129.538 c=0
Rl7 (\1\:B0 \2\:B0) resistor r=74.9799 c=0
Rl1 (\1\:A0 \2\:A0) resistor r=42.2849 c=0
Rl2 (\2\:A0 \3\:A0) resistor r=163.257 c=0
Rl12 (\2\:C1 \3\:C1) resistor r=136.146 c=0
Rl11 (\1\:C1 \2\:C1) resistor r=78.8462 c=0
Rl5 (\1\:B1 \2\:B1) resistor r=59.6085 c=0
Rl6 (\2\:B1 \3\:B1) resistor r=142.301 c=0
Rl9 (\1\:C0 \2\:C0) resistor r=133.79 c=0
Rl10 (\2\:C0 \3\:C0) resistor r=66.4826 c=0
Rl3 (\1\:A1 \2\:A1) resistor r=127.615 c=0
Rl4 (\2\:A1 \3\:A1) resistor r=79.5379 c=0
Rz8 (\5\:VSS \6\:VSS) resistor r=75 c=0
Rz9 (\7\:VSS \8\:VSS) resistor r=75 c=0
Rz3 (\1\:Y \2\:Y) resistor r=75 c=0
Rz1 (n1 \2\:n1) resistor r=75 c=0
Rz2 (\3\:n1 \4\:n1) resistor r=75 c=0
Rz4 (n0 \2\:n0) resistor r=75 c=0
Rz5 (\3\:n0 \4\:n0) resistor r=75 c=0
Rz6 (\5\:n0 \6\:n0) resistor r=75 c=0
Ry3 (\1\:VDD \2\:VDD) resistor r=62 c=0
Ry4 (\6\:VDD \7\:VDD) resistor r=62 c=0
Ry1 (\3\:Y \4\:Y) resistor r=62 c=0
Ry2 (\5\:Y \6\:Y) resistor r=62 c=0
Rx4 (\2\:B0 \4\:B0) resistor r=45 c=0
Rx1 (\2\:A0 \4\:A0) resistor r=45 c=0
Rx6 (\2\:C1 \4\:C1) resistor r=45 c=0
Rx3 (\2\:B1 \5\:B1) resistor r=45 c=0
Rx5 (\2\:C0 \4\:C0) resistor r=45 c=0
Rx2 (\2\:A1 \4\:A1) resistor r=45 c=0
mn0 (\3\:n1 \3\:A0 \7\:VSS VSS) g45n1hvt w=(1.45e-07) l=4.5e-08 nf=1 \
        as=4.37e-14 ad=2.32e-14 ps=1.41e-06 pd=6.1e-07 nrd=1.16667 \
        nrs=1.16667 sa=1e-07 sb=3.05e-07 sd=160n sca=13.9854 scb=0.014728 \
        scc=0.000819645 m=(1)
mn1 (\3\:n1 \3\:A1 \5\:VSS VSS) g45n1hvt w=(1.45e-07) l=4.5e-08 nf=1 \
        as=4.09e-14 ad=2.32e-14 ps=1.35e-06 pd=6.1e-07 nrd=1.16667 \
        nrs=1.16667 sa=3.05e-07 sb=1e-07 sd=160n sca=13.9854 scb=0.014728 \
        scc=0.000819645 m=(1)
mn3 (n0 \3\:B1 n1 VSS) g45n1hvt w=(1.45e-07) l=4.5e-08 nf=1 as=2.32e-14 \
        ad=2.03e-14 ps=6.1e-07 pd=5.7e-07 nrd=1.16667 nrs=1.16667 \
        sa=1.4e-07 sb=7.85e-07 sd=160n sca=13.9854 scb=0.014728 \
        scc=0.000819645 m=(1)
mn2 (\3\:n0 \1\:B0 n1 VSS) g45n1hvt w=(1.45e-07) l=4.5e-08 nf=1 \
        as=2.32e-14 ad=2.682e-14 ps=6.1e-07 pd=6.6e-07 nrd=1.16667 \
        nrs=1.16667 sa=3.45e-07 sb=5.8e-07 sd=160n sca=13.9854 \
        scb=0.014728 scc=0.000819645 m=(1)
mn4 (\1\:Y \3\:C0 \3\:n0 VSS) g45n1hvt w=(1.45e-07) l=4.5e-08 nf=1 \
        as=2.682e-14 ad=2.392e-14 ps=6.6e-07 pd=6.2e-07 nrd=1.16667 \
        nrs=1.16667 sa=5.75e-07 sb=3.5e-07 sd=160n sca=13.9854 \
        scb=0.014728 scc=0.000819645 m=(1)
mn5 (\1\:Y \1\:C1 \5\:n0 VSS) g45n1hvt w=(1.45e-07) l=4.5e-08 nf=1 \
        as=2.03e-14 ad=2.392e-14 ps=5.7e-07 pd=6.2e-07 nrd=1.16667 \
        nrs=1.16667 sa=7.85e-07 sb=1.4e-07 sd=160n sca=13.9854 \
        scb=0.014728 scc=0.000819645 m=(1)
ends OAI222XL
// End of subcircuit definition.
