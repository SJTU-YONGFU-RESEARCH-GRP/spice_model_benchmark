// Generated for: spectre (May  1 09:12:22 2013 )
// Library name: gsclib045_hvt
// Cell name: AND4X8
// View name: extracted

simulator lang=spectre

subckt AND4X8 A B C D VDD VSS Y
mp3 (\29\:net116 \3\:D \22\:VDD VDD) g45p1hvt w=(3.9e-07) l=4.5e-08 nf=1 \
        as=1.128e-13 ad=6.24e-14 ps=1.67e-06 pd=1.1e-06 nrd=1.16667 \
        nrs=1.16667 sa=8.15e-07 sb=1.86308e-06 sd=160n sca=13.679 \
        scb=0.0122069 scc=0.000647515 m=(2)
mp0_1__rcx (\29\:net116 A VDD VDD) g45p1hvt w=(3.9e-07) l=4.5e-08 nf=1 \
        as=9.29e-14 ad=6.24e-14 ps=1.51e-06 pd=1.1e-06 nrd=1.16667 \
        nrs=1.16667 sa=1.4e-07 sb=1.96692e-06 sd=160n sca=24.3679 \
        scb=0.0278844 scc=0.00150868 m=(2)
mp1 (\29\:net116 \1\:B VDD VDD) g45p1hvt w=(3.9e-07) l=4.5e-08 nf=1 \
        as=1.128e-13 ad=6.24e-14 ps=1.67e-06 pd=1.1e-06 nrd=1.16667 \
        nrs=1.16667 sa=3.45e-07 sb=1.93538e-06 sd=160n sca=16.6587 \
        scb=0.0156 scc=0.000671901 m=(2)
mp2 (\29\:net116 \1\:C VDD VDD) g45p1hvt w=(3.9e-07) l=4.5e-08 nf=1 \
        as=1.128e-13 ad=6.24e-14 ps=1.67e-06 pd=1.1e-06 nrd=1.16667 \
        nrs=1.16667 sa=6.1e-07 sb=1.89462e-06 sd=160n sca=14.3316 \
        scb=0.0125202 scc=0.000647698 m=(2)
C1 (Y VSS) capacitor c=1.28916e-17
C2 (B VSS) capacitor c=1.61757e-16
C3 (VDD VSS) capacitor c=6.39828e-16
C4 (C VSS) capacitor c=1.04295e-16
C5 (D VSS) capacitor c=2.88839e-17
C6 (A VSS) capacitor c=6.61334e-16
C7 (11 VSS) capacitor c=9.7715e-18
C8 (net116 VSS) capacitor c=4.85666e-16
C9 (12 VSS) capacitor c=1.35399e-18
C10 (13 VSS) capacitor c=8.8418e-18
C11 (14 VSS) capacitor c=2.0734e-18
C12 (\1\:C VSS) capacitor c=3.14201e-16
C13 (\1\:B VSS) capacitor c=4.01378e-16
C14 (\6\:A VSS) capacitor c=8.11276e-17
C15 (\6\:B VSS) capacitor c=6.84492e-17
C16 (\6\:C VSS) capacitor c=5.58909e-17
C17 (\1\:D VSS) capacitor c=6.50461e-17
C18 (\5\:D VSS) capacitor c=1.7781e-17
C19 (\3\:C VSS) capacitor c=3.89744e-17
C20 (\3\:B VSS) capacitor c=6.30635e-17
C21 (\1\:A VSS) capacitor c=5.96963e-17
C22 (\2\:D VSS) capacitor c=2.67366e-17
C23 (\1\:Y VSS) capacitor c=3.39951e-16
C24 (\29\:net116 VSS) capacitor c=3.7438e-16
C25 (\22\:VDD VSS) capacitor c=2.81093e-17
C26 (\37\:net116 VSS) capacitor c=9.16768e-17
C27 (\3\:D VSS) capacitor c=1.18109e-16
C28 (\7\:D VSS) capacitor c=7.08044e-17
C29 (\28\:net116 VSS) capacitor c=1.32566e-16
C30 (\4\:Y VSS) capacitor c=2.15805e-16
Rk17 (\1\:Y Y) resistor r=0.05089 c=0
Rk18 (Y \4\:Y) resistor r=0.2039 c=0
Rk5 (\1\:B B) resistor r=0.005636 c=0
Rk47 (\1\:VSS \8\:VSS) resistor r=0.3107 c=0
Rk49 (\9\:VSS VSS) resistor r=0.05721 c=0
Rk48 (\8\:VSS \9\:VSS) resistor r=0.4937 c=0
Rk53 (\9\:VSS \17\:VSS) resistor r=0.2036 c=0
Rk41 (VDD \23\:VDD) resistor r=0.1024 c=0
Rk2 (C \1\:C) resistor r=0.03168 c=0
Rk1 (\7\:D D) resistor r=0.145 c=0
Rk10 (net116 \28\:net116) resistor r=0.2198 c=0
Rk11 (\28\:net116 \29\:net116) resistor r=0.5551 c=0
Rk15 (\28\:net116 \38\:net116) resistor r=0.7024 c=0
Rl15 (\1\:B \6\:B) resistor r=96.8456 c=0
Rl4 (\1\:B \3\:B) resistor r=110.713 c=0
Rl13 (\1\:C \6\:C) resistor r=45.3297 c=0
Rl6 (\1\:C \3\:C) resistor r=102.615 c=0
Rl7 (\2\:D \1\:D) resistor r=105.323 c=0
Rl10 (\2\:D \5\:D) resistor r=31.9251 c=0
Rl8 (\3\:D \2\:D) resistor r=79.6836 c=0
Rl17 (A \6\:A) resistor r=115.18 c=0
Rl1 (A \1\:A) resistor r=116.483 c=0
Rz12 (\17\:VSS \16\:VSS) resistor r=75 c=0
Rz1 (\38\:net116 \37\:net116) resistor r=75 c=0
Ry17 (\1\:VSS \3\:VSS) resistor r=10.3333 c=0
Ry18 (\8\:VSS \3\:VSS) resistor r=5.1667 c=0
Ry15 (\23\:VDD \22\:VDD) resistor r=62 c=0
Rx1 (\7\:D \2\:D) resistor r=45 c=0
mn0_1__rcx (9 \1\:A \16\:VSS VSS) g45n1hvt w=(2.6e-07) l=4.5e-08 nf=1 \
        as=3.64e-14 ad=1.95e-14 ps=8e-07 pd=6.7e-07 nrd=1.16667 \
        nrs=1.16667 sa=1.4e-07 sb=2e-06 sd=160n sca=9.14564 scb=0.00759168 \
        scc=0.000213449 m=(1)
mn1_1__rcx (10 \3\:B 9 VSS) g45n1hvt w=(2.6e-07) l=4.5e-08 nf=1 \
        as=1.95e-14 ad=5.72e-14 ps=6.7e-07 pd=9.6e-07 nrd=1.16667 \
        nrs=1.16667 sa=2.6e-07 sb=2e-06 sd=160n sca=9.14564 scb=0.00759168 \
        scc=0.000213449 m=(1)
mn2_1__rcx (10 \3\:C 11 VSS) g45n1hvt w=(2.6e-07) l=4.5e-08 nf=1 \
        as=6.89e-14 ad=5.72e-14 ps=1.05e-06 pd=9.6e-07 nrd=1.16667 \
        nrs=1.16667 sa=5.25e-07 sb=2e-06 sd=160n sca=9.14564 \
        scb=0.00759168 scc=0.000213449 m=(1)
mn3_1__rcx (\37\:net116 \5\:D 11 VSS) g45n1hvt w=(2.6e-07) l=4.5e-08 nf=1 \
        as=6.89e-14 ad=4.16e-14 ps=1.05e-06 pd=8.4e-07 nrd=1.16667 \
        nrs=1.16667 sa=8.35e-07 sb=2e-06 sd=160n sca=9.14564 \
        scb=0.00759168 scc=0.000213449 m=(1)
mn3 (\37\:net116 \1\:D 12 VSS) g45n1hvt w=(2.6e-07) l=4.5e-08 nf=1 \
        as=1.56e-14 ad=4.16e-14 ps=6.4e-07 pd=8.4e-07 nrd=1.16667 \
        nrs=1.16667 sa=1.04e-06 sb=2e-06 sd=160n sca=9.14564 \
        scb=0.00759168 scc=0.000213449 m=(1)
mn2 (12 \6\:C 13 VSS) g45n1hvt w=(2.6e-07) l=4.5e-08 nf=1 as=7.15e-14 \
        ad=1.56e-14 ps=1.07e-06 pd=6.4e-07 nrd=1.16667 nrs=1.16667 \
        sa=1.145e-06 sb=2e-06 sd=160n sca=9.14564 scb=0.00759168 \
        scc=0.000213449 m=(1)
mn1 (14 \6\:B 13 VSS) g45n1hvt w=(2.6e-07) l=4.5e-08 nf=1 as=7.15e-14 \
        ad=1.56e-14 ps=1.07e-06 pd=6.4e-07 nrd=1.16667 nrs=1.16667 \
        sa=1.465e-06 sb=1.75e-06 sd=160n sca=9.14564 scb=0.00759168 \
        scc=0.000213449 m=(1)
mn0 (14 \6\:A \1\:VSS VSS) g45n1hvt w=(2.6e-07) l=4.5e-08 nf=1 \
        as=6.33e-14 ad=1.56e-14 ps=1.05e-06 pd=6.4e-07 nrd=1.16667 \
        nrs=1.16667 sa=1.57e-06 sb=1.645e-06 sd=160n sca=9.14564 \
        scb=0.00759168 scc=0.000213449 m=(1)
mn4_1__rcx (\4\:Y net116 \1\:VSS VSS) g45n1hvt w=(2.95e-07) l=4.5e-08 \
        nf=1 as=4.95e-14 ad=4.636e-14 ps=9.3e-07 pd=9.0429e-07 nrd=1.16667 \
        nrs=1.16667 sa=1.63797e-06 sb=1.37e-06 sd=160n sca=10.0255 \
        scb=0.00888998 scc=0.000340749 m=(7)
mp4_1__rcx (\1\:Y net116 VDD VDD) g45p1hvt w=(4.45e-07) l=4.5e-08 nf=1 \
        as=7.977e-14 ad=6.993e-14 ps=1.31714e-06 pd=1.20429e-06 \
        nrd=1.16667 nrs=1.16667 sa=1.50899e-06 sb=1.37e-06 sd=160n \
        sca=27.9404 scb=0.0185207 scc=0.00295096 m=(7)
ends AND4X8
// End of subcircuit definition.
