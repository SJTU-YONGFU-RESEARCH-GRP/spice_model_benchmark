// Generated for: spectre (May  1 09:20:20 2013 )
// Library name: gsclib045_hvt
// Cell name: XNOR2X1
// View name: extracted

simulator lang=spectre

subckt XNOR2X1 A B VDD VSS Y
mp5 (\1\:Y n0 \6\:VDD VDD) g45p1hvt w=(3.9e-07) l=4.5e-08 nf=1 \
        as=7.677e-14 ad=5.46e-14 ps=1.84e-06 pd=1.06e-06 nrd=1.16667 \
        nrs=1.16667 sa=1.4e-07 sb=6.25e-07 sd=160n sca=33.3935 \
        scb=0.0357498 scc=0.00324908 m=(1)
C1 (A VSS) capacitor c=6.03952e-17
C2 (Y VSS) capacitor c=1.84759e-17
C3 (VDD VSS) capacitor c=1.10495e-16
C4 (n0 VSS) capacitor c=4.11935e-17
C5 (n1 VSS) capacitor c=1.08538e-16
C6 (n2 VSS) capacitor c=4.50313e-17
C7 (\4\:B VSS) capacitor c=3.8499e-17
C8 (\1\:B VSS) capacitor c=5.64065e-17
C9 (\1\:A VSS) capacitor c=4.14201e-17
C10 (\6\:B VSS) capacitor c=3.73462e-17
C11 (\2\:n1 VSS) capacitor c=6.78451e-17
C12 (\3\:n2 VSS) capacitor c=4.92351e-17
C13 (\3\:B VSS) capacitor c=5.20044e-17
C14 (\3\:A VSS) capacitor c=4.45859e-17
C15 (\3\:n0 VSS) capacitor c=4.19318e-17
C16 (\5\:B VSS) capacitor c=3.70968e-17
C17 (\3\:n1 VSS) capacitor c=3.11525e-17
C18 (\2\:B VSS) capacitor c=7.778e-17
C19 (\4\:n2 VSS) capacitor c=4.84421e-17
C20 (\2\:n2 VSS) capacitor c=2.66676e-17
C21 (\2\:A VSS) capacitor c=3.94836e-17
C22 (\2\:n0 VSS) capacitor c=2.6378e-17
C23 (\8\:n2 VSS) capacitor c=7.00741e-17
C24 (\1\:VDD VSS) capacitor c=4.47922e-17
C25 (\6\:n0 VSS) capacitor c=1.50498e-16
C26 (\4\:n1 VSS) capacitor c=9.69954e-17
C27 (\6\:VDD VSS) capacitor c=7.89395e-18
C28 (\1\:Y VSS) capacitor c=7.99782e-17
C29 (\5\:n2 VSS) capacitor c=1.99369e-17
C30 (\4\:n0 VSS) capacitor c=1.00221e-16
C31 (\6\:n1 VSS) capacitor c=1.21137e-16
C32 (\3\:Y VSS) capacitor c=4.92514e-17
C33 (\4\:A VSS) capacitor c=4.80908e-17
C34 (\8\:n0 VSS) capacitor c=1.25416e-16
C35 (\8\:n1 VSS) capacitor c=8.56778e-17
C36 (\7\:B VSS) capacitor c=3.48014e-17
C37 (\8\:B VSS) capacitor c=7.08491e-17
C38 (\7\:n2 VSS) capacitor c=4.88703e-17
C39 (\10\:n2 VSS) capacitor c=1.06438e-16
C40 (\11\:n2 VSS) capacitor c=8.19942e-17
C41 (\4\:VDD VSS) capacitor c=2.40281e-17
C42 (\5\:VDD VSS) capacitor c=7.14335e-18
Rk3 (\4\:A A) resistor r=0.1344 c=0
Rk2 (\4\:Y Y) resistor r=0.02554 c=0
Rk1 (\2\:Y \4\:Y) resistor r=0.4604 c=0
Rk14 (\2\:VSS \4\:VSS) resistor r=0.4663 c=0
Rk16 (\5\:VSS VSS) resistor r=0.1026 c=0
Rk15 (\4\:VSS \5\:VSS) resistor r=0.1983 c=0
Rk17 (\5\:VSS \7\:VSS) resistor r=0.3051 c=0
Rk18 (\2\:VDD \4\:VDD) resistor r=0.2524 c=0
Rk20 (\5\:VDD VDD) resistor r=0.07995 c=0
Rk19 (\4\:VDD \5\:VDD) resistor r=0.2209 c=0
Rk21 (\5\:VDD \7\:VDD) resistor r=0.07488 c=0
Rk8 (\7\:B B) resistor r=0.105 c=0
Rk9 (B \8\:B) resistor r=0.04993 c=0
Rk4 (\5\:n0 \7\:n0) resistor r=0.5904 c=0
Rk5 (\7\:n0 \8\:n0) resistor r=0.738 c=0
Rk6 (\5\:n1 \7\:n1) resistor r=0.4858 c=0
Rk7 (\7\:n1 \8\:n1) resistor r=0.4295 c=0
Rk10 (\6\:n2 \7\:n2) resistor r=0.1354 c=0
Rk11 (\7\:n2 \9\:n2) resistor r=0.2777 c=0
Rk12 (\9\:n2 \10\:n2) resistor r=0.6504 c=0
Rk13 (\7\:n2 \11\:n2) resistor r=0.2288 c=0
Rl3 (\1\:A \2\:A) resistor r=29.5379 c=0
Rl4 (\2\:A \3\:A) resistor r=104.538 c=0
Rl11 (\4\:B \5\:B) resistor r=24.2328 c=0
Rl12 (\5\:B \6\:B) resistor r=106.925 c=0
Rl6 (\1\:B \2\:B) resistor r=26.098 c=0
Rl7 (\2\:B \3\:B) resistor r=138.45 c=0
Rl1 (n0 \2\:n0) resistor r=26.098 c=0
Rl2 (\2\:n0 \3\:n0) resistor r=56.8672 c=0
Rl9 (n1 \2\:n1) resistor r=159.615 c=0
Rl10 (\2\:n1 \3\:n1) resistor r=66.5405 c=0
Rl8 (\3\:n2 \4\:n2) resistor r=24.2328 c=0
Rl5 (n2 \2\:n2) resistor r=52.6149 c=0
Rz1 (\3\:Y \4\:Y) resistor r=37.5 c=0
Rz5 (\1\:VSS \2\:VSS) resistor r=75 c=0
Rz6 (\6\:VSS \7\:VSS) resistor r=75 c=0
Rz2 (\4\:n0 \5\:n0) resistor r=75 c=0
Rz3 (\6\:n1 \7\:n1) resistor r=75 c=0
Rz4 (\5\:n2 \6\:n2) resistor r=75 c=0
Ry1 (\1\:Y \2\:Y) resistor r=20.6667 c=0
Ry6 (\1\:VDD \2\:VDD) resistor r=62 c=0
Ry7 (\6\:VDD \7\:VDD) resistor r=62 c=0
Ry2 (\6\:n0 \7\:n0) resistor r=62 c=0
Ry3 (\4\:n1 \5\:n1) resistor r=62 c=0
Ry4 (\8\:n2 \9\:n2) resistor r=62 c=0
Rx1 (\2\:A \4\:A) resistor r=45 c=0
Rx4 (\5\:B \7\:B) resistor r=45 c=0
Rx5 (\2\:B \8\:B) resistor r=45 c=0
Rx2 (\2\:n0 \8\:n0) resistor r=45 c=0
Rx3 (\3\:n1 \8\:n1) resistor r=45 c=0
Rx6 (\2\:n2 \10\:n2) resistor r=45 c=0
Rx7 (\4\:n2 \11\:n2) resistor r=45 c=0
mn5 (\3\:Y \3\:n0 \6\:VSS VSS) g45n1hvt w=(2.6e-07) l=4.5e-08 nf=1 \
        as=3.47e-14 ad=3.64e-14 ps=8.4e-07 pd=8e-07 nrd=1.16667 \
        nrs=1.16667 sa=1.4e-07 sb=6.40962e-07 sd=160n sca=15.8438 \
        scb=0.0158162 scc=0.00129108 m=(1)
mn0 (\6\:n1 \3\:A \6\:VSS VSS) g45n1hvt w=(1.45e-07) l=4.5e-08 nf=1 \
        as=3.47e-14 ad=2.32e-14 ps=8.4e-07 pd=6.1e-07 nrd=1.16667 \
        nrs=1.16667 sa=3.45e-07 sb=8.65e-07 sd=160n sca=10.7143 \
        scb=0.0101371 scc=0.000327098 m=(1)
mn4 (\4\:n0 \3\:B \6\:n1 VSS) g45n1hvt w=(1.45e-07) l=4.5e-08 nf=1 \
        as=2.32e-14 ad=2.392e-14 ps=6.1e-07 pd=6.2e-07 nrd=1.16667 \
        nrs=1.16667 sa=5.5e-07 sb=6.6e-07 sd=160n sca=10.7143 \
        scb=0.0101371 scc=0.000327098 m=(1)
mn3 (\4\:n0 \3\:n2 net145 VSS) g45n1hvt w=(1.45e-07) l=4.5e-08 nf=1 \
        as=8.7e-15 ad=2.393e-14 ps=4.1e-07 pd=6.2e-07 nrd=1.16667 \
        nrs=1.16667 sa=7.6e-07 sb=4.5e-07 sd=160n sca=10.7143 \
        scb=0.0101371 scc=0.000327098 m=(1)
mn2 (net145 \2\:n1 \1\:VSS VSS) g45n1hvt w=(1.45e-07) l=4.5e-08 nf=1 \
        as=2.32e-14 ad=8.7e-15 ps=6.1e-07 pd=4.1e-07 nrd=1.16667 \
        nrs=1.16667 sa=8.65e-07 sb=3.45e-07 sd=160n sca=10.7143 \
        scb=0.0101371 scc=0.000327098 m=(1)
mn1 (\5\:n2 \6\:B \1\:VSS VSS) g45n1hvt w=(1.45e-07) l=4.5e-08 nf=1 \
        as=2.32e-14 ad=2.03e-14 ps=6.1e-07 pd=5.7e-07 nrd=1.16667 \
        nrs=1.16667 sa=1.07e-06 sb=1.4e-07 sd=160n sca=10.7143 \
        scb=0.0101371 scc=0.000327098 m=(1)
mp0 (\4\:n1 \1\:A \6\:VDD VDD) g45p1hvt w=(2.15e-07) l=4.5e-08 nf=1 \
        as=7.677e-14 ad=3.44e-14 ps=1.84e-06 pd=7.5e-07 nrd=1.16667 \
        nrs=1.16667 sa=3.45e-07 sb=8.47326e-07 sd=160n sca=30.7589 \
        scb=0.0279464 scc=0.00328165 m=(1)
mp4 (\4\:n1 n2 \6\:n0 VDD) g45p1hvt w=(2.15e-07) l=4.5e-08 nf=1 \
        as=3.548e-14 ad=3.44e-14 ps=7.6e-07 pd=7.5e-07 nrd=1.16667 \
        nrs=1.16667 sa=5.5e-07 sb=6.42326e-07 sd=160n sca=28.8228 \
        scb=0.0245184 scc=0.00324094 m=(1)
mp3 (\6\:n0 \1\:B net112 VDD) g45p1hvt w=(2.15e-07) l=4.5e-08 nf=1 \
        as=1.29e-14 ad=3.548e-14 ps=5.5e-07 pd=7.6e-07 nrd=1.16667 \
        nrs=1.16667 sa=7.6e-07 sb=4.32326e-07 sd=160n sca=28.9644 \
        scb=0.0247513 scc=0.00324182 m=(1)
mp2 (net112 n1 \1\:VDD VDD) g45p1hvt w=(2.15e-07) l=4.5e-08 nf=1 \
        as=7.94e-14 ad=1.29e-14 ps=1.83e-06 pd=5.5e-07 nrd=1.16667 \
        nrs=1.16667 sa=8.65e-07 sb=3.27326e-07 sd=160n sca=29.7748 \
        scb=0.0261855 scc=0.00325287 m=(1)
mp1 (\8\:n2 \4\:B \1\:VDD VDD) g45p1hvt w=(2.15e-07) l=4.5e-08 nf=1 \
        as=7.94e-14 ad=2.63e-14 ps=1.83e-06 pd=7.1e-07 nrd=1.16667 \
        nrs=1.16667 sa=1.07e-06 sb=1.22326e-07 sd=160n sca=35.5405 \
        scb=0.0359913 scc=0.00371931 m=(1)
ends XNOR2X1
// End of subcircuit definition.
