// Generated for: spectre (May  1 09:18:49 2013 )
// Library name: gsclib045_hvt
// Cell name: OAI21X4
// View name: extracted

simulator lang=spectre

subckt OAI21X4 A0 A1 B0 VDD VSS Y
mp0_1__rcx (1 \1\:A0 \17\:VDD VDD) g45p1hvt w=(3.9e-07) l=4.5e-08 nf=1 \
        as=5.46e-14 ad=7.995e-14 ps=1.06e-06 pd=1.19e-06 nrd=1.16667 \
        nrs=1.16667 sa=1.4e-07 sb=2e-06 sd=160n sca=21.9101 scb=0.0232377 \
        scc=0.0012647 m=(1)
mp1_1__rcx (\12\:Y \5\:A1 1 VDD) g45p1hvt w=(3.9e-07) l=4.5e-08 nf=1 \
        as=7.995e-14 ad=6.24e-14 ps=1.19e-06 pd=1.1e-06 nrd=1.16667 \
        nrs=1.16667 sa=3.9e-07 sb=1.985e-06 sd=160n sca=17.1039 \
        scb=0.0151782 scc=0.00102545 m=(1)
mp1_2__rcx (\12\:Y \1\:A1 5 VDD) g45p1hvt w=(3.9e-07) l=4.5e-08 nf=1 \
        as=2.34e-14 ad=6.24e-14 ps=9e-07 pd=1.1e-06 nrd=1.16667 \
        nrs=1.16667 sa=5.95e-07 sb=1.78e-06 sd=160n sca=15.9572 \
        scb=0.0141077 scc=0.00102277 m=(1)
mp0_2__rcx (5 \7\:A0 \15\:VDD VDD) g45p1hvt w=(3.9e-07) l=4.5e-08 nf=1 \
        as=6.24e-14 ad=2.34e-14 ps=1.1e-06 pd=9e-07 nrd=1.16667 \
        nrs=1.16667 sa=7e-07 sb=1.675e-06 sd=160n sca=15.641 scb=0.0139735 \
        scc=0.00102271 m=(1)
mp0_3__rcx (6 \4\:A0 \15\:VDD VDD) g45p1hvt w=(3.9e-07) l=4.5e-08 nf=1 \
        as=6.24e-14 ad=2.34e-14 ps=1.1e-06 pd=9e-07 nrd=1.16667 \
        nrs=1.16667 sa=9.05e-07 sb=1.47e-06 sd=160n sca=15.4348 \
        scb=0.0139233 scc=0.00102271 m=(1)
mp1_3__rcx (\10\:Y \10\:A1 6 VDD) g45p1hvt w=(3.9e-07) l=4.5e-08 nf=1 \
        as=2.34e-14 ad=6.24e-14 ps=9e-07 pd=1.1e-06 nrd=1.16667 \
        nrs=1.16667 sa=1.01e-06 sb=1.365e-06 sd=160n sca=15.4348 \
        scb=0.0139233 scc=0.00102271 m=(1)
mp1 (\10\:Y \12\:A1 3 VDD) g45p1hvt w=(3.9e-07) l=4.5e-08 nf=1 \
        as=5.46e-14 ad=6.24e-14 ps=1.06e-06 pd=1.1e-06 nrd=1.16667 \
        nrs=1.16667 sa=1.215e-06 sb=1.16e-06 sd=160n sca=15.4348 \
        scb=0.0139233 scc=0.00102271 m=(1)
mp0 (3 \12\:A0 \3\:VDD VDD) g45p1hvt w=(3.9e-07) l=4.5e-08 nf=1 \
        as=6.825e-14 ad=5.46e-14 ps=1.13e-06 pd=1.06e-06 nrd=1.16667 \
        nrs=1.16667 sa=1.4e-06 sb=9.75e-07 sd=160n sca=15.4348 \
        scb=0.0139233 scc=0.00102271 m=(1)
mp2_1__rcx (\1\:Y B0 \3\:VDD VDD) g45p1hvt w=(3.9e-07) l=4.5e-08 nf=1 \
        as=6.191e-14 ad=6.24e-14 ps=1.0975e-06 pd=1.1e-06 nrd=1.16667 \
        nrs=1.16667 sa=1.62e-06 sb=7.55e-07 sd=160n sca=15.4348 \
        scb=0.0139233 scc=0.00102271 m=(4)
C1 (A0 VSS) capacitor c=4.14374e-17
C2 (A1 VSS) capacitor c=2.75138e-17
C3 (Y VSS) capacitor c=4.5075e-18
C4 (B0 VSS) capacitor c=3.36671e-16
C5 (VDD VSS) capacitor c=1.11623e-16
C6 (n0 VSS) capacitor c=4.91963e-16
C7 (5 VSS) capacitor c=1.92642e-18
C8 (6 VSS) capacitor c=1.92642e-18
C9 (3 VSS) capacitor c=5.39218e-18
C10 (\12\:A0 VSS) capacitor c=5.87066e-17
C11 (\12\:A1 VSS) capacitor c=4.45027e-17
C12 (\10\:A1 VSS) capacitor c=5.9542e-17
C13 (\4\:A0 VSS) capacitor c=7.52476e-17
C14 (\7\:A0 VSS) capacitor c=6.81789e-17
C15 (\1\:A1 VSS) capacitor c=6.41638e-17
C16 (\5\:A1 VSS) capacitor c=2.68717e-17
C17 (\1\:A0 VSS) capacitor c=4.25745e-17
C18 (\2\:A1 VSS) capacitor c=4.2778e-16
C19 (\2\:A0 VSS) capacitor c=5.50399e-16
C20 (\1\:Y VSS) capacitor c=2.12031e-16
C21 (\10\:Y VSS) capacitor c=1.07672e-16
C22 (\15\:VDD VSS) capacitor c=3.84444e-17
C23 (\12\:Y VSS) capacitor c=9.19968e-17
C24 (\17\:VDD VSS) capacitor c=3.13969e-17
C25 (\1\:VDD VSS) capacitor c=1.80747e-17
C26 (\6\:Y VSS) capacitor c=1.58743e-16
C27 (\5\:A0 VSS) capacitor c=3.38243e-17
C28 (\3\:VDD VSS) capacitor c=1.58943e-16
C29 (\7\:VDD VSS) capacitor c=1.8428e-17
C30 (\8\:VDD VSS) capacitor c=1.2584e-17
Rk3 (A0 \2\:A0) resistor r=0.1463 c=0
Rk2 (\2\:A1 A1) resistor r=0.06619 c=0
Rk41 (\3\:VSS VSS) resistor r=0.08978 c=0
Rk36 (\2\:VSS \3\:VSS) resistor r=0.5461 c=0
Rk15 (\1\:Y Y) resistor r=0.08385 c=0
Rk10 (\1\:Y \6\:Y) resistor r=0.4346 c=0
Rk12 (\1\:Y \11\:Y) resistor r=0.4446 c=0
Rk13 (\11\:Y \13\:Y) resistor r=0.4712 c=0
Rk14 (\13\:Y \14\:Y) resistor r=0.1562 c=0
Rk16 (Y \15\:Y) resistor r=0.04792 c=0
Rk17 (\11\:Y \16\:Y) resistor r=0.1562 c=0
Rk24 (\2\:VDD \3\:VDD) resistor r=0.04742 c=0
Rk27 (\3\:VDD \6\:VDD) resistor r=0.2354 c=0
Rk28 (\6\:VDD \7\:VDD) resistor r=0.1151 c=0
Rk30 (\8\:VDD VDD) resistor r=0.05218 c=0
Rk29 (\7\:VDD \8\:VDD) resistor r=0.3831 c=0
Rk34 (\7\:VDD \16\:VDD) resistor r=0.2429 c=0
Rk35 (\8\:VDD \18\:VDD) resistor r=0.3326 c=0
Rl19 (\2\:A0 \12\:A0) resistor r=91.7582 c=0
Rl1 (\2\:A0 \1\:A0) resistor r=99.2328 c=0
Rl8 (\5\:A0 \4\:A0) resistor r=128.331 c=0
Rl10 (\5\:A0 \7\:A0) resistor r=84.1794 c=0
Rl9 (\5\:A0 \2\:A0) resistor r=6.3032 c=0
Rl17 (\2\:A1 \12\:A1) resistor r=82.6695 c=0
Rl15 (\2\:A1 \10\:A1) resistor r=30.5643 c=0
Rl3 (\2\:A1 \1\:A1) resistor r=65.924 c=0
Rl6 (\2\:A1 \5\:A1) resistor r=49.6216 c=0
Rz10 (\2\:VDD \1\:VDD) resistor r=37.5 c=0
Rz11 (\6\:VDD \1\:VDD) resistor r=6.25 c=0
Ry14 (\2\:VSS \1\:VSS) resistor r=31 c=0
Ry15 (\3\:VSS \1\:VSS) resistor r=5.1667 c=0
Ry4 (\11\:Y \10\:Y) resistor r=62 c=0
Ry5 (\13\:Y \12\:Y) resistor r=62 c=0
Ry6 (\14\:Y \12\:Y) resistor r=62 c=0
Ry7 (\15\:Y \1\:Y) resistor r=62 c=0
Ry8 (\16\:Y \10\:Y) resistor r=62 c=0
Ry12 (\16\:VDD \15\:VDD) resistor r=62 c=0
Ry13 (\18\:VDD \17\:VDD) resistor r=20.6667 c=0
mn2_1__rcx (\6\:Y B0 n0 VSS) g45n1hvt w=(2.6e-07) l=4.5e-08 nf=1 \
        as=4.29e-14 ad=4.16e-14 ps=8.5e-07 pd=8.4e-07 nrd=1.16667 \
        nrs=1.16667 sa=1.82e-06 sb=7.55e-07 sd=160n sca=10.3222 \
        scb=0.00938145 scc=0.000353946 m=(4)
mn0_1__rcx (n0 \2\:A0 \3\:VSS VSS) g45n1hvt w=(2.6e-07) l=4.5e-08 nf=1 \
        as=4.16e-14 ad=4.29e-14 ps=8.4e-07 pd=8.5e-07 nrd=1.16667 \
        nrs=1.16667 sa=1.4e-07 sb=2e-06 sd=160n sca=10.3222 scb=0.00938145 \
        scc=0.000353946 m=(4)
mn1_1__rcx (n0 \2\:A1 \3\:VSS VSS) g45n1hvt w=(2.6e-07) l=4.5e-08 nf=1 \
        as=4.16e-14 ad=4.16e-14 ps=8.4e-07 pd=8.4e-07 nrd=1.16667 \
        nrs=1.16667 sa=3.45e-07 sb=2e-06 sd=160n sca=10.3222 \
        scb=0.00938145 scc=0.000353946 m=(4)
ends OAI21X4
// End of subcircuit definition.
