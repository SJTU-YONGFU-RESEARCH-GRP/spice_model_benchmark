// Generated for: spectre (May  1 09:16:18 2013 )
// Library name: gsclib045_hvt
// Cell name: SEDFFTRX4
// View name: extracted

simulator lang=spectre

subckt SEDFFTRX4 CK D E Q QN RN SE SI VDD VSS
mp10 (\5\:SEb \1\:SE \37\:VDD VDD) g45p1hvt w=(2.15e-07) l=4.5e-08 nf=1 \
        as=6.29e-14 ad=3.01e-14 ps=1.13e-06 pd=7.1e-07 nrd=1.16667 \
        nrs=1.16667 sa=1.4e-07 sb=1.195e-06 sd=160n sca=25.3738 \
        scb=0.0277485 scc=0.00188421 m=(1)
mp13 (net557 \1\:SI \37\:VDD VDD) g45p1hvt w=(2.15e-07) l=4.5e-08 nf=1 \
        as=6.29e-14 ad=1.29e-14 ps=1.13e-06 pd=5.5e-07 nrd=1.16667 \
        nrs=1.16667 sa=4.05e-07 sb=9.3e-07 sd=160n sca=20.6042 \
        scb=0.0198237 scc=0.00166414 m=(1)
mp14 (\4\:Dpb \3\:SEb net557 VDD) g45p1hvt w=(2.15e-07) l=4.5e-08 nf=1 \
        as=1.29e-14 ad=6.127e-14 ps=5.5e-07 pd=1e-06 nrd=1.16667 \
        nrs=1.16667 sa=5.1e-07 sb=8.25e-07 sd=160n sca=19.9561 \
        scb=0.0191767 scc=0.00166251 m=(1)
mp12 (\4\:Dpb \6\:SE net549 VDD) g45p1hvt w=(2.15e-07) l=4.5e-08 nf=1 \
        as=2.472e-14 ad=6.127e-14 ps=6.6e-07 pd=1e-06 nrd=1.16667 \
        nrs=1.16667 sa=8.4e-07 sb=4.95e-07 sd=160n sca=19.0975 \
        scb=0.0187686 scc=0.00166224 m=(1)
mp11 (net549 \2\:Dp \33\:VDD VDD) g45p1hvt w=(2.15e-07) l=4.5e-08 nf=1 \
        as=6.19e-14 ad=2.472e-14 ps=1.72e-06 pd=6.6e-07 nrd=1.16667 \
        nrs=1.16667 sa=1e-06 sb=3.35e-07 sd=160n sca=19.0975 scb=0.0187686 \
        scc=0.00166224 m=(1)
mp21 (\14\:CKbb \8\:CKb \33\:VDD VDD) g45p1hvt w=(2.15e-07) l=4.5e-08 \
        nf=1 as=6.19e-14 ad=3.01e-14 ps=1.72e-06 pd=7.1e-07 nrd=1.16667 \
        nrs=1.16667 sa=1.195e-06 sb=1.4e-07 sd=160n sca=19.0975 \
        scb=0.0187686 scc=0.00166224 m=(1)
mp25 (\7\:n20 CKbb \6\:Dpb VDD) g45p1hvt w=(2.15e-07) l=4.5e-08 nf=1 \
        as=3.01e-14 ad=3.44e-14 ps=7.1e-07 pd=7.5e-07 nrd=1.16667 \
        nrs=1.16667 sa=1.4e-07 sb=1.88279e-06 sd=160n sca=13.1637 \
        scb=0.0123476 scc=0.000501177 m=(1)
mp36 (\7\:n20 \6\:CKb net521 VDD) g45p1hvt w=(2.15e-07) l=4.5e-08 nf=1 \
        as=3.332e-14 ad=3.44e-14 ps=7.4e-07 pd=7.5e-07 nrd=1.16667 \
        nrs=1.16667 sa=3.45e-07 sb=1.75198e-06 sd=160n sca=13.1637 \
        scb=0.0123476 scc=0.000501177 m=(1)
mp35 (net521 mout \30\:VDD VDD) g45p1hvt w=(2.15e-07) l=4.5e-08 nf=1 \
        as=8.442e-14 ad=3.332e-14 ps=2e-06 pd=7.4e-07 nrd=1.16667 \
        nrs=1.16667 sa=5.45e-07 sb=1.55198e-06 sd=160n sca=13.1637 \
        scb=0.0123476 scc=0.000501177 m=(1)
mp30 (\8\:mout n20 \30\:VDD VDD) g45p1hvt w=(2.15e-07) l=4.5e-08 nf=1 \
        as=8.442e-14 ad=6.773e-14 ps=2e-06 pd=1.06e-06 nrd=1.16667 \
        nrs=1.16667 sa=7.45e-07 sb=1.35198e-06 sd=160n sca=13.1637 \
        scb=0.0123476 scc=0.000501177 m=(1)
mp40 (\12\:n30 \9\:CKb \8\:mout VDD) g45p1hvt w=(2.15e-07) l=4.5e-08 nf=1 \
        as=6.773e-14 ad=5.16e-14 ps=1.06e-06 pd=9.1e-07 nrd=1.16667 \
        nrs=1.16667 sa=1.105e-06 sb=9.91977e-07 sd=160n sca=13.1637 \
        scb=0.0123476 scc=0.000501177 m=(1)
mp51 (\12\:n30 \5\:CKbb net529 VDD) g45p1hvt w=(2.15e-07) l=4.5e-08 nf=1 \
        as=3.547e-14 ad=5.16e-14 ps=7.6e-07 pd=9.1e-07 nrd=1.16667 \
        nrs=1.16667 sa=1.39e-06 sb=7.06977e-07 sd=160n sca=13.1637 \
        scb=0.0123476 scc=0.000501177 m=(1)
mp50 (net529 qbint \23\:VDD VDD) g45p1hvt w=(2.15e-07) l=4.5e-08 nf=1 \
        as=9.015e-14 ad=3.547e-14 ps=2.09e-06 pd=7.6e-07 nrd=1.16667 \
        nrs=1.16667 sa=1.6e-06 sb=4.96977e-07 sd=160n sca=13.1637 \
        scb=0.0123476 scc=0.000501177 m=(1)
mp20 (\17\:CKb \3\:CK \4\:VDD VDD) g45p1hvt w=(2.15e-07) l=4.5e-08 nf=1 \
        as=1.1772e-13 ad=4.085e-14 ps=1.89e-06 pd=8.1e-07 nrd=1.16667 \
        nrs=1.16667 sa=1.9e-07 sb=2e-06 sd=160n sca=39.8855 scb=0.0273598 \
        scc=0.00519679 m=(1)
mp2 (\6\:RNb \3\:RN \1\:VDD VDD) g45p1hvt w=(2.15e-07) l=4.5e-08 nf=1 \
        as=9.77e-14 ad=3.01e-14 ps=1.71e-06 pd=7.1e-07 nrd=1.16667 \
        nrs=1.16667 sa=1.4e-07 sb=9.7e-07 sd=160n sca=18.4975 \
        scb=0.0182651 scc=0.0015388 m=(1)
mp3 (\3\:net493 \3\:RNb \1\:VDD VDD) g45p1hvt w=(2.15e-07) l=4.5e-08 \
        nf=1 as=9.77e-14 ad=6.773e-14 ps=1.71e-06 pd=1.06e-06 nrd=1.16667 \
        nrs=1.16667 sa=4.05e-07 sb=7.05e-07 sd=160n sca=18.4975 \
        scb=0.0182651 scc=0.0015388 m=(1)
mp5 (net505 \22\:qbint \3\:net493 VDD) g45p1hvt w=(2.15e-07) l=4.5e-08 \
        nf=1 as=6.773e-14 ad=3.44e-14 ps=1.06e-06 pd=7.5e-07 nrd=1.16667 \
        nrs=1.16667 sa=7.65e-07 sb=3.45e-07 sd=160n sca=18.4975 \
        scb=0.0182651 scc=0.0015388 m=(1)
mp4 (net505 Eb net493 VDD) g45p1hvt w=(2.15e-07) l=4.5e-08 nf=1 \
        as=3.01e-14 ad=3.44e-14 ps=7.1e-07 pd=7.5e-07 nrd=1.16667 \
        nrs=1.16667 sa=9.7e-07 sb=1.4e-07 sd=160n sca=18.4975 \
        scb=0.0182651 scc=0.0015388 m=(1)
mp6 (\10\:Dp \3\:E \3\:net505 VDD) g45p1hvt w=(2.15e-07) l=4.5e-08 nf=1 \
        as=3.44e-14 ad=3.332e-14 ps=7.5e-07 pd=7.4e-07 nrd=1.16667 \
        nrs=1.16667 sa=1.55e-07 sb=3.45e-07 sd=160n sca=13.6743 \
        scb=0.0130525 scc=0.000590384 m=(1)
mp7 (\4\:Dp \2\:Db \3\:net505 VDD) g45p1hvt w=(2.15e-07) l=4.5e-08 nf=1 \
        as=3.44e-14 ad=3.01e-14 ps=7.5e-07 pd=7.1e-07 nrd=1.16667 \
        nrs=1.16667 sa=3.6e-07 sb=1.4e-07 sd=160n sca=13.7129 \
        scb=0.0130599 scc=0.000590384 m=(1)
mp0 (\4\:Eb \4\:E \8\:VDD VDD) g45p1hvt w=(2.15e-07) l=4.5e-08 nf=1 \
        as=5.64e-14 ad=3.01e-14 ps=1.5e-06 pd=7.1e-07 nrd=1.16667 \
        nrs=1.16667 sa=1.4e-07 sb=3.55e-07 sd=160n sca=48.724 scb=0.031482 \
        scc=0.00590454 m=(1)
mp1 (\4\:Db \1\:D \8\:VDD VDD) g45p1hvt w=(2.15e-07) l=4.5e-08 nf=1 \
        as=5.64e-14 ad=3.44e-14 ps=1.5e-06 pd=7.5e-07 nrd=1.16667 \
        nrs=1.16667 sa=3.35e-07 sb=1.6e-07 sd=160n sca=55.1271 \
        scb=0.0420653 scc=0.00650135 m=(1)
C1 (D VSS) capacitor c=4.33631e-17
C2 (Q VSS) capacitor c=9.92334e-17
C3 (E VSS) capacitor c=6.10535e-17
C4 (QN VSS) capacitor c=9.45668e-17
C5 (VDD VSS) capacitor c=6.54945e-16
C6 (SE VSS) capacitor c=5.49122e-17
C7 (RN VSS) capacitor c=7.68823e-17
C8 (SEb VSS) capacitor c=5.4968e-17
C9 (net658 VSS) capacitor c=8.64555e-20
C10 (Dpb VSS) capacitor c=7.57089e-17
C11 (net650 VSS) capacitor c=2.61787e-18
C12 (Dp VSS) capacitor c=3.26403e-17
C13 (CKbb VSS) capacitor c=3.96318e-17
C14 (CKb VSS) capacitor c=2.89192e-17
C15 (n20 VSS) capacitor c=5.90503e-17
C16 (mout VSS) capacitor c=4.6819e-17
C17 (n30 VSS) capacitor c=1.21203e-16
C18 (net618 VSS) capacitor c=1.63901e-18
C19 (qbint VSS) capacitor c=4.51048e-17
C20 (net582 VSS) capacitor c=2.89586e-16
C21 (RNb VSS) capacitor c=4.48736e-17
C22 (Eb VSS) capacitor c=4.76364e-17
C23 (net638 VSS) capacitor c=1.98014e-18
C24 (Db VSS) capacitor c=2.24153e-17
C25 (net557 VSS) capacitor c=2.07571e-18
C26 (net549 VSS) capacitor c=2.62936e-18
C27 (net521 VSS) capacitor c=4.23174e-18
C28 (net529 VSS) capacitor c=5.55958e-18
C29 (net493 VSS) capacitor c=8.36506e-17
C30 (net505 VSS) capacitor c=8.02248e-17
C31 (\1\:D VSS) capacitor c=4.09225e-17
C32 (\4\:E VSS) capacitor c=4.48228e-17
C33 (\2\:Db VSS) capacitor c=5.42743e-17
C34 (\3\:E VSS) capacitor c=4.37739e-17
C35 (\22\:qbint VSS) capacitor c=4.76333e-17
C36 (\3\:RNb VSS) capacitor c=4.43197e-17
C37 (\3\:RN VSS) capacitor c=3.91543e-17
C38 (\21\:qbint VSS) capacitor c=5.64117e-17
C39 (\3\:CK VSS) capacitor c=3.98505e-17
C40 (\5\:CKbb VSS) capacitor c=7.38522e-17
C41 (\9\:CKb VSS) capacitor c=3.41954e-17
C42 (\6\:CKb VSS) capacitor c=3.59587e-17
C43 (\8\:CKb VSS) capacitor c=5.46946e-17
C44 (\2\:Dp VSS) capacitor c=6.40192e-17
C45 (\6\:SE VSS) capacitor c=5.23868e-17
C46 (\3\:SEb VSS) capacitor c=4.78551e-17
C47 (\1\:SI VSS) capacitor c=6.1375e-17
C48 (\1\:SE VSS) capacitor c=4.95933e-17
C49 (\3\:D VSS) capacitor c=2.73516e-17
C50 (\7\:E VSS) capacitor c=2.99114e-17
C51 (\3\:Db VSS) capacitor c=7.13476e-17
C52 (\1\:E VSS) capacitor c=5.35186e-17
C53 (\3\:Eb VSS) capacitor c=2.82801e-17
C54 (\23\:qbint VSS) capacitor c=5.2244e-17
C55 (\1\:RN VSS) capacitor c=4.59238e-17
C56 (\19\:qbint VSS) capacitor c=3.25857e-17
C57 (\4\:qbint VSS) capacitor c=3.4155e-16
C58 (\1\:CK VSS) capacitor c=3.06661e-17
C59 (\3\:qbint VSS) capacitor c=6.12528e-17
C60 (\11\:CKb VSS) capacitor c=5.75383e-17
C61 (\7\:CKbb VSS) capacitor c=1.87124e-17
C62 (\4\:n20 VSS) capacitor c=2.86365e-17
C63 (\3\:mout VSS) capacitor c=7.40659e-17
C64 (\3\:CKbb VSS) capacitor c=8.54535e-17
C65 (\7\:CKb VSS) capacitor c=2.7829e-17
C66 (\5\:CKb VSS) capacitor c=3.32534e-17
C67 (\3\:Dp VSS) capacitor c=6.61023e-17
C68 (\4\:SE VSS) capacitor c=6.6042e-17
C69 (\4\:SI VSS) capacitor c=6.02437e-17
C70 (\3\:SE VSS) capacitor c=2.54311e-17
C71 (\2\:D VSS) capacitor c=3.00027e-17
C72 (\6\:E VSS) capacitor c=2.43392e-17
C73 (\2\:E VSS) capacitor c=5.21729e-17
C74 (\2\:Eb VSS) capacitor c=3.66717e-17
C75 (\24\:qbint VSS) capacitor c=2.74544e-17
C76 (\2\:RNb VSS) capacitor c=5.92761e-17
C77 (\2\:RN VSS) capacitor c=4.94869e-17
C78 (\20\:qbint VSS) capacitor c=3.49438e-17
C79 (\2\:CK VSS) capacitor c=2.16789e-17
C80 (\4\:n30 VSS) capacitor c=2.59195e-17
C81 (\2\:qbint VSS) capacitor c=4.63403e-17
C82 (\12\:CKb VSS) capacitor c=5.10337e-17
C83 (\10\:CKb VSS) capacitor c=3.05245e-17
C84 (\6\:CKbb VSS) capacitor c=5.27462e-17
C85 (\3\:n20 VSS) capacitor c=2.50573e-17
C86 (\2\:mout VSS) capacitor c=7.12043e-17
C87 (\4\:CKbb VSS) capacitor c=2.11175e-17
C88 (\2\:CKbb VSS) capacitor c=4.50051e-17
C89 (\7\:SE VSS) capacitor c=4.57055e-17
C90 (\2\:SEb VSS) capacitor c=6.16773e-17
C91 (\5\:SE VSS) capacitor c=4.68411e-17
C92 (\3\:SI VSS) capacitor c=5.62601e-17
C93 (\2\:SE VSS) capacitor c=3.29922e-17
C94 (\4\:Db VSS) capacitor c=8.70201e-17
C95 (\8\:VDD VSS) capacitor c=5.20344e-17
C96 (\4\:Eb VSS) capacitor c=6.013e-17
C97 (\4\:Dp VSS) capacitor c=6.94834e-17
C98 (\3\:net505 VSS) capacitor c=8.63295e-17
C99 (\10\:Dp VSS) capacitor c=3.40127e-17
C100 (\3\:net493 VSS) capacitor c=7.53234e-17
C101 (\1\:VDD VSS) capacitor c=1.98282e-17
C102 (\6\:RNb VSS) capacitor c=5.80367e-17
C103 (\14\:net582 VSS) capacitor c=1.50911e-17
C104 (\17\:CKb VSS) capacitor c=1.12889e-16
C105 (\29\:qbint VSS) capacitor c=5.52558e-17
C106 (\12\:n30 VSS) capacitor c=7.99207e-17
C107 (\8\:mout VSS) capacitor c=4.38559e-17
C108 (\30\:VDD VSS) capacitor c=1.96266e-17
C109 (\7\:n20 VSS) capacitor c=5.52733e-17
C110 (\6\:Dpb VSS) capacitor c=3.18852e-17
C111 (\14\:CKbb VSS) capacitor c=6.43933e-17
C112 (\33\:VDD VSS) capacitor c=2.36853e-17
C113 (\4\:Dpb VSS) capacitor c=1.31508e-16
C114 (\37\:VDD VSS) capacitor c=3.92242e-17
C115 (\5\:SEb VSS) capacitor c=1.24112e-16
C116 (\5\:VDD VSS) capacitor c=1.49486e-16
C117 (\7\:Db VSS) capacitor c=4.10283e-17
C118 (\6\:Eb VSS) capacitor c=1.63062e-16
C119 (\12\:Dp VSS) capacitor c=1.00852e-16
C120 (\14\:Dp VSS) capacitor c=4.36995e-17
C121 (\8\:RNb VSS) capacitor c=2.88993e-17
C122 (\18\:net582 VSS) capacitor c=6.61175e-17
C123 (\1\:QN VSS) capacitor c=1.10772e-16
C124 (\1\:Q VSS) capacitor c=1.36813e-16
C125 (\19\:CKb VSS) capacitor c=7.54983e-17
C126 (\35\:qbint VSS) capacitor c=1.71076e-17
C127 (\10\:n30 VSS) capacitor c=2.27015e-17
C128 (\6\:mout VSS) capacitor c=5.23318e-17
C129 (\9\:n20 VSS) capacitor c=3.65027e-17
C130 (\11\:CKbb VSS) capacitor c=6.89121e-17
C131 (\8\:Dpb VSS) capacitor c=1.0508e-16
C132 (\7\:SEb VSS) capacitor c=7.00336e-17
C133 (\2\:CKb VSS) capacitor c=5.7765e-17
C134 (\3\:CKb VSS) capacitor c=4.48248e-17
C135 (\4\:CKb VSS) capacitor c=3.79459e-17
C136 (\2\:n20 VSS) capacitor c=2.70592e-17
C137 (\5\:SI VSS) capacitor c=1.43146e-16
C138 (\4\:SEb VSS) capacitor c=8.95631e-17
C139 (\8\:SE VSS) capacitor c=1.22571e-16
C140 (\9\:SE VSS) capacitor c=1.09079e-16
C141 (\11\:SE VSS) capacitor c=2.70371e-17
C142 (\3\:Dpb VSS) capacitor c=1.20812e-16
C143 (\5\:n20 VSS) capacitor c=5.42129e-17
C144 (\6\:n20 VSS) capacitor c=6.2147e-17
C145 (\4\:mout VSS) capacitor c=4.4154e-17
C146 (\5\:mout VSS) capacitor c=4.81648e-17
C147 (\8\:CKbb VSS) capacitor c=1.17402e-16
C148 (\9\:CKbb VSS) capacitor c=7.73588e-17
C149 (\10\:CKbb VSS) capacitor c=5.71706e-17
C150 (\13\:CKbb VSS) capacitor c=8.09586e-17
C151 (\8\:n30 VSS) capacitor c=8.35368e-17
C152 (\9\:n30 VSS) capacitor c=6.58251e-17
C153 (\5\:E VSS) capacitor c=2.46118e-17
C154 (\13\:CKb VSS) capacitor c=5.46164e-17
C155 (\14\:CKb VSS) capacitor c=1.66063e-16
C156 (\15\:CKb VSS) capacitor c=1.48642e-16
C157 (\16\:CKb VSS) capacitor c=1.07247e-16
C158 (\21\:CKb VSS) capacitor c=6.06522e-17
C159 (\4\:CK VSS) capacitor c=1.0588e-16
C160 (\16\:net582 VSS) capacitor c=5.4005e-17
C161 (\17\:net582 VSS) capacitor c=4.63955e-17
C162 (\4\:RN VSS) capacitor c=5.55486e-17
C163 (\4\:RNb VSS) capacitor c=3.81725e-17
C164 (\5\:RNb VSS) capacitor c=5.78956e-17
C165 (\25\:qbint VSS) capacitor c=1.1037e-16
C166 (\26\:qbint VSS) capacitor c=2.51173e-16
C167 (\27\:qbint VSS) capacitor c=2.5548e-16
C168 (\28\:qbint VSS) capacitor c=1.21747e-16
C169 (\31\:qbint VSS) capacitor c=5.70581e-17
C170 (\32\:qbint VSS) capacitor c=4.77478e-17
C171 (\6\:Dp VSS) capacitor c=5.63738e-17
C172 (\7\:Dp VSS) capacitor c=1.33596e-16
C173 (\8\:Dp VSS) capacitor c=5.83289e-16
C174 (\9\:Dp VSS) capacitor c=6.78989e-16
C175 (\8\:E VSS) capacitor c=2.59868e-17
C176 (\9\:E VSS) capacitor c=7.39845e-17
C177 (\8\:Eb VSS) capacitor c=1.80795e-16
C178 (\4\:D VSS) capacitor c=7.26533e-17
C179 (\6\:Db VSS) capacitor c=1.02793e-16
C180 (\3\:VDD VSS) capacitor c=4.09445e-17
C181 (\4\:VDD VSS) capacitor c=2.13967e-16
C182 (\23\:VDD VSS) capacitor c=5.64463e-17
C183 (\29\:VDD VSS) capacitor c=6.74532e-17
C184 (\32\:VDD VSS) capacitor c=1.87821e-17
C185 (\36\:VDD VSS) capacitor c=1.56009e-17
Rk73 (D \4\:D) resistor r=0.1712 c=0
Rk34 (\1\:Q Q) resistor r=0.3826 c=0
Rk32 (\4\:CK CK) resistor r=0.03189 c=0
Rk69 (\8\:E E) resistor r=0.0319 c=0
Rk70 (E \9\:E) resistor r=0.2494 c=0
Rk39 (\1\:QN QN) resistor r=0.3282 c=0
Rk105 (\2\:VDD \3\:VDD) resistor r=0.07405 c=0
Rk106 (\3\:VDD \4\:VDD) resistor r=0.4486 c=0
Rk108 (\3\:VDD \7\:VDD) resistor r=0.5341 c=0
Rk109 (\7\:VDD \9\:VDD) resistor r=0.6132 c=0
Rk118 (\4\:VDD \23\:VDD) resistor r=0.2896 c=0
Rk122 (\23\:VDD \29\:VDD) resistor r=0.7357 c=0
Rk123 (\29\:VDD \31\:VDD) resistor r=0.07405 c=0
Rk124 (\29\:VDD \32\:VDD) resistor r=0.415 c=0
Rk125 (\32\:VDD \34\:VDD) resistor r=0.04332 c=0
Rk126 (\32\:VDD \35\:VDD) resistor r=0.05153 c=0
Rk129 (\36\:VDD VDD) resistor r=0.1576 c=0
Rk127 (\35\:VDD \36\:VDD) resistor r=0.3936 c=0
Rk128 (\36\:VDD \38\:VDD) resistor r=0.2667 c=0
Rk5 (\9\:SE SE) resistor r=0.2173 c=0
Rk4 (\8\:SE \9\:SE) resistor r=0.9019 c=0
Rk6 (SE \10\:SE) resistor r=0.01035 c=0
Rk7 (\9\:SE \11\:SE) resistor r=0.08778 c=0
Rk46 (RN \4\:RN) resistor r=0.1137 c=0
Rk1 (\5\:SI SI) resistor r=0.003299 c=0
Rk76 (\2\:VSS \4\:VSS) resistor r=0.5187 c=0
Rk77 (\4\:VSS \5\:VSS) resistor r=0.1534 c=0
Rk78 (\5\:VSS \6\:VSS) resistor r=0.3022 c=0
Rk79 (\6\:VSS \7\:VSS) resistor r=0.4442 c=0
Rk85 (\7\:VSS \13\:VSS) resistor r=0.415 c=0
Rk88 (\13\:VSS \16\:VSS) resistor r=0.563 c=0
Rk89 (\16\:VSS \17\:VSS) resistor r=0.5764 c=0
Rk91 (\18\:VSS VSS) resistor r=0.1576 c=0
Rk90 (\17\:VSS \18\:VSS) resistor r=0.3936 c=0
Rk92 (\4\:VSS \20\:VSS) resistor r=0.2931 c=0
Rk93 (\5\:VSS \22\:VSS) resistor r=0.07405 c=0
Rk94 (\6\:VSS \24\:VSS) resistor r=0.04332 c=0
Rk102 (\16\:VSS \40\:VSS) resistor r=0.04332 c=0
Rk103 (\17\:VSS \42\:VSS) resistor r=0.3581 c=0
Rk104 (\18\:VSS \44\:VSS) resistor r=0.3094 c=0
Rk2 (\4\:SEb \6\:SEb) resistor r=0.5459 c=0
Rk3 (\6\:SEb \8\:SEb) resistor r=0.6251 c=0
Rk8 (\2\:Dpb \3\:Dpb) resistor r=0.3904 c=0
Rk9 (\3\:Dpb \5\:Dpb) resistor r=0.588 c=0
Rk10 (\3\:Dpb \7\:Dpb) resistor r=0.06035 c=0
Rk11 (\5\:Dpb \9\:Dpb) resistor r=0.5454 c=0
Rk62 (\5\:Dp \6\:Dp) resistor r=0.3459 c=0
Rk63 (\6\:Dp \7\:Dp) resistor r=0.1805 c=0
Rk64 (\7\:Dp \8\:Dp) resistor r=0.3849 c=0
Rk65 (\8\:Dp \9\:Dp) resistor r=5.3912 c=0
Rk66 (\6\:Dp \11\:Dp) resistor r=0.03441 c=0
Rk67 (\7\:Dp \13\:Dp) resistor r=0.6102 c=0
Rk68 (\8\:Dp \15\:Dp) resistor r=0.1945 c=0
Rk18 (\8\:CKbb \9\:CKbb) resistor r=0.8482 c=0
Rk19 (\9\:CKbb \10\:CKbb) resistor r=0.1164 c=0
Rk20 (\10\:CKbb \12\:CKbb) resistor r=0.2746 c=0
Rk21 (\10\:CKbb \13\:CKbb) resistor r=0.3615 c=0
Rk22 (\12\:CKbb \15\:CKbb) resistor r=0.4225 c=0
Rk26 (\13\:CKb \14\:CKb) resistor r=0.2242 c=0
Rk27 (\14\:CKb \15\:CKb) resistor r=0.4209 c=0
Rk28 (\15\:CKb \16\:CKb) resistor r=0.7375 c=0
Rk29 (\14\:CKb \18\:CKb) resistor r=0.9008 c=0
Rk30 (\18\:CKb \20\:CKb) resistor r=0.3374 c=0
Rk31 (\15\:CKb \21\:CKb) resistor r=0.2207 c=0
Rk12 (\5\:n20 \6\:n20) resistor r=0.3027 c=0
Rk13 (\6\:n20 \8\:n20) resistor r=0.2842 c=0
Rk14 (\6\:n20 \10\:n20) resistor r=0.1206 c=0
Rk15 (\4\:mout \5\:mout) resistor r=0.1867 c=0
Rk16 (\5\:mout \7\:mout) resistor r=0.2321 c=0
Rk17 (\5\:mout \9\:mout) resistor r=0.1541 c=0
Rk23 (\8\:n30 \9\:n30) resistor r=0.4387 c=0
Rk24 (\9\:n30 \11\:n30) resistor r=0.06436 c=0
Rk25 (\9\:n30 \13\:n30) resistor r=0.3288 c=0
Rk50 (\25\:qbint \26\:qbint) resistor r=0.8224 c=0
Rk56 (\27\:qbint \4\:qbint) resistor r=0.3073 c=0
Rk51 (\26\:qbint \27\:qbint) resistor r=1.421 c=0
Rk52 (\27\:qbint \28\:qbint) resistor r=0.9882 c=0
Rk53 (\28\:qbint \30\:qbint) resistor r=0.2082 c=0
Rk54 (\30\:qbint \31\:qbint) resistor r=0.2512 c=0
Rk55 (\26\:qbint \32\:qbint) resistor r=0.2536 c=0
Rk58 (\28\:qbint \36\:qbint) resistor r=0.06101 c=0
Rk43 (\15\:net582 \16\:net582) resistor r=0.03466 c=0
Rk44 (\16\:net582 \17\:net582) resistor r=0.3591 c=0
Rk45 (\16\:net582 \19\:net582) resistor r=0.3626 c=0
Rk47 (\4\:RNb \5\:RNb) resistor r=0.187 c=0
Rk48 (\5\:RNb \7\:RNb) resistor r=0.3794 c=0
Rk49 (\5\:RNb \9\:RNb) resistor r=0.09154 c=0
Rk71 (\5\:Eb \7\:Eb) resistor r=0.3476 c=0
Rk72 (\7\:Eb \8\:Eb) resistor r=1.2182 c=0
Rk74 (\5\:Db \6\:Db) resistor r=0.8 c=0
Rk75 (\5\:Db \8\:Db) resistor r=0.264 c=0
Rk60 (\2\:net493 \4\:net493) resistor r=0.2998 c=0
Rk61 (\2\:net505 \4\:net505) resistor r=0.5169 c=0
Rl82 (\1\:D \2\:D) resistor r=39.6174 c=0
Rl83 (\2\:D \3\:D) resistor r=24.2328 c=0
Rl39 (\2\:CK \3\:CK) resistor r=76.3736 c=0
Rl38 (\1\:CK \2\:CK) resistor r=26.9231 c=0
Rl76 (\2\:E \3\:E) resistor r=55.7572 c=0
Rl75 (\1\:E \2\:E) resistor r=134.41 c=0
Rl79 (\4\:E \5\:E) resistor r=47.3105 c=0
Rl81 (\5\:E \7\:E) resistor r=41.5412 c=0
Rl80 (\5\:E \6\:E) resistor r=69.604 c=0
Rl9 (\6\:SE \7\:SE) resistor r=64.1533 c=0
Rl6 (\4\:SE \5\:SE) resistor r=35.3072 c=0
Rl1 (\1\:SE \2\:SE) resistor r=114.153 c=0
Rl2 (\2\:SE \3\:SE) resistor r=29.5379 c=0
Rl68 (\2\:RN \3\:RN) resistor r=79.3856 c=0
Rl67 (\1\:RN \2\:RN) resistor r=85.7713 c=0
Rl3 (\1\:SI \2\:SI) resistor r=61.257 c=0
Rl5 (\2\:SI \4\:SI) resistor r=111.257 c=0
Rl4 (\2\:SI \3\:SI) resistor r=3.3229 c=0
Rl8 (\2\:SEb \3\:SEb) resistor r=26.3736 c=0
Rl7 (SEb \2\:SEb) resistor r=136.511 c=0
Rl11 (\2\:Dp \3\:Dp) resistor r=169.083 c=0
Rl10 (Dp \2\:Dp) resistor r=41.0764 c=0
Rl27 (\5\:CKbb \6\:CKbb) resistor r=187.581 c=0
Rl28 (\6\:CKbb \7\:CKbb) resistor r=24.2328 c=0
Rl13 (\3\:CKbb \4\:CKbb) resistor r=44.7803 c=0
Rl12 (CKbb \2\:CKbb) resistor r=63.0341 c=0
Rl29 (\11\:CKb \12\:CKb) resistor r=53.079 c=0
Rl26 (\9\:CKb \10\:CKb) resistor r=24.2328 c=0
Rl18 (\2\:CKb \6\:CKb) resistor r=24.7024 c=0
Rl14 (CKb \2\:CKb) resistor r=4.4012 c=0
Rl19 (\3\:CKb \7\:CKb) resistor r=30.4507 c=0
Rl15 (\2\:CKb \3\:CKb) resistor r=162.881 c=0
Rl20 (\4\:CKb \8\:CKb) resistor r=85.6975 c=0
Rl17 (\4\:CKb \5\:CKb) resistor r=84.2779 c=0
Rl16 (\3\:CKb \4\:CKb) resistor r=146.229 c=0
Rl23 (n20 \2\:n20) resistor r=113.176 c=0
Rl25 (\2\:n20 \4\:n20) resistor r=34.3295 c=0
Rl24 (\2\:n20 \3\:n20) resistor r=1.2666 c=0
Rl21 (mout \2\:mout) resistor r=41.5405 c=0
Rl22 (\2\:mout \3\:mout) resistor r=93.0293 c=0
Rl34 (n30 \4\:n30) resistor r=4.6955 c=0
Rl71 (\23\:qbint \22\:qbint) resistor r=174.673 c=0
Rl72 (\24\:qbint \23\:qbint) resistor r=24.2328 c=0
Rl66 (\20\:qbint \21\:qbint) resistor r=64.8409 c=0
Rl65 (\20\:qbint \19\:qbint) resistor r=41.1312 c=0
Rl30 (\2\:qbint qbint) resistor r=41.5405 c=0
Rl31 (\2\:qbint \3\:qbint) resistor r=85.7713 c=0
Rl70 (\2\:RNb \3\:RNb) resistor r=118.464 c=0
Rl69 (RNb \2\:RNb) resistor r=65.6605 c=0
Rl73 (Eb \2\:Eb) resistor r=118.464 c=0
Rl74 (\2\:Eb \3\:Eb) resistor r=24.2328 c=0
Rl78 (\2\:Db \3\:Db) resistor r=223.077 c=0
Rl77 (Db \2\:Db) resistor r=31.0981 c=0
Rz34 (\4\:VDD \5\:VDD) resistor r=6.25 c=0
Rz35 (\7\:VDD \5\:VDD) resistor r=6.25 c=0
Rz36 (\23\:VDD \5\:VDD) resistor r=6.25 c=0
Rz37 (\35\:VDD \5\:VDD) resistor r=6.25 c=0
Rz20 (\2\:VSS \1\:VSS) resistor r=75 c=0
Rz21 (\20\:VSS \19\:VSS) resistor r=75 c=0
Rz22 (\22\:VSS \21\:VSS) resistor r=75 c=0
Rz23 (\24\:VSS \23\:VSS) resistor r=75 c=0
Rz31 (\40\:VSS \39\:VSS) resistor r=75 c=0
Rz32 (\42\:VSS \41\:VSS) resistor r=75 c=0
Rz33 (\44\:VSS \43\:VSS) resistor r=75 c=0
Rz1 (\7\:SEb \8\:SEb) resistor r=75 c=0
Rz2 (Dpb \2\:Dpb) resistor r=75 c=0
Rz3 (\8\:Dpb \9\:Dpb) resistor r=75 c=0
Rz16 (\12\:Dp \13\:Dp) resistor r=75 c=0
Rz17 (\14\:Dp \15\:Dp) resistor r=75 c=0
Rz6 (\11\:CKbb \12\:CKbb) resistor r=75 c=0
Rz8 (\19\:CKb \20\:CKb) resistor r=75 c=0
Rz4 (\9\:n20 \10\:n20) resistor r=75 c=0
Rz5 (\6\:mout \7\:mout) resistor r=75 c=0
Rz7 (\11\:n30 \10\:n30) resistor r=75 c=0
Rz15 (\36\:qbint \35\:qbint) resistor r=75 c=0
Rz13 (\19\:net582 \18\:net582) resistor r=75 c=0
Rz14 (\8\:RNb \9\:RNb) resistor r=75 c=0
Rz18 (\6\:Eb \7\:Eb) resistor r=75 c=0
Rz19 (\7\:Db \8\:Db) resistor r=75 c=0
Ry28 (\2\:VDD \1\:VDD) resistor r=62 c=0
Ry29 (\9\:VDD \8\:VDD) resistor r=62 c=0
Ry37 (\31\:VDD \30\:VDD) resistor r=62 c=0
Ry38 (\34\:VDD \33\:VDD) resistor r=62 c=0
Ry39 (\38\:VDD \37\:VDD) resistor r=62 c=0
Ry24 (\4\:VSS \3\:VSS) resistor r=5.1667 c=0
Ry25 (\7\:VSS \3\:VSS) resistor r=5.1667 c=0
Ry26 (\13\:VSS \3\:VSS) resistor r=5.1667 c=0
Ry27 (\17\:VSS \3\:VSS) resistor r=5.1667 c=0
Ry1 (\5\:SEb \6\:SEb) resistor r=62 c=0
Ry2 (\4\:Dpb \5\:Dpb) resistor r=62 c=0
Ry3 (\6\:Dpb \7\:Dpb) resistor r=62 c=0
Ry20 (\4\:Dp \5\:Dp) resistor r=62 c=0
Ry21 (\10\:Dp \11\:Dp) resistor r=62 c=0
Ry6 (\14\:CKbb \15\:CKbb) resistor r=62 c=0
Ry8 (\17\:CKb \18\:CKb) resistor r=62 c=0
Ry4 (\7\:n20 \8\:n20) resistor r=62 c=0
Ry5 (\8\:mout \9\:mout) resistor r=62 c=0
Ry7 (\13\:n30 \12\:n30) resistor r=62 c=0
Ry15 (\30\:qbint \29\:qbint) resistor r=62 c=0
Ry13 (\15\:net582 \14\:net582) resistor r=62 c=0
Ry14 (\6\:RNb \7\:RNb) resistor r=62 c=0
Ry22 (\4\:Eb \5\:Eb) resistor r=62 c=0
Ry23 (\4\:Db \5\:Db) resistor r=62 c=0
Ry16 (net493 \2\:net493) resistor r=62 c=0
Ry17 (\3\:net493 \4\:net493) resistor r=62 c=0
Ry18 (net505 \2\:net505) resistor r=62 c=0
Ry19 (\3\:net505 \4\:net505) resistor r=62 c=0
Rx28 (\2\:D \4\:D) resistor r=45 c=0
Rx15 (\2\:CK \4\:CK) resistor r=45 c=0
Rx25 (\6\:E \8\:E) resistor r=45 c=0
Rx26 (\2\:E \9\:E) resistor r=45 c=0
Rx3 (\7\:SE \8\:SE) resistor r=45 c=0
Rx4 (\2\:SE \10\:SE) resistor r=45 c=0
Rx5 (\5\:SE \11\:SE) resistor r=45 c=0
Rx17 (\2\:RN \4\:RN) resistor r=45 c=0
Rx1 (\3\:SI \5\:SI) resistor r=45 c=0
Rx2 (\2\:SEb \4\:SEb) resistor r=45 c=0
Rx24 (Dp \9\:Dp) resistor r=45 c=0
Rx8 (\6\:CKbb \8\:CKbb) resistor r=45 c=0
Rx9 (\4\:CKbb \9\:CKbb) resistor r=45 c=0
Rx10 (\2\:CKbb \13\:CKbb) resistor r=45 c=0
Rx12 (\12\:CKb \13\:CKb) resistor r=45 c=0
Rx13 (CKb \16\:CKb) resistor r=45 c=0
Rx14 (\10\:CKb \21\:CKb) resistor r=45 c=0
Rx6 (\3\:n20 \5\:n20) resistor r=45 c=0
Rx7 (\2\:mout \4\:mout) resistor r=45 c=0
Rx11 (\8\:n30 \4\:n30) resistor r=45 c=0
Rx19 (\25\:qbint \24\:qbint) resistor r=45 c=0
Rx20 (\31\:qbint \2\:qbint) resistor r=45 c=0
Rx21 (\32\:qbint \20\:qbint) resistor r=45 c=0
Rx16 (\17\:net582 net582) resistor r=45 c=0
Rx18 (\2\:RNb \4\:RNb) resistor r=45 c=0
Rx27 (\2\:Eb \8\:Eb) resistor r=45 c=0
Rx29 (Db \6\:Db) resistor r=45 c=0
mn10 (\7\:SEb \3\:SE \43\:VSS VSS) g45n1hvt w=(1.45e-07) l=4.5e-08 nf=1 \
        as=2.9e-14 ad=2.03e-14 ps=6.9e-07 pd=5.7e-07 nrd=1.16667 \
        nrs=1.16667 sa=1.4e-07 sb=1.165e-06 sd=160n sca=11.7118 \
        scb=0.0116498 scc=0.000458536 m=(1)
mn13 (net658 \4\:SI \43\:VSS VSS) g45n1hvt w=(1.45e-07) l=4.5e-08 nf=1 \
        as=2.9e-14 ad=8.7e-15 ps=6.9e-07 pd=4.1e-07 nrd=1.16667 \
        nrs=1.16667 sa=3.85e-07 sb=9.2e-07 sd=160n sca=11.7118 \
        scb=0.0116498 scc=0.000458536 m=(1)
mn14 (\8\:Dpb \4\:SE net658 VSS) g45n1hvt w=(1.45e-07) l=4.5e-08 nf=1 \
        as=8.7e-15 ad=2.32e-14 ps=4.1e-07 pd=6.1e-07 nrd=1.16667 \
        nrs=1.16667 sa=4.9e-07 sb=8.15e-07 sd=160n sca=11.7118 \
        scb=0.0116498 scc=0.000458536 m=(1)
mn12 (\8\:Dpb SEb net650 VSS) g45n1hvt w=(1.45e-07) l=4.5e-08 nf=1 \
        as=3.19e-14 ad=2.32e-14 ps=7.3e-07 pd=6.1e-07 nrd=1.16667 \
        nrs=1.16667 sa=6.95e-07 sb=6.1e-07 sd=160n sca=11.7118 \
        scb=0.0116498 scc=0.000458536 m=(1)
mn11 (net650 \3\:Dp \41\:VSS VSS) g45n1hvt w=(1.45e-07) l=4.5e-08 nf=1 \
        as=2.32e-14 ad=3.19e-14 ps=6.1e-07 pd=7.3e-07 nrd=1.16667 \
        nrs=1.16667 sa=9.6e-07 sb=3.45e-07 sd=160n sca=11.7118 \
        scb=0.0116498 scc=0.000458536 m=(1)
mn21 (\11\:CKbb \5\:CKb \41\:VSS VSS) g45n1hvt w=(1.45e-07) l=4.5e-08 \
        nf=1 as=2.32e-14 ad=2.03e-14 ps=6.1e-07 pd=5.7e-07 nrd=1.16667 \
        nrs=1.16667 sa=1.165e-06 sb=1.4e-07 sd=160n sca=11.7118 \
        scb=0.0116498 scc=0.000458536 m=(1)
mn25 (\9\:n20 \7\:CKb Dpb VSS) g45n1hvt w=(1.45e-07) l=4.5e-08 nf=1 \
        as=2.03e-14 ad=4.422e-14 ps=5.7e-07 pd=9e-07 nrd=1.16667 \
        nrs=1.16667 sa=1.4e-07 sb=2e-06 sd=160n sca=23.279 scb=0.0230742 \
        scc=0.00267719 m=(1)
mn36 (\9\:n20 \3\:CKbb net606 VSS) g45n1hvt w=(1.45e-07) l=4.5e-08 nf=1 \
        as=8.7e-15 ad=4.422e-14 ps=4.1e-07 pd=9e-07 nrd=1.16667 \
        nrs=1.16667 sa=4.9e-07 sb=1.845e-06 sd=160n sca=23.279 \
        scb=0.0230742 scc=0.00267719 m=(1)
mn35 (net606 \3\:mout \39\:VSS VSS) g45n1hvt w=(1.45e-07) l=4.5e-08 nf=1 \
        as=8.41e-14 ad=8.7e-15 ps=1.6e-06 pd=4.1e-07 nrd=1.16667 \
        nrs=1.16667 sa=5.95e-07 sb=1.74e-06 sd=160n sca=23.279 \
        scb=0.0230742 scc=0.00267719 m=(1)
mn30 (\6\:mout \4\:n20 \39\:VSS VSS) g45n1hvt w=(1.45e-07) l=4.5e-08 \
        nf=1 as=8.41e-14 ad=4.567e-14 ps=1.6e-06 pd=9.2e-07 nrd=1.16667 \
        nrs=1.16667 sa=8.6e-07 sb=1.475e-06 sd=160n sca=23.279 \
        scb=0.0230742 scc=0.00267719 m=(1)
mn40 (\10\:n30 \7\:CKbb \6\:mout VSS) g45n1hvt w=(1.45e-07) l=4.5e-08 \
        nf=1 as=4.567e-14 ad=4.857e-14 ps=9.2e-07 pd=9.6e-07 nrd=1.16667 \
        nrs=1.16667 sa=1.22e-06 sb=1.115e-06 sd=160n sca=23.279 \
        scb=0.0230742 scc=0.00267719 m=(1)
mn51 (\10\:n30 \11\:CKb net618 VSS) g45n1hvt w=(1.45e-07) l=4.5e-08 nf=1 \
        as=1.015e-14 ad=4.857e-14 ps=4.3e-07 pd=9.6e-07 nrd=1.16667 \
        nrs=1.16667 sa=1.6e-06 sb=7.35e-07 sd=160n sca=23.279 \
        scb=0.0230742 scc=0.00267719 m=(1)
mn50 (net618 \3\:qbint \13\:VSS VSS) g45n1hvt w=(1.45e-07) l=4.5e-08 \
        nf=1 as=4.102e-14 ad=1.015e-14 ps=8.6e-07 pd=4.3e-07 nrd=1.16667 \
        nrs=1.16667 sa=1.715e-06 sb=6.2e-07 sd=160n sca=23.279 \
        scb=0.0230742 scc=0.00267719 m=(1)
mn20 (\19\:CKb \1\:CK \7\:VSS VSS) g45n1hvt w=(1.45e-07) l=4.5e-08 nf=1 \
        as=9.33e-14 ad=3.407e-14 ps=1.62e-06 pd=7.6e-07 nrd=1.16667 \
        nrs=1.16667 sa=2.35e-07 sb=2e-06 sd=160n sca=13.6097 scb=0.014254 \
        scc=0.000755054 m=(1)
mn2 (\8\:RNb \1\:RN \23\:VSS VSS) g45n1hvt w=(1.45e-07) l=4.5e-08 nf=1 \
        as=7.452e-14 ad=2.03e-14 ps=1.43e-06 pd=5.7e-07 nrd=1.16667 \
        nrs=1.16667 sa=1.4e-07 sb=7.75e-07 sd=160n sca=11.7118 \
        scb=0.0116498 scc=0.000458536 m=(1)
mn3 (\14\:Dp RNb \23\:VSS VSS) g45n1hvt w=(1.45e-07) l=4.5e-08 nf=1 \
        as=7.452e-14 ad=2.32e-14 ps=1.43e-06 pd=6.1e-07 nrd=1.16667 \
        nrs=1.16667 sa=4.3e-07 sb=4.85e-07 sd=160n sca=11.7118 \
        scb=0.0116498 scc=0.000458536 m=(1)
mn5 (\14\:Dp \23\:qbint net634 VSS) g45n1hvt w=(1.45e-07) l=4.5e-08 nf=1 \
        as=1.957e-14 ad=2.32e-14 ps=5.6e-07 pd=6.1e-07 nrd=1.16667 \
        nrs=1.16667 sa=6.35e-07 sb=2.8e-07 sd=160n sca=11.7118 \
        scb=0.0116498 scc=0.000458536 m=(1)
mn4 (net634 \3\:Eb \21\:VSS VSS) g45n1hvt w=(1.45e-07) l=4.5e-08 nf=1 \
        as=3.915e-14 ad=1.957e-14 ps=1.28e-06 pd=5.6e-07 nrd=1.16667 \
        nrs=1.16667 sa=8.15e-07 sb=1e-07 sd=160n sca=11.7118 scb=0.0116498 \
        scc=0.000458536 m=(1)
mn6 (net638 \1\:E \19\:VSS VSS) g45n1hvt w=(1.45e-07) l=4.5e-08 nf=1 \
        as=2.537e-14 ad=1.377e-14 ps=6.4e-07 pd=4.8e-07 nrd=1.16667 \
        nrs=1.16667 sa=1.75e-07 sb=2.8e-07 sd=160n sca=8.70265 \
        scb=0.00681258 scc=0.000126945 m=(1)
mn7 (\12\:Dp \3\:Db net638 VSS) g45n1hvt w=(1.45e-07) l=4.5e-08 nf=1 \
        as=1.377e-14 ad=2.03e-14 ps=4.8e-07 pd=5.7e-07 nrd=1.16667 \
        nrs=1.16667 sa=3.15e-07 sb=1.4e-07 sd=160n sca=8.70265 \
        scb=0.00681258 scc=0.000126945 m=(1)
mn0 (\6\:Eb \7\:E \1\:VSS VSS) g45n1hvt w=(1.45e-07) l=4.5e-08 nf=1 \
        as=5.19e-14 ad=2.03e-14 ps=1.6e-06 pd=5.7e-07 nrd=1.16667 \
        nrs=1.16667 sa=1.4e-07 sb=3.55e-07 sd=160n sca=23.279 \
        scb=0.0230742 scc=0.00267719 m=(1)
mn1 (\7\:Db \3\:D \1\:VSS VSS) g45n1hvt w=(1.45e-07) l=4.5e-08 nf=1 \
        as=5.19e-14 ad=2.32e-14 ps=1.6e-06 pd=6.1e-07 nrd=1.16667 \
        nrs=1.16667 sa=3.35e-07 sb=1.6e-07 sd=160n sca=23.279 \
        scb=0.0230742 scc=0.00267719 m=(1)
mn45 (\35\:qbint n30 \13\:VSS VSS) g45n1hvt w=(2.05e-07) l=4.5e-08 nf=1 \
        as=3.486e-14 ad=3.382e-14 ps=7.75e-07 pd=7.4e-07 nrd=1.16667 \
        nrs=1.16667 sa=1.445e-06 sb=3.5e-07 sd=160n sca=19.867 \
        scb=0.0198061 scc=0.00201945 m=(2)
mn56 (\18\:net582 \19\:qbint \7\:VSS VSS) g45n1hvt w=(2.6e-07) l=4.5e-08 \
        nf=1 as=8.6e-14 ad=3.64e-14 ps=1.44e-06 pd=8e-07 nrd=1.16667 \
        nrs=1.16667 sa=2e-06 sb=1.4e-07 sd=160n sca=11.0409 scb=0.0104003 \
        scc=0.000454168 m=(1)
mn55_1__rcx (\1\:Q \4\:qbint \7\:VSS VSS) g45n1hvt w=(2.6e-07) l=4.5e-08 \
        nf=1 as=8.783e-14 ad=4.16e-14 ps=1.485e-06 pd=8.4e-07 nrd=1.16667 \
        nrs=1.16667 sa=4.04231e-07 sb=2e-06 sd=160n sca=11.0409 \
        scb=0.0104003 scc=0.000454168 m=(4)
mn57_1__rcx (\1\:QN net582 \7\:VSS VSS) g45n1hvt w=(2.6e-07) l=4.5e-08 \
        nf=1 as=8.6e-14 ad=4.16e-14 ps=1.44e-06 pd=8.4e-07 nrd=1.16667 \
        nrs=1.16667 sa=1.34423e-06 sb=1.08e-06 sd=160n sca=11.0409 \
        scb=0.0104003 scc=0.000454168 m=(4)
mp45 (\29\:qbint n30 \23\:VDD VDD) g45p1hvt w=(3.1e-07) l=4.5e-08 nf=1 \
        as=9.662e-14 ad=4.96e-14 ps=1.945e-06 pd=9.4e-07 nrd=1.16667 \
        nrs=1.16667 sa=9.30242e-07 sb=3.75e-07 sd=160n sca=35.6995 \
        scb=0.0234062 scc=0.00420468 m=(2)
mp56 (\14\:net582 \21\:qbint \4\:VDD VDD) g45p1hvt w=(3.9e-07) l=4.5e-08 \
        nf=1 as=1.254e-13 ad=5.46e-14 ps=1.88e-06 pd=1.06e-06 nrd=1.16667 \
        nrs=1.16667 sa=2e-06 sb=1.4e-07 sd=160n sca=27.1129 scb=0.0194379 \
        scc=0.00296416 m=(1)
mp57_1__rcx (QN net582 \4\:VDD VDD) g45p1hvt w=(3.9e-07) l=4.5e-08 nf=1 \
        as=1.206e-13 ad=6.24e-14 ps=1.8e-06 pd=1.1e-06 nrd=1.16667 \
        nrs=1.16667 sa=1.29987e-06 sb=1.08e-06 sd=160n sca=27.1129 \
        scb=0.0194379 scc=0.00296416 m=(4)
mp55_1__rcx (Q \4\:qbint \4\:VDD VDD) g45p1hvt w=(3.9e-07) l=4.5e-08 \
        nf=1 as=1.2348e-13 ad=6.825e-14 ps=1.8825e-06 pd=1.13e-06 \
        nrd=1.16667 nrs=1.16667 sa=3.29872e-07 sb=2e-06 sd=160n \
        sca=27.1129 scb=0.0194379 scc=0.00296416 m=(4)
ends SEDFFTRX4
// End of subcircuit definition.
