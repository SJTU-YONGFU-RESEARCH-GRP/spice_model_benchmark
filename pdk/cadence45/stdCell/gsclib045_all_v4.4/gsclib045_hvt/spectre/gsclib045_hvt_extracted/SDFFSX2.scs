// Generated for: spectre (May  1 09:16:00 2013 )
// Library name: gsclib045_hvt
// Cell name: SDFFSX2
// View name: extracted

simulator lang=spectre

subckt SDFFSX2 CK D Q QN SE SI SN VDD VSS
mp55_1__rcx (\1\:Q qbint \20\:VDD VDD) g45p1hvt w=(3.9e-07) l=4.5e-08 \
        nf=1 as=7.775e-14 ad=6.24e-14 ps=1.725e-06 pd=1.1e-06 nrd=1.16667 \
        nrs=1.16667 sa=2.42756e-07 sb=4.80256e-07 sd=160n sca=30.5009 \
        scb=0.0202006 scc=0.00336097 m=(2)
mp57 (\1\:QN net492 VDD VDD) g45p1hvt w=(3.9e-07) l=4.5e-08 nf=1 \
        as=4.92e-14 ad=6.24e-14 ps=1.06e-06 pd=1.1e-06 nrd=1.16667 \
        nrs=1.16667 sa=1.4e-07 sb=3.17308e-07 sd=160n sca=43.6185 \
        scb=0.0386349 scc=0.00465805 m=(2)
C1 (CK VSS) capacitor c=5.83761e-17
C2 (SE VSS) capacitor c=2.16001e-17
C3 (SN VSS) capacitor c=2.60985e-17
C4 (SI VSS) capacitor c=4.36893e-17
C5 (VDD VSS) capacitor c=5.37608e-16
C6 (D VSS) capacitor c=2.12373e-17
C7 (net492 VSS) capacitor c=1.14392e-16
C8 (qbint VSS) capacitor c=1.36894e-16
C9 (n35 VSS) capacitor c=4.88598e-17
C10 (net518 VSS) capacitor c=1.69034e-18
C11 (CKb VSS) capacitor c=1.77655e-17
C12 (mout VSS) capacitor c=7.29857e-17
C13 (CKbb VSS) capacitor c=6.85968e-17
C14 (net442 VSS) capacitor c=3.88814e-19
C15 (n20 VSS) capacitor c=3.47936e-17
C16 (net478 VSS) capacitor c=1.91044e-18
C17 (Db VSS) capacitor c=9.66311e-17
C18 (net494 VSS) capacitor c=5.97955e-18
C19 (SEb VSS) capacitor c=5.59324e-17
C20 (net405 VSS) capacitor c=7.166e-17
C21 (net417 VSS) capacitor c=1.07651e-18
C22 (net433 VSS) capacitor c=5.51944e-18
C23 (\5\:SE VSS) capacitor c=6.22232e-17
C24 (\1\:SI VSS) capacitor c=5.8399e-17
C25 (\1\:SE VSS) capacitor c=3.74977e-17
C26 (\1\:D VSS) capacitor c=6.08091e-17
C27 (\1\:CK VSS) capacitor c=5.31256e-17
C28 (\5\:CKbb VSS) capacitor c=5.99236e-17
C29 (\7\:CKb VSS) capacitor c=8.80483e-17
C30 (\4\:SN VSS) capacitor c=7.50563e-17
C31 (\2\:CKb VSS) capacitor c=4.22912e-17
C32 (\4\:CKb VSS) capacitor c=1.16186e-16
C33 (\11\:qbint VSS) capacitor c=6.74633e-17
C34 (\3\:SN VSS) capacitor c=6.10531e-17
C35 (\10\:qbint VSS) capacitor c=2.62124e-17
C36 (\7\:SE VSS) capacitor c=3.19611e-17
C37 (\3\:SI VSS) capacitor c=1.03546e-16
C38 (\3\:SE VSS) capacitor c=6.51604e-17
C39 (\3\:SEb VSS) capacitor c=5.46817e-17
C40 (\3\:D VSS) capacitor c=2.25906e-17
C41 (\4\:CK VSS) capacitor c=2.77228e-17
C42 (\9\:CKb VSS) capacitor c=3.42582e-17
C43 (\7\:CKbb VSS) capacitor c=3.87324e-17
C44 (\4\:mout VSS) capacitor c=3.89096e-17
C45 (\3\:n20 VSS) capacitor c=7.36157e-17
C46 (\5\:SN VSS) capacitor c=6.10561e-17
C47 (\6\:CKb VSS) capacitor c=2.94784e-17
C48 (\3\:CKbb VSS) capacitor c=2.75888e-17
C49 (\5\:CKb VSS) capacitor c=1.08554e-16
C50 (\13\:qbint VSS) capacitor c=4.17037e-17
C51 (\1\:SN VSS) capacitor c=4.99032e-17
C52 (\3\:n35 VSS) capacitor c=4.47767e-17
C53 (\5\:qbint VSS) capacitor c=2.17543e-17
C54 (\6\:SE VSS) capacitor c=5.591e-17
C55 (\2\:SI VSS) capacitor c=7.81502e-17
C56 (\4\:SE VSS) capacitor c=5.18859e-17
C57 (\2\:SEb VSS) capacitor c=7.97591e-17
C58 (\2\:SE VSS) capacitor c=3.32239e-17
C59 (\2\:D VSS) capacitor c=4.7814e-17
C60 (\3\:CK VSS) capacitor c=1.81633e-17
C61 (\10\:CKb VSS) capacitor c=2.39e-17
C62 (\6\:CKbb VSS) capacitor c=5.37574e-17
C63 (\8\:CKb VSS) capacitor c=3.07495e-17
C64 (\3\:mout VSS) capacitor c=1.17646e-17
C65 (\2\:n20 VSS) capacitor c=4.06591e-17
C66 (\6\:SN VSS) capacitor c=1.84206e-17
C67 (\4\:CKbb VSS) capacitor c=4.35853e-17
C68 (\12\:qbint VSS) capacitor c=6.61543e-17
C69 (\2\:SN VSS) capacitor c=6.46177e-17
C70 (\4\:n35 VSS) capacitor c=3.00951e-17
C71 (\7\:qbint VSS) capacitor c=2.30224e-17
C72 (\6\:net492 VSS) capacitor c=1.10325e-17
C73 (\8\:SEb VSS) capacitor c=1.41268e-17
C74 (\1\:VDD VSS) capacitor c=5.44226e-17
C75 (\7\:Db VSS) capacitor c=4.63494e-17
C76 (\8\:VDD VSS) capacitor c=3.75903e-17
C77 (\11\:CKb VSS) capacitor c=8.37801e-17
C78 (\5\:Db VSS) capacitor c=2.63528e-17
C79 (\8\:n20 VSS) capacitor c=5.42413e-17
C80 (\10\:VDD VSS) capacitor c=9.01111e-17
C81 (\8\:mout VSS) capacitor c=1.23739e-16
C82 (\12\:VDD VSS) capacitor c=1.64401e-17
C83 (\12\:CKbb VSS) capacitor c=4.21232e-17
C84 (\10\:mout VSS) capacitor c=1.28943e-16
C85 (\5\:n35 VSS) capacitor c=3.69398e-17
C86 (\15\:VDD VSS) capacitor c=3.24337e-17
C87 (\3\:net405 VSS) capacitor c=8.10949e-17
C88 (\18\:VDD VSS) capacitor c=1.46833e-17
C89 (\14\:qbint VSS) capacitor c=3.4567e-17
C90 (\1\:Q VSS) capacitor c=5.28707e-17
C91 (\8\:net492 VSS) capacitor c=1.73206e-17
C92 (\1\:QN VSS) capacitor c=7.66362e-17
C93 (\3\:VDD VSS) capacitor c=7.78325e-17
C94 (\4\:SEb VSS) capacitor c=6.84974e-17
C95 (\17\:CKb VSS) capacitor c=9.15538e-17
C96 (\9\:Db VSS) capacitor c=9.37404e-17
C97 (\4\:n20 VSS) capacitor c=7.13973e-17
C98 (\6\:mout VSS) capacitor c=8.47918e-17
C99 (\8\:CKbb VSS) capacitor c=2.99353e-17
C100 (\12\:mout VSS) capacitor c=9.70995e-17
C101 (\9\:n35 VSS) capacitor c=7.85714e-17
C102 (\19\:qbint VSS) capacitor c=1.53645e-17
C103 (\3\:Q VSS) capacitor c=5.83127e-17
C104 (\12\:net492 VSS) capacitor c=1.8755e-17
C105 (\3\:QN VSS) capacitor c=3.21551e-17
C106 (\4\:qbint VSS) capacitor c=1.14326e-17
C107 (\2\:n35 VSS) capacitor c=2.57383e-17
C108 (\2\:CKbb VSS) capacitor c=2.89322e-17
C109 (\3\:CKb VSS) capacitor c=5.26222e-17
C110 (\2\:mout VSS) capacitor c=4.06495e-17
C111 (\2\:CK VSS) capacitor c=4.90982e-17
C112 (\10\:net492 VSS) capacitor c=1.39992e-17
C113 (\11\:net492 VSS) capacitor c=1.9433e-17
C114 (\16\:qbint VSS) capacitor c=2.31947e-17
C115 (\17\:qbint VSS) capacitor c=3.82987e-17
C116 (\18\:qbint VSS) capacitor c=3.27207e-17
C117 (\21\:qbint VSS) capacitor c=8.6046e-17
C118 (\7\:n35 VSS) capacitor c=1.35931e-16
C119 (\8\:n35 VSS) capacitor c=1.27064e-16
C120 (\7\:SN VSS) capacitor c=6.45354e-17
C121 (\8\:SN VSS) capacitor c=1.74936e-16
C122 (\9\:SN VSS) capacitor c=1.91026e-16
C123 (\5\:mout VSS) capacitor c=6.6731e-17
C124 (\10\:CKbb VSS) capacitor c=5.01693e-17
C125 (\11\:CKbb VSS) capacitor c=1.58876e-16
C126 (\14\:CKbb VSS) capacitor c=1.64134e-16
C127 (\6\:n20 VSS) capacitor c=8.02463e-17
C128 (\7\:n20 VSS) capacitor c=7.70499e-17
C129 (\5\:CK VSS) capacitor c=4.68703e-17
C130 (\13\:CKb VSS) capacitor c=8.62477e-17
C131 (\14\:CKb VSS) capacitor c=1.71364e-16
C132 (\15\:CKb VSS) capacitor c=1.64052e-16
C133 (\16\:CKb VSS) capacitor c=1.61815e-16
C134 (\4\:D VSS) capacitor c=7.13834e-17
C135 (\3\:Db VSS) capacitor c=1.5057e-16
C136 (\4\:Db VSS) capacitor c=1.5275e-16
C137 (\8\:SE VSS) capacitor c=6.54159e-17
C138 (\9\:SE VSS) capacitor c=7.57366e-17
C139 (\10\:SE VSS) capacitor c=3.05262e-17
C140 (\4\:SI VSS) capacitor c=7.75598e-17
C141 (\6\:SEb VSS) capacitor c=1.13414e-16
C142 (\7\:SEb VSS) capacitor c=7.49357e-17
C143 (\5\:VDD VSS) capacitor c=4.03059e-17
C144 (\6\:VDD VSS) capacitor c=4.38944e-17
C145 (\14\:VDD VSS) capacitor c=3.66525e-17
C146 (\17\:VDD VSS) capacitor c=1.27622e-17
C147 (\20\:VDD VSS) capacitor c=2.71959e-17
Rk6 (\2\:Q Q) resistor r=0.2622 c=0
Rk7 (Q \4\:Q) resistor r=0.04331 c=0
Rk31 (\5\:CK CK) resistor r=0.1901 c=0
Rk44 (\8\:SE SE) resistor r=0.09661 c=0
Rk43 (\8\:SE \9\:SE) resistor r=0.4184 c=0
Rk45 (SE \10\:SE) resistor r=0.09784 c=0
Rk18 (\8\:SN SN) resistor r=0.02622 c=0
Rk17 (\7\:SN \8\:SN) resistor r=0.2841 c=0
Rk19 (\8\:SN \9\:SN) resistor r=1.3825 c=0
Rk46 (SI \4\:SI) resistor r=0.1468 c=0
Rk70 (\2\:VSS \4\:VSS) resistor r=0.5271 c=0
Rk71 (\4\:VSS \5\:VSS) resistor r=0.2304 c=0
Rk72 (\5\:VSS \6\:VSS) resistor r=0.6138 c=0
Rk73 (\6\:VSS \7\:VSS) resistor r=0.258 c=0
Rk74 (\7\:VSS \8\:VSS) resistor r=0.1728 c=0
Rk75 (\8\:VSS \9\:VSS) resistor r=0.7241 c=0
Rk79 (\10\:VSS VSS) resistor r=0.1826 c=0
Rk76 (\9\:VSS \10\:VSS) resistor r=0.2453 c=0
Rk82 (\5\:VSS \17\:VSS) resistor r=0.2529 c=0
Rk83 (\6\:VSS \19\:VSS) resistor r=0.1337 c=0
Rk84 (\8\:VSS \21\:VSS) resistor r=0.2168 c=0
Rk85 (\9\:VSS \23\:VSS) resistor r=0.3156 c=0
Rk50 (\2\:VDD \4\:VDD) resistor r=0.4904 c=0
Rk51 (\4\:VDD \5\:VDD) resistor r=0.1928 c=0
Rk52 (\5\:VDD \6\:VDD) resistor r=0.6414 c=0
Rk53 (\6\:VDD \7\:VDD) resistor r=0.2681 c=0
Rk54 (\5\:VDD \9\:VDD) resistor r=0.199 c=0
Rk55 (\6\:VDD \11\:VDD) resistor r=0.4309 c=0
Rk56 (\7\:VDD \13\:VDD) resistor r=0.07145 c=0
Rk57 (\7\:VDD \14\:VDD) resistor r=0.7354 c=0
Rk58 (\14\:VDD \16\:VDD) resistor r=0.2057 c=0
Rk59 (\14\:VDD \17\:VDD) resistor r=0.1977 c=0
Rk60 (\17\:VDD \19\:VDD) resistor r=0.2103 c=0
Rk66 (\20\:VDD VDD) resistor r=0.1826 c=0
Rk61 (\17\:VDD \20\:VDD) resistor r=0.1952 c=0
Rk37 (D \4\:D) resistor r=0.02026 c=0
Rk1 (\2\:QN QN) resistor r=0.3177 c=0
Rk2 (QN \4\:QN) resistor r=0.05414 c=0
Rk3 (\9\:net492 \10\:net492) resistor r=0.09366 c=0
Rk4 (\10\:net492 \11\:net492) resistor r=0.07727 c=0
Rk5 (\10\:net492 \13\:net492) resistor r=0.1296 c=0
Rk8 (\15\:qbint \16\:qbint) resistor r=0.2277 c=0
Rk9 (\16\:qbint \17\:qbint) resistor r=0.1497 c=0
Rk10 (\16\:qbint \18\:qbint) resistor r=0.06153 c=0
Rk11 (\18\:qbint \20\:qbint) resistor r=0.05742 c=0
Rk12 (\18\:qbint \21\:qbint) resistor r=0.4257 c=0
Rk14 (\6\:n35 \7\:n35) resistor r=0.1625 c=0
Rk15 (\7\:n35 \8\:n35) resistor r=0.725 c=0
Rk16 (\7\:n35 \10\:n35) resistor r=0.3712 c=0
Rk32 (\12\:CKb \13\:CKb) resistor r=0.519 c=0
Rk33 (\13\:CKb \14\:CKb) resistor r=0.1432 c=0
Rk34 (\14\:CKb \15\:CKb) resistor r=1.286 c=0
Rk35 (\13\:CKb \16\:CKb) resistor r=0.5197 c=0
Rk36 (\16\:CKb \18\:CKb) resistor r=0.6929 c=0
Rk20 (\5\:mout \7\:mout) resistor r=0.2961 c=0
Rk21 (\7\:mout \9\:mout) resistor r=0.3404 c=0
Rk22 (\9\:mout \11\:mout) resistor r=0.8238 c=0
Rk23 (\11\:mout \13\:mout) resistor r=0.556 c=0
Rk24 (\9\:CKbb \10\:CKbb) resistor r=0.1124 c=0
Rk25 (\10\:CKbb \11\:CKbb) resistor r=0.3452 c=0
Rk26 (\11\:CKbb \13\:CKbb) resistor r=0.1731 c=0
Rk27 (\11\:CKbb \14\:CKbb) resistor r=1.1494 c=0
Rk28 (\5\:n20 \6\:n20) resistor r=0.3457 c=0
Rk29 (\6\:n20 \7\:n20) resistor r=0.3789 c=0
Rk30 (\6\:n20 \9\:n20) resistor r=0.1752 c=0
Rk38 (\2\:Db \3\:Db) resistor r=0.7655 c=0
Rk39 (\3\:Db \4\:Db) resistor r=0.6997 c=0
Rk40 (\4\:Db \6\:Db) resistor r=0.0511 c=0
Rk41 (\3\:Db \8\:Db) resistor r=0.2303 c=0
Rk42 (\4\:Db \10\:Db) resistor r=0.5108 c=0
Rk47 (\5\:SEb \6\:SEb) resistor r=0.7219 c=0
Rk48 (\6\:SEb \7\:SEb) resistor r=0.4893 c=0
Rk49 (\6\:SEb \9\:SEb) resistor r=0.04776 c=0
Rk13 (\2\:net405 \4\:net405) resistor r=0.3382 c=0
Rl42 (\1\:CK \2\:CK) resistor r=226.203 c=0
Rl44 (\2\:CK \4\:CK) resistor r=68.9449 c=0
Rl43 (\2\:CK \3\:CK) resistor r=13.091 c=0
Rl53 (\5\:SE \6\:SE) resistor r=204.538 c=0
Rl54 (\6\:SE \7\:SE) resistor r=56.461 c=0
Rl50 (\3\:SE \4\:SE) resistor r=52.6149 c=0
Rl47 (\1\:SE \2\:SE) resistor r=47.2519 c=0
Rl31 (\4\:SN \5\:SN) resistor r=149.566 c=0
Rl32 (\5\:SN \6\:SN) resistor r=48.5844 c=0
Rl20 (\2\:SN \3\:SN) resistor r=119.895 c=0
Rl19 (\1\:SN \2\:SN) resistor r=92.3077 c=0
Rl51 (\1\:SI \2\:SI) resistor r=82.3533 c=0
Rl52 (\2\:SI \3\:SI) resistor r=193.136 c=0
Rl45 (\1\:D \2\:D) resistor r=220.387 c=0
Rl46 (\2\:D \3\:D) resistor r=37.6944 c=0
Rl5 (net492 \6\:net492) resistor r=9.5287 c=0
Rl21 (\12\:qbint \11\:qbint) resistor r=181.461 c=0
Rl22 (\12\:qbint \13\:qbint) resistor r=29.5379 c=0
Rl12 (qbint \7\:qbint) resistor r=4.8851 c=0
Rl9 (\4\:qbint qbint) resistor r=82.084 c=0
Rl15 (\4\:qbint \10\:qbint) resistor r=53.0797 c=0
Rl10 (\4\:qbint \5\:qbint) resistor r=35.772 c=0
Rl16 (n35 \2\:n35) resistor r=28.0797 c=0
Rl17 (\2\:n35 \3\:n35) resistor r=60.772 c=0
Rl18 (\2\:n35 \4\:n35) resistor r=79.6836 c=0
Rl29 (\4\:CKb \5\:CKb) resistor r=557.258 c=0
Rl41 (\9\:CKb \10\:CKb) resistor r=62.2302 c=0
Rl38 (\7\:CKb \8\:CKb) resistor r=29.5379 c=0
Rl26 (CKb \2\:CKb) resistor r=50.6918 c=0
Rl27 (\2\:CKb \3\:CKb) resistor r=155.747 c=0
Rl28 (\3\:CKb \4\:CKb) resistor r=192.286 c=0
Rl30 (\3\:CKb \6\:CKb) resistor r=82.3738 c=0
Rl35 (mout \2\:mout) resistor r=131.572 c=0
Rl37 (\2\:mout \4\:mout) resistor r=37.3411 c=0
Rl36 (\2\:mout \3\:mout) resistor r=3.1183 c=0
Rl39 (\5\:CKbb \6\:CKbb) resistor r=153.282 c=0
Rl40 (\6\:CKbb \7\:CKbb) resistor r=26.3736 c=0
Rl23 (CKbb \2\:CKbb) resistor r=128.08 c=0
Rl24 (\2\:CKbb \3\:CKbb) resistor r=35.772 c=0
Rl25 (\2\:CKbb \4\:CKbb) resistor r=89.2411 c=0
Rl33 (n20 \2\:n20) resistor r=57.4874 c=0
Rl34 (\2\:n20 \3\:n20) resistor r=126.9 c=0
Rl48 (SEb \2\:SEb) resistor r=93.4636 c=0
Rl49 (\2\:SEb \3\:SEb) resistor r=200.539 c=0
Rz3 (\4\:Q \3\:Q) resistor r=75 c=0
Rz17 (\2\:VSS \1\:VSS) resistor r=75 c=0
Rz19 (\17\:VSS \16\:VSS) resistor r=75 c=0
Rz20 (\19\:VSS \18\:VSS) resistor r=75 c=0
Rz21 (\21\:VSS \20\:VSS) resistor r=75 c=0
Rz22 (\23\:VSS \22\:VSS) resistor r=75 c=0
Rz14 (\4\:VDD \3\:VDD) resistor r=7.5 c=0
Rz15 (\7\:VDD \3\:VDD) resistor r=6.25 c=0
Rz16 (\20\:VDD \3\:VDD) resistor r=6.25 c=0
Rz1 (\4\:QN \3\:QN) resistor r=75 c=0
Rz2 (\13\:net492 \12\:net492) resistor r=75 c=0
Rz4 (\20\:qbint \19\:qbint) resistor r=75 c=0
Rz5 (\9\:n35 \10\:n35) resistor r=75 c=0
Rz10 (\17\:CKb \18\:CKb) resistor r=75 c=0
Rz6 (\6\:mout \7\:mout) resistor r=75 c=0
Rz7 (\12\:mout \13\:mout) resistor r=75 c=0
Rz8 (\8\:CKbb \9\:CKbb) resistor r=75 c=0
Rz9 (\4\:n20 \5\:n20) resistor r=75 c=0
Rz11 (Db \2\:Db) resistor r=75 c=0
Rz12 (\9\:Db \10\:Db) resistor r=75 c=0
Rz13 (\4\:SEb \5\:SEb) resistor r=75 c=0
Ry3 (\2\:Q \1\:Q) resistor r=20.6667 c=0
Ry26 (\4\:VSS \3\:VSS) resistor r=6.2 c=0
Ry27 (\7\:VSS \3\:VSS) resistor r=5.1667 c=0
Ry28 (\10\:VSS \3\:VSS) resistor r=5.1667 c=0
Ry16 (\2\:VDD \1\:VDD) resistor r=62 c=0
Ry17 (\9\:VDD \8\:VDD) resistor r=62 c=0
Ry18 (\11\:VDD \10\:VDD) resistor r=62 c=0
Ry19 (\13\:VDD \12\:VDD) resistor r=62 c=0
Ry20 (\16\:VDD \15\:VDD) resistor r=62 c=0
Ry21 (\19\:VDD \18\:VDD) resistor r=62 c=0
Ry1 (\2\:QN \1\:QN) resistor r=20.6667 c=0
Ry2 (\9\:net492 \8\:net492) resistor r=62 c=0
Ry4 (\15\:qbint \14\:qbint) resistor r=62 c=0
Ry7 (\5\:n35 \6\:n35) resistor r=62 c=0
Ry12 (\11\:CKb \12\:CKb) resistor r=62 c=0
Ry8 (\8\:mout \9\:mout) resistor r=62 c=0
Ry9 (\10\:mout \11\:mout) resistor r=62 c=0
Ry10 (\12\:CKbb \13\:CKbb) resistor r=62 c=0
Ry11 (\8\:n20 \9\:n20) resistor r=62 c=0
Ry13 (\5\:Db \6\:Db) resistor r=62 c=0
Ry14 (\7\:Db \8\:Db) resistor r=62 c=0
Ry15 (\8\:SEb \9\:SEb) resistor r=62 c=0
Ry5 (net405 \2\:net405) resistor r=62 c=0
Ry6 (\3\:net405 \4\:net405) resistor r=62 c=0
Rx11 (\3\:CK \5\:CK) resistor r=45 c=0
Rx16 (\4\:SE \8\:SE) resistor r=45 c=0
Rx17 (\2\:SE \9\:SE) resistor r=45 c=0
Rx18 (\6\:SE \10\:SE) resistor r=45 c=0
Rx5 (\2\:SN \7\:SN) resistor r=45 c=0
Rx6 (\6\:SN \9\:SN) resistor r=45 c=0
Rx19 (\2\:SI \4\:SI) resistor r=45 c=0
Rx15 (\2\:D \4\:D) resistor r=45 c=0
Rx1 (\11\:net492 \6\:net492) resistor r=45 c=0
Rx2 (\17\:qbint \7\:qbint) resistor r=45 c=0
Rx3 (\21\:qbint \12\:qbint) resistor r=45 c=0
Rx4 (\4\:n35 \8\:n35) resistor r=45 c=0
Rx12 (\8\:CKb \14\:CKb) resistor r=45 c=0
Rx13 (CKb \15\:CKb) resistor r=45 c=0
Rx14 (\10\:CKb \16\:CKb) resistor r=45 c=0
Rx7 (\3\:mout \5\:mout) resistor r=45 c=0
Rx8 (\4\:CKbb \10\:CKbb) resistor r=45 c=0
Rx9 (\6\:CKbb \14\:CKbb) resistor r=45 c=0
Rx10 (\2\:n20 \7\:n20) resistor r=45 c=0
Rx20 (\2\:SEb \7\:SEb) resistor r=45 c=0
mn57_1__rcx (\3\:QN net492 VSS VSS) g45n1hvt w=(2.6e-07) l=4.5e-08 nf=1 \
        as=4.34e-14 ad=4.16e-14 ps=1.15e-06 pd=8.4e-07 nrd=1.16667 \
        nrs=1.16667 sa=1.4e-07 sb=3.05e-07 sd=160n sca=17.5885 \
        scb=0.0172826 scc=0.00162584 m=(2)
mn55 (\3\:Q qbint \10\:VSS VSS) g45n1hvt w=(2.6e-07) l=4.5e-08 nf=1 \
        as=4.098e-14 ad=4.16e-14 ps=8.7e-07 pd=8.4e-07 nrd=1.16667 \
        nrs=1.16667 sa=2.71058e-07 sb=4.98173e-07 sd=160n sca=17.5885 \
        scb=0.0172826 scc=0.00162584 m=(2)
mn56 (\12\:net492 \5\:qbint \10\:VSS VSS) g45n1hvt w=(1.45e-07) \
        l=4.5e-08 nf=1 as=4.365e-14 ad=2.03e-14 ps=9e-07 pd=5.7e-07 \
        nrd=1.16667 nrs=1.16667 sa=1.4e-07 sb=7.85e-07 sd=160n sca=23.279 \
        scb=0.0230742 scc=0.00267719 m=(1)
mn50 (net521 \1\:SN \22\:VSS VSS) g45n1hvt w=(1.45e-07) l=4.5e-08 nf=1 \
        as=2.03e-14 ad=8.7e-15 ps=5.7e-07 pd=4.1e-07 nrd=1.16667 \
        nrs=1.16667 sa=1.4e-07 sb=7.5e-07 sd=160n sca=14.7993 \
        scb=0.0157101 scc=0.000964917 m=(1)
mn51 (net518 \13\:qbint net521 VSS) g45n1hvt w=(1.45e-07) l=4.5e-08 nf=1 \
        as=8.7e-15 ad=3.263e-14 ps=4.1e-07 pd=7.4e-07 nrd=1.16667 \
        nrs=1.16667 sa=2.45e-07 sb=6.45e-07 sd=160n sca=14.7993 \
        scb=0.0157101 scc=0.000964917 m=(1)
mn52 (\9\:n35 \5\:CKb net518 VSS) g45n1hvt w=(1.45e-07) l=4.5e-08 nf=1 \
        as=3.263e-14 ad=2.755e-14 ps=7.4e-07 pd=6.7e-07 nrd=1.16667 \
        nrs=1.16667 sa=5.15e-07 sb=3.75e-07 sd=160n sca=14.7993 \
        scb=0.0157101 scc=0.000964917 m=(1)
mn40 (\9\:n35 \3\:CKbb \12\:mout VSS) g45n1hvt w=(1.45e-07) l=4.5e-08 \
        nf=1 as=2.03e-14 ad=2.755e-14 ps=5.7e-07 pd=6.7e-07 nrd=1.16667 \
        nrs=1.16667 sa=7.5e-07 sb=1.4e-07 sd=160n sca=14.7993 \
        scb=0.0157101 scc=0.000964917 m=(1)
mn21 (\8\:CKbb \6\:CKb \20\:VSS VSS) g45n1hvt w=(1.45e-07) l=4.5e-08 \
        nf=1 as=8.445e-14 ad=3.698e-14 ps=1.51e-06 pd=8e-07 nrd=1.16667 \
        nrs=1.16667 sa=2.55e-07 sb=7.4e-07 sd=160n sca=15.7071 \
        scb=0.0167369 scc=0.00113434 m=(1)
mn30 (net442 \5\:SN \20\:VSS VSS) g45n1hvt w=(1.45e-07) l=4.5e-08 nf=1 \
        as=8.445e-14 ad=8.7e-15 ps=1.51e-06 pd=4.1e-07 nrd=1.16667 \
        nrs=1.16667 sa=7.5e-07 sb=2.45e-07 sd=160n sca=15.7071 \
        scb=0.0167369 scc=0.00113434 m=(1)
mn31 (\6\:mout \3\:n20 net442 VSS) g45n1hvt w=(1.45e-07) l=4.5e-08 nf=1 \
        as=8.7e-15 ad=2.03e-14 ps=4.1e-07 pd=5.7e-07 nrd=1.16667 \
        nrs=1.16667 sa=8.55e-07 sb=1.4e-07 sd=160n sca=15.7071 \
        scb=0.0167369 scc=0.00113434 m=(1)
mn35 (net478 \4\:mout \18\:VSS VSS) g45n1hvt w=(1.45e-07) l=4.5e-08 nf=1 \
        as=4.325e-14 ad=9.42e-15 ps=9.4e-07 pd=4.2e-07 nrd=1.16667 \
        nrs=1.16667 sa=1.7e-07 sb=7.25e-07 sd=160n sca=8.55924 \
        scb=0.0065649 scc=0.000116351 m=(1)
mn36 (\4\:n20 \7\:CKbb net478 VSS) g45n1hvt w=(1.45e-07) l=4.5e-08 nf=1 \
        as=9.42e-15 ad=4.567e-14 ps=4.2e-07 pd=9.2e-07 nrd=1.16667 \
        nrs=1.16667 sa=2.8e-07 sb=6.15e-07 sd=160n sca=8.55924 \
        scb=0.0065649 scc=0.000116351 m=(1)
mn25 (\9\:Db \9\:CKb \4\:n20 VSS) g45n1hvt w=(1.45e-07) l=4.5e-08 nf=1 \
        as=4.567e-14 ad=3.698e-14 ps=9.2e-07 pd=8e-07 nrd=1.16667 \
        nrs=1.16667 sa=6.4e-07 sb=2.55e-07 sd=160n sca=8.55924 \
        scb=0.0065649 scc=0.000116351 m=(1)
mn20 (\17\:CKb \4\:CK \16\:VSS VSS) g45n1hvt w=(1.45e-07) l=4.5e-08 nf=1 \
        as=3.842e-14 ad=2.03e-14 ps=8.2e-07 pd=5.7e-07 nrd=1.16667 \
        nrs=1.16667 sa=1.4e-07 sb=1.435e-06 sd=160n sca=8.70265 \
        scb=0.00681258 scc=0.000126945 m=(1)
mn11 (net494 \3\:D \16\:VSS VSS) g45n1hvt w=(1.45e-07) l=4.5e-08 nf=1 \
        as=3.842e-14 ad=5.292e-14 ps=8.2e-07 pd=1.02e-06 nrd=1.16667 \
        nrs=1.16667 sa=4.5e-07 sb=1.125e-06 sd=160n sca=8.70265 \
        scb=0.00681258 scc=0.000126945 m=(1)
mn12 (Db \3\:SEb net494 VSS) g45n1hvt w=(1.45e-07) l=4.5e-08 nf=1 \
        as=5.292e-14 ad=2.32e-14 ps=1.02e-06 pd=6.1e-07 nrd=1.16667 \
        nrs=1.16667 sa=8.6e-07 sb=7.15e-07 sd=160n sca=8.70265 \
        scb=0.00681258 scc=0.000126945 m=(1)
mn14 (Db \3\:SE net506 VSS) g45n1hvt w=(1.45e-07) l=4.5e-08 nf=1 \
        as=8.7e-15 ad=2.32e-14 ps=4.1e-07 pd=6.1e-07 nrd=1.16667 \
        nrs=1.16667 sa=1.065e-06 sb=5.1e-07 sd=160n sca=8.70265 \
        scb=0.00681258 scc=0.000126945 m=(1)
mn13 (net506 \3\:SI \1\:VSS VSS) g45n1hvt w=(1.45e-07) l=4.5e-08 nf=1 \
        as=2.32e-14 ad=8.7e-15 ps=6.1e-07 pd=4.1e-07 nrd=1.16667 \
        nrs=1.16667 sa=1.17e-06 sb=4.05e-07 sd=160n sca=8.70265 \
        scb=0.00681258 scc=0.000126945 m=(1)
mn10 (\4\:SEb \7\:SE \1\:VSS VSS) g45n1hvt w=(1.45e-07) l=4.5e-08 nf=1 \
        as=2.32e-14 ad=2.9e-14 ps=6.1e-07 pd=6.9e-07 nrd=1.16667 \
        nrs=1.16667 sa=1.375e-06 sb=2e-07 sd=160n sca=8.70265 \
        scb=0.00681258 scc=0.000126945 m=(1)
mn45 (\19\:qbint \3\:n35 \10\:VSS VSS) g45n1hvt w=(2.05e-07) l=4.5e-08 \
        nf=1 as=3.83e-14 ad=2.87e-14 ps=8.4e-07 pd=6.9e-07 nrd=1.16667 \
        nrs=1.16667 sa=7.1622e-07 sb=1.4e-07 sd=160n sca=19.867 \
        scb=0.0198061 scc=0.00201945 m=(1)
mp56 (\8\:net492 \10\:qbint \20\:VDD VDD) g45p1hvt w=(2.15e-07) \
        l=4.5e-08 nf=1 as=7.25e-14 ad=2.63e-14 ps=1.53e-06 pd=7.1e-07 \
        nrd=1.16667 nrs=1.16667 sa=1.22326e-07 sb=7.67326e-07 sd=160n \
        sca=46.2604 scb=0.0284877 scc=0.00588421 m=(1)
mp50 (\3\:net405 \3\:SN \18\:VDD VDD) g45p1hvt w=(2.15e-07) l=4.5e-08 \
        nf=1 as=2.63e-14 ad=3.44e-14 ps=7.1e-07 pd=7.5e-07 nrd=1.16667 \
        nrs=1.16667 sa=1.22326e-07 sb=3.6e-07 sd=160n sca=10.1345 \
        scb=0.00732736 scc=7.25592e-05 m=(1)
mp51 (\3\:net405 \11\:qbint \15\:VDD VDD) g45p1hvt w=(2.15e-07) \
        l=4.5e-08 nf=1 as=3.332e-14 ad=3.44e-14 ps=7.4e-07 pd=7.5e-07 \
        nrd=1.16667 nrs=1.16667 sa=3.27326e-07 sb=1.55e-07 sd=160n \
        sca=10.1345 scb=0.00732736 scc=7.25592e-05 m=(1)
mp52 (\5\:n35 CKbb net405 VDD) g45p1hvt w=(2.15e-07) l=4.5e-08 nf=1 \
        as=3.01e-14 ad=3.44e-14 ps=7.1e-07 pd=7.5e-07 nrd=1.16667 \
        nrs=1.16667 sa=1.4e-07 sb=3.45e-07 sd=160n sca=15.2551 \
        scb=0.0150251 scc=0.000885438 m=(1)
mp40 (\5\:n35 \4\:CKb \10\:mout VDD) g45p1hvt w=(2.15e-07) l=4.5e-08 nf=1 \
        as=3.01e-14 ad=3.44e-14 ps=7.1e-07 pd=7.5e-07 nrd=1.16667 \
        nrs=1.16667 sa=3.45e-07 sb=1.4e-07 sd=160n sca=15.2551 \
        scb=0.0150251 scc=0.000885438 m=(1)
mp21 (\12\:CKbb \2\:CKb \12\:VDD VDD) g45p1hvt w=(2.15e-07) l=4.5e-08 \
        nf=1 as=1.049e-13 ad=3.01e-14 ps=1.83e-06 pd=7.1e-07 nrd=1.16667 \
        nrs=1.16667 sa=1.4e-07 sb=1.415e-06 sd=160n sca=29.9075 \
        scb=0.0247057 scc=0.00372713 m=(1)
mp30 (\8\:mout \4\:SN \12\:VDD VDD) g45p1hvt w=(2.15e-07) l=4.5e-08 nf=1 \
        as=1.049e-13 ad=4.73e-14 ps=1.83e-06 pd=8.7e-07 nrd=1.16667 \
        nrs=1.16667 sa=4.05e-07 sb=1.15e-06 sd=160n sca=29.9075 \
        scb=0.0247057 scc=0.00372713 m=(1)
mp31 (\8\:mout n20 \10\:VDD VDD) g45p1hvt w=(2.15e-07) l=4.5e-08 nf=1 \
        as=5.267e-14 ad=4.73e-14 ps=9.2e-07 pd=8.7e-07 nrd=1.16667 \
        nrs=1.16667 sa=6.7e-07 sb=8.85e-07 sd=160n sca=29.9075 \
        scb=0.0247057 scc=0.00372713 m=(1)
mp35 (net417 mout \10\:VDD VDD) g45p1hvt w=(2.15e-07) l=4.5e-08 nf=1 \
        as=5.267e-14 ad=1.29e-14 ps=9.2e-07 pd=5.5e-07 nrd=1.16667 \
        nrs=1.16667 sa=9.6e-07 sb=5.95e-07 sd=160n sca=29.9075 \
        scb=0.0247057 scc=0.00372713 m=(1)
mp36 (\8\:n20 \7\:CKb net417 VDD) g45p1hvt w=(2.15e-07) l=4.5e-08 nf=1 \
        as=1.29e-14 ad=3.44e-14 ps=5.5e-07 pd=7.5e-07 nrd=1.16667 \
        nrs=1.16667 sa=1.065e-06 sb=4.9e-07 sd=160n sca=29.9075 \
        scb=0.0247057 scc=0.00372713 m=(1)
mp25 (\8\:n20 \5\:CKbb \5\:Db VDD) g45p1hvt w=(2.15e-07) l=4.5e-08 nf=1 \
        as=6.127e-14 ad=3.44e-14 ps=1e-06 pd=7.5e-07 nrd=1.16667 \
        nrs=1.16667 sa=1.27e-06 sb=2.85e-07 sd=160n sca=29.9075 \
        scb=0.0247057 scc=0.00372713 m=(1)
mp20 (\11\:CKb \1\:CK \8\:VDD VDD) g45p1hvt w=(2.15e-07) l=4.5e-08 nf=1 \
        as=3.762e-14 ad=3.01e-14 ps=7.8e-07 pd=7.1e-07 nrd=1.16667 \
        nrs=1.16667 sa=1.4e-07 sb=1.285e-06 sd=160n sca=10.1292 \
        scb=0.00731698 scc=7.20009e-05 m=(1)
mp11 (net433 \1\:D \8\:VDD VDD) g45p1hvt w=(2.15e-07) l=4.5e-08 nf=1 \
        as=3.762e-14 ad=5.59e-14 ps=7.8e-07 pd=9.5e-07 nrd=1.16667 \
        nrs=1.16667 sa=3.6e-07 sb=1.065e-06 sd=160n sca=10.1292 \
        scb=0.00731698 scc=7.20009e-05 m=(1)
mp12 (\7\:Db \1\:SE net433 VDD) g45p1hvt w=(2.15e-07) l=4.5e-08 nf=1 \
        as=5.59e-14 ad=5.375e-14 ps=9.5e-07 pd=9.3e-07 nrd=1.16667 \
        nrs=1.16667 sa=6.65e-07 sb=7.6e-07 sd=160n sca=10.1579 \
        scb=0.00732238 scc=7.20014e-05 m=(1)
mp14 (\7\:Db SEb net441 VDD) g45p1hvt w=(2.15e-07) l=4.5e-08 nf=1 \
        as=1.612e-14 ad=5.375e-14 ps=5.8e-07 pd=9.3e-07 nrd=1.16667 \
        nrs=1.16667 sa=9.6e-07 sb=4.65e-07 sd=160n sca=11.144 \
        scb=0.00785651 scc=7.24744e-05 m=(1)
mp13 (net441 \1\:SI \1\:VDD VDD) g45p1hvt w=(2.15e-07) l=4.5e-08 nf=1 \
        as=3.44e-14 ad=1.612e-14 ps=7.5e-07 pd=5.8e-07 nrd=1.16667 \
        nrs=1.16667 sa=1.08e-06 sb=3.45e-07 sd=160n sca=12.0249 \
        scb=0.00887156 scc=7.63487e-05 m=(1)
mp10 (\8\:SEb \5\:SE \1\:VDD VDD) g45p1hvt w=(2.15e-07) l=4.5e-08 nf=1 \
        as=3.44e-14 ad=3.01e-14 ps=7.5e-07 pd=7.1e-07 nrd=1.16667 \
        nrs=1.16667 sa=1.285e-06 sb=1.4e-07 sd=160n sca=15.8545 \
        scb=0.0153548 scc=0.000243119 m=(1)
mp45 (\14\:qbint n35 \20\:VDD VDD) g45p1hvt w=(3.1e-07) l=4.5e-08 nf=1 \
        as=8.3e-14 ad=3.58e-14 ps=1.92e-06 pd=9e-07 nrd=1.16667 \
        nrs=1.16667 sa=6.88468e-07 sb=1.15484e-07 sd=160n sca=35.6995 \
        scb=0.0234062 scc=0.00420468 m=(1)
ends SDFFSX2
// End of subcircuit definition.
