// Generated for: spectre (May  1 09:20:30 2013 )
// Library name: gsclib045_hvt
// Cell name: XOR3XL
// View name: extracted

simulator lang=spectre

subckt XOR3XL A B C VDD VSS Y
mp10 (\14\:n62 \1\:A \7\:VDD VDD) g45p1hvt w=(3.1e-07) l=4.5e-08 nf=1 \
        as=1.067e-13 ad=4.34e-14 ps=1.67e-06 pd=9e-07 nrd=1.16667 \
        nrs=1.16667 sa=1.4e-07 sb=5.2e-07 sd=160n sca=23.5711 \
        scb=0.0270642 scc=0.00135402 m=(1)
mp9 (\10\:n61 \6\:B \7\:VDD VDD) g45p1hvt w=(3.1e-07) l=4.5e-08 nf=1 \
        as=1.067e-13 ad=7.595e-14 ps=1.67e-06 pd=1.11e-06 nrd=1.16667 \
        nrs=1.16667 sa=4.15e-07 sb=2.45e-07 sd=160n sca=15.89 \
        scb=0.0145486 scc=0.000688173 m=(1)
mp0 (\6\:n11 \3\:n62 \9\:VDD VDD) g45p1hvt w=(3.1e-07) l=4.5e-08 nf=1 \
        as=5.25e-14 ad=6.82e-14 ps=1.26e-06 pd=1.06e-06 nrd=1.16667 \
        nrs=1.16667 sa=1.1129e-07 sb=7.61774e-07 sd=160n sca=10.5719 \
        scb=0.0081746 scc=0.000117241 m=(1)
mp2 (n44 \1\:B \6\:n11 VDD) g45p1hvt w=(3.1e-07) l=4.5e-08 nf=1 \
        as=6.82e-14 ad=9.18e-14 ps=1.06e-06 pd=1.64e-06 nrd=1.16667 \
        nrs=1.16667 sa=3.7629e-07 sb=4.96774e-07 sd=160n sca=10.5719 \
        scb=0.0081746 scc=0.000117241 m=(1)
mp1 (n44 \3\:n61 \7\:n62 VDD) g45p1hvt w=(3.1e-07) l=4.5e-08 nf=1 \
        as=5.89e-14 ad=9.18e-14 ps=1e-06 pd=1.64e-06 nrd=1.16667 \
        nrs=1.16667 sa=3.92581e-07 sb=5.65242e-07 sd=160n sca=14.8314 \
        scb=0.0138806 scc=0.000865287 m=(1)
mp5 (\8\:n56 \12\:B \7\:n62 VDD) g45p1hvt w=(3.1e-07) l=4.5e-08 nf=1 \
        as=5.89e-14 ad=6.88e-14 ps=1e-06 pd=1.24e-06 nrd=1.16667 \
        nrs=1.16667 sa=6.27581e-07 sb=3.30242e-07 sd=160n sca=14.8314 \
        scb=0.0138806 scc=0.000865287 m=(1)
mp6 (\4\:n11 \2\:n61 \8\:n56 VDD) g45p1hvt w=(3.1e-07) l=4.5e-08 nf=1 \
        as=6.88e-14 ad=5.93e-14 ps=1.24e-06 pd=1.07e-06 nrd=1.16667 \
        nrs=1.16667 sa=6.89597e-07 sb=1.7e-07 sd=160n sca=10.9702 \
        scb=0.00883933 scc=0.000174052 m=(1)
mp4 (\8\:n50 \3\:n60 \5\:n44 VDD) g45p1hvt w=(3.1e-07) l=4.5e-08 nf=1 \
        as=6.83e-14 ad=4.96e-14 ps=1.22e-06 pd=9.4e-07 nrd=1.16667 \
        nrs=1.16667 sa=1.7e-07 sb=3.75e-07 sd=160n sca=14.8314 \
        scb=0.0138806 scc=0.000865287 m=(1)
mp3 (\8\:n50 \7\:C \3\:n56 VDD) g45p1hvt w=(3.1e-07) l=4.5e-08 nf=1 \
        as=5.27e-14 ad=4.96e-14 ps=9.6e-07 pd=9.4e-07 nrd=1.16667 \
        nrs=1.16667 sa=3.75e-07 sb=1.7e-07 sd=160n sca=14.8314 \
        scb=0.0138806 scc=0.000865287 m=(1)
mp8 (\5\:n60 \3\:C \1\:VDD VDD) g45p1hvt w=(3.1e-07) l=4.5e-08 nf=1 \
        as=1.265e-13 ad=5.27e-14 ps=1.85e-06 pd=9.6e-07 nrd=1.16667 \
        nrs=1.16667 sa=1.7e-07 sb=4.30242e-07 sd=160n sca=16.2999 \
        scb=0.0148905 scc=0.000867022 m=(1)
C1 (B VSS) capacitor c=6.96109e-17
C2 (A VSS) capacitor c=7.72406e-17
C3 (VDD VSS) capacitor c=3.54687e-16
C4 (C VSS) capacitor c=4.33372e-17
C5 (n62 VSS) capacitor c=6.6348e-17
C6 (n61 VSS) capacitor c=1.01079e-16
C7 (n11 VSS) capacitor c=7.47837e-17
C8 (n44 VSS) capacitor c=3.31044e-16
C9 (n56 VSS) capacitor c=8.40754e-17
C10 (n50 VSS) capacitor c=2.57878e-17
C11 (n60 VSS) capacitor c=4.58758e-17
C12 (\3\:C VSS) capacitor c=2.90607e-17
C13 (\7\:C VSS) capacitor c=3.47766e-17
C14 (\3\:n60 VSS) capacitor c=6.58879e-17
C15 (\2\:n61 VSS) capacitor c=1.01402e-16
C16 (\12\:B VSS) capacitor c=7.12452e-17
C17 (\3\:n61 VSS) capacitor c=9.48787e-17
C18 (\1\:B VSS) capacitor c=6.23712e-17
C19 (\3\:n62 VSS) capacitor c=4.77839e-17
C20 (\6\:B VSS) capacitor c=4.77929e-17
C21 (\1\:A VSS) capacitor c=4.3791e-17
C22 (\3\:n50 VSS) capacitor c=2.67141e-17
C23 (\6\:C VSS) capacitor c=4.46016e-17
C24 (\4\:n60 VSS) capacitor c=3.65917e-17
C25 (\1\:C VSS) capacitor c=4.04697e-17
C26 (\14\:B VSS) capacitor c=4.65989e-17
C27 (\13\:B VSS) capacitor c=2.45532e-17
C28 (\6\:n61 VSS) capacitor c=3.81261e-17
C29 (\7\:B VSS) capacitor c=3.63274e-17
C30 (\4\:A VSS) capacitor c=3.02549e-17
C31 (\2\:n50 VSS) capacitor c=2.09504e-17
C32 (\5\:C VSS) capacitor c=5.55789e-17
C33 (\2\:C VSS) capacitor c=2.49607e-17
C34 (\2\:n11 VSS) capacitor c=7.96795e-17
C35 (\15\:B VSS) capacitor c=4.08714e-17
C36 (\8\:B VSS) capacitor c=2.99644e-17
C37 (\11\:B VSS) capacitor c=2.51989e-17
C38 (\4\:n62 VSS) capacitor c=3.17228e-17
C39 (\2\:n62 VSS) capacitor c=4.76935e-17
C40 (\5\:n61 VSS) capacitor c=8.65499e-17
C41 (\4\:B VSS) capacitor c=2.67531e-17
C42 (\3\:A VSS) capacitor c=1.27416e-17
C43 (\1\:Y VSS) capacitor c=3.59021e-17
C44 (\1\:VDD VSS) capacitor c=8.75364e-17
C45 (\5\:n60 VSS) capacitor c=6.51648e-17
C46 (\3\:n56 VSS) capacitor c=1.5273e-16
C47 (\8\:n50 VSS) capacitor c=9.75605e-17
C48 (\5\:n44 VSS) capacitor c=2.54775e-16
C49 (\4\:n11 VSS) capacitor c=1.27821e-16
C50 (\8\:n56 VSS) capacitor c=6.86067e-17
C51 (\7\:n62 VSS) capacitor c=1.55531e-16
C52 (\6\:n11 VSS) capacitor c=1.04554e-16
C53 (\9\:VDD VSS) capacitor c=1.0529e-17
C54 (\10\:n61 VSS) capacitor c=8.30896e-17
C55 (\7\:VDD VSS) capacitor c=3.73848e-17
C56 (\14\:n62 VSS) capacitor c=2.71076e-17
C57 (\3\:VDD VSS) capacitor c=1.56312e-16
C58 (\3\:Y VSS) capacitor c=5.09216e-17
C59 (\8\:n60 VSS) capacitor c=4.83363e-17
C60 (\6\:n50 VSS) capacitor c=9.77154e-17
C61 (\7\:n44 VSS) capacitor c=6.43026e-17
C62 (\9\:n11 VSS) capacitor c=1.37967e-16
C63 (\6\:n56 VSS) capacitor c=1.11807e-16
C64 (\5\:n62 VSS) capacitor c=9.44027e-17
C65 (\3\:n44 VSS) capacitor c=1.09863e-16
C66 (\11\:n11 VSS) capacitor c=1.39005e-16
C67 (\7\:n61 VSS) capacitor c=3.73773e-17
C68 (\11\:n62 VSS) capacitor c=1.12994e-16
C69 (\2\:A VSS) capacitor c=2.17283e-17
C70 (\2\:B VSS) capacitor c=1.07627e-16
C71 (\3\:B VSS) capacitor c=6.16327e-17
C72 (\9\:B VSS) capacitor c=2.11541e-17
C73 (\10\:B VSS) capacitor c=2.3833e-17
C74 (\4\:n61 VSS) capacitor c=1.25078e-16
C75 (\2\:n60 VSS) capacitor c=5.53491e-17
C76 (\4\:C VSS) capacitor c=3.87749e-17
C77 (\5\:A VSS) capacitor c=3.35698e-17
C78 (\16\:B VSS) capacitor c=5.94849e-17
C79 (\9\:n61 VSS) capacitor c=5.73233e-17
C80 (\17\:B VSS) capacitor c=6.42224e-17
C81 (\18\:B VSS) capacitor c=6.61725e-17
C82 (\9\:n62 VSS) capacitor c=1.28324e-16
C83 (\10\:n62 VSS) capacitor c=1.63489e-16
C84 (\13\:n62 VSS) capacitor c=6.74379e-17
C85 (\19\:B VSS) capacitor c=3.76444e-17
C86 (\20\:B VSS) capacitor c=6.35371e-17
C87 (\3\:n11 VSS) capacitor c=5.21822e-17
C88 (\8\:n11 VSS) capacitor c=2.14728e-17
C89 (\8\:C VSS) capacitor c=4.95747e-17
C90 (\9\:C VSS) capacitor c=2.48107e-17
C91 (\5\:n56 VSS) capacitor c=1.71804e-16
C92 (\7\:n60 VSS) capacitor c=4.30346e-17
C93 (\4\:n50 VSS) capacitor c=3.85134e-17
C94 (\5\:n50 VSS) capacitor c=1.9163e-16
C95 (\6\:VDD VSS) capacitor c=1.23303e-17
Rk2 (\16\:B B) resistor r=0.2075 c=0
Rk6 (\17\:B \18\:B) resistor r=0.2584 c=0
Rk13 (\19\:B \20\:B) resistor r=0.1661 c=0
Rk1 (\5\:A A) resistor r=0.08725 c=0
Rk31 (\2\:Y Y) resistor r=0.2806 c=0
Rk32 (Y \4\:Y) resistor r=0.03227 c=0
Rk33 (\2\:VDD \4\:VDD) resistor r=0.5553 c=0
Rk34 (\4\:VDD \5\:VDD) resistor r=1.1034 c=0
Rk36 (\6\:VDD VDD) resistor r=0.2895 c=0
Rk35 (\5\:VDD \6\:VDD) resistor r=0.05904 c=0
Rk37 (VDD \8\:VDD) resistor r=0.1938 c=0
Rk38 (\6\:VDD \10\:VDD) resistor r=0.04331 c=0
Rk39 (\2\:VSS \4\:VSS) resistor r=0.5469 c=0
Rk40 (\4\:VSS \5\:VSS) resistor r=1.1034 c=0
Rk42 (\6\:VSS VSS) resistor r=0.2519 c=0
Rk41 (\5\:VSS \6\:VSS) resistor r=0.09666 c=0
Rk43 (VSS \8\:VSS) resistor r=0.122 c=0
Rk44 (\6\:VSS \10\:VSS) resistor r=0.04331 c=0
Rk20 (C \8\:C) resistor r=0.3089 c=0
Rk21 (C \9\:C) resistor r=0.02032 c=0
Rk7 (\6\:n62 \8\:n62) resistor r=0.5309 c=0
Rk8 (\8\:n62 \9\:n62) resistor r=0.7002 c=0
Rk9 (\9\:n62 \10\:n62) resistor r=0.7198 c=0
Rk10 (\10\:n62 \12\:n62) resistor r=0.6908 c=0
Rk11 (\12\:n62 \13\:n62) resistor r=0.5692 c=0
Rk12 (\10\:n62 \15\:n62) resistor r=0.113 c=0
Rk3 (\8\:n61 \9\:n61) resistor r=0.1048 c=0
Rk4 (\9\:n61 \11\:n61) resistor r=0.2997 c=0
Rk14 (\3\:n11 \5\:n11) resistor r=0.2376 c=0
Rk15 (\5\:n11 \7\:n11) resistor r=0.7362 c=0
Rk16 (\8\:n11 \10\:n11) resistor r=0.1186 c=0
Rk17 (\10\:n11 \12\:n11) resistor r=0.9632 c=0
Rk5 (\2\:n44 \4\:n44) resistor r=0.8462 c=0
Rk18 (\6\:n44 \8\:n44) resistor r=0.5314 c=0
Rk19 (\9\:n44 \10\:n44) resistor r=1.0989 c=0
Rk22 (\2\:n56 \4\:n56) resistor r=0.3905 c=0
Rk23 (\4\:n56 \5\:n56) resistor r=0.7258 c=0
Rk24 (\5\:n56 \7\:n56) resistor r=0.6678 c=0
Rk25 (\5\:n56 \9\:n56) resistor r=0.339 c=0
Rk28 (\4\:n50 \5\:n50) resistor r=0.1546 c=0
Rk29 (\5\:n50 \7\:n50) resistor r=0.8123 c=0
Rk30 (\5\:n50 \9\:n50) resistor r=0.7381 c=0
Rk26 (\6\:n60 \7\:n60) resistor r=0.1817 c=0
Rk27 (\7\:n60 \9\:n60) resistor r=0.09164 c=0
Rl22 (\14\:B \15\:B) resistor r=53.079 c=0
Rl11 (\4\:B \7\:B) resistor r=24.2328 c=0
Rl6 (\1\:B \2\:B) resistor r=131.458 c=0
Rl9 (\2\:B \5\:B) resistor r=3.9152 c=0
Rl10 (\3\:B \6\:B) resistor r=72.3105 c=0
Rl8 (\3\:B \4\:B) resistor r=35.0048 c=0
Rl7 (\2\:B \3\:B) resistor r=327.99 c=0
Rl15 (\9\:B \12\:B) resistor r=97.7584 c=0
Rl12 (\8\:B \9\:B) resistor r=19.1561 c=0
Rl16 (\10\:B \13\:B) resistor r=34.3295 c=0
Rl14 (\10\:B \11\:B) resistor r=8.3038 c=0
Rl13 (\9\:B \10\:B) resistor r=95.8459 c=0
Rl1 (\1\:A \2\:A) resistor r=117.022 c=0
Rl3 (\2\:A \4\:A) resistor r=38.1757 c=0
Rl2 (\2\:A \3\:A) resistor r=8.3038 c=0
Rl31 (\5\:C \7\:C) resistor r=26.1559 c=0
Rl24 (\1\:C \2\:C) resistor r=47.59 c=0
Rl28 (\3\:C \4\:C) resistor r=28.0797 c=0
Rl30 (\4\:C \6\:C) resistor r=103.08 c=0
Rl29 (\4\:C \5\:C) resistor r=172.554 c=0
Rl5 (\3\:n62 \4\:n62) resistor r=132.902 c=0
Rl4 (n62 \2\:n62) resistor r=205.584 c=0
Rl18 (\2\:n61 \3\:n61) resistor r=284.181 c=0
Rl17 (n61 \2\:n61) resistor r=255.703 c=0
Rl19 (\3\:n61 \4\:n61) resistor r=241.851 c=0
Rl21 (\4\:n61 \6\:n61) resistor r=57.3738 c=0
Rl20 (\4\:n61 \5\:n61) resistor r=241.764 c=0
Rl23 (n11 \2\:n11) resistor r=176.032 c=0
Rl32 (n50 \2\:n50) resistor r=41.5405 c=0
Rl33 (\2\:n50 \3\:n50) resistor r=64.6174 c=0
Rl26 (\2\:n60 \3\:n60) resistor r=159.593 c=0
Rl27 (\2\:n60 \4\:n60) resistor r=70.8353 c=0
Rl25 (n60 \2\:n60) resistor r=106.101 c=0
Rz12 (\3\:Y \4\:Y) resistor r=75 c=0
Rz13 (\3\:VDD \4\:VDD) resistor r=7.5 c=0
Rz14 (\3\:VDD \5\:VDD) resistor r=6.25 c=0
Rz15 (\1\:VSS \2\:VSS) resistor r=18.75 c=0
Rz16 (\7\:VSS \8\:VSS) resistor r=75 c=0
Rz17 (\9\:VSS \10\:VSS) resistor r=75 c=0
Rz3 (\5\:n62 \6\:n62) resistor r=75 c=0
Rz4 (\11\:n62 \12\:n62) resistor r=75 c=0
Rz1 (\7\:n61 \8\:n61) resistor r=75 c=0
Rz5 (\9\:n11 \10\:n11) resistor r=75 c=0
Rz6 (\11\:n11 \12\:n11) resistor r=75 c=0
Rz2 (\3\:n44 \4\:n44) resistor r=75 c=0
Rz7 (\7\:n44 \8\:n44) resistor r=75 c=0
Rz8 (n56 \2\:n56) resistor r=75 c=0
Rz9 (\6\:n56 \7\:n56) resistor r=75 c=0
Rz11 (\6\:n50 \7\:n50) resistor r=75 c=0
Rz10 (\8\:n60 \9\:n60) resistor r=75 c=0
Ry14 (\1\:Y \2\:Y) resistor r=62 c=0
Ry15 (\1\:VDD \2\:VDD) resistor r=12.4 c=0
Ry16 (\7\:VDD \8\:VDD) resistor r=31 c=0
Ry17 (\9\:VDD \10\:VDD) resistor r=62 c=0
Ry18 (\3\:VSS \4\:VSS) resistor r=6.2 c=0
Ry19 (\3\:VSS \5\:VSS) resistor r=5.1667 c=0
Ry3 (\7\:n62 \8\:n62) resistor r=62 c=0
Ry4 (\14\:n62 \15\:n62) resistor r=62 c=0
Ry1 (\10\:n61 \11\:n61) resistor r=62 c=0
Ry5 (\4\:n11 \5\:n11) resistor r=62 c=0
Ry6 (\6\:n11 \7\:n11) resistor r=62 c=0
Ry2 (n44 \2\:n44) resistor r=62 c=0
Ry7 (\5\:n44 \6\:n44) resistor r=62 c=0
Ry8 (\5\:n44 \9\:n44) resistor r=62 c=0
Ry9 (n44 \10\:n44) resistor r=62 c=0
Ry10 (\3\:n56 \4\:n56) resistor r=62 c=0
Ry11 (\8\:n56 \9\:n56) resistor r=62 c=0
Ry13 (\8\:n50 \9\:n50) resistor r=62 c=0
Ry12 (\5\:n60 \6\:n60) resistor r=62 c=0
Rx2 (\4\:B \16\:B) resistor r=45 c=0
Rx4 (\5\:B \17\:B) resistor r=45 c=0
Rx5 (\11\:B \18\:B) resistor r=45 c=0
Rx8 (\15\:B \19\:B) resistor r=45 c=0
Rx9 (\8\:B \20\:B) resistor r=45 c=0
Rx1 (\3\:A \5\:A) resistor r=45 c=0
Rx12 (\2\:C \8\:C) resistor r=45 c=0
Rx13 (\5\:C \9\:C) resistor r=45 c=0
Rx6 (\4\:n62 \9\:n62) resistor r=45 c=0
Rx7 (\2\:n62 \13\:n62) resistor r=45 c=0
Rx3 (\5\:n61 \9\:n61) resistor r=45 c=0
Rx10 (n11 \3\:n11) resistor r=45 c=0
Rx11 (\2\:n11 \8\:n11) resistor r=45 c=0
Rx15 (\2\:n50 \4\:n50) resistor r=45 c=0
Rx14 (n60 \7\:n60) resistor r=45 c=0
mn10 (\11\:n62 \4\:A \7\:VSS VSS) g45n1hvt w=(1.9e-07) l=4.5e-08 nf=1 \
        as=8.33e-14 ad=3.23e-14 ps=1.5e-06 pd=7.2e-07 nrd=1.16667 \
        nrs=1.16667 sa=1.7e-07 sb=4.45e-07 sd=160n sca=13.8407 \
        scb=0.0143094 scc=0.000839093 m=(1)
mn9 (\7\:n61 \7\:B \7\:VSS VSS) g45n1hvt w=(1.9e-07) l=4.5e-08 nf=1 \
        as=8.33e-14 ad=3.23e-14 ps=1.5e-06 pd=7.2e-07 nrd=1.16667 \
        nrs=1.16667 sa=4.45e-07 sb=1.7e-07 sd=160n sca=13.8407 \
        scb=0.0143094 scc=0.000839093 m=(1)
mn0 (\11\:n11 n62 \9\:VSS VSS) g45n1hvt w=(1.9e-07) l=4.5e-08 nf=1 \
        as=5.75e-14 ad=5.26e-14 ps=1.14e-06 pd=1e-06 nrd=1.16667 \
        nrs=1.16667 sa=1.7e-07 sb=1.42e-06 sd=160n sca=8.3036 \
        scb=0.00616975 scc=0.000110509 m=(1)
mn2 (\11\:n11 \6\:n61 \3\:n44 VSS) g45n1hvt w=(1.9e-07) l=4.5e-08 nf=1 \
        as=7.6e-14 ad=5.26e-14 ps=1.18e-06 pd=1e-06 nrd=1.16667 \
        nrs=1.16667 sa=4.35e-07 sb=1.155e-06 sd=160n sca=8.3036 \
        scb=0.00616975 scc=0.000110509 m=(1)
mn1 (\5\:n62 \13\:B \3\:n44 VSS) g45n1hvt w=(1.9e-07) l=4.5e-08 nf=1 \
        as=7.6e-14 ad=4.37e-14 ps=1.18e-06 pd=8.4e-07 nrd=1.16667 \
        nrs=1.16667 sa=8.8e-07 sb=7.1e-07 sd=160n sca=8.3036 \
        scb=0.00616975 scc=0.000110509 m=(1)
mn5 (\5\:n62 n61 \6\:n56 VSS) g45n1hvt w=(1.9e-07) l=4.5e-08 nf=1 \
        as=4.18e-14 ad=4.37e-14 ps=8.2e-07 pd=8.4e-07 nrd=1.16667 \
        nrs=1.16667 sa=1.155e-06 sb=4.35e-07 sd=160n sca=8.3036 \
        scb=0.00616975 scc=0.000110509 m=(1)
mn6 (\6\:n56 \14\:B \9\:n11 VSS) g45n1hvt w=(1.9e-07) l=4.5e-08 nf=1 \
        as=4.31e-14 ad=4.18e-14 ps=9e-07 pd=8.2e-07 nrd=1.16667 \
        nrs=1.16667 sa=1.42e-06 sb=1.7e-07 sd=160n sca=8.3036 \
        scb=0.00616975 scc=0.000110509 m=(1)
mn4 (\7\:n44 \1\:C \6\:n50 VSS) g45n1hvt w=(1.9e-07) l=4.5e-08 nf=1 \
        as=4.18e-14 ad=3.23e-14 ps=8.2e-07 pd=7.2e-07 nrd=1.16667 \
        nrs=1.16667 sa=1.7e-07 sb=4.35e-07 sd=160n sca=11.8451 \
        scb=0.0117279 scc=0.00051251 m=(1)
mn3 (n56 \4\:n60 \6\:n50 VSS) g45n1hvt w=(1.9e-07) l=4.5e-08 nf=1 \
        as=4.18e-14 ad=4.31e-14 ps=8.2e-07 pd=9e-07 nrd=1.16667 \
        nrs=1.16667 sa=4.35e-07 sb=1.7e-07 sd=160n sca=11.8451 \
        scb=0.0117279 scc=0.00051251 m=(1)
mn8 (\8\:n60 \6\:C \1\:VSS VSS) g45n1hvt w=(1.9e-07) l=4.5e-08 nf=1 \
        as=1.0475e-13 ad=3.23e-14 ps=1.77e-06 pd=7.2e-07 nrd=1.16667 \
        nrs=1.16667 sa=1.7e-07 sb=5.2e-07 sd=160n sca=20.6114 \
        scb=0.0205722 scc=0.00215666 m=(1)
mn7 (\3\:Y \3\:n50 \1\:VSS VSS) g45n1hvt w=(1.9e-07) l=4.5e-08 nf=1 \
        as=1.0475e-13 ad=3.23e-14 ps=1.77e-06 pd=7.2e-07 nrd=1.16667 \
        nrs=1.16667 sa=5.2e-07 sb=1.7e-07 sd=160n sca=20.6114 \
        scb=0.0205722 scc=0.00215666 m=(1)
mp7 (\1\:Y n50 \1\:VDD VDD) g45p1hvt w=(2.05e-07) l=4.5e-08 nf=1 \
        as=1.265e-13 ad=3.485e-14 ps=1.85e-06 pd=7.5e-07 nrd=1.16667 \
        nrs=1.16667 sa=5.2e-07 sb=1.7e-07 sd=160n sca=28.0221 scb=0.032906 \
        scc=0.00213116 m=(1)
ends XOR3XL
// End of subcircuit definition.
