// Generated for: spectre (May  1 09:13:43 2013 )
// Library name: gsclib045_hvt
// Cell name: CLKBUFX12
// View name: extracted

simulator lang=spectre

subckt CLKBUFX12 A VDD VSS Y
mp1_1__rcx (Y net44 VDD VDD) g45p1hvt w=(4.7e-07) l=4.5e-08 nf=1 \
        as=7.573e-14 ad=7.52e-14 ps=1.266e-06 pd=1.26e-06 nrd=1.16667 \
        nrs=1.16667 sa=1.4e-07 sb=1.99064e-06 sd=160n sca=28.0481 \
        scb=0.031636 scc=0.00223037 m=(10)
C1 (VDD VSS) capacitor c=6.81006e-16
C2 (A VSS) capacitor c=5.11987e-17
C3 (Y VSS) capacitor c=5.25716e-16
C4 (net44 VSS) capacitor c=8.1871e-16
C5 (\1\:A VSS) capacitor c=2.32714e-16
C6 (\31\:net44 VSS) capacitor c=1.39051e-16
C7 (\7\:Y VSS) capacitor c=4.7554e-16
C8 (\10\:A VSS) capacitor c=4.44273e-17
C9 (\34\:net44 VSS) capacitor c=1.08506e-16
Rk19 (A \10\:A) resistor r=0.1302 c=0
Rk5 (Y \7\:Y) resistor r=0.4369 c=0
Rk23 (\34\:net44 net44) resistor r=0.4423 c=0
Rk21 (\31\:net44 \34\:net44) resistor r=0.276 c=0
Rx1 (\10\:A \1\:A) resistor r=45 c=0
mn1_1__rcx (\7\:Y net44 VSS VSS) g45n1hvt w=(3.1e-07) l=4.5e-08 nf=1 \
        as=4.998e-14 ad=4.96e-14 ps=9.46e-07 pd=9.4e-07 nrd=1.16667 \
        nrs=1.16667 sa=1.4e-07 sb=1.99113e-06 sd=160n sca=9.61806 \
        scb=0.00827687 scc=0.000298696 m=(10)
mn0_1__rcx (\34\:net44 \1\:A VSS VSS) g45n1hvt w=(2.6e-07) l=4.5e-08 \
        nf=1 as=4.76e-14 ad=5.373e-14 ps=9.0667e-07 pd=9.3333e-07 \
        nrd=1.16667 nrs=1.16667 sa=2e-06 sb=6.3e-07 sd=160n sca=10.3222 \
        scb=0.00938145 scc=0.000353946 m=(3)
mp0_1__rcx (\31\:net44 \1\:A VDD VDD) g45p1hvt w=(3.9e-07) l=4.5e-08 \
        nf=1 as=7.157e-14 ad=8.06e-14 ps=1.18667e-06 pd=1.19333e-06 \
        nrd=1.16667 nrs=1.16667 sa=2e-06 sb=6.3e-07 sd=160n sca=12.7559 \
        scb=0.0106631 scc=0.000333478 m=(3)
ends CLKBUFX12
// End of subcircuit definition.
