// Generated for: spectre (May  1 09:13:35 2013 )
// Library name: gsclib045_hvt
// Cell name: TBUFXL
// View name: extracted

simulator lang=spectre

subckt TBUFXL A OE VDD VSS Y
mp4 (\5\:pon \3\:OE \6\:VDD VDD) g45p1hvt w=(2.15e-07) l=4.5e-08 nf=1 \
        as=3.01e-14 ad=3.44e-14 ps=7.1e-07 pd=7.5e-07 nrd=1.16667 \
        nrs=1.16667 sa=1.4e-07 sb=6.1e-07 sd=160n sca=23.8733 \
        scb=0.0264891 scc=0.00148688 m=(1)
mp3 (\5\:pon \1\:A \8\:VDD VDD) g45p1hvt w=(2.15e-07) l=4.5e-08 nf=1 \
        as=7.43e-14 ad=3.44e-14 ps=1.32e-06 pd=7.5e-07 nrd=1.16667 \
        nrs=1.16667 sa=3.45e-07 sb=4.05e-07 sd=160n sca=13.8395 \
        scb=0.0118164 scc=0.000122256 m=(1)
mp0 (\6\:OEb \4\:OE \8\:VDD VDD) g45p1hvt w=(2.15e-07) l=4.5e-08 nf=1 \
        as=7.43e-14 ad=3.01e-14 ps=1.32e-06 pd=7.1e-07 nrd=1.16667 \
        nrs=1.16667 sa=6.1e-07 sb=1.4e-07 sd=160n sca=11.1189 \
        scb=0.00792127 scc=8.08408e-05 m=(1)
mp2 (\5\:non OEb net127 VDD) g45p1hvt w=(2.15e-07) l=4.5e-08 nf=1 \
        as=1.29e-14 ad=3.01e-14 ps=5.5e-07 pd=7.1e-07 nrd=1.16667 \
        nrs=1.16667 sa=1.4e-07 sb=5.1e-07 sd=160n sca=28.9946 \
        scb=0.0243497 scc=0.00347661 m=(1)
mp1 (net127 \4\:A \1\:VDD VDD) g45p1hvt w=(2.15e-07) l=4.5e-08 nf=1 \
        as=1.043e-13 ad=1.29e-14 ps=1.82e-06 pd=5.5e-07 nrd=1.16667 \
        nrs=1.16667 sa=2.45e-07 sb=4.05e-07 sd=160n sca=29.4689 \
        scb=0.0246948 scc=0.00347702 m=(1)
mp5 (\1\:Y pon \1\:VDD VDD) g45p1hvt w=(2.15e-07) l=4.5e-08 nf=1 \
        as=1.043e-13 ad=3.01e-14 ps=1.82e-06 pd=7.1e-07 nrd=1.16667 \
        nrs=1.16667 sa=5.1e-07 sb=1.4e-07 sd=160n sca=32.5034 \
        scb=0.0292389 scc=0.00353613 m=(1)
C1 (OE VSS) capacitor c=2.21604e-17
C2 (VDD VSS) capacitor c=1.8931e-16
C3 (A VSS) capacitor c=1.83678e-17
C4 (pon VSS) capacitor c=4.86582e-17
C5 (OEb VSS) capacitor c=6.25111e-17
C6 (non VSS) capacitor c=4.63215e-17
C7 (\4\:A VSS) capacitor c=8.07172e-17
C8 (\4\:OE VSS) capacitor c=5.01905e-17
C9 (\1\:A VSS) capacitor c=4.53026e-17
C10 (\3\:OE VSS) capacitor c=4.41271e-17
C11 (\5\:A VSS) capacitor c=5.74211e-17
C12 (\3\:OEb VSS) capacitor c=3.0725e-17
C13 (\6\:OE VSS) capacitor c=4.25186e-17
C14 (\3\:A VSS) capacitor c=6.5642e-17
C15 (\1\:OE VSS) capacitor c=4.81758e-17
C16 (\2\:pon VSS) capacitor c=2.08242e-17
C17 (\2\:non VSS) capacitor c=4.01256e-17
C18 (\6\:A VSS) capacitor c=2.66037e-17
C19 (\2\:OEb VSS) capacitor c=4.3534e-17
C20 (\5\:OE VSS) capacitor c=4.22448e-17
C21 (\2\:A VSS) capacitor c=6.86384e-17
C22 (\2\:OE VSS) capacitor c=5.56721e-17
C23 (\1\:Y VSS) capacitor c=3.31083e-17
C24 (\1\:VDD VSS) capacitor c=3.82263e-17
C25 (\5\:non VSS) capacitor c=6.10096e-17
C26 (\6\:OEb VSS) capacitor c=8.15421e-17
C27 (\8\:VDD VSS) capacitor c=2.45385e-17
C28 (\5\:pon VSS) capacitor c=1.83542e-16
C29 (\6\:VDD VSS) capacitor c=3.12628e-17
C30 (\3\:Y VSS) capacitor c=4.52945e-17
C31 (\7\:non VSS) capacitor c=3.91306e-17
C32 (\8\:OEb VSS) capacitor c=5.90211e-17
C33 (\3\:pon VSS) capacitor c=7.40779e-17
C34 (\7\:OE VSS) capacitor c=5.249e-17
C35 (\9\:OE VSS) capacitor c=5.56997e-17
C36 (\4\:OEb VSS) capacitor c=3.06565e-17
C37 (\5\:OEb VSS) capacitor c=8.77883e-17
C38 (\7\:A VSS) capacitor c=1.59929e-16
C39 (\8\:A VSS) capacitor c=1.86645e-16
C40 (\3\:non VSS) capacitor c=3.16143e-17
C41 (\4\:non VSS) capacitor c=3.97846e-17
C42 (\7\:pon VSS) capacitor c=1.21116e-16
C43 (\4\:VDD VSS) capacitor c=3.05783e-17
C44 (\5\:VDD VSS) capacitor c=2.17526e-17
Rk3 (\8\:OE OE) resistor r=0.05673 c=0
Rk1 (\7\:OE \8\:OE) resistor r=0.1998 c=0
Rk2 (\8\:OE \9\:OE) resistor r=0.037 c=0
Rk14 (Y \2\:Y) resistor r=0.002901 c=0
Rk15 (\2\:Y \4\:Y) resistor r=0.3392 c=0
Rk21 (\2\:VDD \4\:VDD) resistor r=0.3155 c=0
Rk23 (\5\:VDD VDD) resistor r=0.2195 c=0
Rk22 (\4\:VDD \5\:VDD) resistor r=0.2295 c=0
Rk24 (VDD \7\:VDD) resistor r=0.239 c=0
Rk25 (\5\:VDD \9\:VDD) resistor r=0.04328 c=0
Rk8 (\8\:A A) resistor r=0.02018 c=0
Rk7 (\7\:A \8\:A) resistor r=1.3617 c=0
Rk16 (\2\:VSS \4\:VSS) resistor r=0.07144 c=0
Rk18 (\5\:VSS VSS) resistor r=0.1976 c=0
Rk17 (\4\:VSS \5\:VSS) resistor r=0.253 c=0
Rk19 (\4\:VSS \7\:VSS) resistor r=0.6425 c=0
Rk20 (\5\:VSS \9\:VSS) resistor r=0.2832 c=0
Rk12 (\4\:pon \6\:pon) resistor r=0.671 c=0
Rk13 (\6\:pon \7\:pon) resistor r=1.0729 c=0
Rk4 (\4\:OEb \5\:OEb) resistor r=0.09647 c=0
Rk5 (\5\:OEb \7\:OEb) resistor r=0.5589 c=0
Rk6 (\5\:OEb \9\:OEb) resistor r=0.2473 c=0
Rk9 (\3\:non \4\:non) resistor r=0.1183 c=0
Rk10 (\4\:non \6\:non) resistor r=0.3397 c=0
Rk11 (\4\:non \8\:non) resistor r=0.1145 c=0
Rl5 (\4\:OE \5\:OE) resistor r=131.02 c=0
Rl6 (\5\:OE \6\:OE) resistor r=76.1559 c=0
Rl2 (\2\:OE \3\:OE) resistor r=135.714 c=0
Rl1 (\1\:OE \2\:OE) resistor r=75 c=0
Rl9 (\4\:A \5\:A) resistor r=129.43 c=0
Rl10 (\5\:A \6\:A) resistor r=35.3072 c=0
Rl3 (\1\:A \2\:A) resistor r=60.7713 c=0
Rl4 (\2\:A \3\:A) resistor r=155.323 c=0
Rl12 (pon \2\:pon) resistor r=71.8456 c=0
Rl7 (OEb \2\:OEb) resistor r=93.7849 c=0
Rl8 (\2\:OEb \3\:OEb) resistor r=24.2328 c=0
Rl11 (non \2\:non) resistor r=35.2058 c=0
Rz4 (\3\:Y \4\:Y) resistor r=75 c=0
Rz5 (\1\:VSS \2\:VSS) resistor r=75 c=0
Rz6 (\6\:VSS \7\:VSS) resistor r=75 c=0
Rz7 (\8\:VSS \9\:VSS) resistor r=75 c=0
Rz3 (\3\:pon \4\:pon) resistor r=75 c=0
Rz1 (\8\:OEb \9\:OEb) resistor r=75 c=0
Rz2 (\7\:non \8\:non) resistor r=75 c=0
Ry4 (\1\:Y \2\:Y) resistor r=62 c=0
Ry6 (\1\:VDD \2\:VDD) resistor r=62 c=0
Ry7 (\6\:VDD \7\:VDD) resistor r=62 c=0
Ry8 (\8\:VDD \9\:VDD) resistor r=62 c=0
Ry3 (\5\:pon \6\:pon) resistor r=62 c=0
Ry1 (\6\:OEb \7\:OEb) resistor r=62 c=0
Ry2 (\5\:non \6\:non) resistor r=62 c=0
Rx1 (\5\:OE \7\:OE) resistor r=45 c=0
Rx2 (\2\:OE \9\:OE) resistor r=45 c=0
Rx4 (\6\:A \7\:A) resistor r=45 c=0
Rx5 (\2\:A \8\:A) resistor r=45 c=0
Rx7 (\2\:pon \7\:pon) resistor r=45 c=0
Rx3 (\2\:OEb \4\:OEb) resistor r=45 c=0
Rx6 (\2\:non \3\:non) resistor r=45 c=0
mn4 (\3\:pon \1\:OE net144 VSS) g45n1hvt w=(1.45e-07) l=4.5e-08 nf=1 \
        as=8.7e-15 ad=2.393e-14 ps=4.1e-07 pd=6.2e-07 nrd=1.16667 \
        nrs=1.16667 sa=1.65e-07 sb=6.25e-07 sd=160n sca=13.6097 \
        scb=0.014254 scc=0.000755054 m=(1)
mn3 (net144 \3\:A \8\:VSS VSS) g45n1hvt w=(1.45e-07) l=4.5e-08 nf=1 \
        as=4.358e-14 ad=8.7e-15 ps=9.1e-07 pd=4.1e-07 nrd=1.16667 \
        nrs=1.16667 sa=2.7e-07 sb=5.2e-07 sd=160n sca=13.6097 scb=0.014254 \
        scc=0.000755054 m=(1)
mn0 (\8\:OEb \6\:OE \8\:VSS VSS) g45n1hvt w=(1.45e-07) l=4.5e-08 nf=1 \
        as=4.358e-14 ad=3.19e-14 ps=9.1e-07 pd=7.3e-07 nrd=1.16667 \
        nrs=1.16667 sa=5.7e-07 sb=2.2e-07 sd=160n sca=13.6097 scb=0.014254 \
        scc=0.000755054 m=(1)
mn2 (\7\:non \3\:OEb \1\:VSS VSS) g45n1hvt w=(1.45e-07) l=4.5e-08 nf=1 \
        as=7.025e-14 ad=2.32e-14 ps=1.39e-06 pd=6.1e-07 nrd=1.16667 \
        nrs=1.16667 sa=1.7e-07 sb=5.65e-07 sd=160n sca=15.7071 \
        scb=0.0167369 scc=0.00113434 m=(1)
mn1 (\7\:non \5\:A \6\:VSS VSS) g45n1hvt w=(1.45e-07) l=4.5e-08 nf=1 \
        as=2.537e-14 ad=2.32e-14 ps=6.4e-07 pd=6.1e-07 nrd=1.16667 \
        nrs=1.16667 sa=3.75e-07 sb=3.6e-07 sd=160n sca=15.7071 \
        scb=0.0167369 scc=0.00113434 m=(1)
mn5 (\3\:Y non \6\:VSS VSS) g45n1hvt w=(1.45e-07) l=4.5e-08 nf=1 \
        as=2.537e-14 ad=2.03e-14 ps=6.4e-07 pd=5.7e-07 nrd=1.16667 \
        nrs=1.16667 sa=5.95e-07 sb=1.4e-07 sd=160n sca=15.7071 \
        scb=0.0167369 scc=0.00113434 m=(1)
ends TBUFXL
// End of subcircuit definition.
