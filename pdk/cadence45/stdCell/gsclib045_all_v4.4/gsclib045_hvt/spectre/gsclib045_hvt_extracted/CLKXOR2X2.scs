// Generated for: spectre (May  1 09:14:07 2013 )
// Library name: gsclib045_hvt
// Cell name: CLKXOR2X2
// View name: extracted

simulator lang=spectre

subckt CLKXOR2X2 A B VDD VSS Y
mp5 (\3\:Y n0 \5\:VDD VDD) g45p1hvt w=(3.9e-07) l=4.5e-08 nf=1 \
        as=8.826e-14 ad=6.24e-14 ps=1.45e-06 pd=1.1e-06 nrd=1.16667 \
        nrs=1.16667 sa=1.9e-07 sb=9.73526e-07 sd=160n sca=22.1173 \
        scb=0.0235828 scc=0.00128647 m=(2)
C1 (VDD VSS) capacitor c=1.2638e-16
C2 (Y VSS) capacitor c=6.24434e-17
C3 (B VSS) capacitor c=5.6512e-17
C4 (n0 VSS) capacitor c=1.38487e-16
C5 (n1 VSS) capacitor c=4.8225e-17
C6 (n2 VSS) capacitor c=2.98851e-17
C7 (net130 VSS) capacitor c=1.88405e-18
C8 (\7\:B VSS) capacitor c=3.89021e-17
C9 (\3\:n1 VSS) capacitor c=8.96263e-17
C10 (\2\:n2 VSS) capacitor c=7.86672e-17
C11 (\1\:B VSS) capacitor c=4.17204e-17
C12 (\1\:A VSS) capacitor c=3.59161e-17
C13 (\5\:B VSS) capacitor c=4.14188e-17
C14 (\3\:B VSS) capacitor c=7.01522e-17
C15 (\3\:n2 VSS) capacitor c=6.84166e-17
C16 (\3\:A VSS) capacitor c=4.08917e-17
C17 (\6\:B VSS) capacitor c=5.33881e-17
C18 (\2\:n1 VSS) capacitor c=7.83729e-17
C19 (\4\:B VSS) capacitor c=7.0855e-17
C20 (\2\:B VSS) capacitor c=4.42822e-17
C21 (\2\:A VSS) capacitor c=3.59421e-17
C22 (\8\:n2 VSS) capacitor c=1.08958e-17
C23 (\1\:VDD VSS) capacitor c=6.78052e-17
C24 (\10\:n0 VSS) capacitor c=1.13681e-16
C25 (\6\:n1 VSS) capacitor c=5.97862e-17
C26 (\3\:Y VSS) capacitor c=8.59937e-17
C27 (\4\:n2 VSS) capacitor c=5.56415e-17
C28 (\7\:n0 VSS) capacitor c=1.03976e-16
C29 (\8\:n1 VSS) capacitor c=3.78307e-17
C30 (\1\:Y VSS) capacitor c=4.49962e-17
C31 (\4\:A VSS) capacitor c=1.29454e-16
C32 (\9\:n0 VSS) capacitor c=2.55434e-16
C33 (\4\:n1 VSS) capacitor c=8.93173e-17
C34 (\5\:n1 VSS) capacitor c=9.09055e-17
C35 (\8\:B VSS) capacitor c=2.95104e-17
C36 (\9\:B VSS) capacitor c=3.35495e-17
C37 (\10\:B VSS) capacitor c=4.60576e-17
C38 (\6\:n2 VSS) capacitor c=1.11673e-16
C39 (\7\:n2 VSS) capacitor c=8.18396e-17
C40 (\4\:VDD VSS) capacitor c=3.70778e-17
C41 (\5\:VDD VSS) capacitor c=9.01807e-17
Rk3 (A \4\:A) resistor r=0.03171 c=0
Rk21 (\2\:VDD \4\:VDD) resistor r=0.5922 c=0
Rk24 (\5\:VDD VDD) resistor r=0.02463 c=0
Rk22 (\4\:VDD \5\:VDD) resistor r=0.1794 c=0
Rk15 (\2\:VSS \4\:VSS) resistor r=0.6099 c=0
Rk18 (\5\:VSS VSS) resistor r=0.02463 c=0
Rk16 (\4\:VSS \5\:VSS) resistor r=0.1954 c=0
Rk1 (\2\:Y Y) resistor r=0.1481 c=0
Rk2 (Y \4\:Y) resistor r=0.4376 c=0
Rk9 (\8\:B B) resistor r=0.1668 c=0
Rk10 (B \9\:B) resistor r=0.06849 c=0
Rk11 (\9\:B \10\:B) resistor r=0.2021 c=0
Rk4 (\8\:n0 \9\:n0) resistor r=0.9513 c=0
Rk5 (\9\:n0 \11\:n0) resistor r=0.9572 c=0
Rk6 (\4\:n1 \5\:n1) resistor r=0.4557 c=0
Rk7 (\5\:n1 \7\:n1) resistor r=0.3155 c=0
Rk8 (\5\:n1 \9\:n1) resistor r=0.1277 c=0
Rk12 (\5\:n2 \6\:n2) resistor r=0.524 c=0
Rk13 (\6\:n2 \7\:n2) resistor r=0.6001 c=0
Rk14 (\6\:n2 \9\:n2) resistor r=0.04786 c=0
Rl6 (\1\:A \2\:A) resistor r=60.7134 c=0
Rl7 (\2\:A \3\:A) resistor r=99.1749 c=0
Rl15 (\6\:B \7\:B) resistor r=78.8233 c=0
Rl14 (\5\:B \6\:B) resistor r=86.3335 c=0
Rl11 (\3\:B \4\:B) resistor r=89.6174 c=0
Rl8 (\1\:B \2\:B) resistor r=71.8456 c=0
Rl13 (\2\:n1 \3\:n1) resistor r=149.361 c=0
Rl12 (n1 \2\:n1) resistor r=31.791 c=0
Rl10 (\2\:n2 \3\:n2) resistor r=208.747 c=0
Rl9 (n2 \2\:n2) resistor r=24.2328 c=0
Rz5 (\2\:VSS \1\:VSS) resistor r=75 c=0
Rz1 (\2\:Y \1\:Y) resistor r=75 c=0
Rz2 (\8\:n0 \7\:n0) resistor r=75 c=0
Rz3 (\8\:n1 \9\:n1) resistor r=75 c=0
Rz4 (\4\:n2 \5\:n2) resistor r=75 c=0
Ry6 (\2\:VDD \1\:VDD) resistor r=62 c=0
Ry1 (\4\:Y \3\:Y) resistor r=62 c=0
Ry2 (\11\:n0 \10\:n0) resistor r=62 c=0
Ry3 (\6\:n1 \7\:n1) resistor r=62 c=0
Ry4 (\8\:n2 \9\:n2) resistor r=62 c=0
Rx1 (\2\:A \4\:A) resistor r=45 c=0
Rx4 (\6\:B \8\:B) resistor r=45 c=0
Rx5 (\4\:B \9\:B) resistor r=45 c=0
Rx6 (\2\:B \10\:B) resistor r=45 c=0
Rx2 (\9\:n0 n0) resistor r=45 c=0
Rx3 (\2\:n1 \4\:n1) resistor r=45 c=0
Rx7 (n2 \7\:n2) resistor r=45 c=0
mn5 (\1\:Y n0 \5\:VSS VSS) g45n1hvt w=(2.6e-07) l=4.5e-08 nf=1 \
        as=4.483e-14 ad=4.16e-14 ps=9e-07 pd=8.4e-07 nrd=1.16667 \
        nrs=1.16667 sa=1.9e-07 sb=9.95577e-07 sd=160n sca=17.5885 \
        scb=0.0172826 scc=0.00162584 m=(2)
mn0 (\8\:n1 \3\:A \5\:VSS VSS) g45n1hvt w=(1.45e-07) l=4.5e-08 nf=1 \
        as=4.025e-14 ad=5.728e-14 ps=9e-07 pd=1.08e-06 nrd=1.16667 \
        nrs=1.16667 sa=6.3e-07 sb=1.095e-06 sd=160n sca=13.253 \
        scb=0.0137915 scc=0.000695334 m=(1)
mn4 (\7\:n0 \3\:n2 \8\:n1 VSS) g45n1hvt w=(1.45e-07) l=4.5e-08 nf=1 \
        as=5.728e-14 ad=2.32e-14 ps=1.08e-06 pd=6.1e-07 nrd=1.16667 \
        nrs=1.16667 sa=1.07e-06 sb=6.55e-07 sd=160n sca=13.253 \
        scb=0.0137915 scc=0.000695334 m=(1)
mn3 (\7\:n0 \3\:B net139 VSS) g45n1hvt w=(1.45e-07) l=4.5e-08 nf=1 \
        as=8.7e-15 ad=2.32e-14 ps=4.1e-07 pd=6.1e-07 nrd=1.16667 \
        nrs=1.16667 sa=1.275e-06 sb=4.5e-07 sd=160n sca=13.253 \
        scb=0.0137915 scc=0.000695334 m=(1)
mn2 (net139 n1 \1\:VSS VSS) g45n1hvt w=(1.45e-07) l=4.5e-08 nf=1 \
        as=2.32e-14 ad=8.7e-15 ps=6.1e-07 pd=4.1e-07 nrd=1.16667 \
        nrs=1.16667 sa=1.38e-06 sb=3.45e-07 sd=160n sca=13.253 \
        scb=0.0137915 scc=0.000695334 m=(1)
mn1 (\4\:n2 \5\:B \1\:VSS VSS) g45n1hvt w=(1.45e-07) l=4.5e-08 nf=1 \
        as=2.32e-14 ad=2.03e-14 ps=6.1e-07 pd=5.7e-07 nrd=1.16667 \
        nrs=1.16667 sa=1.585e-06 sb=1.4e-07 sd=160n sca=13.253 \
        scb=0.0137915 scc=0.000695334 m=(1)
mp0 (\6\:n1 \1\:A \5\:VDD VDD) g45p1hvt w=(2.15e-07) l=4.5e-08 nf=1 \
        as=1.0243e-13 ad=5.805e-14 ps=1.74e-06 pd=9.7e-07 nrd=1.16667 \
        nrs=1.16667 sa=6.65e-07 sb=1.015e-06 sd=160n sca=13.1802 \
        scb=0.0118482 scc=0.000425234 m=(1)
mp4 (\10\:n0 \1\:B \6\:n1 VDD) g45p1hvt w=(2.15e-07) l=4.5e-08 nf=1 \
        as=5.805e-14 ad=3.87e-14 ps=9.7e-07 pd=7.9e-07 nrd=1.16667 \
        nrs=1.16667 sa=9.8e-07 sb=7e-07 sd=160n sca=12.8224 scb=0.011715 \
        scc=0.000425192 m=(1)
mp3 (\10\:n0 \2\:n2 net130 VDD) g45p1hvt w=(2.15e-07) l=4.5e-08 nf=1 \
        as=1.828e-14 ad=3.87e-14 ps=6e-07 pd=7.9e-07 nrd=1.16667 \
        nrs=1.16667 sa=1.205e-06 sb=4.75e-07 sd=160n sca=13.569 \
        scb=0.0120992 scc=0.00042546 m=(1)
mp2 (net130 \3\:n1 \1\:VDD VDD) g45p1hvt w=(2.15e-07) l=4.5e-08 nf=1 \
        as=3.44e-14 ad=1.828e-14 ps=7.5e-07 pd=6e-07 nrd=1.16667 \
        nrs=1.16667 sa=1.335e-06 sb=3.45e-07 sd=160n sca=14.4226 \
        scb=0.0130013 scc=0.000428203 m=(1)
mp1 (\8\:n2 \7\:B \1\:VDD VDD) g45p1hvt w=(2.15e-07) l=4.5e-08 nf=1 \
        as=3.44e-14 ad=3.01e-14 ps=7.5e-07 pd=7.1e-07 nrd=1.16667 \
        nrs=1.16667 sa=1.54e-06 sb=1.4e-07 sd=160n sca=17.794 \
        scb=0.0186079 scc=0.000545865 m=(1)
ends CLKXOR2X2
// End of subcircuit definition.
