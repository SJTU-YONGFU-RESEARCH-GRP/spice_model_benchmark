// Generated for: spectre (May  1 09:15:44 2013 )
// Library name: gsclib045_hvt
// Cell name: SDFFRX4
// View name: extracted

simulator lang=spectre

subckt SDFFRX4 CK D Q QN RN SE SI VDD VSS
mp10 (\8\:SEb \1\:SE \39\:VDD VDD) g45p1hvt w=(2.15e-07) l=4.5e-08 nf=1 \
        as=3.44e-14 ad=3.01e-14 ps=7.5e-07 pd=7.1e-07 nrd=1.16667 \
        nrs=1.16667 sa=1.4e-07 sb=1.32e-06 sd=160n sca=14.1047 \
        scb=0.0123052 scc=0.000144089 m=(1)
mp13 (n4 \1\:SI \39\:VDD VDD) g45p1hvt w=(2.15e-07) l=4.5e-08 nf=1 \
        as=3.44e-14 ad=4.193e-14 ps=7.5e-07 pd=8.2e-07 nrd=1.16667 \
        nrs=1.16667 sa=3.45e-07 sb=1.115e-06 sd=160n sca=11.6656 \
        scb=0.00859665 scc=9.9547e-05 m=(1)
mp14 (\8\:Db \3\:SEb n4 VDD) g45p1hvt w=(2.15e-07) l=4.5e-08 nf=1 \
        as=4.192e-14 ad=5.697e-14 ps=8.2e-07 pd=9.6e-07 nrd=1.16667 \
        nrs=1.16667 sa=5.85e-07 sb=8.75e-07 sd=160n sca=10.6337 \
        scb=0.00785382 scc=9.84653e-05 m=(1)
mp12 (\8\:Db \6\:SE n2 VDD) g45p1hvt w=(2.15e-07) l=4.5e-08 nf=1 \
        as=1.29e-14 ad=5.697e-14 ps=5.5e-07 pd=9.6e-07 nrd=1.16667 \
        nrs=1.16667 sa=8.95e-07 sb=5.65e-07 sd=160n sca=10.3756 \
        scb=0.00778655 scc=9.84544e-05 m=(1)
mp11 (n2 \1\:D \37\:VDD VDD) g45p1hvt w=(2.15e-07) l=4.5e-08 nf=1 \
        as=3.44e-14 ad=1.29e-14 ps=7.5e-07 pd=5.5e-07 nrd=1.16667 \
        nrs=1.16667 sa=1e-06 sb=4.6e-07 sd=160n sca=10.3756 scb=0.00778655 \
        scc=9.84544e-05 m=(1)
mp20 (\17\:CKb \1\:CK \37\:VDD VDD) g45p1hvt w=(2.15e-07) l=4.5e-08 nf=1 \
        as=3.44e-14 ad=5.483e-14 ps=7.5e-07 pd=9.4e-07 nrd=1.16667 \
        nrs=1.16667 sa=1.205e-06 sb=2.55e-07 sd=160n sca=10.3756 \
        scb=0.00778655 scc=9.84544e-05 m=(1)
mp21 (\13\:Ckbb \4\:CKb \35\:VDD VDD) g45p1hvt w=(2.15e-07) l=4.5e-08 \
        nf=1 as=4.98e-14 ad=3.01e-14 ps=1.44e-06 pd=7.1e-07 nrd=1.16667 \
        nrs=1.16667 sa=1e-07 sb=1.4e-07 sd=160n sca=45.7906 scb=0.0283307 \
        scc=0.00588417 m=(1)
mp25 (\7\:n20 Ckbb \3\:Db VDD) g45p1hvt w=(2.15e-07) l=4.5e-08 nf=1 \
        as=3.01e-14 ad=3.44e-14 ps=7.1e-07 pd=7.5e-07 nrd=1.16667 \
        nrs=1.16667 sa=1.4e-07 sb=3.8e-07 sd=160n sca=45.7906 \
        scb=0.0283307 scc=0.00588417 m=(1)
mp37 (\7\:n20 \6\:CKb n6 VDD) g45p1hvt w=(2.15e-07) l=4.5e-08 nf=1 \
        as=3.762e-14 ad=3.44e-14 ps=7.8e-07 pd=7.5e-07 nrd=1.16667 \
        nrs=1.16667 sa=3.45e-07 sb=1.75e-07 sd=160n sca=45.7906 \
        scb=0.0283307 scc=0.00588417 m=(1)
mp36 (\3\:n6 \3\:mout \33\:VDD VDD) g45p1hvt w=(2.15e-07) l=4.5e-08 nf=1 \
        as=7.795e-14 ad=3.44e-14 ps=1.81e-06 pd=7.5e-07 nrd=1.16667 \
        nrs=1.16667 sa=1.47674e-07 sb=2e-06 sd=160n sca=15.2551 \
        scb=0.0150251 scc=0.000885438 m=(1)
mp35 (\3\:n6 \1\:RN \31\:VDD VDD) g45p1hvt w=(2.15e-07) l=4.5e-08 nf=1 \
        as=1.1823e-13 ad=3.44e-14 ps=1.87e-06 pd=7.5e-07 nrd=1.16667 \
        nrs=1.16667 sa=3.52674e-07 sb=2e-06 sd=160n sca=15.2551 \
        scb=0.0150251 scc=0.000885438 m=(1)
mp30 (\8\:mout n20 \31\:VDD VDD) g45p1hvt w=(2.15e-07) l=4.5e-08 nf=1 \
        as=1.1823e-13 ad=3.44e-14 ps=1.87e-06 pd=7.5e-07 nrd=1.16667 \
        nrs=1.16667 sa=7.32674e-07 sb=2e-06 sd=160n sca=15.2551 \
        scb=0.0150251 scc=0.000885438 m=(1)
mp40 (\13\:n30 \9\:CKb \8\:mout VDD) g45p1hvt w=(2.15e-07) l=4.5e-08 nf=1 \
        as=3.44e-14 ad=3.762e-14 ps=7.5e-07 pd=7.8e-07 nrd=1.16667 \
        nrs=1.16667 sa=9.37674e-07 sb=2e-06 sd=160n sca=15.2551 \
        scb=0.0150251 scc=0.000885438 m=(1)
mp51 (\13\:n30 \5\:Ckbb n8 VDD) g45p1hvt w=(2.15e-07) l=4.5e-08 nf=1 \
        as=3.548e-14 ad=3.762e-14 ps=7.6e-07 pd=7.8e-07 nrd=1.16667 \
        nrs=1.16667 sa=1.15767e-06 sb=2e-06 sd=160n sca=15.2551 \
        scb=0.0150251 scc=0.000885438 m=(1)
mp50 (n8 \3\:qbint \3\:VDD VDD) g45p1hvt w=(2.15e-07) l=4.5e-08 nf=1 \
        as=6.97e-14 ad=3.548e-14 ps=1.18e-06 pd=7.6e-07 nrd=1.16667 \
        nrs=1.16667 sa=1.36767e-06 sb=2e-06 sd=160n sca=15.2551 \
        scb=0.0150251 scc=0.000885438 m=(1)
C1 (RN VSS) capacitor c=9.62889e-18
C2 (Q VSS) capacitor c=2.33672e-17
C3 (SI VSS) capacitor c=5.25256e-17
C4 (QN VSS) capacitor c=2.09398e-17
C5 (VDD VSS) capacitor c=4.95253e-16
C6 (CK VSS) capacitor c=7.83984e-17
C7 (D VSS) capacitor c=3.90105e-17
C8 (SEb VSS) capacitor c=6.3957e-17
C9 (n3 VSS) capacitor c=8.64555e-20
C10 (Db VSS) capacitor c=6.93067e-17
C11 (n1 VSS) capacitor c=4.33203e-18
C12 (CKb VSS) capacitor c=1.92188e-17
C13 (Ckbb VSS) capacitor c=5.08643e-17
C14 (n20 VSS) capacitor c=5.9691e-17
C15 (mout VSS) capacitor c=9.47725e-17
C16 (n30 VSS) capacitor c=9.63666e-17
C17 (n11 VSS) capacitor c=9.10397e-19
C18 (qbint VSS) capacitor c=6.18603e-17
C19 (29 VSS) capacitor c=1.18163e-18
C20 (qint VSS) capacitor c=2.90109e-16
C21 (n6 VSS) capacitor c=6.99202e-17
C22 (n8 VSS) capacitor c=2.23881e-18
C23 (\23\:qbint VSS) capacitor c=4.74243e-17
C24 (\4\:qbint VSS) capacitor c=2.69036e-16
C25 (\3\:qbint VSS) capacitor c=3.35992e-17
C26 (\5\:Ckbb VSS) capacitor c=7.83871e-17
C27 (\9\:CKb VSS) capacitor c=5.2352e-17
C28 (\1\:RN VSS) capacitor c=4.56797e-17
C29 (\3\:mout VSS) capacitor c=3.75241e-17
C30 (\6\:CKb VSS) capacitor c=3.68071e-17
C31 (\4\:CKb VSS) capacitor c=2.5472e-17
C32 (\1\:CK VSS) capacitor c=5.50201e-17
C33 (\1\:D VSS) capacitor c=9.13212e-17
C34 (\6\:SE VSS) capacitor c=5.89738e-17
C35 (\3\:SEb VSS) capacitor c=2.82319e-17
C36 (\1\:SI VSS) capacitor c=5.67418e-17
C37 (\1\:SE VSS) capacitor c=5.80475e-17
C38 (\21\:qbint VSS) capacitor c=3.1405e-17
C39 (\9\:RN VSS) capacitor c=4.8411e-17
C40 (\6\:n30 VSS) capacitor c=3.23425e-17
C41 (\5\:n30 VSS) capacitor c=4.29652e-17
C42 (\4\:RN VSS) capacitor c=5.00516e-17
C43 (\11\:CKb VSS) capacitor c=5.85869e-17
C44 (\6\:Ckbb VSS) capacitor c=8.10412e-17
C45 (\4\:n20 VSS) capacitor c=3.4686e-17
C46 (\3\:RN VSS) capacitor c=5.60653e-17
C47 (\3\:Ckbb VSS) capacitor c=6.76545e-17
C48 (\8\:CKb VSS) capacitor c=3.955e-17
C49 (\3\:CK VSS) capacitor c=2.71903e-17
C50 (\3\:D VSS) capacitor c=3.85963e-17
C51 (\4\:SE VSS) capacitor c=6.56828e-17
C52 (\3\:SI VSS) capacitor c=6.49516e-17
C53 (\3\:SE VSS) capacitor c=2.31382e-17
C54 (\22\:qbint VSS) capacitor c=3.13027e-17
C55 (\13\:qbint VSS) capacitor c=2.53607e-17
C56 (\7\:n30 VSS) capacitor c=1.38362e-17
C57 (\5\:RN VSS) capacitor c=4.48713e-16
C58 (\2\:qbint VSS) capacitor c=4.58507e-17
C59 (\12\:CKb VSS) capacitor c=4.56623e-17
C60 (\10\:CKb VSS) capacitor c=2.31925e-17
C61 (\3\:n20 VSS) capacitor c=2.97867e-17
C62 (\7\:Ckbb VSS) capacitor c=4.76758e-17
C63 (\2\:RN VSS) capacitor c=5.69972e-17
C64 (\2\:mout VSS) capacitor c=5.78251e-17
C65 (\4\:Ckbb VSS) capacitor c=2.56227e-17
C66 (\7\:CKb VSS) capacitor c=2.54371e-17
C67 (\2\:Ckbb VSS) capacitor c=3.8198e-17
C68 (\5\:CKb VSS) capacitor c=2.52076e-17
C69 (\3\:CKb VSS) capacitor c=7.16119e-18
C70 (\2\:CK VSS) capacitor c=5.16093e-17
C71 (\2\:D VSS) capacitor c=5.46689e-17
C72 (\7\:SE VSS) capacitor c=4.25082e-17
C73 (\2\:SEb VSS) capacitor c=5.39758e-17
C74 (\5\:SE VSS) capacitor c=4.98961e-17
C75 (\2\:SI VSS) capacitor c=6.79805e-17
C76 (\2\:SE VSS) capacitor c=5.92793e-17
C77 (\19\:qint VSS) capacitor c=3.68277e-17
C78 (\1\:QN VSS) capacitor c=1.70351e-16
C79 (\1\:Q VSS) capacitor c=1.74601e-16
C80 (\27\:VDD VSS) capacitor c=3.48328e-17
C81 (\13\:n30 VSS) capacitor c=8.93465e-17
C82 (\8\:mout VSS) capacitor c=2.18363e-17
C83 (\31\:VDD VSS) capacitor c=2.10592e-17
C84 (\3\:n6 VSS) capacitor c=7.23359e-17
C85 (\33\:VDD VSS) capacitor c=1.772e-17
C86 (\7\:n20 VSS) capacitor c=7.36972e-17
C87 (\3\:Db VSS) capacitor c=2.59973e-16
C88 (\13\:Ckbb VSS) capacitor c=5.03475e-17
C89 (\35\:VDD VSS) capacitor c=4.77777e-17
C90 (\17\:CKb VSS) capacitor c=8.97718e-17
C91 (\37\:VDD VSS) capacitor c=4.27953e-17
C92 (\8\:Db VSS) capacitor c=1.59927e-17
C93 (\39\:VDD VSS) capacitor c=2.75493e-17
C94 (\8\:SEb VSS) capacitor c=1.46218e-17
C95 (\1\:VDD VSS) capacitor c=8.25368e-17
C96 (\15\:qint VSS) capacitor c=4.19575e-17
C97 (\4\:QN VSS) capacitor c=1.15915e-16
C98 (\35\:qbint VSS) capacitor c=1.08437e-16
C99 (\15\:n30 VSS) capacitor c=2.6998e-17
C100 (\4\:mout VSS) capacitor c=8.26425e-17
C101 (\9\:n20 VSS) capacitor c=2.60468e-17
C102 (\11\:Ckbb VSS) capacitor c=3.29697e-17
C103 (\15\:CKb VSS) capacitor c=5.67052e-17
C104 (\6\:Db VSS) capacitor c=1.20789e-16
C105 (\6\:SEb VSS) capacitor c=7.09073e-17
C106 (\2\:CKb VSS) capacitor c=8.34758e-18
C107 (\2\:n20 VSS) capacitor c=2.83943e-17
C108 (\3\:n30 VSS) capacitor c=2.79452e-17
C109 (\4\:n30 VSS) capacitor c=2.87694e-17
C110 (\4\:SI VSS) capacitor c=5.83986e-17
C111 (\4\:SEb VSS) capacitor c=6.60744e-17
C112 (\5\:SEb VSS) capacitor c=8.55173e-17
C113 (\8\:SE VSS) capacitor c=1.87915e-16
C114 (\9\:SE VSS) capacitor c=1.40931e-16
C115 (\10\:SE VSS) capacitor c=3.22764e-17
C116 (\11\:SE VSS) capacitor c=4.43552e-17
C117 (\5\:D VSS) capacitor c=9.38002e-17
C118 (\4\:CK VSS) capacitor c=4.18721e-17
C119 (\13\:CKb VSS) capacitor c=3.36184e-17
C120 (\14\:CKb VSS) capacitor c=8.00513e-17
C121 (\5\:Db VSS) capacitor c=2.70943e-16
C122 (\8\:Ckbb VSS) capacitor c=4.48944e-17
C123 (\9\:Ckbb VSS) capacitor c=9.74916e-17
C124 (\10\:Ckbb VSS) capacitor c=7.73493e-17
C125 (\5\:n20 VSS) capacitor c=7.56036e-17
C126 (\6\:n20 VSS) capacitor c=7.05498e-17
C127 (\6\:mout VSS) capacitor c=1.14255e-16
C128 (\7\:mout VSS) capacitor c=9.55609e-17
C129 (\19\:CKb VSS) capacitor c=1.61657e-16
C130 (\20\:CKb VSS) capacitor c=6.47176e-17
C131 (\21\:CKb VSS) capacitor c=1.60179e-16
C132 (\22\:CKb VSS) capacitor c=1.10725e-16
C133 (\11\:n30 VSS) capacitor c=1.26963e-16
C134 (\12\:n30 VSS) capacitor c=1.4253e-16
C135 (\11\:RN VSS) capacitor c=1.98727e-16
C136 (\12\:RN VSS) capacitor c=8.83666e-17
C137 (\24\:qbint VSS) capacitor c=3.886e-17
C138 (\25\:qbint VSS) capacitor c=1.84855e-16
C139 (\27\:qbint VSS) capacitor c=6.48917e-17
C140 (\4\:Q VSS) capacitor c=1.24664e-16
C141 (\32\:qbint VSS) capacitor c=1.27561e-16
C142 (\33\:qbint VSS) capacitor c=2.28337e-16
C143 (\34\:qbint VSS) capacitor c=4.06073e-17
C144 (\17\:qint VSS) capacitor c=3.43684e-17
C145 (\18\:qint VSS) capacitor c=2.96141e-17
C146 (\3\:VDD VSS) capacitor c=5.33452e-16
C147 (\12\:VDD VSS) capacitor c=3.54341e-17
C148 (\13\:VDD VSS) capacitor c=4.3771e-17
C149 (\14\:VDD VSS) capacitor c=2.7627e-17
C150 (\16\:VDD VSS) capacitor c=2.67309e-17
Rk40 (\11\:RN RN) resistor r=0.003081 c=0
Rk37 (\5\:RN \11\:RN) resistor r=1.2016 c=0
Rk38 (\11\:RN \12\:RN) resistor r=0.4973 c=0
Rk47 (\1\:Q Q) resistor r=0.07816 c=0
Rk48 (Q \4\:Q) resistor r=0.2117 c=0
Rk5 (\8\:SE \9\:SE) resistor r=1.2212 c=0
Rk6 (\9\:SE \10\:SE) resistor r=0.0935 c=0
Rk8 (\11\:SE SE) resistor r=0.003679 c=0
Rk7 (\9\:SE \11\:SE) resistor r=0.1995 c=0
Rk1 (\4\:SI SI) resistor r=0.01562 c=0
Rk53 (\1\:QN QN) resistor r=0.07599 c=0
Rk54 (QN \4\:QN) resistor r=0.2228 c=0
Rk85 (\2\:VDD \3\:VDD) resistor r=0.06252 c=0
Rk93 (\3\:VDD \11\:VDD) resistor r=0.4216 c=0
Rk94 (\11\:VDD \12\:VDD) resistor r=0.3755 c=0
Rk95 (\12\:VDD \13\:VDD) resistor r=0.4226 c=0
Rk96 (\13\:VDD \14\:VDD) resistor r=0.3207 c=0
Rk97 (\14\:VDD \15\:VDD) resistor r=0.08259 c=0
Rk99 (\16\:VDD VDD) resistor r=0.2028 c=0
Rk98 (\15\:VDD \16\:VDD) resistor r=0.3485 c=0
Rk105 (\3\:VDD \28\:VDD) resistor r=0.273 c=0
Rk107 (\11\:VDD \32\:VDD) resistor r=0.1494 c=0
Rk108 (\12\:VDD \34\:VDD) resistor r=0.04333 c=0
Rk109 (\13\:VDD \36\:VDD) resistor r=0.2398 c=0
Rk110 (\14\:VDD \38\:VDD) resistor r=0.184 c=0
Rk111 (\16\:VDD \40\:VDD) resistor r=0.1747 c=0
Rk12 (CK \4\:CK) resistor r=0.1172 c=0
Rk11 (D \5\:D) resistor r=0.06012 c=0
Rk63 (\2\:VSS \3\:VSS) resistor r=0.06659 c=0
Rk71 (\3\:VSS \14\:VSS) resistor r=0.4427 c=0
Rk72 (\14\:VSS \15\:VSS) resistor r=0.5015 c=0
Rk73 (\15\:VSS \16\:VSS) resistor r=0.8759 c=0
Rk74 (\16\:VSS \17\:VSS) resistor r=0.263 c=0
Rk75 (\17\:VSS \18\:VSS) resistor r=0.06503 c=0
Rk77 (\19\:VSS VSS) resistor r=0.1425 c=0
Rk76 (\18\:VSS \19\:VSS) resistor r=0.4087 c=0
Rk80 (\14\:VSS \25\:VSS) resistor r=0.1029 c=0
Rk81 (\15\:VSS \27\:VSS) resistor r=0.3735 c=0
Rk82 (\16\:VSS \29\:VSS) resistor r=0.3759 c=0
Rk83 (\17\:VSS \31\:VSS) resistor r=0.2753 c=0
Rk84 (\19\:VSS \33\:VSS) resistor r=0.2756 c=0
Rk2 (\4\:SEb \5\:SEb) resistor r=0.42 c=0
Rk3 (\5\:SEb \7\:SEb) resistor r=0.669 c=0
Rk4 (\5\:SEb \9\:SEb) resistor r=0.04813 c=0
Rk16 (\2\:Db \4\:Db) resistor r=0.4418 c=0
Rk17 (\4\:Db \5\:Db) resistor r=1.6409 c=0
Rk18 (\5\:Db \7\:Db) resistor r=0.7439 c=0
Rk19 (\5\:Db \9\:Db) resistor r=0.0745 c=0
Rk13 (\13\:CKb \14\:CKb) resistor r=0.1766 c=0
Rk14 (\14\:CKb \16\:CKb) resistor r=0.2999 c=0
Rk15 (\14\:CKb \18\:CKb) resistor r=0.4265 c=0
Rk31 (\19\:CKb \20\:CKb) resistor r=0.3441 c=0
Rk32 (\19\:CKb \21\:CKb) resistor r=1.0203 c=0
Rk33 (\21\:CKb \22\:CKb) resistor r=0.6479 c=0
Rk21 (\8\:Ckbb \9\:Ckbb) resistor r=0.2893 c=0
Rk22 (\9\:Ckbb \10\:Ckbb) resistor r=0.7846 c=0
Rk23 (\10\:Ckbb \12\:Ckbb) resistor r=0.1632 c=0
Rk24 (\12\:Ckbb \14\:Ckbb) resistor r=0.2407 c=0
Rk25 (\5\:n20 \6\:n20) resistor r=0.4458 c=0
Rk26 (\6\:n20 \8\:n20) resistor r=0.346 c=0
Rk27 (\6\:n20 \10\:n20) resistor r=0.1277 c=0
Rk28 (\5\:mout \6\:mout) resistor r=0.4669 c=0
Rk29 (\6\:mout \7\:mout) resistor r=0.5867 c=0
Rk30 (\6\:mout \9\:mout) resistor r=0.03287 c=0
Rk34 (\11\:n30 \12\:n30) resistor r=0.7801 c=0
Rk35 (\12\:n30 \14\:n30) resistor r=0.5019 c=0
Rk36 (\12\:n30 \16\:n30) resistor r=0.03063 c=0
Rk41 (\24\:qbint \25\:qbint) resistor r=0.2725 c=0
Rk43 (\25\:qbint \27\:qbint) resistor r=0.3392 c=0
Rk57 (\32\:qbint \33\:qbint) resistor r=1.0529 c=0
Rk58 (\33\:qbint \34\:qbint) resistor r=0.2134 c=0
Rk59 (\33\:qbint \36\:qbint) resistor r=0.9778 c=0
Rk60 (\16\:qint \17\:qint) resistor r=0.2712 c=0
Rk61 (\17\:qint \18\:qint) resistor r=0.1876 c=0
Rk62 (\17\:qint \20\:qint) resistor r=0.1489 c=0
Rk20 (\2\:n6 \4\:n6) resistor r=0.2612 c=0
Rl47 (\5\:RN \9\:RN) resistor r=30.5643 c=0
Rl34 (\5\:RN \4\:RN) resistor r=26.9231 c=0
Rl23 (\2\:RN \1\:RN) resistor r=63.4615 c=0
Rl24 (\2\:RN \3\:RN) resistor r=87.9121 c=0
Rl8 (\6\:SE \7\:SE) resistor r=73.7687 c=0
Rl5 (\4\:SE \5\:SE) resistor r=43.4636 c=0
Rl1 (\1\:SE \2\:SE) resistor r=236.104 c=0
Rl2 (\2\:SE \3\:SE) resistor r=39.5604 c=0
Rl3 (\1\:SI \2\:SI) resistor r=148.077 c=0
Rl4 (\2\:SI \3\:SI) resistor r=120.33 c=0
Rl11 (\1\:CK \2\:CK) resistor r=219.923 c=0
Rl12 (\2\:CK \3\:CK) resistor r=46.8456 c=0
Rl9 (\1\:D \2\:D) resistor r=179.538 c=0
Rl10 (\2\:D \3\:D) resistor r=88.2781 c=0
Rl7 (\2\:SEb \3\:SEb) resistor r=24.2328 c=0
Rl6 (SEb \2\:SEb) resistor r=236.583 c=0
Rl19 (\6\:CKb \8\:CKb) resistor r=125 c=0
Rl31 (\11\:CKb \12\:CKb) resistor r=49.2328 c=0
Rl28 (\9\:CKb \10\:CKb) resistor r=24.2328 c=0
Rl18 (\6\:CKb \7\:CKb) resistor r=29.5379 c=0
Rl16 (\4\:CKb \5\:CKb) resistor r=84.9359 c=0
Rl15 (\2\:CKb \4\:CKb) resistor r=47.791 c=0
Rl13 (CKb \2\:CKb) resistor r=36.2526 c=0
Rl14 (\2\:CKb \3\:CKb) resistor r=1.2666 c=0
Rl29 (\5\:Ckbb \6\:Ckbb) resistor r=201.161 c=0
Rl30 (\6\:Ckbb \7\:Ckbb) resistor r=291.821 c=0
Rl20 (\3\:Ckbb \4\:Ckbb) resistor r=53.079 c=0
Rl17 (Ckbb \2\:Ckbb) resistor r=121.131 c=0
Rl25 (n20 \2\:n20) resistor r=143.464 c=0
Rl27 (\2\:n20 \4\:n20) resistor r=28.0797 c=0
Rl26 (\2\:n20 \3\:n20) resistor r=64.2411 c=0
Rl22 (\2\:mout \3\:mout) resistor r=24.2328 c=0
Rl21 (mout \2\:mout) resistor r=122.31 c=0
Rl42 (n30 \7\:n30) resistor r=11.572 c=0
Rl37 (\3\:n30 n30) resistor r=95.1951 c=0
Rl40 (\3\:n30 \6\:n30) resistor r=37.6951 c=0
Rl39 (\4\:n30 \5\:n30) resistor r=34.6788 c=0
Rl41 (\4\:n30 \7\:n30) resistor r=20.9149 c=0
Rl38 (\4\:n30 \3\:n30) resistor r=98.4217 c=0
Rl78 (\22\:qbint \23\:qbint) resistor r=78.6412 c=0
Rl77 (\22\:qbint \21\:qbint) resistor r=32.6802 c=0
Rl56 (\4\:qbint \13\:qbint) resistor r=7.553 c=0
Rl33 (\2\:qbint \3\:qbint) resistor r=26.3736 c=0
Rl32 (\2\:qbint qbint) resistor r=125 c=0
Rz25 (\2\:VDD \1\:VDD) resistor r=25 c=0
Rz26 (\3\:VDD \1\:VDD) resistor r=6.25 c=0
Rz27 (\11\:VDD \1\:VDD) resistor r=6.25 c=0
Rz28 (\15\:VDD \1\:VDD) resistor r=6.25 c=0
Rz20 (\25\:VSS \24\:VSS) resistor r=75 c=0
Rz21 (\27\:VSS \26\:VSS) resistor r=75 c=0
Rz22 (\29\:VSS \28\:VSS) resistor r=75 c=0
Rz23 (\31\:VSS \30\:VSS) resistor r=75 c=0
Rz24 (\33\:VSS \32\:VSS) resistor r=75 c=0
Rz1 (\6\:SEb \7\:SEb) resistor r=75 c=0
Rz3 (Db \2\:Db) resistor r=75 c=0
Rz4 (\6\:Db \7\:Db) resistor r=75 c=0
Rz2 (\15\:CKb \16\:CKb) resistor r=75 c=0
Rz5 (\11\:Ckbb \12\:Ckbb) resistor r=75 c=0
Rz6 (\9\:n20 \10\:n20) resistor r=75 c=0
Rz7 (\4\:mout \5\:mout) resistor r=75 c=0
Rz8 (\16\:n30 \15\:n30) resistor r=75 c=0
Rz13 (\36\:qbint \35\:qbint) resistor r=75 c=0
Rz14 (\16\:qint \15\:qint) resistor r=75 c=0
Ry27 (\28\:VDD \27\:VDD) resistor r=62 c=0
Ry29 (\32\:VDD \31\:VDD) resistor r=62 c=0
Ry30 (\34\:VDD \33\:VDD) resistor r=62 c=0
Ry31 (\36\:VDD \35\:VDD) resistor r=62 c=0
Ry32 (\38\:VDD \37\:VDD) resistor r=62 c=0
Ry33 (\40\:VDD \39\:VDD) resistor r=62 c=0
Ry18 (\2\:VSS \1\:VSS) resistor r=20.6667 c=0
Ry19 (\3\:VSS \1\:VSS) resistor r=5.1667 c=0
Ry20 (\15\:VSS \1\:VSS) resistor r=5.1667 c=0
Ry21 (\18\:VSS \1\:VSS) resistor r=5.1667 c=0
Ry1 (\8\:SEb \9\:SEb) resistor r=62 c=0
Ry3 (\3\:Db \4\:Db) resistor r=62 c=0
Ry4 (\8\:Db \9\:Db) resistor r=62 c=0
Ry2 (\17\:CKb \18\:CKb) resistor r=62 c=0
Ry7 (\13\:Ckbb \14\:Ckbb) resistor r=62 c=0
Ry8 (\7\:n20 \8\:n20) resistor r=62 c=0
Ry9 (\8\:mout \9\:mout) resistor r=62 c=0
Ry10 (\14\:n30 \13\:n30) resistor r=62 c=0
Ry17 (\20\:qint \19\:qint) resistor r=20.6667 c=0
Ry5 (n6 \2\:n6) resistor r=62 c=0
Ry6 (\3\:n6 \4\:n6) resistor r=62 c=0
Rx20 (\12\:RN \2\:RN) resistor r=45 c=0
Rx3 (\7\:SE \8\:SE) resistor r=45 c=0
Rx4 (\5\:SE \10\:SE) resistor r=45 c=0
Rx5 (\2\:SE \11\:SE) resistor r=45 c=0
Rx1 (\2\:SI \4\:SI) resistor r=45 c=0
Rx7 (\2\:CK \4\:CK) resistor r=45 c=0
Rx6 (\2\:D \5\:D) resistor r=45 c=0
Rx2 (\2\:SEb \4\:SEb) resistor r=45 c=0
Rx8 (\3\:CKb \13\:CKb) resistor r=45 c=0
Rx14 (\7\:CKb \19\:CKb) resistor r=45 c=0
Rx15 (\5\:CKb \20\:CKb) resistor r=45 c=0
Rx16 (\10\:CKb \21\:CKb) resistor r=45 c=0
Rx17 (\12\:CKb \22\:CKb) resistor r=45 c=0
Rx9 (\7\:Ckbb \8\:Ckbb) resistor r=45 c=0
Rx10 (\4\:Ckbb \9\:Ckbb) resistor r=45 c=0
Rx11 (\2\:Ckbb \10\:Ckbb) resistor r=45 c=0
Rx12 (\3\:n20 \5\:n20) resistor r=45 c=0
Rx13 (\2\:mout \7\:mout) resistor r=45 c=0
Rx18 (\11\:n30 \7\:n30) resistor r=45 c=0
Rx22 (\24\:qbint \13\:qbint) resistor r=45 c=0
Rx23 (\27\:qbint \2\:qbint) resistor r=45 c=0
Rx24 (\32\:qbint \22\:qbint) resistor r=45 c=0
Rx25 (\34\:qbint \4\:qbint) resistor r=45 c=0
Rx26 (\18\:qint qint) resistor r=45 c=0
mn10 (\6\:SEb \3\:SE \32\:VSS VSS) g45n1hvt w=(1.45e-07) l=4.5e-08 nf=1 \
        as=3.263e-14 ad=2.465e-14 ps=7.4e-07 pd=6.3e-07 nrd=1.16667 \
        nrs=1.16667 sa=1.7e-07 sb=1.325e-06 sd=160n sca=9.68855 \
        scb=0.00848242 scc=0.000213356 m=(1)
mn13 (n3 \3\:SI \32\:VSS VSS) g45n1hvt w=(1.45e-07) l=4.5e-08 nf=1 \
        as=3.263e-14 ad=8.7e-15 ps=7.4e-07 pd=4.1e-07 nrd=1.16667 \
        nrs=1.16667 sa=4.4e-07 sb=1.055e-06 sd=160n sca=9.68855 \
        scb=0.00848242 scc=0.000213356 m=(1)
mn14 (\6\:Db \4\:SE n3 VSS) g45n1hvt w=(1.45e-07) l=4.5e-08 nf=1 \
        as=8.7e-15 ad=2.32e-14 ps=4.1e-07 pd=6.1e-07 nrd=1.16667 \
        nrs=1.16667 sa=5.45e-07 sb=9.5e-07 sd=160n sca=9.68855 \
        scb=0.00848242 scc=0.000213356 m=(1)
mn12 (\6\:Db SEb n1 VSS) g45n1hvt w=(1.45e-07) l=4.5e-08 nf=1 as=4.64e-14 \
        ad=2.32e-14 ps=9.3e-07 pd=6.1e-07 nrd=1.16667 nrs=1.16667 \
        sa=7.5e-07 sb=7.45e-07 sd=160n sca=9.68855 scb=0.00848242 \
        scc=0.000213356 m=(1)
mn11 (n1 \3\:D \30\:VSS VSS) g45n1hvt w=(1.45e-07) l=4.5e-08 nf=1 \
        as=2.828e-14 ad=4.64e-14 ps=6.8e-07 pd=9.3e-07 nrd=1.16667 \
        nrs=1.16667 sa=1.115e-06 sb=3.8e-07 sd=160n sca=9.68855 \
        scb=0.00848242 scc=0.000213356 m=(1)
mn20 (\15\:CKb \3\:CK \30\:VSS VSS) g45n1hvt w=(1.45e-07) l=4.5e-08 nf=1 \
        as=2.828e-14 ad=2.03e-14 ps=6.8e-07 pd=5.7e-07 nrd=1.16667 \
        nrs=1.16667 sa=1.355e-06 sb=1.4e-07 sd=160n sca=9.68855 \
        scb=0.00848242 scc=0.000213356 m=(1)
mn21 (\11\:Ckbb CKb \28\:VSS VSS) g45n1hvt w=(1.45e-07) l=4.5e-08 nf=1 \
        as=2.973e-14 ad=2.03e-14 ps=7e-07 pd=5.7e-07 nrd=1.16667 \
        nrs=1.16667 sa=2.05e-07 sb=1.4e-07 sd=160n sca=23.279 \
        scb=0.0230742 scc=0.00267719 m=(1)
mn25 (Db \8\:CKb \9\:n20 VSS) g45n1hvt w=(1.45e-07) l=4.5e-08 nf=1 \
        as=3.843e-14 ad=2.03e-14 ps=8.2e-07 pd=5.7e-07 nrd=1.16667 \
        nrs=1.16667 sa=1.4e-07 sb=2e-06 sd=160n sca=13.253 scb=0.0137915 \
        scc=0.000695334 m=(1)
mn37 (\9\:n20 \3\:Ckbb n5 VSS) g45n1hvt w=(1.45e-07) l=4.5e-08 nf=1 \
        as=8.7e-15 ad=3.843e-14 ps=4.1e-07 pd=8.2e-07 nrd=1.16667 \
        nrs=1.16667 sa=4.5e-07 sb=2e-06 sd=160n sca=13.253 scb=0.0137915 \
        scc=0.000695334 m=(1)
mn36 (n5 mout n7 VSS) g45n1hvt w=(1.45e-07) l=4.5e-08 nf=1 as=9.43e-15 \
        ad=8.7e-15 ps=4.2e-07 pd=4.1e-07 nrd=1.16667 nrs=1.16667 \
        sa=5.55e-07 sb=2e-06 sd=160n sca=13.253 scb=0.0137915 \
        scc=0.000695334 m=(1)
mn35 (n7 \3\:RN \26\:VSS VSS) g45n1hvt w=(1.45e-07) l=4.5e-08 nf=1 \
        as=6.018e-14 ad=9.43e-15 ps=1.12e-06 pd=4.2e-07 nrd=1.16667 \
        nrs=1.16667 sa=6.65e-07 sb=2e-06 sd=160n sca=13.253 scb=0.0137915 \
        scc=0.000695334 m=(1)
mn30 (\4\:mout \4\:n20 \26\:VSS VSS) g45n1hvt w=(1.45e-07) l=4.5e-08 \
        nf=1 as=6.018e-14 ad=3.625e-14 ps=1.12e-06 pd=7.9e-07 nrd=1.16667 \
        nrs=1.16667 sa=1.125e-06 sb=2e-06 sd=160n sca=13.253 scb=0.0137915 \
        scc=0.000695334 m=(1)
mn40 (\4\:mout \6\:Ckbb \15\:n30 VSS) g45n1hvt w=(1.45e-07) l=4.5e-08 \
        nf=1 as=3.48e-14 ad=3.625e-14 ps=7.7e-07 pd=7.9e-07 nrd=1.16667 \
        nrs=1.16667 sa=1.42e-06 sb=2e-06 sd=160n sca=13.253 scb=0.0137915 \
        scc=0.000695334 m=(1)
mn51 (\15\:n30 \11\:CKb n11 VSS) g45n1hvt w=(1.45e-07) l=4.5e-08 nf=1 \
        as=1.232e-14 ad=3.48e-14 ps=4.6e-07 pd=7.7e-07 nrd=1.16667 \
        nrs=1.16667 sa=1.705e-06 sb=2e-06 sd=160n sca=13.253 scb=0.0137915 \
        scc=0.000695334 m=(1)
mn50 (n11 qbint \24\:VSS VSS) g45n1hvt w=(1.45e-07) l=4.5e-08 nf=1 \
        as=8.923e-14 ad=1.233e-14 ps=1.6e-06 pd=4.6e-07 nrd=1.16667 \
        nrs=1.16667 sa=1.835e-06 sb=2e-06 sd=160n sca=13.253 scb=0.0137915 \
        scc=0.000695334 m=(1)
mn45_1__rcx (28 \4\:RN \24\:VSS VSS) g45n1hvt w=(2.05e-07) l=4.5e-08 \
        nf=1 as=8.923e-14 ad=1.23e-14 ps=1.6e-06 pd=5.3e-07 nrd=1.16667 \
        nrs=1.16667 sa=1.46439e-06 sb=2e-06 sd=160n sca=11.814 \
        scb=0.0116374 scc=0.000520744 m=(1)
mn46_1__rcx (\35\:qbint \5\:n30 28 VSS) g45n1hvt w=(2.05e-07) l=4.5e-08 \
        nf=1 as=1.23e-14 ad=6.048e-14 ps=5.3e-07 pd=1e-06 nrd=1.16667 \
        nrs=1.16667 sa=1.49512e-06 sb=2e-06 sd=160n sca=11.814 \
        scb=0.0116374 scc=0.000520744 m=(1)
mn46 (\35\:qbint \6\:n30 29 VSS) g45n1hvt w=(2.05e-07) l=4.5e-08 nf=1 \
        as=2.05e-14 ad=6.048e-14 ps=6.1e-07 pd=1e-06 nrd=1.16667 \
        nrs=1.16667 sa=1.59463e-06 sb=2e-06 sd=160n sca=11.814 \
        scb=0.0116374 scc=0.000520744 m=(1)
mn45 (29 \9\:RN \3\:VSS VSS) g45n1hvt w=(2.05e-07) l=4.5e-08 nf=1 \
        as=8.265e-14 ad=2.05e-14 ps=1.43e-06 pd=6.1e-07 nrd=1.16667 \
        nrs=1.16667 sa=1.63707e-06 sb=2e-06 sd=160n sca=11.814 \
        scb=0.0116374 scc=0.000520744 m=(1)
mn56 (\15\:qint \21\:qbint \3\:VSS VSS) g45n1hvt w=(2.6e-07) l=4.5e-08 \
        nf=1 as=8.54e-14 ad=4.16e-14 ps=1.43e-06 pd=8.4e-07 nrd=1.16667 \
        nrs=1.16667 sa=2e-06 sb=1.6e-07 sd=160n sca=10.79 scb=0.0100512 \
        scc=0.000418069 m=(1)
mn55_1__rcx (\4\:Q \4\:qbint \3\:VSS VSS) g45n1hvt w=(2.6e-07) l=4.5e-08 \
        nf=1 as=8.471e-14 ad=4.16e-14 ps=1.43e-06 pd=8.4e-07 nrd=1.16667 \
        nrs=1.16667 sa=1.38788e-06 sb=2e-06 sd=160n sca=10.79 \
        scb=0.0100512 scc=0.000418069 m=(4)
mn57_1__rcx (\4\:QN qint \3\:VSS VSS) g45n1hvt w=(2.6e-07) l=4.5e-08 \
        nf=1 as=8.54e-14 ad=4.16e-14 ps=1.43e-06 pd=8.4e-07 nrd=1.16667 \
        nrs=1.16667 sa=1.80365e-06 sb=1.1e-06 sd=160n sca=10.79 \
        scb=0.0100512 scc=0.000418069 m=(4)
mp46_1__rcx (\25\:qbint n30 \27\:VDD VDD) g45p1hvt w=(3.1e-07) l=4.5e-08 \
        nf=1 as=9.145e-14 ad=4.96e-14 ps=1.21e-06 pd=9.4e-07 nrd=1.16667 \
        nrs=1.16667 sa=1.40073e-06 sb=2e-06 sd=160n sca=13.6224 \
        scb=0.0125368 scc=0.000630866 m=(2)
mp45 (\25\:qbint \5\:RN \3\:VDD VDD) g45p1hvt w=(3.1e-07) l=4.5e-08 nf=1 \
        as=9.47e-14 ad=4.96e-14 ps=1.33e-06 pd=9.4e-07 nrd=1.16667 \
        nrs=1.16667 sa=1.2046e-06 sb=2e-06 sd=160n sca=13.6224 \
        scb=0.0125368 scc=0.000630866 m=(2)
mp56 (\19\:qint \23\:qbint \3\:VDD VDD) g45p1hvt w=(3.9e-07) l=4.5e-08 \
        nf=1 as=6.63e-14 ad=5.46e-14 ps=1.12e-06 pd=1.06e-06 nrd=1.16667 \
        nrs=1.16667 sa=1.96308e-06 sb=1.4e-07 sd=160n sca=25.3022 \
        scb=0.0253386 scc=0.00193759 m=(1)
mp55 (\1\:Q \4\:qbint \3\:VDD VDD) g45p1hvt w=(3.9e-07) l=4.5e-08 nf=1 \
        as=7.673e-14 ad=6.24e-14 ps=1.195e-06 pd=1.1e-06 nrd=1.16667 \
        nrs=1.16667 sa=1.43455e-06 sb=1.82e-06 sd=160n sca=19.0259 \
        scb=0.0163587 scc=0.00171562 m=(4)
mp57_1__rcx (\1\:QN qint \3\:VDD VDD) g45p1hvt w=(3.9e-07) l=4.5e-08 \
        nf=1 as=6.337e-14 ad=6.825e-14 ps=1.105e-06 pd=1.13e-06 \
        nrd=1.16667 nrs=1.16667 sa=1.78667e-06 sb=1e-06 sd=160n \
        sca=19.0259 scb=0.0163587 scc=0.00171562 m=(4)
ends SDFFRX4
// End of subcircuit definition.
