// Generated for: spectre (May  1 09:16:03 2013 )
// Library name: gsclib045_hvt
// Cell name: SDFFTRX1
// View name: extracted

simulator lang=spectre

subckt SDFFTRX1 CK D Q QN RN SE SI VDD VSS
mp57 (\1\:QN \4\:net436 \22\:VDD VDD) g45p1hvt w=(3.9e-07) l=4.5e-08 \
        nf=1 as=5.728e-14 ad=5.46e-14 ps=1.15e-06 pd=1.06e-06 nrd=1.16667 \
        nrs=1.16667 sa=1.4e-07 sb=2.48846e-07 sd=160n sca=34.3332 \
        scb=0.0249008 scc=0.00341086 m=(1)
mp55 (\1\:Q qbint \19\:VDD VDD) g45p1hvt w=(3.9e-07) l=4.5e-08 nf=1 \
        as=7.288e-14 ad=5.46e-14 ps=1.23e-06 pd=1.06e-06 nrd=1.16667 \
        nrs=1.16667 sa=1.4e-07 sb=3.1641e-07 sd=160n sca=20.5009 \
        scb=0.0171135 scc=0.00197772 m=(1)
C1 (D VSS) capacitor c=7.91989e-17
C2 (SI VSS) capacitor c=8.64782e-17
C3 (QN VSS) capacitor c=2.29669e-17
C4 (RN VSS) capacitor c=6.30025e-17
C5 (Q VSS) capacitor c=1.70766e-17
C6 (VDD VSS) capacitor c=3.23784e-16
C7 (CK VSS) capacitor c=6.96629e-17
C8 (SE VSS) capacitor c=6.56135e-17
C9 (net436 VSS) capacitor c=2.18789e-17
C10 (qbint VSS) capacitor c=4.50195e-17
C11 (CKb VSS) capacitor c=5.45013e-17
C12 (n30 VSS) capacitor c=5.10791e-17
C13 (mout VSS) capacitor c=7.99829e-17
C14 (CKbb VSS) capacitor c=1.93632e-17
C15 (n20 VSS) capacitor c=1.97545e-17
C16 (Dbp VSS) capacitor c=4.61965e-17
C17 (Db VSS) capacitor c=1.13439e-16
C18 (SEb VSS) capacitor c=4.07741e-17
C19 (net395 VSS) capacitor c=2.89993e-18
C20 (net375 VSS) capacitor c=5.01329e-20
C21 (\1\:D VSS) capacitor c=3.35382e-17
C22 (\1\:RN VSS) capacitor c=5.03813e-17
C23 (\1\:SE VSS) capacitor c=2.71816e-17
C24 (\6\:SE VSS) capacitor c=3.60913e-17
C25 (\1\:SI VSS) capacitor c=4.34466e-17
C26 (\5\:CKb VSS) capacitor c=6.13073e-17
C27 (\6\:CKbb VSS) capacitor c=3.92964e-17
C28 (\8\:CKb VSS) capacitor c=5.87403e-17
C29 (\4\:n20 VSS) capacitor c=3.99945e-17
C30 (\3\:CKb VSS) capacitor c=5.68212e-17
C31 (\3\:CKbb VSS) capacitor c=4.42854e-17
C32 (\8\:qbint VSS) capacitor c=4.37755e-17
C33 (\1\:CK VSS) capacitor c=3.54508e-17
C34 (\7\:qbint VSS) capacitor c=3.11638e-17
C35 (\4\:net436 VSS) capacitor c=4.54578e-17
C36 (\3\:D VSS) capacitor c=3.64e-17
C37 (\3\:RN VSS) capacitor c=2.60523e-17
C38 (\5\:SE VSS) capacitor c=3.71308e-17
C39 (\3\:SEb VSS) capacitor c=3.57849e-17
C40 (\4\:SE VSS) capacitor c=5.30386e-17
C41 (\3\:SI VSS) capacitor c=5.36207e-17
C42 (\9\:CKb VSS) capacitor c=2.35854e-17
C43 (\10\:CKb VSS) capacitor c=2.80188e-17
C44 (\4\:CKbb VSS) capacitor c=7.99498e-17
C45 (\3\:mout VSS) capacitor c=5.25619e-17
C46 (\3\:n20 VSS) capacitor c=3.89952e-17
C47 (\11\:qbint VSS) capacitor c=5.0156e-17
C48 (\2\:n30 VSS) capacitor c=4.32167e-17
C49 (\3\:CK VSS) capacitor c=4.27151e-17
C50 (\5\:qbint VSS) capacitor c=2.92187e-17
C51 (\4\:qbint VSS) capacitor c=2.74337e-17
C52 (\3\:net436 VSS) capacitor c=3.80289e-17
C53 (\2\:D VSS) capacitor c=3.7242e-17
C54 (\2\:RN VSS) capacitor c=4.0913e-17
C55 (\2\:SE VSS) capacitor c=4.94766e-17
C56 (\4\:SEb VSS) capacitor c=4.16052e-17
C57 (\2\:SEb VSS) capacitor c=4.6275e-17
C58 (\2\:SI VSS) capacitor c=5.69348e-17
C59 (\7\:CKbb VSS) capacitor c=4.21271e-17
C60 (\11\:CKb VSS) capacitor c=2.93743e-17
C61 (\5\:CKbb VSS) capacitor c=2.90912e-17
C62 (\2\:mout VSS) capacitor c=5.15503e-17
C63 (\4\:CKb VSS) capacitor c=2.0751e-17
C64 (\2\:CKbb VSS) capacitor c=5.19036e-17
C65 (\2\:CKb VSS) capacitor c=3.28433e-17
C66 (\10\:qbint VSS) capacitor c=5.27633e-17
C67 (\3\:n30 VSS) capacitor c=2.32825e-17
C68 (\2\:CK VSS) capacitor c=2.78309e-17
C69 (\6\:qbint VSS) capacitor c=2.03773e-17
C70 (\1\:VDD VSS) capacitor c=4.17125e-17
C71 (\3\:Db VSS) capacitor c=2.02812e-16
C72 (\11\:VDD VSS) capacitor c=2.06927e-17
C73 (\5\:SEb VSS) capacitor c=1.18666e-16
C74 (\5\:Db VSS) capacitor c=1.29429e-16
C75 (\13\:VDD VSS) capacitor c=4.08934e-17
C76 (\8\:CKbb VSS) capacitor c=8.51042e-17
C77 (\4\:Dbp VSS) capacitor c=1.20971e-16
C78 (\5\:n20 VSS) capacitor c=3.15373e-17
C79 (\15\:VDD VSS) capacitor c=9.0318e-18
C80 (\8\:mout VSS) capacitor c=4.16388e-17
C81 (\4\:n30 VSS) capacitor c=7.53095e-17
C82 (\17\:VDD VSS) capacitor c=3.17715e-17
C83 (\16\:qbint VSS) capacitor c=4.45142e-17
C84 (\15\:CKb VSS) capacitor c=9.37418e-17
C85 (\19\:VDD VSS) capacitor c=3.64584e-17
C86 (\1\:Q VSS) capacitor c=9.61811e-17
C87 (\5\:net436 VSS) capacitor c=2.74392e-17
C88 (\22\:VDD VSS) capacitor c=5.73182e-17
C89 (\1\:QN VSS) capacitor c=4.81242e-17
C90 (\3\:VDD VSS) capacitor c=6.48634e-17
C91 (\7\:SEb VSS) capacitor c=1.31516e-16
C92 (\7\:Db VSS) capacitor c=1.05927e-16
C93 (\8\:Dbp VSS) capacitor c=8.38255e-17
C94 (\14\:CKbb VSS) capacitor c=6.55459e-17
C95 (\6\:Dbp VSS) capacitor c=8.59529e-17
C96 (\9\:n20 VSS) capacitor c=5.5575e-17
C97 (\6\:mout VSS) capacitor c=3.76637e-17
C98 (\6\:n30 VSS) capacitor c=9.99633e-17
C99 (\14\:qbint VSS) capacitor c=8.05533e-17
C100 (\17\:CKb VSS) capacitor c=6.04987e-17
C101 (\3\:Q VSS) capacitor c=5.57635e-17
C102 (\9\:net436 VSS) capacitor c=1.95157e-17
C103 (\3\:QN VSS) capacitor c=2.74556e-17
C104 (\2\:net436 VSS) capacitor c=7.14124e-18
C105 (\2\:qbint VSS) capacitor c=2.30601e-17
C106 (\3\:qbint VSS) capacitor c=3.33487e-17
C107 (\2\:n20 VSS) capacitor c=2.57346e-17
C108 (\6\:CKb VSS) capacitor c=6.13913e-17
C109 (\7\:CKb VSS) capacitor c=7.42802e-17
C110 (\3\:SE VSS) capacitor c=8.91263e-17
C111 (\7\:net436 VSS) capacitor c=2.41457e-17
C112 (\8\:net436 VSS) capacitor c=2.22323e-17
C113 (\4\:CK VSS) capacitor c=4.30876e-17
C114 (\12\:qbint VSS) capacitor c=3.1174e-17
C115 (\13\:qbint VSS) capacitor c=3.18561e-17
C116 (\18\:qbint VSS) capacitor c=1.06323e-16
C117 (\8\:n30 VSS) capacitor c=6.04885e-17
C118 (\4\:mout VSS) capacitor c=5.186e-17
C119 (\5\:mout VSS) capacitor c=5.09291e-17
C120 (\12\:CKb VSS) capacitor c=5.12393e-17
C121 (\13\:CKb VSS) capacitor c=6.79807e-17
C122 (\14\:CKb VSS) capacitor c=9.45778e-17
C123 (\19\:CKb VSS) capacitor c=1.21045e-17
C124 (\20\:CKb VSS) capacitor c=5.41954e-17
C125 (\7\:n20 VSS) capacitor c=5.53094e-17
C126 (\8\:n20 VSS) capacitor c=5.26149e-17
C127 (\10\:CKbb VSS) capacitor c=1.20577e-16
C128 (\11\:CKbb VSS) capacitor c=7.41924e-17
C129 (\12\:CKbb VSS) capacitor c=8.8955e-17
C130 (\13\:CKbb VSS) capacitor c=1.12034e-16
C131 (\16\:CKbb VSS) capacitor c=2.91168e-17
C132 (\4\:SI VSS) capacitor c=4.28298e-17
C133 (\3\:Dbp VSS) capacitor c=1.0455e-16
C134 (\9\:SEb VSS) capacitor c=1.11054e-16
C135 (\10\:SEb VSS) capacitor c=5.45455e-17
C136 (\7\:SE VSS) capacitor c=5.26064e-17
C137 (\4\:RN VSS) capacitor c=3.96668e-17
C138 (\4\:D VSS) capacitor c=4.20097e-17
C139 (\5\:VDD VSS) capacitor c=2.58882e-17
C140 (\6\:VDD VSS) capacitor c=3.298e-17
C141 (\8\:VDD VSS) capacitor c=3.69598e-17
C142 (\9\:VDD VSS) capacitor c=3.01961e-17
C143 (\21\:VDD VSS) capacitor c=1.57649e-17
Rk43 (\4\:D D) resistor r=0.07299 c=0
Rk33 (\4\:SI SI) resistor r=0.09342 c=0
Rk2 (\4\:QN QN) resistor r=0.0928 c=0
Rk1 (\2\:QN \4\:QN) resistor r=0.3049 c=0
Rk42 (\4\:RN RN) resistor r=0.1928 c=0
Rk7 (\4\:Q Q) resistor r=0.03363 c=0
Rk6 (\2\:Q \4\:Q) resistor r=0.491 c=0
Rk47 (\2\:VDD \4\:VDD) resistor r=0.6439 c=0
Rk48 (\4\:VDD \5\:VDD) resistor r=0.06746 c=0
Rk49 (\5\:VDD \6\:VDD) resistor r=0.6812 c=0
Rk50 (\6\:VDD \7\:VDD) resistor r=0.2529 c=0
Rk51 (\7\:VDD \8\:VDD) resistor r=0.2955 c=0
Rk52 (\8\:VDD \9\:VDD) resistor r=0.5133 c=0
Rk53 (\9\:VDD \10\:VDD) resistor r=0.3932 c=0
Rk54 (\5\:VDD \12\:VDD) resistor r=0.1762 c=0
Rk55 (\6\:VDD \14\:VDD) resistor r=0.2923 c=0
Rk56 (\8\:VDD \16\:VDD) resistor r=0.07334 c=0
Rk57 (\9\:VDD \18\:VDD) resistor r=0.2446 c=0
Rk58 (\10\:VDD \20\:VDD) resistor r=0.3229 c=0
Rk61 (\21\:VDD VDD) resistor r=0.2 c=0
Rk59 (\10\:VDD \21\:VDD) resistor r=0.3512 c=0
Rk60 (\21\:VDD \23\:VDD) resistor r=0.4324 c=0
Rk8 (\4\:CK CK) resistor r=0.1143 c=0
Rk62 (\2\:VSS \3\:VSS) resistor r=0.08249 c=0
Rk63 (\3\:VSS \4\:VSS) resistor r=0.6661 c=0
Rk64 (\4\:VSS \5\:VSS) resistor r=0.2529 c=0
Rk65 (\5\:VSS \6\:VSS) resistor r=0.2945 c=0
Rk66 (\6\:VSS \7\:VSS) resistor r=0.4964 c=0
Rk67 (\7\:VSS \8\:VSS) resistor r=0.4073 c=0
Rk68 (\3\:VSS \10\:VSS) resistor r=0.1821 c=0
Rk69 (\4\:VSS \12\:VSS) resistor r=0.303 c=0
Rk70 (\6\:VSS \14\:VSS) resistor r=0.04326 c=0
Rk71 (\7\:VSS \16\:VSS) resistor r=0.04326 c=0
Rk73 (\17\:VSS VSS) resistor r=0.215 c=0
Rk72 (\8\:VSS \17\:VSS) resistor r=0.3361 c=0
Rk74 (\8\:VSS \19\:VSS) resistor r=0.3347 c=0
Rk75 (\17\:VSS \21\:VSS) resistor r=0.07334 c=0
Rk41 (\7\:SE SE) resistor r=0.03494 c=0
Rk3 (\6\:net436 \7\:net436) resistor r=0.1174 c=0
Rk4 (\7\:net436 \8\:net436) resistor r=0.119 c=0
Rk5 (\7\:net436 \10\:net436) resistor r=0.1055 c=0
Rk9 (\12\:qbint \13\:qbint) resistor r=0.1669 c=0
Rk10 (\13\:qbint \15\:qbint) resistor r=0.1202 c=0
Rk11 (\13\:qbint \17\:qbint) resistor r=0.2251 c=0
Rk12 (\15\:qbint \18\:qbint) resistor r=0.7137 c=0
Rk18 (\12\:CKb \13\:CKb) resistor r=0.4686 c=0
Rk19 (\13\:CKb \14\:CKb) resistor r=0.3611 c=0
Rk20 (\14\:CKb \16\:CKb) resistor r=0.5753 c=0
Rk21 (\16\:CKb \18\:CKb) resistor r=0.272 c=0
Rk22 (\13\:CKb \19\:CKb) resistor r=0.02031 c=0
Rk23 (\14\:CKb \20\:CKb) resistor r=0.3158 c=0
Rk13 (\5\:n30 \7\:n30) resistor r=0.5237 c=0
Rk14 (\7\:n30 \8\:n30) resistor r=0.4249 c=0
Rk15 (\4\:mout \5\:mout) resistor r=0.2403 c=0
Rk16 (\5\:mout \7\:mout) resistor r=0.1339 c=0
Rk17 (\5\:mout \9\:mout) resistor r=0.229 c=0
Rk27 (\9\:CKbb \10\:CKbb) resistor r=0.5668 c=0
Rk28 (\10\:CKbb \11\:CKbb) resistor r=0.3502 c=0
Rk29 (\11\:CKbb \12\:CKbb) resistor r=0.2125 c=0
Rk30 (\12\:CKbb \13\:CKbb) resistor r=0.7325 c=0
Rk31 (\11\:CKbb \15\:CKbb) resistor r=0.3718 c=0
Rk32 (\12\:CKbb \16\:CKbb) resistor r=0.04286 c=0
Rk24 (\6\:n20 \7\:n20) resistor r=0.1265 c=0
Rk25 (\7\:n20 \8\:n20) resistor r=0.2701 c=0
Rk26 (\7\:n20 \10\:n20) resistor r=0.2503 c=0
Rk34 (\2\:Dbp \3\:Dbp) resistor r=0.2771 c=0
Rk35 (\3\:Dbp \5\:Dbp) resistor r=0.4525 c=0
Rk36 (\5\:Dbp \7\:Dbp) resistor r=0.4277 c=0
Rk37 (\3\:Dbp \9\:Dbp) resistor r=0.5421 c=0
Rk44 (\2\:Db \4\:Db) resistor r=1.03 c=0
Rk45 (\4\:Db \6\:Db) resistor r=0.851 c=0
Rk46 (\6\:Db \8\:Db) resistor r=0.5915 c=0
Rk38 (\6\:SEb \8\:SEb) resistor r=0.7061 c=0
Rk39 (\8\:SEb \9\:SEb) resistor r=0.6569 c=0
Rk40 (\9\:SEb \10\:SEb) resistor r=0.2593 c=0
Rl45 (\1\:D \2\:D) resistor r=78.079 c=0
Rl46 (\2\:D \3\:D) resistor r=91.5405 c=0
Rl34 (\1\:SI \2\:SI) resistor r=86.7959 c=0
Rl35 (\2\:SI \3\:SI) resistor r=107.95 c=0
Rl43 (\1\:RN \2\:RN) resistor r=131.925 c=0
Rl44 (\2\:RN \3\:RN) resistor r=37.6944 c=0
Rl10 (\1\:CK \2\:CK) resistor r=29.5379 c=0
Rl11 (\2\:CK \3\:CK) resistor r=56.461 c=0
Rl38 (\1\:SE \2\:SE) resistor r=31.5021 c=0
Rl41 (\2\:SE \5\:SE) resistor r=132.487 c=0
Rl42 (\3\:SE \6\:SE) resistor r=97.7584 c=0
Rl40 (\3\:SE \4\:SE) resistor r=168.774 c=0
Rl39 (\2\:SE \3\:SE) resistor r=229.236 c=0
Rl3 (\2\:net436 \4\:net436) resistor r=49.7141 c=0
Rl2 (\2\:net436 \3\:net436) resistor r=34.3295 c=0
Rl1 (net436 \2\:net436) resistor r=5.915 c=0
Rl4 (qbint \2\:qbint) resistor r=68.0527 c=0
Rl7 (\2\:qbint \5\:qbint) resistor r=33.4373 c=0
Rl8 (\2\:qbint \6\:qbint) resistor r=4.8851 c=0
Rl9 (\3\:qbint \7\:qbint) resistor r=60.772 c=0
Rl6 (\3\:qbint \4\:qbint) resistor r=28.0797 c=0
Rl5 (\2\:qbint \3\:qbint) resistor r=161.779 c=0
Rl14 (\8\:qbint \9\:qbint) resistor r=108.895 c=0
Rl16 (\9\:qbint \11\:qbint) resistor r=34.3295 c=0
Rl15 (\9\:qbint \10\:qbint) resistor r=0.5166 c=0
Rl33 (\8\:CKb \11\:CKb) resistor r=24.2328 c=0
Rl20 (\3\:CKb \4\:CKb) resistor r=51.1559 c=0
Rl17 (CKb \2\:CKb) resistor r=39.6174 c=0
Rl28 (\5\:CKb \6\:CKb) resistor r=162.128 c=0
Rl31 (\6\:CKb \9\:CKb) resistor r=40.6968 c=0
Rl30 (\7\:CKb \8\:CKb) resistor r=151.467 c=0
Rl32 (\7\:CKb \10\:CKb) resistor r=34.2969 c=0
Rl29 (\6\:CKb \7\:CKb) resistor r=202.903 c=0
Rl12 (n30 \2\:n30) resistor r=142.308 c=0
Rl13 (\2\:n30 \3\:n30) resistor r=29.5379 c=0
Rl24 (mout \2\:mout) resistor r=87.2302 c=0
Rl25 (\2\:mout \3\:mout) resistor r=29.5379 c=0
Rl27 (\6\:CKbb \7\:CKbb) resistor r=35.7713 c=0
Rl26 (\4\:CKbb \5\:CKbb) resistor r=71.8456 c=0
Rl19 (\2\:CKbb \3\:CKbb) resistor r=110.337 c=0
Rl18 (CKbb \2\:CKbb) resistor r=24.2328 c=0
Rl23 (\2\:n20 \4\:n20) resistor r=34.3295 c=0
Rl22 (\2\:n20 \3\:n20) resistor r=99.7141 c=0
Rl21 (n20 \2\:n20) resistor r=2.7713 c=0
Rl37 (\3\:SEb \4\:SEb) resistor r=35.7713 c=0
Rl36 (SEb \2\:SEb) resistor r=79.5379 c=0
Rz1 (\3\:QN \4\:QN) resistor r=75 c=0
Rz3 (\3\:Q \4\:Q) resistor r=75 c=0
Rz15 (\3\:VDD \4\:VDD) resistor r=9.375 c=0
Rz16 (\3\:VDD \7\:VDD) resistor r=6.25 c=0
Rz17 (\3\:VDD \10\:VDD) resistor r=6.25 c=0
Rz18 (\9\:VSS \10\:VSS) resistor r=75 c=0
Rz19 (\11\:VSS \12\:VSS) resistor r=75 c=0
Rz20 (\13\:VSS \14\:VSS) resistor r=75 c=0
Rz21 (\15\:VSS \16\:VSS) resistor r=75 c=0
Rz22 (\18\:VSS \19\:VSS) resistor r=75 c=0
Rz23 (\20\:VSS \21\:VSS) resistor r=75 c=0
Rz2 (\9\:net436 \10\:net436) resistor r=75 c=0
Rz4 (\14\:qbint \15\:qbint) resistor r=75 c=0
Rz7 (\17\:CKb \18\:CKb) resistor r=75 c=0
Rz5 (\6\:n30 \7\:n30) resistor r=75 c=0
Rz6 (\6\:mout \7\:mout) resistor r=75 c=0
Rz9 (\14\:CKbb \15\:CKbb) resistor r=75 c=0
Rz8 (\9\:n20 \10\:n20) resistor r=75 c=0
Rz10 (\6\:Dbp \7\:Dbp) resistor r=75 c=0
Rz11 (\8\:Dbp \9\:Dbp) resistor r=75 c=0
Rz13 (Db \2\:Db) resistor r=75 c=0
Rz14 (\7\:Db \8\:Db) resistor r=75 c=0
Rz12 (\7\:SEb \8\:SEb) resistor r=75 c=0
Ry1 (\1\:QN \2\:QN) resistor r=20.6667 c=0
Ry3 (\1\:Q \2\:Q) resistor r=20.6667 c=0
Ry15 (\1\:VDD \2\:VDD) resistor r=62 c=0
Ry16 (\11\:VDD \12\:VDD) resistor r=62 c=0
Ry17 (\13\:VDD \14\:VDD) resistor r=62 c=0
Ry18 (\15\:VDD \16\:VDD) resistor r=62 c=0
Ry19 (\17\:VDD \18\:VDD) resistor r=62 c=0
Ry20 (\19\:VDD \20\:VDD) resistor r=62 c=0
Ry21 (\22\:VDD \23\:VDD) resistor r=62 c=0
Ry22 (\1\:VSS \2\:VSS) resistor r=7.75 c=0
Ry23 (\1\:VSS \5\:VSS) resistor r=5.1667 c=0
Ry24 (\1\:VSS \8\:VSS) resistor r=5.1667 c=0
Ry2 (\5\:net436 \6\:net436) resistor r=62 c=0
Ry4 (\16\:qbint \17\:qbint) resistor r=62 c=0
Ry7 (\15\:CKb \16\:CKb) resistor r=62 c=0
Ry5 (\4\:n30 \5\:n30) resistor r=62 c=0
Ry6 (\8\:mout \9\:mout) resistor r=62 c=0
Ry9 (\8\:CKbb \9\:CKbb) resistor r=62 c=0
Ry8 (\5\:n20 \6\:n20) resistor r=62 c=0
Ry10 (Dbp \2\:Dbp) resistor r=62 c=0
Ry11 (\4\:Dbp \5\:Dbp) resistor r=62 c=0
Ry13 (\3\:Db \4\:Db) resistor r=62 c=0
Ry14 (\5\:Db \6\:Db) resistor r=62 c=0
Ry12 (\5\:SEb \6\:SEb) resistor r=62 c=0
Rx19 (\2\:D \4\:D) resistor r=45 c=0
Rx14 (\2\:SI \4\:SI) resistor r=45 c=0
Rx18 (\2\:RN \4\:RN) resistor r=45 c=0
Rx2 (\2\:CK \4\:CK) resistor r=45 c=0
Rx17 (\2\:SE \7\:SE) resistor r=45 c=0
Rx1 (net436 \8\:net436) resistor r=45 c=0
Rx3 (\10\:qbint \12\:qbint) resistor r=45 c=0
Rx4 (\6\:qbint \18\:qbint) resistor r=45 c=0
Rx7 (\11\:CKb \12\:CKb) resistor r=45 c=0
Rx8 (\4\:CKb \19\:CKb) resistor r=45 c=0
Rx9 (\2\:CKb \20\:CKb) resistor r=45 c=0
Rx5 (\3\:n30 \8\:n30) resistor r=45 c=0
Rx6 (\2\:mout \4\:mout) resistor r=45 c=0
Rx11 (\7\:CKbb \10\:CKbb) resistor r=45 c=0
Rx12 (\2\:CKbb \13\:CKbb) resistor r=45 c=0
Rx13 (\5\:CKbb \16\:CKbb) resistor r=45 c=0
Rx10 (n20 \8\:n20) resistor r=45 c=0
Rx15 (\4\:SEb \9\:SEb) resistor r=45 c=0
Rx16 (\2\:SEb \10\:SEb) resistor r=45 c=0
mn57 (\3\:QN \3\:net436 \20\:VSS VSS) g45n1hvt w=(2.6e-07) l=4.5e-08 \
        nf=1 as=6.273e-14 ad=3.64e-14 ps=1.67e-06 pd=8e-07 nrd=1.16667 \
        nrs=1.16667 sa=1.4e-07 sb=2.50577e-07 sd=160n sca=17.5885 \
        scb=0.0172826 scc=0.00162584 m=(1)
mn55 (\3\:Q \5\:qbint \18\:VSS VSS) g45n1hvt w=(2.6e-07) l=4.5e-08 nf=1 \
        as=4.873e-14 ad=3.64e-14 ps=9.7e-07 pd=8e-07 nrd=1.16667 \
        nrs=1.16667 sa=1.4e-07 sb=3.18462e-07 sd=160n sca=16.3874 \
        scb=0.0162972 scc=0.00139495 m=(1)
mn56 (\9\:net436 \4\:qbint \20\:VSS VSS) g45n1hvt w=(1.45e-07) l=4.5e-08 \
        nf=1 as=6.273e-14 ad=2.03e-14 ps=1.67e-06 pd=5.7e-07 nrd=1.16667 \
        nrs=1.16667 sa=3.7e-07 sb=1.4e-07 sd=160n sca=23.279 scb=0.0230742 \
        scc=0.00267719 m=(1)
mn20 (\17\:CKb \3\:CK \18\:VSS VSS) g45n1hvt w=(1.45e-07) l=4.5e-08 nf=1 \
        as=4.873e-14 ad=2.755e-14 ps=9.7e-07 pd=6.7e-07 nrd=1.16667 \
        nrs=1.16667 sa=4.1e-07 sb=1.9e-07 sd=160n sca=21.4614 \
        scb=0.0218523 scc=0.00230065 m=(1)
mn45 (\14\:qbint \2\:n30 \15\:VSS VSS) g45n1hvt w=(1.45e-07) l=4.5e-08 \
        nf=1 as=4.665e-14 ad=2.465e-14 ps=1.39e-06 pd=6.3e-07 nrd=1.16667 \
        nrs=1.16667 sa=1.7e-07 sb=1.855e-06 sd=160n sca=11.9911 \
        scb=0.0120555 scc=0.000498628 m=(1)
mn50 (net460 \11\:qbint \15\:VSS VSS) g45n1hvt w=(1.45e-07) l=4.5e-08 \
        nf=1 as=4.665e-14 ad=1.233e-14 ps=1.39e-06 pd=4.6e-07 nrd=1.16667 \
        nrs=1.16667 sa=3.65e-07 sb=1.66e-06 sd=160n sca=11.9911 \
        scb=0.0120555 scc=0.000498628 m=(1)
mn51 (\6\:n30 CKb net460 VSS) g45n1hvt w=(1.45e-07) l=4.5e-08 nf=1 \
        as=1.233e-14 ad=4.278e-14 ps=4.6e-07 pd=8.8e-07 nrd=1.16667 \
        nrs=1.16667 sa=4.95e-07 sb=1.53e-06 sd=160n sca=11.9911 \
        scb=0.0120555 scc=0.000498628 m=(1)
mn40 (\6\:n30 CKbb \6\:mout VSS) g45n1hvt w=(1.45e-07) l=4.5e-08 nf=1 \
        as=4.132e-14 ad=4.277e-14 ps=8.6e-07 pd=8.8e-07 nrd=1.16667 \
        nrs=1.16667 sa=8.35e-07 sb=1.19e-06 sd=160n sca=11.9911 \
        scb=0.0120555 scc=0.000498628 m=(1)
mn30 (\6\:mout \3\:n20 \13\:VSS VSS) g45n1hvt w=(1.45e-07) l=4.5e-08 \
        nf=1 as=7.15e-14 ad=4.132e-14 ps=1.39e-06 pd=8.6e-07 nrd=1.16667 \
        nrs=1.16667 sa=1.165e-06 sb=8.6e-07 sd=160n sca=11.9911 \
        scb=0.0120555 scc=0.000498628 m=(1)
mn35 (net452 \3\:mout \13\:VSS VSS) g45n1hvt w=(1.45e-07) l=4.5e-08 nf=1 \
        as=7.15e-14 ad=8.7e-15 ps=1.39e-06 pd=4.1e-07 nrd=1.16667 \
        nrs=1.16667 sa=1.43e-06 sb=5.95e-07 sd=160n sca=11.9911 \
        scb=0.0120555 scc=0.000498628 m=(1)
mn36 (\9\:n20 \4\:CKbb net452 VSS) g45n1hvt w=(1.45e-07) l=4.5e-08 nf=1 \
        as=8.7e-15 ad=2.32e-14 ps=4.1e-07 pd=6.1e-07 nrd=1.16667 \
        nrs=1.16667 sa=1.535e-06 sb=4.9e-07 sd=160n sca=11.9911 \
        scb=0.0120555 scc=0.000498628 m=(1)
mn25 (\6\:Dbp \10\:CKb \9\:n20 VSS) g45n1hvt w=(1.45e-07) l=4.5e-08 nf=1 \
        as=2.32e-14 ad=4.132e-14 ps=6.1e-07 pd=8.6e-07 nrd=1.16667 \
        nrs=1.16667 sa=1.74e-06 sb=2.85e-07 sd=160n sca=11.9911 \
        scb=0.0120555 scc=0.000498628 m=(1)
mn21 (\14\:CKbb \9\:CKb \11\:VSS VSS) g45n1hvt w=(1.45e-07) l=4.5e-08 \
        nf=1 as=2.32e-14 ad=2.03e-14 ps=6.1e-07 pd=5.7e-07 nrd=1.16667 \
        nrs=1.16667 sa=1.4e-07 sb=8.75e-07 sd=160n sca=11.7118 \
        scb=0.0116498 scc=0.000458536 m=(1)
mn12 (net484 \3\:SI \11\:VSS VSS) g45n1hvt w=(1.45e-07) l=4.5e-08 nf=1 \
        as=2.32e-14 ad=2.392e-14 ps=6.1e-07 pd=6.2e-07 nrd=1.16667 \
        nrs=1.16667 sa=3.45e-07 sb=6.7e-07 sd=160n sca=11.7118 \
        scb=0.0116498 scc=0.000458536 m=(1)
mn13 (\8\:Dbp \4\:SE net484 VSS) g45n1hvt w=(1.45e-07) l=4.5e-08 nf=1 \
        as=2.392e-14 ad=3.045e-14 ps=6.2e-07 pd=7.1e-07 nrd=1.16667 \
        nrs=1.16667 sa=5.55e-07 sb=4.6e-07 sd=160n sca=11.7118 \
        scb=0.0116498 scc=0.000458536 m=(1)
mn11 (\7\:Db \3\:SEb \8\:Dbp VSS) g45n1hvt w=(1.45e-07) l=4.5e-08 nf=1 \
        as=3.045e-14 ad=2.972e-14 ps=7.1e-07 pd=7e-07 nrd=1.16667 \
        nrs=1.16667 sa=8.1e-07 sb=2.05e-07 sd=160n sca=11.7118 \
        scb=0.0116498 scc=0.000458536 m=(1)
mn10 (\7\:SEb \5\:SE \9\:VSS VSS) g45n1hvt w=(1.45e-07) l=4.5e-08 nf=1 \
        as=4.495e-14 ad=2.03e-14 ps=9.1e-07 pd=5.7e-07 nrd=1.16667 \
        nrs=1.16667 sa=1.4e-07 sb=7e-07 sd=160n sca=6.75077 scb=0.00344229 \
        scc=2.58723e-05 m=(1)
mn0 (net476 \3\:RN \9\:VSS VSS) g45n1hvt w=(1.45e-07) l=4.5e-08 nf=1 \
        as=4.495e-14 ad=2.32e-14 ps=9.1e-07 pd=6.1e-07 nrd=1.16667 \
        nrs=1.16667 sa=4.95e-07 sb=3.45e-07 sd=160n sca=6.75077 \
        scb=0.00344229 scc=2.58723e-05 m=(1)
mn1 (Db \3\:D net476 VSS) g45n1hvt w=(1.45e-07) l=4.5e-08 nf=1 \
        as=2.32e-14 ad=2.03e-14 ps=6.1e-07 pd=5.7e-07 nrd=1.16667 \
        nrs=1.16667 sa=7e-07 sb=1.4e-07 sd=160n sca=6.75077 scb=0.00344229 \
        scc=2.58723e-05 m=(1)
mp56 (\5\:net436 \7\:qbint \22\:VDD VDD) g45p1hvt w=(2.15e-07) l=4.5e-08 \
        nf=1 as=5.728e-14 ad=3.01e-14 ps=1.15e-06 pd=7.1e-07 nrd=1.16667 \
        nrs=1.16667 sa=3.7e-07 sb=1.4e-07 sd=160n sca=46.9517 scb=0.029008 \
        scc=0.00588492 m=(1)
mp20 (\15\:CKb \1\:CK \19\:VDD VDD) g45p1hvt w=(2.15e-07) l=4.5e-08 nf=1 \
        as=7.288e-14 ad=4.085e-14 ps=1.23e-06 pd=8.1e-07 nrd=1.16667 \
        nrs=1.16667 sa=4.1e-07 sb=1.9e-07 sd=160n sca=28.4541 \
        scb=0.0241553 scc=0.00347654 m=(1)
mp45 (\16\:qbint n30 \17\:VDD VDD) g45p1hvt w=(2.15e-07) l=4.5e-08 nf=1 \
        as=7.43e-14 ad=3.01e-14 ps=1.32e-06 pd=7.1e-07 nrd=1.16667 \
        nrs=1.16667 sa=1.4e-07 sb=1.855e-06 sd=160n sca=33.2772 \
        scb=0.0257934 scc=0.00427133 m=(1)
mp50 (net395 \8\:qbint \17\:VDD VDD) g45p1hvt w=(2.15e-07) l=4.5e-08 \
        nf=1 as=7.43e-14 ad=5.483e-14 ps=1.32e-06 pd=9.4e-07 nrd=1.16667 \
        nrs=1.16667 sa=4.05e-07 sb=1.59e-06 sd=160n sca=33.2772 \
        scb=0.0257934 scc=0.00427133 m=(1)
mp51 (\4\:n30 \3\:CKbb net395 VDD) g45p1hvt w=(2.15e-07) l=4.5e-08 nf=1 \
        as=5.482e-14 ad=3.44e-14 ps=9.4e-07 pd=7.5e-07 nrd=1.16667 \
        nrs=1.16667 sa=7.05e-07 sb=1.29e-06 sd=160n sca=33.2772 \
        scb=0.0257934 scc=0.00427133 m=(1)
mp40 (\4\:n30 \3\:CKb \8\:mout VDD) g45p1hvt w=(2.15e-07) l=4.5e-08 nf=1 \
        as=3.87e-14 ad=3.44e-14 ps=7.9e-07 pd=7.5e-07 nrd=1.16667 \
        nrs=1.16667 sa=9.1e-07 sb=1.085e-06 sd=160n sca=33.2772 \
        scb=0.0257934 scc=0.00427133 m=(1)
mp30 (\8\:mout \4\:n20 \15\:VDD VDD) g45p1hvt w=(2.15e-07) l=4.5e-08 \
        nf=1 as=1.061e-13 ad=3.87e-14 ps=1.85e-06 pd=7.9e-07 nrd=1.16667 \
        nrs=1.16667 sa=1.135e-06 sb=8.6e-07 sd=160n sca=33.2772 \
        scb=0.0257934 scc=0.00427133 m=(1)
mp35 (net375 mout \15\:VDD VDD) g45p1hvt w=(2.15e-07) l=4.5e-08 nf=1 \
        as=1.061e-13 ad=1.29e-14 ps=1.85e-06 pd=5.5e-07 nrd=1.16667 \
        nrs=1.16667 sa=1.4e-06 sb=5.95e-07 sd=160n sca=33.2772 \
        scb=0.0257934 scc=0.00427133 m=(1)
mp36 (\5\:n20 \8\:CKb net375 VDD) g45p1hvt w=(2.15e-07) l=4.5e-08 nf=1 \
        as=1.29e-14 ad=4.515e-14 ps=5.5e-07 pd=8.5e-07 nrd=1.16667 \
        nrs=1.16667 sa=1.505e-06 sb=4.9e-07 sd=160n sca=33.2772 \
        scb=0.0257934 scc=0.00427133 m=(1)
mp25 (\5\:n20 \6\:CKbb \4\:Dbp VDD) g45p1hvt w=(2.15e-07) l=4.5e-08 nf=1 \
        as=5.053e-14 ad=4.515e-14 ps=9e-07 pd=8.5e-07 nrd=1.16667 \
        nrs=1.16667 sa=1.76e-06 sb=2.35e-07 sd=160n sca=33.2772 \
        scb=0.0257934 scc=0.00427133 m=(1)
mp21 (\8\:CKbb \5\:CKb \13\:VDD VDD) g45p1hvt w=(2.15e-07) l=4.5e-08 \
        nf=1 as=3.44e-14 ad=3.01e-14 ps=7.5e-07 pd=7.1e-07 nrd=1.16667 \
        nrs=1.16667 sa=1.4e-07 sb=8.05e-07 sd=160n sca=12.3081 \
        scb=0.0110829 scc=0.000360616 m=(1)
mp12 (net411 \1\:SI \13\:VDD VDD) g45p1hvt w=(2.15e-07) l=4.5e-08 nf=1 \
        as=3.44e-14 ad=4.515e-14 ps=7.5e-07 pd=8.5e-07 nrd=1.16667 \
        nrs=1.16667 sa=3.45e-07 sb=6e-07 sd=160n sca=12.3081 scb=0.0110829 \
        scc=0.000360616 m=(1)
mp13 (Dbp SEb net411 VDD) g45p1hvt w=(2.15e-07) l=4.5e-08 nf=1 \
        as=4.515e-14 ad=3.44e-14 ps=8.5e-07 pd=7.5e-07 nrd=1.16667 \
        nrs=1.16667 sa=6e-07 sb=3.45e-07 sd=160n sca=12.3081 scb=0.0110829 \
        scc=0.000360616 m=(1)
mp11 (Dbp \6\:SE \5\:Db VDD) g45p1hvt w=(2.15e-07) l=4.5e-08 nf=1 \
        as=3.01e-14 ad=3.44e-14 ps=7.1e-07 pd=7.5e-07 nrd=1.16667 \
        nrs=1.16667 sa=8.05e-07 sb=1.4e-07 sd=160n sca=12.3081 \
        scb=0.0110829 scc=0.000360616 m=(1)
mp10 (\5\:SEb \1\:SE \11\:VDD VDD) g45p1hvt w=(2.15e-07) l=4.5e-08 nf=1 \
        as=1.0985e-13 ad=3.01e-14 ps=1.77e-06 pd=7.1e-07 nrd=1.16667 \
        nrs=1.16667 sa=1.4e-07 sb=7.6e-07 sd=160n sca=45.7906 \
        scb=0.0283307 scc=0.00588417 m=(1)
mp0 (\3\:Db \1\:RN \11\:VDD VDD) g45p1hvt w=(2.15e-07) l=4.5e-08 nf=1 \
        as=1.0985e-13 ad=3.44e-14 ps=1.77e-06 pd=7.5e-07 nrd=1.16667 \
        nrs=1.16667 sa=4.95e-07 sb=4.05e-07 sd=160n sca=46.5108 \
        scb=0.0286367 scc=0.00588432 m=(1)
mp1 (\3\:Db \1\:D \1\:VDD VDD) g45p1hvt w=(2.15e-07) l=4.5e-08 nf=1 \
        as=4.3e-14 ad=3.44e-14 ps=8.3e-07 pd=7.5e-07 nrd=1.16667 \
        nrs=1.16667 sa=7e-07 sb=2e-07 sd=160n sca=47.9436 scb=0.0302509 \
        scc=0.00589103 m=(1)
ends SDFFTRX1
// End of subcircuit definition.
