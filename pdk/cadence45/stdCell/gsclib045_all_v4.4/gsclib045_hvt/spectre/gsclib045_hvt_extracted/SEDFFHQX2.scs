// Generated for: spectre (May  1 09:16:13 2013 )
// Library name: gsclib045_hvt
// Cell name: SEDFFHQX2
// View name: extracted

simulator lang=spectre

subckt SEDFFHQX2 CK D E Q SE SI VDD VSS
mp0 (\7\:Eb \1\:E \23\:VDD VDD) g45p1hvt w=(2.15e-07) l=4.5e-08 nf=1 \
        as=6.535e-14 ad=3.01e-14 ps=1.16e-06 pd=7.1e-07 nrd=1.16667 \
        nrs=1.16667 sa=1.4e-07 sb=1.36e-06 sd=160n sca=14.119 scb=0.012489 \
        scc=0.00033733 m=(1)
mp10 (\7\:SEb \6\:SE \21\:VDD VDD) g45p1hvt w=(2.15e-07) l=4.5e-08 nf=1 \
        as=8.363e-14 ad=3.01e-14 ps=1.33e-06 pd=7.1e-07 nrd=1.16667 \
        nrs=1.16667 sa=1.36e-06 sb=1.4e-07 sd=160n sca=12.1244 \
        scb=0.0107968 scc=0.000332109 m=(1)
mp21 (\10\:Ckbb \6\:CKb \1\:VDD VDD) g45p1hvt w=(2.15e-07) l=4.5e-08 \
        nf=1 as=5.267e-14 ad=3.655e-14 ps=9.2e-07 pd=7.7e-07 nrd=1.16667 \
        nrs=1.16667 sa=1.7e-07 sb=4.3e-07 sd=160n sca=12.2145 \
        scb=0.00974237 scc=0.000188593 m=(1)
mp20 (\18\:CKb \1\:CK \1\:VDD VDD) g45p1hvt w=(2.15e-07) l=4.5e-08 nf=1 \
        as=5.267e-14 ad=3.01e-14 ps=9.2e-07 pd=7.1e-07 nrd=1.16667 \
        nrs=1.16667 sa=4.6e-07 sb=1.4e-07 sd=160n sca=16.1974 \
        scb=0.0160404 scc=0.000308643 m=(1)
C1 (SI VSS) capacitor c=7.31585e-17
C2 (Q VSS) capacitor c=2.74608e-17
C3 (VDD VSS) capacitor c=4.17589e-16
C4 (SE VSS) capacitor c=4.24807e-17
C5 (E VSS) capacitor c=4.34332e-17
C6 (CK VSS) capacitor c=2.45228e-17
C7 (Eb VSS) capacitor c=6.3732e-17
C8 (net526 VSS) capacitor c=4.94823e-18
C9 (Db VSS) capacitor c=8.48048e-17
C10 (net494 VSS) capacitor c=3.18617e-18
C11 (qint VSS) capacitor c=3.6561e-17
C12 (SEb VSS) capacitor c=3.32565e-17
C13 (Dbp VSS) capacitor c=8.83023e-17
C14 (net518 VSS) capacitor c=1.39771e-18
C15 (qbint VSS) capacitor c=4.6892e-17
C16 (n30 VSS) capacitor c=4.58482e-17
C17 (net509 VSS) capacitor c=3.41934e-18
C18 (CKb VSS) capacitor c=7.52887e-17
C19 (mout VSS) capacitor c=4.37764e-17
C20 (Ckbb VSS) capacitor c=4.47334e-17
C21 (n20 VSS) capacitor c=4.4085e-17
C22 (net501 VSS) capacitor c=1.52067e-18
C23 (net449 VSS) capacitor c=1.88455e-18
C24 (net405 VSS) capacitor c=6.71218e-18
C25 (net441 VSS) capacitor c=1.64085e-18
C26 (net426 VSS) capacitor c=4.71835e-18
C27 (net417 VSS) capacitor c=1.2468e-18
C28 (\1\:CK VSS) capacitor c=3.27696e-17
C29 (\6\:CKb VSS) capacitor c=3.71459e-17
C30 (\5\:Ckbb VSS) capacitor c=3.66363e-17
C31 (\4\:CKb VSS) capacitor c=6.95285e-17
C32 (\3\:mout VSS) capacitor c=9.65807e-17
C33 (\3\:n20 VSS) capacitor c=5.63341e-17
C34 (\2\:CKb VSS) capacitor c=5.54083e-17
C35 (\16\:qbint VSS) capacitor c=5.31057e-17
C36 (\1\:SI VSS) capacitor c=5.39821e-17
C37 (\3\:SEb VSS) capacitor c=3.72403e-17
C38 (\5\:SE VSS) capacitor c=2.59369e-17
C39 (\6\:SE VSS) capacitor c=3.15321e-17
C40 (\4\:E VSS) capacitor c=6.53358e-17
C41 (\1\:D VSS) capacitor c=9.26442e-17
C42 (\1\:E VSS) capacitor c=5.28153e-17
C43 (\3\:CK VSS) capacitor c=5.00717e-17
C44 (\10\:CKb VSS) capacitor c=2.55572e-17
C45 (\8\:CKb VSS) capacitor c=4.77076e-17
C46 (\7\:Ckbb VSS) capacitor c=6.57069e-17
C47 (\3\:Ckbb VSS) capacitor c=3.7306e-17
C48 (\13\:qbint VSS) capacitor c=3.08739e-17
C49 (\3\:n30 VSS) capacitor c=4.90707e-17
C50 (\9\:qbint VSS) capacitor c=2.65114e-17
C51 (\3\:SI VSS) capacitor c=8.10922e-17
C52 (\1\:SE VSS) capacitor c=1.03329e-16
C53 (\4\:SE VSS) capacitor c=4.18448e-17
C54 (\3\:qint VSS) capacitor c=1.00295e-16
C55 (\3\:Eb VSS) capacitor c=5.75275e-17
C56 (\6\:E VSS) capacitor c=3.09247e-17
C57 (\3\:D VSS) capacitor c=6.32244e-17
C58 (\3\:E VSS) capacitor c=2.74337e-17
C59 (\4\:CK VSS) capacitor c=1.29561e-17
C60 (\9\:CKb VSS) capacitor c=1.85948e-17
C61 (\6\:Ckbb VSS) capacitor c=2.43767e-17
C62 (\5\:CKb VSS) capacitor c=3.00606e-17
C63 (\2\:mout VSS) capacitor c=5.17862e-17
C64 (\2\:n20 VSS) capacitor c=3.90024e-17
C65 (\4\:Ckbb VSS) capacitor c=3.99469e-17
C66 (\3\:CKb VSS) capacitor c=2.10798e-17
C67 (\2\:Ckbb VSS) capacitor c=4.12063e-17
C68 (\15\:qbint VSS) capacitor c=3.25864e-17
C69 (\2\:n30 VSS) capacitor c=3.80739e-17
C70 (\8\:qbint VSS) capacitor c=1.97356e-17
C71 (\4\:SI VSS) capacitor c=4.84068e-17
C72 (\4\:SEb VSS) capacitor c=4.71172e-17
C73 (\2\:SEb VSS) capacitor c=3.43092e-17
C74 (\3\:SE VSS) capacitor c=5.29068e-17
C75 (\2\:qint VSS) capacitor c=4.06128e-17
C76 (\4\:Eb VSS) capacitor c=4.52189e-17
C77 (\5\:E VSS) capacitor c=6.58165e-17
C78 (\2\:Eb VSS) capacitor c=3.50545e-17
C79 (\2\:D VSS) capacitor c=5.15234e-17
C80 (\2\:E VSS) capacitor c=4.16908e-17
C81 (\18\:CKb VSS) capacitor c=3.29215e-17
C82 (\1\:VDD VSS) capacitor c=5.93457e-17
C83 (\10\:Ckbb VSS) capacitor c=9.98175e-17
C84 (\8\:n20 VSS) capacitor c=4.29635e-17
C85 (\13\:VDD VSS) capacitor c=2.17812e-17
C86 (\4\:mout VSS) capacitor c=5.89414e-17
C87 (\8\:n30 VSS) capacitor c=5.97687e-17
C88 (\15\:VDD VSS) capacitor c=6.31179e-17
C89 (\21\:qbint VSS) capacitor c=4.93079e-17
C90 (\8\:qint VSS) capacitor c=1.70476e-17
C91 (\1\:Q VSS) capacitor c=6.54261e-17
C92 (\7\:Dbp VSS) capacitor c=9.27837e-17
C93 (\7\:SEb VSS) capacitor c=1.13337e-16
C94 (\21\:VDD VSS) capacitor c=6.87248e-17
C95 (\7\:Db VSS) capacitor c=1.14157e-16
C96 (\23\:VDD VSS) capacitor c=2.75365e-17
C97 (\7\:Eb VSS) capacitor c=7.94691e-17
C98 (\3\:VDD VSS) capacitor c=8.45461e-17
C99 (\11\:CKb VSS) capacitor c=2.32923e-17
C100 (\14\:Ckbb VSS) capacitor c=1.06097e-16
C101 (\3\:Dbp VSS) capacitor c=3.82227e-16
C102 (\4\:n20 VSS) capacitor c=6.9449e-17
C103 (\7\:mout VSS) capacitor c=4.87322e-17
C104 (\4\:n30 VSS) capacitor c=8.78565e-17
C105 (\19\:qbint VSS) capacitor c=5.02897e-17
C106 (\6\:qint VSS) capacitor c=8.23892e-17
C107 (\3\:Q VSS) capacitor c=4.88125e-17
C108 (\5\:Dbp VSS) capacitor c=3.61654e-16
C109 (\3\:Db VSS) capacitor c=1.52256e-16
C110 (\10\:SEb VSS) capacitor c=8.6339e-17
C111 (\5\:Db VSS) capacitor c=1.70268e-16
C112 (\5\:Eb VSS) capacitor c=9.66379e-17
C113 (\2\:SE VSS) capacitor c=5.71535e-17
C114 (\2\:qbint VSS) capacitor c=1.27861e-17
C115 (\3\:qbint VSS) capacitor c=3.73253e-18
C116 (\4\:qbint VSS) capacitor c=1.44319e-16
C117 (\14\:qbint VSS) capacitor c=2.68772e-17
C118 (\4\:D VSS) capacitor c=9.7041e-17
C119 (\7\:E VSS) capacitor c=7.61954e-17
C120 (\8\:E VSS) capacitor c=7.20808e-17
C121 (\7\:CKb VSS) capacitor c=3.55688e-17
C122 (\9\:Eb VSS) capacitor c=1.21866e-16
C123 (\10\:Eb VSS) capacitor c=4.60098e-17
C124 (\11\:Eb VSS) capacitor c=1.202e-16
C125 (\2\:CK VSS) capacitor c=3.79514e-17
C126 (\8\:SE VSS) capacitor c=5.25927e-17
C127 (\5\:SEb VSS) capacitor c=6.76918e-17
C128 (\6\:SEb VSS) capacitor c=1.37513e-16
C129 (\9\:SEb VSS) capacitor c=8.05773e-17
C130 (\5\:SI VSS) capacitor c=3.74785e-17
C131 (\4\:qint VSS) capacitor c=2.44122e-16
C132 (\5\:qint VSS) capacitor c=2.33881e-16
C133 (\17\:qbint VSS) capacitor c=5.43319e-17
C134 (\18\:qbint VSS) capacitor c=6.26099e-17
C135 (\6\:n30 VSS) capacitor c=8.78019e-17
C136 (\7\:n30 VSS) capacitor c=6.07084e-17
C137 (\6\:mout VSS) capacitor c=4.35284e-17
C138 (\9\:mout VSS) capacitor c=4.39292e-17
C139 (\6\:n20 VSS) capacitor c=5.93845e-17
C140 (\7\:n20 VSS) capacitor c=4.43323e-17
C141 (\8\:Ckbb VSS) capacitor c=6.34999e-17
C142 (\9\:Ckbb VSS) capacitor c=1.59172e-16
C143 (\12\:Ckbb VSS) capacitor c=1.30366e-16
C144 (\13\:Ckbb VSS) capacitor c=1.76076e-17
C145 (\16\:Ckbb VSS) capacitor c=4.66368e-17
C146 (\13\:CKb VSS) capacitor c=5.39534e-17
C147 (\14\:CKb VSS) capacitor c=1.32216e-16
C148 (\15\:CKb VSS) capacitor c=1.67086e-16
C149 (\16\:CKb VSS) capacitor c=7.49682e-17
C150 (\17\:CKb VSS) capacitor c=2.91227e-17
C151 (\5\:CK VSS) capacitor c=7.31758e-17
C152 (\5\:VDD VSS) capacitor c=4.54153e-17
C153 (\6\:VDD VSS) capacitor c=2.23379e-17
C154 (\8\:VDD VSS) capacitor c=1.11279e-16
C155 (\10\:VDD VSS) capacitor c=4.30426e-17
C156 (\12\:VDD VSS) capacitor c=2.42182e-17
Rk1 (\4\:D D) resistor r=0.003004 c=0
Rk17 (\5\:SI SI) resistor r=0.05217 c=0
Rk18 (\2\:Q Q) resistor r=0.2414 c=0
Rk19 (Q \4\:Q) resistor r=0.08409 c=0
Rk67 (\2\:VSS \4\:VSS) resistor r=0.4568 c=0
Rk68 (\4\:VSS \5\:VSS) resistor r=0.2823 c=0
Rk69 (\5\:VSS \6\:VSS) resistor r=0.5354 c=0
Rk70 (\6\:VSS \7\:VSS) resistor r=0.2832 c=0
Rk71 (\7\:VSS \8\:VSS) resistor r=0.1193 c=0
Rk73 (\8\:VSS \10\:VSS) resistor r=0.6392 c=0
Rk74 (\10\:VSS \11\:VSS) resistor r=0.1478 c=0
Rk76 (\12\:VSS VSS) resistor r=0.277 c=0
Rk75 (\11\:VSS \12\:VSS) resistor r=0.2723 c=0
Rk77 (\5\:VSS \14\:VSS) resistor r=0.04332 c=0
Rk78 (\6\:VSS \16\:VSS) resistor r=0.2366 c=0
Rk81 (\10\:VSS \22\:VSS) resistor r=0.1745 c=0
Rk82 (\12\:VSS \24\:VSS) resistor r=0.1211 c=0
Rk51 (\2\:VDD \4\:VDD) resistor r=0.5549 c=0
Rk52 (\4\:VDD \5\:VDD) resistor r=0.335 c=0
Rk53 (\5\:VDD \6\:VDD) resistor r=0.5229 c=0
Rk54 (\6\:VDD \7\:VDD) resistor r=0.2431 c=0
Rk55 (\7\:VDD \8\:VDD) resistor r=0.09512 c=0
Rk57 (\8\:VDD \10\:VDD) resistor r=0.7395 c=0
Rk58 (\10\:VDD \11\:VDD) resistor r=0.1628 c=0
Rk60 (\12\:VDD VDD) resistor r=0.278 c=0
Rk59 (\11\:VDD \12\:VDD) resistor r=0.2732 c=0
Rk61 (\5\:VDD \14\:VDD) resistor r=0.04332 c=0
Rk62 (\6\:VDD \16\:VDD) resistor r=0.3384 c=0
Rk65 (\10\:VDD \22\:VDD) resistor r=0.2473 c=0
Rk66 (\12\:VDD \24\:VDD) resistor r=0.1744 c=0
Rk9 (SE \8\:SE) resistor r=0.05225 c=0
Rk8 (\7\:SE \8\:SE) resistor r=0.001772 c=0
Rk3 (\8\:E E) resistor r=0.1322 c=0
Rk2 (\7\:E \8\:E) resistor r=0.53 c=0
Rk50 (CK \5\:CK) resistor r=0.06251 c=0
Rk4 (\6\:Eb \8\:Eb) resistor r=0.8928 c=0
Rk5 (\8\:Eb \9\:Eb) resistor r=0.2918 c=0
Rk6 (\9\:Eb \10\:Eb) resistor r=0.175 c=0
Rk7 (\9\:Eb \11\:Eb) resistor r=0.8958 c=0
Rk10 (\2\:Db \4\:Db) resistor r=0.4645 c=0
Rk11 (\4\:Db \6\:Db) resistor r=0.9933 c=0
Rk12 (\6\:Db \8\:Db) resistor r=0.5856 c=0
Rk20 (\4\:qint \5\:qint) resistor r=1.8102 c=0
Rk21 (\5\:qint \7\:qint) resistor r=0.5173 c=0
Rk22 (\5\:qint \9\:qint) resistor r=0.05784 c=0
Rk13 (\5\:SEb \6\:SEb) resistor r=0.4997 c=0
Rk14 (\6\:SEb \8\:SEb) resistor r=0.3644 c=0
Rk15 (\6\:SEb \9\:SEb) resistor r=0.3726 c=0
Rk16 (\8\:SEb \11\:SEb) resistor r=0.5618 c=0
Rk35 (\2\:Dbp \4\:Dbp) resistor r=0.4582 c=0
Rk36 (\4\:Dbp \6\:Dbp) resistor r=2.8143 c=0
Rk37 (\6\:Dbp \8\:Dbp) resistor r=0.3409 c=0
Rk23 (\17\:qbint \18\:qbint) resistor r=0.226 c=0
Rk24 (\18\:qbint \20\:qbint) resistor r=0.08584 c=0
Rk25 (\18\:qbint \22\:qbint) resistor r=0.2829 c=0
Rk26 (\5\:n30 \6\:n30) resistor r=0.4747 c=0
Rk27 (\6\:n30 \7\:n30) resistor r=0.2481 c=0
Rk28 (\6\:n30 \9\:n30) resistor r=0.345 c=0
Rk44 (\12\:CKb \13\:CKb) resistor r=0.2034 c=0
Rk45 (\13\:CKb \14\:CKb) resistor r=0.363 c=0
Rk46 (\14\:CKb \15\:CKb) resistor r=0.9003 c=0
Rk47 (\15\:CKb \16\:CKb) resistor r=0.554 c=0
Rk48 (\13\:CKb \17\:CKb) resistor r=0.1176 c=0
Rk49 (\14\:CKb \19\:CKb) resistor r=0.1756 c=0
Rk29 (\5\:mout \6\:mout) resistor r=0.3134 c=0
Rk30 (\6\:mout \8\:mout) resistor r=0.1882 c=0
Rk31 (\6\:mout \9\:mout) resistor r=0.2058 c=0
Rk38 (\8\:Ckbb \9\:Ckbb) resistor r=0.245 c=0
Rk39 (\9\:Ckbb \11\:Ckbb) resistor r=0.2901 c=0
Rk40 (\9\:Ckbb \12\:Ckbb) resistor r=1.0096 c=0
Rk41 (\12\:Ckbb \13\:Ckbb) resistor r=0.0984 c=0
Rk42 (\11\:Ckbb \15\:Ckbb) resistor r=0.6457 c=0
Rk43 (\12\:Ckbb \16\:Ckbb) resistor r=0.1375 c=0
Rk32 (\5\:n20 \6\:n20) resistor r=0.3803 c=0
Rk33 (\6\:n20 \7\:n20) resistor r=0.2058 c=0
Rk34 (\6\:n20 \9\:n20) resistor r=0.1206 c=0
Rl3 (\1\:D \2\:D) resistor r=78.079 c=0
Rl4 (\2\:D \3\:D) resistor r=122.31 c=0
Rl18 (\1\:SI \2\:SI) resistor r=47.9178 c=0
Rl19 (\2\:SI \3\:SI) resistor r=104.871 c=0
Rl20 (\2\:SI \4\:SI) resistor r=4.0612 c=0
Rl16 (\3\:SE \6\:SE) resistor r=94.9636 c=0
Rl14 (\3\:SE \4\:SE) resistor r=99.7951 c=0
Rl15 (\2\:SE \5\:SE) resistor r=30.4507 c=0
Rl12 (\1\:SE \2\:SE) resistor r=191.851 c=0
Rl13 (\2\:SE \3\:SE) resistor r=186.928 c=0
Rl6 (\4\:E \5\:E) resistor r=232.246 c=0
Rl7 (\5\:E \6\:E) resistor r=24.2328 c=0
Rl1 (\1\:E \2\:E) resistor r=155.769 c=0
Rl2 (\2\:E \3\:E) resistor r=48.2661 c=0
Rl52 (\1\:CK \2\:CK) resistor r=91.0479 c=0
Rl53 (\2\:CK \3\:CK) resistor r=173.385 c=0
Rl54 (\2\:CK \4\:CK) resistor r=5.1011 c=0
Rl8 (\3\:Eb \4\:Eb) resistor r=49.2328 c=0
Rl5 (Eb \2\:Eb) resistor r=24.2328 c=0
Rl9 (qint \2\:qint) resistor r=24.2328 c=0
Rl10 (\2\:qint \3\:qint) resistor r=176.156 c=0
Rl17 (\3\:SEb \4\:SEb) resistor r=24.2328 c=0
Rl11 (SEb \2\:SEb) resistor r=29.5379 c=0
Rl21 (\2\:qbint qbint) resistor r=122.758 c=0
Rl27 (\2\:qbint \8\:qbint) resistor r=42.6971 c=0
Rl28 (\3\:qbint \9\:qbint) resistor r=36.22 c=0
Rl22 (\3\:qbint \2\:qbint) resistor r=27.3132 c=0
Rl23 (\4\:qbint \3\:qbint) resistor r=67.6978 c=0
Rl36 (\14\:qbint \16\:qbint) resistor r=82.3738 c=0
Rl34 (\14\:qbint \13\:qbint) resistor r=76.901 c=0
Rl35 (\14\:qbint \15\:qbint) resistor r=35.0048 c=0
Rl32 (n30 \2\:n30) resistor r=24.2328 c=0
Rl33 (\2\:n30 \3\:n30) resistor r=93.4636 c=0
Rl38 (CKb \2\:CKb) resistor r=168.796 c=0
Rl51 (\9\:CKb \10\:CKb) resistor r=39.1533 c=0
Rl45 (\4\:CKb \5\:CKb) resistor r=24.2328 c=0
Rl39 (\2\:CKb \3\:CKb) resistor r=24.2328 c=0
Rl48 (\6\:CKb \7\:CKb) resistor r=168.464 c=0
Rl49 (\7\:CKb \8\:CKb) resistor r=188.887 c=0
Rl50 (\7\:CKb \9\:CKb) resistor r=28.7715 c=0
Rl44 (\2\:mout \3\:mout) resistor r=86.3335 c=0
Rl43 (mout \2\:mout) resistor r=32.9629 c=0
Rl46 (\5\:Ckbb \6\:Ckbb) resistor r=24.2328 c=0
Rl47 (\6\:Ckbb \7\:Ckbb) resistor r=106.491 c=0
Rl40 (\3\:Ckbb \4\:Ckbb) resistor r=70.3867 c=0
Rl37 (Ckbb \2\:Ckbb) resistor r=38.5707 c=0
Rl42 (\2\:n20 \3\:n20) resistor r=46.4312 c=0
Rl41 (n20 \2\:n20) resistor r=86.3335 c=0
Rz5 (\4\:Q \3\:Q) resistor r=75 c=0
Rz18 (\2\:VSS \1\:VSS) resistor r=75 c=0
Rz19 (\14\:VSS \13\:VSS) resistor r=75 c=0
Rz20 (\16\:VSS \15\:VSS) resistor r=75 c=0
Rz23 (\22\:VSS \21\:VSS) resistor r=75 c=0
Rz24 (\24\:VSS \23\:VSS) resistor r=75 c=0
Rz15 (\4\:VDD \3\:VDD) resistor r=7.5 c=0
Rz16 (\7\:VDD \3\:VDD) resistor r=6.25 c=0
Rz17 (\11\:VDD \3\:VDD) resistor r=6.25 c=0
Rz1 (\5\:Eb \6\:Eb) resistor r=75 c=0
Rz2 (\3\:Db \4\:Db) resistor r=75 c=0
Rz3 (\5\:Db \6\:Db) resistor r=75 c=0
Rz6 (\6\:qint \7\:qint) resistor r=75 c=0
Rz4 (\10\:SEb \11\:SEb) resistor r=75 c=0
Rz11 (\3\:Dbp \4\:Dbp) resistor r=75 c=0
Rz12 (\5\:Dbp \6\:Dbp) resistor r=75 c=0
Rz7 (\20\:qbint \19\:qbint) resistor r=75 c=0
Rz8 (\4\:n30 \5\:n30) resistor r=75 c=0
Rz14 (\11\:CKb \12\:CKb) resistor r=75 c=0
Rz9 (\7\:mout \8\:mout) resistor r=75 c=0
Rz13 (\14\:Ckbb \15\:Ckbb) resistor r=75 c=0
Rz10 (\4\:n20 \5\:n20) resistor r=75 c=0
Ry5 (\2\:Q \1\:Q) resistor r=62 c=0
Ry22 (\4\:VSS \3\:VSS) resistor r=6.2 c=0
Ry23 (\7\:VSS \3\:VSS) resistor r=5.1667 c=0
Ry24 (\11\:VSS \3\:VSS) resistor r=5.1667 c=0
Ry15 (\2\:VDD \1\:VDD) resistor r=62 c=0
Ry16 (\14\:VDD \13\:VDD) resistor r=62 c=0
Ry17 (\16\:VDD \15\:VDD) resistor r=20.6667 c=0
Ry20 (\22\:VDD \21\:VDD) resistor r=31 c=0
Ry21 (\24\:VDD \23\:VDD) resistor r=62 c=0
Ry1 (\7\:Eb \8\:Eb) resistor r=62 c=0
Ry2 (Db \2\:Db) resistor r=62 c=0
Ry3 (\7\:Db \8\:Db) resistor r=62 c=0
Ry6 (\8\:qint \9\:qint) resistor r=62 c=0
Ry4 (\7\:SEb \8\:SEb) resistor r=62 c=0
Ry11 (Dbp \2\:Dbp) resistor r=62 c=0
Ry12 (\7\:Dbp \8\:Dbp) resistor r=62 c=0
Ry7 (\22\:qbint \21\:qbint) resistor r=62 c=0
Ry8 (\8\:n30 \9\:n30) resistor r=31 c=0
Ry14 (\18\:CKb \19\:CKb) resistor r=62 c=0
Ry9 (\4\:mout \5\:mout) resistor r=62 c=0
Ry13 (\10\:Ckbb \11\:Ckbb) resistor r=62 c=0
Ry10 (\8\:n20 \9\:n20) resistor r=62 c=0
Rx1 (\2\:D \4\:D) resistor r=45 c=0
Rx9 (\4\:SI \5\:SI) resistor r=45 c=0
Rx6 (\3\:SE \7\:SE) resistor r=45 c=0
Rx2 (\5\:E \7\:E) resistor r=45 c=0
Rx3 (\2\:E \8\:E) resistor r=45 c=0
Rx22 (\4\:CK \5\:CK) resistor r=45 c=0
Rx4 (\2\:Eb \10\:Eb) resistor r=45 c=0
Rx5 (\4\:Eb \11\:Eb) resistor r=45 c=0
Rx10 (\2\:qint \4\:qint) resistor r=45 c=0
Rx7 (\4\:SEb \5\:SEb) resistor r=45 c=0
Rx8 (\2\:SEb \9\:SEb) resistor r=45 c=0
Rx11 (\17\:qbint \15\:qbint) resistor r=45 c=0
Rx12 (\18\:qbint \8\:qbint) resistor r=45 c=0
Rx13 (\2\:n30 \7\:n30) resistor r=45 c=0
Rx19 (\5\:CKb \15\:CKb) resistor r=45 c=0
Rx20 (\3\:CKb \16\:CKb) resistor r=45 c=0
Rx21 (\9\:CKb \17\:CKb) resistor r=45 c=0
Rx14 (\2\:mout \9\:mout) resistor r=45 c=0
Rx16 (\6\:Ckbb \8\:Ckbb) resistor r=45 c=0
Rx17 (\4\:Ckbb \13\:Ckbb) resistor r=45 c=0
Rx18 (\2\:Ckbb \16\:Ckbb) resistor r=45 c=0
Rx15 (\2\:n20 \7\:n20) resistor r=45 c=0
mn0 (\5\:Eb \3\:E \23\:VSS VSS) g45n1hvt w=(1.45e-07) l=4.5e-08 nf=1 \
        as=5.09e-14 ad=2.03e-14 ps=1e-06 pd=5.7e-07 nrd=1.16667 \
        nrs=1.16667 sa=1.4e-07 sb=1.47e-06 sd=160n sca=9.33388 \
        scb=0.00788941 scc=0.00017958 m=(1)
mn10 (\10\:SEb \4\:SE \21\:VSS VSS) g45n1hvt w=(1.45e-07) l=4.5e-08 nf=1 \
        as=4.8e-14 ad=3.698e-14 ps=9.6e-07 pd=8e-07 nrd=1.16667 \
        nrs=1.16667 sa=1.355e-06 sb=2.55e-07 sd=160n sca=9.33388 \
        scb=0.00788941 scc=0.00017958 m=(1)
mn21 (\14\:Ckbb \10\:CKb \1\:VSS VSS) g45n1hvt w=(1.45e-07) l=4.5e-08 \
        nf=1 as=2.32e-14 ad=2.03e-14 ps=6.1e-07 pd=5.7e-07 nrd=1.16667 \
        nrs=1.16667 sa=1.4e-07 sb=3.45e-07 sd=160n sca=7.688 \
        scb=0.00504888 scc=6.29443e-05 m=(1)
mn20 (\11\:CKb \3\:CK \1\:VSS VSS) g45n1hvt w=(1.45e-07) l=4.5e-08 nf=1 \
        as=2.32e-14 ad=2.03e-14 ps=6.1e-07 pd=5.7e-07 nrd=1.16667 \
        nrs=1.16667 sa=3.45e-07 sb=1.4e-07 sd=160n sca=7.688 \
        scb=0.00504888 scc=6.29443e-05 m=(1)
mn3 (net526 \3\:D \23\:VSS VSS) g45n1hvt w=(2.6e-07) l=4.5e-08 nf=1 \
        as=5.09e-14 ad=4.29e-14 ps=1e-06 pd=8.5e-07 nrd=1.16667 \
        nrs=1.16667 sa=2.98942e-07 sb=1.01692e-06 sd=160n sca=7.96722 \
        scb=0.00567143 scc=0.000107411 m=(1)
mn4 (\5\:Db \6\:E net526 VSS) g45n1hvt w=(2.6e-07) l=4.5e-08 nf=1 \
        as=4.29e-14 ad=7.93e-14 ps=8.5e-07 pd=1.13e-06 nrd=1.16667 \
        nrs=1.16667 sa=5.08942e-07 sb=8.06923e-07 sd=160n sca=7.96722 \
        scb=0.00567143 scc=0.000107411 m=(1)
mn2 (\5\:Db \3\:Eb net494 VSS) g45n1hvt w=(2.6e-07) l=4.5e-08 nf=1 \
        as=1.56e-14 ad=7.93e-14 ps=6.4e-07 pd=1.13e-06 nrd=1.16667 \
        nrs=1.16667 sa=8.58942e-07 sb=4.56923e-07 sd=160n sca=7.96722 \
        scb=0.00567143 scc=0.000107411 m=(1)
mn1 (net494 \3\:qint \21\:VSS VSS) g45n1hvt w=(2.6e-07) l=4.5e-08 nf=1 \
        as=4.8e-14 ad=1.56e-14 ps=9.6e-07 pd=6.4e-07 nrd=1.16667 \
        nrs=1.16667 sa=9.63942e-07 sb=3.51923e-07 sd=160n sca=7.96722 \
        scb=0.00567143 scc=0.000107411 m=(1)
mn11 (\3\:Db SEb \5\:Dbp VSS) g45n1hvt w=(2.6e-07) l=4.5e-08 nf=1 \
        as=4.94e-14 ad=3.64e-14 ps=9e-07 pd=8e-07 nrd=1.16667 nrs=1.16667 \
        sa=1.4e-07 sb=1.25529e-06 sd=160n sca=11.3041 scb=0.010759 \
        scc=0.000493236 m=(1)
mn13 (\5\:Dbp \1\:SE net518 VSS) g45n1hvt w=(2.6e-07) l=4.5e-08 nf=1 \
        as=1.56e-14 ad=4.94e-14 ps=6.4e-07 pd=9e-07 nrd=1.16667 \
        nrs=1.16667 sa=3.75e-07 sb=1.02029e-06 sd=160n sca=11.3041 \
        scb=0.010759 scc=0.000493236 m=(1)
mn12 (net518 \3\:SI \8\:VSS VSS) g45n1hvt w=(2.6e-07) l=4.5e-08 nf=1 \
        as=8.06e-14 ad=1.56e-14 ps=1.14e-06 pd=6.4e-07 nrd=1.16667 \
        nrs=1.16667 sa=4.8e-07 sb=9.15288e-07 sd=160n sca=11.3041 \
        scb=0.010759 scc=0.000493236 m=(1)
mn45 (\19\:qbint \3\:n30 \15\:VSS VSS) g45n1hvt w=(2.6e-07) l=4.5e-08 \
        nf=1 as=7.525e-14 ad=5.33e-14 ps=1.12e-06 pd=9.3e-07 nrd=1.16667 \
        nrs=1.16667 sa=2.05e-07 sb=1.53913e-06 sd=160n sca=11.3041 \
        scb=0.010759 scc=0.000493236 m=(1)
mn55 (\3\:Q \4\:qbint \8\:VSS VSS) g45n1hvt w=(2.6e-07) l=4.5e-08 nf=1 \
        as=8.222e-14 ad=4.16e-14 ps=1.295e-06 pd=8.4e-07 nrd=1.16667 \
        nrs=1.16667 sa=8.35e-07 sb=5.60288e-07 sd=160n sca=11.3041 \
        scb=0.010759 scc=0.000493236 m=(2)
mn56 (\6\:qint \9\:qbint \8\:VSS VSS) g45n1hvt w=(2.05e-07) l=4.5e-08 \
        nf=1 as=8.385e-14 ad=2.87e-14 ps=1.45e-06 pd=6.9e-07 nrd=1.16667 \
        nrs=1.16667 sa=1.305e-06 sb=1.4e-07 sd=160n sca=12.4149 \
        scb=0.012446 scc=0.000614222 m=(1)
mn50 (net509 \13\:qbint \15\:VSS VSS) g45n1hvt w=(2.05e-07) l=4.5e-08 \
        nf=1 as=7.525e-14 ad=3.28e-14 ps=1.12e-06 pd=7.3e-07 nrd=1.16667 \
        nrs=1.16667 sa=5.5e-07 sb=1.54e-06 sd=160n sca=12.4149 \
        scb=0.012446 scc=0.000614222 m=(1)
mn51 (\4\:n30 CKb net509 VSS) g45n1hvt w=(2.05e-07) l=4.5e-08 nf=1 \
        as=3.28e-14 ad=3.382e-14 ps=7.3e-07 pd=7.4e-07 nrd=1.16667 \
        nrs=1.16667 sa=7.55e-07 sb=1.335e-06 sd=160n sca=12.4149 \
        scb=0.012446 scc=0.000614222 m=(1)
mn40 (\4\:n30 \3\:Ckbb \7\:mout VSS) g45n1hvt w=(2.05e-07) l=4.5e-08 nf=1 \
        as=6.458e-14 ad=3.383e-14 ps=1.04e-06 pd=7.4e-07 nrd=1.16667 \
        nrs=1.16667 sa=9.65e-07 sb=1.125e-06 sd=160n sca=12.4149 \
        scb=0.012446 scc=0.000614222 m=(1)
mn30 (\7\:mout n20 \13\:VSS VSS) g45n1hvt w=(2.05e-07) l=4.5e-08 nf=1 \
        as=8.11e-14 ad=6.458e-14 ps=1.45e-06 pd=1.04e-06 nrd=1.16667 \
        nrs=1.16667 sa=1.325e-06 sb=7.65e-07 sd=160n sca=12.4149 \
        scb=0.012446 scc=0.000614222 m=(1)
mn35 (net501 mout \13\:VSS VSS) g45n1hvt w=(2.05e-07) l=4.5e-08 nf=1 \
        as=8.11e-14 ad=2.255e-14 ps=1.45e-06 pd=6.3e-07 nrd=1.16667 \
        nrs=1.16667 sa=1.59e-06 sb=5e-07 sd=160n sca=12.4149 scb=0.012446 \
        scc=0.000614222 m=(1)
mn36 (\4\:n20 \7\:Ckbb net501 VSS) g45n1hvt w=(2.05e-07) l=4.5e-08 nf=1 \
        as=2.255e-14 ad=3.28e-14 ps=6.3e-07 pd=7.3e-07 nrd=1.16667 \
        nrs=1.16667 sa=1.745e-06 sb=3.45e-07 sd=160n sca=12.4149 \
        scb=0.012446 scc=0.000614222 m=(1)
mn25 (\4\:n20 \8\:CKb \3\:Dbp VSS) g45n1hvt w=(2.05e-07) l=4.5e-08 nf=1 \
        as=2.87e-14 ad=3.28e-14 ps=6.9e-07 pd=7.3e-07 nrd=1.16667 \
        nrs=1.16667 sa=1.95e-06 sb=1.4e-07 sd=160n sca=12.4149 \
        scb=0.012446 scc=0.000614222 m=(1)
mp3 (net449 \1\:D \23\:VDD VDD) g45p1hvt w=(3.9e-07) l=4.5e-08 nf=1 \
        as=6.535e-14 ad=2.34e-14 ps=1.16e-06 pd=9e-07 nrd=1.16667 \
        nrs=1.16667 sa=2.69551e-07 sb=9.8141e-07 sd=160n sca=11.9271 \
        scb=0.00973247 scc=0.000231921 m=(1)
mp4 (\7\:Db Eb net449 VDD) g45p1hvt w=(3.9e-07) l=4.5e-08 nf=1 \
        as=2.34e-14 ad=8.775e-14 ps=9e-07 pd=1.23e-06 nrd=1.16667 \
        nrs=1.16667 sa=3.74551e-07 sb=8.7641e-07 sd=160n sca=11.6054 \
        scb=0.0095923 scc=0.000231863 m=(1)
mp2 (\7\:Db \4\:E net405 VDD) g45p1hvt w=(3.9e-07) l=4.5e-08 nf=1 \
        as=9.555e-14 ad=8.775e-14 ps=1.27e-06 pd=1.23e-06 nrd=1.16667 \
        nrs=1.16667 sa=6.44551e-07 sb=6.0641e-07 sd=160n sca=11.3866 \
        scb=0.00953811 scc=0.000231855 m=(1)
mp1 (net405 qint \21\:VDD VDD) g45p1hvt w=(3.9e-07) l=4.5e-08 nf=1 \
        as=8.363e-14 ad=9.555e-14 ps=1.33e-06 pd=1.27e-06 nrd=1.16667 \
        nrs=1.16667 sa=9.34551e-07 sb=3.1641e-07 sd=160n sca=11.3866 \
        scb=0.00953811 scc=0.000231855 m=(1)
mp11 (Db \5\:SE \7\:Dbp VDD) g45p1hvt w=(3.9e-07) l=4.5e-08 nf=1 \
        as=1.443e-13 ad=5.46e-14 ps=1.52e-06 pd=1.06e-06 nrd=1.16667 \
        nrs=1.16667 sa=1.4e-07 sb=1.37231e-06 sd=160n sca=21.3455 \
        scb=0.0174972 scc=0.00212086 m=(1)
mp13 (\7\:Dbp \3\:SEb net441 VDD) g45p1hvt w=(3.9e-07) l=4.5e-08 nf=1 \
        as=5.265e-14 ad=1.443e-13 ps=1.05e-06 pd=1.52e-06 nrd=1.16667 \
        nrs=1.16667 sa=5.55e-07 sb=9.57308e-07 sd=160n sca=21.3455 \
        scb=0.0174972 scc=0.00212086 m=(1)
mp12 (net441 \1\:SI \8\:VDD VDD) g45p1hvt w=(3.9e-07) l=4.5e-08 nf=1 \
        as=1.11e-13 ad=5.265e-14 ps=1.64e-06 pd=1.05e-06 nrd=1.16667 \
        nrs=1.16667 sa=7.35e-07 sb=7.77308e-07 sd=160n sca=21.3455 \
        scb=0.0174972 scc=0.00212086 m=(1)
mp45 (\21\:qbint n30 \15\:VDD VDD) g45p1hvt w=(3.9e-07) l=4.5e-08 nf=1 \
        as=7.94e-14 ad=4.5e-14 ps=1.22e-06 pd=1.06e-06 nrd=1.16667 \
        nrs=1.16667 sa=1.15385e-07 sb=1.52705e-06 sd=160n sca=17.2385 \
        scb=0.0152696 scc=0.00137893 m=(1)
mp55_1__rcx (\1\:Q \4\:qbint \8\:VDD VDD) g45p1hvt w=(3.9e-07) l=4.5e-08 \
        nf=1 as=1.055e-13 ad=6.24e-14 ps=1.64e-06 pd=1.1e-06 nrd=1.16667 \
        nrs=1.16667 sa=1e-06 sb=5.12308e-07 sd=160n sca=21.3455 \
        scb=0.0174972 scc=0.00212086 m=(2)
mp56 (\8\:qint qbint \8\:VDD VDD) g45p1hvt w=(3.1e-07) l=4.5e-08 nf=1 \
        as=1e-13 ad=3.58e-14 ps=1.64e-06 pd=9e-07 nrd=1.16667 nrs=1.16667 \
        sa=1.38613e-06 sb=1.15484e-07 sd=160n sca=13.3668 scb=0.0122284 \
        scc=0.000582667 m=(1)
mp50 (net426 \16\:qbint \15\:VDD VDD) g45p1hvt w=(3.1e-07) l=4.5e-08 \
        nf=1 as=7.94e-14 ad=4.34e-14 ps=1.22e-06 pd=9e-07 nrd=1.16667 \
        nrs=1.16667 sa=3.84355e-07 sb=1.62e-06 sd=160n sca=19.1541 \
        scb=0.0174883 scc=0.00172295 m=(1)
mp51 (\8\:n30 Ckbb net426 VDD) g45p1hvt w=(3.1e-07) l=4.5e-08 nf=1 \
        as=4.34e-14 ad=4.96e-14 ps=9e-07 pd=9.4e-07 nrd=1.16667 \
        nrs=1.16667 sa=5.69355e-07 sb=1.435e-06 sd=160n sca=19.1541 \
        scb=0.0174883 scc=0.00172295 m=(1)
mp40 (\8\:n30 \2\:CKb \4\:mout VDD) g45p1hvt w=(3.1e-07) l=4.5e-08 nf=1 \
        as=9.765e-14 ad=4.96e-14 ps=1.25e-06 pd=9.4e-07 nrd=1.16667 \
        nrs=1.16667 sa=7.74355e-07 sb=1.23e-06 sd=160n sca=19.1541 \
        scb=0.0174883 scc=0.00172295 m=(1)
mp30 (\4\:mout \3\:n20 \13\:VDD VDD) g45p1hvt w=(3.1e-07) l=4.5e-08 nf=1 \
        as=1.108e-13 ad=9.765e-14 ps=1.77e-06 pd=1.25e-06 nrd=1.16667 \
        nrs=1.16667 sa=1.13435e-06 sb=8.7e-07 sd=160n sca=19.1541 \
        scb=0.0174883 scc=0.00172295 m=(1)
mp35 (net417 \3\:mout \13\:VDD VDD) g45p1hvt w=(3.1e-07) l=4.5e-08 nf=1 \
        as=1.108e-13 ad=1.86e-14 ps=1.77e-06 pd=7.4e-07 nrd=1.16667 \
        nrs=1.16667 sa=1.39935e-06 sb=6.05e-07 sd=160n sca=19.1541 \
        scb=0.0174883 scc=0.00172295 m=(1)
mp36 (\8\:n20 \4\:CKb net417 VDD) g45p1hvt w=(3.1e-07) l=4.5e-08 nf=1 \
        as=1.86e-14 ad=5.89e-14 ps=7.4e-07 pd=1e-06 nrd=1.16667 \
        nrs=1.16667 sa=1.50435e-06 sb=5e-07 sd=160n sca=19.1541 \
        scb=0.0174883 scc=0.00172295 m=(1)
mp25 (\8\:n20 \5\:Ckbb Dbp VDD) g45p1hvt w=(3.1e-07) l=4.5e-08 nf=1 \
        as=8.215e-14 ad=5.89e-14 ps=1.15e-06 pd=1e-06 nrd=1.16667 \
        nrs=1.16667 sa=1.73935e-06 sb=2.65e-07 sd=160n sca=19.1541 \
        scb=0.0174883 scc=0.00172295 m=(1)
ends SEDFFHQX2
// End of subcircuit definition.
