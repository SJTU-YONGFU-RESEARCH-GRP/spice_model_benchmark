// Generated for: spectre (May  1 09:16:42 2013 )
// Library name: gsclib045_hvt
// Cell name: BMXIX2
// View name: extracted

simulator lang=spectre

subckt BMXIX2 A M0 M1 PPN S VDD VSS X2
mp0 (\11\:M0b \1\:M0 \15\:VDD VDD) g45p1hvt w=(2.15e-07) l=4.5e-08 nf=1 \
        as=3.44e-14 ad=3.01e-14 ps=7.5e-07 pd=7.1e-07 nrd=1.16667 \
        nrs=1.16667 sa=1.4e-07 sb=1.7886e-06 sd=160n sca=16.5061 \
        scb=0.0165824 scc=0.000331714 m=(1)
mp3 (n4 \1\:S \15\:VDD VDD) g45p1hvt w=(2.15e-07) l=4.5e-08 nf=1 \
        as=3.44e-14 ad=1.935e-14 ps=7.5e-07 pd=6.1e-07 nrd=1.16667 \
        nrs=1.16667 sa=3.45e-07 sb=1.61372e-06 sd=160n sca=12.9155 \
        scb=0.0105511 scc=0.000191587 m=(1)
mp4 (\9\:n0 \6\:M0 n4 VDD) g45p1hvt w=(2.15e-07) l=4.5e-08 nf=1 \
        as=1.935e-14 ad=6.128e-14 ps=6.1e-07 pd=1e-06 nrd=1.16667 \
        nrs=1.16667 sa=4.8e-07 sb=1.47872e-06 sd=160n sca=11.9971 \
        scb=0.00955136 scc=0.000188264 m=(1)
mp6 (\9\:n0 \3\:M0b n6 VDD) g45p1hvt w=(2.15e-07) l=4.5e-08 nf=1 \
        as=1.29e-14 ad=6.128e-14 ps=5.5e-07 pd=1e-06 nrd=1.16667 \
        nrs=1.16667 sa=8.1e-07 sb=1.14872e-06 sd=160n sca=11.1138 \
        scb=0.00912362 scc=0.000187967 m=(1)
mp5 (n6 \5\:A \12\:VDD VDD) g45p1hvt w=(2.15e-07) l=4.5e-08 nf=1 \
        as=8.21e-14 ad=1.29e-14 ps=1.45e-06 pd=5.5e-07 nrd=1.16667 \
        nrs=1.16667 sa=9.15e-07 sb=1.04372e-06 sd=160n sca=11.1138 \
        scb=0.00912362 scc=0.000187967 m=(1)
mp9 (n10 \1\:A \12\:VDD VDD) g45p1hvt w=(2.15e-07) l=4.5e-08 nf=1 \
        as=8.21e-14 ad=3.762e-14 ps=1.45e-06 pd=7.8e-07 nrd=1.16667 \
        nrs=1.16667 sa=1.18e-06 sb=7.78721e-07 sd=160n sca=11.1138 \
        scb=0.00912362 scc=0.000187967 m=(1)
mp10 (\4\:n1 M1b n10 VDD) g45p1hvt w=(2.15e-07) l=4.5e-08 nf=1 \
        as=3.762e-14 ad=3.56e-14 ps=7.8e-07 pd=8.1e-07 nrd=1.16667 \
        nrs=1.16667 sa=1.4e-06 sb=5.58721e-07 sd=160n sca=11.1138 \
        scb=0.00912362 scc=0.000187967 m=(1)
mp8 (\4\:n1 \1\:M1 n8 VDD) g45p1hvt w=(2.15e-07) l=4.5e-08 nf=1 \
        as=3.118e-14 ad=3.56e-14 ps=7.2e-07 pd=8.1e-07 nrd=1.16667 \
        nrs=1.16667 sa=1.395e-06 sb=4.68837e-07 sd=160n sca=11.9515 \
        scb=0.0105226 scc=0.000305882 m=(1)
mp7 (n8 \4\:S \10\:VDD VDD) g45p1hvt w=(2.15e-07) l=4.5e-08 nf=1 \
        as=9.32e-14 ad=3.117e-14 ps=1.81e-06 pd=7.2e-07 nrd=1.16667 \
        nrs=1.16667 sa=1.585e-06 sb=2.78837e-07 sd=160n sca=11.9515 \
        scb=0.0105226 scc=0.000305882 m=(1)
mp1 (\5\:M1b \4\:M1 \10\:VDD VDD) g45p1hvt w=(2.15e-07) l=4.5e-08 nf=1 \
        as=9.32e-14 ad=5.697e-14 ps=1.81e-06 pd=9.6e-07 nrd=1.16667 \
        nrs=1.16667 sa=4.72791e-07 sb=2.65e-07 sd=160n sca=27.1298 \
        scb=0.023603 scc=0.0032399 m=(1)
mp11 (\11\:net293 X2b n0 VDD) g45p1hvt w=(2.15e-07) l=4.5e-08 nf=1 \
        as=5.375e-14 ad=3.547e-14 ps=9.3e-07 pd=7.6e-07 nrd=1.16667 \
        nrs=1.16667 sa=2.5e-07 sb=3.5e-07 sd=160n sca=15.6338 scb=0.015455 \
        scc=0.000959319 m=(1)
mp12 (n1 \6\:X2 \11\:net293 VDD) g45p1hvt w=(2.15e-07) l=4.5e-08 nf=1 \
        as=3.547e-14 ad=3.01e-14 ps=7.6e-07 pd=7.1e-07 nrd=1.16667 \
        nrs=1.16667 sa=4.6e-07 sb=1.4e-07 sd=160n sca=15.6338 scb=0.015455 \
        scc=0.000959319 m=(1)
mp2 (\5\:X2b \1\:X2 \1\:VDD VDD) g45p1hvt w=(2.15e-07) l=4.5e-08 nf=1 \
        as=5.942e-14 ad=3.01e-14 ps=1.17e-06 pd=7.1e-07 nrd=1.16667 \
        nrs=1.16667 sa=1.4e-07 sb=5.85e-07 sd=160n sca=18.9525 \
        scb=0.0183104 scc=0.0014243 m=(1)
C1 (M0 VSS) capacitor c=6.48898e-17
C2 (M1 VSS) capacitor c=3.32044e-17
C3 (S VSS) capacitor c=1.65719e-16
C4 (VDD VSS) capacitor c=3.36717e-16
C5 (PPN VSS) capacitor c=2.36872e-17
C6 (X2 VSS) capacitor c=5.33086e-17
C7 (A VSS) capacitor c=5.15966e-17
C8 (M0b VSS) capacitor c=6.19923e-17
C9 (n3 VSS) capacitor c=7.26019e-19
C10 (n0 VSS) capacitor c=2.5896e-17
C11 (n5 VSS) capacitor c=3.40937e-18
C12 (n1 VSS) capacitor c=1.06569e-16
C13 (M1b VSS) capacitor c=5.64069e-17
C14 (net293 VSS) capacitor c=1.25912e-16
C15 (X2b VSS) capacitor c=4.89867e-17
C16 (n4 VSS) capacitor c=3.60548e-18
C17 (n10 VSS) capacitor c=4.35927e-19
C18 (n8 VSS) capacitor c=4.21134e-18
C19 (\1\:X2 VSS) capacitor c=3.38947e-17
C20 (\6\:X2 VSS) capacitor c=3.15874e-17
C21 (\4\:M1 VSS) capacitor c=4.13005e-17
C22 (\4\:S VSS) capacitor c=6.07146e-17
C23 (\1\:M1 VSS) capacitor c=6.74269e-17
C24 (\1\:A VSS) capacitor c=3.37974e-17
C25 (\5\:A VSS) capacitor c=5.47219e-17
C26 (\3\:M0b VSS) capacitor c=6.39208e-17
C27 (\6\:M0 VSS) capacitor c=4.82931e-17
C28 (\1\:S VSS) capacitor c=4.04462e-17
C29 (\1\:M0 VSS) capacitor c=3.88944e-17
C30 (\5\:X2 VSS) capacitor c=3.59065e-17
C31 (\3\:X2b VSS) capacitor c=5.24641e-17
C32 (\4\:X2 VSS) capacitor c=4.88138e-17
C33 (\6\:M1 VSS) capacitor c=3.85822e-17
C34 (\6\:S VSS) capacitor c=9.3944e-17
C35 (\3\:M1b VSS) capacitor c=6.51682e-17
C36 (\3\:M1 VSS) capacitor c=5.38677e-17
C37 (\6\:A VSS) capacitor c=1.64922e-17
C38 (\4\:A VSS) capacitor c=3.26334e-17
C39 (\4\:M0 VSS) capacitor c=4.79078e-17
C40 (\3\:S VSS) capacitor c=7.94875e-17
C41 (\3\:M0 VSS) capacitor c=3.7844e-17
C42 (\4\:net293 VSS) capacitor c=1.26553e-17
C43 (\2\:X2 VSS) capacitor c=5.22664e-17
C44 (\4\:X2b VSS) capacitor c=4.94202e-17
C45 (\2\:X2b VSS) capacitor c=2.48964e-17
C46 (\5\:M1 VSS) capacitor c=2.57765e-17
C47 (\5\:S VSS) capacitor c=2.73388e-17
C48 (\4\:M1b VSS) capacitor c=5.40581e-17
C49 (\2\:M1 VSS) capacitor c=7.42758e-17
C50 (\2\:M1b VSS) capacitor c=4.49346e-17
C51 (\2\:A VSS) capacitor c=5.37989e-17
C52 (\4\:M0b VSS) capacitor c=4.96157e-17
C53 (\5\:M0 VSS) capacitor c=5.03364e-17
C54 (\2\:M0b VSS) capacitor c=4.86142e-17
C55 (\2\:S VSS) capacitor c=6.61409e-17
C56 (\2\:M0 VSS) capacitor c=4.73302e-17
C57 (\1\:VDD VSS) capacitor c=1.2366e-16
C58 (\3\:PPN VSS) capacitor c=8.02206e-17
C59 (\5\:X2b VSS) capacitor c=2.99849e-17
C60 (\11\:net293 VSS) capacitor c=7.59475e-17
C61 (\5\:M1b VSS) capacitor c=5.07036e-17
C62 (\10\:VDD VSS) capacitor c=2.13e-17
C63 (\4\:n1 VSS) capacitor c=1.64172e-16
C64 (\12\:VDD VSS) capacitor c=2.36532e-17
C65 (\9\:n0 VSS) capacitor c=2.38479e-17
C66 (\15\:VDD VSS) capacitor c=5.15042e-17
C67 (\11\:M0b VSS) capacitor c=4.86554e-17
C68 (\4\:VDD VSS) capacitor c=1.04175e-16
C69 (\1\:PPN VSS) capacitor c=3.69103e-17
C70 (\10\:X2b VSS) capacitor c=4.12592e-17
C71 (\6\:n1 VSS) capacitor c=7.60569e-17
C72 (\9\:net293 VSS) capacitor c=1.58038e-16
C73 (\7\:n0 VSS) capacitor c=6.8781e-17
C74 (\10\:M1b VSS) capacitor c=4.77774e-17
C75 (\8\:n1 VSS) capacitor c=1.74803e-16
C76 (\5\:n0 VSS) capacitor c=9.71123e-17
C77 (\8\:M0b VSS) capacitor c=1.79253e-17
C78 (\3\:A VSS) capacitor c=1.52232e-17
C79 (\3\:X2 VSS) capacitor c=6.58407e-17
C80 (\7\:M0 VSS) capacitor c=7.3642e-17
C81 (\5\:M0b VSS) capacitor c=1.40415e-16
C82 (\6\:M0b VSS) capacitor c=1.30123e-16
C83 (\7\:M0b VSS) capacitor c=5.82999e-17
C84 (\10\:M0b VSS) capacitor c=2.34287e-17
C85 (\7\:A VSS) capacitor c=5.52908e-17
C86 (\7\:S VSS) capacitor c=1.52163e-16
C87 (\7\:M1 VSS) capacitor c=5.17071e-17
C88 (\8\:M1 VSS) capacitor c=2.78164e-17
C89 (\7\:M1b VSS) capacitor c=6.12837e-17
C90 (\8\:M1b VSS) capacitor c=9.39555e-17
C91 (\9\:M1b VSS) capacitor c=4.80871e-17
C92 (\3\:n0 VSS) capacitor c=2.32956e-16
C93 (\4\:n0 VSS) capacitor c=1.8902e-16
C94 (\3\:n1 VSS) capacitor c=3.47633e-16
C95 (\7\:X2b VSS) capacitor c=8.16821e-17
C96 (\8\:X2b VSS) capacitor c=5.74674e-17
C97 (\9\:X2b VSS) capacitor c=7.53527e-17
C98 (\7\:X2 VSS) capacitor c=4.43267e-17
C99 (\8\:net293 VSS) capacitor c=1.23064e-16
C100 (\6\:VDD VSS) capacitor c=5.21577e-17
C101 (\14\:VDD VSS) capacitor c=2.34979e-17
Rk1 (\7\:M0 M0) resistor r=0.2478 c=0
Rk11 (\7\:M1 M1) resistor r=0.1922 c=0
Rk12 (M1 \8\:M1) resistor r=0.0364 c=0
Rk46 (\1\:VSS \5\:VSS) resistor r=0.2272 c=0
Rk47 (\5\:VSS \6\:VSS) resistor r=0.6387 c=0
Rk48 (\6\:VSS \7\:VSS) resistor r=0.463 c=0
Rk50 (\6\:VSS \11\:VSS) resistor r=0.04334 c=0
Rk52 (\12\:VSS VSS) resistor r=0.1325 c=0
Rk51 (\7\:VSS \12\:VSS) resistor r=0.4192 c=0
Rk53 (\7\:VSS \14\:VSS) resistor r=0.3714 c=0
Rk54 (\12\:VSS \16\:VSS) resistor r=0.3281 c=0
Rk10 (\8\:S S) resistor r=0.00755 c=0
Rk9 (\7\:S \8\:S) resistor r=1.2624 c=0
Rk36 (\1\:VDD \5\:VDD) resistor r=0.2256 c=0
Rk37 (\5\:VDD \6\:VDD) resistor r=0.6387 c=0
Rk38 (\6\:VDD \7\:VDD) resistor r=0.4641 c=0
Rk40 (\6\:VDD \11\:VDD) resistor r=0.04334 c=0
Rk41 (\7\:VDD \13\:VDD) resistor r=0.07151 c=0
Rk44 (\14\:VDD VDD) resistor r=0.1702 c=0
Rk42 (\7\:VDD \14\:VDD) resistor r=0.3812 c=0
Rk43 (\14\:VDD \16\:VDD) resistor r=0.2808 c=0
Rk33 (PPN \2\:PPN) resistor r=0.1534 c=0
Rk34 (PPN \4\:PPN) resistor r=0.1444 c=0
Rk30 (X2 \7\:X2) resistor r=0.1414 c=0
Rk8 (A \7\:A) resistor r=0.02572 c=0
Rk3 (\5\:M0b \6\:M0b) resistor r=0.9383 c=0
Rk4 (\6\:M0b \7\:M0b) resistor r=0.2916 c=0
Rk5 (\7\:M0b \9\:M0b) resistor r=0.09782 c=0
Rk6 (\6\:M0b \10\:M0b) resistor r=0.072 c=0
Rk7 (\7\:M0b \12\:M0b) resistor r=0.4752 c=0
Rk17 (\2\:n0 \3\:n0) resistor r=0.02033 c=0
Rk18 (\3\:n0 \4\:n0) resistor r=1.4965 c=0
Rk19 (\4\:n0 \6\:n0) resistor r=0.5347 c=0
Rk20 (\3\:n0 \8\:n0) resistor r=0.4151 c=0
Rk21 (\4\:n0 \10\:n0) resistor r=0.06984 c=0
Rk22 (\2\:n1 \3\:n1) resistor r=0.4252 c=0
Rk23 (\3\:n1 \5\:n1) resistor r=1.0478 c=0
Rk24 (\2\:n1 \7\:n1) resistor r=0.4278 c=0
Rk25 (\3\:n1 \9\:n1) resistor r=1.5837 c=0
Rk13 (\6\:M1b \7\:M1b) resistor r=0.2551 c=0
Rk14 (\7\:M1b \8\:M1b) resistor r=0.4766 c=0
Rk15 (\8\:M1b \9\:M1b) resistor r=0.299 c=0
Rk16 (\7\:M1b \11\:M1b) resistor r=0.2465 c=0
Rk31 (\8\:net293 \10\:net293) resistor r=1.0046 c=0
Rk32 (\10\:net293 \12\:net293) resistor r=0.4278 c=0
Rk26 (\6\:X2b \7\:X2b) resistor r=0.1086 c=0
Rk27 (\7\:X2b \8\:X2b) resistor r=0.2904 c=0
Rk28 (\7\:X2b \9\:X2b) resistor r=0.5037 c=0
Rk29 (\8\:X2b \11\:X2b) resistor r=0.1523 c=0
Rl7 (\5\:M0 \6\:M0) resistor r=84.0659 c=0
Rl6 (\4\:M0 \5\:M0) resistor r=109.181 c=0
Rl1 (\1\:M0 \2\:M0) resistor r=84.6154 c=0
Rl2 (\2\:M0 \3\:M0) resistor r=101.374 c=0
Rl20 (\4\:M1 \5\:M1) resistor r=24.2328 c=0
Rl21 (\5\:M1 \6\:M1) resistor r=76.1559 c=0
Rl15 (\1\:M1 \2\:M1) resistor r=81.9251 c=0
Rl16 (\2\:M1 \3\:M1) resistor r=122.264 c=0
Rl19 (\4\:S \6\:S) resistor r=198.077 c=0
Rl18 (\4\:S \5\:S) resistor r=25.2509 c=0
Rl3 (\1\:S \2\:S) resistor r=26.9231 c=0
Rl4 (\2\:S \3\:S) resistor r=159.066 c=0
Rl24 (\1\:X2 \2\:X2) resistor r=24.848 c=0
Rl27 (\2\:X2 \5\:X2) resistor r=76.2482 c=0
Rl28 (\3\:X2 \6\:X2) resistor r=30.4507 c=0
Rl26 (\3\:X2 \4\:X2) resistor r=153.39 c=0
Rl25 (\2\:X2 \3\:X2) resistor r=179.178 c=0
Rl9 (\1\:A \2\:A) resistor r=96.131 c=0
Rl12 (\2\:A \5\:A) resistor r=80.7464 c=0
Rl13 (\3\:A \6\:A) resistor r=44.2087 c=0
Rl11 (\3\:A \4\:A) resistor r=88.4394 c=0
Rl10 (\2\:A \3\:A) resistor r=72.5535 c=0
Rl8 (\3\:M0b \4\:M0b) resistor r=102.615 c=0
Rl5 (M0b \2\:M0b) resistor r=26.1559 c=0
Rl17 (\3\:M1b \4\:M1b) resistor r=26.1559 c=0
Rl14 (M1b \2\:M1b) resistor r=102.615 c=0
Rl31 (net293 \4\:net293) resistor r=4.8851 c=0
Rl23 (\3\:X2b \4\:X2b) resistor r=120.667 c=0
Rl22 (X2b \2\:X2b) resistor r=76.7653 c=0
Rz14 (\11\:VSS \10\:VSS) resistor r=75 c=0
Rz15 (\14\:VSS \13\:VSS) resistor r=75 c=0
Rz16 (\16\:VSS \15\:VSS) resistor r=75 c=0
Rz10 (\5\:VDD \4\:VDD) resistor r=7.5 c=0
Rz11 (\7\:VDD \4\:VDD) resistor r=6.25 c=0
Rz9 (\2\:PPN \1\:PPN) resistor r=75 c=0
Rz1 (\8\:M0b \9\:M0b) resistor r=75 c=0
Rz3 (\5\:n0 \6\:n0) resistor r=75 c=0
Rz4 (\7\:n0 \8\:n0) resistor r=75 c=0
Rz5 (\6\:n1 \7\:n1) resistor r=75 c=0
Rz6 (\8\:n1 \9\:n1) resistor r=75 c=0
Rz2 (\10\:M1b \11\:M1b) resistor r=75 c=0
Rz8 (\10\:net293 \9\:net293) resistor r=75 c=0
Rz7 (\10\:X2b \11\:X2b) resistor r=75 c=0
Ry15 (\5\:VSS \4\:VSS) resistor r=6.2 c=0
Ry16 (\7\:VSS \4\:VSS) resistor r=5.1667 c=0
Ry12 (\11\:VDD \10\:VDD) resistor r=62 c=0
Ry13 (\13\:VDD \12\:VDD) resistor r=62 c=0
Ry14 (\16\:VDD \15\:VDD) resistor r=62 c=0
Ry9 (\4\:PPN \3\:PPN) resistor r=20.6667 c=0
Ry1 (\11\:M0b \12\:M0b) resistor r=62 c=0
Ry3 (n0 \2\:n0) resistor r=62 c=0
Ry4 (\9\:n0 \10\:n0) resistor r=62 c=0
Ry5 (n1 \2\:n1) resistor r=62 c=0
Ry6 (\4\:n1 \5\:n1) resistor r=62 c=0
Ry2 (\5\:M1b \6\:M1b) resistor r=62 c=0
Ry8 (\12\:net293 \11\:net293) resistor r=62 c=0
Ry7 (\5\:X2b \6\:X2b) resistor r=62 c=0
Rx2 (\2\:M0 M0) resistor r=45 c=0
Rx1 (\5\:M0 \7\:M0) resistor r=45 c=0
Rx8 (\5\:M1 \7\:M1) resistor r=45 c=0
Rx9 (\2\:M1 \8\:M1) resistor r=45 c=0
Rx6 (\5\:S \7\:S) resistor r=45 c=0
Rx7 (\2\:S \8\:S) resistor r=45 c=0
Rx14 (\2\:X2 \7\:X2) resistor r=45 c=0
Rx5 (\2\:A \7\:A) resistor r=45 c=0
Rx3 (\4\:M0b \5\:M0b) resistor r=45 c=0
Rx4 (\2\:M0b \10\:M0b) resistor r=45 c=0
Rx10 (\4\:M1b \8\:M1b) resistor r=45 c=0
Rx11 (\2\:M1b \9\:M1b) resistor r=45 c=0
Rx15 (\8\:net293 \4\:net293) resistor r=45 c=0
Rx12 (\4\:X2b \8\:X2b) resistor r=45 c=0
Rx13 (\2\:X2b \9\:X2b) resistor r=45 c=0
mn0 (\8\:M0b \3\:M0 \15\:VSS VSS) g45n1hvt w=(1.45e-07) l=4.5e-08 nf=1 \
        as=2.32e-14 ad=2.03e-14 ps=6.1e-07 pd=5.7e-07 nrd=1.16667 \
        nrs=1.16667 sa=1.4e-07 sb=1.97931e-06 sd=160n sca=13.6097 \
        scb=0.014254 scc=0.000755054 m=(1)
mn3 (n3 \3\:S \15\:VSS VSS) g45n1hvt w=(1.45e-07) l=4.5e-08 nf=1 \
        as=2.32e-14 ad=8.7e-15 ps=6.1e-07 pd=4.1e-07 nrd=1.16667 \
        nrs=1.16667 sa=3.45e-07 sb=1.88138e-06 sd=160n sca=13.6097 \
        scb=0.014254 scc=0.000755054 m=(1)
mn4 (\5\:n0 M0b n3 VSS) g45n1hvt w=(1.45e-07) l=4.5e-08 nf=1 as=8.7e-15 \
        ad=2.9e-14 ps=4.1e-07 pd=6.9e-07 nrd=1.16667 nrs=1.16667 \
        sa=4.5e-07 sb=1.77638e-06 sd=160n sca=13.6097 scb=0.014254 \
        scc=0.000755054 m=(1)
mn6 (\5\:n0 \4\:M0 n5 VSS) g45n1hvt w=(1.45e-07) l=4.5e-08 nf=1 \
        as=3.335e-14 ad=2.9e-14 ps=7.5e-07 pd=6.9e-07 nrd=1.16667 \
        nrs=1.16667 sa=6.95e-07 sb=1.53138e-06 sd=160n sca=13.6097 \
        scb=0.014254 scc=0.000755054 m=(1)
mn5 (n5 \4\:A \13\:VSS VSS) g45n1hvt w=(1.45e-07) l=4.5e-08 nf=1 \
        as=2.32e-14 ad=3.335e-14 ps=6.1e-07 pd=7.5e-07 nrd=1.16667 \
        nrs=1.16667 sa=9.7e-07 sb=1.25638e-06 sd=160n sca=13.6097 \
        scb=0.014254 scc=0.000755054 m=(1)
mn9 (n9 \6\:A \13\:VSS VSS) g45n1hvt w=(1.45e-07) l=4.5e-08 nf=1 \
        as=2.32e-14 ad=4.93e-14 ps=6.1e-07 pd=9.7e-07 nrd=1.16667 \
        nrs=1.16667 sa=1.175e-06 sb=1.05138e-06 sd=160n sca=13.6097 \
        scb=0.014254 scc=0.000755054 m=(1)
mn10 (\8\:n1 \3\:M1 n9 VSS) g45n1hvt w=(1.45e-07) l=4.5e-08 nf=1 \
        as=4.93e-14 ad=2.32e-14 ps=9.7e-07 pd=6.1e-07 nrd=1.16667 \
        nrs=1.16667 sa=1.56e-06 sb=6.66379e-07 sd=160n sca=13.6097 \
        scb=0.014254 scc=0.000755054 m=(1)
mn8 (\8\:n1 \3\:M1b n7 VSS) g45n1hvt w=(1.45e-07) l=4.5e-08 nf=1 \
        as=8.7e-15 ad=2.32e-14 ps=4.1e-07 pd=6.1e-07 nrd=1.16667 \
        nrs=1.16667 sa=1.765e-06 sb=4.61379e-07 sd=160n sca=13.6097 \
        scb=0.014254 scc=0.000755054 m=(1)
mn7 (n7 \6\:S \10\:VSS VSS) g45n1hvt w=(1.45e-07) l=4.5e-08 nf=1 \
        as=7.6e-14 ad=8.7e-15 ps=1.5e-06 pd=4.1e-07 nrd=1.16667 \
        nrs=1.16667 sa=1.87e-06 sb=3.56379e-07 sd=160n sca=13.6097 \
        scb=0.014254 scc=0.000755054 m=(1)
mn1 (\10\:M1b \6\:M1 \10\:VSS VSS) g45n1hvt w=(1.45e-07) l=4.5e-08 nf=1 \
        as=7.6e-14 ad=2.03e-14 ps=1.5e-06 pd=5.7e-07 nrd=1.16667 \
        nrs=1.16667 sa=1.6069e-06 sb=1.4e-07 sd=160n sca=16.2011 \
        scb=0.0172667 scc=0.0012292 m=(1)
mn11 (\9\:net293 \4\:X2 \7\:n0 VSS) g45n1hvt w=(1.45e-07) l=4.5e-08 nf=1 \
        as=3.697e-14 ad=2.32e-14 ps=8e-07 pd=6.1e-07 nrd=1.16667 \
        nrs=1.16667 sa=2.55e-07 sb=3.45e-07 sd=160n sca=23.279 \
        scb=0.0230742 scc=0.00267719 m=(1)
mn12 (\6\:n1 \3\:X2b \9\:net293 VSS) g45n1hvt w=(1.45e-07) l=4.5e-08 nf=1 \
        as=2.32e-14 ad=2.03e-14 ps=6.1e-07 pd=5.7e-07 nrd=1.16667 \
        nrs=1.16667 sa=4.6e-07 sb=1.4e-07 sd=160n sca=23.279 scb=0.0230742 \
        scc=0.00267719 m=(1)
mn2 (\10\:X2b \5\:X2 \1\:VSS VSS) g45n1hvt w=(1.45e-07) l=4.5e-08 nf=1 \
        as=9.71e-14 ad=3.045e-14 ps=1.7e-06 pd=7.1e-07 nrd=1.16667 \
        nrs=1.16667 sa=2.1e-07 sb=6.6e-07 sd=160n sca=23.279 scb=0.0230742 \
        scc=0.00267719 m=(1)
mn13_1__rcx (\1\:PPN net293 \1\:VSS VSS) g45n1hvt w=(2.6e-07) l=4.5e-08 \
        nf=1 as=6.675e-14 ad=4.16e-14 ps=1.25e-06 pd=8.4e-07 nrd=1.16667 \
        nrs=1.16667 sa=3.67981e-07 sb=3.45e-07 sd=160n sca=17.5885 \
        scb=0.0172826 scc=0.00162584 m=(2)
mp13 (\3\:PPN net293 \1\:VDD VDD) g45p1hvt w=(3.9e-07) l=4.5e-08 nf=1 \
        as=5.701e-14 ad=6.24e-14 ps=1.115e-06 pd=1.1e-06 nrd=1.16667 \
        nrs=1.16667 sa=2.54359e-07 sb=3.45e-07 sd=160n sca=34.0333 \
        scb=0.0243751 scc=0.00339915 m=(2)
ends BMXIX2
// End of subcircuit definition.
