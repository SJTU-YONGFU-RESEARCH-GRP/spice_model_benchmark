// Generated for: spectre (May  1 09:18:41 2013 )
// Library name: gsclib045_hvt
// Cell name: OA22XL
// View name: extracted

simulator lang=spectre

subckt OA22XL A0 A1 B0 B1 VDD VSS Y
mp0 (net119 \1\:A0 \6\:VDD VDD) g45p1hvt w=(2.15e-07) l=4.5e-08 nf=1 \
        as=3.01e-14 ad=3.225e-14 ps=7.1e-07 pd=7.3e-07 nrd=1.16667 \
        nrs=1.16667 sa=1.4e-07 sb=1.035e-06 sd=160n sca=15.0366 \
        scb=0.0139559 scc=0.00019117 m=(1)
mp1 (\6\:net128 \1\:A1 net119 VDD) g45p1hvt w=(2.15e-07) l=4.5e-08 nf=1 \
        as=3.225e-14 ad=4.192e-14 ps=7.3e-07 pd=8.2e-07 nrd=1.16667 \
        nrs=1.16667 sa=3.35e-07 sb=8.4e-07 sd=160n sca=12.0447 \
        scb=0.00904147 scc=0.000101203 m=(1)
mp3 (\6\:net128 \1\:B1 net115 VDD) g45p1hvt w=(2.15e-07) l=4.5e-08 nf=1 \
        as=4.515e-14 ad=4.192e-14 ps=8.5e-07 pd=8.2e-07 nrd=1.16667 \
        nrs=1.16667 sa=5.75e-07 sb=6e-07 sd=160n sca=10.7796 \
        scb=0.00791215 scc=9.84845e-05 m=(1)
mp2 (net115 \3\:B0 \1\:VDD VDD) g45p1hvt w=(2.15e-07) l=4.5e-08 nf=1 \
        as=3.44e-14 ad=4.515e-14 ps=7.5e-07 pd=8.5e-07 nrd=1.16667 \
        nrs=1.16667 sa=8.3e-07 sb=3.45e-07 sd=160n sca=10.9535 \
        scb=0.00800214 scc=9.85336e-05 m=(1)
mp4 (\3\:Y \3\:net128 \1\:VDD VDD) g45p1hvt w=(2.15e-07) l=4.5e-08 nf=1 \
        as=3.44e-14 ad=3.01e-14 ps=7.5e-07 pd=7.1e-07 nrd=1.16667 \
        nrs=1.16667 sa=1.035e-06 sb=1.4e-07 sd=160n sca=12.1773 \
        scb=0.00921403 scc=0.000102074 m=(1)
C1 (A1 VSS) capacitor c=1.11455e-16
C2 (VDD VSS) capacitor c=1.4553e-16
C3 (A0 VSS) capacitor c=3.11497e-17
C4 (Y VSS) capacitor c=6.80447e-17
C5 (B1 VSS) capacitor c=7.82952e-17
C6 (net124 VSS) capacitor c=8.18515e-17
C7 (net128 VSS) capacitor c=3.33906e-17
C8 (net115 VSS) capacitor c=3.22087e-18
C9 (\3\:net128 VSS) capacitor c=6.16443e-17
C10 (\3\:B0 VSS) capacitor c=5.06841e-17
C11 (\1\:B1 VSS) capacitor c=5.41512e-17
C12 (\1\:A1 VSS) capacitor c=6.67281e-17
C13 (\1\:A0 VSS) capacitor c=5.22555e-17
C14 (\1\:B0 VSS) capacitor c=4.54995e-17
C15 (\3\:B1 VSS) capacitor c=3.43576e-17
C16 (\3\:A1 VSS) capacitor c=3.73546e-17
C17 (\4\:A0 VSS) capacitor c=4.2681e-17
C18 (\2\:net128 VSS) capacitor c=5.86386e-17
C19 (\2\:B0 VSS) capacitor c=6.40225e-17
C20 (\2\:B1 VSS) capacitor c=4.98134e-17
C21 (\2\:A1 VSS) capacitor c=5.99456e-17
C22 (\3\:A0 VSS) capacitor c=4.64772e-17
C23 (\3\:Y VSS) capacitor c=3.12523e-17
C24 (\1\:VDD VSS) capacitor c=3.58986e-17
C25 (\6\:net128 VSS) capacitor c=9.61691e-17
C26 (\6\:VDD VSS) capacitor c=1.26104e-17
C27 (\1\:Y VSS) capacitor c=5.01181e-17
C28 (\8\:net128 VSS) capacitor c=2.90712e-17
C29 (\3\:net124 VSS) capacitor c=9.23196e-17
C30 (\5\:net124 VSS) capacitor c=3.23136e-17
C31 (\5\:A0 VSS) capacitor c=5.97127e-17
C32 (\4\:B1 VSS) capacitor c=4.81527e-17
C33 (\4\:B0 VSS) capacitor c=1.04681e-16
C34 (\4\:net128 VSS) capacitor c=3.372e-17
C35 (\5\:net128 VSS) capacitor c=1.07711e-16
C36 (\4\:VDD VSS) capacitor c=5.96587e-17
C37 (\5\:VDD VSS) capacitor c=1.44508e-17
Rk2 (A1 \4\:A1) resistor r=0.003947 c=0
Rk16 (\2\:VDD \4\:VDD) resistor r=0.306 c=0
Rk18 (\5\:VDD VDD) resistor r=0.07937 c=0
Rk17 (\4\:VDD \5\:VDD) resistor r=0.319 c=0
Rk19 (\5\:VDD \7\:VDD) resistor r=0.1713 c=0
Rk4 (\4\:B0 B0) resistor r=0.002981 c=0
Rk1 (A0 \5\:A0) resistor r=0.06559 c=0
Rk10 (\2\:Y Y) resistor r=0.6708 c=0
Rk11 (Y \4\:Y) resistor r=0.07319 c=0
Rk12 (\2\:VSS \4\:VSS) resistor r=0.3183 c=0
Rk14 (\5\:VSS VSS) resistor r=0.1966 c=0
Rk13 (\4\:VSS \5\:VSS) resistor r=0.2018 c=0
Rk15 (\5\:VSS \7\:VSS) resistor r=0.07265 c=0
Rk3 (\4\:B1 B1) resistor r=0.1925 c=0
Rk5 (\2\:net124 \4\:net124) resistor r=0.6714 c=0
Rk6 (\4\:net124 \6\:net124) resistor r=0.275 c=0
Rk7 (\4\:net128 \5\:net128) resistor r=0.2348 c=0
Rk8 (\5\:net128 \7\:net128) resistor r=0.633 c=0
Rk9 (\5\:net128 \9\:net128) resistor r=0.1357 c=0
Rl4 (\1\:A1 \2\:A1) resistor r=219.923 c=0
Rl5 (\2\:A1 \3\:A1) resistor r=39.1533 c=0
Rl9 (\2\:B0 \3\:B0) resistor r=147.528 c=0
Rl8 (\1\:B0 \2\:B0) resistor r=113.462 c=0
Rl1 (\1\:A0 \2\:A0) resistor r=184.329 c=0
Rl3 (\2\:A0 \4\:A0) resistor r=92.0218 c=0
Rl2 (\2\:A0 \3\:A0) resistor r=0.5166 c=0
Rl6 (\1\:B1 \2\:B1) resistor r=193 c=0
Rl7 (\2\:B1 \3\:B1) resistor r=66.0764 c=0
Rl11 (\2\:net128 \3\:net128) resistor r=230.002 c=0
Rl10 (net128 \2\:net128) resistor r=104.386 c=0
Rz5 (\1\:Y \2\:Y) resistor r=75 c=0
Rz6 (\1\:VSS \2\:VSS) resistor r=75 c=0
Rz7 (\6\:VSS \7\:VSS) resistor r=75 c=0
Rz1 (net124 \2\:net124) resistor r=75 c=0
Rz2 (\3\:net124 \4\:net124) resistor r=75 c=0
Rz3 (\5\:net124 \6\:net124) resistor r=75 c=0
Rz4 (\8\:net128 \9\:net128) resistor r=75 c=0
Ry4 (\1\:VDD \2\:VDD) resistor r=62 c=0
Ry5 (\6\:VDD \7\:VDD) resistor r=62 c=0
Ry2 (\3\:Y \4\:Y) resistor r=62 c=0
Ry1 (\6\:net128 \7\:net128) resistor r=62 c=0
Rx2 (\2\:A1 \4\:A1) resistor r=45 c=0
Rx4 (\2\:B0 \4\:B0) resistor r=45 c=0
Rx1 (\3\:A0 \5\:A0) resistor r=45 c=0
Rx3 (\2\:B1 \4\:B1) resistor r=45 c=0
Rx5 (\2\:net128 \4\:net128) resistor r=45 c=0
mn0 (\5\:net124 \4\:A0 \6\:VSS VSS) g45n1hvt w=(1.45e-07) l=4.5e-08 nf=1 \
        as=4.515e-14 ad=2.03e-14 ps=1.33e-06 pd=5.7e-07 nrd=1.16667 \
        nrs=1.16667 sa=1.4e-07 sb=9.05e-07 sd=160n sca=10.4914 \
        scb=0.00978575 scc=0.000300434 m=(1)
mn1 (\3\:net124 \3\:A1 \6\:VSS VSS) g45n1hvt w=(1.45e-07) l=4.5e-08 nf=1 \
        as=4.515e-14 ad=2.828e-14 ps=1.33e-06 pd=6.8e-07 nrd=1.16667 \
        nrs=1.16667 sa=3.35e-07 sb=7.1e-07 sd=160n sca=10.4914 \
        scb=0.00978575 scc=0.000300434 m=(1)
mn3 (\8\:net128 \3\:B1 \3\:net124 VSS) g45n1hvt w=(1.45e-07) l=4.5e-08 \
        nf=1 as=2.827e-14 ad=4.132e-14 ps=6.8e-07 pd=8.6e-07 nrd=1.16667 \
        nrs=1.16667 sa=5.75e-07 sb=4.7e-07 sd=160n sca=10.4914 \
        scb=0.00978575 scc=0.000300434 m=(1)
mn2 (\8\:net128 \1\:B0 net124 VSS) g45n1hvt w=(1.45e-07) l=4.5e-08 nf=1 \
        as=2.03e-14 ad=4.132e-14 ps=5.7e-07 pd=8.6e-07 nrd=1.16667 \
        nrs=1.16667 sa=9.05e-07 sb=1.4e-07 sd=160n sca=10.4914 \
        scb=0.00978575 scc=0.000300434 m=(1)
mn4 (\1\:Y net128 \1\:VSS VSS) g45n1hvt w=(1.45e-07) l=4.5e-08 nf=1 \
        as=3.89e-14 ad=2.03e-14 ps=1.27e-06 pd=5.7e-07 nrd=1.16667 \
        nrs=1.16667 sa=1e-07 sb=1.4e-07 sd=160n sca=11.4452 scb=0.0112553 \
        scc=0.00042156 m=(1)
ends OA22XL
// End of subcircuit definition.
