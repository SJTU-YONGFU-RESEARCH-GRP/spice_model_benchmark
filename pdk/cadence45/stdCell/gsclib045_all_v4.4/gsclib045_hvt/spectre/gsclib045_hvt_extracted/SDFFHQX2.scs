// Generated for: spectre (May  1 09:15:24 2013 )
// Library name: gsclib045_hvt
// Cell name: SDFFHQX2
// View name: extracted

simulator lang=spectre

subckt SDFFHQX2 CK D Q SE SI VDD VSS
mp11 (net342 \1\:D \14\:VDD VDD) g45p1hvt w=(3.9e-07) l=4.5e-08 nf=1 \
        as=6.535e-14 ad=5.655e-14 ps=1.16e-06 pd=1.07e-06 nrd=1.16667 \
        nrs=1.16667 sa=2.69551e-07 sb=9.85833e-07 sd=160n sca=15.8351 \
        scb=0.0142471 scc=0.00110276 m=(1)
mp12 (\6\:Db \1\:SE net342 VDD) g45p1hvt w=(3.9e-07) l=4.5e-08 nf=1 \
        as=5.655e-14 ad=7.02e-14 ps=1.07e-06 pd=1.14e-06 nrd=1.16667 \
        nrs=1.16667 sa=4.59551e-07 sb=7.95833e-07 sd=160n sca=15.8351 \
        scb=0.0142471 scc=0.00110276 m=(1)
mp14 (\6\:Db SEb net350 VDD) g45p1hvt w=(3.9e-07) l=4.5e-08 nf=1 \
        as=5.265e-14 ad=7.02e-14 ps=1.05e-06 pd=1.14e-06 nrd=1.16667 \
        nrs=1.16667 sa=6.84551e-07 sb=5.70833e-07 sd=160n sca=15.8351 \
        scb=0.0142471 scc=0.00110276 m=(1)
mp13 (net350 \3\:SI \12\:VDD VDD) g45p1hvt w=(3.9e-07) l=4.5e-08 nf=1 \
        as=1.1265e-13 ad=5.265e-14 ps=1.6e-06 pd=1.05e-06 nrd=1.16667 \
        nrs=1.16667 sa=8.64551e-07 sb=3.90833e-07 sd=160n sca=16.239 \
        scb=0.0143727 scc=0.00110279 m=(1)
mp55 (\1\:Q qbint VDD VDD) g45p1hvt w=(3.9e-07) l=4.5e-08 nf=1 \
        as=5.325e-14 ad=6.24e-14 ps=1.08e-06 pd=1.1e-06 nrd=1.16667 \
        nrs=1.16667 sa=1.4e-07 sb=4.40064e-07 sd=160n sca=30.9465 \
        scb=0.0329575 scc=0.002778 m=(2)
C1 (D VSS) capacitor c=5.86585e-17
C2 (Q VSS) capacitor c=3.45083e-17
C3 (VDD VSS) capacitor c=3.42065e-16
C4 (CK VSS) capacitor c=5.83872e-17
C5 (SI VSS) capacitor c=1.10775e-16
C6 (qbint VSS) capacitor c=1.42921e-16
C7 (CKb VSS) capacitor c=1.68871e-17
C8 (n30 VSS) capacitor c=3.72615e-17
C9 (mout VSS) capacitor c=6.00805e-17
C10 (CKbb VSS) capacitor c=3.53933e-17
C11 (n20 VSS) capacitor c=3.96373e-17
C12 (net378 VSS) capacitor c=1.65965e-18
C13 (Db VSS) capacitor c=1.07303e-16
C14 (net399 VSS) capacitor c=1.17545e-17
C15 (SEb VSS) capacitor c=4.5651e-17
C16 (net411 VSS) capacitor c=1.47994e-18
C17 (net334 VSS) capacitor c=9.04161e-18
C18 (net319 VSS) capacitor c=6.19945e-18
C19 (net342 VSS) capacitor c=5.59536e-18
C20 (net350 VSS) capacitor c=3.91527e-18
C21 (\7\:SE VSS) capacitor c=3.10912e-17
C22 (\3\:SI VSS) capacitor c=5.11695e-17
C23 (\1\:SE VSS) capacitor c=4.97908e-17
C24 (\1\:D VSS) capacitor c=6.54026e-17
C25 (\10\:CKb VSS) capacitor c=5.3274e-17
C26 (\7\:CKbb VSS) capacitor c=3.94237e-17
C27 (\8\:CKb VSS) capacitor c=4.39846e-17
C28 (\4\:CKb VSS) capacitor c=2.1519e-17
C29 (\8\:qbint VSS) capacitor c=4.78273e-17
C30 (\3\:n30 VSS) capacitor c=4.30002e-17
C31 (\3\:CK VSS) capacitor c=3.95459e-17
C32 (\5\:SE VSS) capacitor c=2.96943e-17
C33 (\1\:SI VSS) capacitor c=7.46974e-17
C34 (\3\:SE VSS) capacitor c=6.63223e-17
C35 (\3\:SEb VSS) capacitor c=5.95274e-17
C36 (\4\:D VSS) capacitor c=4.3845e-17
C37 (\5\:CKb VSS) capacitor c=3.20886e-17
C38 (\11\:CKb VSS) capacitor c=2.44232e-17
C39 (\5\:CKbb VSS) capacitor c=5.21993e-17
C40 (\4\:mout VSS) capacitor c=5.50107e-17
C41 (\3\:n20 VSS) capacitor c=4.36534e-17
C42 (\3\:CKbb VSS) capacitor c=3.00472e-17
C43 (\3\:CKb VSS) capacitor c=6.77966e-17
C44 (\11\:qbint VSS) capacitor c=3.57889e-17
C45 (\1\:CK VSS) capacitor c=4.22686e-17
C46 (\6\:SE VSS) capacitor c=2.65133e-17
C47 (\2\:SI VSS) capacitor c=5.05078e-17
C48 (\4\:SE VSS) capacitor c=4.74044e-17
C49 (\2\:SEb VSS) capacitor c=6.68526e-17
C50 (\2\:SE VSS) capacitor c=3.84466e-17
C51 (\3\:D VSS) capacitor c=2.76836e-17
C52 (\8\:CKbb VSS) capacitor c=3.96293e-17
C53 (\9\:CKb VSS) capacitor c=2.41808e-17
C54 (\6\:CKbb VSS) capacitor c=4.74902e-17
C55 (\3\:mout VSS) capacitor c=1.84103e-17
C56 (\2\:n20 VSS) capacitor c=3.54151e-17
C57 (\4\:CKbb VSS) capacitor c=3.88909e-17
C58 (\2\:CKbb VSS) capacitor c=4.35208e-17
C59 (\10\:qbint VSS) capacitor c=2.49612e-17
C60 (\2\:n30 VSS) capacitor c=4.31174e-17
C61 (\2\:CK VSS) capacitor c=3.65523e-17
C62 (\6\:qbint VSS) capacitor c=2.596e-17
C63 (\5\:SEb VSS) capacitor c=1.06163e-16
C64 (\12\:VDD VSS) capacitor c=3.83257e-17
C65 (\6\:Db VSS) capacitor c=6.55996e-17
C66 (\14\:VDD VSS) capacitor c=5.47512e-17
C67 (\9\:CKbb VSS) capacitor c=7.45193e-17
C68 (\4\:Db VSS) capacitor c=9.126e-17
C69 (\4\:n20 VSS) capacitor c=6.12637e-17
C70 (\16\:VDD VSS) capacitor c=3.5225e-17
C71 (\9\:mout VSS) capacitor c=6.27091e-17
C72 (\6\:n30 VSS) capacitor c=5.93577e-17
C73 (\18\:VDD VSS) capacitor c=2.86758e-17
C74 (\14\:qbint VSS) capacitor c=7.53905e-17
C75 (\15\:CKb VSS) capacitor c=3.65219e-17
C76 (\1\:Q VSS) capacitor c=8.10944e-17
C77 (\1\:VDD VSS) capacitor c=5.8476e-17
C78 (\7\:SEb VSS) capacitor c=6.85301e-17
C79 (\15\:CKbb VSS) capacitor c=5.92557e-17
C80 (\8\:Db VSS) capacitor c=7.20809e-17
C81 (\8\:n20 VSS) capacitor c=6.67022e-17
C82 (\7\:mout VSS) capacitor c=5.95759e-17
C83 (\8\:n30 VSS) capacitor c=8.96019e-17
C84 (\16\:qbint VSS) capacitor c=7.57164e-17
C85 (\18\:CKb VSS) capacitor c=8.95627e-17
C86 (\3\:Q VSS) capacitor c=1.51928e-17
C87 (\9\:qbint VSS) capacitor c=2.44775e-17
C88 (\2\:CKb VSS) capacitor c=4.32357e-17
C89 (\2\:mout VSS) capacitor c=3.34305e-17
C90 (\6\:CKb VSS) capacitor c=7.6933e-17
C91 (\7\:CKb VSS) capacitor c=7.02433e-17
C92 (\2\:D VSS) capacitor c=2.48941e-17
C93 (\4\:CK VSS) capacitor c=7.23277e-17
C94 (\12\:qbint VSS) capacitor c=6.72714e-17
C95 (\13\:qbint VSS) capacitor c=6.08996e-17
C96 (\18\:qbint VSS) capacitor c=9.49802e-17
C97 (\4\:n30 VSS) capacitor c=7.30267e-17
C98 (\5\:n30 VSS) capacitor c=9.11922e-17
C99 (\5\:mout VSS) capacitor c=5.12745e-17
C100 (\6\:mout VSS) capacitor c=4.82322e-17
C101 (\12\:CKb VSS) capacitor c=5.42788e-17
C102 (\13\:CKb VSS) capacitor c=1.43598e-16
C103 (\14\:CKb VSS) capacitor c=1.4286e-16
C104 (\17\:CKb VSS) capacitor c=8.12018e-17
C105 (\6\:n20 VSS) capacitor c=7.25667e-17
C106 (\7\:n20 VSS) capacitor c=6.22133e-17
C107 (\11\:CKbb VSS) capacitor c=1.29025e-16
C108 (\12\:CKbb VSS) capacitor c=7.63497e-17
C109 (\13\:CKbb VSS) capacitor c=1.28425e-16
C110 (\14\:CKbb VSS) capacitor c=1.33018e-16
C111 (\17\:CKbb VSS) capacitor c=4.68267e-17
C112 (\18\:CKbb VSS) capacitor c=6.0968e-17
C113 (\5\:D VSS) capacitor c=5.41637e-17
C114 (\3\:Db VSS) capacitor c=1.48383e-16
C115 (\8\:SE VSS) capacitor c=1.4458e-17
C116 (\9\:SE VSS) capacitor c=1.21238e-16
C117 (\10\:SE VSS) capacitor c=5.649e-17
C118 (\11\:SE VSS) capacitor c=9.79259e-17
C119 (\4\:SEb VSS) capacitor c=9.18656e-17
C120 (\3\:VDD VSS) capacitor c=1.56441e-17
C121 (\4\:VDD VSS) capacitor c=1.66881e-17
C122 (\6\:VDD VSS) capacitor c=3.79881e-17
C123 (\7\:VDD VSS) capacitor c=2.10421e-17
Rk29 (\5\:D D) resistor r=0.1122 c=0
Rk1 (\2\:Q Q) resistor r=0.2051 c=0
Rk2 (Q \4\:Q) resistor r=0.166 c=0
Rk41 (\2\:VSS \3\:VSS) resistor r=0.1677 c=0
Rk42 (\3\:VSS \4\:VSS) resistor r=0.4307 c=0
Rk43 (\4\:VSS \5\:VSS) resistor r=0.1527 c=0
Rk44 (\5\:VSS \6\:VSS) resistor r=0.4485 c=0
Rk45 (\6\:VSS \7\:VSS) resistor r=0.6563 c=0
Rk47 (\8\:VSS VSS) resistor r=0.3332 c=0
Rk46 (\7\:VSS \8\:VSS) resistor r=0.09756 c=0
Rk50 (\3\:VSS \13\:VSS) resistor r=0.2067 c=0
Rk51 (\4\:VSS \15\:VSS) resistor r=0.2111 c=0
Rk52 (\6\:VSS \17\:VSS) resistor r=0.1222 c=0
Rk53 (\7\:VSS \19\:VSS) resistor r=0.237 c=0
Rk55 (\2\:VDD \3\:VDD) resistor r=0.1978 c=0
Rk56 (\3\:VDD \4\:VDD) resistor r=0.4007 c=0
Rk57 (\4\:VDD \5\:VDD) resistor r=0.1527 c=0
Rk58 (\5\:VDD \6\:VDD) resistor r=0.4786 c=0
Rk59 (\6\:VDD \7\:VDD) resistor r=0.6388 c=0
Rk61 (\8\:VDD VDD) resistor r=0.3332 c=0
Rk60 (\7\:VDD \8\:VDD) resistor r=0.08503 c=0
Rk64 (\3\:VDD \13\:VDD) resistor r=0.2466 c=0
Rk65 (\4\:VDD \15\:VDD) resistor r=0.3102 c=0
Rk66 (\6\:VDD \17\:VDD) resistor r=0.242 c=0
Rk67 (\7\:VDD \19\:VDD) resistor r=0.2266 c=0
Rk3 (\4\:CK CK) resistor r=0.1297 c=0
Rk35 (\8\:SE \9\:SE) resistor r=0.04037 c=0
Rk36 (\9\:SE \10\:SE) resistor r=0.4299 c=0
Rk38 (\11\:SE SE) resistor r=0.004282 c=0
Rk37 (\9\:SE \11\:SE) resistor r=0.6809 c=0
Rk34 (\4\:SI SI) resistor r=0.003482 c=0
Rk4 (\12\:qbint \13\:qbint) resistor r=0.3074 c=0
Rk5 (\13\:qbint \15\:qbint) resistor r=0.3138 c=0
Rk6 (\13\:qbint \17\:qbint) resistor r=0.05799 c=0
Rk7 (\17\:qbint \18\:qbint) resistor r=0.7082 c=0
Rk14 (\12\:CKb \13\:CKb) resistor r=0.2506 c=0
Rk15 (\13\:CKb \14\:CKb) resistor r=0.9254 c=0
Rk16 (\14\:CKb \16\:CKb) resistor r=0.1459 c=0
Rk17 (\13\:CKb \17\:CKb) resistor r=0.6495 c=0
Rk18 (\14\:CKb \19\:CKb) resistor r=0.4111 c=0
Rk8 (\4\:n30 \5\:n30) resistor r=0.3724 c=0
Rk9 (\5\:n30 \7\:n30) resistor r=0.1741 c=0
Rk10 (\5\:n30 \9\:n30) resistor r=0.5381 c=0
Rk11 (\5\:mout \6\:mout) resistor r=0.241 c=0
Rk12 (\6\:mout \8\:mout) resistor r=0.1153 c=0
Rk13 (\6\:mout \10\:mout) resistor r=0.2348 c=0
Rk22 (\10\:CKbb \11\:CKbb) resistor r=0.5667 c=0
Rk23 (\11\:CKbb \12\:CKbb) resistor r=0.3076 c=0
Rk24 (\12\:CKbb \13\:CKbb) resistor r=0.3291 c=0
Rk25 (\13\:CKbb \14\:CKbb) resistor r=0.858 c=0
Rk26 (\12\:CKbb \16\:CKbb) resistor r=0.2753 c=0
Rk27 (\13\:CKbb \17\:CKbb) resistor r=0.1843 c=0
Rk28 (\14\:CKbb \18\:CKbb) resistor r=0.2539 c=0
Rk19 (\5\:n20 \6\:n20) resistor r=0.1934 c=0
Rk20 (\6\:n20 \7\:n20) resistor r=0.3963 c=0
Rk21 (\6\:n20 \9\:n20) resistor r=0.2531 c=0
Rk30 (\2\:Db \3\:Db) resistor r=0.6822 c=0
Rk31 (\3\:Db \5\:Db) resistor r=0.3925 c=0
Rk32 (\3\:Db \7\:Db) resistor r=0.3379 c=0
Rk33 (\5\:Db \9\:Db) resistor r=0.3871 c=0
Rk39 (\4\:SEb \6\:SEb) resistor r=0.649 c=0
Rk40 (\6\:SEb \8\:SEb) resistor r=0.5281 c=0
Rl32 (\1\:D \2\:D) resistor r=101.637 c=0
Rl34 (\2\:D \4\:D) resistor r=59.3295 c=0
Rl33 (\2\:D \3\:D) resistor r=8.3038 c=0
Rl8 (\2\:CK \3\:CK) resistor r=52.6149 c=0
Rl7 (\1\:CK \2\:CK) resistor r=96.1338 c=0
Rl42 (\6\:SE \7\:SE) resistor r=39.5604 c=0
Rl41 (\5\:SE \6\:SE) resistor r=105.769 c=0
Rl38 (\3\:SE \4\:SE) resistor r=29.4849 c=0
Rl35 (\1\:SE \2\:SE) resistor r=48.7687 c=0
Rl40 (\2\:SI \3\:SI) resistor r=48.0541 c=0
Rl39 (\1\:SI \2\:SI) resistor r=99.7951 c=0
Rl5 (qbint \6\:qbint) resistor r=9.5287 c=0
Rl11 (\9\:qbint \8\:qbint) resistor r=49.7141 c=0
Rl13 (\9\:qbint \11\:qbint) resistor r=84.3295 c=0
Rl12 (\9\:qbint \10\:qbint) resistor r=2.7666 c=0
Rl29 (\8\:CKb \9\:CKb) resistor r=24.2328 c=0
Rl18 (\2\:CKb \4\:CKb) resistor r=30.4507 c=0
Rl17 (\2\:CKb \3\:CKb) resistor r=178.39 c=0
Rl16 (CKb \2\:CKb) resistor r=37.675 c=0
Rl30 (\6\:CKb \10\:CKb) resistor r=199.259 c=0
Rl26 (\5\:CKb \6\:CKb) resistor r=76.0085 c=0
Rl28 (\7\:CKb \8\:CKb) resistor r=143.774 c=0
Rl31 (\7\:CKb \11\:CKb) resistor r=30.4507 c=0
Rl27 (\6\:CKb \7\:CKb) resistor r=198.915 c=0
Rl10 (\2\:n30 \3\:n30) resistor r=33.7912 c=0
Rl9 (n30 \2\:n30) resistor r=84.6154 c=0
Rl21 (mout \2\:mout) resistor r=99.7141 c=0
Rl23 (\2\:mout \4\:mout) resistor r=34.3295 c=0
Rl22 (\2\:mout \3\:mout) resistor r=2.7666 c=0
Rl25 (\7\:CKbb \8\:CKbb) resistor r=39.6174 c=0
Rl24 (\5\:CKbb \6\:CKbb) resistor r=24.2328 c=0
Rl15 (\3\:CKbb \4\:CKbb) resistor r=33.8482 c=0
Rl14 (CKbb \2\:CKbb) resistor r=37.6944 c=0
Rl19 (n20 \2\:n20) resistor r=29.5379 c=0
Rl20 (\2\:n20 \3\:n20) resistor r=87.2302 c=0
Rl36 (SEb \2\:SEb) resistor r=24.2328 c=0
Rl37 (\2\:SEb \3\:SEb) resistor r=131.73 c=0
Rz1 (\4\:Q \3\:Q) resistor r=75 c=0
Rz12 (\13\:VSS \12\:VSS) resistor r=75 c=0
Rz13 (\15\:VSS \14\:VSS) resistor r=75 c=0
Rz14 (\17\:VSS \16\:VSS) resistor r=75 c=0
Rz15 (\19\:VSS \18\:VSS) resistor r=75 c=0
Rz17 (\2\:VDD \1\:VDD) resistor r=25 c=0
Rz18 (\5\:VDD \1\:VDD) resistor r=6.25 c=0
Rz19 (\8\:VDD \1\:VDD) resistor r=6.25 c=0
Rz2 (\17\:qbint \16\:qbint) resistor r=75 c=0
Rz5 (\18\:CKb \19\:CKb) resistor r=75 c=0
Rz3 (\8\:n30 \9\:n30) resistor r=75 c=0
Rz4 (\7\:mout \8\:mout) resistor r=75 c=0
Rz7 (\15\:CKbb \16\:CKbb) resistor r=75 c=0
Rz6 (\8\:n20 \9\:n20) resistor r=75 c=0
Rz8 (Db \2\:Db) resistor r=75 c=0
Rz9 (\8\:Db \9\:Db) resistor r=75 c=0
Rz10 (\7\:SEb \8\:SEb) resistor r=75 c=0
Ry1 (\2\:Q \1\:Q) resistor r=20.6667 c=0
Ry11 (\2\:VSS \1\:VSS) resistor r=20.6667 c=0
Ry12 (\5\:VSS \1\:VSS) resistor r=5.1667 c=0
Ry13 (\8\:VSS \1\:VSS) resistor r=5.1667 c=0
Ry15 (\13\:VDD \12\:VDD) resistor r=62 c=0
Ry16 (\15\:VDD \14\:VDD) resistor r=31 c=0
Ry17 (\17\:VDD \16\:VDD) resistor r=62 c=0
Ry18 (\19\:VDD \18\:VDD) resistor r=62 c=0
Ry2 (\15\:qbint \14\:qbint) resistor r=62 c=0
Ry5 (\15\:CKb \16\:CKb) resistor r=62 c=0
Ry3 (\6\:n30 \7\:n30) resistor r=62 c=0
Ry4 (\9\:mout \10\:mout) resistor r=62 c=0
Ry7 (\9\:CKbb \10\:CKbb) resistor r=62 c=0
Ry6 (\4\:n20 \5\:n20) resistor r=31 c=0
Ry8 (\4\:Db \5\:Db) resistor r=62 c=0
Ry9 (\6\:Db \7\:Db) resistor r=20.6667 c=0
Ry10 (\5\:SEb \6\:SEb) resistor r=62 c=0
Rx13 (\3\:D \5\:D) resistor r=45 c=0
Rx1 (\2\:CK \4\:CK) resistor r=45 c=0
Rx15 (\4\:SE \8\:SE) resistor r=45 c=0
Rx16 (\2\:SE \10\:SE) resistor r=45 c=0
Rx17 (\6\:SE \11\:SE) resistor r=45 c=0
Rx14 (\2\:SI \4\:SI) resistor r=45 c=0
Rx2 (\12\:qbint \10\:qbint) resistor r=45 c=0
Rx3 (\18\:qbint \6\:qbint) resistor r=45 c=0
Rx6 (CKb \12\:CKb) resistor r=45 c=0
Rx7 (\9\:CKb \17\:CKb) resistor r=45 c=0
Rx4 (\2\:n30 \4\:n30) resistor r=45 c=0
Rx5 (\3\:mout \5\:mout) resistor r=45 c=0
Rx9 (\8\:CKbb \11\:CKbb) resistor r=45 c=0
Rx10 (\4\:CKbb \14\:CKbb) resistor r=45 c=0
Rx11 (\6\:CKbb \17\:CKbb) resistor r=45 c=0
Rx12 (\2\:CKbb \18\:CKbb) resistor r=45 c=0
Rx8 (\2\:n20 \7\:n20) resistor r=45 c=0
Rx18 (\2\:SEb \4\:SEb) resistor r=45 c=0
mn11 (net399 \4\:D \14\:VSS VSS) g45n1hvt w=(2.6e-07) l=4.5e-08 nf=1 \
        as=3.47e-14 ad=7.67e-14 ps=8.4e-07 pd=1.11e-06 nrd=1.16667 \
        nrs=1.16667 sa=2.36635e-07 sb=1.07942e-06 sd=160n sca=9.32128 \
        scb=0.00786794 scc=0.000232361 m=(1)
mn12 (Db \3\:SEb net399 VSS) g45n1hvt w=(2.6e-07) l=4.5e-08 nf=1 \
        as=7.67e-14 ad=4.16e-14 ps=1.11e-06 pd=8.4e-07 nrd=1.16667 \
        nrs=1.16667 sa=5.76635e-07 sb=7.39423e-07 sd=160n sca=9.32128 \
        scb=0.00786794 scc=0.000232361 m=(1)
mn14 (Db \3\:SE net411 VSS) g45n1hvt w=(2.6e-07) l=4.5e-08 nf=1 \
        as=1.69e-14 ad=4.16e-14 ps=6.5e-07 pd=8.4e-07 nrd=1.16667 \
        nrs=1.16667 sa=7.81635e-07 sb=5.34423e-07 sd=160n sca=9.32128 \
        scb=0.00786794 scc=0.000232361 m=(1)
mn13 (net411 \1\:SI \12\:VSS VSS) g45n1hvt w=(2.6e-07) l=4.5e-08 nf=1 \
        as=7.482e-14 ad=1.69e-14 ps=1.33e-06 pd=6.5e-07 nrd=1.16667 \
        nrs=1.16667 sa=8.91635e-07 sb=4.24423e-07 sd=160n sca=9.32128 \
        scb=0.00786794 scc=0.000232361 m=(1)
mn55_1__rcx (\3\:Q qbint VSS VSS) g45n1hvt w=(2.6e-07) l=4.5e-08 nf=1 \
        as=4.003e-14 ad=4.16e-14 ps=8.5e-07 pd=8.4e-07 nrd=1.16667 \
        nrs=1.16667 sa=1.4e-07 sb=5.73654e-07 sd=160n sca=17.5885 \
        scb=0.0172826 scc=0.00162584 m=(2)
mn20 (\18\:CKb \1\:CK VSS VSS) g45n1hvt w=(1.45e-07) l=4.5e-08 nf=1 \
        as=4.365e-14 ad=4.567e-14 ps=9e-07 pd=9.2e-07 nrd=1.16667 \
        nrs=1.16667 sa=5.8e-07 sb=3.15e-07 sd=160n sca=23.279 \
        scb=0.0230742 scc=0.00267719 m=(1)
mn21 (\15\:CKbb \5\:CKb \14\:VSS VSS) g45n1hvt w=(1.45e-07) l=4.5e-08 \
        nf=1 as=3.47e-14 ad=2.03e-14 ps=8.4e-07 pd=5.7e-07 nrd=1.16667 \
        nrs=1.16667 sa=1.4e-07 sb=1.10552e-06 sd=160n sca=7.47547 \
        scb=0.00467957 scc=5.27432e-05 m=(1)
mn10 (\7\:SEb \5\:SE \12\:VSS VSS) g45n1hvt w=(1.45e-07) l=4.5e-08 nf=1 \
        as=7.482e-14 ad=2.9e-14 ps=1.33e-06 pd=6.9e-07 nrd=1.16667 \
        nrs=1.16667 sa=1.25569e-06 sb=2e-07 sd=160n sca=11.1906 \
        scb=0.0108717 scc=0.000387468 m=(1)
mn45 (\16\:qbint n30 \18\:VSS VSS) g45n1hvt w=(2.05e-07) l=4.5e-08 nf=1 \
        as=3.382e-14 ad=2.87e-14 ps=7.4e-07 pd=6.9e-07 nrd=1.16667 \
        nrs=1.16667 sa=1.4e-07 sb=2e-06 sd=160n sca=9.70996 scb=0.0085072 \
        scc=0.000244399 m=(1)
mn50 (net391 \11\:qbint \18\:VSS VSS) g45n1hvt w=(2.05e-07) l=4.5e-08 \
        nf=1 as=3.382e-14 ad=5.432e-14 ps=7.4e-07 pd=9.4e-07 nrd=1.16667 \
        nrs=1.16667 sa=3.5e-07 sb=2e-06 sd=160n sca=9.70996 scb=0.0085072 \
        scc=0.000244399 m=(1)
mn51 (\8\:n30 \3\:CKb net391 VSS) g45n1hvt w=(2.05e-07) l=4.5e-08 nf=1 \
        as=5.432e-14 ad=4.51e-14 ps=9.4e-07 pd=8.5e-07 nrd=1.16667 \
        nrs=1.16667 sa=6.6e-07 sb=1.725e-06 sd=160n sca=9.70996 \
        scb=0.0085072 scc=0.000244399 m=(1)
mn40 (\7\:mout \3\:CKbb \8\:n30 VSS) g45n1hvt w=(2.05e-07) l=4.5e-08 nf=1 \
        as=4.51e-14 ad=8.61e-14 ps=8.5e-07 pd=1.25e-06 nrd=1.16667 \
        nrs=1.16667 sa=9.25e-07 sb=1.46e-06 sd=160n sca=9.70996 \
        scb=0.0085072 scc=0.000244399 m=(1)
mn30 (\7\:mout \3\:n20 \16\:VSS VSS) g45n1hvt w=(2.05e-07) l=4.5e-08 \
        nf=1 as=6.49e-14 ad=8.61e-14 ps=1.18e-06 pd=1.25e-06 nrd=1.16667 \
        nrs=1.16667 sa=1.39e-06 sb=9.95e-07 sd=160n sca=9.70996 \
        scb=0.0085072 scc=0.000244399 m=(1)
mn35 (net378 \4\:mout \16\:VSS VSS) g45n1hvt w=(2.05e-07) l=4.5e-08 nf=1 \
        as=6.49e-14 ad=1.435e-14 ps=1.18e-06 pd=5.5e-07 nrd=1.16667 \
        nrs=1.16667 sa=1.655e-06 sb=7.3e-07 sd=160n sca=9.70996 \
        scb=0.0085072 scc=0.000244399 m=(1)
mn36 (\8\:n20 \5\:CKbb net378 VSS) g45n1hvt w=(2.05e-07) l=4.5e-08 nf=1 \
        as=1.435e-14 ad=5.227e-14 ps=5.5e-07 pd=9.2e-07 nrd=1.16667 \
        nrs=1.16667 sa=1.77e-06 sb=6.15e-07 sd=160n sca=9.70996 \
        scb=0.0085072 scc=0.000244399 m=(1)
mn25 (\8\:n20 \11\:CKb \8\:Db VSS) g45n1hvt w=(2.05e-07) l=4.5e-08 nf=1 \
        as=6.458e-14 ad=5.228e-14 ps=1.04e-06 pd=9.2e-07 nrd=1.16667 \
        nrs=1.16667 sa=2e-06 sb=3.15e-07 sd=160n sca=9.70996 scb=0.0085072 \
        scc=0.000244399 m=(1)
mp20 (\15\:CKb \3\:CK VDD VDD) g45p1hvt w=(2.15e-07) l=4.5e-08 nf=1 \
        as=5.19e-14 ad=3.01e-14 ps=1.1e-06 pd=7.1e-07 nrd=1.16667 \
        nrs=1.16667 sa=5.5e-07 sb=1.4e-07 sd=160n sca=12.3324 \
        scb=0.00994664 scc=0.000204208 m=(1)
mp21 (\9\:CKbb \10\:CKb \14\:VDD VDD) g45p1hvt w=(2.15e-07) l=4.5e-08 \
        nf=1 as=6.535e-14 ad=3.01e-14 ps=1.16e-06 pd=7.1e-07 nrd=1.16667 \
        nrs=1.16667 sa=1.4e-07 sb=1.05465e-06 sd=160n sca=10.5619 \
        scb=0.00813366 scc=0.000119634 m=(1)
mp10 (\5\:SEb \7\:SE \12\:VDD VDD) g45p1hvt w=(2.15e-07) l=4.5e-08 nf=1 \
        as=1.1265e-13 ad=3.01e-14 ps=1.6e-06 pd=7.1e-07 nrd=1.16667 \
        nrs=1.16667 sa=1.23372e-06 sb=1.4e-07 sd=160n sca=25.6683 \
        scb=0.0269847 scc=0.00206824 m=(1)
mp45 (\14\:qbint \3\:n30 \18\:VDD VDD) g45p1hvt w=(3.1e-07) l=4.5e-08 \
        nf=1 as=9.1e-14 ad=4.96e-14 ps=1.44e-06 pd=9.4e-07 nrd=1.16667 \
        nrs=1.16667 sa=1.6e-07 sb=2e-06 sd=160n sca=35.6995 scb=0.0234062 \
        scc=0.00420468 m=(1)
mp50 (net334 \8\:qbint \18\:VDD VDD) g45p1hvt w=(3.1e-07) l=4.5e-08 nf=1 \
        as=9.1e-14 ad=5.27e-14 ps=1.44e-06 pd=9.6e-07 nrd=1.16667 \
        nrs=1.16667 sa=4.25e-07 sb=1.92871e-06 sd=160n sca=35.6995 \
        scb=0.0234062 scc=0.00420468 m=(1)
mp51 (\6\:n30 CKbb net334 VDD) g45p1hvt w=(3.1e-07) l=4.5e-08 nf=1 \
        as=5.27e-14 ad=9.765e-14 ps=9.6e-07 pd=1.25e-06 nrd=1.16667 \
        nrs=1.16667 sa=6.4e-07 sb=1.71597e-06 sd=160n sca=35.6995 \
        scb=0.0234062 scc=0.00420468 m=(1)
mp40 (\6\:n30 \4\:CKb \9\:mout VDD) g45p1hvt w=(3.1e-07) l=4.5e-08 nf=1 \
        as=1.302e-13 ad=9.765e-14 ps=1.46e-06 pd=1.25e-06 nrd=1.16667 \
        nrs=1.16667 sa=1e-06 sb=1.35597e-06 sd=160n sca=35.6995 \
        scb=0.0234062 scc=0.00420468 m=(1)
mp30 (\9\:mout n20 \16\:VDD VDD) g45p1hvt w=(3.1e-07) l=4.5e-08 nf=1 \
        as=8.74e-14 ad=1.302e-13 ps=1.38e-06 pd=1.46e-06 nrd=1.16667 \
        nrs=1.16667 sa=1.465e-06 sb=8.90968e-07 sd=160n sca=35.6995 \
        scb=0.0234062 scc=0.00420468 m=(1)
mp35 (net319 mout \16\:VDD VDD) g45p1hvt w=(3.1e-07) l=4.5e-08 nf=1 \
        as=8.74e-14 ad=6.045e-14 ps=1.38e-06 pd=1.01e-06 nrd=1.16667 \
        nrs=1.16667 sa=1.73e-06 sb=6.25968e-07 sd=160n sca=35.6995 \
        scb=0.0234062 scc=0.00420468 m=(1)
mp36 (\4\:n20 \8\:CKb net319 VDD) g45p1hvt w=(3.1e-07) l=4.5e-08 nf=1 \
        as=6.045e-14 ad=5.58e-14 ps=1.01e-06 pd=9.8e-07 nrd=1.16667 \
        nrs=1.16667 sa=1.97e-06 sb=3.85968e-07 sd=160n sca=35.6995 \
        scb=0.0234062 scc=0.00420468 m=(1)
mp25 (\4\:Db \7\:CKbb \4\:n20 VDD) g45p1hvt w=(3.1e-07) l=4.5e-08 nf=1 \
        as=5.58e-14 ad=4.99e-14 ps=9.8e-07 pd=1.09e-06 nrd=1.16667 \
        nrs=1.16667 sa=2e-06 sb=1.60968e-07 sd=160n sca=35.6995 \
        scb=0.0234062 scc=0.00420468 m=(1)
ends SDFFHQX2
// End of subcircuit definition.
