// Generated for: spectre (May  1 09:15:42 2013 )
// Library name: gsclib045_hvt
// Cell name: SDFFRX1
// View name: extracted

simulator lang=spectre

subckt SDFFRX1 CK D Q QN RN SE SI VDD VSS
mp57 (\1\:QN \4\:qint \26\:VDD VDD) g45p1hvt w=(3.9e-07) l=4.5e-08 nf=1 \
        as=7.142e-14 ad=5.46e-14 ps=1.52e-06 pd=1.06e-06 nrd=1.16667 \
        nrs=1.16667 sa=1.4e-07 sb=2.49744e-07 sd=160n sca=35.1619 \
        scb=0.02637 scc=0.00345369 m=(1)
mp55 (\1\:Q qbint \24\:VDD VDD) g45p1hvt w=(3.9e-07) l=4.5e-08 nf=1 \
        as=6.965e-14 ad=5.46e-14 ps=1.2e-06 pd=1.06e-06 nrd=1.16667 \
        nrs=1.16667 sa=1.4e-07 sb=3.02628e-07 sd=160n sca=20.5009 \
        scb=0.0171135 scc=0.00197772 m=(1)
C1 (RN VSS) capacitor c=8.7932e-17
C2 (QN VSS) capacitor c=2.14017e-17
C3 (SE VSS) capacitor c=4.24894e-17
C4 (SI VSS) capacitor c=7.82079e-17
C5 (VDD VSS) capacitor c=3.82149e-16
C6 (CK VSS) capacitor c=6.8427e-17
C7 (D VSS) capacitor c=5.71422e-17
C8 (qint VSS) capacitor c=2.13771e-17
C9 (qbint VSS) capacitor c=4.04991e-17
C10 (CKb VSS) capacitor c=4.52719e-17
C11 (n9 VSS) capacitor c=2.50111e-18
C12 (n30 VSS) capacitor c=2.09631e-17
C13 (n11 VSS) capacitor c=4.35612e-18
C14 (mout VSS) capacitor c=5.76693e-17
C15 (Ckbb VSS) capacitor c=2.27596e-17
C16 (n20 VSS) capacitor c=3.91598e-17
C17 (n7 VSS) capacitor c=7.275e-19
C18 (Db VSS) capacitor c=1.01741e-16
C19 (n1 VSS) capacitor c=8.34339e-18
C20 (SEb VSS) capacitor c=3.76651e-17
C21 (n8 VSS) capacitor c=3.12581e-18
C22 (n6 VSS) capacitor c=6.32439e-17
C23 (n2 VSS) capacitor c=7.58328e-18
C24 (\5\:SE VSS) capacitor c=3.55088e-17
C25 (\1\:SI VSS) capacitor c=4.19887e-17
C26 (\1\:SE VSS) capacitor c=3.96346e-17
C27 (\1\:D VSS) capacitor c=6.14583e-17
C28 (\9\:CKb VSS) capacitor c=5.54127e-17
C29 (\7\:Ckbb VSS) capacitor c=4.6094e-17
C30 (\6\:CKb VSS) capacitor c=4.99369e-17
C31 (\6\:RN VSS) capacitor c=6.76711e-17
C32 (\3\:n20 VSS) capacitor c=4.44199e-17
C33 (\3\:CKb VSS) capacitor c=3.64461e-17
C34 (\3\:Ckbb VSS) capacitor c=6.68967e-17
C35 (\8\:qbint VSS) capacitor c=5.52638e-17
C36 (\3\:RN VSS) capacitor c=3.90527e-17
C37 (\3\:n30 VSS) capacitor c=5.01678e-17
C38 (\1\:CK VSS) capacitor c=3.12235e-17
C39 (\7\:qbint VSS) capacitor c=3.10212e-17
C40 (\4\:qint VSS) capacitor c=4.47874e-17
C41 (\7\:SE VSS) capacitor c=1.98052e-17
C42 (\3\:SI VSS) capacitor c=5.63681e-17
C43 (\3\:SE VSS) capacitor c=6.7387e-17
C44 (\3\:SEb VSS) capacitor c=5.9398e-17
C45 (\3\:D VSS) capacitor c=2.70336e-17
C46 (\8\:CKb VSS) capacitor c=5.64822e-17
C47 (\5\:CKb VSS) capacitor c=4.81988e-17
C48 (\4\:Ckbb VSS) capacitor c=7.34209e-17
C49 (\3\:mout VSS) capacitor c=5.78248e-17
C50 (\5\:RN VSS) capacitor c=8.99042e-17
C51 (\10\:qbint VSS) capacitor c=3.91271e-17
C52 (\1\:RN VSS) capacitor c=5.13212e-17
C53 (\2\:n30 VSS) capacitor c=4.65525e-17
C54 (\3\:CK VSS) capacitor c=3.43976e-17
C55 (\5\:qbint VSS) capacitor c=3.02208e-17
C56 (\4\:qbint VSS) capacitor c=3.14393e-17
C57 (\3\:qint VSS) capacitor c=3.66959e-17
C58 (\6\:SE VSS) capacitor c=2.63734e-17
C59 (\2\:SI VSS) capacitor c=5.40428e-17
C60 (\4\:SE VSS) capacitor c=6.03027e-17
C61 (\2\:SEb VSS) capacitor c=7.28919e-17
C62 (\2\:SE VSS) capacitor c=4.35397e-17
C63 (\2\:D VSS) capacitor c=3.86703e-17
C64 (\10\:CKb VSS) capacitor c=2.3022e-17
C65 (\6\:Ckbb VSS) capacitor c=3.194e-17
C66 (\7\:CKb VSS) capacitor c=2.02439e-17
C67 (\5\:Ckbb VSS) capacitor c=3.37815e-17
C68 (\2\:mout VSS) capacitor c=6.09843e-17
C69 (\7\:RN VSS) capacitor c=2.82343e-17
C70 (\2\:n20 VSS) capacitor c=4.5627e-17
C71 (\4\:CKb VSS) capacitor c=3.1916e-17
C72 (\2\:Ckbb VSS) capacitor c=5.26665e-17
C73 (\2\:CKb VSS) capacitor c=5.54134e-17
C74 (\9\:qbint VSS) capacitor c=4.869e-17
C75 (\2\:RN VSS) capacitor c=4.27332e-17
C76 (\4\:RN VSS) capacitor c=2.59851e-17
C77 (\2\:CK VSS) capacitor c=2.90765e-17
C78 (\4\:SEb VSS) capacitor c=7.28406e-18
C79 (\1\:VDD VSS) capacitor c=3.33844e-17
C80 (\8\:Db VSS) capacitor c=3.05518e-17
C81 (\14\:VDD VSS) capacitor c=7.45943e-18
C82 (\13\:Ckbb VSS) capacitor c=7.65835e-17
C83 (\4\:Db VSS) capacitor c=1.57893e-16
C84 (\7\:n20 VSS) capacitor c=5.2632e-17
C85 (\16\:VDD VSS) capacitor c=4.06071e-17
C86 (\3\:n6 VSS) capacitor c=6.77072e-17
C87 (\18\:VDD VSS) capacitor c=2.57615e-17
C88 (\8\:mout VSS) capacitor c=6.04974e-17
C89 (\7\:n30 VSS) capacitor c=8.44612e-17
C90 (\20\:VDD VSS) capacitor c=2.56005e-17
C91 (\11\:qbint VSS) capacitor c=9.77771e-17
C92 (\22\:VDD VSS) capacitor c=1.02615e-17
C93 (\15\:CKb VSS) capacitor c=1.33131e-16
C94 (\24\:VDD VSS) capacitor c=4.3568e-17
C95 (\1\:Q VSS) capacitor c=7.33879e-17
C96 (\5\:qint VSS) capacitor c=2.45112e-17
C97 (\26\:VDD VSS) capacitor c=1.85875e-17
C98 (\1\:QN VSS) capacitor c=3.52654e-17
C99 (\3\:VDD VSS) capacitor c=5.80316e-17
C100 (\8\:SEb VSS) capacitor c=5.7483e-17
C101 (\9\:Ckbb VSS) capacitor c=1.14983e-16
C102 (\6\:Db VSS) capacitor c=7.64813e-17
C103 (\4\:n20 VSS) capacitor c=5.11719e-17
C104 (\6\:mout VSS) capacitor c=3.12386e-17
C105 (\4\:n30 VSS) capacitor c=1.22854e-16
C106 (\14\:qbint VSS) capacitor c=7.42396e-17
C107 (\19\:CKb VSS) capacitor c=6.36781e-17
C108 (\3\:Q VSS) capacitor c=7.46376e-17
C109 (\9\:qint VSS) capacitor c=2.36187e-17
C110 (\3\:QN VSS) capacitor c=2.63059e-17
C111 (\2\:qint VSS) capacitor c=7.32123e-18
C112 (\2\:qbint VSS) capacitor c=3.87893e-17
C113 (\3\:qbint VSS) capacitor c=3.05606e-17
C114 (\7\:qint VSS) capacitor c=2.71099e-17
C115 (\8\:qint VSS) capacitor c=1.98745e-17
C116 (\4\:CK VSS) capacitor c=4.1319e-17
C117 (\8\:RN VSS) capacitor c=4.02292e-17
C118 (\13\:qbint VSS) capacitor c=1.11882e-16
C119 (\16\:qbint VSS) capacitor c=8.54339e-17
C120 (\17\:qbint VSS) capacitor c=1.11139e-16
C121 (\6\:n30 VSS) capacitor c=9.69982e-17
C122 (\9\:RN VSS) capacitor c=1.68008e-16
C123 (\10\:RN VSS) capacitor c=1.65826e-16
C124 (\4\:mout VSS) capacitor c=6.49029e-17
C125 (\5\:mout VSS) capacitor c=7.40697e-17
C126 (\6\:n20 VSS) capacitor c=1.09794e-16
C127 (\9\:n20 VSS) capacitor c=8.59357e-17
C128 (\8\:Ckbb VSS) capacitor c=3.41045e-17
C129 (\11\:Ckbb VSS) capacitor c=1.8757e-16
C130 (\12\:Ckbb VSS) capacitor c=1.29738e-16
C131 (\11\:CKb VSS) capacitor c=7.98327e-17
C132 (\12\:CKb VSS) capacitor c=1.64649e-16
C133 (\13\:CKb VSS) capacitor c=1.2796e-16
C134 (\14\:CKb VSS) capacitor c=1.58451e-16
C135 (\17\:CKb VSS) capacitor c=6.84331e-17
C136 (\18\:CKb VSS) capacitor c=7.01807e-17
C137 (\4\:D VSS) capacitor c=4.83274e-17
C138 (\3\:Db VSS) capacitor c=1.52558e-16
C139 (\4\:SI VSS) capacitor c=4.64261e-17
C140 (\8\:SE VSS) capacitor c=7.85651e-17
C141 (\9\:SE VSS) capacitor c=1.02287e-16
C142 (\10\:SE VSS) capacitor c=4.23401e-17
C143 (\6\:SEb VSS) capacitor c=7.92635e-17
C144 (\7\:SEb VSS) capacitor c=9.48785e-17
C145 (\5\:VDD VSS) capacitor c=3.94931e-17
C146 (\6\:VDD VSS) capacitor c=2.45265e-17
C147 (\8\:VDD VSS) capacitor c=3.54967e-17
C148 (\9\:VDD VSS) capacitor c=3.95558e-17
C149 (\10\:VDD VSS) capacitor c=1.58492e-17
C150 (\12\:VDD VSS) capacitor c=1.01303e-17
C151 (\13\:VDD VSS) capacitor c=1.16239e-17
Rk9 (\8\:RN RN) resistor r=0.1221 c=0
Rk16 (\9\:RN \10\:RN) resistor r=1.0603 c=0
Rk2 (\4\:QN QN) resistor r=0.07593 c=0
Rk1 (\2\:QN \4\:QN) resistor r=0.3057 c=0
Rk41 (SE \8\:SE) resistor r=0.09091 c=0
Rk42 (\8\:SE \9\:SE) resistor r=0.5972 c=0
Rk43 (\9\:SE \10\:SE) resistor r=0.1875 c=0
Rk6 (\2\:Q Q) resistor r=0.3602 c=0
Rk7 (Q \4\:Q) resistor r=0.04708 c=0
Rk40 (SI \4\:SI) resistor r=0.04461 c=0
Rk47 (\2\:VDD \4\:VDD) resistor r=0.4042 c=0
Rk48 (\4\:VDD \5\:VDD) resistor r=0.3885 c=0
Rk49 (\5\:VDD \6\:VDD) resistor r=0.5638 c=0
Rk50 (\6\:VDD \7\:VDD) resistor r=0.04995 c=0
Rk51 (\7\:VDD \8\:VDD) resistor r=0.1694 c=0
Rk52 (\8\:VDD \9\:VDD) resistor r=0.5393 c=0
Rk53 (\9\:VDD \10\:VDD) resistor r=0.1993 c=0
Rk54 (\10\:VDD \11\:VDD) resistor r=0.2907 c=0
Rk55 (\11\:VDD \12\:VDD) resistor r=0.04243 c=0
Rk57 (\13\:VDD VDD) resistor r=0.1976 c=0
Rk56 (\12\:VDD \13\:VDD) resistor r=0.3105 c=0
Rk58 (\5\:VDD \15\:VDD) resistor r=0.07381 c=0
Rk59 (\6\:VDD \17\:VDD) resistor r=0.1759 c=0
Rk60 (\8\:VDD \19\:VDD) resistor r=0.0433 c=0
Rk61 (\9\:VDD \21\:VDD) resistor r=0.0433 c=0
Rk62 (\10\:VDD \23\:VDD) resistor r=0.07381 c=0
Rk63 (\12\:VDD \25\:VDD) resistor r=0.2785 c=0
Rk64 (\13\:VDD \27\:VDD) resistor r=0.224 c=0
Rk8 (\4\:CK CK) resistor r=0.1844 c=0
Rk35 (\4\:D D) resistor r=0.1361 c=0
Rk65 (\2\:VSS \3\:VSS) resistor r=0.2039 c=0
Rk66 (\3\:VSS \5\:VSS) resistor r=0.4236 c=0
Rk67 (\3\:VSS \6\:VSS) resistor r=0.579 c=0
Rk68 (\6\:VSS \7\:VSS) resistor r=0.1051 c=0
Rk69 (\7\:VSS \8\:VSS) resistor r=0.6064 c=0
Rk70 (\8\:VSS \9\:VSS) resistor r=0.4913 c=0
Rk71 (\9\:VSS \10\:VSS) resistor r=0.065 c=0
Rk73 (\11\:VSS VSS) resistor r=0.1976 c=0
Rk72 (\10\:VSS \11\:VSS) resistor r=0.288 c=0
Rk74 (\5\:VSS \13\:VSS) resistor r=0.2757 c=0
Rk75 (\7\:VSS \15\:VSS) resistor r=0.1225 c=0
Rk76 (\8\:VSS \17\:VSS) resistor r=0.1506 c=0
Rk77 (\10\:VSS \19\:VSS) resistor r=0.2864 c=0
Rk78 (\11\:VSS \21\:VSS) resistor r=0.07381 c=0
Rk3 (\6\:qint \7\:qint) resistor r=0.1177 c=0
Rk4 (\7\:qint \8\:qint) resistor r=0.1193 c=0
Rk5 (\7\:qint \10\:qint) resistor r=0.1057 c=0
Rk10 (\12\:qbint \13\:qbint) resistor r=0.5616 c=0
Rk11 (\13\:qbint \15\:qbint) resistor r=0.1131 c=0
Rk12 (\13\:qbint \16\:qbint) resistor r=0.4471 c=0
Rk13 (\15\:qbint \17\:qbint) resistor r=0.677 c=0
Rk28 (\11\:CKb \12\:CKb) resistor r=0.5573 c=0
Rk29 (\12\:CKb \13\:CKb) resistor r=0.8047 c=0
Rk30 (\13\:CKb \14\:CKb) resistor r=0.2989 c=0
Rk31 (\14\:CKb \16\:CKb) resistor r=0.9156 c=0
Rk32 (\13\:CKb \17\:CKb) resistor r=0.2834 c=0
Rk33 (\14\:CKb \18\:CKb) resistor r=0.3719 c=0
Rk34 (\16\:CKb \20\:CKb) resistor r=0.3553 c=0
Rk14 (\5\:n30 \6\:n30) resistor r=0.6434 c=0
Rk15 (\5\:n30 \8\:n30) resistor r=0.4521 c=0
Rk17 (\4\:mout \5\:mout) resistor r=0.4543 c=0
Rk18 (\5\:mout \7\:mout) resistor r=0.1108 c=0
Rk19 (\5\:mout \9\:mout) resistor r=0.2121 c=0
Rk24 (\8\:Ckbb \10\:Ckbb) resistor r=0.2636 c=0
Rk25 (\10\:Ckbb \11\:Ckbb) resistor r=0.5614 c=0
Rk26 (\11\:Ckbb \12\:Ckbb) resistor r=1.129 c=0
Rk27 (\10\:Ckbb \14\:Ckbb) resistor r=0.5596 c=0
Rk21 (\5\:n20 \6\:n20) resistor r=0.2469 c=0
Rk22 (\6\:n20 \8\:n20) resistor r=0.2957 c=0
Rk23 (\6\:n20 \9\:n20) resistor r=0.5202 c=0
Rk36 (\2\:Db \3\:Db) resistor r=0.7641 c=0
Rk37 (\3\:Db \5\:Db) resistor r=0.7638 c=0
Rk38 (\5\:Db \7\:Db) resistor r=0.4683 c=0
Rk39 (\3\:Db \9\:Db) resistor r=0.178 c=0
Rk44 (\5\:SEb \6\:SEb) resistor r=0.04786 c=0
Rk45 (\6\:SEb \7\:SEb) resistor r=0.5956 c=0
Rk46 (\6\:SEb \9\:SEb) resistor r=0.4871 c=0
Rk20 (\2\:n6 \4\:n6) resistor r=0.219 c=0
Rl25 (\5\:RN \6\:RN) resistor r=188.027 c=0
Rl26 (\6\:RN \7\:RN) resistor r=87.2302 c=0
Rl15 (\2\:RN \3\:RN) resistor r=51.1559 c=0
Rl14 (\1\:RN \2\:RN) resistor r=87.6944 c=0
Rl16 (\3\:RN \4\:RN) resistor r=87.2302 c=0
Rl43 (\5\:SE \6\:SE) resistor r=158.384 c=0
Rl44 (\6\:SE \7\:SE) resistor r=29.5379 c=0
Rl40 (\3\:SE \4\:SE) resistor r=81.461 c=0
Rl37 (\1\:SE \2\:SE) resistor r=79.5379 c=0
Rl41 (\1\:SI \2\:SI) resistor r=98.7687 c=0
Rl42 (\2\:SI \3\:SI) resistor r=89.1533 c=0
Rl10 (\1\:CK \2\:CK) resistor r=37.2302 c=0
Rl11 (\2\:CK \3\:CK) resistor r=44.9225 c=0
Rl35 (\1\:D \2\:D) resistor r=160.618 c=0
Rl36 (\2\:D \3\:D) resistor r=26.1559 c=0
Rl3 (\2\:qint \4\:qint) resistor r=49.7141 c=0
Rl2 (\2\:qint \3\:qint) resistor r=34.3295 c=0
Rl1 (qint \2\:qint) resistor r=5.915 c=0
Rl17 (\8\:qbint \9\:qbint) resistor r=102.615 c=0
Rl18 (\9\:qbint \10\:qbint) resistor r=39.1533 c=0
Rl4 (qbint \2\:qbint) resistor r=68.2462 c=0
Rl7 (\2\:qbint \5\:qbint) resistor r=37.477 c=0
Rl8 (\2\:qbint \6\:qbint) resistor r=5.6723 c=0
Rl9 (\3\:qbint \7\:qbint) resistor r=41.5412 c=0
Rl6 (\3\:qbint \4\:qbint) resistor r=47.3105 c=0
Rl5 (\2\:qbint \3\:qbint) resistor r=145.337 c=0
Rl33 (\8\:CKb \9\:CKb) resistor r=211.022 c=0
Rl30 (\5\:CKb \6\:CKb) resistor r=150.368 c=0
Rl34 (\9\:CKb \10\:CKb) resistor r=50.6918 c=0
Rl31 (\6\:CKb \7\:CKb) resistor r=47.2519 c=0
Rl22 (\3\:CKb \4\:CKb) resistor r=24.2328 c=0
Rl19 (CKb \2\:CKb) resistor r=64.6174 c=0
Rl13 (\2\:n30 \3\:n30) resistor r=170.72 c=0
Rl12 (n30 \2\:n30) resistor r=26.1559 c=0
Rl27 (mout \2\:mout) resistor r=114.617 c=0
Rl28 (\2\:mout \3\:mout) resistor r=24.2328 c=0
Rl32 (\6\:Ckbb \7\:Ckbb) resistor r=118.744 c=0
Rl29 (\4\:Ckbb \5\:Ckbb) resistor r=26.1559 c=0
Rl21 (\2\:Ckbb \3\:Ckbb) resistor r=164.504 c=0
Rl20 (Ckbb \2\:Ckbb) resistor r=24.2328 c=0
Rl24 (\2\:n20 \3\:n20) resistor r=53.4003 c=0
Rl23 (n20 \2\:n20) resistor r=97.3098 c=0
Rl38 (SEb \2\:SEb) resistor r=26.9231 c=0
Rl39 (\2\:SEb \3\:SEb) resistor r=167.606 c=0
Rz1 (\3\:QN \4\:QN) resistor r=75 c=0
Rz3 (\3\:Q \4\:Q) resistor r=75 c=0
Rz13 (\3\:VDD \4\:VDD) resistor r=9.375 c=0
Rz14 (\3\:VDD \7\:VDD) resistor r=6.25 c=0
Rz15 (\3\:VDD \11\:VDD) resistor r=6.25 c=0
Rz16 (\1\:VSS \2\:VSS) resistor r=75 c=0
Rz17 (\12\:VSS \13\:VSS) resistor r=75 c=0
Rz18 (\14\:VSS \15\:VSS) resistor r=75 c=0
Rz19 (\16\:VSS \17\:VSS) resistor r=75 c=0
Rz20 (\18\:VSS \19\:VSS) resistor r=75 c=0
Rz21 (\20\:VSS \21\:VSS) resistor r=75 c=0
Rz2 (\9\:qint \10\:qint) resistor r=75 c=0
Rz4 (\14\:qbint \15\:qbint) resistor r=75 c=0
Rz9 (\19\:CKb \20\:CKb) resistor r=75 c=0
Rz5 (\4\:n30 \5\:n30) resistor r=75 c=0
Rz6 (\6\:mout \7\:mout) resistor r=75 c=0
Rz8 (\9\:Ckbb \10\:Ckbb) resistor r=75 c=0
Rz7 (\4\:n20 \5\:n20) resistor r=75 c=0
Rz10 (Db \2\:Db) resistor r=75 c=0
Rz11 (\6\:Db \7\:Db) resistor r=75 c=0
Rz12 (\8\:SEb \9\:SEb) resistor r=75 c=0
Ry1 (\1\:QN \2\:QN) resistor r=20.6667 c=0
Ry3 (\1\:Q \2\:Q) resistor r=20.6667 c=0
Ry15 (\1\:VDD \2\:VDD) resistor r=62 c=0
Ry16 (\14\:VDD \15\:VDD) resistor r=62 c=0
Ry17 (\16\:VDD \17\:VDD) resistor r=62 c=0
Ry18 (\18\:VDD \19\:VDD) resistor r=62 c=0
Ry19 (\20\:VDD \21\:VDD) resistor r=62 c=0
Ry20 (\22\:VDD \23\:VDD) resistor r=62 c=0
Ry21 (\24\:VDD \25\:VDD) resistor r=62 c=0
Ry22 (\26\:VDD \27\:VDD) resistor r=62 c=0
Ry23 (\4\:VSS \5\:VSS) resistor r=7.75 c=0
Ry24 (\4\:VSS \6\:VSS) resistor r=5.1667 c=0
Ry25 (\4\:VSS \9\:VSS) resistor r=5.1667 c=0
Ry2 (\5\:qint \6\:qint) resistor r=62 c=0
Ry4 (\11\:qbint \12\:qbint) resistor r=62 c=0
Ry11 (\15\:CKb \16\:CKb) resistor r=62 c=0
Ry5 (\7\:n30 \8\:n30) resistor r=62 c=0
Ry6 (\8\:mout \9\:mout) resistor r=62 c=0
Ry10 (\13\:Ckbb \14\:Ckbb) resistor r=62 c=0
Ry9 (\7\:n20 \8\:n20) resistor r=62 c=0
Ry12 (\4\:Db \5\:Db) resistor r=62 c=0
Ry13 (\8\:Db \9\:Db) resistor r=62 c=0
Ry14 (\4\:SEb \5\:SEb) resistor r=62 c=0
Ry7 (n6 \2\:n6) resistor r=62 c=0
Ry8 (\3\:n6 \4\:n6) resistor r=62 c=0
Rx3 (\2\:RN \8\:RN) resistor r=45 c=0
Rx7 (\7\:RN \9\:RN) resistor r=45 c=0
Rx8 (\4\:RN \10\:RN) resistor r=45 c=0
Rx20 (\6\:SE \8\:SE) resistor r=45 c=0
Rx21 (\4\:SE \9\:SE) resistor r=45 c=0
Rx22 (\2\:SE \10\:SE) resistor r=45 c=0
Rx19 (\2\:SI \4\:SI) resistor r=45 c=0
Rx2 (\2\:CK \4\:CK) resistor r=45 c=0
Rx18 (\2\:D \4\:D) resistor r=45 c=0
Rx1 (qint \8\:qint) resistor r=45 c=0
Rx4 (\9\:qbint \16\:qbint) resistor r=45 c=0
Rx5 (\6\:qbint \17\:qbint) resistor r=45 c=0
Rx14 (\10\:CKb \11\:CKb) resistor r=45 c=0
Rx15 (\7\:CKb \12\:CKb) resistor r=45 c=0
Rx16 (\4\:CKb \17\:CKb) resistor r=45 c=0
Rx17 (\2\:CKb \18\:CKb) resistor r=45 c=0
Rx6 (n30 \6\:n30) resistor r=45 c=0
Rx9 (\2\:mout \4\:mout) resistor r=45 c=0
Rx11 (\6\:Ckbb \8\:Ckbb) resistor r=45 c=0
Rx12 (\5\:Ckbb \11\:Ckbb) resistor r=45 c=0
Rx13 (\2\:Ckbb \12\:Ckbb) resistor r=45 c=0
Rx10 (\2\:n20 \9\:n20) resistor r=45 c=0
Rx23 (\2\:SEb \7\:SEb) resistor r=45 c=0
mn57 (\3\:QN \3\:qint \20\:VSS VSS) g45n1hvt w=(2.6e-07) l=4.5e-08 nf=1 \
        as=6.273e-14 ad=3.64e-14 ps=1.67e-06 pd=8e-07 nrd=1.16667 \
        nrs=1.16667 sa=1.4e-07 sb=2.50577e-07 sd=160n sca=17.5885 \
        scb=0.0172826 scc=0.00162584 m=(1)
mn55 (\3\:Q \5\:qbint \18\:VSS VSS) g45n1hvt w=(2.6e-07) l=4.5e-08 nf=1 \
        as=4.873e-14 ad=3.64e-14 ps=9.7e-07 pd=8e-07 nrd=1.16667 \
        nrs=1.16667 sa=1.4e-07 sb=3.51923e-07 sd=160n sca=17.5885 \
        scb=0.0172826 scc=0.00162584 m=(1)
mn56 (\9\:qint \4\:qbint \20\:VSS VSS) g45n1hvt w=(1.45e-07) l=4.5e-08 \
        nf=1 as=6.273e-14 ad=2.03e-14 ps=1.67e-06 pd=5.7e-07 nrd=1.16667 \
        nrs=1.16667 sa=3.7e-07 sb=1.4e-07 sd=160n sca=23.279 scb=0.0230742 \
        scc=0.00267719 m=(1)
mn20 (\19\:CKb \3\:CK \18\:VSS VSS) g45n1hvt w=(1.45e-07) l=4.5e-08 nf=1 \
        as=4.873e-14 ad=3.625e-14 ps=9.7e-07 pd=7.9e-07 nrd=1.16667 \
        nrs=1.16667 sa=4.1e-07 sb=2.5e-07 sd=160n sca=23.279 scb=0.0230742 \
        scc=0.00267719 m=(1)
mn46 (\14\:qbint \2\:n30 n9 VSS) g45n1hvt w=(1.45e-07) l=4.5e-08 nf=1 \
        as=1.523e-14 ad=3.698e-14 ps=5e-07 pd=8e-07 nrd=1.16667 \
        nrs=1.16667 sa=2.55e-07 sb=2e-06 sd=160n sca=9.50767 \
        scb=0.00818119 scc=0.00019576 m=(1)
mn45 (n9 \1\:RN \16\:VSS VSS) g45n1hvt w=(1.45e-07) l=4.5e-08 nf=1 \
        as=5.11e-14 ad=1.523e-14 ps=1.05e-06 pd=5e-07 nrd=1.16667 \
        nrs=1.16667 sa=4.05e-07 sb=2e-06 sd=160n sca=9.50767 \
        scb=0.00818119 scc=0.00019576 m=(1)
mn50 (n11 \10\:qbint \16\:VSS VSS) g45n1hvt w=(1.45e-07) l=4.5e-08 nf=1 \
        as=5.11e-14 ad=1.957e-14 ps=1.05e-06 pd=5.6e-07 nrd=1.16667 \
        nrs=1.16667 sa=6.7e-07 sb=1.81e-06 sd=160n sca=9.50767 \
        scb=0.00818119 scc=0.00019576 m=(1)
mn51 (\4\:n30 CKb n11 VSS) g45n1hvt w=(1.45e-07) l=4.5e-08 nf=1 \
        as=1.958e-14 ad=2.9e-14 ps=5.6e-07 pd=6.9e-07 nrd=1.16667 \
        nrs=1.16667 sa=8.5e-07 sb=1.63e-06 sd=160n sca=9.50767 \
        scb=0.00818119 scc=0.00019576 m=(1)
mn40 (\6\:mout Ckbb \4\:n30 VSS) g45n1hvt w=(1.45e-07) l=4.5e-08 nf=1 \
        as=2.9e-14 ad=5.728e-14 ps=6.9e-07 pd=1.08e-06 nrd=1.16667 \
        nrs=1.16667 sa=1.095e-06 sb=1.385e-06 sd=160n sca=9.50767 \
        scb=0.00818119 scc=0.00019576 m=(1)
mn30 (\6\:mout n20 \14\:VSS VSS) g45n1hvt w=(1.45e-07) l=4.5e-08 nf=1 \
        as=6.255e-14 ad=5.728e-14 ps=1.22e-06 pd=1.08e-06 nrd=1.16667 \
        nrs=1.16667 sa=1.535e-06 sb=9.45e-07 sd=160n sca=9.50767 \
        scb=0.00818119 scc=0.00019576 m=(1)
mn35 (n7 \5\:RN \14\:VSS VSS) g45n1hvt w=(1.45e-07) l=4.5e-08 nf=1 \
        as=6.255e-14 ad=8.7e-15 ps=1.22e-06 pd=4.1e-07 nrd=1.16667 \
        nrs=1.16667 sa=1.85e-06 sb=6.3e-07 sd=160n sca=9.50767 \
        scb=0.00818119 scc=0.00019576 m=(1)
mn36 (n5 \3\:mout n7 VSS) g45n1hvt w=(1.45e-07) l=4.5e-08 nf=1 as=8.7e-15 \
        ad=1.958e-14 ps=4.1e-07 pd=5.6e-07 nrd=1.16667 nrs=1.16667 \
        sa=1.955e-06 sb=5.25e-07 sd=160n sca=9.50767 scb=0.00818119 \
        scc=0.00019576 m=(1)
mn37 (\4\:n20 \4\:Ckbb n5 VSS) g45n1hvt w=(1.45e-07) l=4.5e-08 nf=1 \
        as=1.958e-14 ad=2.32e-14 ps=5.6e-07 pd=6.1e-07 nrd=1.16667 \
        nrs=1.16667 sa=2e-06 sb=3.45e-07 sd=160n sca=9.50767 \
        scb=0.00818119 scc=0.00019576 m=(1)
mn25 (\6\:Db \5\:CKb \4\:n20 VSS) g45n1hvt w=(1.45e-07) l=4.5e-08 nf=1 \
        as=2.32e-14 ad=2.03e-14 ps=6.1e-07 pd=5.7e-07 nrd=1.16667 \
        nrs=1.16667 sa=2e-06 sb=1.4e-07 sd=160n sca=9.50767 scb=0.00818119 \
        scc=0.00019576 m=(1)
mn21 (\9\:Ckbb \8\:CKb \1\:VSS VSS) g45n1hvt w=(1.45e-07) l=4.5e-08 nf=1 \
        as=2.32e-14 ad=4.64e-14 ps=6.1e-07 pd=9.3e-07 nrd=1.16667 \
        nrs=1.16667 sa=3.2e-07 sb=1.635e-06 sd=160n sca=7.37439 \
        scb=0.00450456 scc=4.82709e-05 m=(1)
mn11 (n1 \3\:D \1\:VSS VSS) g45n1hvt w=(1.45e-07) l=4.5e-08 nf=1 \
        as=2.32e-14 ad=5.148e-14 ps=6.1e-07 pd=1e-06 nrd=1.16667 \
        nrs=1.16667 sa=5.25e-07 sb=1.43e-06 sd=160n sca=7.37439 \
        scb=0.00450456 scc=4.82709e-05 m=(1)
mn12 (Db \3\:SEb n1 VSS) g45n1hvt w=(1.45e-07) l=4.5e-08 nf=1 \
        as=5.148e-14 ad=2.32e-14 ps=1e-06 pd=6.1e-07 nrd=1.16667 \
        nrs=1.16667 sa=9.25e-07 sb=1.03e-06 sd=160n sca=7.37439 \
        scb=0.00450456 scc=4.82709e-05 m=(1)
mn14 (Db \3\:SE n3 VSS) g45n1hvt w=(1.45e-07) l=4.5e-08 nf=1 as=8.7e-15 \
        ad=2.32e-14 ps=4.1e-07 pd=6.1e-07 nrd=1.16667 nrs=1.16667 \
        sa=1.13e-06 sb=8.25e-07 sd=160n sca=7.37439 scb=0.00450456 \
        scc=4.82709e-05 m=(1)
mn13 (n3 \3\:SI \12\:VSS VSS) g45n1hvt w=(1.45e-07) l=4.5e-08 nf=1 \
        as=6.525e-14 ad=8.7e-15 ps=1.19e-06 pd=4.1e-07 nrd=1.16667 \
        nrs=1.16667 sa=1.235e-06 sb=7.2e-07 sd=160n sca=7.37439 \
        scb=0.00450456 scc=4.82709e-05 m=(1)
mn10 (\8\:SEb \7\:SE \12\:VSS VSS) g45n1hvt w=(1.45e-07) l=4.5e-08 nf=1 \
        as=6.525e-14 ad=3.263e-14 ps=1.19e-06 pd=7.4e-07 nrd=1.16667 \
        nrs=1.16667 sa=1.73e-06 sb=2.25e-07 sd=160n sca=7.37439 \
        scb=0.00450456 scc=4.82709e-05 m=(1)
mp56 (\5\:qint \7\:qbint \26\:VDD VDD) g45p1hvt w=(2.15e-07) l=4.5e-08 \
        nf=1 as=7.142e-14 ad=3.01e-14 ps=1.52e-06 pd=7.1e-07 nrd=1.16667 \
        nrs=1.16667 sa=3.7e-07 sb=1.4e-07 sd=160n sca=47.1852 \
        scb=0.0292558 scc=0.00588561 m=(1)
mp20 (\15\:CKb \1\:CK \24\:VDD VDD) g45p1hvt w=(2.15e-07) l=4.5e-08 nf=1 \
        as=6.965e-14 ad=3.87e-14 ps=1.2e-06 pd=7.9e-07 nrd=1.16667 \
        nrs=1.16667 sa=3.95e-07 sb=1.8e-07 sd=160n sca=28.4541 \
        scb=0.0241553 scc=0.00347654 m=(1)
mp46 (\11\:qbint \3\:n30 \22\:VDD VDD) g45p1hvt w=(2.15e-07) l=4.5e-08 \
        nf=1 as=5.39e-14 ad=3.44e-14 ps=1.73e-06 pd=7.5e-07 nrd=1.16667 \
        nrs=1.16667 sa=1e-07 sb=1.855e-06 sd=160n sca=29.9075 \
        scb=0.0247057 scc=0.00372713 m=(1)
mp45 (\11\:qbint \3\:RN \20\:VDD VDD) g45p1hvt w=(2.15e-07) l=4.5e-08 \
        nf=1 as=1.049e-13 ad=3.44e-14 ps=1.83e-06 pd=7.5e-07 nrd=1.16667 \
        nrs=1.16667 sa=3.05e-07 sb=1.65e-06 sd=160n sca=29.9075 \
        scb=0.0247057 scc=0.00372713 m=(1)
mp50 (n8 \8\:qbint \20\:VDD VDD) g45p1hvt w=(2.15e-07) l=4.5e-08 nf=1 \
        as=1.049e-13 ad=3.978e-14 ps=1.83e-06 pd=8e-07 nrd=1.16667 \
        nrs=1.16667 sa=5.7e-07 sb=1.385e-06 sd=160n sca=29.9075 \
        scb=0.0247057 scc=0.00372713 m=(1)
mp51 (\7\:n30 \3\:Ckbb n8 VDD) g45p1hvt w=(2.15e-07) l=4.5e-08 nf=1 \
        as=3.978e-14 ad=5.483e-14 ps=8e-07 pd=9.4e-07 nrd=1.16667 \
        nrs=1.16667 sa=8e-07 sb=1.155e-06 sd=160n sca=29.9075 \
        scb=0.0247057 scc=0.00372713 m=(1)
mp40 (\7\:n30 \3\:CKb \8\:mout VDD) g45p1hvt w=(2.15e-07) l=4.5e-08 nf=1 \
        as=5.16e-14 ad=5.483e-14 ps=9.1e-07 pd=9.4e-07 nrd=1.16667 \
        nrs=1.16667 sa=1.1e-06 sb=8.55e-07 sd=160n sca=29.9075 \
        scb=0.0247057 scc=0.00372713 m=(1)
mp30 (\8\:mout \3\:n20 \18\:VDD VDD) g45p1hvt w=(2.15e-07) l=4.5e-08 \
        nf=1 as=1.049e-13 ad=5.16e-14 ps=1.83e-06 pd=9.1e-07 nrd=1.16667 \
        nrs=1.16667 sa=1.385e-06 sb=5.7e-07 sd=160n sca=29.9075 \
        scb=0.0247057 scc=0.00372713 m=(1)
mp35 (\3\:n6 \6\:RN \18\:VDD VDD) g45p1hvt w=(2.15e-07) l=4.5e-08 nf=1 \
        as=1.049e-13 ad=3.44e-14 ps=1.83e-06 pd=7.5e-07 nrd=1.16667 \
        nrs=1.16667 sa=1.65e-06 sb=3.05e-07 sd=160n sca=29.9075 \
        scb=0.0247057 scc=0.00372713 m=(1)
mp36 (\3\:n6 mout \16\:VDD VDD) g45p1hvt w=(2.15e-07) l=4.5e-08 nf=1 \
        as=4.59e-14 ad=3.44e-14 ps=1.41e-06 pd=7.5e-07 nrd=1.16667 \
        nrs=1.16667 sa=1.855e-06 sb=1e-07 sd=160n sca=29.9075 \
        scb=0.0247057 scc=0.00372713 m=(1)
mp37 (\7\:n20 \6\:CKb n6 VDD) g45p1hvt w=(2.15e-07) l=4.5e-08 nf=1 \
        as=3.01e-14 ad=3.44e-14 ps=7.1e-07 pd=7.5e-07 nrd=1.16667 \
        nrs=1.16667 sa=1.4e-07 sb=3.45e-07 sd=160n sca=45.7906 \
        scb=0.0283307 scc=0.00588417 m=(1)
mp25 (\7\:n20 \7\:Ckbb \4\:Db VDD) g45p1hvt w=(2.15e-07) l=4.5e-08 nf=1 \
        as=3.01e-14 ad=3.44e-14 ps=7.1e-07 pd=7.5e-07 nrd=1.16667 \
        nrs=1.16667 sa=3.45e-07 sb=1.4e-07 sd=160n sca=45.7906 \
        scb=0.0283307 scc=0.00588417 m=(1)
mp21 (\13\:Ckbb \9\:CKb \14\:VDD VDD) g45p1hvt w=(2.15e-07) l=4.5e-08 \
        nf=1 as=6.91e-14 ad=3.01e-14 ps=1.81e-06 pd=7.1e-07 nrd=1.16667 \
        nrs=1.16667 sa=1.4e-07 sb=1.54e-06 sd=160n sca=21.1782 \
        scb=0.0203295 scc=0.00208843 m=(1)
mp11 (n2 \1\:D \14\:VDD VDD) g45p1hvt w=(2.15e-07) l=4.5e-08 nf=1 \
        as=6.91e-14 ad=5.697e-14 ps=1.81e-06 pd=9.6e-07 nrd=1.16667 \
        nrs=1.16667 sa=3.65e-07 sb=1.315e-06 sd=160n sca=21.1782 \
        scb=0.0203295 scc=0.00208843 m=(1)
mp12 (\8\:Db \1\:SE n2 VDD) g45p1hvt w=(2.15e-07) l=4.5e-08 nf=1 \
        as=5.697e-14 ad=3.44e-14 ps=9.6e-07 pd=7.5e-07 nrd=1.16667 \
        nrs=1.16667 sa=6.75e-07 sb=1.005e-06 sd=160n sca=21.1782 \
        scb=0.0203295 scc=0.00208843 m=(1)
mp14 (\8\:Db SEb n4 VDD) g45p1hvt w=(2.15e-07) l=4.5e-08 nf=1 as=2.58e-14 \
        ad=3.44e-14 ps=6.7e-07 pd=7.5e-07 nrd=1.16667 nrs=1.16667 \
        sa=8.8e-07 sb=8e-07 sd=160n sca=21.1782 scb=0.0203295 \
        scc=0.00208843 m=(1)
mp13 (n4 \1\:SI \1\:VDD VDD) g45p1hvt w=(2.15e-07) l=4.5e-08 nf=1 \
        as=9.675e-14 ad=2.58e-14 ps=1.33e-06 pd=6.7e-07 nrd=1.16667 \
        nrs=1.16667 sa=1.045e-06 sb=6.35e-07 sd=160n sca=21.4774 \
        scb=0.0204117 scc=0.00208844 m=(1)
mp10 (\4\:SEb \5\:SE \1\:VDD VDD) g45p1hvt w=(2.15e-07) l=4.5e-08 nf=1 \
        as=9.675e-14 ad=3.01e-14 ps=1.33e-06 pd=7.1e-07 nrd=1.16667 \
        nrs=1.16667 sa=1.54e-06 sb=1.4e-07 sd=160n sca=26.5704 \
        scb=0.0277882 scc=0.00223218 m=(1)
ends SDFFRX1
// End of subcircuit definition.
