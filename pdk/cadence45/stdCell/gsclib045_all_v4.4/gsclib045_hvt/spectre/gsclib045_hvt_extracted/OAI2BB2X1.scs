// Generated for: spectre (May  1 09:19:11 2013 )
// Library name: gsclib045_hvt
// Cell name: OAI2BB2X1
// View name: extracted

simulator lang=spectre

subckt OAI2BB2X1 A0N A1N B0 B1 VDD VSS Y
mp1 (\6\:n1 \1\:A1N \9\:VDD VDD) g45p1hvt w=(2.15e-07) l=4.5e-08 nf=1 \
        as=3.44e-14 ad=3.655e-14 ps=7.5e-07 pd=7.7e-07 nrd=1.16667 \
        nrs=1.16667 sa=1.7e-07 sb=3.45e-07 sd=160n sca=14.4258 \
        scb=0.0129222 scc=0.000259662 m=(1)
mp0 (\6\:n0 \3\:A0N \9\:VDD VDD) g45p1hvt w=(2.15e-07) l=4.5e-08 nf=1 \
        as=3.44e-14 ad=3.01e-14 ps=7.5e-07 pd=7.1e-07 nrd=1.16667 \
        nrs=1.16667 sa=3.75e-07 sb=1.4e-07 sd=160n sca=12.5073 \
        scb=0.0103104 scc=0.000239765 m=(1)
C1 (B1 VSS) capacitor c=1.12677e-16
C2 (Y VSS) capacitor c=4.36652e-17
C3 (A0N VSS) capacitor c=4.70497e-17
C4 (B0 VSS) capacitor c=4.00323e-17
C5 (VDD VSS) capacitor c=1.33919e-16
C6 (A1N VSS) capacitor c=4.49848e-17
C7 (n1 VSS) capacitor c=5.95779e-17
C8 (n0 VSS) capacitor c=4.0585e-17
C9 (n4 VSS) capacitor c=6.61756e-17
C10 (n2 VSS) capacitor c=6.28521e-18
C11 (n3 VSS) capacitor c=9.49141e-18
C12 (\3\:B0 VSS) capacitor c=3.98587e-17
C13 (\3\:B1 VSS) capacitor c=5.21256e-17
C14 (\3\:A0N VSS) capacitor c=2.91637e-17
C15 (\1\:A1N VSS) capacitor c=3.57365e-17
C16 (\1\:B0 VSS) capacitor c=3.83905e-17
C17 (\1\:B1 VSS) capacitor c=3.88583e-17
C18 (\3\:n1 VSS) capacitor c=3.87969e-17
C19 (\3\:n0 VSS) capacitor c=4.50396e-17
C20 (\1\:A0N VSS) capacitor c=5.01883e-17
C21 (\3\:A1N VSS) capacitor c=3.72157e-17
C22 (\4\:B0 VSS) capacitor c=1.37945e-17
C23 (\2\:B1 VSS) capacitor c=4.8319e-17
C24 (\2\:n1 VSS) capacitor c=4.3287e-17
C25 (\2\:n0 VSS) capacitor c=3.1492e-17
C26 (\2\:A0N VSS) capacitor c=3.90331e-17
C27 (\2\:A1N VSS) capacitor c=3.69735e-17
C28 (\1\:VDD VSS) capacitor c=6.78967e-17
C29 (\3\:Y VSS) capacitor c=1.10733e-16
C30 (\7\:VDD VSS) capacitor c=7.11652e-17
C31 (\6\:n0 VSS) capacitor c=7.72622e-17
C32 (\9\:VDD VSS) capacitor c=3.39728e-17
C33 (\6\:n1 VSS) capacitor c=5.73099e-17
C34 (\5\:n4 VSS) capacitor c=5.83422e-17
C35 (\1\:Y VSS) capacitor c=1.35288e-16
C36 (\3\:n4 VSS) capacitor c=1.04578e-16
C37 (\8\:n0 VSS) capacitor c=6.18229e-17
C38 (\8\:n1 VSS) capacitor c=1.60949e-17
C39 (\2\:B0 VSS) capacitor c=2.19162e-17
C40 (\4\:A1N VSS) capacitor c=6.95361e-17
C41 (\4\:A0N VSS) capacitor c=6.73028e-17
C42 (\4\:n0 VSS) capacitor c=5.09774e-17
C43 (\5\:n0 VSS) capacitor c=7.69939e-17
C44 (\4\:n1 VSS) capacitor c=1.98636e-16
C45 (\5\:n1 VSS) capacitor c=2.23569e-16
C46 (\5\:B0 VSS) capacitor c=4.64126e-17
C47 (\3\:VDD VSS) capacitor c=2.77216e-17
C48 (\5\:VDD VSS) capacitor c=1.12701e-17
C49 (\6\:VDD VSS) capacitor c=1.7844e-17
Rk22 (\3\:VSS VSS) resistor r=0.2377 c=0
Rk21 (\2\:VSS \3\:VSS) resistor r=0.326 c=0
Rk23 (\3\:VSS \5\:VSS) resistor r=0.3132 c=0
Rk24 (\5\:VSS \7\:VSS) resistor r=0.3855 c=0
Rk9 (\4\:B1 B1) resistor r=0.002999 c=0
Rk11 (\4\:Y Y) resistor r=0.162 c=0
Rk10 (\2\:Y \4\:Y) resistor r=0.8246 c=0
Rk2 (\4\:A0N A0N) resistor r=0.00989 c=0
Rk14 (B0 \5\:B0) resistor r=0.1009 c=0
Rk15 (\2\:VDD \3\:VDD) resistor r=0.8178 c=0
Rk16 (\3\:VDD \5\:VDD) resistor r=0.05245 c=0
Rk18 (\6\:VDD VDD) resistor r=0.2252 c=0
Rk17 (\5\:VDD \6\:VDD) resistor r=0.3257 c=0
Rk19 (\3\:VDD \8\:VDD) resistor r=0.3795 c=0
Rk20 (\6\:VDD \10\:VDD) resistor r=0.2814 c=0
Rk1 (A1N \4\:A1N) resistor r=0.1066 c=0
Rk6 (\4\:n1 \5\:n1) resistor r=1.4576 c=0
Rk7 (\5\:n1 \7\:n1) resistor r=0.6195 c=0
Rk8 (\5\:n1 \9\:n1) resistor r=0.09247 c=0
Rk3 (\4\:n0 \5\:n0) resistor r=0.2654 c=0
Rk4 (\5\:n0 \7\:n0) resistor r=0.5092 c=0
Rk5 (\5\:n0 \9\:n0) resistor r=0.2704 c=0
Rk12 (\2\:n4 \4\:n4) resistor r=0.3145 c=0
Rk13 (\4\:n4 \6\:n4) resistor r=0.4324 c=0
Rl10 (\2\:B1 \3\:B1) resistor r=87.6944 c=0
Rl9 (\1\:B1 \2\:B1) resistor r=45.3867 c=0
Rl4 (\2\:A0N \3\:A0N) resistor r=29.9451 c=0
Rl3 (\1\:A0N \2\:A0N) resistor r=148.077 c=0
Rl12 (\2\:B0 \3\:B0) resistor r=63.4394 c=0
Rl11 (\1\:B0 \2\:B0) resistor r=99.9628 c=0
Rl13 (\2\:B0 \4\:B0) resistor r=23.4664 c=0
Rl1 (\1\:A1N \2\:A1N) resistor r=77.6148 c=0
Rl2 (\2\:A1N \3\:A1N) resistor r=98.7687 c=0
Rl7 (n1 \2\:n1) resistor r=102.615 c=0
Rl8 (\2\:n1 \3\:n1) resistor r=33.3841 c=0
Rl5 (n0 \2\:n0) resistor r=39.6174 c=0
Rl6 (\2\:n0 \3\:n0) resistor r=93.4636 c=0
Rz8 (\1\:VSS \2\:VSS) resistor r=75 c=0
Rz9 (\6\:VSS \7\:VSS) resistor r=75 c=0
Rz3 (\1\:Y \2\:Y) resistor r=75 c=0
Rz2 (\8\:n1 \9\:n1) resistor r=75 c=0
Rz1 (\8\:n0 \9\:n0) resistor r=75 c=0
Rz4 (n4 \2\:n4) resistor r=75 c=0
Rz5 (\3\:n4 \4\:n4) resistor r=75 c=0
Rz6 (\5\:n4 \6\:n4) resistor r=75 c=0
Ry3 (\3\:Y \4\:Y) resistor r=62 c=0
Ry4 (\1\:VDD \2\:VDD) resistor r=31 c=0
Ry5 (\7\:VDD \8\:VDD) resistor r=20.6667 c=0
Ry6 (\9\:VDD \10\:VDD) resistor r=62 c=0
Ry2 (\6\:n1 \7\:n1) resistor r=62 c=0
Ry1 (\6\:n0 \7\:n0) resistor r=62 c=0
Rx5 (\2\:B1 \4\:B1) resistor r=45 c=0
Rx2 (\2\:A0N \4\:A0N) resistor r=45 c=0
Rx6 (\4\:B0 \5\:B0) resistor r=45 c=0
Rx1 (\2\:A1N \4\:A1N) resistor r=45 c=0
Rx4 (\2\:n1 \4\:n1) resistor r=45 c=0
Rx3 (\2\:n0 \4\:n0) resistor r=45 c=0
mn1 (\8\:n1 \3\:A1N \1\:VSS VSS) g45n1hvt w=(1.45e-07) l=4.5e-08 nf=1 \
        as=3.175e-14 ad=2.03e-14 ps=7.3e-07 pd=5.7e-07 nrd=1.16667 \
        nrs=1.16667 sa=1.4e-07 sb=4.85e-07 sd=160n sca=13.9854 \
        scb=0.014728 scc=0.000819645 m=(1)
mn0 (\8\:n0 \1\:A0N \1\:VSS VSS) g45n1hvt w=(1.45e-07) l=4.5e-08 nf=1 \
        as=3.175e-14 ad=3.263e-14 ps=7.3e-07 pd=7.4e-07 nrd=1.16667 \
        nrs=1.16667 sa=4e-07 sb=2.25e-07 sd=160n sca=13.9854 scb=0.014728 \
        scc=0.000819645 m=(1)
mn2 (n4 \3\:n0 \6\:VSS VSS) g45n1hvt w=(2.6e-07) l=4.5e-08 nf=1 \
        as=4.16e-14 ad=3.64e-14 ps=8.4e-07 pd=8e-07 nrd=1.16667 \
        nrs=1.16667 sa=1.4e-07 sb=8e-07 sd=160n sca=8.22858 scb=0.00610564 \
        scc=0.00012768 m=(1)
mn3 (\3\:n4 \3\:n1 \6\:VSS VSS) g45n1hvt w=(2.6e-07) l=4.5e-08 nf=1 \
        as=4.16e-14 ad=4.55e-14 ps=8.4e-07 pd=8.7e-07 nrd=1.16667 \
        nrs=1.16667 sa=3.45e-07 sb=5.95e-07 sd=160n sca=8.22858 \
        scb=0.00610564 scc=0.00012768 m=(1)
mn5 (\1\:Y \1\:B1 \3\:n4 VSS) g45n1hvt w=(2.6e-07) l=4.5e-08 nf=1 \
        as=4.55e-14 ad=4.94e-14 ps=8.7e-07 pd=9e-07 nrd=1.16667 \
        nrs=1.16667 sa=5.65e-07 sb=3.75e-07 sd=160n sca=8.22858 \
        scb=0.00610564 scc=0.00012768 m=(1)
mn4 (\1\:Y \1\:B0 \5\:n4 VSS) g45n1hvt w=(2.6e-07) l=4.5e-08 nf=1 \
        as=3.64e-14 ad=4.94e-14 ps=8e-07 pd=9e-07 nrd=1.16667 nrs=1.16667 \
        sa=8e-07 sb=1.4e-07 sd=160n sca=8.22858 scb=0.00610564 \
        scc=0.00012768 m=(1)
mp2 (n2 n0 \7\:VDD VDD) g45p1hvt w=(3.9e-07) l=4.5e-08 nf=1 as=7.8e-14 \
        ad=6.24e-14 ps=1.18e-06 pd=1.1e-06 nrd=1.16667 nrs=1.16667 \
        sa=2e-07 sb=8e-07 sd=160n sca=23.3582 scb=0.018284 scc=0.00243236 \
        m=(1)
mp3 (\3\:Y n1 n2 VDD) g45p1hvt w=(3.9e-07) l=4.5e-08 nf=1 as=6.24e-14 \
        ad=6.24e-14 ps=1.1e-06 pd=1.1e-06 nrd=1.16667 nrs=1.16667 \
        sa=4.05e-07 sb=5.95e-07 sd=160n sca=23.9563 scb=0.0185363 \
        scc=0.00243248 m=(1)
mp5 (\3\:Y \3\:B1 n3 VDD) g45p1hvt w=(3.9e-07) l=4.5e-08 nf=1 \
        as=6.825e-14 ad=6.24e-14 ps=1.13e-06 pd=1.1e-06 nrd=1.16667 \
        nrs=1.16667 sa=6.1e-07 sb=3.9e-07 sd=160n sca=25.2941 \
        scb=0.0199646 scc=0.00243758 m=(1)
mp4 (n3 \3\:B0 \1\:VDD VDD) g45p1hvt w=(3.9e-07) l=4.5e-08 nf=1 \
        as=6.63e-14 ad=6.825e-14 ps=1.12e-06 pd=1.13e-06 nrd=1.16667 \
        nrs=1.16667 sa=8.3e-07 sb=1.7e-07 sd=160n sca=29.982 scb=0.0279319 \
        scc=0.00269613 m=(1)
ends OAI2BB2X1
// End of subcircuit definition.
