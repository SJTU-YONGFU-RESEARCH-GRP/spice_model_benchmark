// Generated for: spectre (May  1 09:19:29 2013 )
// Library name: gsclib045_hvt
// Cell name: OR2X1
// View name: extracted

simulator lang=spectre

subckt OR2X1 A B VDD VSS Y
mp1 (\6\:n0 \1\:B n1 VDD) g45p1hvt w=(2.15e-07) l=4.5e-08 nf=1 \
        as=1.29e-14 ad=3.01e-14 ps=5.5e-07 pd=7.1e-07 nrd=1.16667 \
        nrs=1.16667 sa=1.4e-07 sb=4.8e-07 sd=160n sca=56.6055 \
        scb=0.0430318 scc=0.00645527 m=(1)
mp0 (n1 \3\:A \1\:VDD VDD) g45p1hvt w=(2.15e-07) l=4.5e-08 nf=1 \
        as=6.535e-14 ad=1.29e-14 ps=1.16e-06 pd=5.5e-07 nrd=1.16667 \
        nrs=1.16667 sa=2.45e-07 sb=3.75e-07 sd=160n sca=53.5433 \
        scb=0.0379171 scc=0.00600127 m=(1)
C1 (A VSS) capacitor c=7.17933e-17
C2 (VDD VSS) capacitor c=4.53937e-17
C3 (B VSS) capacitor c=2.99567e-17
C4 (Y VSS) capacitor c=4.7365e-17
C5 (n0 VSS) capacitor c=4.43431e-17
C6 (n1 VSS) capacitor c=9.48821e-19
C7 (\3\:A VSS) capacitor c=5.37917e-17
C8 (\1\:B VSS) capacitor c=5.70167e-17
C9 (\3\:n0 VSS) capacitor c=3.93729e-17
C10 (\1\:A VSS) capacitor c=3.89545e-17
C11 (\4\:B VSS) capacitor c=2.78982e-17
C12 (\2\:n0 VSS) capacitor c=3.60103e-17
C13 (\2\:A VSS) capacitor c=4.95308e-17
C14 (\3\:B VSS) capacitor c=1.57766e-17
C15 (\1\:Y VSS) capacitor c=3.49646e-17
C16 (\1\:VDD VSS) capacitor c=8.26809e-17
C17 (\6\:n0 VSS) capacitor c=6.87481e-17
C18 (\3\:Y VSS) capacitor c=4.8217e-17
C19 (\8\:n0 VSS) capacitor c=2.47413e-17
C20 (\2\:B VSS) capacitor c=2.48493e-17
C21 (\5\:B VSS) capacitor c=3.8239e-17
C22 (\4\:A VSS) capacitor c=6.76579e-17
C23 (\4\:n0 VSS) capacitor c=7.58772e-17
C24 (\5\:n0 VSS) capacitor c=6.37949e-17
C25 (\4\:VDD VSS) capacitor c=1.84662e-17
Rk2 (\4\:A A) resistor r=0.1787 c=0
Rk9 (\4\:VDD VDD) resistor r=0.1503 c=0
Rk8 (\2\:VDD \4\:VDD) resistor r=0.4545 c=0
Rk1 (B \5\:B) resistor r=0.04349 c=0
Rk6 (\2\:Y Y) resistor r=0.1673 c=0
Rk7 (Y \4\:Y) resistor r=0.2251 c=0
Rk10 (\2\:VSS VSS) resistor r=0.1107 c=0
Rk11 (VSS \4\:VSS) resistor r=0.1511 c=0
Rk12 (\4\:VSS \6\:VSS) resistor r=0.393 c=0
Rk3 (\4\:n0 \5\:n0) resistor r=0.2897 c=0
Rk4 (\5\:n0 \7\:n0) resistor r=0.3221 c=0
Rk5 (\5\:n0 \9\:n0) resistor r=0.05545 c=0
Rl5 (\2\:A \3\:A) resistor r=26.098 c=0
Rl4 (\1\:A \2\:A) resistor r=43.4057 c=0
Rl1 (\1\:B \2\:B) resistor r=69.5391 c=0
Rl3 (\2\:B \4\:B) resistor r=25.6632 c=0
Rl2 (\2\:B \3\:B) resistor r=9.7447 c=0
Rl6 (n0 \2\:n0) resistor r=41.4826 c=0
Rl7 (\2\:n0 \3\:n0) resistor r=28.0211 c=0
Rz2 (\3\:Y \4\:Y) resistor r=37.5 c=0
Rz4 (\1\:VSS \2\:VSS) resistor r=75 c=0
Rz5 (\5\:VSS \6\:VSS) resistor r=75 c=0
Rz1 (\8\:n0 \9\:n0) resistor r=75 c=0
Ry3 (\1\:VDD \2\:VDD) resistor r=20.6667 c=0
Ry2 (\1\:Y \2\:Y) resistor r=20.6667 c=0
Ry1 (\6\:n0 \7\:n0) resistor r=62 c=0
Rx2 (\2\:A \4\:A) resistor r=45 c=0
Rx1 (\3\:B \5\:B) resistor r=45 c=0
Rx3 (\2\:n0 \4\:n0) resistor r=45 c=0
mn1 (\8\:n0 \4\:B \1\:VSS VSS) g45n1hvt w=(1.45e-07) l=4.5e-08 nf=1 \
        as=5.04e-14 ad=2.32e-14 ps=1.45e-06 pd=6.1e-07 nrd=1.16667 \
        nrs=1.16667 sa=1e-07 sb=5.5e-07 sd=160n sca=19.1673 scb=0.0200674 \
        scc=0.00182521 m=(1)
mn0 (\8\:n0 \1\:A \5\:VSS VSS) g45n1hvt w=(1.45e-07) l=4.5e-08 nf=1 \
        as=3.47e-14 ad=2.32e-14 ps=8.4e-07 pd=6.1e-07 nrd=1.16667 \
        nrs=1.16667 sa=3.05e-07 sb=3.45e-07 sd=160n sca=19.1673 \
        scb=0.0200674 scc=0.00182521 m=(1)
mn2 (\3\:Y \3\:n0 \5\:VSS VSS) g45n1hvt w=(2.6e-07) l=4.5e-08 nf=1 \
        as=3.47e-14 ad=3.64e-14 ps=8.4e-07 pd=8e-07 nrd=1.16667 \
        nrs=1.16667 sa=3.28654e-07 sb=1.4e-07 sd=160n sca=14.8545 \
        scb=0.0148797 scc=0.00110433 m=(1)
mp2 (\1\:Y n0 \1\:VDD VDD) g45p1hvt w=(3.9e-07) l=4.5e-08 nf=1 \
        as=6.535e-14 ad=5.46e-14 ps=1.16e-06 pd=1.06e-06 nrd=1.16667 \
        nrs=1.16667 sa=3.27436e-07 sb=1.4e-07 sd=160n sca=45.5228 \
        scb=0.0401019 scc=0.00476865 m=(1)
ends OR2X1
// End of subcircuit definition.
