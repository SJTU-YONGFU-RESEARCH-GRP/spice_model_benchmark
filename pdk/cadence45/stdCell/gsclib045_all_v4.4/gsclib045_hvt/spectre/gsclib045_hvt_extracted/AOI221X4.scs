// Generated for: spectre (May  1 09:12:45 2013 )
// Library name: gsclib045_hvt
// Cell name: AOI221X4
// View name: extracted

simulator lang=spectre

subckt AOI221X4 A0 A1 B0 B1 C0 VDD VSS Y
mp0_1__rcx (net107 A0 \3\:VDD VDD) g45p1hvt w=(3.9e-07) l=4.5e-08 nf=1 \
        as=5.85e-14 ad=6.24e-14 ps=1.08e-06 pd=1.1e-06 nrd=1.16667 \
        nrs=1.16667 sa=1.4e-07 sb=1.575e-06 sd=160n sca=22.272 \
        scb=0.025008 scc=0.00116916 m=(4)
mp1_1__rcx (net107 A1 \3\:VDD VDD) g45p1hvt w=(3.9e-07) l=4.5e-08 nf=1 \
        as=6.24e-14 ad=6.24e-14 ps=1.1e-06 pd=1.1e-06 nrd=1.16667 \
        nrs=1.16667 sa=3.45e-07 sb=1.37e-06 sd=160n sca=16.2105 \
        scb=0.0148596 scc=0.000661709 m=(4)
mp4_1__rcx (\15\:Y C0 net104 VDD) g45p1hvt w=(3.9e-07) l=4.5e-08 nf=1 \
        as=6.045e-14 ad=6.24e-14 ps=1.09e-06 pd=1.1e-06 nrd=1.16667 \
        nrs=1.16667 sa=1.78e-06 sb=7.55e-07 sd=160n sca=13.8524 \
        scb=0.01226 scc=0.000647526 m=(4)
mp2_1__rcx (net104 \1\:B0 \9\:net107 VDD) g45p1hvt w=(3.9e-07) l=4.5e-08 \
        nf=1 as=6.24e-14 ad=6.045e-14 ps=1.1e-06 pd=1.09e-06 nrd=1.16667 \
        nrs=1.16667 sa=1.4e-07 sb=2e-06 sd=160n sca=13.5671 scb=0.012183 \
        scc=0.000647513 m=(4)
mp3_1__rcx (net104 B1 \9\:net107 VDD) g45p1hvt w=(3.9e-07) l=4.5e-08 nf=1 \
        as=6.24e-14 ad=6.24e-14 ps=1.1e-06 pd=1.1e-06 nrd=1.16667 \
        nrs=1.16667 sa=3.45e-07 sb=2e-06 sd=160n sca=13.5671 scb=0.012183 \
        scc=0.000647513 m=(4)
C1 (C0 VSS) capacitor c=3.52023e-16
C2 (A0 VSS) capacitor c=6.20055e-16
C3 (B0 VSS) capacitor c=3.6344e-17
C4 (A1 VSS) capacitor c=3.89484e-16
C5 (Y VSS) capacitor c=1.2169e-17
C6 (VDD VSS) capacitor c=2.4899e-16
C7 (B1 VSS) capacitor c=4.37493e-16
C8 (12 VSS) capacitor c=1.7621e-18
C9 (13 VSS) capacitor c=1.7621e-18
C10 (14 VSS) capacitor c=1.7621e-18
C11 (15 VSS) capacitor c=4.45741e-18
C12 (16 VSS) capacitor c=5.16334e-18
C13 (17 VSS) capacitor c=3.10511e-18
C14 (18 VSS) capacitor c=2.07007e-18
C15 (net107 VSS) capacitor c=3.83599e-16
C16 (net104 VSS) capacitor c=5.0711e-16
C17 (\1\:B0 VSS) capacitor c=6.27719e-16
C18 (\12\:B0 VSS) capacitor c=5.64927e-17
C19 (\13\:B1 VSS) capacitor c=5.93777e-17
C20 (\12\:B1 VSS) capacitor c=4.11068e-17
C21 (\9\:B0 VSS) capacitor c=4.62908e-17
C22 (\8\:B0 VSS) capacitor c=2.63704e-17
C23 (\7\:B1 VSS) capacitor c=2.43835e-17
C24 (\5\:B1 VSS) capacitor c=3.78421e-17
C25 (\3\:B0 VSS) capacitor c=3.02809e-17
C26 (\12\:A0 VSS) capacitor c=5.18572e-17
C27 (\8\:A1 VSS) capacitor c=6.31997e-17
C28 (\11\:A1 VSS) capacitor c=5.57545e-17
C29 (\4\:A0 VSS) capacitor c=6.69895e-17
C30 (\6\:A0 VSS) capacitor c=4.79609e-17
C31 (\1\:A1 VSS) capacitor c=6.58025e-17
C32 (\4\:A1 VSS) capacitor c=4.62066e-17
C33 (\1\:A0 VSS) capacitor c=7.73589e-17
C34 (\15\:Y VSS) capacitor c=3.13177e-16
C35 (\9\:net107 VSS) capacitor c=3.99378e-16
C36 (\1\:VDD VSS) capacitor c=1.80239e-16
C37 (\1\:Y VSS) capacitor c=1.35437e-16
C38 (\3\:Y VSS) capacitor c=1.06678e-16
C39 (\5\:Y VSS) capacitor c=9.72968e-17
C40 (\8\:Y VSS) capacitor c=9.84804e-17
C41 (\10\:Y VSS) capacitor c=6.93512e-17
C42 (\2\:A1 VSS) capacitor c=3.18665e-17
C43 (\9\:A1 VSS) capacitor c=3.39458e-17
C44 (\4\:B1 VSS) capacitor c=1.91516e-17
C45 (\7\:Y VSS) capacitor c=5.67653e-17
C46 (\14\:Y VSS) capacitor c=2.13076e-16
C47 (\3\:VDD VSS) capacitor c=2.94022e-16
Rk15 (B0 \1\:B0) resistor r=0.1258 c=0
Rk20 (\1\:Y \4\:Y) resistor r=0.3923 c=0
Rk21 (\4\:Y \6\:Y) resistor r=0.5694 c=0
Rk22 (\6\:Y \7\:Y) resistor r=0.3618 c=0
Rk23 (\7\:Y \9\:Y) resistor r=0.3734 c=0
Rk24 (\9\:Y \11\:Y) resistor r=0.4686 c=0
Rk27 (\14\:Y Y) resistor r=0.003075 c=0
Rk28 (\14\:Y \15\:Y) resistor r=1.7225 c=0
Rk26 (\7\:Y \14\:Y) resistor r=0.1119 c=0
Rk61 (\3\:VDD VDD) resistor r=0.02964 c=0
Rk55 (\2\:VDD \3\:VDD) resistor r=0.8674 c=0
Rk44 (\1\:VSS \8\:VSS) resistor r=0.3463 c=0
Rk45 (\8\:VSS \9\:VSS) resistor r=0.5462 c=0
Rk46 (\9\:VSS \10\:VSS) resistor r=0.2606 c=0
Rk47 (\10\:VSS \11\:VSS) resistor r=0.04995 c=0
Rk49 (\12\:VSS VSS) resistor r=0.2052 c=0
Rk48 (\11\:VSS \12\:VSS) resistor r=0.2955 c=0
Rk51 (\8\:VSS \16\:VSS) resistor r=0.1993 c=0
Rk52 (\9\:VSS \18\:VSS) resistor r=0.1993 c=0
Rk53 (\11\:VSS \20\:VSS) resistor r=0.1993 c=0
Rk54 (\12\:VSS \22\:VSS) resistor r=0.2039 c=0
Rk11 (net107 \9\:net107) resistor r=0.4915 c=0
Rl20 (A0 \12\:A0) resistor r=41.4835 c=0
Rl9 (A0 \4\:A0) resistor r=85.3597 c=0
Rl10 (A0 \6\:A0) resistor r=39.5284 c=0
Rl1 (A0 \1\:A0) resistor r=140.362 c=0
Rl40 (\1\:B0 \12\:B0) resistor r=50.8402 c=0
Rl33 (\1\:B0 \9\:B0) resistor r=90.1033 c=0
Rl32 (\1\:B0 \8\:B0) resistor r=44.5244 c=0
Rl22 (\1\:B0 \3\:B0) resistor r=44.9225 c=0
Rl4 (\2\:A1 A1) resistor r=29.4415 c=0
Rl3 (\2\:A1 \1\:A1) resistor r=82.1768 c=0
Rl5 (\2\:A1 \4\:A1) resistor r=32.7557 c=0
Rl15 (\9\:A1 A1) resistor r=6.3032 c=0
Rl14 (\9\:A1 \8\:A1) resistor r=137.946 c=0
Rl16 (\9\:A1 \11\:A1) resistor r=88.5249 c=0
Rl38 (B1 \13\:B1) resistor r=151.642 c=0
Rl37 (B1 \12\:B1) resistor r=106.063 c=0
Rl25 (\4\:B1 B1) resistor r=67.233 c=0
Rl28 (\4\:B1 \7\:B1) resistor r=35.772 c=0
Rl26 (\4\:B1 \5\:B1) resistor r=100.426 c=0
Rz2 (\4\:Y \3\:Y) resistor r=75 c=0
Rz3 (\6\:Y \5\:Y) resistor r=75 c=0
Rz4 (\9\:Y \8\:Y) resistor r=75 c=0
Rz5 (\11\:Y \10\:Y) resistor r=75 c=0
Rz14 (\2\:VDD \1\:VDD) resistor r=6.8182 c=0
Rz15 (\3\:VDD \1\:VDD) resistor r=6.25 c=0
Rz10 (\16\:VSS \15\:VSS) resistor r=75 c=0
Rz11 (\18\:VSS \17\:VSS) resistor r=75 c=0
Rz12 (\20\:VSS \19\:VSS) resistor r=75 c=0
Rz13 (\22\:VSS \21\:VSS) resistor r=75 c=0
Ry18 (\1\:VSS \4\:VSS) resistor r=5.6364 c=0
Ry19 (\10\:VSS \4\:VSS) resistor r=5.1667 c=0
mn0_1__rcx (11 \1\:A0 \21\:VSS VSS) g45n1hvt w=(2.6e-07) l=4.5e-08 nf=1 \
        as=3.64e-14 ad=1.56e-14 ps=8e-07 pd=6.4e-07 nrd=1.16667 \
        nrs=1.16667 sa=1.4e-07 sb=2e-06 sd=160n sca=9.14564 scb=0.00759168 \
        scc=0.000213449 m=(1)
mn1_1__rcx (\10\:Y \4\:A1 11 VSS) g45n1hvt w=(2.6e-07) l=4.5e-08 nf=1 \
        as=1.56e-14 ad=4.16e-14 ps=6.4e-07 pd=8.4e-07 nrd=1.16667 \
        nrs=1.16667 sa=2.45e-07 sb=2e-06 sd=160n sca=9.14564 \
        scb=0.00759168 scc=0.000213449 m=(1)
mn1_2__rcx (\10\:Y \1\:A1 12 VSS) g45n1hvt w=(2.6e-07) l=4.5e-08 nf=1 \
        as=1.56e-14 ad=4.16e-14 ps=6.4e-07 pd=8.4e-07 nrd=1.16667 \
        nrs=1.16667 sa=4.5e-07 sb=2e-06 sd=160n sca=9.14564 scb=0.00759168 \
        scc=0.000213449 m=(1)
mn0_2__rcx (12 \6\:A0 \19\:VSS VSS) g45n1hvt w=(2.6e-07) l=4.5e-08 nf=1 \
        as=4.16e-14 ad=1.56e-14 ps=8.4e-07 pd=6.4e-07 nrd=1.16667 \
        nrs=1.16667 sa=5.55e-07 sb=2e-06 sd=160n sca=9.14564 \
        scb=0.00759168 scc=0.000213449 m=(1)
mn0_3__rcx (13 \4\:A0 \19\:VSS VSS) g45n1hvt w=(2.6e-07) l=4.5e-08 nf=1 \
        as=4.16e-14 ad=1.56e-14 ps=8.4e-07 pd=6.4e-07 nrd=1.16667 \
        nrs=1.16667 sa=7.6e-07 sb=2e-06 sd=160n sca=9.14564 scb=0.00759168 \
        scc=0.000213449 m=(1)
mn1_3__rcx (\8\:Y \11\:A1 13 VSS) g45n1hvt w=(2.6e-07) l=4.5e-08 nf=1 \
        as=1.56e-14 ad=4.16e-14 ps=6.4e-07 pd=8.4e-07 nrd=1.16667 \
        nrs=1.16667 sa=8.65e-07 sb=2e-06 sd=160n sca=9.14564 \
        scb=0.00759168 scc=0.000213449 m=(1)
mn1 (\8\:Y \8\:A1 14 VSS) g45n1hvt w=(2.6e-07) l=4.5e-08 nf=1 as=1.56e-14 \
        ad=4.16e-14 ps=6.4e-07 pd=8.4e-07 nrd=1.16667 nrs=1.16667 \
        sa=1.07e-06 sb=2e-06 sd=160n sca=9.14564 scb=0.00759168 \
        scc=0.000213449 m=(1)
mn0 (14 \12\:A0 \17\:VSS VSS) g45n1hvt w=(2.6e-07) l=4.5e-08 nf=1 \
        as=1.118e-13 ad=1.56e-14 ps=1.38e-06 pd=6.4e-07 nrd=1.16667 \
        nrs=1.16667 sa=1.175e-06 sb=2e-06 sd=160n sca=9.14564 \
        scb=0.00759168 scc=0.000213449 m=(1)
mn2_1__rcx (15 \3\:B0 \17\:VSS VSS) g45n1hvt w=(2.6e-07) l=4.5e-08 nf=1 \
        as=1.118e-13 ad=4.16e-14 ps=1.38e-06 pd=8.4e-07 nrd=1.16667 \
        nrs=1.16667 sa=1.65e-06 sb=2e-06 sd=160n sca=9.14564 \
        scb=0.00759168 scc=0.000213449 m=(1)
mn3_1__rcx (\5\:Y \5\:B1 15 VSS) g45n1hvt w=(2.6e-07) l=4.5e-08 nf=1 \
        as=4.16e-14 ad=4.16e-14 ps=8.4e-07 pd=8.4e-07 nrd=1.16667 \
        nrs=1.16667 sa=1.855e-06 sb=2e-06 sd=160n sca=9.14564 \
        scb=0.00759168 scc=0.000213449 m=(1)
mn3_2__rcx (\5\:Y \7\:B1 16 VSS) g45n1hvt w=(2.6e-07) l=4.5e-08 nf=1 \
        as=4.16e-14 ad=4.16e-14 ps=8.4e-07 pd=8.4e-07 nrd=1.16667 \
        nrs=1.16667 sa=2e-06 sb=1.885e-06 sd=160n sca=9.14564 \
        scb=0.00759168 scc=0.000213449 m=(1)
mn2_2__rcx (16 \8\:B0 \15\:VSS VSS) g45n1hvt w=(2.6e-07) l=4.5e-08 nf=1 \
        as=4.16e-14 ad=4.16e-14 ps=8.4e-07 pd=8.4e-07 nrd=1.16667 \
        nrs=1.16667 sa=2e-06 sb=1.68e-06 sd=160n sca=9.14564 \
        scb=0.00759168 scc=0.000213449 m=(1)
mn2_3__rcx (17 \9\:B0 \15\:VSS VSS) g45n1hvt w=(2.6e-07) l=4.5e-08 nf=1 \
        as=4.16e-14 ad=2.73e-14 ps=8.4e-07 pd=7.3e-07 nrd=1.16667 \
        nrs=1.16667 sa=2e-06 sb=1.475e-06 sd=160n sca=9.14564 \
        scb=0.00759168 scc=0.000213449 m=(1)
mn3_3__rcx (\3\:Y \12\:B1 17 VSS) g45n1hvt w=(2.6e-07) l=4.5e-08 nf=1 \
        as=2.73e-14 ad=4.16e-14 ps=7.3e-07 pd=8.4e-07 nrd=1.16667 \
        nrs=1.16667 sa=2e-06 sb=1.325e-06 sd=160n sca=9.14564 \
        scb=0.00759168 scc=0.000213449 m=(1)
mn3 (\3\:Y \13\:B1 18 VSS) g45n1hvt w=(2.6e-07) l=4.5e-08 nf=1 \
        as=1.82e-14 ad=4.16e-14 ps=6.6e-07 pd=8.4e-07 nrd=1.16667 \
        nrs=1.16667 sa=2e-06 sb=1.12e-06 sd=160n sca=9.14564 \
        scb=0.00759168 scc=0.000213449 m=(1)
mn2 (18 \12\:B0 \1\:VSS VSS) g45n1hvt w=(2.6e-07) l=4.5e-08 nf=1 \
        as=4.55e-14 ad=1.82e-14 ps=8.7e-07 pd=6.6e-07 nrd=1.16667 \
        nrs=1.16667 sa=2e-06 sb=1.005e-06 sd=160n sca=9.14564 \
        scb=0.00759168 scc=0.000213449 m=(1)
mn4_1__rcx (\1\:Y C0 \1\:VSS VSS) g45n1hvt w=(2.6e-07) l=4.5e-08 nf=1 \
        as=4.517e-14 ad=4.16e-14 ps=8.675e-07 pd=8.4e-07 nrd=1.16667 \
        nrs=1.16667 sa=2e-06 sb=7.85e-07 sd=160n sca=9.14564 \
        scb=0.00759168 scc=0.000213449 m=(4)
ends AOI221X4
// End of subcircuit definition.
