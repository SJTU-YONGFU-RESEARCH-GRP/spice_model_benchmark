// Generated for: spectre (May  1 09:15:04 2013 )
// Library name: gsclib045_hvt
// Cell name: DFFXL
// View name: extracted

simulator lang=spectre

subckt DFFXL CK D Q QN VDD VSS
mp57 (\4\:QN qint \15\:VDD VDD) g45p1hvt w=(2.15e-07) l=4.5e-08 nf=1 \
        as=3.44e-14 ad=3.01e-14 ps=7.5e-07 pd=7.1e-07 nrd=1.16667 \
        nrs=1.16667 sa=1.4e-07 sb=3.45e-07 sd=160n sca=49.1385 \
        scb=0.0321853 scc=0.00591609 m=(1)
mp56 (\4\:qint \6\:qbint \15\:VDD VDD) g45p1hvt w=(2.15e-07) l=4.5e-08 \
        nf=1 as=3.44e-14 ad=3.01e-14 ps=7.5e-07 pd=7.1e-07 nrd=1.16667 \
        nrs=1.16667 sa=3.45e-07 sb=1.4e-07 sd=160n sca=46.9517 \
        scb=0.029008 scc=0.00588492 m=(1)
mp55 (\1\:Q qbint \12\:VDD VDD) g45p1hvt w=(2.15e-07) l=4.5e-08 nf=1 \
        as=3.978e-14 ad=3.01e-14 ps=8e-07 pd=7.1e-07 nrd=1.16667 \
        nrs=1.16667 sa=1.4e-07 sb=3.7e-07 sd=160n sca=45.7906 \
        scb=0.0283307 scc=0.00588417 m=(1)
mp20 (\18\:CKb \1\:CK \12\:VDD VDD) g45p1hvt w=(2.15e-07) l=4.5e-08 nf=1 \
        as=3.978e-14 ad=3.01e-14 ps=8e-07 pd=7.1e-07 nrd=1.16667 \
        nrs=1.16667 sa=3.7e-07 sb=1.4e-07 sd=160n sca=45.7906 \
        scb=0.0283307 scc=0.00588417 m=(1)
mp45 (\15\:qbint n30 \10\:VDD VDD) g45p1hvt w=(2.15e-07) l=4.5e-08 nf=1 \
        as=7.43e-14 ad=3.01e-14 ps=1.32e-06 pd=7.1e-07 nrd=1.16667 \
        nrs=1.16667 sa=1.4e-07 sb=2e-06 sd=160n sca=10.2104 scb=0.00747301 \
        scc=8.05149e-05 m=(1)
mp50 (n36 \7\:qbint \10\:VDD VDD) g45p1hvt w=(2.15e-07) l=4.5e-08 nf=1 \
        as=7.43e-14 ad=3.44e-14 ps=1.32e-06 pd=7.5e-07 nrd=1.16667 \
        nrs=1.16667 sa=4.05e-07 sb=2e-06 sd=160n sca=10.2104 \
        scb=0.00747301 scc=8.05149e-05 m=(1)
mp51 (\9\:n30 CKbb n36 VDD) g45p1hvt w=(2.15e-07) l=4.5e-08 nf=1 \
        as=3.44e-14 ad=4.515e-14 ps=7.5e-07 pd=8.5e-07 nrd=1.16667 \
        nrs=1.16667 sa=6.1e-07 sb=1.88e-06 sd=160n sca=10.2104 \
        scb=0.00747301 scc=8.05149e-05 m=(1)
mp40 (\9\:n30 CKb \7\:mout VDD) g45p1hvt w=(2.15e-07) l=4.5e-08 nf=1 \
        as=6.45e-14 ad=4.515e-14 ps=1.03e-06 pd=8.5e-07 nrd=1.16667 \
        nrs=1.16667 sa=8.65e-07 sb=1.625e-06 sd=160n sca=10.2104 \
        scb=0.00747301 scc=8.05149e-05 m=(1)
mp30 (\7\:mout n20 \8\:VDD VDD) g45p1hvt w=(2.15e-07) l=4.5e-08 nf=1 \
        as=7.43e-14 ad=6.45e-14 ps=1.32e-06 pd=1.03e-06 nrd=1.16667 \
        nrs=1.16667 sa=1.21e-06 sb=1.28e-06 sd=160n sca=10.2104 \
        scb=0.00747301 scc=8.05149e-05 m=(1)
mp35 (n26 \4\:mout \8\:VDD VDD) g45p1hvt w=(2.15e-07) l=4.5e-08 nf=1 \
        as=7.43e-14 ad=2.58e-14 ps=1.32e-06 pd=6.7e-07 nrd=1.16667 \
        nrs=1.16667 sa=1.475e-06 sb=1.015e-06 sd=160n sca=10.2104 \
        scb=0.00747301 scc=8.05149e-05 m=(1)
mp36 (\4\:n20 \5\:CKb n26 VDD) g45p1hvt w=(2.15e-07) l=4.5e-08 nf=1 \
        as=2.58e-14 ad=3.44e-14 ps=6.7e-07 pd=7.5e-07 nrd=1.16667 \
        nrs=1.16667 sa=1.64e-06 sb=8.5e-07 sd=160n sca=10.3113 \
        scb=0.00749421 scc=8.05171e-05 m=(1)
mp26 (\4\:n20 \5\:CKbb n22 VDD) g45p1hvt w=(2.15e-07) l=4.5e-08 nf=1 \
        as=5.053e-14 ad=3.44e-14 ps=9e-07 pd=7.5e-07 nrd=1.16667 \
        nrs=1.16667 sa=1.845e-06 sb=6.45e-07 sd=160n sca=10.9525 \
        scb=0.00779426 scc=8.06839e-05 m=(1)
mp25 (n22 \1\:D \1\:VDD VDD) g45p1hvt w=(2.15e-07) l=4.5e-08 nf=1 \
        as=3.44e-14 ad=5.053e-14 ps=7.5e-07 pd=9e-07 nrd=1.16667 \
        nrs=1.16667 sa=2e-06 sb=3.65e-07 sd=160n sca=13.4702 scb=0.0111763 \
        scc=0.0001097 m=(1)
mp21 (\8\:CKbb \8\:CKb \1\:VDD VDD) g45p1hvt w=(2.15e-07) l=4.5e-08 nf=1 \
        as=3.44e-14 ad=3.44e-14 ps=7.5e-07 pd=7.5e-07 nrd=1.16667 \
        nrs=1.16667 sa=2e-06 sb=1.6e-07 sd=160n sca=21.8638 scb=0.0242315 \
        scc=0.00109598 m=(1)
C1 (D VSS) capacitor c=1.34698e-16
C2 (QN VSS) capacitor c=2.03706e-17
C3 (Q VSS) capacitor c=2.71174e-17
C4 (VDD VSS) capacitor c=2.93624e-16
C5 (CK VSS) capacitor c=4.52271e-17
C6 (qint VSS) capacitor c=2.9782e-17
C7 (qbint VSS) capacitor c=2.28165e-17
C8 (CKb VSS) capacitor c=2.1751e-17
C9 (n30 VSS) capacitor c=4.76274e-17
C10 (n35 VSS) capacitor c=6.99755e-18
C11 (mout VSS) capacitor c=4.25177e-17
C12 (CKbb VSS) capacitor c=3.95676e-17
C13 (n20 VSS) capacitor c=4.87301e-17
C14 (n25 VSS) capacitor c=1.70374e-18
C15 (n21 VSS) capacitor c=1.28589e-18
C16 (n36 VSS) capacitor c=2.02629e-18
C17 (n26 VSS) capacitor c=1.81666e-18
C18 (n22 VSS) capacitor c=2.87857e-18
C19 (\8\:CKb VSS) capacitor c=4.755e-17
C20 (\1\:D VSS) capacitor c=4.06208e-17
C21 (\5\:CKbb VSS) capacitor c=7.90554e-17
C22 (\5\:CKb VSS) capacitor c=4.18102e-17
C23 (\4\:mout VSS) capacitor c=7.89853e-17
C24 (\7\:qbint VSS) capacitor c=8.0823e-17
C25 (\1\:CK VSS) capacitor c=2.7879e-17
C26 (\6\:qbint VSS) capacitor c=2.50634e-17
C27 (\11\:CKb VSS) capacitor c=3.838e-17
C28 (\3\:D VSS) capacitor c=9.05842e-17
C29 (\6\:CKb VSS) capacitor c=6.6981e-17
C30 (\6\:CKbb VSS) capacitor c=7.99667e-17
C31 (\3\:n20 VSS) capacitor c=5.03173e-17
C32 (\3\:CKbb VSS) capacitor c=3.90482e-17
C33 (\3\:CKb VSS) capacitor c=6.99326e-17
C34 (\10\:qbint VSS) capacitor c=2.60709e-17
C35 (\3\:n30 VSS) capacitor c=4.25598e-17
C36 (\3\:CK VSS) capacitor c=2.2785e-17
C37 (\5\:qbint VSS) capacitor c=1.68913e-17
C38 (\4\:qbint VSS) capacitor c=2.36864e-17
C39 (\3\:qint VSS) capacitor c=2.78761e-17
C40 (\10\:CKb VSS) capacitor c=3.03183e-17
C41 (\2\:D VSS) capacitor c=7.67685e-17
C42 (\7\:CKb VSS) capacitor c=5.66111e-17
C43 (\7\:CKbb VSS) capacitor c=3.13385e-17
C44 (\4\:CKb VSS) capacitor c=4.83799e-17
C45 (\3\:mout VSS) capacitor c=2.97858e-17
C46 (\2\:n20 VSS) capacitor c=5.2618e-17
C47 (\2\:CKb VSS) capacitor c=8.66721e-17
C48 (\4\:CKbb VSS) capacitor c=3.50379e-17
C49 (\2\:CKbb VSS) capacitor c=5.5001e-17
C50 (\9\:qbint VSS) capacitor c=3.05954e-17
C51 (\4\:n30 VSS) capacitor c=2.83454e-17
C52 (\2\:CK VSS) capacitor c=2.02014e-17
C53 (\2\:qbint VSS) capacitor c=3.1155e-17
C54 (\2\:qint VSS) capacitor c=2.43969e-17
C55 (\8\:CKbb VSS) capacitor c=6.4966e-17
C56 (\1\:VDD VSS) capacitor c=5.25136e-17
C57 (\4\:n20 VSS) capacitor c=7.69281e-17
C58 (\8\:VDD VSS) capacitor c=2.46184e-17
C59 (\7\:mout VSS) capacitor c=7.29146e-17
C60 (\9\:n30 VSS) capacitor c=7.64854e-17
C61 (\10\:VDD VSS) capacitor c=2.36568e-17
C62 (\15\:qbint VSS) capacitor c=6.22773e-17
C63 (\18\:CKb VSS) capacitor c=1.58646e-16
C64 (\12\:VDD VSS) capacitor c=5.34649e-17
C65 (\1\:Q VSS) capacitor c=2.32957e-17
C66 (\4\:qint VSS) capacitor c=3.54716e-17
C67 (\15\:VDD VSS) capacitor c=4.34684e-17
C68 (\4\:QN VSS) capacitor c=3.673e-17
C69 (\3\:VDD VSS) capacitor c=9.05041e-17
C70 (\14\:CKbb VSS) capacitor c=1.41139e-17
C71 (\7\:n20 VSS) capacitor c=8.10363e-17
C72 (\9\:mout VSS) capacitor c=4.87788e-17
C73 (\5\:n30 VSS) capacitor c=7.52993e-17
C74 (\13\:qbint VSS) capacitor c=7.35002e-17
C75 (\20\:CKb VSS) capacitor c=7.49915e-17
C76 (\4\:Q VSS) capacitor c=8.672e-17
C77 (\8\:qint VSS) capacitor c=4.08796e-17
C78 (\1\:QN VSS) capacitor c=1.86453e-17
C79 (\3\:qbint VSS) capacitor c=2.91971e-17
C80 (\2\:n30 VSS) capacitor c=3.75823e-17
C81 (\8\:qbint VSS) capacitor c=4.56179e-17
C82 (\2\:mout VSS) capacitor c=4.69331e-17
C83 (\9\:CKb VSS) capacitor c=4.23203e-17
C84 (\3\:QN VSS) capacitor c=2.31195e-17
C85 (\6\:qint VSS) capacitor c=3.40345e-17
C86 (\7\:qint VSS) capacitor c=3.18161e-17
C87 (\3\:Q VSS) capacitor c=4.76271e-17
C88 (\4\:CK VSS) capacitor c=5.87935e-17
C89 (\11\:qbint VSS) capacitor c=4.03024e-17
C90 (\12\:qbint VSS) capacitor c=6.89486e-17
C91 (\17\:qbint VSS) capacitor c=1.22229e-16
C92 (\7\:n30 VSS) capacitor c=1.08692e-16
C93 (\8\:n30 VSS) capacitor c=3.39539e-17
C94 (\5\:mout VSS) capacitor c=4.70408e-17
C95 (\6\:mout VSS) capacitor c=6.8136e-17
C96 (\6\:n20 VSS) capacitor c=8.02564e-17
C97 (\9\:n20 VSS) capacitor c=4.85413e-17
C98 (\12\:CKb VSS) capacitor c=4.70783e-17
C99 (\13\:CKb VSS) capacitor c=6.34091e-17
C100 (\14\:CKb VSS) capacitor c=1.36381e-16
C101 (\15\:CKb VSS) capacitor c=3.95055e-17
C102 (\16\:CKb VSS) capacitor c=2.50409e-16
C103 (\17\:CKb VSS) capacitor c=5.19319e-17
C104 (\10\:CKbb VSS) capacitor c=1.23117e-16
C105 (\11\:CKbb VSS) capacitor c=2.18529e-16
C106 (\12\:CKbb VSS) capacitor c=1.64606e-16
C107 (\13\:CKbb VSS) capacitor c=5.97739e-17
C108 (\5\:VDD VSS) capacitor c=3.30199e-17
C109 (\6\:VDD VSS) capacitor c=5.82865e-17
C110 (\14\:VDD VSS) capacitor c=1.13019e-17
Rk24 (\4\:D D) resistor r=0.01595 c=0
Rk2 (\3\:QN QN) resistor r=0.04422 c=0
Rk1 (\2\:QN \3\:QN) resistor r=0.04806 c=0
Rk3 (\3\:QN \5\:QN) resistor r=0.2045 c=0
Rk8 (\3\:Q Q) resistor r=0.1133 c=0
Rk7 (\2\:Q \3\:Q) resistor r=0.04292 c=0
Rk9 (\3\:Q \5\:Q) resistor r=0.3038 c=0
Rk37 (\2\:VDD \4\:VDD) resistor r=0.5647 c=0
Rk38 (\4\:VDD \5\:VDD) resistor r=0.1042 c=0
Rk39 (\5\:VDD \6\:VDD) resistor r=0.5347 c=0
Rk40 (\6\:VDD \7\:VDD) resistor r=0.4611 c=0
Rk41 (\5\:VDD \9\:VDD) resistor r=0.04334 c=0
Rk42 (\6\:VDD \11\:VDD) resistor r=0.04334 c=0
Rk43 (\7\:VDD \13\:VDD) resistor r=0.4896 c=0
Rk46 (\14\:VDD VDD) resistor r=0.2128 c=0
Rk44 (\7\:VDD \14\:VDD) resistor r=0.3385 c=0
Rk45 (\14\:VDD \16\:VDD) resistor r=0.4203 c=0
Rk10 (CK \4\:CK) resistor r=0.1371 c=0
Rk47 (\2\:VSS \4\:VSS) resistor r=0.55 c=0
Rk48 (\4\:VSS \5\:VSS) resistor r=0.03995 c=0
Rk49 (\5\:VSS \6\:VSS) resistor r=0.6244 c=0
Rk50 (\6\:VSS \7\:VSS) resistor r=0.4389 c=0
Rk51 (\7\:VSS \8\:VSS) resistor r=0.03242 c=0
Rk53 (\9\:VSS VSS) resistor r=0.2128 c=0
Rk52 (\8\:VSS \9\:VSS) resistor r=0.3057 c=0
Rk54 (\5\:VSS \11\:VSS) resistor r=0.1257 c=0
Rk55 (\6\:VSS \13\:VSS) resistor r=0.2317 c=0
Rk56 (\8\:VSS \15\:VSS) resistor r=0.07428 c=0
Rk57 (\9\:VSS \17\:VSS) resistor r=0.3721 c=0
Rk4 (\5\:qint \6\:qint) resistor r=0.09998 c=0
Rk5 (\6\:qint \7\:qint) resistor r=0.1347 c=0
Rk6 (\6\:qint \9\:qint) resistor r=0.124 c=0
Rk11 (\11\:qbint \12\:qbint) resistor r=0.1344 c=0
Rk12 (\12\:qbint \14\:qbint) resistor r=0.2037 c=0
Rk13 (\12\:qbint \16\:qbint) resistor r=0.4439 c=0
Rk14 (\14\:qbint \17\:qbint) resistor r=0.773 c=0
Rk25 (\12\:CKb \13\:CKb) resistor r=0.2246 c=0
Rk26 (\13\:CKb \14\:CKb) resistor r=0.2437 c=0
Rk27 (\14\:CKb \15\:CKb) resistor r=0.1623 c=0
Rk28 (\14\:CKb \16\:CKb) resistor r=1.1478 c=0
Rk29 (\16\:CKb \17\:CKb) resistor r=0.2328 c=0
Rk30 (\16\:CKb \19\:CKb) resistor r=1.2308 c=0
Rk31 (\19\:CKb \21\:CKb) resistor r=0.5628 c=0
Rk15 (\6\:n30 \7\:n30) resistor r=0.5455 c=0
Rk16 (\7\:n30 \8\:n30) resistor r=0.1057 c=0
Rk17 (\7\:n30 \10\:n30) resistor r=0.5067 c=0
Rk18 (\5\:mout \6\:mout) resistor r=0.1675 c=0
Rk19 (\6\:mout \8\:mout) resistor r=0.4479 c=0
Rk20 (\6\:mout \10\:mout) resistor r=0.1703 c=0
Rk32 (\9\:CKbb \10\:CKbb) resistor r=0.5433 c=0
Rk33 (\10\:CKbb \11\:CKbb) resistor r=0.7331 c=0
Rk34 (\11\:CKbb \12\:CKbb) resistor r=1.1779 c=0
Rk35 (\12\:CKbb \13\:CKbb) resistor r=0.4168 c=0
Rk36 (\10\:CKbb \15\:CKbb) resistor r=0.06511 c=0
Rk21 (\5\:n20 \6\:n20) resistor r=0.4732 c=0
Rk22 (\6\:n20 \8\:n20) resistor r=0.4662 c=0
Rk23 (\6\:n20 \9\:n20) resistor r=0.188 c=0
Rl29 (\1\:D \2\:D) resistor r=103.365 c=0
Rl30 (\2\:D \3\:D) resistor r=158.414 c=0
Rl8 (\1\:CK \2\:CK) resistor r=39.6174 c=0
Rl9 (\2\:CK \3\:CK) resistor r=24.2328 c=0
Rl1 (qint \2\:qint) resistor r=28.079 c=0
Rl2 (\2\:qint \3\:qint) resistor r=35.7713 c=0
Rl3 (qbint \2\:qbint) resistor r=33.4251 c=0
Rl6 (\2\:qbint \5\:qbint) resistor r=24.7951 c=0
Rl7 (\3\:qbint \6\:qbint) resistor r=33.8489 c=0
Rl5 (\3\:qbint \4\:qbint) resistor r=55.0028 c=0
Rl4 (\2\:qbint \3\:qbint) resistor r=160.453 c=0
Rl13 (\7\:qbint \8\:qbint) resistor r=226.203 c=0
Rl15 (\8\:qbint \10\:qbint) resistor r=47.791 c=0
Rl14 (\8\:qbint \9\:qbint) resistor r=9.1017 c=0
Rl28 (\6\:CKb \7\:CKb) resistor r=74.2328 c=0
Rl25 (\4\:CKb \5\:CKb) resistor r=64.5404 c=0
Rl18 (CKb \2\:CKb) resistor r=24.2328 c=0
Rl19 (\2\:CKb \3\:CKb) resistor r=291.427 c=0
Rl31 (\8\:CKb \9\:CKb) resistor r=177.726 c=0
Rl33 (\9\:CKb \11\:CKb) resistor r=95.0334 c=0
Rl32 (\9\:CKb \10\:CKb) resistor r=2.4801 c=0
Rl10 (n30 \2\:n30) resistor r=131.606 c=0
Rl11 (\2\:n30 \3\:n30) resistor r=141.815 c=0
Rl12 (\2\:n30 \4\:n30) resistor r=7.6417 c=0
Rl24 (\2\:mout \4\:mout) resistor r=219.894 c=0
Rl22 (mout \2\:mout) resistor r=67.6161 c=0
Rl23 (\2\:mout \3\:mout) resistor r=15.3298 c=0
Rl26 (\5\:CKbb \6\:CKbb) resistor r=303.412 c=0
Rl27 (\6\:CKbb \7\:CKbb) resistor r=26.1559 c=0
Rl17 (\3\:CKbb \4\:CKbb) resistor r=62.6944 c=0
Rl16 (CKbb \2\:CKbb) resistor r=74.2328 c=0
Rl20 (n20 \2\:n20) resistor r=133.79 c=0
Rl21 (\2\:n20 \3\:n20) resistor r=116.483 c=0
Rz1 (\1\:QN \2\:QN) resistor r=75 c=0
Rz3 (\4\:Q \5\:Q) resistor r=75 c=0
Rz10 (\3\:VDD \4\:VDD) resistor r=7.5 c=0
Rz11 (\3\:VDD \7\:VDD) resistor r=6.25 c=0
Rz12 (\1\:VSS \2\:VSS) resistor r=75 c=0
Rz13 (\10\:VSS \11\:VSS) resistor r=75 c=0
Rz14 (\12\:VSS \13\:VSS) resistor r=75 c=0
Rz15 (\14\:VSS \15\:VSS) resistor r=75 c=0
Rz16 (\16\:VSS \17\:VSS) resistor r=75 c=0
Rz2 (\8\:qint \9\:qint) resistor r=75 c=0
Rz4 (\13\:qbint \14\:qbint) resistor r=75 c=0
Rz8 (\20\:CKb \21\:CKb) resistor r=75 c=0
Rz5 (\5\:n30 \6\:n30) resistor r=75 c=0
Rz6 (\9\:mout \10\:mout) resistor r=75 c=0
Rz9 (\14\:CKbb \15\:CKbb) resistor r=75 c=0
Rz7 (\7\:n20 \8\:n20) resistor r=75 c=0
Ry1 (\4\:QN \5\:QN) resistor r=62 c=0
Ry3 (\1\:Q \2\:Q) resistor r=62 c=0
Ry10 (\1\:VDD \2\:VDD) resistor r=62 c=0
Ry11 (\8\:VDD \9\:VDD) resistor r=62 c=0
Ry12 (\10\:VDD \11\:VDD) resistor r=62 c=0
Ry13 (\12\:VDD \13\:VDD) resistor r=62 c=0
Ry14 (\15\:VDD \16\:VDD) resistor r=62 c=0
Ry15 (\3\:VSS \4\:VSS) resistor r=6.2 c=0
Ry16 (\3\:VSS \7\:VSS) resistor r=5.1667 c=0
Ry2 (\4\:qint \5\:qint) resistor r=62 c=0
Ry4 (\15\:qbint \16\:qbint) resistor r=62 c=0
Ry8 (\18\:CKb \19\:CKb) resistor r=62 c=0
Ry5 (\9\:n30 \10\:n30) resistor r=62 c=0
Ry6 (\7\:mout \8\:mout) resistor r=62 c=0
Ry9 (\8\:CKbb \9\:CKbb) resistor r=62 c=0
Ry7 (\4\:n20 \5\:n20) resistor r=62 c=0
Rx8 (\2\:D \4\:D) resistor r=45 c=0
Rx2 (\2\:CK \4\:CK) resistor r=45 c=0
Rx1 (\2\:qint \7\:qint) resistor r=45 c=0
Rx3 (\9\:qbint \11\:qbint) resistor r=45 c=0
Rx4 (\2\:qbint \17\:qbint) resistor r=45 c=0
Rx9 (\10\:CKb \12\:CKb) resistor r=45 c=0
Rx10 (\7\:CKb \13\:CKb) resistor r=45 c=0
Rx11 (\4\:CKb \15\:CKb) resistor r=45 c=0
Rx12 (\2\:CKb \17\:CKb) resistor r=45 c=0
Rx5 (\4\:n30 \8\:n30) resistor r=45 c=0
Rx6 (\3\:mout \5\:mout) resistor r=45 c=0
Rx13 (\7\:CKbb \11\:CKbb) resistor r=45 c=0
Rx14 (\4\:CKbb \12\:CKbb) resistor r=45 c=0
Rx15 (\2\:CKbb \13\:CKbb) resistor r=45 c=0
Rx7 (\2\:n20 \9\:n20) resistor r=45 c=0
mn57 (\1\:QN \3\:qint \16\:VSS VSS) g45n1hvt w=(1.45e-07) l=4.5e-08 nf=1 \
        as=2.32e-14 ad=2.03e-14 ps=6.1e-07 pd=5.7e-07 nrd=1.16667 \
        nrs=1.16667 sa=1.4e-07 sb=3.45e-07 sd=160n sca=23.279 \
        scb=0.0230742 scc=0.00267719 m=(1)
mn56 (\8\:qint \4\:qbint \16\:VSS VSS) g45n1hvt w=(1.45e-07) l=4.5e-08 \
        nf=1 as=2.32e-14 ad=2.03e-14 ps=6.1e-07 pd=5.7e-07 nrd=1.16667 \
        nrs=1.16667 sa=3.45e-07 sb=1.4e-07 sd=160n sca=23.279 \
        scb=0.0230742 scc=0.00267719 m=(1)
mn55 (\4\:Q \5\:qbint \14\:VSS VSS) g45n1hvt w=(1.45e-07) l=4.5e-08 nf=1 \
        as=6.495e-14 ad=2.03e-14 ps=1.78e-06 pd=5.7e-07 nrd=1.16667 \
        nrs=1.16667 sa=1.4e-07 sb=5.4e-07 sd=160n sca=23.279 scb=0.0230742 \
        scc=0.00267719 m=(1)
mn20 (\20\:CKb \3\:CK \14\:VSS VSS) g45n1hvt w=(1.45e-07) l=4.5e-08 nf=1 \
        as=6.495e-14 ad=3.698e-14 ps=1.78e-06 pd=8e-07 nrd=1.16667 \
        nrs=1.16667 sa=4.25e-07 sb=2.55e-07 sd=160n sca=23.279 \
        scb=0.0230742 scc=0.00267719 m=(1)
mn45 (\13\:qbint \3\:n30 \12\:VSS VSS) g45n1hvt w=(1.45e-07) l=4.5e-08 \
        nf=1 as=2.973e-14 ad=2.03e-14 ps=7e-07 pd=5.7e-07 nrd=1.16667 \
        nrs=1.16667 sa=1.4e-07 sb=2e-06 sd=160n sca=8.15925 scb=0.00587019 \
        scc=8.94977e-05 m=(1)
mn50 (n35 \10\:qbint \12\:VSS VSS) g45n1hvt w=(1.45e-07) l=4.5e-08 nf=1 \
        as=2.973e-14 ad=3.407e-14 ps=7e-07 pd=7.6e-07 nrd=1.16667 \
        nrs=1.16667 sa=3.9e-07 sb=2e-06 sd=160n sca=8.15925 scb=0.00587019 \
        scc=8.94977e-05 m=(1)
mn51 (\5\:n30 \3\:CKb n35 VSS) g45n1hvt w=(1.45e-07) l=4.5e-08 nf=1 \
        as=3.407e-14 ad=2.32e-14 ps=7.6e-07 pd=6.1e-07 nrd=1.16667 \
        nrs=1.16667 sa=6.7e-07 sb=1.83e-06 sd=160n sca=8.15925 \
        scb=0.00587019 scc=8.94977e-05 m=(1)
mn40 (\5\:n30 \3\:CKbb \9\:mout VSS) g45n1hvt w=(1.45e-07) l=4.5e-08 nf=1 \
        as=4.64e-14 ad=2.32e-14 ps=9.3e-07 pd=6.1e-07 nrd=1.16667 \
        nrs=1.16667 sa=8.75e-07 sb=1.625e-06 sd=160n sca=8.15925 \
        scb=0.00587019 scc=8.94977e-05 m=(1)
mn30 (\9\:mout \3\:n20 \10\:VSS VSS) g45n1hvt w=(1.45e-07) l=4.5e-08 \
        nf=1 as=6.44e-14 ad=4.64e-14 ps=1.23e-06 pd=9.3e-07 nrd=1.16667 \
        nrs=1.16667 sa=1.24e-06 sb=1.26e-06 sd=160n sca=8.15925 \
        scb=0.00587019 scc=8.94977e-05 m=(1)
mn35 (n25 mout \10\:VSS VSS) g45n1hvt w=(1.45e-07) l=4.5e-08 nf=1 \
        as=6.44e-14 ad=1.813e-14 ps=1.23e-06 pd=5.4e-07 nrd=1.16667 \
        nrs=1.16667 sa=1.605e-06 sb=8.95e-07 sd=160n sca=8.15925 \
        scb=0.00587019 scc=8.94977e-05 m=(1)
mn36 (\7\:n20 \6\:CKbb n25 VSS) g45n1hvt w=(1.45e-07) l=4.5e-08 nf=1 \
        as=1.813e-14 ad=2.32e-14 ps=5.4e-07 pd=6.1e-07 nrd=1.16667 \
        nrs=1.16667 sa=1.775e-06 sb=7.25e-07 sd=160n sca=8.15925 \
        scb=0.00587019 scc=8.94977e-05 m=(1)
mn26 (\7\:n20 \6\:CKb n21 VSS) g45n1hvt w=(1.45e-07) l=4.5e-08 nf=1 \
        as=1.015e-14 ad=2.32e-14 ps=4.3e-07 pd=6.1e-07 nrd=1.16667 \
        nrs=1.16667 sa=1.98e-06 sb=5.2e-07 sd=160n sca=8.15925 \
        scb=0.00587019 scc=8.94977e-05 m=(1)
mn25 (n21 \3\:D \1\:VSS VSS) g45n1hvt w=(1.45e-07) l=4.5e-08 nf=1 \
        as=3.61e-14 ad=1.015e-14 ps=8e-07 pd=4.3e-07 nrd=1.16667 \
        nrs=1.16667 sa=2e-06 sb=4.05e-07 sd=160n sca=8.15925 \
        scb=0.00587019 scc=8.94977e-05 m=(1)
mn21 (\14\:CKbb \11\:CKb \1\:VSS VSS) g45n1hvt w=(1.45e-07) l=4.5e-08 \
        nf=1 as=3.61e-14 ad=2.03e-14 ps=8e-07 pd=5.7e-07 nrd=1.16667 \
        nrs=1.16667 sa=2e-06 sb=1.4e-07 sd=160n sca=8.15925 scb=0.00587019 \
        scc=8.94977e-05 m=(1)
ends DFFXL
// End of subcircuit definition.
