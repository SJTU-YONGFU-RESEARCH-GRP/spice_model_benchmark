// Generated for: spectre (May  1 09:13:29 2013 )
// Library name: gsclib045_hvt
// Cell name: TBUFX2
// View name: extracted

simulator lang=spectre

subckt TBUFX2 A OE VDD VSS Y
mp4 (\6\:pon \3\:OE \12\:VDD VDD) g45p1hvt w=(2.15e-07) l=4.5e-08 nf=1 \
        as=3.01e-14 ad=4.837e-14 ps=7.1e-07 pd=8.8e-07 nrd=1.16667 \
        nrs=1.16667 sa=1.4e-07 sb=6.7e-07 sd=160n sca=33.0431 \
        scb=0.0334326 scc=0.00333002 m=(1)
mp3 (\6\:pon \1\:A \10\:VDD VDD) g45p1hvt w=(2.15e-07) l=4.5e-08 nf=1 \
        as=6.39e-14 ad=4.838e-14 ps=1.8e-06 pd=8.8e-07 nrd=1.16667 \
        nrs=1.16667 sa=4.1e-07 sb=4e-07 sd=160n sca=27.5463 scb=0.0242522 \
        scc=0.00301933 m=(1)
mp0 (\9\:OEb \4\:OE \10\:VDD VDD) g45p1hvt w=(2.15e-07) l=4.5e-08 nf=1 \
        as=6.39e-14 ad=4.408e-14 ps=1.8e-06 pd=8.4e-07 nrd=1.16667 \
        nrs=1.16667 sa=6.05e-07 sb=2.05e-07 sd=160n sca=26.4598 \
        scb=0.0232447 scc=0.00301689 m=(1)
mp2 (\8\:non OEb net127 VDD) g45p1hvt w=(2.15e-07) l=4.5e-08 nf=1 \
        as=2.365e-14 ad=3.01e-14 ps=6.5e-07 pd=7.1e-07 nrd=1.16667 \
        nrs=1.16667 sa=1.4e-07 sb=7.95e-07 sd=160n sca=26.1509 \
        scb=0.0231087 scc=0.00301684 m=(1)
mp1 (net127 \5\:A \1\:VDD VDD) g45p1hvt w=(2.15e-07) l=4.5e-08 nf=1 \
        as=1.208e-13 ad=2.365e-14 ps=1.96e-06 pd=6.5e-07 nrd=1.16667 \
        nrs=1.16667 sa=2.95e-07 sb=6.4e-07 sd=160n sca=26.6838 \
        scb=0.0233875 scc=0.00301701 m=(1)
C1 (Y VSS) capacitor c=1.99375e-17
C2 (VDD VSS) capacitor c=1.46202e-16
C3 (A VSS) capacitor c=1.26649e-16
C4 (pon VSS) capacitor c=9.89633e-17
C5 (OEb VSS) capacitor c=6.27169e-17
C6 (non VSS) capacitor c=8.10462e-17
C7 (net127 VSS) capacitor c=1.93634e-18
C8 (\5\:A VSS) capacitor c=5.36401e-17
C9 (\4\:OE VSS) capacitor c=5.79083e-17
C10 (\1\:A VSS) capacitor c=3.64499e-17
C11 (\3\:OE VSS) capacitor c=3.34052e-17
C12 (\7\:A VSS) capacitor c=4.62448e-17
C13 (\4\:OEb VSS) capacitor c=3.07988e-17
C14 (\7\:OE VSS) capacitor c=2.33988e-17
C15 (\3\:A VSS) capacitor c=4.83728e-17
C16 (\1\:OE VSS) capacitor c=2.76418e-17
C17 (\3\:non VSS) capacitor c=2.70907e-17
C18 (\6\:A VSS) capacitor c=5.47823e-17
C19 (\3\:OEb VSS) capacitor c=1.85833e-17
C20 (\6\:OE VSS) capacitor c=4.26227e-17
C21 (\2\:OE VSS) capacitor c=3.15231e-17
C22 (\1\:VDD VSS) capacitor c=1.14756e-16
C23 (\3\:Y VSS) capacitor c=7.29007e-17
C24 (\8\:non VSS) capacitor c=7.18589e-17
C25 (\9\:OEb VSS) capacitor c=5.69676e-17
C26 (\10\:VDD VSS) capacitor c=2.31593e-17
C27 (\6\:pon VSS) capacitor c=2.03413e-16
C28 (\12\:VDD VSS) capacitor c=4.40941e-17
C29 (\1\:Y VSS) capacitor c=4.45837e-17
C30 (\5\:non VSS) capacitor c=3.59809e-17
C31 (\7\:OEb VSS) capacitor c=2.17299e-17
C32 (\4\:pon VSS) capacitor c=6.56797e-17
C33 (\2\:A VSS) capacitor c=5.04055e-17
C34 (\2\:OEb VSS) capacitor c=3.57727e-17
C35 (\8\:OE VSS) capacitor c=6.04919e-17
C36 (\9\:OE VSS) capacitor c=5.26302e-17
C37 (\5\:OEb VSS) capacitor c=1.60273e-17
C38 (\6\:OEb VSS) capacitor c=3.77947e-17
C39 (\8\:A VSS) capacitor c=1.31029e-16
C40 (\9\:A VSS) capacitor c=2.77299e-17
C41 (\7\:non VSS) capacitor c=5.95749e-17
C42 (\10\:non VSS) capacitor c=3.73037e-17
C43 (\8\:pon VSS) capacitor c=1.49732e-16
C44 (\5\:VDD VSS) capacitor c=3.1445e-17
C45 (\6\:VDD VSS) capacitor c=1.9295e-17
C46 (\7\:VDD VSS) capacitor c=1.15627e-17
Rk2 (\9\:OE OE) resistor r=0.009977 c=0
Rk1 (\8\:OE \9\:OE) resistor r=0.2301 c=0
Rk24 (\1\:VSS \4\:VSS) resistor r=0.1901 c=0
Rk25 (\4\:VSS \6\:VSS) resistor r=0.04493 c=0
Rk27 (\7\:VSS VSS) resistor r=0.2778 c=0
Rk26 (\6\:VSS \7\:VSS) resistor r=0.2229 c=0
Rk29 (\4\:VSS \11\:VSS) resistor r=0.2295 c=0
Rk30 (\7\:VSS \13\:VSS) resistor r=0.2911 c=0
Rk13 (Y \2\:Y) resistor r=0.2524 c=0
Rk14 (Y \4\:Y) resistor r=0.1409 c=0
Rk16 (\1\:VDD \5\:VDD) resistor r=0.2796 c=0
Rk17 (\5\:VDD \6\:VDD) resistor r=0.237 c=0
Rk19 (\7\:VDD VDD) resistor r=0.04468 c=0
Rk18 (\6\:VDD \7\:VDD) resistor r=0.2168 c=0
Rk21 (\6\:VDD \11\:VDD) resistor r=0.04329 c=0
Rk22 (\7\:VDD \13\:VDD) resistor r=0.4084 c=0
Rk6 (\8\:A A) resistor r=1.0464 c=0
Rk7 (A \9\:A) resistor r=0.051 c=0
Rk11 (\5\:pon \7\:pon) resistor r=0.6441 c=0
Rk12 (\7\:pon \8\:pon) resistor r=1.3156 c=0
Rk3 (\5\:OEb \6\:OEb) resistor r=0.1077 c=0
Rk4 (\6\:OEb \8\:OEb) resistor r=0.1174 c=0
Rk5 (\6\:OEb \10\:OEb) resistor r=0.246 c=0
Rk8 (\6\:non \7\:non) resistor r=0.09746 c=0
Rk9 (\7\:non \9\:non) resistor r=0.4111 c=0
Rk10 (\7\:non \10\:non) resistor r=0.189 c=0
Rl2 (\2\:OE \3\:OE) resistor r=89.5604 c=0
Rl1 (\1\:OE \2\:OE) resistor r=40.3846 c=0
Rl6 (\4\:OE \5\:OE) resistor r=109.329 c=0
Rl8 (\5\:OE \7\:OE) resistor r=36.2526 c=0
Rl7 (\5\:OE \6\:OE) resistor r=0.5166 c=0
Rl12 (\5\:A \6\:A) resistor r=74.2328 c=0
Rl13 (\6\:A \7\:A) resistor r=87.6944 c=0
Rl3 (\1\:A \2\:A) resistor r=41.4601 c=0
Rl4 (\2\:A \3\:A) resistor r=106.845 c=0
Rl5 (\2\:A \4\:A) resistor r=4.959 c=0
Rl9 (OEb \2\:OEb) resistor r=112.741 c=0
Rl11 (\2\:OEb \4\:OEb) resistor r=70.868 c=0
Rl10 (\2\:OEb \3\:OEb) resistor r=25.857 c=0
Rl15 (non \3\:non) resistor r=18.7325 c=0
Rz8 (\11\:VSS \10\:VSS) resistor r=75 c=0
Rz9 (\13\:VSS \12\:VSS) resistor r=75 c=0
Rz4 (\2\:Y \1\:Y) resistor r=75 c=0
Rz3 (\5\:pon \4\:pon) resistor r=75 c=0
Rz1 (\7\:OEb \8\:OEb) resistor r=75 c=0
Rz2 (\6\:non \5\:non) resistor r=75 c=0
Ry4 (\4\:Y \3\:Y) resistor r=20.6667 c=0
Ry7 (\11\:VDD \10\:VDD) resistor r=62 c=0
Ry8 (\13\:VDD \12\:VDD) resistor r=62 c=0
Ry3 (\7\:pon \6\:pon) resistor r=62 c=0
Ry1 (\9\:OEb \10\:OEb) resistor r=62 c=0
Ry2 (\9\:non \8\:non) resistor r=62 c=0
Rx1 (\6\:OE \8\:OE) resistor r=45 c=0
Rx2 (\2\:OE \9\:OE) resistor r=45 c=0
Rx4 (\6\:A \8\:A) resistor r=45 c=0
Rx5 (\4\:A \9\:A) resistor r=45 c=0
Rx7 (\8\:pon pon) resistor r=45 c=0
Rx3 (\3\:OEb \5\:OEb) resistor r=45 c=0
Rx6 (\10\:non \3\:non) resistor r=45 c=0
mn4 (\4\:pon \1\:OE net144 VSS) g45n1hvt w=(1.45e-07) l=4.5e-08 nf=1 \
        as=2.32e-14 ad=2.03e-14 ps=6.1e-07 pd=5.7e-07 nrd=1.16667 \
        nrs=1.16667 sa=1.4e-07 sb=5.85e-07 sd=160n sca=11.7118 \
        scb=0.0116498 scc=0.000458536 m=(1)
mn3 (net144 \3\:A \12\:VSS VSS) g45n1hvt w=(1.45e-07) l=4.5e-08 nf=1 \
        as=2.32e-14 ad=2.32e-14 ps=6.1e-07 pd=6.1e-07 nrd=1.16667 \
        nrs=1.16667 sa=3.45e-07 sb=3.8e-07 sd=160n sca=11.7118 \
        scb=0.0116498 scc=0.000458536 m=(1)
mn0 (\7\:OEb \7\:OE \12\:VSS VSS) g45n1hvt w=(1.45e-07) l=4.5e-08 nf=1 \
        as=2.32e-14 ad=2.537e-14 ps=6.1e-07 pd=6.4e-07 nrd=1.16667 \
        nrs=1.16667 sa=5.5e-07 sb=1.75e-07 sd=160n sca=11.7118 \
        scb=0.0116498 scc=0.000458536 m=(1)
mn2 (\5\:non \4\:OEb \10\:VSS VSS) g45n1hvt w=(1.45e-07) l=4.5e-08 nf=1 \
        as=2.03e-14 ad=2.32e-14 ps=5.7e-07 pd=6.1e-07 nrd=1.16667 \
        nrs=1.16667 sa=1.4e-07 sb=8.15e-07 sd=160n sca=8.15925 \
        scb=0.00587019 scc=8.94977e-05 m=(1)
mn1 (\5\:non \7\:A \1\:VSS VSS) g45n1hvt w=(1.45e-07) l=4.5e-08 nf=1 \
        as=4.34e-14 ad=2.32e-14 ps=9.6e-07 pd=6.1e-07 nrd=1.16667 \
        nrs=1.16667 sa=3.45e-07 sb=6.1e-07 sd=160n sca=8.15925 \
        scb=0.00587019 scc=8.94977e-05 m=(1)
mn5 (\1\:Y non \1\:VSS VSS) g45n1hvt w=(2.6e-07) l=4.5e-08 nf=1 \
        as=3.99e-14 ad=4.16e-14 ps=8.8e-07 pd=8.4e-07 nrd=1.16667 \
        nrs=1.16667 sa=3.84423e-07 sb=3.45e-07 sd=160n sca=7.84363 \
        scb=0.00546499 scc=9.84911e-05 m=(2)
mp5 (\3\:Y pon \1\:VDD VDD) g45p1hvt w=(3.9e-07) l=4.5e-08 nf=1 \
        as=8.77e-14 ad=6.24e-14 ps=1.51e-06 pd=1.1e-06 nrd=1.16667 \
        nrs=1.16667 sa=3.92564e-07 sb=3.45e-07 sd=160n sca=34.13 \
        scb=0.0245441 scc=0.00340271 m=(2)
ends TBUFX2
// End of subcircuit definition.
