// Generated for: spectre (May  1 09:12:41 2013 )
// Library name: gsclib045_hvt
// Cell name: AOI21X4
// View name: extracted

simulator lang=spectre

subckt AOI21X4 A0 A1 B0 VDD VSS Y
mp0_1__rcx (net70 \2\:A0 \3\:VDD VDD) g45p1hvt w=(3.9e-07) l=4.5e-08 \
        nf=1 as=6.24e-14 ad=6.142e-14 ps=1.1e-06 pd=1.095e-06 nrd=1.16667 \
        nrs=1.16667 sa=1.4e-07 sb=2e-06 sd=160n sca=23.7719 scb=0.023448 \
        scc=0.0017399 m=(4)
mp1_1__rcx (net70 A1 \3\:VDD VDD) g45p1hvt w=(3.9e-07) l=4.5e-08 nf=1 \
        as=6.24e-14 ad=6.24e-14 ps=1.1e-06 pd=1.1e-06 nrd=1.16667 \
        nrs=1.16667 sa=3.45e-07 sb=2e-06 sd=160n sca=20.1813 scb=0.0174167 \
        scc=0.00159977 m=(4)
mp2_1__rcx (\10\:Y B0 net70 VDD) g45p1hvt w=(3.9e-07) l=4.5e-08 nf=1 \
        as=6.142e-14 ad=6.24e-14 ps=1.095e-06 pd=1.1e-06 nrd=1.16667 \
        nrs=1.16667 sa=1.79e-06 sb=7.55e-07 sd=160n sca=18.3796 \
        scb=0.0159892 scc=0.00159615 m=(4)
C1 (A0 VSS) capacitor c=3.72999e-17
C2 (Y VSS) capacitor c=6.06891e-17
C3 (A1 VSS) capacitor c=3.83932e-16
C4 (VDD VSS) capacitor c=1.0948e-16
C5 (B0 VSS) capacitor c=3.55175e-16
C6 (9 VSS) capacitor c=1.82117e-18
C7 (10 VSS) capacitor c=1.77435e-18
C8 (11 VSS) capacitor c=1.79527e-18
C9 (net70 VSS) capacitor c=4.78873e-16
C10 (\12\:A0 VSS) capacitor c=6.71688e-17
C11 (\12\:A1 VSS) capacitor c=6.2149e-17
C12 (\10\:A1 VSS) capacitor c=5.40382e-17
C13 (\4\:A0 VSS) capacitor c=5.30746e-17
C14 (\6\:A0 VSS) capacitor c=4.89127e-17
C15 (\1\:A1 VSS) capacitor c=6.83111e-17
C16 (\4\:A1 VSS) capacitor c=4.80598e-17
C17 (\1\:A0 VSS) capacitor c=5.49719e-17
C18 (\2\:A0 VSS) capacitor c=6.01214e-16
C19 (\10\:Y VSS) capacitor c=1.02015e-16
C20 (\1\:VDD VSS) capacitor c=5.06598e-17
C21 (\1\:Y VSS) capacitor c=1.04746e-16
C22 (\4\:Y VSS) capacitor c=8.814e-17
C23 (\6\:Y VSS) capacitor c=6.7645e-17
C24 (\2\:A1 VSS) capacitor c=3.09817e-17
C25 (\9\:A1 VSS) capacitor c=3.89699e-17
C26 (\3\:Y VSS) capacitor c=6.38825e-17
C27 (\3\:VDD VSS) capacitor c=2.20517e-16
Rk3 (A0 \2\:A0) resistor r=0.08359 c=0
Rk11 (Y \10\:Y) resistor r=0.0853 c=0
Rk10 (\3\:Y Y) resistor r=0.3437 c=0
Rk6 (\1\:Y \3\:Y) resistor r=0.04576 c=0
Rk7 (\3\:Y \5\:Y) resistor r=0.3361 c=0
Rk8 (\5\:Y \7\:Y) resistor r=0.4638 c=0
Rk25 (\2\:VSS \3\:VSS) resistor r=0.04477 c=0
Rk28 (\3\:VSS \6\:VSS) resistor r=0.2721 c=0
Rk29 (\6\:VSS \7\:VSS) resistor r=0.03728 c=0
Rk31 (\8\:VSS VSS) resistor r=0.2169 c=0
Rk30 (\7\:VSS \8\:VSS) resistor r=0.2944 c=0
Rk35 (\7\:VSS \16\:VSS) resistor r=0.197 c=0
Rk36 (\8\:VSS \18\:VSS) resistor r=0.2015 c=0
Rk42 (\3\:VDD VDD) resistor r=0.1694 c=0
Rk37 (\2\:VDD \3\:VDD) resistor r=0.5144 c=0
Rl19 (\2\:A0 \12\:A0) resistor r=55.0021 c=0
Rl8 (\2\:A0 \4\:A0) resistor r=73.8213 c=0
Rl9 (\2\:A0 \6\:A0) resistor r=51.7021 c=0
Rl1 (\2\:A0 \1\:A0) resistor r=43.4636 c=0
Rl4 (\2\:A1 A1) resistor r=25.7773 c=0
Rl3 (\2\:A1 \1\:A1) resistor r=86.2215 c=0
Rl5 (\2\:A1 \4\:A1) resistor r=38.3697 c=0
Rl14 (\9\:A1 A1) resistor r=10.2925 c=0
Rl17 (\9\:A1 \12\:A1) resistor r=128.331 c=0
Rl15 (\9\:A1 \10\:A1) resistor r=78.9095 c=0
Rz2 (\5\:Y \4\:Y) resistor r=75 c=0
Rz3 (\7\:Y \6\:Y) resistor r=75 c=0
Rz8 (\16\:VSS \15\:VSS) resistor r=75 c=0
Rz9 (\18\:VSS \17\:VSS) resistor r=75 c=0
Rz10 (\2\:VDD \1\:VDD) resistor r=25 c=0
Rz11 (\3\:VDD \1\:VDD) resistor r=6.25 c=0
Ry10 (\2\:VSS \1\:VSS) resistor r=20.6667 c=0
Ry11 (\6\:VSS \1\:VSS) resistor r=5.1667 c=0
mn0_1__rcx (8 \1\:A0 \17\:VSS VSS) g45n1hvt w=(2.6e-07) l=4.5e-08 nf=1 \
        as=3.64e-14 ad=1.56e-14 ps=8e-07 pd=6.4e-07 nrd=1.16667 \
        nrs=1.16667 sa=1.4e-07 sb=2e-06 sd=160n sca=9.14564 scb=0.00759168 \
        scc=0.000213449 m=(1)
mn1_1__rcx (\6\:Y \4\:A1 8 VSS) g45n1hvt w=(2.6e-07) l=4.5e-08 nf=1 \
        as=1.56e-14 ad=4.16e-14 ps=6.4e-07 pd=8.4e-07 nrd=1.16667 \
        nrs=1.16667 sa=2.45e-07 sb=1.905e-06 sd=160n sca=9.14564 \
        scb=0.00759168 scc=0.000213449 m=(1)
mn1_2__rcx (\6\:Y \1\:A1 9 VSS) g45n1hvt w=(2.6e-07) l=4.5e-08 nf=1 \
        as=1.56e-14 ad=4.16e-14 ps=6.4e-07 pd=8.4e-07 nrd=1.16667 \
        nrs=1.16667 sa=4.5e-07 sb=1.7e-06 sd=160n sca=9.14564 \
        scb=0.00759168 scc=0.000213449 m=(1)
mn0_2__rcx (9 \6\:A0 \15\:VSS VSS) g45n1hvt w=(2.6e-07) l=4.5e-08 nf=1 \
        as=4.16e-14 ad=1.56e-14 ps=8.4e-07 pd=6.4e-07 nrd=1.16667 \
        nrs=1.16667 sa=5.55e-07 sb=1.595e-06 sd=160n sca=9.14564 \
        scb=0.00759168 scc=0.000213449 m=(1)
mn0_3__rcx (10 \4\:A0 \15\:VSS VSS) g45n1hvt w=(2.6e-07) l=4.5e-08 nf=1 \
        as=4.16e-14 ad=1.56e-14 ps=8.4e-07 pd=6.4e-07 nrd=1.16667 \
        nrs=1.16667 sa=7.6e-07 sb=1.39e-06 sd=160n sca=9.14564 \
        scb=0.00759168 scc=0.000213449 m=(1)
mn1_3__rcx (\4\:Y \10\:A1 10 VSS) g45n1hvt w=(2.6e-07) l=4.5e-08 nf=1 \
        as=1.56e-14 ad=4.16e-14 ps=6.4e-07 pd=8.4e-07 nrd=1.16667 \
        nrs=1.16667 sa=8.65e-07 sb=1.285e-06 sd=160n sca=9.14564 \
        scb=0.00759168 scc=0.000213449 m=(1)
mn1 (\4\:Y \12\:A1 11 VSS) g45n1hvt w=(2.6e-07) l=4.5e-08 nf=1 \
        as=1.56e-14 ad=4.16e-14 ps=6.4e-07 pd=8.4e-07 nrd=1.16667 \
        nrs=1.16667 sa=1.07e-06 sb=1.08e-06 sd=160n sca=9.14564 \
        scb=0.00759168 scc=0.000213449 m=(1)
mn0 (11 \12\:A0 \3\:VSS VSS) g45n1hvt w=(2.6e-07) l=4.5e-08 nf=1 \
        as=4.16e-14 ad=1.56e-14 ps=8.4e-07 pd=6.4e-07 nrd=1.16667 \
        nrs=1.16667 sa=1.175e-06 sb=9.75e-07 sd=160n sca=9.14564 \
        scb=0.00759168 scc=0.000213449 m=(1)
mn2_1__rcx (\1\:Y B0 \3\:VSS VSS) g45n1hvt w=(2.6e-07) l=4.5e-08 nf=1 \
        as=4.225e-14 ad=4.16e-14 ps=8.45e-07 pd=8.4e-07 nrd=1.16667 \
        nrs=1.16667 sa=1.38e-06 sb=7.7e-07 sd=160n sca=9.14564 \
        scb=0.00759168 scc=0.000213449 m=(4)
ends AOI21X4
// End of subcircuit definition.
