// Generated for: spectre (May  1 09:12:34 2013 )
// Library name: gsclib045_hvt
// Cell name: AOI211X1
// View name: extracted

simulator lang=spectre

subckt AOI211X1 A0 A1 B0 C0 VDD VSS Y
mp0 (\3\:net91 \1\:A0 \4\:VDD VDD) g45p1hvt w=(3.9e-07) l=4.5e-08 nf=1 \
        as=6.24e-14 ad=5.46e-14 ps=1.1e-06 pd=1.06e-06 nrd=1.16667 \
        nrs=1.16667 sa=1.4e-07 sb=7.25e-07 sd=160n sca=15.668 \
        scb=0.0150333 scc=0.000302999 m=(1)
mp1 (net91 \1\:A1 \4\:VDD VDD) g45p1hvt w=(3.9e-07) l=4.5e-08 nf=1 \
        as=6.24e-14 ad=6.24e-14 ps=1.1e-06 pd=1.1e-06 nrd=1.16667 \
        nrs=1.16667 sa=3.45e-07 sb=5.2e-07 sd=160n sca=13.1976 \
        scb=0.0106472 scc=0.00023361 m=(1)
mp2 (net82 \1\:B0 net91 VDD) g45p1hvt w=(3.9e-07) l=4.5e-08 nf=1 \
        as=6.24e-14 ad=5.07e-14 ps=1.1e-06 pd=1.04e-06 nrd=1.16667 \
        nrs=1.16667 sa=5.5e-07 sb=3.15e-07 sd=160n sca=13.0795 \
        scb=0.0104536 scc=0.000232888 m=(1)
mp3 (\5\:Y \1\:C0 net82 VDD) g45p1hvt w=(3.9e-07) l=4.5e-08 nf=1 \
        as=5.07e-14 ad=5.46e-14 ps=1.04e-06 pd=1.06e-06 nrd=1.16667 \
        nrs=1.16667 sa=7.25e-07 sb=1.4e-07 sd=160n sca=14.4782 \
        scb=0.0129551 scc=0.000256244 m=(1)
C1 (C0 VSS) capacitor c=7.30775e-17
C2 (A0 VSS) capacitor c=9.56427e-17
C3 (Y VSS) capacitor c=9.38306e-17
C4 (B0 VSS) capacitor c=5.70251e-17
C5 (VDD VSS) capacitor c=1.0164e-16
C6 (A1 VSS) capacitor c=6.30463e-17
C7 (net91 VSS) capacitor c=6.97797e-17
C8 (\1\:C0 VSS) capacitor c=5.74001e-17
C9 (\1\:B0 VSS) capacitor c=7.09041e-17
C10 (\1\:A1 VSS) capacitor c=4.78234e-17
C11 (\1\:A0 VSS) capacitor c=6.19125e-17
C12 (\3\:C0 VSS) capacitor c=3.45564e-17
C13 (\3\:B0 VSS) capacitor c=3.35342e-17
C14 (\3\:A1 VSS) capacitor c=8.05233e-17
C15 (\4\:A0 VSS) capacitor c=5.25374e-17
C16 (\2\:C0 VSS) capacitor c=3.67887e-17
C17 (\2\:B0 VSS) capacitor c=4.48405e-17
C18 (\2\:A1 VSS) capacitor c=6.3434e-17
C19 (\3\:A0 VSS) capacitor c=1.01432e-17
C20 (\5\:Y VSS) capacitor c=9.08878e-17
C21 (\4\:VDD VSS) capacitor c=4.10994e-17
C22 (\3\:net91 VSS) capacitor c=6.28105e-17
C23 (\3\:Y VSS) capacitor c=5.97535e-17
C24 (\2\:A0 VSS) capacitor c=4.53732e-17
C25 (\4\:A1 VSS) capacitor c=5.8427e-17
C26 (\4\:B0 VSS) capacitor c=6.38039e-17
C27 (\4\:C0 VSS) capacitor c=3.34132e-17
C28 (\3\:VDD VSS) capacitor c=5.12885e-17
Rk5 (\4\:C0 C0) resistor r=0.1325 c=0
Rk1 (\5\:A0 A0) resistor r=0.002985 c=0
Rk6 (Y \2\:Y) resistor r=0.005069 c=0
Rk7 (\2\:Y \4\:Y) resistor r=0.3489 c=0
Rk8 (Y \6\:Y) resistor r=0.7916 c=0
Rk4 (B0 \4\:B0) resistor r=0.1064 c=0
Rk10 (\3\:VSS VSS) resistor r=0.08699 c=0
Rk9 (\2\:VSS \3\:VSS) resistor r=0.2114 c=0
Rk11 (\3\:VSS \5\:VSS) resistor r=0.2122 c=0
Rk12 (\5\:VSS \7\:VSS) resistor r=0.2963 c=0
Rk14 (\3\:VDD VDD) resistor r=0.1894 c=0
Rk15 (\3\:VDD \5\:VDD) resistor r=0.1817 c=0
Rk2 (A1 \4\:A1) resistor r=0.0597 c=0
Rk3 (\2\:net91 \4\:net91) resistor r=0.428 c=0
Rl8 (\1\:C0 \2\:C0) resistor r=137.23 c=0
Rl9 (\2\:C0 \3\:C0) resistor r=44.9225 c=0
Rl1 (\1\:A0 \2\:A0) resistor r=160.418 c=0
Rl3 (\2\:A0 \4\:A0) resistor r=37.3411 c=0
Rl2 (\2\:A0 \3\:A0) resistor r=2.4801 c=0
Rl6 (\1\:B0 \2\:B0) resistor r=145.329 c=0
Rl7 (\2\:B0 \3\:B0) resistor r=29.9442 c=0
Rl4 (\1\:A1 \2\:A1) resistor r=42.2849 c=0
Rl5 (\2\:A1 \3\:A1) resistor r=138.257 c=0
Rz1 (\1\:Y \2\:Y) resistor r=75 c=0
Rz2 (\3\:Y \4\:Y) resistor r=75 c=0
Rz3 (\1\:VSS \2\:VSS) resistor r=75 c=0
Rz4 (\6\:VSS \7\:VSS) resistor r=75 c=0
Ry3 (\5\:Y \6\:Y) resistor r=20.6667 c=0
Ry5 (\4\:VDD \5\:VDD) resistor r=62 c=0
Ry1 (net91 \2\:net91) resistor r=31 c=0
Ry2 (\3\:net91 \4\:net91) resistor r=31 c=0
Rx4 (\2\:C0 \4\:C0) resistor r=45 c=0
Rx1 (\3\:A0 \5\:A0) resistor r=45 c=0
Rx3 (\2\:B0 \4\:B0) resistor r=45 c=0
Rx2 (\2\:A1 \4\:A1) resistor r=45 c=0
mn0 (net95 \4\:A0 \1\:VSS VSS) g45n1hvt w=(2.6e-07) l=4.5e-08 nf=1 \
        as=3.64e-14 ad=1.56e-14 ps=8e-07 pd=6.4e-07 nrd=1.16667 \
        nrs=1.16667 sa=1.4e-07 sb=7.5e-07 sd=160n sca=9.69565 \
        scb=0.00844644 scc=0.000275168 m=(1)
mn1 (\3\:Y \3\:A1 net95 VSS) g45n1hvt w=(2.6e-07) l=4.5e-08 nf=1 \
        as=1.56e-14 ad=5.59e-14 ps=6.4e-07 pd=9.5e-07 nrd=1.16667 \
        nrs=1.16667 sa=2.45e-07 sb=6.45e-07 sd=160n sca=9.69565 \
        scb=0.00844644 scc=0.000275168 m=(1)
mn2 (\3\:Y \3\:B0 \6\:VSS VSS) g45n1hvt w=(2.6e-07) l=4.5e-08 nf=1 \
        as=4.55e-14 ad=5.59e-14 ps=8.7e-07 pd=9.5e-07 nrd=1.16667 \
        nrs=1.16667 sa=5.05e-07 sb=3.85e-07 sd=160n sca=9.69565 \
        scb=0.00844644 scc=0.000275168 m=(1)
mn3 (\1\:Y \3\:C0 \6\:VSS VSS) g45n1hvt w=(2.6e-07) l=4.5e-08 nf=1 \
        as=4.55e-14 ad=4.29e-14 ps=8.7e-07 pd=8.5e-07 nrd=1.16667 \
        nrs=1.16667 sa=7.25e-07 sb=1.65e-07 sd=160n sca=9.69565 \
        scb=0.00844644 scc=0.000275168 m=(1)
ends AOI211X1
// End of subcircuit definition.
