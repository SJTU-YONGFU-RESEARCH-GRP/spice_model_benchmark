// Generated for: spectre (May  1 09:17:43 2013 )
// Library name: gsclib045_hvt
// Cell name: NAND4BBX4
// View name: extracted

simulator lang=spectre

subckt NAND4BBX4 AN BN C D VDD VSS Y
mp1 (\18\:n1 \1\:BN \30\:VDD VDD) g45p1hvt w=(3.9e-07) l=4.5e-08 nf=1 \
        as=6.24e-14 ad=5.46e-14 ps=1.1e-06 pd=1.06e-06 nrd=1.16667 \
        nrs=1.16667 sa=1.4e-07 sb=3.75e-07 sd=160n sca=16.9422 \
        scb=0.0172816 scc=0.000388705 m=(1)
mp0 (\16\:n0 \1\:AN \30\:VDD VDD) g45p1hvt w=(3.9e-07) l=4.5e-08 nf=1 \
        as=6.24e-14 ad=6.63e-14 ps=1.1e-06 pd=1.12e-06 nrd=1.16667 \
        nrs=1.16667 sa=3.45e-07 sb=1.7e-07 sd=160n sca=13.2347 \
        scb=0.0110279 scc=0.000235823 m=(1)
mp3_1__rcx (\9\:Y n1 \1\:VDD VDD) g45p1hvt w=(3.9e-07) l=4.5e-08 nf=1 \
        as=6.24e-14 ad=6.24e-14 ps=1.1e-06 pd=1.1e-06 nrd=1.16667 \
        nrs=1.16667 sa=9.6e-07 sb=2e-06 sd=160n sca=16.2669 scb=0.0145797 \
        scc=0.00118861 m=(4)
mp4_1__rcx (\7\:Y \1\:C \1\:VDD VDD) g45p1hvt w=(3.9e-07) l=4.5e-08 nf=1 \
        as=6.24e-14 ad=6.24e-14 ps=1.1e-06 pd=1.1e-06 nrd=1.16667 \
        nrs=1.16667 sa=1.78e-06 sb=1.575e-06 sd=160n sca=16.2669 \
        scb=0.0145797 scc=0.00118861 m=(4)
mp5_1__rcx (\5\:Y \1\:D \1\:VDD VDD) g45p1hvt w=(3.9e-07) l=4.5e-08 nf=1 \
        as=6.045e-14 ad=6.24e-14 ps=1.09e-06 pd=1.1e-06 nrd=1.16667 \
        nrs=1.16667 sa=2e-06 sb=7.55e-07 sd=160n sca=16.2957 scb=0.0145851 \
        scc=0.00118861 m=(4)
mp2_1__rcx (\11\:Y n0 \1\:VDD VDD) g45p1hvt w=(3.9e-07) l=4.5e-08 nf=1 \
        as=6.045e-14 ad=6.24e-14 ps=1.09e-06 pd=1.1e-06 nrd=1.16667 \
        nrs=1.16667 sa=1.4e-07 sb=2e-06 sd=160n sca=16.2669 scb=0.0145797 \
        scc=0.00118861 m=(4)
C1 (BN VSS) capacitor c=1.00086e-16
C2 (D VSS) capacitor c=6.16931e-17
C3 (VDD VSS) capacitor c=2.23536e-16
C4 (C VSS) capacitor c=2.75115e-17
C5 (AN VSS) capacitor c=8.07034e-17
C6 (Y VSS) capacitor c=3.13929e-17
C7 (n1 VSS) capacitor c=2.78216e-16
C8 (n0 VSS) capacitor c=2.6421e-16
C9 (n4 VSS) capacitor c=3.85236e-16
C10 (n3 VSS) capacitor c=1.65896e-16
C11 (n2 VSS) capacitor c=3.10092e-16
C12 (\1\:AN VSS) capacitor c=4.32818e-17
C13 (\1\:BN VSS) capacitor c=4.65308e-17
C14 (\1\:D VSS) capacitor c=2.62412e-16
C15 (\1\:C VSS) capacitor c=2.86903e-16
C16 (\3\:AN VSS) capacitor c=3.71654e-17
C17 (\3\:BN VSS) capacitor c=3.07548e-17
C18 (\2\:AN VSS) capacitor c=3.26591e-17
C19 (\2\:BN VSS) capacitor c=3.89688e-17
C20 (\1\:VDD VSS) capacitor c=5.5423e-16
C21 (\16\:n0 VSS) capacitor c=6.3804e-17
C22 (\30\:VDD VSS) capacitor c=3.3055e-17
C23 (\18\:n1 VSS) capacitor c=8.45396e-17
C24 (\1\:Y VSS) capacitor c=1.31821e-16
C25 (\4\:n3 VSS) capacitor c=1.43308e-16
C26 (\18\:n0 VSS) capacitor c=5.99747e-17
C27 (\16\:n1 VSS) capacitor c=2.76938e-16
C28 (\4\:BN VSS) capacitor c=3.41251e-17
C29 (\4\:AN VSS) capacitor c=5.13105e-17
C30 (\14\:n0 VSS) capacitor c=5.85535e-17
C31 (\15\:n0 VSS) capacitor c=6.98837e-17
C32 (\15\:n1 VSS) capacitor c=1.99764e-16
C33 (\14\:C VSS) capacitor c=6.72503e-17
C34 (\16\:D VSS) capacitor c=5.12715e-17
C35 (\5\:Y VSS) capacitor c=1.7241e-16
C36 (\7\:Y VSS) capacitor c=1.66006e-16
C37 (\9\:Y VSS) capacitor c=1.38341e-16
C38 (\11\:Y VSS) capacitor c=1.27398e-16
C39 (\29\:VDD VSS) capacitor c=1.98192e-17
Rk1 (\4\:BN BN) resistor r=0.021 c=0
Rk17 (D \16\:D) resistor r=0.1098 c=0
Rk59 (\29\:VDD VDD) resistor r=0.1675 c=0
Rk57 (\1\:VDD \29\:VDD) resistor r=0.3281 c=0
Rk58 (\29\:VDD \31\:VDD) resistor r=0.181 c=0
Rk12 (C \14\:C) resistor r=0.02606 c=0
Rk2 (AN \4\:AN) resistor r=0.135 c=0
Rk60 (\2\:VSS \3\:VSS) resistor r=0.9275 c=0
Rk64 (\7\:VSS VSS) resistor r=0.1299 c=0
Rk63 (\3\:VSS \7\:VSS) resistor r=0.4216 c=0
Rk66 (\7\:VSS \11\:VSS) resistor r=0.2799 c=0
Rk19 (\1\:Y \5\:Y) resistor r=0.432 c=0
Rk21 (\5\:Y \7\:Y) resistor r=0.3033 c=0
Rk23 (\7\:Y \9\:Y) resistor r=0.3044 c=0
Rk35 (\11\:Y Y) resistor r=0.01692 c=0
Rk25 (\9\:Y \11\:Y) resistor r=0.2996 c=0
Rk6 (\15\:n1 \17\:n1) resistor r=1.7189 c=0
Rk7 (\17\:n1 \19\:n1) resistor r=0.651 c=0
Rk3 (\14\:n0 \15\:n0) resistor r=0.3252 c=0
Rk4 (\15\:n0 \17\:n0) resistor r=0.3093 c=0
Rk5 (\15\:n0 \19\:n0) resistor r=0.2262 c=0
Rk14 (n3 \4\:n3) resistor r=0.4388 c=0
Rl1 (\1\:BN \2\:BN) resistor r=92.3077 c=0
Rl2 (\2\:BN \3\:BN) resistor r=57.1429 c=0
Rl3 (\1\:AN \2\:AN) resistor r=91.0764 c=0
Rl4 (\2\:AN \3\:AN) resistor r=56.461 c=0
Rz23 (\11\:VSS \10\:VSS) resistor r=75 c=0
Rz2 (\17\:n1 \16\:n1) resistor r=75 c=0
Rz1 (\19\:n0 \18\:n0) resistor r=75 c=0
Ry20 (\31\:VDD \30\:VDD) resistor r=62 c=0
Ry21 (\2\:VSS \1\:VSS) resistor r=5.6364 c=0
Ry22 (\3\:VSS \1\:VSS) resistor r=5.1667 c=0
Ry2 (\19\:n1 \18\:n1) resistor r=62 c=0
Ry1 (\17\:n0 \16\:n0) resistor r=20.6667 c=0
Rx1 (\2\:BN \4\:BN) resistor r=45 c=0
Rx6 (\16\:D \1\:D) resistor r=45 c=0
Rx5 (\14\:C \1\:C) resistor r=45 c=0
Rx2 (\2\:AN \4\:AN) resistor r=45 c=0
Rx4 (\15\:n1 n1) resistor r=45 c=0
Rx3 (\14\:n0 n0) resistor r=45 c=0
mn1 (\16\:n1 \3\:BN \10\:VSS VSS) g45n1hvt w=(2.6e-07) l=4.5e-08 nf=1 \
        as=6.11e-14 ad=3.64e-14 ps=9.9e-07 pd=8e-07 nrd=1.16667 \
        nrs=1.16667 sa=1.4e-07 sb=4.6e-07 sd=160n sca=15.3338 \
        scb=0.0153436 scc=0.00119435 m=(1)
mn0 (\18\:n0 \3\:AN \10\:VSS VSS) g45n1hvt w=(2.6e-07) l=4.5e-08 nf=1 \
        as=6.11e-14 ad=4.68e-14 ps=9.9e-07 pd=8.8e-07 nrd=1.16667 \
        nrs=1.16667 sa=4.2e-07 sb=1.8e-07 sd=160n sca=15.3338 \
        scb=0.0153436 scc=0.00119435 m=(1)
mn4_1__rcx (n2 \1\:C n3 VSS) g45n1hvt w=(2.6e-07) l=4.5e-08 nf=1 \
        as=4.16e-14 ad=4.03e-14 ps=8.4e-07 pd=8.3e-07 nrd=1.16667 \
        nrs=1.16667 sa=1.4e-07 sb=1.575e-06 sd=160n sca=9.32128 \
        scb=0.00786794 scc=0.000232361 m=(4)
mn5 (\1\:Y \1\:D n2 VSS) g45n1hvt w=(2.6e-07) l=4.5e-08 nf=1 as=4.03e-14 \
        ad=4.16e-14 ps=8.3e-07 pd=8.4e-07 nrd=1.16667 nrs=1.16667 \
        sa=9.6e-07 sb=7.55e-07 sd=160n sca=9.32128 scb=0.00786794 \
        scc=0.000232361 m=(4)
mn2_1__rcx (n4 n0 \3\:VSS VSS) g45n1hvt w=(2.6e-07) l=4.5e-08 nf=1 \
        as=4.16e-14 ad=4.127e-14 ps=8.4e-07 pd=8.375e-07 nrd=1.16667 \
        nrs=1.16667 sa=1.4e-07 sb=1.59e-06 sd=160n sca=11.3041 \
        scb=0.010759 scc=0.000493236 m=(4)
mn3_1__rcx (\4\:n3 n1 n4 VSS) g45n1hvt w=(2.6e-07) l=4.5e-08 nf=1 \
        as=4.127e-14 ad=4.16e-14 ps=8.375e-07 pd=8.4e-07 nrd=1.16667 \
        nrs=1.16667 sa=9.75e-07 sb=7.55e-07 sd=160n sca=11.3041 \
        scb=0.010759 scc=0.000493236 m=(4)
ends NAND4BBX4
// End of subcircuit definition.
