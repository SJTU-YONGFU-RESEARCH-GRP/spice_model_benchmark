// Generated for: spectre (May  1 09:20:10 2013 )
// Library name: gsclib045_hvt
// Cell name: TLATNX4
// View name: extracted

simulator lang=spectre

subckt TLATNX4 D GN Q QN VDD VSS
mp0 (\15\:GNb \1\:GN \4\:VDD VDD) g45p1hvt w=(2.15e-07) l=4.5e-08 nf=1 \
        as=6.535e-14 ad=3.01e-14 ps=1.16e-06 pd=7.1e-07 nrd=1.16667 \
        nrs=1.16667 sa=1.4e-07 sb=2e-06 sd=160n sca=27.6315 scb=0.0243605 \
        scc=0.00301984 m=(1)
mp15 (net212 \31\:Qint \4\:VDD VDD) g45p1hvt w=(2.15e-07) l=4.5e-08 nf=1 \
        as=9.07e-14 ad=3.117e-14 ps=1.34e-06 pd=7.2e-07 nrd=1.16667 \
        nrs=1.16667 sa=2e-06 sb=9.65e-07 sd=160n sca=11.1138 \
        scb=0.00912362 scc=0.000187967 m=(1)
mp16 (\8\:n0 GNb net212 VDD) g45p1hvt w=(2.15e-07) l=4.5e-08 nf=1 \
        as=3.118e-14 ad=5.59e-14 ps=7.2e-07 pd=9.5e-07 nrd=1.16667 \
        nrs=1.16667 sa=2e-06 sb=7.75e-07 sd=160n sca=11.1138 \
        scb=0.00912362 scc=0.000187967 m=(1)
mp6 (\8\:n0 GNbb net220 VDD) g45p1hvt w=(2.15e-07) l=4.5e-08 nf=1 \
        as=1.72e-14 ad=5.59e-14 ps=5.9e-07 pd=9.5e-07 nrd=1.16667 \
        nrs=1.16667 sa=2e-06 sb=4.7e-07 sd=160n sca=11.7304 scb=0.00936234 \
        scc=0.000188063 m=(1)
mp5 (net220 \1\:D \5\:VDD VDD) g45p1hvt w=(2.15e-07) l=4.5e-08 nf=1 \
        as=3.44e-14 ad=1.72e-14 ps=7.5e-07 pd=5.9e-07 nrd=1.16667 \
        nrs=1.16667 sa=2e-06 sb=3.45e-07 sd=160n sca=12.3705 \
        scb=0.00989845 scc=0.000188963 m=(1)
mp1 (\4\:GNbb \5\:GNb \5\:VDD VDD) g45p1hvt w=(2.15e-07) l=4.5e-08 nf=1 \
        as=3.44e-14 ad=3.01e-14 ps=7.5e-07 pd=7.1e-07 nrd=1.16667 \
        nrs=1.16667 sa=2e-06 sb=1.4e-07 sd=160n sca=14.743 scb=0.013467 \
        scc=0.000229709 m=(1)
C1 (D VSS) capacitor c=4.68869e-17
C2 (GN VSS) capacitor c=6.20269e-17
C3 (QN VSS) capacitor c=1.42165e-16
C4 (VDD VSS) capacitor c=2.35051e-16
C5 (Q VSS) capacitor c=2.18778e-17
C6 (GNb VSS) capacitor c=3.75667e-17
C7 (Qbint VSS) capacitor c=2.67546e-16
C8 (Qint VSS) capacitor c=2.3585e-16
C9 (n0 VSS) capacitor c=1.95136e-16
C10 (net245 VSS) capacitor c=9.60816e-19
C11 (GNbb VSS) capacitor c=5.53362e-17
C12 (net257 VSS) capacitor c=5.51213e-19
C13 (\5\:GNb VSS) capacitor c=7.00065e-17
C14 (\1\:D VSS) capacitor c=7.22177e-17
C15 (\31\:Qint VSS) capacitor c=5.49447e-17
C16 (\1\:GN VSS) capacitor c=3.30389e-17
C17 (\6\:GNb VSS) capacitor c=4.80453e-17
C18 (\3\:D VSS) capacitor c=6.13163e-17
C19 (\3\:GNb VSS) capacitor c=5.31032e-17
C20 (\3\:GNbb VSS) capacitor c=8.84974e-17
C21 (\29\:Qint VSS) capacitor c=5.55309e-17
C22 (\3\:GN VSS) capacitor c=3.68945e-17
C23 (\7\:GNb VSS) capacitor c=1.73721e-17
C24 (\2\:D VSS) capacitor c=6.8058e-17
C25 (\2\:GNbb VSS) capacitor c=6.43557e-17
C26 (\4\:GNb VSS) capacitor c=2.62475e-17
C27 (\2\:GNb VSS) capacitor c=4.59585e-17
C28 (\30\:Qint VSS) capacitor c=6.27936e-17
C29 (\2\:GN VSS) capacitor c=3.63444e-17
C30 (\4\:GNbb VSS) capacitor c=5.86994e-17
C31 (\5\:VDD VSS) capacitor c=2.78706e-17
C32 (\8\:n0 VSS) capacitor c=1.51094e-17
C33 (\38\:Qint VSS) capacitor c=7.92768e-17
C34 (\1\:Q VSS) capacitor c=1.73612e-16
C35 (\15\:GNb VSS) capacitor c=6.43847e-17
C36 (\1\:VDD VSS) capacitor c=4.37358e-17
C37 (\6\:GNbb VSS) capacitor c=1.04603e-16
C38 (\12\:n0 VSS) capacitor c=8.24906e-17
C39 (\32\:Qint VSS) capacitor c=2.66157e-17
C40 (\1\:QN VSS) capacitor c=1.24395e-16
C41 (\15\:Qbint VSS) capacitor c=9.0129e-17
C42 (\11\:GNb VSS) capacitor c=3.54441e-16
C43 (\14\:Qint VSS) capacitor c=2.36766e-16
C44 (\4\:GN VSS) capacitor c=4.15863e-17
C45 (\4\:Q VSS) capacitor c=1.1412e-16
C46 (\19\:Qbint VSS) capacitor c=2.49651e-17
C47 (\20\:Qbint VSS) capacitor c=4.6676e-17
C48 (\21\:Qbint VSS) capacitor c=1.50743e-16
C49 (\34\:Qint VSS) capacitor c=2.72325e-17
C50 (\35\:Qint VSS) capacitor c=3.70248e-17
C51 (\36\:Qint VSS) capacitor c=4.2629e-17
C52 (\37\:Qint VSS) capacitor c=4.84751e-17
C53 (\10\:n0 VSS) capacitor c=7.77575e-17
C54 (\11\:n0 VSS) capacitor c=8.04013e-17
C55 (\4\:D VSS) capacitor c=7.27709e-17
C56 (\8\:GNb VSS) capacitor c=2.87638e-17
C57 (\9\:GNb VSS) capacitor c=5.5128e-17
C58 (\10\:GNb VSS) capacitor c=3.58034e-16
C59 (\13\:GNb VSS) capacitor c=7.63501e-17
C60 (\14\:GNb VSS) capacitor c=7.81559e-17
C61 (\8\:GNbb VSS) capacitor c=1.07529e-16
C62 (\3\:VDD VSS) capacitor c=1.84545e-17
C63 (\4\:VDD VSS) capacitor c=5.87141e-16
Rk30 (D \4\:D) resistor r=0.2006 c=0
Rk1 (GN \4\:GN) resistor r=0.05181 c=0
Rk15 (\1\:QN QN) resistor r=0.2989 c=0
Rk39 (\2\:VDD \3\:VDD) resistor r=0.1552 c=0
Rk58 (\4\:VDD VDD) resistor r=0.2928 c=0
Rk40 (\3\:VDD \4\:VDD) resistor r=0.5468 c=0
Rk41 (\3\:VDD \6\:VDD) resistor r=0.2662 c=0
Rk3 (\1\:Q Q) resistor r=0.07979 c=0
Rk4 (Q \4\:Q) resistor r=0.1901 c=0
Rk59 (\2\:VSS \3\:VSS) resistor r=0.1702 c=0
Rk70 (\4\:VSS VSS) resistor r=0.19 c=0
Rk60 (\3\:VSS \4\:VSS) resistor r=0.3605 c=0
Rk71 (\3\:VSS \15\:VSS) resistor r=0.07346 c=0
Rk31 (\8\:GNb \9\:GNb) resistor r=0.0554 c=0
Rk32 (\9\:GNb \10\:GNb) resistor r=0.1943 c=0
Rk33 (\10\:GNb \12\:GNb) resistor r=2.8604 c=0
Rk34 (\9\:GNb \13\:GNb) resistor r=0.4135 c=0
Rk35 (\10\:GNb \14\:GNb) resistor r=0.3981 c=0
Rk36 (\12\:GNb \16\:GNb) resistor r=0.4808 c=0
Rk9 (\15\:Qbint \19\:Qbint) resistor r=0.2234 c=0
Rk10 (\19\:Qbint \20\:Qbint) resistor r=0.258 c=0
Rk11 (\19\:Qbint \21\:Qbint) resistor r=0.1278 c=0
Rk22 (\33\:Qint \34\:Qint) resistor r=0.08745 c=0
Rk23 (\34\:Qint \35\:Qint) resistor r=0.1556 c=0
Rk24 (\35\:Qint \36\:Qint) resistor r=0.259 c=0
Rk25 (\34\:Qint \37\:Qint) resistor r=0.2121 c=0
Rk26 (\35\:Qint \39\:Qint) resistor r=0.3346 c=0
Rk27 (\9\:n0 \10\:n0) resistor r=0.08384 c=0
Rk28 (\10\:n0 \11\:n0) resistor r=0.5287 c=0
Rk29 (\10\:n0 \13\:n0) resistor r=0.435 c=0
Rk37 (\5\:GNbb \7\:GNbb) resistor r=0.4941 c=0
Rk38 (\7\:GNbb \8\:GNbb) resistor r=0.4569 c=0
Rl55 (\1\:D \2\:D) resistor r=153.207 c=0
Rl56 (\2\:D \3\:D) resistor r=76.9003 c=0
Rl1 (\1\:GN \2\:GN) resistor r=40.1797 c=0
Rl2 (\2\:GN \3\:GN) resistor r=117.285 c=0
Rl57 (\5\:GNb \6\:GNb) resistor r=214.304 c=0
Rl58 (\6\:GNb \7\:GNb) resistor r=29.5379 c=0
Rl52 (\3\:GNb \4\:GNb) resistor r=81.0213 c=0
Rl51 (GNb \2\:GNb) resistor r=66.5405 c=0
Rl50 (\30\:Qint \31\:Qint) resistor r=149.233 c=0
Rl49 (\30\:Qint \29\:Qint) resistor r=66.8618 c=0
Rl28 (\14\:Qint Qint) resistor r=50.0953 c=0
Rl53 (GNbb \2\:GNbb) resistor r=106.925 c=0
Rl54 (\2\:GNbb \3\:GNbb) resistor r=178.4 c=0
Rz11 (\2\:VDD \1\:VDD) resistor r=37.5 c=0
Rz12 (\4\:VDD \1\:VDD) resistor r=3.125 c=0
Rz14 (\15\:VSS \14\:VSS) resistor r=75 c=0
Rz9 (\11\:GNb \12\:GNb) resistor r=75 c=0
Rz7 (\33\:Qint \32\:Qint) resistor r=75 c=0
Rz8 (\13\:n0 \12\:n0) resistor r=75 c=0
Rz10 (\6\:GNbb \7\:GNbb) resistor r=75 c=0
Ry13 (\6\:VDD \5\:VDD) resistor r=62 c=0
Ry22 (\2\:VSS \1\:VSS) resistor r=31 c=0
Ry24 (\4\:VSS \1\:VSS) resistor r=2.5833 c=0
Ry11 (\15\:GNb \16\:GNb) resistor r=62 c=0
Ry9 (\39\:Qint \38\:Qint) resistor r=31 c=0
Ry10 (\9\:n0 \8\:n0) resistor r=62 c=0
Ry12 (\4\:GNbb \5\:GNbb) resistor r=62 c=0
Rx6 (\2\:D \4\:D) resistor r=45 c=0
Rx1 (\2\:GN \4\:GN) resistor r=45 c=0
Rx7 (\4\:GNb \8\:GNb) resistor r=45 c=0
Rx8 (\7\:GNb \13\:GNb) resistor r=45 c=0
Rx9 (\2\:GNb \14\:GNb) resistor r=45 c=0
Rx2 (\20\:Qbint Qbint) resistor r=45 c=0
Rx3 (\36\:Qint Qint) resistor r=45 c=0
Rx4 (\37\:Qint \30\:Qint) resistor r=45 c=0
Rx5 (\11\:n0 n0) resistor r=45 c=0
Rx10 (\2\:GNbb \8\:GNbb) resistor r=45 c=0
mn0 (\11\:GNb \3\:GN \4\:VSS VSS) g45n1hvt w=(1.45e-07) l=4.5e-08 nf=1 \
        as=1.0175e-13 ad=2.03e-14 ps=1.6e-06 pd=5.7e-07 nrd=1.16667 \
        nrs=1.16667 sa=1.4e-07 sb=2e-06 sd=160n sca=13.253 scb=0.0137915 \
        scc=0.000695334 m=(1)
mn15 (net245 \29\:Qint \4\:VSS VSS) g45n1hvt w=(1.45e-07) l=4.5e-08 nf=1 \
        as=9.432e-14 ad=8.7e-15 ps=1.6e-06 pd=4.1e-07 nrd=1.16667 \
        nrs=1.16667 sa=2e-06 sb=8.9e-07 sd=160n sca=13.253 scb=0.0137915 \
        scc=0.000695334 m=(1)
mn16 (\12\:n0 \3\:GNbb net245 VSS) g45n1hvt w=(1.45e-07) l=4.5e-08 nf=1 \
        as=8.7e-15 ad=2.32e-14 ps=4.1e-07 pd=6.1e-07 nrd=1.16667 \
        nrs=1.16667 sa=2e-06 sb=7.85e-07 sd=160n sca=13.253 scb=0.0137915 \
        scc=0.000695334 m=(1)
mn6 (\12\:n0 \3\:GNb net257 VSS) g45n1hvt w=(1.45e-07) l=4.5e-08 nf=1 \
        as=1.45e-14 ad=2.32e-14 ps=4.9e-07 pd=6.1e-07 nrd=1.16667 \
        nrs=1.16667 sa=2e-06 sb=5.8e-07 sd=160n sca=13.253 scb=0.0137915 \
        scc=0.000695334 m=(1)
mn5 (net257 \3\:D \14\:VSS VSS) g45n1hvt w=(1.45e-07) l=4.5e-08 nf=1 \
        as=7.825e-14 ad=1.45e-14 ps=1.49e-06 pd=4.9e-07 nrd=1.16667 \
        nrs=1.16667 sa=2e-06 sb=4.35e-07 sd=160n sca=13.253 scb=0.0137915 \
        scc=0.000695334 m=(1)
mn1 (\6\:GNbb \6\:GNb \14\:VSS VSS) g45n1hvt w=(1.45e-07) l=4.5e-08 nf=1 \
        as=7.825e-14 ad=2.03e-14 ps=1.49e-06 pd=5.7e-07 nrd=1.16667 \
        nrs=1.16667 sa=2e-06 sb=1.4e-07 sd=160n sca=13.253 scb=0.0137915 \
        scc=0.000695334 m=(1)
mn22_1__rcx (\1\:QN Qint \4\:VSS VSS) g45n1hvt w=(2.6e-07) l=4.5e-08 \
        nf=1 as=8.471e-14 ad=4.16e-14 ps=1.43e-06 pd=8.4e-07 nrd=1.16667 \
        nrs=1.16667 sa=2e-06 sb=1.61721e-06 sd=160n sca=10.79 \
        scb=0.0100512 scc=0.000418069 m=(4)
mn21_1__rcx (\4\:Q Qbint \4\:VSS VSS) g45n1hvt w=(2.6e-07) l=4.5e-08 \
        nf=1 as=8.949e-14 ad=4.16e-14 ps=1.4725e-06 pd=8.4e-07 nrd=1.16667 \
        nrs=1.16667 sa=3.86058e-07 sb=2e-06 sd=160n sca=10.79 \
        scb=0.0100512 scc=0.000418069 m=(4)
mn20_1__rcx (\15\:Qbint \14\:Qint \4\:VSS VSS) g45n1hvt w=(2.6e-07) \
        l=4.5e-08 nf=1 as=8.54e-14 ad=4.16e-14 ps=1.43e-06 pd=8.4e-07 \
        nrd=1.16667 nrs=1.16667 sa=1.32606e-06 sb=1.95452e-06 sd=160n \
        sca=10.79 scb=0.0100512 scc=0.000418069 m=(4)
mn10_1__rcx (\32\:Qint n0 \4\:VSS VSS) g45n1hvt w=(2.05e-07) l=4.5e-08 \
        nf=1 as=8.849e-14 ad=3.28e-14 ps=1.515e-06 pd=7.3e-07 nrd=1.16667 \
        nrs=1.16667 sa=2e-06 sb=1.15671e-06 sd=160n sca=11.814 \
        scb=0.0116374 scc=0.000520744 m=(2)
mp21_1__rcx (\1\:Q Qbint \4\:VDD VDD) g45p1hvt w=(3.9e-07) l=4.5e-08 \
        nf=1 as=6.606e-14 ad=6.24e-14 ps=1.13e-06 pd=1.1e-06 nrd=1.16667 \
        nrs=1.16667 sa=2.69551e-07 sb=2e-06 sd=160n sca=19.4622 \
        scb=0.0164993 scc=0.00171566 m=(4)
mp20_1__rcx (\21\:Qbint \14\:Qint \4\:VDD VDD) g45p1hvt w=(3.9e-07) \
        l=4.5e-08 nf=1 as=6.532e-14 ad=6.24e-14 ps=1.115e-06 pd=1.1e-06 \
        nrd=1.16667 nrs=1.16667 sa=1.11955e-06 sb=1.92308e-06 sd=160n \
        sca=19.0259 scb=0.0163587 scc=0.00171562 m=(4)
mp22 (QN Qint \4\:VDD VDD) g45p1hvt w=(3.9e-07) l=4.5e-08 nf=1 \
        as=6.432e-14 ad=7.215e-14 ps=1.115e-06 pd=1.15e-06 nrd=1.16667 \
        nrs=1.16667 sa=1.91474e-06 sb=1.57096e-06 sd=160n sca=19.0259 \
        scb=0.0163587 scc=0.00171562 m=(4)
mp10 (\38\:Qint n0 \4\:VDD VDD) g45p1hvt w=(3.1e-07) l=4.5e-08 nf=1 \
        as=8.04e-14 ad=4.96e-14 ps=1.25e-06 pd=9.4e-07 nrd=1.16667 \
        nrs=1.16667 sa=2e-06 sb=1.19806e-06 sd=160n sca=13.6224 \
        scb=0.0125368 scc=0.000630866 m=(2)
ends TLATNX4
// End of subcircuit definition.
