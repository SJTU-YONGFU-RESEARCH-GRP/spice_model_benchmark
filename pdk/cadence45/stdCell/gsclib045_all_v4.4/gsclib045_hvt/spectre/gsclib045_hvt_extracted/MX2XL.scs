// Generated for: spectre (May  1 09:16:51 2013 )
// Library name: gsclib045_hvt
// Cell name: MX2XL
// View name: extracted

simulator lang=spectre

subckt MX2XL A B S0 VDD VSS Y
mp0 (\10\:S0b \1\:S0 \6\:VDD VDD) g45p1hvt w=(2.15e-07) l=4.5e-08 nf=1 \
        as=3.44e-14 ad=3.01e-14 ps=7.5e-07 pd=7.1e-07 nrd=1.16667 \
        nrs=1.16667 sa=1.4e-07 sb=1.03e-06 sd=160n sca=24.6667 \
        scb=0.0279468 scc=0.00158007 m=(1)
mp1 (n4 \1\:A \6\:VDD VDD) g45p1hvt w=(2.15e-07) l=4.5e-08 nf=1 \
        as=3.44e-14 ad=1.613e-14 ps=7.5e-07 pd=5.8e-07 nrd=1.16667 \
        nrs=1.16667 sa=3.45e-07 sb=8.25e-07 sd=160n sca=14.6329 \
        scb=0.0132741 scc=0.000215448 m=(1)
mp2 (\9\:n0 \6\:S0 n4 VDD) g45p1hvt w=(2.15e-07) l=4.5e-08 nf=1 \
        as=1.613e-14 ad=3.548e-14 ps=5.8e-07 pd=7.6e-07 nrd=1.16667 \
        nrs=1.16667 sa=4.65e-07 sb=7.05e-07 sd=160n sca=13.1421 \
        scb=0.0105991 scc=0.000178477 m=(1)
mp4 (\9\:n0 \3\:S0b n6 VDD) g45p1hvt w=(2.15e-07) l=4.5e-08 nf=1 \
        as=2.258e-14 ad=3.548e-14 ps=6.4e-07 pd=7.6e-07 nrd=1.16667 \
        nrs=1.16667 sa=6.75e-07 sb=4.95e-07 sd=160n sca=12.581 \
        scb=0.00966143 scc=0.000174195 m=(1)
mp3 (n6 \4\:B \1\:VDD VDD) g45p1hvt w=(2.15e-07) l=4.5e-08 nf=1 \
        as=3.44e-14 ad=2.258e-14 ps=7.5e-07 pd=6.4e-07 nrd=1.16667 \
        nrs=1.16667 sa=8.25e-07 sb=3.45e-07 sd=160n sca=13.2602 \
        scb=0.0108078 scc=0.000179977 m=(1)
mp5 (\1\:Y n0 \1\:VDD VDD) g45p1hvt w=(2.15e-07) l=4.5e-08 nf=1 \
        as=3.44e-14 ad=3.01e-14 ps=7.5e-07 pd=7.1e-07 nrd=1.16667 \
        nrs=1.16667 sa=1.03e-06 sb=1.4e-07 sd=160n sca=17.479 \
        scb=0.0182451 scc=0.000415696 m=(1)
C1 (S0 VSS) capacitor c=4.21635e-17
C2 (Y VSS) capacitor c=5.97795e-17
C3 (VDD VSS) capacitor c=1.41782e-16
C4 (B VSS) capacitor c=4.16681e-17
C5 (S0b VSS) capacitor c=5.07525e-17
C6 (n0 VSS) capacitor c=2.99106e-17
C7 (n5 VSS) capacitor c=2.33876e-18
C8 (n6 VSS) capacitor c=3.31583e-18
C9 (\4\:B VSS) capacitor c=8.18783e-17
C10 (\3\:S0b VSS) capacitor c=4.41917e-17
C11 (\6\:S0 VSS) capacitor c=5.84257e-17
C12 (\1\:A VSS) capacitor c=7.29592e-17
C13 (\1\:S0 VSS) capacitor c=3.03229e-17
C14 (\4\:n0 VSS) capacitor c=6.40071e-17
C15 (\3\:B VSS) capacitor c=3.58965e-17
C16 (\4\:S0 VSS) capacitor c=6.34834e-17
C17 (\3\:A VSS) capacitor c=5.97168e-17
C18 (\3\:S0 VSS) capacitor c=4.95774e-17
C19 (\3\:n0 VSS) capacitor c=2.69303e-17
C20 (\1\:B VSS) capacitor c=2.7807e-17
C21 (\4\:S0b VSS) capacitor c=4.70346e-17
C22 (\2\:S0b VSS) capacitor c=3.92753e-17
C23 (\5\:S0 VSS) capacitor c=8.78504e-17
C24 (\2\:A VSS) capacitor c=6.7301e-17
C25 (\2\:S0 VSS) capacitor c=4.27888e-17
C26 (\1\:Y VSS) capacitor c=7.24362e-17
C27 (\1\:VDD VSS) capacitor c=3.64848e-17
C28 (\9\:n0 VSS) capacitor c=2.75e-17
C29 (\6\:VDD VSS) capacitor c=3.60742e-17
C30 (\10\:S0b VSS) capacitor c=7.19169e-17
C31 (\3\:Y VSS) capacitor c=1.96505e-17
C32 (\7\:n0 VSS) capacitor c=1.20966e-16
C33 (\8\:S0b VSS) capacitor c=1.93391e-17
C34 (\2\:B VSS) capacitor c=4.4162e-17
C35 (\2\:n0 VSS) capacitor c=2.92215e-17
C36 (\5\:A VSS) capacitor c=4.7481e-17
C37 (\6\:A VSS) capacitor c=4.1063e-17
C38 (\7\:S0 VSS) capacitor c=4.09847e-17
C39 (\8\:S0 VSS) capacitor c=7.11238e-17
C40 (\5\:S0b VSS) capacitor c=8.54158e-17
C41 (\6\:S0b VSS) capacitor c=1.1077e-16
C42 (\7\:S0b VSS) capacitor c=7.5337e-17
C43 (\5\:n0 VSS) capacitor c=4.40488e-17
C44 (\6\:n0 VSS) capacitor c=9.38087e-17
C45 (\5\:B VSS) capacitor c=4.78823e-17
C46 (\4\:VDD VSS) capacitor c=3.70654e-17
C47 (\5\:VDD VSS) capacitor c=7.32806e-18
Rk4 (\7\:S0 S0) resistor r=0.1314 c=0
Rk5 (S0 \8\:S0) resistor r=0.1615 c=0
Rk14 (\2\:Y Y) resistor r=0.5118 c=0
Rk15 (Y \4\:Y) resistor r=0.05349 c=0
Rk1 (\4\:A \5\:A) resistor r=0.01269 c=0
Rk2 (A \6\:A) resistor r=0.01254 c=0
Rk3 (\4\:A \6\:A) resistor r=0.03203 c=0
Rk20 (\2\:VSS \4\:VSS) resistor r=0.4231 c=0
Rk22 (\5\:VSS VSS) resistor r=0.1025 c=0
Rk21 (\4\:VSS \5\:VSS) resistor r=0.1981 c=0
Rk23 (\5\:VSS \7\:VSS) resistor r=0.278 c=0
Rk16 (\2\:VDD \4\:VDD) resistor r=0.4143 c=0
Rk18 (\5\:VDD VDD) resistor r=0.1025 c=0
Rk17 (\4\:VDD \5\:VDD) resistor r=0.1981 c=0
Rk19 (\5\:VDD \7\:VDD) resistor r=0.2712 c=0
Rk13 (B \5\:B) resistor r=0.07283 c=0
Rk6 (\5\:S0b \6\:S0b) resistor r=0.3322 c=0
Rk7 (\6\:S0b \7\:S0b) resistor r=0.3175 c=0
Rk8 (\7\:S0b \9\:S0b) resistor r=0.1206 c=0
Rk9 (\7\:S0b \11\:S0b) resistor r=0.5113 c=0
Rk10 (\5\:n0 \6\:n0) resistor r=0.1792 c=0
Rk11 (\6\:n0 \8\:n0) resistor r=0.6176 c=0
Rk12 (\6\:n0 \10\:n0) resistor r=0.2318 c=0
Rl7 (\5\:S0 \6\:S0) resistor r=79.9442 c=0
Rl6 (\4\:S0 \5\:S0) resistor r=169.15 c=0
Rl1 (\1\:S0 \2\:S0) resistor r=26.098 c=0
Rl2 (\2\:S0 \3\:S0) resistor r=176.098 c=0
Rl3 (\1\:A \2\:A) resistor r=129.538 c=0
Rl4 (\2\:A \3\:A) resistor r=79.5379 c=0
Rl11 (\2\:B \4\:B) resistor r=174.714 c=0
Rl10 (\2\:B \3\:B) resistor r=51.6372 c=0
Rl9 (\1\:B \2\:B) resistor r=2.0213 c=0
Rl8 (\3\:S0b \4\:S0b) resistor r=42.9995 c=0
Rl5 (S0b \2\:S0b) resistor r=29.5379 c=0
Rl12 (n0 \2\:n0) resistor r=35.0798 c=0
Rl14 (\2\:n0 \4\:n0) resistor r=190.849 c=0
Rl13 (\2\:n0 \3\:n0) resistor r=0.8823 c=0
Rz3 (\3\:Y \4\:Y) resistor r=75 c=0
Rz5 (\1\:VSS \2\:VSS) resistor r=75 c=0
Rz6 (\6\:VSS \7\:VSS) resistor r=75 c=0
Rz1 (\8\:S0b \9\:S0b) resistor r=75 c=0
Rz2 (\7\:n0 \8\:n0) resistor r=75 c=0
Ry3 (\1\:Y \2\:Y) resistor r=62 c=0
Ry4 (\1\:VDD \2\:VDD) resistor r=62 c=0
Ry5 (\6\:VDD \7\:VDD) resistor r=62 c=0
Ry1 (\10\:S0b \11\:S0b) resistor r=62 c=0
Ry2 (\9\:n0 \10\:n0) resistor r=62 c=0
Rx2 (\5\:S0 \7\:S0) resistor r=45 c=0
Rx3 (\2\:S0 \8\:S0) resistor r=45 c=0
Rx1 (\2\:A \5\:A) resistor r=45 c=0
Rx7 (\1\:B \5\:B) resistor r=45 c=0
Rx4 (\4\:S0b \5\:S0b) resistor r=45 c=0
Rx5 (\2\:S0b \6\:S0b) resistor r=45 c=0
Rx6 (\3\:n0 \5\:n0) resistor r=45 c=0
mn0 (\8\:S0b \3\:S0 \6\:VSS VSS) g45n1hvt w=(1.45e-07) l=4.5e-08 nf=1 \
        as=2.32e-14 ad=2.03e-14 ps=6.1e-07 pd=5.7e-07 nrd=1.16667 \
        nrs=1.16667 sa=1.4e-07 sb=1.03e-06 sd=160n sca=10.2779 \
        scb=0.00944477 scc=0.000275883 m=(1)
mn1 (n3 \3\:A \6\:VSS VSS) g45n1hvt w=(1.45e-07) l=4.5e-08 nf=1 \
        as=2.32e-14 ad=9.42e-15 ps=6.1e-07 pd=4.2e-07 nrd=1.16667 \
        nrs=1.16667 sa=3.45e-07 sb=8.25e-07 sd=160n sca=10.2779 \
        scb=0.00944477 scc=0.000275883 m=(1)
mn2 (\7\:n0 S0b n3 VSS) g45n1hvt w=(1.45e-07) l=4.5e-08 nf=1 as=9.42e-15 \
        ad=2.32e-14 ps=4.2e-07 pd=6.1e-07 nrd=1.16667 nrs=1.16667 \
        sa=4.55e-07 sb=7.15e-07 sd=160n sca=10.2779 scb=0.00944477 \
        scc=0.000275883 m=(1)
mn4 (\7\:n0 \4\:S0 n5 VSS) g45n1hvt w=(1.45e-07) l=4.5e-08 nf=1 \
        as=1.74e-14 ad=2.32e-14 ps=5.3e-07 pd=6.1e-07 nrd=1.16667 \
        nrs=1.16667 sa=6.6e-07 sb=5.1e-07 sd=160n sca=10.2779 \
        scb=0.00944477 scc=0.000275883 m=(1)
mn3 (n5 \3\:B \1\:VSS VSS) g45n1hvt w=(1.45e-07) l=4.5e-08 nf=1 \
        as=2.32e-14 ad=1.74e-14 ps=6.1e-07 pd=5.3e-07 nrd=1.16667 \
        nrs=1.16667 sa=8.25e-07 sb=3.45e-07 sd=160n sca=10.2779 \
        scb=0.00944477 scc=0.000275883 m=(1)
mn5 (\3\:Y \4\:n0 \1\:VSS VSS) g45n1hvt w=(1.45e-07) l=4.5e-08 nf=1 \
        as=2.32e-14 ad=2.03e-14 ps=6.1e-07 pd=5.7e-07 nrd=1.16667 \
        nrs=1.16667 sa=1.03e-06 sb=1.4e-07 sd=160n sca=10.2779 \
        scb=0.00944477 scc=0.000275883 m=(1)
ends MX2XL
// End of subcircuit definition.
