// Generated for: spectre (May  1 09:16:02 2013 )
// Library name: gsclib045_hvt
// Cell name: SDFFSXL
// View name: extracted

simulator lang=spectre

subckt SDFFSXL CK D Q QN SE SI SN VDD VSS
mp57 (\1\:QN net492 \26\:VDD VDD) g45p1hvt w=(2.15e-07) l=4.5e-08 nf=1 \
        as=5.697e-14 ad=3.65e-14 ps=9.6e-07 pd=8.8e-07 nrd=1.16667 \
        nrs=1.16667 sa=2.65e-07 sb=1.69767e-07 sd=160n sca=23.1398 \
        scb=0.0253243 scc=0.00148794 m=(1)
mp56 (\7\:net492 \5\:qbint \24\:VDD VDD) g45p1hvt w=(2.15e-07) l=4.5e-08 \
        nf=1 as=3.44e-14 ad=2.63e-14 ps=7.5e-07 pd=7.1e-07 nrd=1.16667 \
        nrs=1.16667 sa=1.22326e-07 sb=3.33256e-07 sd=160n sca=46.2604 \
        scb=0.0284877 scc=0.00588421 m=(1)
mp55 (\3\:Q qbint \24\:VDD VDD) g45p1hvt w=(2.15e-07) l=4.5e-08 nf=1 \
        as=3.44e-14 ad=2.758e-14 ps=7.5e-07 pd=7.2e-07 nrd=1.16667 \
        nrs=1.16667 sa=3.27326e-07 sb=1.28256e-07 sd=160n sca=45.7906 \
        scb=0.0283307 scc=0.00588417 m=(1)
mp45 (\15\:qbint \3\:n35 \22\:VDD VDD) g45p1hvt w=(2.15e-07) l=4.5e-08 \
        nf=1 as=4.085e-14 ad=3.01e-14 ps=8.1e-07 pd=7.1e-07 nrd=1.16667 \
        nrs=1.16667 sa=1.4e-07 sb=5.95e-07 sd=160n sca=10.1345 \
        scb=0.00732736 scc=7.25592e-05 m=(1)
mp50 (\3\:net405 \3\:SN \22\:VDD VDD) g45p1hvt w=(2.15e-07) l=4.5e-08 \
        nf=1 as=4.085e-14 ad=3.763e-14 ps=8.1e-07 pd=7.8e-07 nrd=1.16667 \
        nrs=1.16667 sa=3.75e-07 sb=3.6e-07 sd=160n sca=10.1345 \
        scb=0.00732736 scc=7.25592e-05 m=(1)
mp51 (\3\:net405 \8\:qbint \20\:VDD VDD) g45p1hvt w=(2.15e-07) l=4.5e-08 \
        nf=1 as=3.01e-14 ad=3.763e-14 ps=7.1e-07 pd=7.8e-07 nrd=1.16667 \
        nrs=1.16667 sa=5.95e-07 sb=1.4e-07 sd=160n sca=10.1345 \
        scb=0.00732736 scc=7.25592e-05 m=(1)
mp52 (\5\:n35 \4\:CKbb net405 VDD) g45p1hvt w=(2.15e-07) l=4.5e-08 nf=1 \
        as=3.01e-14 ad=3.44e-14 ps=7.1e-07 pd=7.5e-07 nrd=1.16667 \
        nrs=1.16667 sa=1.4e-07 sb=3.45e-07 sd=160n sca=15.2551 \
        scb=0.0150251 scc=0.000885438 m=(1)
mp40 (\5\:n35 \4\:CKb \11\:mout VDD) g45p1hvt w=(2.15e-07) l=4.5e-08 nf=1 \
        as=3.01e-14 ad=3.44e-14 ps=7.1e-07 pd=7.5e-07 nrd=1.16667 \
        nrs=1.16667 sa=3.45e-07 sb=1.4e-07 sd=160n sca=15.2551 \
        scb=0.0150251 scc=0.000885438 m=(1)
mp21 (\13\:CKbb \2\:CKb \18\:VDD VDD) g45p1hvt w=(2.15e-07) l=4.5e-08 \
        nf=1 as=1.019e-13 ad=3.01e-14 ps=1.78e-06 pd=7.1e-07 nrd=1.16667 \
        nrs=1.16667 sa=1.4e-07 sb=1.49e-06 sd=160n sca=23.7894 \
        scb=0.0219499 scc=0.00260958 m=(1)
mp30 (\7\:mout \4\:SN \18\:VDD VDD) g45p1hvt w=(2.15e-07) l=4.5e-08 nf=1 \
        as=1.019e-13 ad=4.945e-14 ps=1.78e-06 pd=8.9e-07 nrd=1.16667 \
        nrs=1.16667 sa=4.05e-07 sb=1.225e-06 sd=160n sca=23.7894 \
        scb=0.0219499 scc=0.00260958 m=(1)
mp31 (\7\:mout n20 \16\:VDD VDD) g45p1hvt w=(2.15e-07) l=4.5e-08 nf=1 \
        as=1.0943e-13 ad=4.945e-14 ps=1.85e-06 pd=8.9e-07 nrd=1.16667 \
        nrs=1.16667 sa=6.8e-07 sb=9.5e-07 sd=160n sca=23.7894 \
        scb=0.0219499 scc=0.00260958 m=(1)
mp35 (net417 mout \16\:VDD VDD) g45p1hvt w=(2.15e-07) l=4.5e-08 nf=1 \
        as=1.0943e-13 ad=1.29e-14 ps=1.85e-06 pd=5.5e-07 nrd=1.16667 \
        nrs=1.16667 sa=9.8e-07 sb=6.5e-07 sd=160n sca=23.7894 \
        scb=0.0219499 scc=0.00260958 m=(1)
mp36 (\4\:n20 \7\:CKb net417 VDD) g45p1hvt w=(2.15e-07) l=4.5e-08 nf=1 \
        as=1.29e-14 ad=5.268e-14 ps=5.5e-07 pd=9.2e-07 nrd=1.16667 \
        nrs=1.16667 sa=1.085e-06 sb=5.45e-07 sd=160n sca=23.7894 \
        scb=0.0219499 scc=0.00260958 m=(1)
mp25 (\4\:n20 \5\:CKbb \4\:Db VDD) g45p1hvt w=(2.15e-07) l=4.5e-08 nf=1 \
        as=5.483e-14 ad=5.268e-14 ps=9.4e-07 pd=9.2e-07 nrd=1.16667 \
        nrs=1.16667 sa=1.375e-06 sb=2.55e-07 sd=160n sca=23.7894 \
        scb=0.0219499 scc=0.00260958 m=(1)
mp20 (\11\:CKb \1\:CK \14\:VDD VDD) g45p1hvt w=(2.15e-07) l=4.5e-08 nf=1 \
        as=3.44e-14 ad=3.01e-14 ps=7.5e-07 pd=7.1e-07 nrd=1.16667 \
        nrs=1.16667 sa=1.4e-07 sb=1.145e-06 sd=160n sca=10.2104 \
        scb=0.00747301 scc=8.05149e-05 m=(1)
mp11 (net433 \1\:D \14\:VDD VDD) g45p1hvt w=(2.15e-07) l=4.5e-08 nf=1 \
        as=3.44e-14 ad=2.58e-14 ps=7.5e-07 pd=6.7e-07 nrd=1.16667 \
        nrs=1.16667 sa=3.45e-07 sb=9.4e-07 sd=160n sca=10.2104 \
        scb=0.00747301 scc=8.05149e-05 m=(1)
mp12 (\6\:Db \1\:SE net433 VDD) g45p1hvt w=(2.15e-07) l=4.5e-08 nf=1 \
        as=2.58e-14 ad=3.44e-14 ps=6.7e-07 pd=7.5e-07 nrd=1.16667 \
        nrs=1.16667 sa=5.1e-07 sb=7.75e-07 sd=160n sca=10.4041 \
        scb=0.00751939 scc=8.05211e-05 m=(1)
mp14 (\6\:Db \4\:SEb net441 VDD) g45p1hvt w=(2.15e-07) l=4.5e-08 nf=1 \
        as=3.87e-14 ad=3.44e-14 ps=7.9e-07 pd=7.5e-07 nrd=1.16667 \
        nrs=1.16667 sa=7.15e-07 sb=5.7e-07 sd=160n sca=11.1447 \
        scb=0.00794267 scc=8.08728e-05 m=(1)
mp13 (net441 \3\:SI \1\:VDD VDD) g45p1hvt w=(2.15e-07) l=4.5e-08 nf=1 \
        as=3.44e-14 ad=3.87e-14 ps=7.5e-07 pd=7.9e-07 nrd=1.16667 \
        nrs=1.16667 sa=9.4e-07 sb=3.45e-07 sd=160n sca=13.2217 \
        scb=0.0107547 scc=0.000102805 m=(1)
mp10 (\9\:SEb \8\:SE \1\:VDD VDD) g45p1hvt w=(2.15e-07) l=4.5e-08 nf=1 \
        as=3.44e-14 ad=3.01e-14 ps=7.5e-07 pd=7.1e-07 nrd=1.16667 \
        nrs=1.16667 sa=1.145e-06 sb=1.4e-07 sd=160n sca=20.617 \
        scb=0.0226642 scc=0.000873207 m=(1)
C1 (Q VSS) capacitor c=2.19031e-17
C2 (CK VSS) capacitor c=5.18167e-17
C3 (SE VSS) capacitor c=5.04096e-17
C4 (SN VSS) capacitor c=1.85388e-16
C5 (SI VSS) capacitor c=5.05737e-17
C6 (VDD VSS) capacitor c=4.35397e-16
C7 (QN VSS) capacitor c=4.92474e-17
C8 (D VSS) capacitor c=7.78348e-17
C9 (net492 VSS) capacitor c=2.94883e-17
C10 (qbint VSS) capacitor c=1.5556e-17
C11 (n35 VSS) capacitor c=3.31787e-17
C12 (net518 VSS) capacitor c=1.75078e-18
C13 (CKb VSS) capacitor c=1.59703e-17
C14 (mout VSS) capacitor c=7.35231e-17
C15 (CKbb VSS) capacitor c=2.77098e-17
C16 (net442 VSS) capacitor c=2.18407e-18
C17 (n20 VSS) capacitor c=3.38079e-17
C18 (net478 VSS) capacitor c=1.42439e-18
C19 (Db VSS) capacitor c=9.05445e-17
C20 (net494 VSS) capacitor c=5.02687e-18
C21 (net405 VSS) capacitor c=7.35297e-17
C22 (\8\:SE VSS) capacitor c=5.31407e-17
C23 (\3\:SI VSS) capacitor c=5.43391e-17
C24 (\4\:SEb VSS) capacitor c=3.36863e-17
C25 (\1\:SE VSS) capacitor c=4.72804e-17
C26 (\1\:D VSS) capacitor c=7.25133e-17
C27 (\1\:CK VSS) capacitor c=4.25523e-17
C28 (\5\:CKbb VSS) capacitor c=4.66689e-17
C29 (\7\:CKb VSS) capacitor c=7.28715e-17
C30 (\4\:SN VSS) capacitor c=6.79327e-17
C31 (\2\:CKb VSS) capacitor c=4.14238e-17
C32 (\4\:CKb VSS) capacitor c=1.05133e-16
C33 (\4\:CKbb VSS) capacitor c=6.75554e-17
C34 (\8\:qbint VSS) capacitor c=6.92321e-17
C35 (\3\:SN VSS) capacitor c=4.836e-17
C36 (\3\:n35 VSS) capacitor c=5.28435e-17
C37 (\5\:qbint VSS) capacitor c=1.97159e-17
C38 (\5\:SE VSS) capacitor c=3.08675e-17
C39 (\1\:SI VSS) capacitor c=7.65589e-17
C40 (\3\:SE VSS) capacitor c=6.51009e-17
C41 (\3\:SEb VSS) capacitor c=7.48671e-17
C42 (\3\:D VSS) capacitor c=2.3709e-17
C43 (\3\:CK VSS) capacitor c=3.52286e-17
C44 (\9\:CKb VSS) capacitor c=3.65893e-17
C45 (\7\:CKbb VSS) capacitor c=4.15858e-17
C46 (\4\:mout VSS) capacitor c=4.35208e-17
C47 (\3\:n20 VSS) capacitor c=5.41937e-17
C48 (\5\:SN VSS) capacitor c=5.09777e-17
C49 (\6\:CKb VSS) capacitor c=4.31184e-17
C50 (\3\:CKbb VSS) capacitor c=3.07058e-17
C51 (\5\:CKb VSS) capacitor c=1.10805e-16
C52 (\10\:qbint VSS) capacitor c=4.06764e-17
C53 (\1\:SN VSS) capacitor c=5.63438e-17
C54 (\6\:qbint VSS) capacitor c=1.28263e-17
C55 (\7\:qbint VSS) capacitor c=1.26671e-17
C56 (\3\:net492 VSS) capacitor c=1.70384e-17
C57 (\7\:SE VSS) capacitor c=6.05986e-17
C58 (\2\:SI VSS) capacitor c=7.34033e-17
C59 (\4\:SE VSS) capacitor c=5.40625e-17
C60 (\2\:SE VSS) capacitor c=4.47928e-17
C61 (\2\:D VSS) capacitor c=4.19605e-17
C62 (\2\:CK VSS) capacitor c=4.15132e-17
C63 (\10\:CKb VSS) capacitor c=2.6974e-17
C64 (\8\:CKb VSS) capacitor c=2.59152e-17
C65 (\6\:CKbb VSS) capacitor c=6.46316e-17
C66 (\3\:mout VSS) capacitor c=1.64653e-17
C67 (\2\:n20 VSS) capacitor c=4.26956e-17
C68 (\6\:SN VSS) capacitor c=2.7308e-17
C69 (\9\:qbint VSS) capacitor c=6.86292e-17
C70 (\2\:SN VSS) capacitor c=9.18415e-17
C71 (\3\:qbint VSS) capacitor c=4.32805e-18
C72 (\2\:net492 VSS) capacitor c=2.17792e-17
C73 (\9\:SEb VSS) capacitor c=1.36929e-17
C74 (\1\:VDD VSS) capacitor c=3.11601e-17
C75 (\6\:Db VSS) capacitor c=4.80266e-17
C76 (\14\:VDD VSS) capacitor c=3.61195e-17
C77 (\11\:CKb VSS) capacitor c=6.86538e-17
C78 (\4\:Db VSS) capacitor c=1.30678e-16
C79 (\4\:n20 VSS) capacitor c=2.78368e-17
C80 (\16\:VDD VSS) capacitor c=1.4258e-17
C81 (\7\:mout VSS) capacitor c=8.48768e-17
C82 (\18\:VDD VSS) capacitor c=1.8909e-17
C83 (\13\:CKbb VSS) capacitor c=5.34828e-17
C84 (\11\:mout VSS) capacitor c=1.40724e-16
C85 (\5\:n35 VSS) capacitor c=4.41138e-17
C86 (\20\:VDD VSS) capacitor c=3.35012e-17
C87 (\3\:net405 VSS) capacitor c=8.8825e-17
C88 (\22\:VDD VSS) capacitor c=1.29139e-17
C89 (\15\:qbint VSS) capacitor c=5.32195e-17
C90 (\3\:Q VSS) capacitor c=3.71721e-17
C91 (\24\:VDD VSS) capacitor c=5.11291e-17
C92 (\7\:net492 VSS) capacitor c=5.39503e-17
C93 (\1\:QN VSS) capacitor c=4.51677e-17
C94 (\26\:VDD VSS) capacitor c=1.55542e-17
C95 (\3\:VDD VSS) capacitor c=6.23495e-17
C96 (\5\:SEb VSS) capacitor c=5.16162e-17
C97 (\17\:CKb VSS) capacitor c=7.88695e-17
C98 (\8\:Db VSS) capacitor c=8.0784e-17
C99 (\8\:n20 VSS) capacitor c=6.39489e-17
C100 (\9\:mout VSS) capacitor c=3.09311e-17
C101 (\10\:CKbb VSS) capacitor c=3.63982e-17
C102 (\13\:mout VSS) capacitor c=1.19842e-16
C103 (\9\:n35 VSS) capacitor c=8.93119e-17
C104 (\13\:qbint VSS) capacitor c=6.25919e-17
C105 (\1\:Q VSS) capacitor c=6.1085e-17
C106 (\5\:net492 VSS) capacitor c=8.83026e-17
C107 (\3\:QN VSS) capacitor c=3.81091e-17
C108 (\2\:qbint VSS) capacitor c=6.34944e-18
C109 (\4\:qbint VSS) capacitor c=5.49281e-18
C110 (\2\:n35 VSS) capacitor c=5.29898e-17
C111 (\2\:CKbb VSS) capacitor c=2.87912e-17
C112 (\3\:CKb VSS) capacitor c=2.98268e-17
C113 (\2\:mout VSS) capacitor c=3.90246e-17
C114 (\2\:SEb VSS) capacitor c=7.64609e-17
C115 (\4\:net492 VSS) capacitor c=7.11892e-17
C116 (\11\:qbint VSS) capacitor c=6.2794e-17
C117 (\12\:qbint VSS) capacitor c=8.42862e-17
C118 (\17\:qbint VSS) capacitor c=7.41705e-17
C119 (\7\:n35 VSS) capacitor c=1.38601e-16
C120 (\8\:n35 VSS) capacitor c=1.09904e-16
C121 (\7\:SN VSS) capacitor c=1.62844e-16
C122 (\8\:SN VSS) capacitor c=3.16522e-17
C123 (\5\:mout VSS) capacitor c=6.66907e-17
C124 (\6\:mout VSS) capacitor c=4.66114e-17
C125 (\8\:CKbb VSS) capacitor c=1.59306e-16
C126 (\9\:CKbb VSS) capacitor c=1.2174e-16
C127 (\12\:CKbb VSS) capacitor c=4.18618e-17
C128 (\6\:n20 VSS) capacitor c=7.10206e-17
C129 (\7\:n20 VSS) capacitor c=6.3751e-17
C130 (\4\:CK VSS) capacitor c=4.92807e-17
C131 (\13\:CKb VSS) capacitor c=8.79949e-17
C132 (\14\:CKb VSS) capacitor c=7.94286e-17
C133 (\15\:CKb VSS) capacitor c=1.09191e-16
C134 (\16\:CKb VSS) capacitor c=1.42423e-16
C135 (\4\:D VSS) capacitor c=2.13949e-17
C136 (\3\:Db VSS) capacitor c=1.56327e-16
C137 (\4\:SI VSS) capacitor c=7.32612e-17
C138 (\9\:SE VSS) capacitor c=7.10791e-17
C139 (\10\:SE VSS) capacitor c=7.05234e-17
C140 (\7\:SEb VSS) capacitor c=7.26053e-17
C141 (\8\:SEb VSS) capacitor c=5.70097e-17
C142 (\5\:VDD VSS) capacitor c=3.68296e-17
C143 (\6\:VDD VSS) capacitor c=3.35549e-17
C144 (\8\:VDD VSS) capacitor c=3.08135e-17
C145 (\9\:VDD VSS) capacitor c=3.26209e-17
C146 (\10\:VDD VSS) capacitor c=1.26555e-17
C147 (\12\:VDD VSS) capacitor c=1.02031e-17
C148 (\13\:VDD VSS) capacitor c=7.07542e-18
Rk6 (\4\:Q Q) resistor r=0.04195 c=0
Rk5 (\2\:Q \4\:Q) resistor r=0.219 c=0
Rk29 (\4\:CK CK) resistor r=0.1912 c=0
Rk42 (\9\:SE SE) resistor r=0.1768 c=0
Rk41 (\9\:SE \10\:SE) resistor r=0.4141 c=0
Rk43 (SE \11\:SE) resistor r=0.005694 c=0
Rk15 (\7\:SN SN) resistor r=1.3139 c=0
Rk16 (SN \8\:SN) resistor r=0.09304 c=0
Rk40 (SI \4\:SI) resistor r=0.06453 c=0
Rk62 (\2\:VDD \4\:VDD) resistor r=0.4046 c=0
Rk63 (\4\:VDD \5\:VDD) resistor r=0.2204 c=0
Rk64 (\5\:VDD \6\:VDD) resistor r=0.6689 c=0
Rk65 (\6\:VDD \7\:VDD) resistor r=0.06247 c=0
Rk66 (\7\:VDD \8\:VDD) resistor r=0.2069 c=0
Rk67 (\8\:VDD \9\:VDD) resistor r=0.6027 c=0
Rk68 (\9\:VDD \10\:VDD) resistor r=0.1976 c=0
Rk69 (\10\:VDD \11\:VDD) resistor r=0.1928 c=0
Rk70 (\11\:VDD \12\:VDD) resistor r=0.1602 c=0
Rk72 (\13\:VDD VDD) resistor r=0.0171 c=0
Rk71 (\12\:VDD \13\:VDD) resistor r=0.3731 c=0
Rk73 (\5\:VDD \15\:VDD) resistor r=0.2233 c=0
Rk74 (\6\:VDD \17\:VDD) resistor r=0.07358 c=0
Rk75 (\8\:VDD \19\:VDD) resistor r=0.04328 c=0
Rk76 (\9\:VDD \21\:VDD) resistor r=0.2054 c=0
Rk77 (\10\:VDD \23\:VDD) resistor r=0.21 c=0
Rk78 (\12\:VDD \25\:VDD) resistor r=0.4203 c=0
Rk79 (\13\:VDD \27\:VDD) resistor r=0.3464 c=0
Rk1 (\2\:QN QN) resistor r=0.3587 c=0
Rk2 (QN \4\:QN) resistor r=0.03632 c=0
Rk35 (\4\:D D) resistor r=0.0173 c=0
Rk47 (\2\:VSS \4\:VSS) resistor r=0.4576 c=0
Rk48 (\4\:VSS \5\:VSS) resistor r=0.2755 c=0
Rk49 (\5\:VSS \6\:VSS) resistor r=0.5962 c=0
Rk50 (\6\:VSS \7\:VSS) resistor r=0.08001 c=0
Rk51 (\7\:VSS \8\:VSS) resistor r=0.3347 c=0
Rk52 (\8\:VSS \9\:VSS) resistor r=0.6353 c=0
Rk53 (\9\:VSS \10\:VSS) resistor r=0.2304 c=0
Rk55 (\11\:VSS VSS) resistor r=0.376 c=0
Rk54 (\10\:VSS \11\:VSS) resistor r=0.1753 c=0
Rk56 (VSS \13\:VSS) resistor r=0.3828 c=0
Rk57 (\5\:VSS \15\:VSS) resistor r=0.2721 c=0
Rk58 (\6\:VSS \17\:VSS) resistor r=0.2133 c=0
Rk59 (\8\:VSS \19\:VSS) resistor r=0.04328 c=0
Rk60 (\9\:VSS \21\:VSS) resistor r=0.3058 c=0
Rk61 (\11\:VSS \23\:VSS) resistor r=0.07358 c=0
Rk3 (\4\:net492 \6\:net492) resistor r=0.5929 c=0
Rk4 (\6\:net492 \8\:net492) resistor r=0.2882 c=0
Rk7 (\11\:qbint \12\:qbint) resistor r=0.3563 c=0
Rk8 (\12\:qbint \14\:qbint) resistor r=0.1393 c=0
Rk9 (\12\:qbint \16\:qbint) resistor r=0.4743 c=0
Rk10 (\14\:qbint \17\:qbint) resistor r=0.5678 c=0
Rk12 (\6\:n35 \7\:n35) resistor r=0.2222 c=0
Rk13 (\7\:n35 \8\:n35) resistor r=0.6787 c=0
Rk14 (\7\:n35 \10\:n35) resistor r=0.3893 c=0
Rk30 (\12\:CKb \13\:CKb) resistor r=0.3782 c=0
Rk31 (\13\:CKb \14\:CKb) resistor r=0.2191 c=0
Rk32 (\14\:CKb \15\:CKb) resistor r=0.7001 c=0
Rk33 (\13\:CKb \16\:CKb) resistor r=0.4406 c=0
Rk34 (\16\:CKb \18\:CKb) resistor r=0.587 c=0
Rk17 (\5\:mout \6\:mout) resistor r=0.2914 c=0
Rk18 (\6\:mout \8\:mout) resistor r=0.2281 c=0
Rk19 (\6\:mout \10\:mout) resistor r=0.08248 c=0
Rk20 (\8\:mout \12\:mout) resistor r=0.6494 c=0
Rk21 (\12\:mout \14\:mout) resistor r=0.6934 c=0
Rk22 (\8\:CKbb \9\:CKbb) resistor r=1.0828 c=0
Rk23 (\9\:CKbb \11\:CKbb) resistor r=0.1419 c=0
Rk24 (\11\:CKbb \12\:CKbb) resistor r=0.1094 c=0
Rk25 (\9\:CKbb \14\:CKbb) resistor r=0.2309 c=0
Rk26 (\5\:n20 \6\:n20) resistor r=0.1268 c=0
Rk27 (\6\:n20 \7\:n20) resistor r=0.3778 c=0
Rk28 (\6\:n20 \9\:n20) resistor r=0.295 c=0
Rk36 (\2\:Db \3\:Db) resistor r=0.7297 c=0
Rk37 (\3\:Db \5\:Db) resistor r=0.6165 c=0
Rk38 (\3\:Db \7\:Db) resistor r=0.2388 c=0
Rk39 (\5\:Db \9\:Db) resistor r=0.4123 c=0
Rk44 (\6\:SEb \7\:SEb) resistor r=0.5552 c=0
Rk45 (\7\:SEb \8\:SEb) resistor r=0.3713 c=0
Rk46 (\7\:SEb \10\:SEb) resistor r=0.04767 c=0
Rk11 (\2\:net405 \4\:net405) resistor r=0.3559 c=0
Rl35 (\1\:CK \2\:CK) resistor r=123.054 c=0
Rl36 (\2\:CK \3\:CK) resistor r=136.333 c=0
Rl43 (\3\:SE \4\:SE) resistor r=39.1533 c=0
Rl39 (\1\:SE \2\:SE) resistor r=74.4182 c=0
Rl48 (\6\:SE \8\:SE) resistor r=199.429 c=0
Rl46 (\5\:SE \6\:SE) resistor r=64.8131 c=0
Rl47 (\6\:SE \7\:SE) resistor r=5.0185 c=0
Rl24 (\4\:SN \5\:SN) resistor r=159.181 c=0
Rl25 (\5\:SN \6\:SN) resistor r=26.1559 c=0
Rl13 (\2\:SN \3\:SN) resistor r=111.916 c=0
Rl12 (\1\:SN \2\:SN) resistor r=92.9995 c=0
Rl45 (\2\:SI \3\:SI) resistor r=104.944 c=0
Rl44 (\1\:SI \2\:SI) resistor r=124.175 c=0
Rl37 (\1\:D \2\:D) resistor r=196.846 c=0
Rl38 (\2\:D \3\:D) resistor r=39.1533 c=0
Rl1 (net492 \2\:net492) resistor r=80.0021 c=0
Rl2 (\2\:net492 \3\:net492) resistor r=24.2328 c=0
Rl14 (\8\:qbint \9\:qbint) resistor r=191.541 c=0
Rl15 (\9\:qbint \10\:qbint) resistor r=26.1559 c=0
Rl3 (qbint \2\:qbint) resistor r=40.0987 c=0
Rl7 (\2\:qbint \6\:qbint) resistor r=43.9449 c=0
Rl4 (\2\:qbint \3\:qbint) resistor r=2.0166 c=0
Rl6 (\4\:qbint \5\:qbint) resistor r=53.6427 c=0
Rl8 (\4\:qbint \7\:qbint) resistor r=37.353 c=0
Rl5 (\3\:qbint \4\:qbint) resistor r=34.566 c=0
Rl10 (\2\:n35 \3\:n35) resistor r=165.363 c=0
Rl9 (n35 \2\:n35) resistor r=94.1936 c=0
Rl11 (\2\:n35 \4\:n35) resistor r=16.9983 c=0
Rl22 (\4\:CKb \5\:CKb) resistor r=566.873 c=0
Rl34 (\9\:CKb \10\:CKb) resistor r=35.3072 c=0
Rl31 (\7\:CKb \8\:CKb) resistor r=52.6149 c=0
Rl19 (CKb \2\:CKb) resistor r=50.6918 c=0
Rl20 (\2\:CKb \3\:CKb) resistor r=90.3625 c=0
Rl21 (\3\:CKb \4\:CKb) resistor r=151.901 c=0
Rl23 (\3\:CKb \6\:CKb) resistor r=70.8353 c=0
Rl28 (mout \2\:mout) resistor r=95.0334 c=0
Rl30 (\2\:mout \4\:mout) resistor r=48.8796 c=0
Rl29 (\2\:mout \3\:mout) resistor r=1.2301 c=0
Rl32 (\5\:CKbb \6\:CKbb) resistor r=157.235 c=0
Rl33 (\6\:CKbb \7\:CKbb) resistor r=24.7951 c=0
Rl18 (\2\:CKbb \4\:CKbb) resistor r=132.406 c=0
Rl17 (\2\:CKbb \3\:CKbb) resistor r=36.2526 c=0
Rl16 (CKbb \2\:CKbb) resistor r=21.8724 c=0
Rl26 (n20 \2\:n20) resistor r=24.2328 c=0
Rl27 (\2\:n20 \3\:n20) resistor r=143.029 c=0
Rl42 (\2\:SEb \4\:SEb) resistor r=42.7807 c=0
Rl41 (\2\:SEb \3\:SEb) resistor r=221.283 c=0
Rl40 (SEb \2\:SEb) resistor r=8.3086 c=0
Rz3 (\1\:Q \2\:Q) resistor r=75 c=0
Rz21 (\3\:VDD \4\:VDD) resistor r=10.7143 c=0
Rz22 (\3\:VDD \7\:VDD) resistor r=6.25 c=0
Rz23 (\3\:VDD \11\:VDD) resistor r=6.25 c=0
Rz1 (\3\:QN \4\:QN) resistor r=75 c=0
Rz14 (\1\:VSS \2\:VSS) resistor r=75 c=0
Rz15 (\12\:VSS \13\:VSS) resistor r=75 c=0
Rz16 (\14\:VSS \15\:VSS) resistor r=75 c=0
Rz17 (\16\:VSS \17\:VSS) resistor r=75 c=0
Rz18 (\18\:VSS \19\:VSS) resistor r=75 c=0
Rz19 (\20\:VSS \21\:VSS) resistor r=75 c=0
Rz20 (\22\:VSS \23\:VSS) resistor r=75 c=0
Rz2 (\5\:net492 \6\:net492) resistor r=75 c=0
Rz4 (\13\:qbint \14\:qbint) resistor r=75 c=0
Rz5 (\9\:n35 \10\:n35) resistor r=75 c=0
Rz10 (\17\:CKb \18\:CKb) resistor r=75 c=0
Rz6 (\9\:mout \10\:mout) resistor r=75 c=0
Rz7 (\13\:mout \14\:mout) resistor r=75 c=0
Rz8 (\10\:CKbb \11\:CKbb) resistor r=75 c=0
Rz9 (\8\:n20 \9\:n20) resistor r=75 c=0
Rz11 (Db \2\:Db) resistor r=75 c=0
Rz12 (\8\:Db \9\:Db) resistor r=75 c=0
Rz13 (\5\:SEb \6\:SEb) resistor r=75 c=0
Ry3 (\3\:Q \4\:Q) resistor r=62 c=0
Ry19 (\1\:VDD \2\:VDD) resistor r=62 c=0
Ry20 (\14\:VDD \15\:VDD) resistor r=62 c=0
Ry21 (\16\:VDD \17\:VDD) resistor r=62 c=0
Ry22 (\18\:VDD \19\:VDD) resistor r=62 c=0
Ry23 (\20\:VDD \21\:VDD) resistor r=62 c=0
Ry24 (\22\:VDD \23\:VDD) resistor r=62 c=0
Ry25 (\24\:VDD \25\:VDD) resistor r=62 c=0
Ry26 (\26\:VDD \27\:VDD) resistor r=62 c=0
Ry1 (\1\:QN \2\:QN) resistor r=62 c=0
Ry16 (\3\:VSS \4\:VSS) resistor r=8.8571 c=0
Ry17 (\3\:VSS \7\:VSS) resistor r=5.1667 c=0
Ry18 (\3\:VSS \10\:VSS) resistor r=5.1667 c=0
Ry2 (\7\:net492 \8\:net492) resistor r=62 c=0
Ry4 (\15\:qbint \16\:qbint) resistor r=62 c=0
Ry7 (\5\:n35 \6\:n35) resistor r=62 c=0
Ry12 (\11\:CKb \12\:CKb) resistor r=62 c=0
Ry8 (\7\:mout \8\:mout) resistor r=62 c=0
Ry9 (\11\:mout \12\:mout) resistor r=62 c=0
Ry10 (\13\:CKbb \14\:CKbb) resistor r=62 c=0
Ry11 (\4\:n20 \5\:n20) resistor r=62 c=0
Ry13 (\4\:Db \5\:Db) resistor r=62 c=0
Ry14 (\6\:Db \7\:Db) resistor r=62 c=0
Ry15 (\9\:SEb \10\:SEb) resistor r=62 c=0
Ry5 (net405 \2\:net405) resistor r=62 c=0
Ry6 (\3\:net405 \4\:net405) resistor r=62 c=0
Rx11 (\2\:CK \4\:CK) resistor r=45 c=0
Rx17 (\4\:SE \9\:SE) resistor r=45 c=0
Rx18 (\2\:SE \10\:SE) resistor r=45 c=0
Rx19 (\7\:SE \11\:SE) resistor r=45 c=0
Rx5 (\6\:SN \7\:SN) resistor r=45 c=0
Rx6 (\2\:SN \8\:SN) resistor r=45 c=0
Rx16 (\2\:SI \4\:SI) resistor r=45 c=0
Rx15 (\2\:D \4\:D) resistor r=45 c=0
Rx1 (\2\:net492 \4\:net492) resistor r=45 c=0
Rx2 (\9\:qbint \11\:qbint) resistor r=45 c=0
Rx3 (\3\:qbint \17\:qbint) resistor r=45 c=0
Rx4 (\4\:n35 \8\:n35) resistor r=45 c=0
Rx12 (\8\:CKb \14\:CKb) resistor r=45 c=0
Rx13 (CKb \15\:CKb) resistor r=45 c=0
Rx14 (\10\:CKb \16\:CKb) resistor r=45 c=0
Rx7 (\3\:mout \5\:mout) resistor r=45 c=0
Rx8 (\6\:CKbb \8\:CKbb) resistor r=45 c=0
Rx9 (CKbb \12\:CKbb) resistor r=45 c=0
Rx10 (\2\:n20 \7\:n20) resistor r=45 c=0
Rx20 (SEb \8\:SEb) resistor r=45 c=0
mn57 (\3\:QN \3\:net492 \12\:VSS VSS) g45n1hvt w=(1.45e-07) l=4.5e-08 \
        nf=1 as=3.843e-14 ad=2.755e-14 ps=8.2e-07 pd=6.7e-07 nrd=1.16667 \
        nrs=1.16667 sa=2.65e-07 sb=1.9e-07 sd=160n sca=23.279 \
        scb=0.0230742 scc=0.00267719 m=(1)
mn56 (\5\:net492 \7\:qbint \22\:VSS VSS) g45n1hvt w=(1.45e-07) l=4.5e-08 \
        nf=1 as=5.19e-14 ad=2.03e-14 ps=1.6e-06 pd=5.7e-07 nrd=1.16667 \
        nrs=1.16667 sa=1.4e-07 sb=3.9e-07 sd=160n sca=23.279 scb=0.0230742 \
        scc=0.00267719 m=(1)
mn55 (\1\:Q \6\:qbint \22\:VSS VSS) g45n1hvt w=(1.45e-07) l=4.5e-08 nf=1 \
        as=5.19e-14 ad=2.828e-14 ps=1.6e-06 pd=6.8e-07 nrd=1.16667 \
        nrs=1.16667 sa=3.35e-07 sb=1.95e-07 sd=160n sca=23.279 \
        scb=0.0230742 scc=0.00267719 m=(1)
mn45 (\13\:qbint n35 \20\:VSS VSS) g45n1hvt w=(1.45e-07) l=4.5e-08 nf=1 \
        as=3.335e-14 ad=2.03e-14 ps=7.5e-07 pd=5.7e-07 nrd=1.16667 \
        nrs=1.16667 sa=1.4e-07 sb=1.04e-06 sd=160n sca=12.9138 \
        scb=0.0133404 scc=0.000640143 m=(1)
mn50 (net521 \1\:SN \20\:VSS VSS) g45n1hvt w=(1.45e-07) l=4.5e-08 nf=1 \
        as=3.335e-14 ad=8.7e-15 ps=7.5e-07 pd=4.1e-07 nrd=1.16667 \
        nrs=1.16667 sa=4.15e-07 sb=7.65e-07 sd=160n sca=12.9138 \
        scb=0.0133404 scc=0.000640143 m=(1)
mn51 (net518 \10\:qbint net521 VSS) g45n1hvt w=(1.45e-07) l=4.5e-08 nf=1 \
        as=8.7e-15 ad=3.48e-14 ps=4.1e-07 pd=7.7e-07 nrd=1.16667 \
        nrs=1.16667 sa=5.2e-07 sb=6.6e-07 sd=160n sca=12.9138 \
        scb=0.0133404 scc=0.000640143 m=(1)
mn52 (\9\:n35 \5\:CKb net518 VSS) g45n1hvt w=(1.45e-07) l=4.5e-08 nf=1 \
        as=3.48e-14 ad=2.755e-14 ps=7.7e-07 pd=6.7e-07 nrd=1.16667 \
        nrs=1.16667 sa=8.05e-07 sb=3.75e-07 sd=160n sca=12.9138 \
        scb=0.0133404 scc=0.000640143 m=(1)
mn40 (\9\:n35 \3\:CKbb \13\:mout VSS) g45n1hvt w=(1.45e-07) l=4.5e-08 \
        nf=1 as=2.03e-14 ad=2.755e-14 ps=5.7e-07 pd=6.7e-07 nrd=1.16667 \
        nrs=1.16667 sa=1.04e-06 sb=1.4e-07 sd=160n sca=12.9138 \
        scb=0.0133404 scc=0.000640143 m=(1)
mn21 (\10\:CKbb \6\:CKb \18\:VSS VSS) g45n1hvt w=(1.45e-07) l=4.5e-08 \
        nf=1 as=6.517e-14 ad=2.03e-14 ps=1.79e-06 pd=5.7e-07 nrd=1.16667 \
        nrs=1.16667 sa=1.4e-07 sb=5.9e-07 sd=160n sca=23.279 scb=0.0230742 \
        scc=0.00267719 m=(1)
mn30 (net442 \5\:SN \18\:VSS VSS) g45n1hvt w=(1.45e-07) l=4.5e-08 nf=1 \
        as=6.517e-14 ad=1.958e-14 ps=1.79e-06 pd=5.6e-07 nrd=1.16667 \
        nrs=1.16667 sa=4.1e-07 sb=3.2e-07 sd=160n sca=23.279 scb=0.0230742 \
        scc=0.00267719 m=(1)
mn31 (\9\:mout \3\:n20 net442 VSS) g45n1hvt w=(1.45e-07) l=4.5e-08 nf=1 \
        as=1.958e-14 ad=2.03e-14 ps=5.6e-07 pd=5.7e-07 nrd=1.16667 \
        nrs=1.16667 sa=5.9e-07 sb=1.4e-07 sd=160n sca=23.279 scb=0.0230742 \
        scc=0.00267719 m=(1)
mn35 (net478 \4\:mout \16\:VSS VSS) g45n1hvt w=(1.45e-07) l=4.5e-08 nf=1 \
        as=3.965e-14 ad=8.7e-15 ps=8.8e-07 pd=4.1e-07 nrd=1.16667 \
        nrs=1.16667 sa=1.7e-07 sb=6.8e-07 sd=160n sca=12.2839 \
        scb=0.0124725 scc=0.000542081 m=(1)
mn36 (\8\:n20 \7\:CKbb net478 VSS) g45n1hvt w=(1.45e-07) l=4.5e-08 nf=1 \
        as=8.7e-15 ad=3.988e-14 ps=4.1e-07 pd=8.4e-07 nrd=1.16667 \
        nrs=1.16667 sa=2.75e-07 sb=5.75e-07 sd=160n sca=12.2839 \
        scb=0.0124725 scc=0.000542081 m=(1)
mn25 (\8\:Db \9\:CKb \8\:n20 VSS) g45n1hvt w=(1.45e-07) l=4.5e-08 nf=1 \
        as=3.988e-14 ad=3.698e-14 ps=8.4e-07 pd=8e-07 nrd=1.16667 \
        nrs=1.16667 sa=5.95e-07 sb=2.55e-07 sd=160n sca=12.2839 \
        scb=0.0124725 scc=0.000542081 m=(1)
mn20 (\17\:CKb \3\:CK \14\:VSS VSS) g45n1hvt w=(1.45e-07) l=4.5e-08 nf=1 \
        as=3.915e-14 ad=2.03e-14 ps=8.3e-07 pd=5.7e-07 nrd=1.16667 \
        nrs=1.16667 sa=1.4e-07 sb=1.29e-06 sd=160n sca=9.87692 \
        scb=0.0087933 scc=0.000232488 m=(1)
mn11 (net494 \3\:D \14\:VSS VSS) g45n1hvt w=(1.45e-07) l=4.5e-08 nf=1 \
        as=3.915e-14 ad=3.77e-14 ps=8.3e-07 pd=8.1e-07 nrd=1.16667 \
        nrs=1.16667 sa=4.55e-07 sb=9.75e-07 sd=160n sca=9.87692 \
        scb=0.0087933 scc=0.000232488 m=(1)
mn12 (Db \3\:SEb net494 VSS) g45n1hvt w=(1.45e-07) l=4.5e-08 nf=1 \
        as=3.77e-14 ad=2.32e-14 ps=8.1e-07 pd=6.1e-07 nrd=1.16667 \
        nrs=1.16667 sa=7.6e-07 sb=6.7e-07 sd=160n sca=9.87692 \
        scb=0.0087933 scc=0.000232488 m=(1)
mn14 (Db \3\:SE net506 VSS) g45n1hvt w=(1.45e-07) l=4.5e-08 nf=1 \
        as=8.7e-15 ad=2.32e-14 ps=4.1e-07 pd=6.1e-07 nrd=1.16667 \
        nrs=1.16667 sa=9.65e-07 sb=4.65e-07 sd=160n sca=9.87692 \
        scb=0.0087933 scc=0.000232488 m=(1)
mn13 (net506 \1\:SI \1\:VSS VSS) g45n1hvt w=(1.45e-07) l=4.5e-08 nf=1 \
        as=2.32e-14 ad=8.7e-15 ps=6.1e-07 pd=4.1e-07 nrd=1.16667 \
        nrs=1.16667 sa=1.07e-06 sb=3.6e-07 sd=160n sca=9.87692 \
        scb=0.0087933 scc=0.000232488 m=(1)
mn10 (\5\:SEb \5\:SE \1\:VSS VSS) g45n1hvt w=(1.45e-07) l=4.5e-08 nf=1 \
        as=2.32e-14 ad=2.248e-14 ps=6.1e-07 pd=6e-07 nrd=1.16667 \
        nrs=1.16667 sa=1.275e-06 sb=1.55e-07 sd=160n sca=9.87692 \
        scb=0.0087933 scc=0.000232488 m=(1)
ends SDFFSXL
// End of subcircuit definition.
