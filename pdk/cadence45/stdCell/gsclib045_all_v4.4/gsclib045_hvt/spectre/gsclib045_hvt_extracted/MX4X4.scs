// Generated for: spectre (May  1 09:16:59 2013 )
// Library name: gsclib045_hvt
// Cell name: MX4X4
// View name: extracted

simulator lang=spectre

subckt MX4X4 A B C D S0 S1 VDD VSS Y
mp10 (\17\:n2 \4\:S1 \4\:n0 VDD) g45p1hvt w=(3.9e-07) l=4.5e-08 nf=1 \
        as=8.385e-14 ad=6.24e-14 ps=1.21e-06 pd=1.1e-06 nrd=1.16667 \
        nrs=1.16667 sa=2.15e-07 sb=3.7e-07 sd=160n sca=32.1279 \
        scb=0.0214025 scc=0.00336348 m=(1)
mp11 (\7\:n1 \3\:S1b \17\:n2 VDD) g45p1hvt w=(3.9e-07) l=4.5e-08 nf=1 \
        as=6.24e-14 ad=6.435e-14 ps=1.1e-06 pd=1.11e-06 nrd=1.16667 \
        nrs=1.16667 sa=4.2e-07 sb=1.65e-07 sd=160n sca=31.0054 \
        scb=0.0203755 scc=0.00336103 m=(1)
mp12_1__rcx (Y n2 \6\:VDD VDD) g45p1hvt w=(3.9e-07) l=4.5e-08 nf=1 \
        as=9.509e-14 ad=6.24e-14 ps=1.525e-06 pd=1.1e-06 nrd=1.16667 \
        nrs=1.16667 sa=2.99551e-07 sb=1.16763e-06 sd=160n sca=30.5009 \
        scb=0.0202006 scc=0.00336097 m=(4)
C1 (S1 VSS) capacitor c=5.97094e-17
C2 (C VSS) capacitor c=5.2864e-17
C3 (S0 VSS) capacitor c=4.63725e-17
C4 (VDD VSS) capacitor c=3.52212e-16
C5 (B VSS) capacitor c=5.14754e-17
C6 (D VSS) capacitor c=4.77497e-17
C7 (A VSS) capacitor c=3.3173e-17
C8 (Y VSS) capacitor c=2.10679e-16
C9 (n2 VSS) capacitor c=2.78254e-16
C10 (S1b VSS) capacitor c=2.9089e-17
C11 (n0 VSS) capacitor c=1.44429e-16
C12 (n1 VSS) capacitor c=3.63391e-16
C13 (n3 VSS) capacitor c=5.43409e-18
C14 (S0b VSS) capacitor c=3.84525e-17
C15 (n5 VSS) capacitor c=1.48975e-18
C16 (n7 VSS) capacitor c=8.48361e-18
C17 (n9 VSS) capacitor c=7.08461e-20
C18 (n4 VSS) capacitor c=5.34832e-18
C19 (n6 VSS) capacitor c=5.45315e-18
C20 (n8 VSS) capacitor c=1.14135e-17
C21 (\10\:S0 VSS) capacitor c=3.71468e-17
C22 (\1\:D VSS) capacitor c=5.4382e-17
C23 (\6\:S0b VSS) capacitor c=5.36646e-17
C24 (\9\:S0 VSS) capacitor c=3.77538e-17
C25 (\3\:C VSS) capacitor c=3.90582e-17
C26 (\3\:B VSS) capacitor c=4.75264e-17
C27 (\1\:S0 VSS) capacitor c=3.78048e-17
C28 (\1\:A VSS) capacitor c=5.49286e-17
C29 (\1\:S1 VSS) capacitor c=3.93411e-17
C30 (\3\:S1b VSS) capacitor c=4.62e-17
C31 (\4\:S1 VSS) capacitor c=5.76924e-17
C32 (\12\:S0 VSS) capacitor c=2.21568e-17
C33 (\3\:D VSS) capacitor c=3.77231e-17
C34 (\5\:S0 VSS) capacitor c=2.8574e-17
C35 (\4\:S0b VSS) capacitor c=4.15854e-17
C36 (\1\:C VSS) capacitor c=3.91692e-17
C37 (\1\:B VSS) capacitor c=6.78245e-17
C38 (\3\:S0 VSS) capacitor c=6.75286e-17
C39 (\3\:S0b VSS) capacitor c=6.42737e-17
C40 (\3\:A VSS) capacitor c=3.03826e-17
C41 (\5\:S1 VSS) capacitor c=3.25022e-17
C42 (\6\:S1 VSS) capacitor c=3.26964e-17
C43 (\11\:S0 VSS) capacitor c=3.17304e-17
C44 (\2\:D VSS) capacitor c=4.4525e-17
C45 (\7\:S0b VSS) capacitor c=3.39916e-17
C46 (\6\:S0 VSS) capacitor c=4.35236e-17
C47 (\5\:S0b VSS) capacitor c=3.686e-17
C48 (\8\:S0 VSS) capacitor c=3.62532e-17
C49 (\2\:C VSS) capacitor c=5.88386e-17
C50 (\2\:B VSS) capacitor c=6.4045e-17
C51 (\4\:S0 VSS) capacitor c=4.83758e-17
C52 (\2\:S0b VSS) capacitor c=5.68923e-17
C53 (\2\:S0 VSS) capacitor c=3.3703e-17
C54 (\2\:A VSS) capacitor c=4.0223e-17
C55 (\8\:n2 VSS) capacitor c=1.32458e-17
C56 (\2\:S1 VSS) capacitor c=6.06527e-17
C57 (\6\:S1b VSS) capacitor c=4.0023e-17
C58 (\5\:S1b VSS) capacitor c=3.07656e-17
C59 (\2\:S1b VSS) capacitor c=2.82223e-17
C60 (\8\:S0b VSS) capacitor c=8.83952e-18
C61 (\10\:VDD VSS) capacitor c=3.51329e-17
C62 (\5\:n1 VSS) capacitor c=1.059e-16
C63 (\12\:VDD VSS) capacitor c=3.91869e-17
C64 (\8\:n0 VSS) capacitor c=4.80204e-17
C65 (\9\:S1b VSS) capacitor c=6.61128e-17
C66 (\7\:n1 VSS) capacitor c=9.49108e-17
C67 (\17\:n2 VSS) capacitor c=1.90568e-16
C68 (\4\:n0 VSS) capacitor c=2.41988e-16
C69 (\1\:VDD VSS) capacitor c=8.4438e-17
C70 (\14\:S0b VSS) capacitor c=9.66266e-17
C71 (\13\:S1b VSS) capacitor c=5.34815e-17
C72 (\3\:n1 VSS) capacitor c=3.54553e-16
C73 (\19\:n2 VSS) capacitor c=9.63739e-17
C74 (\6\:n0 VSS) capacitor c=6.78676e-17
C75 (\4\:S1b VSS) capacitor c=2.2579e-17
C76 (\3\:S1 VSS) capacitor c=7.06763e-17
C77 (\7\:S0 VSS) capacitor c=4.29397e-17
C78 (\7\:S1b VSS) capacitor c=1.49488e-16
C79 (\8\:S1b VSS) capacitor c=1.21885e-16
C80 (\12\:S1b VSS) capacitor c=6.81972e-17
C81 (\7\:S1 VSS) capacitor c=6.41994e-17
C82 (\16\:n2 VSS) capacitor c=1.34912e-16
C83 (\4\:A VSS) capacitor c=7.48756e-17
C84 (\3\:n0 VSS) capacitor c=3.08886e-16
C85 (\5\:B VSS) capacitor c=5.27146e-17
C86 (\13\:S0 VSS) capacitor c=1.06881e-16
C87 (\14\:S0 VSS) capacitor c=1.05679e-16
C88 (\15\:S0 VSS) capacitor c=7.92813e-17
C89 (\4\:C VSS) capacitor c=6.74165e-17
C90 (\4\:D VSS) capacitor c=4.43121e-17
C91 (\17\:S0 VSS) capacitor c=7.78734e-17
C92 (\18\:S0 VSS) capacitor c=6.02417e-17
C93 (\10\:S0b VSS) capacitor c=8.70172e-17
C94 (\11\:S0b VSS) capacitor c=9.5418e-17
C95 (\12\:S0b VSS) capacitor c=1.62788e-16
C96 (\13\:S0b VSS) capacitor c=1.25208e-16
C97 (\16\:S0b VSS) capacitor c=2.40422e-17
C98 (\17\:S0b VSS) capacitor c=8.34683e-17
C99 (\3\:VDD VSS) capacitor c=2.86056e-17
C100 (\5\:VDD VSS) capacitor c=2.10962e-17
C101 (\6\:VDD VSS) capacitor c=1.48944e-16
Rk5 (\7\:S1 S1) resistor r=0.1159 c=0
Rk24 (C \4\:C) resistor r=0.2114 c=0
Rk22 (\13\:S0 \14\:S0) resistor r=0.4736 c=0
Rk23 (\14\:S0 \15\:S0) resistor r=0.4382 c=0
Rk29 (S0 \16\:S0) resistor r=0.1443 c=0
Rk30 (\16\:S0 \17\:S0) resistor r=0.5237 c=0
Rk31 (\16\:S0 \18\:S0) resistor r=0.02672 c=0
Rk39 (\2\:VDD \3\:VDD) resistor r=0.2957 c=0
Rk40 (\3\:VDD \4\:VDD) resistor r=0.4562 c=0
Rk41 (\4\:VDD \5\:VDD) resistor r=0.1352 c=0
Rk42 (\5\:VDD \6\:VDD) resistor r=0.4835 c=0
Rk46 (\9\:VDD VDD) resistor r=0.5514 c=0
Rk45 (\6\:VDD \9\:VDD) resistor r=0.1267 c=0
Rk47 (\3\:VDD \11\:VDD) resistor r=0.244 c=0
Rk48 (\5\:VDD \13\:VDD) resistor r=0.1792 c=0
Rk19 (\4\:B \5\:B) resistor r=0.003606 c=0
Rk20 (\6\:B B) resistor r=0.003709 c=0
Rk21 (\5\:B \6\:B) resistor r=0.1016 c=0
Rk28 (D \4\:D) resistor r=0.1552 c=0
Rk14 (A \4\:A) resistor r=0.027 c=0
Rk52 (\2\:VSS \3\:VSS) resistor r=0.3107 c=0
Rk53 (\3\:VSS \4\:VSS) resistor r=0.4411 c=0
Rk54 (\4\:VSS \5\:VSS) resistor r=0.0675 c=0
Rk55 (\5\:VSS \6\:VSS) resistor r=0.5362 c=0
Rk59 (\9\:VSS VSS) resistor r=0.5514 c=0
Rk58 (\6\:VSS \9\:VSS) resistor r=0.1267 c=0
Rk60 (\3\:VSS \11\:VSS) resistor r=0.2894 c=0
Rk61 (\5\:VSS \13\:VSS) resistor r=0.2171 c=0
Rk6 (\16\:n2 \18\:n2) resistor r=0.9507 c=0
Rk7 (\18\:n2 \20\:n2) resistor r=0.4982 c=0
Rk1 (\7\:S1b \8\:S1b) resistor r=0.8625 c=0
Rk2 (\10\:S1b \11\:S1b) resistor r=0.1861 c=0
Rk3 (\11\:S1b \12\:S1b) resistor r=0.01531 c=0
Rk4 (\11\:S1b \14\:S1b) resistor r=0.1821 c=0
Rk15 (\2\:n0 \3\:n0) resistor r=0.8047 c=0
Rk16 (\3\:n0 \5\:n0) resistor r=1.8858 c=0
Rk17 (\5\:n0 \7\:n0) resistor r=0.5293 c=0
Rk18 (\3\:n0 \9\:n0) resistor r=0.1867 c=0
Rk25 (\2\:n1 \4\:n1) resistor r=2.4956 c=0
Rk26 (\2\:n1 \6\:n1) resistor r=0.566 c=0
Rk27 (\4\:n1 \8\:n1) resistor r=0.4539 c=0
Rk32 (\9\:S0b \10\:S0b) resistor r=0.04786 c=0
Rk33 (\10\:S0b \11\:S0b) resistor r=0.4929 c=0
Rk34 (\11\:S0b \12\:S0b) resistor r=0.552 c=0
Rk35 (\12\:S0b \13\:S0b) resistor r=0.7466 c=0
Rk36 (\10\:S0b \15\:S0b) resistor r=0.8241 c=0
Rk37 (\11\:S0b \16\:S0b) resistor r=0.05728 c=0
Rk38 (\12\:S0b \17\:S0b) resistor r=0.4298 c=0
Rl5 (\1\:S1 \2\:S1) resistor r=65.1797 c=0
Rl8 (\2\:S1 \5\:S1) resistor r=33.4251 c=0
Rl7 (\3\:S1 \4\:S1) resistor r=119.209 c=0
Rl9 (\3\:S1 \6\:S1) resistor r=30.4507 c=0
Rl6 (\2\:S1 \3\:S1) resistor r=233.082 c=0
Rl33 (\2\:C \3\:C) resistor r=102.615 c=0
Rl32 (\1\:C \2\:C) resistor r=109.98 c=0
Rl42 (\10\:S0 \11\:S0) resistor r=169.923 c=0
Rl43 (\11\:S0 \12\:S0) resistor r=39.1533 c=0
Rl35 (\5\:S0 \6\:S0) resistor r=26.1559 c=0
Rl29 (\3\:S0 \4\:S0) resistor r=31.9251 c=0
Rl26 (\1\:S0 \2\:S0) resistor r=71.8456 c=0
Rl38 (\7\:S0 \9\:S0) resistor r=115.066 c=0
Rl36 (\6\:S0 \7\:S0) resistor r=114.917 c=0
Rl37 (\7\:S0 \8\:S0) resistor r=92.233 c=0
Rl31 (\2\:B \3\:B) resistor r=103.297 c=0
Rl30 (\1\:B \2\:B) resistor r=107.692 c=0
Rl40 (\1\:D \2\:D) resistor r=98.7687 c=0
Rl41 (\2\:D \3\:D) resistor r=110.307 c=0
Rl24 (\1\:A \2\:A) resistor r=162.23 c=0
Rl25 (\2\:A \3\:A) resistor r=46.8456 c=0
Rl16 (n2 \8\:n2) resistor r=1.2301 c=0
Rl1 (S1b \2\:S1b) resistor r=26.1559 c=0
Rl2 (\3\:S1b \4\:S1b) resistor r=27.5863 c=0
Rl4 (\4\:S1b \6\:S1b) resistor r=85.3353 c=0
Rl3 (\4\:S1b \5\:S1b) resistor r=5.8511 c=0
Rl39 (\6\:S0b \7\:S0b) resistor r=28.079 c=0
Rl34 (\4\:S0b \5\:S0b) resistor r=44.9225 c=0
Rl27 (S0b \2\:S0b) resistor r=56.9251 c=0
Rl28 (\2\:S0b \3\:S0b) resistor r=149.816 c=0
Rz10 (\2\:VDD \1\:VDD) resistor r=25 c=0
Rz11 (\4\:VDD \1\:VDD) resistor r=6.25 c=0
Rz12 (\9\:VDD \1\:VDD) resistor r=6.25 c=0
Rz13 (\11\:VSS \10\:VSS) resistor r=75 c=0
Rz14 (\13\:VSS \12\:VSS) resistor r=75 c=0
Rz2 (\20\:n2 \19\:n2) resistor r=75 c=0
Rz1 (\13\:S1b \14\:S1b) resistor r=75 c=0
Rz5 (n0 \2\:n0) resistor r=75 c=0
Rz6 (\6\:n0 \7\:n0) resistor r=75 c=0
Rz7 (n1 \2\:n1) resistor r=75 c=0
Rz8 (\3\:n1 \4\:n1) resistor r=75 c=0
Rz9 (\14\:S0b \15\:S0b) resistor r=75 c=0
Ry10 (\11\:VDD \10\:VDD) resistor r=62 c=0
Ry11 (\13\:VDD \12\:VDD) resistor r=62 c=0
Ry15 (\2\:VSS \1\:VSS) resistor r=20.6667 c=0
Ry16 (\4\:VSS \1\:VSS) resistor r=5.1667 c=0
Ry17 (\9\:VSS \1\:VSS) resistor r=5.1667 c=0
Ry2 (\18\:n2 \17\:n2) resistor r=31 c=0
Ry1 (\9\:S1b \10\:S1b) resistor r=62 c=0
Ry5 (\4\:n0 \5\:n0) resistor r=20.6667 c=0
Ry6 (\8\:n0 \9\:n0) resistor r=62 c=0
Ry7 (\5\:n1 \6\:n1) resistor r=62 c=0
Ry8 (\7\:n1 \8\:n1) resistor r=62 c=0
Ry9 (\8\:S0b \9\:S0b) resistor r=62 c=0
Rx4 (\2\:S1 \7\:S1) resistor r=45 c=0
Rx11 (\2\:C \4\:C) resistor r=45 c=0
Rx8 (\8\:S0 \13\:S0) resistor r=45 c=0
Rx9 (\4\:S0 \14\:S0) resistor r=45 c=0
Rx10 (\2\:S0 \15\:S0) resistor r=45 c=0
Rx13 (\6\:S0 \17\:S0) resistor r=45 c=0
Rx14 (\11\:S0 \18\:S0) resistor r=45 c=0
Rx7 (\2\:B \4\:B) resistor r=45 c=0
Rx12 (\2\:D \4\:D) resistor r=45 c=0
Rx6 (\2\:A \4\:A) resistor r=45 c=0
Rx5 (\16\:n2 \8\:n2) resistor r=45 c=0
Rx1 (\5\:S1b \7\:S1b) resistor r=45 c=0
Rx2 (\2\:S1b \8\:S1b) resistor r=45 c=0
Rx3 (\6\:S1b \12\:S1b) resistor r=45 c=0
Rx15 (\2\:S0b \13\:S0b) resistor r=45 c=0
Rx16 (\7\:S0b \16\:S0b) resistor r=45 c=0
Rx17 (\5\:S0b \17\:S0b) resistor r=45 c=0
mn10 (\19\:n2 S1b \6\:n0 VSS) g45n1hvt w=(2.6e-07) l=4.5e-08 nf=1 \
        as=6.11e-14 ad=4.68e-14 ps=9.9e-07 pd=8.8e-07 nrd=1.16667 \
        nrs=1.16667 sa=2.35e-07 sb=4.8e-07 sd=160n sca=9.69565 \
        scb=0.00844644 scc=0.000275168 m=(1)
mn11 (\19\:n2 \6\:S1 \3\:n1 VSS) g45n1hvt w=(2.6e-07) l=4.5e-08 nf=1 \
        as=6.63e-14 ad=4.68e-14 ps=1.03e-06 pd=8.8e-07 nrd=1.16667 \
        nrs=1.16667 sa=4.6e-07 sb=2.55e-07 sd=160n sca=9.69565 \
        scb=0.00844644 scc=0.000275168 m=(1)
mn12_1__rcx (Y n2 \6\:VSS VSS) g45n1hvt w=(2.6e-07) l=4.5e-08 nf=1 \
        as=7.844e-14 ad=4.16e-14 ps=1.4525e-06 pd=8.4e-07 nrd=1.16667 \
        nrs=1.16667 sa=3.65192e-07 sb=1.45817e-06 sd=160n sca=9.89531 \
        scb=0.00874901 scc=0.000299334 m=(4)
mn1 (\13\:S1b \5\:S1 \6\:VSS VSS) g45n1hvt w=(1.45e-07) l=4.5e-08 nf=1 \
        as=8.523e-14 ad=2.9e-14 ps=1.5e-06 pd=6.9e-07 nrd=1.16667 \
        nrs=1.16667 sa=2e-07 sb=2e-06 sd=160n sca=11.9911 scb=0.0120555 \
        scc=0.000498628 m=(1)
mn2 (n3 \3\:A \6\:VSS VSS) g45n1hvt w=(1.45e-07) l=4.5e-08 nf=1 \
        as=6.255e-14 ad=5.945e-14 ps=1.53e-06 pd=1.11e-06 nrd=1.16667 \
        nrs=1.16667 sa=1.46e-06 sb=2e-06 sd=160n sca=11.9911 scb=0.0120555 \
        scc=0.000498628 m=(1)
mn3 (n0 \3\:S0b n3 VSS) g45n1hvt w=(1.45e-07) l=4.5e-08 nf=1 as=5.945e-14 \
        ad=2.465e-14 ps=1.11e-06 pd=6.3e-07 nrd=1.16667 nrs=1.16667 \
        sa=1.915e-06 sb=2e-06 sd=160n sca=11.9911 scb=0.0120555 \
        scc=0.000498628 m=(1)
mn5 (n0 \3\:S0 n5 VSS) g45n1hvt w=(1.45e-07) l=4.5e-08 nf=1 as=8.7e-15 \
        ad=2.465e-14 ps=4.1e-07 pd=6.3e-07 nrd=1.16667 nrs=1.16667 \
        sa=2e-06 sb=1.845e-06 sd=160n sca=11.9911 scb=0.0120555 \
        scc=0.000498628 m=(1)
mn4 (n5 \1\:B \12\:VSS VSS) g45n1hvt w=(1.45e-07) l=4.5e-08 nf=1 \
        as=4.57e-14 ad=8.7e-15 ps=9.6e-07 pd=4.1e-07 nrd=1.16667 \
        nrs=1.16667 sa=2e-06 sb=1.74e-06 sd=160n sca=11.9911 scb=0.0120555 \
        scc=0.000498628 m=(1)
mn6 (n7 \1\:C \12\:VSS VSS) g45n1hvt w=(1.45e-07) l=4.5e-08 nf=1 \
        as=4.57e-14 ad=4.495e-14 ps=9.6e-07 pd=9.1e-07 nrd=1.16667 \
        nrs=1.16667 sa=2e-06 sb=1.475e-06 sd=160n sca=11.9911 \
        scb=0.0120555 scc=0.000498628 m=(1)
mn7 (n1 \4\:S0b n7 VSS) g45n1hvt w=(1.45e-07) l=4.5e-08 nf=1 as=4.495e-14 \
        ad=3.045e-14 ps=9.1e-07 pd=7.1e-07 nrd=1.16667 nrs=1.16667 \
        sa=2e-06 sb=1.12e-06 sd=160n sca=11.9911 scb=0.0120555 \
        scc=0.000498628 m=(1)
mn9 (n1 \5\:S0 n9 VSS) g45n1hvt w=(1.45e-07) l=4.5e-08 nf=1 as=2.683e-14 \
        ad=3.045e-14 ps=6.6e-07 pd=7.1e-07 nrd=1.16667 nrs=1.16667 \
        sa=2e-06 sb=8.65e-07 sd=160n sca=11.9911 scb=0.0120555 \
        scc=0.000498628 m=(1)
mn8 (n9 \3\:D \10\:VSS VSS) g45n1hvt w=(1.45e-07) l=4.5e-08 nf=1 \
        as=6.525e-14 ad=2.683e-14 ps=1.19e-06 pd=6.6e-07 nrd=1.16667 \
        nrs=1.16667 sa=2e-06 sb=6.35e-07 sd=160n sca=11.9911 scb=0.0120555 \
        scc=0.000498628 m=(1)
mn0 (\14\:S0b \12\:S0 \10\:VSS VSS) g45n1hvt w=(1.45e-07) l=4.5e-08 nf=1 \
        as=6.525e-14 ad=2.03e-14 ps=1.19e-06 pd=5.7e-07 nrd=1.16667 \
        nrs=1.16667 sa=2e-06 sb=1.4e-07 sd=160n sca=11.9911 scb=0.0120555 \
        scc=0.000498628 m=(1)
mp1 (\9\:S1b \1\:S1 \6\:VDD VDD) g45p1hvt w=(2.15e-07) l=4.5e-08 nf=1 \
        as=1.1785e-13 ad=3.01e-14 ps=1.9e-06 pd=7.1e-07 nrd=1.16667 \
        nrs=1.16667 sa=1.4e-07 sb=1.04e-06 sd=160n sca=45.7906 \
        scb=0.0283307 scc=0.00588417 m=(1)
mp2 (n4 \1\:A \6\:VDD VDD) g45p1hvt w=(2.15e-07) l=4.5e-08 nf=1 \
        as=6.93e-14 ad=4.945e-14 ps=1.4e-06 pd=8.9e-07 nrd=1.16667 \
        nrs=1.16667 sa=7.16512e-07 sb=2e-06 sd=160n sca=10.4315 \
        scb=0.0078915 scc=0.00010471 m=(1)
mp3 (\8\:n0 \1\:S0 n4 VDD) g45p1hvt w=(2.15e-07) l=4.5e-08 nf=1 \
        as=4.945e-14 ad=3.655e-14 ps=8.9e-07 pd=7.7e-07 nrd=1.16667 \
        nrs=1.16667 sa=9.91512e-07 sb=2e-06 sd=160n sca=10.4315 \
        scb=0.0078915 scc=0.00010471 m=(1)
mp5 (\8\:n0 S0b n6 VDD) g45p1hvt w=(2.15e-07) l=4.5e-08 nf=1 as=3.548e-14 \
        ad=3.655e-14 ps=7.6e-07 pd=7.7e-07 nrd=1.16667 nrs=1.16667 \
        sa=1.20651e-06 sb=2e-06 sd=160n sca=10.4315 scb=0.0078915 \
        scc=0.00010471 m=(1)
mp4 (n6 \3\:B \12\:VDD VDD) g45p1hvt w=(2.15e-07) l=4.5e-08 nf=1 \
        as=6.825e-14 ad=3.548e-14 ps=1.14e-06 pd=7.6e-07 nrd=1.16667 \
        nrs=1.16667 sa=1.41651e-06 sb=1.815e-06 sd=160n sca=10.4315 \
        scb=0.0078915 scc=0.00010471 m=(1)
mp6 (n8 \3\:C \12\:VDD VDD) g45p1hvt w=(2.15e-07) l=4.5e-08 nf=1 \
        as=6.825e-14 ad=8.493e-14 ps=1.14e-06 pd=1.22e-06 nrd=1.16667 \
        nrs=1.16667 sa=1.65884e-06 sb=1.5e-06 sd=160n sca=10.4315 \
        scb=0.0078915 scc=0.00010471 m=(1)
mp7 (\5\:n1 \9\:S0 n8 VDD) g45p1hvt w=(2.15e-07) l=4.5e-08 nf=1 \
        as=8.493e-14 ad=5.483e-14 ps=1.22e-06 pd=9.4e-07 nrd=1.16667 \
        nrs=1.16667 sa=1.84302e-06 sb=1.06e-06 sd=160n sca=10.4315 \
        scb=0.0078915 scc=0.00010471 m=(1)
mp9 (\5\:n1 \6\:S0b n10 VDD) g45p1hvt w=(2.15e-07) l=4.5e-08 nf=1 \
        as=1.72e-14 ad=5.483e-14 ps=5.9e-07 pd=9.4e-07 nrd=1.16667 \
        nrs=1.16667 sa=1.9686e-06 sb=7.6e-07 sd=160n sca=10.4315 \
        scb=0.0078915 scc=0.00010471 m=(1)
mp8 (n10 \1\:D \10\:VDD VDD) g45p1hvt w=(2.15e-07) l=4.5e-08 nf=1 \
        as=9.675e-14 ad=1.72e-14 ps=1.33e-06 pd=5.9e-07 nrd=1.16667 \
        nrs=1.16667 sa=2e-06 sb=6.35e-07 sd=160n sca=10.4315 scb=0.0078915 \
        scc=0.00010471 m=(1)
mp0 (\8\:S0b \10\:S0 \10\:VDD VDD) g45p1hvt w=(2.15e-07) l=4.5e-08 nf=1 \
        as=9.675e-14 ad=3.01e-14 ps=1.33e-06 pd=7.1e-07 nrd=1.16667 \
        nrs=1.16667 sa=2e-06 sb=1.4e-07 sd=160n sca=12.6973 scb=0.00997937 \
        scc=0.000112947 m=(1)
ends MX4X4
// End of subcircuit definition.
