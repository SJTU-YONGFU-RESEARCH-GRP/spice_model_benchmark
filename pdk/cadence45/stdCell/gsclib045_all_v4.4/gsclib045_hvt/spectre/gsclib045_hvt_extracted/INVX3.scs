// Generated for: spectre (May  1 09:16:37 2013 )
// Library name: gsclib045_hvt
// Cell name: INVX3
// View name: extracted

simulator lang=spectre

subckt INVX3 A VDD VSS Y
mp0 (Y \1\:A VDD VDD) g45p1hvt w=(3.9e-07) l=4.5e-08 nf=1 as=6.92e-14 \
        ad=5.98e-14 ps=1.34e-06 pd=1.08667e-06 nrd=1.16667 nrs=1.16667 \
        sa=1.25e-07 sb=5.5e-07 sd=160n sca=47.2615 scb=0.0418019 \
        scc=0.00515049 m=(3)
C1 (Y VSS) capacitor c=2.39041e-16
C2 (VDD VSS) capacitor c=1.52509e-16
C3 (\1\:A VSS) capacitor c=1.55107e-16
C4 (\5\:A VSS) capacitor c=9.11424e-18
C5 (\11\:A VSS) capacitor c=1.83106e-17
C6 (\12\:A VSS) capacitor c=3.30933e-17
Rk1 (A \11\:A) resistor r=0.006611 c=0
Rk3 (\11\:A \12\:A) resistor r=0.00973 c=0
Rk2 (\12\:A \13\:A) resistor r=0.006611 c=0
Rl4 (\1\:A \5\:A) resistor r=4.0454 c=0
Rx1 (\13\:A \5\:A) resistor r=45 c=0
mn0 (Y \1\:A VSS VSS) g45n1hvt w=(2.6e-07) l=4.5e-08 nf=1 as=4.868e-14 \
        ad=3.987e-14 ps=1.06667e-06 pd=8.2667e-07 nrd=1.16667 nrs=1.16667 \
        sa=1.25e-07 sb=5.5e-07 sd=160n sca=17.5885 scb=0.0172826 \
        scc=0.00162584 m=(3)
ends INVX3
// End of subcircuit definition.
