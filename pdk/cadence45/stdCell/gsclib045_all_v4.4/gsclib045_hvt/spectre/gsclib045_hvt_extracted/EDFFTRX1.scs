// Generated for: spectre (May  1 09:15:09 2013 )
// Library name: gsclib045_hvt
// Cell name: EDFFTRX1
// View name: extracted

simulator lang=spectre

subckt EDFFTRX1 CK D E Q QN RN VDD VSS
mp57 (\1\:QN \4\:qint \22\:VDD VDD) g45p1hvt w=(3.9e-07) l=4.5e-08 nf=1 \
        as=7.142e-14 ad=5.46e-14 ps=1.52e-06 pd=1.06e-06 nrd=1.16667 \
        nrs=1.16667 sa=1.4e-07 sb=2.4e-07 sd=160n sca=34.3332 \
        scb=0.0249008 scc=0.00341086 m=(1)
mp55 (\1\:Q qbint \19\:VDD VDD) g45p1hvt w=(3.9e-07) l=4.5e-08 nf=1 \
        as=1.0705e-13 ad=5.15e-14 ps=1.72e-06 pd=1.08e-06 nrd=1.16667 \
        nrs=1.16667 sa=1.32051e-07 sb=3.32628e-07 sd=160n sca=30.5009 \
        scb=0.0202006 scc=0.00336097 m=(1)
C1 (D VSS) capacitor c=7.52345e-17
C2 (Q VSS) capacitor c=7.63403e-17
C3 (CK VSS) capacitor c=7.18253e-17
C4 (VDD VSS) capacitor c=4.24913e-16
C5 (RN VSS) capacitor c=8.38429e-17
C6 (QN VSS) capacitor c=2.29663e-17
C7 (qint VSS) capacitor c=2.13499e-17
C8 (qbint VSS) capacitor c=2.49912e-17
C9 (CKb VSS) capacitor c=8.93696e-17
C10 (n30 VSS) capacitor c=3.7354e-17
C11 (net496 VSS) capacitor c=4.27757e-20
C12 (mout VSS) capacitor c=5.67367e-17
C13 (CKbb VSS) capacitor c=3.13331e-17
C14 (n20 VSS) capacitor c=4.7926e-17
C15 (net516 VSS) capacitor c=7.19536e-19
C16 (Dp VSS) capacitor c=6.79073e-17
C17 (RNb VSS) capacitor c=4.49575e-17
C18 (Eb VSS) capacitor c=5.00907e-17
C19 (n1 VSS) capacitor c=1.37941e-18
C20 (Db VSS) capacitor c=9.72919e-17
C21 (net427 VSS) capacitor c=7.07753e-19
C22 (n2 VSS) capacitor c=8.7571e-17
C23 (n3 VSS) capacitor c=8.27516e-17
C24 (\1\:D VSS) capacitor c=3.1754e-17
C25 (\4\:E VSS) capacitor c=3.59273e-17
C26 (\2\:Db VSS) capacitor c=5.86694e-17
C27 (\3\:E VSS) capacitor c=4.01286e-17
C28 (\11\:qbint VSS) capacitor c=5.76828e-17
C29 (\3\:RNb VSS) capacitor c=6.15343e-17
C30 (\1\:RN VSS) capacitor c=3.94806e-17
C31 (\11\:CKb VSS) capacitor c=4.84147e-17
C32 (\5\:CKb VSS) capacitor c=6.07996e-17
C33 (\3\:mout VSS) capacitor c=8.05873e-17
C34 (\3\:n20 VSS) capacitor c=3.29938e-17
C35 (\3\:CKb VSS) capacitor c=3.78819e-17
C36 (\5\:CKbb VSS) capacitor c=9.99566e-17
C37 (\7\:qbint VSS) capacitor c=5.98182e-17
C38 (\1\:CK VSS) capacitor c=2.12646e-17
C39 (\6\:qbint VSS) capacitor c=3.29188e-17
C40 (\4\:qint VSS) capacitor c=4.72851e-17
C41 (\3\:D VSS) capacitor c=2.65469e-17
C42 (\7\:E VSS) capacitor c=2.69442e-17
C43 (\1\:E VSS) capacitor c=6.72256e-17
C44 (\3\:Eb VSS) capacitor c=5.25672e-17
C45 (\10\:qbint VSS) capacitor c=1.06031e-16
C46 (\3\:RN VSS) capacitor c=3.77277e-17
C47 (\9\:CKb VSS) capacitor c=3.1975e-17
C48 (\2\:Dp VSS) capacitor c=5.52307e-17
C49 (\7\:CKb VSS) capacitor c=4.90764e-17
C50 (\3\:CKbb VSS) capacitor c=1.15364e-16
C51 (\4\:CKbb VSS) capacitor c=1.22224e-16
C52 (\9\:qbint VSS) capacitor c=8.15574e-17
C53 (\3\:n30 VSS) capacitor c=3.41982e-17
C54 (\3\:CK VSS) capacitor c=3.09939e-17
C55 (\5\:qbint VSS) capacitor c=4.23922e-17
C56 (\4\:qbint VSS) capacitor c=2.86154e-17
C57 (\3\:qint VSS) capacitor c=3.7656e-17
C58 (\2\:D VSS) capacitor c=2.31343e-17
C59 (\6\:E VSS) capacitor c=3.69366e-17
C60 (\3\:Db VSS) capacitor c=2.17658e-17
C61 (\2\:E VSS) capacitor c=7.13751e-17
C62 (\2\:Eb VSS) capacitor c=5.01584e-17
C63 (\12\:qbint VSS) capacitor c=3.05769e-17
C64 (\2\:RNb VSS) capacitor c=6.14036e-17
C65 (\2\:RN VSS) capacitor c=3.94708e-17
C66 (\10\:CKb VSS) capacitor c=3.87431e-17
C67 (\3\:Dp VSS) capacitor c=2.74192e-17
C68 (\8\:CKb VSS) capacitor c=5.48584e-17
C69 (\2\:CKbb VSS) capacitor c=7.71828e-17
C70 (\6\:CKb VSS) capacitor c=5.35666e-17
C71 (\2\:mout VSS) capacitor c=6.43947e-17
C72 (\4\:CKb VSS) capacitor c=4.41774e-17
C73 (\2\:CKb VSS) capacitor c=3.57599e-17
C74 (\8\:qbint VSS) capacitor c=2.8035e-17
C75 (\2\:n30 VSS) capacitor c=2.21742e-17
C76 (\2\:CK VSS) capacitor c=2.78028e-17
C77 (\2\:qbint VSS) capacitor c=3.57411e-17
C78 (\4\:Db VSS) capacitor c=1.20661e-16
C79 (\1\:VDD VSS) capacitor c=4.27815e-17
C80 (\4\:Eb VSS) capacitor c=4.04364e-17
C81 (\13\:Dp VSS) capacitor c=8.29391e-17
C82 (\3\:n3 VSS) capacitor c=8.49472e-17
C83 (\11\:Dp VSS) capacitor c=2.87487e-17
C84 (\3\:n2 VSS) capacitor c=7.23379e-17
C85 (\11\:VDD VSS) capacitor c=1.47061e-17
C86 (\6\:RNb VSS) capacitor c=4.63496e-17
C87 (\6\:CKbb VSS) capacitor c=3.31274e-17
C88 (\13\:VDD VSS) capacitor c=1.74449e-17
C89 (\5\:n20 VSS) capacitor c=1.84632e-17
C90 (\15\:VDD VSS) capacitor c=1.27987e-17
C91 (\8\:mout VSS) capacitor c=3.91829e-17
C92 (\8\:n30 VSS) capacitor c=4.21766e-17
C93 (\17\:VDD VSS) capacitor c=7.8639e-17
C94 (\16\:qbint VSS) capacitor c=9.21781e-17
C95 (\19\:CKb VSS) capacitor c=6.62446e-17
C96 (\19\:VDD VSS) capacitor c=3.12974e-17
C97 (\1\:Q VSS) capacitor c=5.3205e-17
C98 (\5\:qint VSS) capacitor c=2.54911e-17
C99 (\22\:VDD VSS) capacitor c=1.75742e-17
C100 (\1\:QN VSS) capacitor c=3.57749e-17
C101 (\3\:VDD VSS) capacitor c=9.89437e-17
C102 (\7\:Db VSS) capacitor c=3.3091e-17
C103 (\8\:Eb VSS) capacitor c=1.14929e-16
C104 (\4\:Dp VSS) capacitor c=1.05398e-16
C105 (\8\:Dp VSS) capacitor c=2.53495e-17
C106 (\8\:RNb VSS) capacitor c=4.7946e-17
C107 (\10\:CKbb VSS) capacitor c=4.15466e-17
C108 (\9\:n20 VSS) capacitor c=8.52921e-17
C109 (\6\:mout VSS) capacitor c=4.62858e-17
C110 (\6\:n30 VSS) capacitor c=5.75595e-17
C111 (\20\:qbint VSS) capacitor c=6.66264e-17
C112 (\17\:CKb VSS) capacitor c=1.44483e-16
C113 (\4\:Q VSS) capacitor c=2.13384e-17
C114 (\9\:qint VSS) capacitor c=2.74146e-17
C115 (\3\:QN VSS) capacitor c=2.71271e-17
C116 (\2\:qint VSS) capacitor c=7.89869e-18
C117 (\3\:qbint VSS) capacitor c=3.41223e-17
C118 (\2\:n20 VSS) capacitor c=3.95531e-17
C119 (\7\:qint VSS) capacitor c=2.81958e-17
C120 (\8\:qint VSS) capacitor c=1.972e-17
C121 (\4\:CK VSS) capacitor c=5.56118e-17
C122 (\5\:E VSS) capacitor c=2.29658e-17
C123 (\4\:n30 VSS) capacitor c=6.64004e-17
C124 (\5\:n30 VSS) capacitor c=6.40386e-17
C125 (\4\:mout VSS) capacitor c=5.65719e-17
C126 (\5\:mout VSS) capacitor c=5.91103e-17
C127 (\7\:n20 VSS) capacitor c=6.07806e-17
C128 (\8\:n20 VSS) capacitor c=7.04273e-17
C129 (\12\:CKb VSS) capacitor c=4.4046e-17
C130 (\13\:CKb VSS) capacitor c=1.09462e-16
C131 (\14\:CKb VSS) capacitor c=1.55131e-16
C132 (\15\:CKb VSS) capacitor c=1.02612e-16
C133 (\16\:CKb VSS) capacitor c=1.88572e-16
C134 (\21\:CKb VSS) capacitor c=4.84196e-17
C135 (\22\:CKb VSS) capacitor c=6.98299e-17
C136 (\8\:CKbb VSS) capacitor c=6.07125e-17
C137 (\9\:CKbb VSS) capacitor c=7.17699e-17
C138 (\4\:RN VSS) capacitor c=2.98768e-17
C139 (\4\:RNb VSS) capacitor c=5.97389e-17
C140 (\5\:RNb VSS) capacitor c=5.62332e-17
C141 (\13\:qbint VSS) capacitor c=2.00567e-16
C142 (\15\:qbint VSS) capacitor c=8.37726e-17
C143 (\18\:qbint VSS) capacitor c=1.63643e-16
C144 (\19\:qbint VSS) capacitor c=2.54358e-16
C145 (\6\:Dp VSS) capacitor c=2.86028e-16
C146 (\7\:Dp VSS) capacitor c=1.59147e-16
C147 (\10\:Dp VSS) capacitor c=1.26257e-16
C148 (\8\:E VSS) capacitor c=7.41641e-17
C149 (\9\:E VSS) capacitor c=7.56673e-17
C150 (\7\:Eb VSS) capacitor c=1.60652e-16
C151 (\4\:D VSS) capacitor c=3.79498e-17
C152 (\6\:Db VSS) capacitor c=9.98641e-17
C153 (\5\:VDD VSS) capacitor c=4.61343e-17
C154 (\6\:VDD VSS) capacitor c=2.42672e-17
C155 (\8\:VDD VSS) capacitor c=3.53237e-17
C156 (\9\:VDD VSS) capacitor c=3.9628e-17
C157 (\21\:VDD VSS) capacitor c=1.17535e-17
Rk53 (\4\:D D) resistor r=0.1309 c=0
Rk7 (\3\:Q Q) resistor r=0.02419 c=0
Rk6 (\2\:Q \3\:Q) resistor r=0.4387 c=0
Rk8 (\3\:Q \5\:Q) resistor r=0.179 c=0
Rk9 (CK \4\:CK) resistor r=0.1694 c=0
Rk48 (\8\:E E) resistor r=0.245 c=0
Rk49 (E \9\:E) resistor r=0.002376 c=0
Rk71 (\2\:VSS \4\:VSS) resistor r=0.7607 c=0
Rk72 (\4\:VSS \5\:VSS) resistor r=0.1352 c=0
Rk73 (\5\:VSS \6\:VSS) resistor r=0.1274 c=0
Rk74 (\6\:VSS \7\:VSS) resistor r=0.2277 c=0
Rk75 (\7\:VSS \8\:VSS) resistor r=0.4849 c=0
Rk76 (\8\:VSS \9\:VSS) resistor r=0.2244 c=0
Rk77 (\9\:VSS \10\:VSS) resistor r=0.2505 c=0
Rk78 (\10\:VSS \11\:VSS) resistor r=0.5109 c=0
Rk79 (\11\:VSS \12\:VSS) resistor r=0.441 c=0
Rk80 (\5\:VSS \14\:VSS) resistor r=0.202 c=0
Rk81 (\6\:VSS \16\:VSS) resistor r=0.202 c=0
Rk82 (\7\:VSS \18\:VSS) resistor r=0.2125 c=0
Rk83 (\8\:VSS \20\:VSS) resistor r=0.04328 c=0
Rk84 (\10\:VSS \22\:VSS) resistor r=0.2544 c=0
Rk85 (\11\:VSS \24\:VSS) resistor r=0.3404 c=0
Rk87 (\25\:VSS VSS) resistor r=0.2151 c=0
Rk86 (\12\:VSS \25\:VSS) resistor r=0.3361 c=0
Rk88 (\12\:VSS \27\:VSS) resistor r=0.401 c=0
Rk89 (\25\:VSS \29\:VSS) resistor r=0.07358 c=0
Rk56 (\2\:VDD \4\:VDD) resistor r=0.5762 c=0
Rk57 (\4\:VDD \5\:VDD) resistor r=0.5688 c=0
Rk58 (\5\:VDD \6\:VDD) resistor r=0.4633 c=0
Rk59 (\6\:VDD \7\:VDD) resistor r=0.1703 c=0
Rk60 (\7\:VDD \8\:VDD) resistor r=0.278 c=0
Rk61 (\8\:VDD \9\:VDD) resistor r=0.526 c=0
Rk62 (\9\:VDD \10\:VDD) resistor r=0.3983 c=0
Rk63 (\5\:VDD \12\:VDD) resistor r=0.07358 c=0
Rk64 (\6\:VDD \14\:VDD) resistor r=0.1022 c=0
Rk65 (\8\:VDD \16\:VDD) resistor r=0.07358 c=0
Rk66 (\9\:VDD \18\:VDD) resistor r=0.3694 c=0
Rk67 (\10\:VDD \20\:VDD) resistor r=0.175 c=0
Rk70 (\21\:VDD VDD) resistor r=0.2151 c=0
Rk68 (\10\:VDD \21\:VDD) resistor r=0.3361 c=0
Rk69 (\21\:VDD \23\:VDD) resistor r=0.2233 c=0
Rk30 (\4\:RN RN) resistor r=0.07165 c=0
Rk2 (\4\:QN QN) resistor r=0.09283 c=0
Rk1 (\2\:QN \4\:QN) resistor r=0.3053 c=0
Rk3 (\6\:qint \7\:qint) resistor r=0.1296 c=0
Rk4 (\7\:qint \8\:qint) resistor r=0.1192 c=0
Rk5 (\7\:qint \10\:qint) resistor r=0.0936 c=0
Rk34 (\13\:qbint \14\:qbint) resistor r=1.9974 c=0
Rk35 (\14\:qbint \15\:qbint) resistor r=0.5272 c=0
Rk36 (\15\:qbint \17\:qbint) resistor r=0.05765 c=0
Rk37 (\17\:qbint \18\:qbint) resistor r=1.0114 c=0
Rk38 (\14\:qbint \19\:qbint) resistor r=0.04612 c=0
Rk39 (\15\:qbint \21\:qbint) resistor r=0.3747 c=0
Rk19 (\12\:CKb \13\:CKb) resistor r=0.2736 c=0
Rk20 (\13\:CKb \14\:CKb) resistor r=0.6521 c=0
Rk21 (\14\:CKb \15\:CKb) resistor r=0.6405 c=0
Rk22 (\15\:CKb \16\:CKb) resistor r=0.1789 c=0
Rk23 (\16\:CKb \18\:CKb) resistor r=1.201 c=0
Rk24 (\18\:CKb \20\:CKb) resistor r=0.3632 c=0
Rk25 (\14\:CKb \21\:CKb) resistor r=0.21 c=0
Rk26 (\15\:CKb \22\:CKb) resistor r=0.3497 c=0
Rk10 (\4\:n30 \5\:n30) resistor r=0.314 c=0
Rk11 (\5\:n30 \7\:n30) resistor r=0.2323 c=0
Rk12 (\5\:n30 \9\:n30) resistor r=0.1882 c=0
Rk13 (\4\:mout \5\:mout) resistor r=0.2539 c=0
Rk14 (\5\:mout \7\:mout) resistor r=0.1504 c=0
Rk15 (\5\:mout \9\:mout) resistor r=0.2658 c=0
Rk27 (\7\:CKbb \8\:CKbb) resistor r=0.1404 c=0
Rk28 (\8\:CKbb \9\:CKbb) resistor r=0.4133 c=0
Rk29 (\8\:CKbb \11\:CKbb) resistor r=0.2357 c=0
Rk16 (\6\:n20 \7\:n20) resistor r=0.05734 c=0
Rk17 (\7\:n20 \8\:n20) resistor r=0.415 c=0
Rk18 (\7\:n20 \10\:n20) resistor r=0.381 c=0
Rk42 (\5\:Dp \6\:Dp) resistor r=0.7338 c=0
Rk43 (\6\:Dp \7\:Dp) resistor r=1.3263 c=0
Rk44 (\6\:Dp \9\:Dp) resistor r=0.09158 c=0
Rk45 (\6\:Dp \10\:Dp) resistor r=0.7072 c=0
Rk46 (\10\:Dp \12\:Dp) resistor r=0.0496 c=0
Rk47 (\10\:Dp \14\:Dp) resistor r=0.3172 c=0
Rk31 (\4\:RNb \5\:RNb) resistor r=0.2715 c=0
Rk32 (\5\:RNb \7\:RNb) resistor r=0.2862 c=0
Rk33 (\5\:RNb \9\:RNb) resistor r=0.2124 c=0
Rk50 (\5\:Eb \6\:Eb) resistor r=0.2114 c=0
Rk51 (\6\:Eb \7\:Eb) resistor r=0.8562 c=0
Rk52 (\6\:Eb \9\:Eb) resistor r=0.0529 c=0
Rk54 (\5\:Db \6\:Db) resistor r=0.9098 c=0
Rk55 (\5\:Db \8\:Db) resistor r=0.2562 c=0
Rk40 (\2\:n2 \4\:n2) resistor r=0.3108 c=0
Rk41 (\2\:n3 \4\:n3) resistor r=0.4714 c=0
Rl47 (\1\:D \2\:D) resistor r=26.1559 c=0
Rl48 (\2\:D \3\:D) resistor r=37.6944 c=0
Rl9 (\1\:CK \2\:CK) resistor r=42.3077 c=0
Rl10 (\2\:CK \3\:CK) resistor r=39.5604 c=0
Rl41 (\2\:E \3\:E) resistor r=63.4387 c=0
Rl40 (\1\:E \2\:E) resistor r=134.41 c=0
Rl44 (\4\:E \5\:E) resistor r=39.6181 c=0
Rl46 (\5\:E \7\:E) resistor r=49.2335 c=0
Rl45 (\5\:E \6\:E) resistor r=125.373 c=0
Rl32 (\1\:RN \2\:RN) resistor r=56.9251 c=0
Rl33 (\2\:RN \3\:RN) resistor r=137.694 c=0
Rl3 (\2\:qint \4\:qint) resistor r=49.7141 c=0
Rl2 (\2\:qint \3\:qint) resistor r=34.3295 c=0
Rl1 (qint \2\:qint) resistor r=5.915 c=0
Rl36 (\10\:qbint \11\:qbint) resistor r=241.873 c=0
Rl14 (\7\:qbint \9\:qbint) resistor r=165.385 c=0
Rl37 (\11\:qbint \12\:qbint) resistor r=24.2328 c=0
Rl13 (\7\:qbint \8\:qbint) resistor r=35.7713 c=0
Rl4 (qbint \2\:qbint) resistor r=24.2328 c=0
Rl7 (\2\:qbint \5\:qbint) resistor r=53.079 c=0
Rl8 (\3\:qbint \6\:qbint) resistor r=47.3105 c=0
Rl6 (\3\:qbint \4\:qbint) resistor r=41.5412 c=0
Rl5 (\2\:qbint \3\:qbint) resistor r=167.299 c=0
Rl31 (\10\:CKb \11\:CKb) resistor r=103.079 c=0
Rl30 (\9\:CKb \10\:CKb) resistor r=57.2464 c=0
Rl27 (\7\:CKb \8\:CKb) resistor r=33.8482 c=0
Rl22 (\5\:CKb \6\:CKb) resistor r=62.6944 c=0
Rl16 (\3\:CKb \4\:CKb) resistor r=62.6944 c=0
Rl15 (CKb \2\:CKb) resistor r=43.4636 c=0
Rl11 (n30 \2\:n30) resistor r=24.2328 c=0
Rl12 (\2\:n30 \3\:n30) resistor r=53.079 c=0
Rl21 (\2\:mout \3\:mout) resistor r=103.079 c=0
Rl20 (mout \2\:mout) resistor r=60.6695 c=0
Rl26 (\4\:CKbb \5\:CKbb) resistor r=201.054 c=0
Rl25 (\3\:CKbb \4\:CKbb) resistor r=459.181 c=0
Rl23 (CKbb \2\:CKbb) resistor r=41.5405 c=0
Rl24 (\2\:CKbb \3\:CKbb) resistor r=172.197 c=0
Rl18 (\2\:n20 \3\:n20) resistor r=49.7185 c=0
Rl17 (n20 \2\:n20) resistor r=118.949 c=0
Rl19 (\2\:n20 \4\:n20) resistor r=3.3229 c=0
Rl28 (Dp \2\:Dp) resistor r=165.385 c=0
Rl29 (\2\:Dp \3\:Dp) resistor r=24.2328 c=0
Rl35 (\2\:RNb \3\:RNb) resistor r=118.464 c=0
Rl34 (RNb \2\:RNb) resistor r=94.9523 c=0
Rl38 (Eb \2\:Eb) resistor r=115.18 c=0
Rl39 (\2\:Eb \3\:Eb) resistor r=74.168 c=0
Rl42 (Db \2\:Db) resistor r=226.489 c=0
Rl43 (\2\:Db \3\:Db) resistor r=24.2328 c=0
Rz3 (\4\:Q \5\:Q) resistor r=75 c=0
Rz18 (\1\:VSS \2\:VSS) resistor r=75 c=0
Rz19 (\13\:VSS \14\:VSS) resistor r=75 c=0
Rz20 (\15\:VSS \16\:VSS) resistor r=75 c=0
Rz21 (\17\:VSS \18\:VSS) resistor r=75 c=0
Rz22 (\19\:VSS \20\:VSS) resistor r=75 c=0
Rz23 (\21\:VSS \22\:VSS) resistor r=75 c=0
Rz24 (\23\:VSS \24\:VSS) resistor r=75 c=0
Rz25 (\26\:VSS \27\:VSS) resistor r=75 c=0
Rz26 (\28\:VSS \29\:VSS) resistor r=75 c=0
Rz15 (\3\:VDD \4\:VDD) resistor r=6.25 c=0
Rz16 (\3\:VDD \7\:VDD) resistor r=6.25 c=0
Rz17 (\3\:VDD \10\:VDD) resistor r=6.25 c=0
Rz1 (\3\:QN \4\:QN) resistor r=75 c=0
Rz2 (\9\:qint \10\:qint) resistor r=75 c=0
Rz10 (\20\:qbint \21\:qbint) resistor r=75 c=0
Rz7 (\17\:CKb \18\:CKb) resistor r=75 c=0
Rz4 (\6\:n30 \7\:n30) resistor r=75 c=0
Rz5 (\6\:mout \7\:mout) resistor r=75 c=0
Rz8 (\10\:CKbb \11\:CKbb) resistor r=75 c=0
Rz6 (\9\:n20 \10\:n20) resistor r=75 c=0
Rz11 (\4\:Dp \5\:Dp) resistor r=75 c=0
Rz12 (\8\:Dp \9\:Dp) resistor r=75 c=0
Rz9 (\8\:RNb \9\:RNb) resistor r=75 c=0
Rz13 (\8\:Eb \9\:Eb) resistor r=75 c=0
Rz14 (\7\:Db \8\:Db) resistor r=75 c=0
Ry3 (\1\:Q \2\:Q) resistor r=62 c=0
Ry26 (\3\:VSS \4\:VSS) resistor r=5.1667 c=0
Ry27 (\3\:VSS \9\:VSS) resistor r=5.1667 c=0
Ry28 (\3\:VSS \12\:VSS) resistor r=5.1667 c=0
Ry19 (\1\:VDD \2\:VDD) resistor r=62 c=0
Ry20 (\11\:VDD \12\:VDD) resistor r=62 c=0
Ry21 (\13\:VDD \14\:VDD) resistor r=62 c=0
Ry22 (\15\:VDD \16\:VDD) resistor r=62 c=0
Ry23 (\17\:VDD \18\:VDD) resistor r=62 c=0
Ry24 (\19\:VDD \20\:VDD) resistor r=62 c=0
Ry25 (\22\:VDD \23\:VDD) resistor r=62 c=0
Ry1 (\1\:QN \2\:QN) resistor r=20.6667 c=0
Ry2 (\5\:qint \6\:qint) resistor r=62 c=0
Ry10 (\16\:qbint \17\:qbint) resistor r=31 c=0
Ry7 (\19\:CKb \20\:CKb) resistor r=62 c=0
Ry4 (\8\:n30 \9\:n30) resistor r=62 c=0
Ry5 (\8\:mout \9\:mout) resistor r=62 c=0
Ry8 (\6\:CKbb \7\:CKbb) resistor r=62 c=0
Ry6 (\5\:n20 \6\:n20) resistor r=62 c=0
Ry15 (\11\:Dp \12\:Dp) resistor r=62 c=0
Ry16 (\13\:Dp \14\:Dp) resistor r=62 c=0
Ry9 (\6\:RNb \7\:RNb) resistor r=62 c=0
Ry17 (\4\:Eb \5\:Eb) resistor r=62 c=0
Ry18 (\4\:Db \5\:Db) resistor r=62 c=0
Ry11 (n2 \2\:n2) resistor r=62 c=0
Ry12 (\3\:n2 \4\:n2) resistor r=62 c=0
Ry13 (n3 \2\:n3) resistor r=62 c=0
Ry14 (\3\:n3 \4\:n3) resistor r=62 c=0
Rx21 (\2\:D \4\:D) resistor r=45 c=0
Rx2 (\2\:CK \4\:CK) resistor r=45 c=0
Rx18 (\2\:E \8\:E) resistor r=45 c=0
Rx19 (\6\:E \9\:E) resistor r=45 c=0
Rx12 (\2\:RN \4\:RN) resistor r=45 c=0
Rx1 (qint \8\:qint) resistor r=45 c=0
Rx14 (\12\:qbint \13\:qbint) resistor r=45 c=0
Rx15 (\2\:qbint \18\:qbint) resistor r=45 c=0
Rx16 (\8\:qbint \19\:qbint) resistor r=45 c=0
Rx6 (\10\:CKb \12\:CKb) resistor r=45 c=0
Rx7 (\8\:CKb \13\:CKb) resistor r=45 c=0
Rx8 (\2\:CKb \16\:CKb) resistor r=45 c=0
Rx9 (\6\:CKb \21\:CKb) resistor r=45 c=0
Rx10 (\4\:CKb \22\:CKb) resistor r=45 c=0
Rx3 (\2\:n30 \4\:n30) resistor r=45 c=0
Rx4 (\2\:mout \4\:mout) resistor r=45 c=0
Rx11 (\2\:CKbb \9\:CKbb) resistor r=45 c=0
Rx5 (\4\:n20 \8\:n20) resistor r=45 c=0
Rx17 (\3\:Dp \7\:Dp) resistor r=45 c=0
Rx13 (\2\:RNb \4\:RNb) resistor r=45 c=0
Rx20 (\2\:Eb \7\:Eb) resistor r=45 c=0
Rx22 (\3\:Db \6\:Db) resistor r=45 c=0
mn57 (\3\:QN \3\:qint \28\:VSS VSS) g45n1hvt w=(2.6e-07) l=4.5e-08 nf=1 \
        as=6.273e-14 ad=3.64e-14 ps=1.67e-06 pd=8e-07 nrd=1.16667 \
        nrs=1.16667 sa=1.4e-07 sb=2.50577e-07 sd=160n sca=17.5885 \
        scb=0.0172826 scc=0.00162584 m=(1)
mn55 (\4\:Q \5\:qbint \26\:VSS VSS) g45n1hvt w=(2.6e-07) l=4.5e-08 nf=1 \
        as=3.542e-14 ad=3.64e-14 ps=8.5e-07 pd=8e-07 nrd=1.16667 \
        nrs=1.16667 sa=1.4e-07 sb=2.39423e-07 sd=160n sca=13.9783 \
        scb=0.013979 scc=0.000942864 m=(1)
mn56 (\9\:qint \4\:qbint \28\:VSS VSS) g45n1hvt w=(1.45e-07) l=4.5e-08 \
        nf=1 as=6.273e-14 ad=2.03e-14 ps=1.67e-06 pd=5.7e-07 nrd=1.16667 \
        nrs=1.16667 sa=3.7e-07 sb=1.4e-07 sd=160n sca=23.279 scb=0.0230742 \
        scc=0.00267719 m=(1)
mn20 (\17\:CKb \3\:CK \26\:VSS VSS) g45n1hvt w=(1.45e-07) l=4.5e-08 nf=1 \
        as=3.542e-14 ad=2.03e-14 ps=8.5e-07 pd=5.7e-07 nrd=1.16667 \
        nrs=1.16667 sa=3.5e-07 sb=1.4e-07 sd=160n sca=17.8702 \
        scb=0.0189183 scc=0.00156031 m=(1)
mn50 (net496 \9\:qbint \23\:VSS VSS) g45n1hvt w=(1.45e-07) l=4.5e-08 \
        nf=1 as=4.08e-14 ad=8.7e-15 ps=8.9e-07 pd=4.1e-07 nrd=1.16667 \
        nrs=1.16667 sa=5.6e-07 sb=2e-06 sd=160n sca=15.2405 scb=0.016218 \
        scc=0.00104639 m=(1)
mn51 (\6\:n30 CKb net496 VSS) g45n1hvt w=(1.45e-07) l=4.5e-08 nf=1 \
        as=8.7e-15 ad=2.32e-14 ps=4.1e-07 pd=6.1e-07 nrd=1.16667 \
        nrs=1.16667 sa=6.65e-07 sb=1.995e-06 sd=160n sca=15.2405 \
        scb=0.016218 scc=0.00104639 m=(1)
mn40 (\6\:n30 \4\:CKbb \6\:mout VSS) g45n1hvt w=(1.45e-07) l=4.5e-08 nf=1 \
        as=5.148e-14 ad=2.32e-14 ps=1e-06 pd=6.1e-07 nrd=1.16667 \
        nrs=1.16667 sa=8.7e-07 sb=1.79e-06 sd=160n sca=15.2405 \
        scb=0.016218 scc=0.00104639 m=(1)
mn30 (\6\:mout n20 \21\:VSS VSS) g45n1hvt w=(1.45e-07) l=4.5e-08 nf=1 \
        as=5.453e-14 ad=5.148e-14 ps=1.08e-06 pd=1e-06 nrd=1.16667 \
        nrs=1.16667 sa=1.27e-06 sb=1.39e-06 sd=160n sca=15.2405 \
        scb=0.016218 scc=0.00104639 m=(1)
mn35 (net516 mout \21\:VSS VSS) g45n1hvt w=(1.45e-07) l=4.5e-08 nf=1 \
        as=5.453e-14 ad=8.7e-15 ps=1.08e-06 pd=4.1e-07 nrd=1.16667 \
        nrs=1.16667 sa=1.6e-06 sb=1.06e-06 sd=160n sca=15.2405 \
        scb=0.016218 scc=0.00104639 m=(1)
mn36 (\9\:n20 \3\:CKbb net516 VSS) g45n1hvt w=(1.45e-07) l=4.5e-08 nf=1 \
        as=8.7e-15 ad=3.553e-14 ps=4.1e-07 pd=7.8e-07 nrd=1.16667 \
        nrs=1.16667 sa=1.705e-06 sb=9.55e-07 sd=160n sca=15.2405 \
        scb=0.016218 scc=0.00104639 m=(1)
mn26 (\9\:n20 \7\:CKb n21 VSS) g45n1hvt w=(1.45e-07) l=4.5e-08 nf=1 \
        as=1.958e-14 ad=3.553e-14 ps=5.6e-07 pd=7.8e-07 nrd=1.16667 \
        nrs=1.16667 sa=1.995e-06 sb=6.65e-07 sd=160n sca=15.2405 \
        scb=0.016218 scc=0.00104639 m=(1)
mn25 (n21 \2\:Dp \19\:VSS VSS) g45n1hvt w=(1.45e-07) l=4.5e-08 nf=1 \
        as=8.85e-14 ad=1.957e-14 ps=1.64e-06 pd=5.6e-07 nrd=1.16667 \
        nrs=1.16667 sa=2e-06 sb=4.85e-07 sd=160n sca=15.2405 scb=0.016218 \
        scc=0.00104639 m=(1)
mn21 (\10\:CKbb \9\:CKb \19\:VSS VSS) g45n1hvt w=(1.45e-07) l=4.5e-08 \
        nf=1 as=8.85e-14 ad=2.03e-14 ps=1.64e-06 pd=5.7e-07 nrd=1.16667 \
        nrs=1.16667 sa=2e-06 sb=1.4e-07 sd=160n sca=15.2405 scb=0.016218 \
        scc=0.00104639 m=(1)
mn2 (\8\:RNb \3\:RN \17\:VSS VSS) g45n1hvt w=(1.45e-07) l=4.5e-08 nf=1 \
        as=4.568e-14 ad=2.32e-14 ps=9.2e-07 pd=6.1e-07 nrd=1.16667 \
        nrs=1.16667 sa=1.6e-07 sb=8.1e-07 sd=160n sca=7.47547 \
        scb=0.00467957 scc=5.27432e-05 m=(1)
mn3 (\8\:Dp RNb \17\:VSS VSS) g45n1hvt w=(1.45e-07) l=4.5e-08 nf=1 \
        as=4.568e-14 ad=2.32e-14 ps=9.2e-07 pd=6.1e-07 nrd=1.16667 \
        nrs=1.16667 sa=5.2e-07 sb=4.5e-07 sd=160n sca=7.47547 \
        scb=0.00467957 scc=5.27432e-05 m=(1)
mn5 (\8\:Dp \10\:qbint n0 VSS) g45n1hvt w=(1.45e-07) l=4.5e-08 nf=1 \
        as=8.7e-15 ad=2.32e-14 ps=4.1e-07 pd=6.1e-07 nrd=1.16667 \
        nrs=1.16667 sa=7.25e-07 sb=2.45e-07 sd=160n sca=7.47547 \
        scb=0.00467957 scc=5.27432e-05 m=(1)
mn4 (n0 \3\:Eb \15\:VSS VSS) g45n1hvt w=(1.45e-07) l=4.5e-08 nf=1 \
        as=2.03e-14 ad=8.7e-15 ps=5.7e-07 pd=4.1e-07 nrd=1.16667 \
        nrs=1.16667 sa=8.3e-07 sb=1.4e-07 sd=160n sca=7.47547 \
        scb=0.00467957 scc=5.27432e-05 m=(1)
mn6 (n1 \1\:E \13\:VSS VSS) g45n1hvt w=(1.45e-07) l=4.5e-08 nf=1 \
        as=2.03e-14 ad=8.7e-15 ps=5.7e-07 pd=4.1e-07 nrd=1.16667 \
        nrs=1.16667 sa=1.4e-07 sb=2.45e-07 sd=160n sca=7.47547 \
        scb=0.00467957 scc=5.27432e-05 m=(1)
mn7 (\4\:Dp Db n1 VSS) g45n1hvt w=(1.45e-07) l=4.5e-08 nf=1 as=8.7e-15 \
        ad=2.03e-14 ps=4.1e-07 pd=5.7e-07 nrd=1.16667 nrs=1.16667 \
        sa=2.45e-07 sb=1.4e-07 sd=160n sca=7.47547 scb=0.00467957 \
        scc=5.27432e-05 m=(1)
mn0 (\8\:Eb \7\:E \1\:VSS VSS) g45n1hvt w=(1.45e-07) l=4.5e-08 nf=1 \
        as=3.19e-14 ad=2.03e-14 ps=7.3e-07 pd=5.7e-07 nrd=1.16667 \
        nrs=1.16667 sa=1.4e-07 sb=4.25e-07 sd=160n sca=23.279 \
        scb=0.0230742 scc=0.00267719 m=(1)
mn1 (\7\:Db \3\:D \1\:VSS VSS) g45n1hvt w=(1.45e-07) l=4.5e-08 nf=1 \
        as=3.19e-14 ad=2.32e-14 ps=7.3e-07 pd=6.1e-07 nrd=1.16667 \
        nrs=1.16667 sa=4.05e-07 sb=1.6e-07 sd=160n sca=23.279 \
        scb=0.0230742 scc=0.00267719 m=(1)
mn45 (\20\:qbint \3\:n30 \23\:VSS VSS) g45n1hvt w=(2.05e-07) l=4.5e-08 \
        nf=1 as=4.08e-14 ad=5.638e-14 ps=8.9e-07 pd=9.6e-07 nrd=1.16667 \
        nrs=1.16667 sa=2.75e-07 sb=1.4439e-06 sd=160n sca=19.867 \
        scb=0.0198061 scc=0.00201945 m=(1)
mp56 (\5\:qint \6\:qbint \22\:VDD VDD) g45p1hvt w=(2.15e-07) l=4.5e-08 \
        nf=1 as=7.142e-14 ad=2.63e-14 ps=1.52e-06 pd=7.1e-07 nrd=1.16667 \
        nrs=1.16667 sa=3.7e-07 sb=1.22326e-07 sd=160n sca=46.9517 \
        scb=0.029008 scc=0.00588492 m=(1)
mp20 (\19\:CKb \1\:CK \19\:VDD VDD) g45p1hvt w=(2.15e-07) l=4.5e-08 nf=1 \
        as=1.0705e-13 ad=4.3e-14 ps=1.72e-06 pd=8.3e-07 nrd=1.16667 \
        nrs=1.16667 sa=3.82442e-07 sb=2e-07 sd=160n sca=45.7906 \
        scb=0.0283307 scc=0.00588417 m=(1)
mp50 (net411 \7\:qbint \17\:VDD VDD) g45p1hvt w=(2.15e-07) l=4.5e-08 \
        nf=1 as=6.11e-14 ad=1.72e-14 ps=1.1e-06 pd=5.9e-07 nrd=1.16667 \
        nrs=1.16667 sa=4.25e-07 sb=2e-06 sd=160n sca=15.2551 scb=0.0150251 \
        scc=0.000885438 m=(1)
mp51 (\8\:n30 \5\:CKbb net411 VDD) g45p1hvt w=(2.15e-07) l=4.5e-08 nf=1 \
        as=1.72e-14 ad=3.44e-14 ps=5.9e-07 pd=7.5e-07 nrd=1.16667 \
        nrs=1.16667 sa=5.5e-07 sb=1.895e-06 sd=160n sca=15.2551 \
        scb=0.0150251 scc=0.000885438 m=(1)
mp40 (\8\:n30 \3\:CKb \8\:mout VDD) g45p1hvt w=(2.15e-07) l=4.5e-08 nf=1 \
        as=6.773e-14 ad=3.44e-14 ps=1.06e-06 pd=7.5e-07 nrd=1.16667 \
        nrs=1.16667 sa=7.55e-07 sb=1.69e-06 sd=160n sca=15.2551 \
        scb=0.0150251 scc=0.000885438 m=(1)
mp30 (\8\:mout \3\:n20 \15\:VDD VDD) g45p1hvt w=(2.15e-07) l=4.5e-08 \
        nf=1 as=9.35e-14 ad=6.773e-14 ps=1.64e-06 pd=1.06e-06 nrd=1.16667 \
        nrs=1.16667 sa=1.115e-06 sb=1.33e-06 sd=160n sca=15.2551 \
        scb=0.0150251 scc=0.000885438 m=(1)
mp35 (net427 \3\:mout \15\:VDD VDD) g45p1hvt w=(2.15e-07) l=4.5e-08 nf=1 \
        as=9.35e-14 ad=1.29e-14 ps=1.64e-06 pd=5.5e-07 nrd=1.16667 \
        nrs=1.16667 sa=1.38e-06 sb=1.065e-06 sd=160n sca=15.2551 \
        scb=0.0150251 scc=0.000885438 m=(1)
mp36 (\5\:n20 \5\:CKb net427 VDD) g45p1hvt w=(2.15e-07) l=4.5e-08 nf=1 \
        as=1.29e-14 ad=6.558e-14 ps=5.5e-07 pd=1.04e-06 nrd=1.16667 \
        nrs=1.16667 sa=1.485e-06 sb=9.6e-07 sd=160n sca=15.2551 \
        scb=0.0150251 scc=0.000885438 m=(1)
mp26 (\5\:n20 CKbb n22 VDD) g45p1hvt w=(2.15e-07) l=4.5e-08 nf=1 \
        as=3.44e-14 ad=6.558e-14 ps=7.5e-07 pd=1.04e-06 nrd=1.16667 \
        nrs=1.16667 sa=1.835e-06 sb=6.1e-07 sd=160n sca=15.2551 \
        scb=0.0150251 scc=0.000885438 m=(1)
mp25 (n22 Dp \13\:VDD VDD) g45p1hvt w=(2.15e-07) l=4.5e-08 nf=1 \
        as=9.35e-14 ad=3.44e-14 ps=1.64e-06 pd=7.5e-07 nrd=1.16667 \
        nrs=1.16667 sa=2e-06 sb=4.05e-07 sd=160n sca=15.2551 scb=0.0150251 \
        scc=0.000885438 m=(1)
mp21 (\6\:CKbb \11\:CKb \13\:VDD VDD) g45p1hvt w=(2.15e-07) l=4.5e-08 \
        nf=1 as=9.35e-14 ad=3.01e-14 ps=1.64e-06 pd=7.1e-07 nrd=1.16667 \
        nrs=1.16667 sa=2e-06 sb=1.4e-07 sd=160n sca=15.2551 scb=0.0150251 \
        scc=0.000885438 m=(1)
mp2 (\6\:RNb \1\:RN \11\:VDD VDD) g45p1hvt w=(2.15e-07) l=4.5e-08 nf=1 \
        as=9.65e-14 ad=4.085e-14 ps=1.69e-06 pd=8.1e-07 nrd=1.16667 \
        nrs=1.16667 sa=1.9e-07 sb=8.15e-07 sd=160n sca=17.4145 \
        scb=0.0172865 scc=0.00131682 m=(1)
mp3 (\3\:n2 \3\:RNb \11\:VDD VDD) g45p1hvt w=(2.15e-07) l=4.5e-08 nf=1 \
        as=9.65e-14 ad=3.44e-14 ps=1.69e-06 pd=7.5e-07 nrd=1.16667 \
        nrs=1.16667 sa=4.55e-07 sb=5.5e-07 sd=160n sca=17.4145 \
        scb=0.0172865 scc=0.00131682 m=(1)
mp5 (n3 \11\:qbint \3\:n2 VDD) g45p1hvt w=(2.15e-07) l=4.5e-08 nf=1 \
        as=3.44e-14 ad=3.44e-14 ps=7.5e-07 pd=7.5e-07 nrd=1.16667 \
        nrs=1.16667 sa=6.6e-07 sb=3.45e-07 sd=160n sca=17.4145 \
        scb=0.0172865 scc=0.00131682 m=(1)
mp4 (n3 Eb n2 VDD) g45p1hvt w=(2.15e-07) l=4.5e-08 nf=1 as=3.01e-14 \
        ad=3.44e-14 ps=7.1e-07 pd=7.5e-07 nrd=1.16667 nrs=1.16667 \
        sa=8.65e-07 sb=1.4e-07 sd=160n sca=17.4145 scb=0.0172865 \
        scc=0.00131682 m=(1)
mp6 (\11\:Dp \3\:E \3\:n3 VDD) g45p1hvt w=(2.15e-07) l=4.5e-08 nf=1 \
        as=3.548e-14 ad=3.01e-14 ps=7.6e-07 pd=7.1e-07 nrd=1.16667 \
        nrs=1.16667 sa=1.4e-07 sb=3.6e-07 sd=160n sca=17.4145 \
        scb=0.0172865 scc=0.00131682 m=(1)
mp7 (\13\:Dp \2\:Db \3\:n3 VDD) g45p1hvt w=(2.15e-07) l=4.5e-08 nf=1 \
        as=3.548e-14 ad=3.225e-14 ps=7.6e-07 pd=7.3e-07 nrd=1.16667 \
        nrs=1.16667 sa=3.5e-07 sb=1.5e-07 sd=160n sca=17.4145 \
        scb=0.0172865 scc=0.00131682 m=(1)
mp0 (\4\:Eb \4\:E \1\:VDD VDD) g45p1hvt w=(2.15e-07) l=4.5e-08 nf=1 \
        as=9.23e-14 ad=3.01e-14 ps=1.62e-06 pd=7.1e-07 nrd=1.16667 \
        nrs=1.16667 sa=1.4e-07 sb=4.25e-07 sd=160n sca=47.8367 \
        scb=0.030096 scc=0.00588989 m=(1)
mp1 (\4\:Db \1\:D \1\:VDD VDD) g45p1hvt w=(2.15e-07) l=4.5e-08 nf=1 \
        as=9.23e-14 ad=3.44e-14 ps=1.62e-06 pd=7.5e-07 nrd=1.16667 \
        nrs=1.16667 sa=4.05e-07 sb=1.6e-07 sd=160n sca=55.1271 \
        scb=0.0420653 scc=0.00650135 m=(1)
mp45 (\16\:qbint n30 \17\:VDD VDD) g45p1hvt w=(3.1e-07) l=4.5e-08 nf=1 \
        as=6.11e-14 ad=4.34e-14 ps=1.1e-06 pd=9e-07 nrd=1.16667 \
        nrs=1.16667 sa=1.4e-07 sb=1.41774e-06 sd=160n sca=24.2842 \
        scb=0.0202139 scc=0.00265344 m=(1)
ends EDFFTRX1
// End of subcircuit definition.
