// Generated for: spectre (May  1 09:19:54 2013 )
// Library name: gsclib045_hvt
// Cell name: TLATNCAX3
// View name: extracted

simulator lang=spectre

subckt TLATNCAX3 CK E ECK VDD VSS
mp0 (\14\:CKb \1\:CK \19\:VDD VDD) g45p1hvt w=(2.15e-07) l=4.5e-08 nf=1 \
        as=3.01e-14 ad=3.01e-14 ps=7.1e-07 pd=7.1e-07 nrd=1.16667 \
        nrs=1.16667 sa=1.4e-07 sb=1.4e-07 sd=160n sca=54.8038 \
        scb=0.0416044 scc=0.00645165 m=(1)
mp1 (\14\:CKbb \4\:CKb \17\:VDD VDD) g45p1hvt w=(2.15e-07) l=4.5e-08 \
        nf=1 as=3.44e-14 ad=3.01e-14 ps=7.5e-07 pd=7.1e-07 nrd=1.16667 \
        nrs=1.16667 sa=1.4e-07 sb=1.15e-06 sd=160n sca=10.9938 \
        scb=0.00779206 scc=7.78676e-05 m=(1)
mp5 (net217 \3\:E \17\:VDD VDD) g45p1hvt w=(2.15e-07) l=4.5e-08 nf=1 \
        as=3.44e-14 ad=1.29e-14 ps=7.5e-07 pd=5.5e-07 nrd=1.16667 \
        nrs=1.16667 sa=3.45e-07 sb=9.45e-07 sd=160n sca=10.3176 \
        scb=0.00745056 scc=7.7647e-05 m=(1)
mp6 (\6\:n0 CKbb net217 VDD) g45p1hvt w=(2.15e-07) l=4.5e-08 nf=1 \
        as=1.29e-14 ad=4.3e-14 ps=5.5e-07 pd=8.3e-07 nrd=1.16667 \
        nrs=1.16667 sa=4.5e-07 sb=8.4e-07 sd=160n sca=10.1832 \
        scb=0.00742094 scc=7.76436e-05 m=(1)
mp16 (\6\:n0 \5\:CKb net205 VDD) g45p1hvt w=(2.15e-07) l=4.5e-08 nf=1 \
        as=4.407e-14 ad=4.3e-14 ps=8.4e-07 pd=8.3e-07 nrd=1.16667 \
        nrs=1.16667 sa=6.95e-07 sb=5.95e-07 sd=160n sca=10.1832 \
        scb=0.00742094 scc=7.76436e-05 m=(1)
mp15 (net205 \3\:Eint \15\:VDD VDD) g45p1hvt w=(2.15e-07) l=4.5e-08 nf=1 \
        as=3.44e-14 ad=4.407e-14 ps=7.5e-07 pd=8.4e-07 nrd=1.16667 \
        nrs=1.16667 sa=9.45e-07 sb=3.45e-07 sd=160n sca=10.1832 \
        scb=0.00742094 scc=7.76436e-05 m=(1)
mp10 (\13\:Eint \3\:n0 \15\:VDD VDD) g45p1hvt w=(2.15e-07) l=4.5e-08 \
        nf=1 as=3.44e-14 ad=3.01e-14 ps=7.5e-07 pd=7.1e-07 nrd=1.16667 \
        nrs=1.16667 sa=1.15e-06 sb=1.4e-07 sd=160n sca=10.1832 \
        scb=0.00742094 scc=7.76436e-05 m=(1)
C1 (VDD VSS) capacitor c=1.87057e-16
C2 (CK VSS) capacitor c=5.33352e-17
C3 (ECK VSS) capacitor c=2.83502e-17
C4 (E VSS) capacitor c=7.11437e-17
C5 (CKb VSS) capacitor c=3.53393e-17
C6 (CKbb VSS) capacitor c=6.3854e-17
C7 (net254 VSS) capacitor c=3.02785e-18
C8 (n0 VSS) capacitor c=2.98019e-17
C9 (Eint VSS) capacitor c=7.598e-17
C10 (net238 VSS) capacitor c=1.63395e-18
C11 (ECKb VSS) capacitor c=1.87683e-16
C12 (net205 VSS) capacitor c=2.41748e-18
C13 (\4\:Eint VSS) capacitor c=4.82577e-17
C14 (\7\:CKbb VSS) capacitor c=4.75839e-17
C15 (\3\:n0 VSS) capacitor c=5.63133e-17
C16 (\3\:Eint VSS) capacitor c=4.05091e-17
C17 (\5\:CKb VSS) capacitor c=5.27646e-17
C18 (\3\:E VSS) capacitor c=7.44024e-17
C19 (\4\:CKb VSS) capacitor c=5.71352e-17
C20 (\1\:CK VSS) capacitor c=2.75447e-17
C21 (\6\:Eint VSS) capacitor c=7.75264e-17
C22 (\5\:CKbb VSS) capacitor c=5.61766e-17
C23 (\3\:CKbb VSS) capacitor c=7.81924e-17
C24 (\8\:CKb VSS) capacitor c=4.34972e-17
C25 (\1\:E VSS) capacitor c=5.93975e-17
C26 (\4\:CK VSS) capacitor c=1.97471e-17
C27 (\5\:ECKb VSS) capacitor c=2.18879e-17
C28 (\5\:Eint VSS) capacitor c=4.61313e-17
C29 (\6\:CKbb VSS) capacitor c=4.54632e-17
C30 (\2\:n0 VSS) capacitor c=4.00303e-17
C31 (\2\:Eint VSS) capacitor c=5.81921e-17
C32 (\4\:CKbb VSS) capacitor c=3.21148e-17
C33 (\2\:CKbb VSS) capacitor c=5.03505e-17
C34 (\7\:CKb VSS) capacitor c=5.20508e-17
C35 (\2\:E VSS) capacitor c=9.95073e-17
C36 (\3\:CKb VSS) capacitor c=1.67766e-17
C37 (\3\:CK VSS) capacitor c=1.08957e-17
C38 (\1\:ECK VSS) capacitor c=1.31929e-16
C39 (\1\:VDD VSS) capacitor c=1.17448e-16
C40 (\11\:ECKb VSS) capacitor c=9.50808e-17
C41 (\13\:VDD VSS) capacitor c=2.92118e-17
C42 (\13\:Eint VSS) capacitor c=2.81692e-17
C43 (\15\:VDD VSS) capacitor c=2.4608e-17
C44 (\6\:n0 VSS) capacitor c=5.94816e-17
C45 (\17\:VDD VSS) capacitor c=2.92347e-17
C46 (\14\:CKbb VSS) capacitor c=6.62392e-17
C47 (\14\:CKb VSS) capacitor c=2.95315e-17
C48 (\19\:VDD VSS) capacitor c=3.10888e-17
C49 (\3\:VDD VSS) capacitor c=4.26455e-17
C50 (\4\:ECK VSS) capacitor c=7.09449e-17
C51 (\14\:ECKb VSS) capacitor c=4.65598e-17
C52 (\11\:Eint VSS) capacitor c=6.21369e-17
C53 (\8\:n0 VSS) capacitor c=3.32176e-17
C54 (\11\:CKbb VSS) capacitor c=7.4625e-17
C55 (\12\:CKb VSS) capacitor c=2.43344e-17
C56 (\2\:CK VSS) capacitor c=1.0713e-17
C57 (\2\:CKb VSS) capacitor c=5.81685e-17
C58 (\6\:CKb VSS) capacitor c=4.0278e-17
C59 (\5\:CK VSS) capacitor c=3.61283e-17
C60 (\4\:E VSS) capacitor c=5.50668e-17
C61 (\9\:CKb VSS) capacitor c=7.06275e-17
C62 (\10\:CKb VSS) capacitor c=7.46292e-17
C63 (\11\:CKb VSS) capacitor c=3.35324e-17
C64 (\4\:n0 VSS) capacitor c=4.33553e-17
C65 (\5\:n0 VSS) capacitor c=8.44516e-17
C66 (\8\:CKbb VSS) capacitor c=1.35793e-16
C67 (\9\:CKbb VSS) capacitor c=1.35369e-16
C68 (\10\:CKbb VSS) capacitor c=1.04183e-16
C69 (\13\:CKbb VSS) capacitor c=1.09291e-16
C70 (\7\:Eint VSS) capacitor c=7.25277e-17
C71 (\8\:Eint VSS) capacitor c=5.01835e-17
C72 (\9\:Eint VSS) capacitor c=3.23252e-17
C73 (\10\:Eint VSS) capacitor c=3.53846e-17
C74 (\13\:ECKb VSS) capacitor c=1.052e-16
C75 (\6\:VDD VSS) capacitor c=1.42377e-17
C76 (\7\:VDD VSS) capacitor c=1.93066e-17
C77 (\9\:VDD VSS) capacitor c=2.25717e-17
C78 (\10\:VDD VSS) capacitor c=9.09611e-18
Rk29 (\1\:VDD \6\:VDD) resistor r=0.2201 c=0
Rk30 (\6\:VDD \7\:VDD) resistor r=0.3128 c=0
Rk31 (\7\:VDD \8\:VDD) resistor r=0.2003 c=0
Rk32 (\8\:VDD \9\:VDD) resistor r=0.2028 c=0
Rk34 (\10\:VDD VDD) resistor r=0.02712 c=0
Rk33 (\9\:VDD \10\:VDD) resistor r=0.3203 c=0
Rk36 (\6\:VDD \14\:VDD) resistor r=0.2224 c=0
Rk37 (\7\:VDD \16\:VDD) resistor r=0.2193 c=0
Rk38 (\9\:VDD \18\:VDD) resistor r=0.2193 c=0
Rk39 (\10\:VDD \20\:VDD) resistor r=0.4151 c=0
Rk1 (\5\:CK CK) resistor r=0.1908 c=0
Rk23 (\1\:ECK ECK) resistor r=0.1145 c=0
Rk24 (ECK \4\:ECK) resistor r=0.1733 c=0
Rk42 (\1\:VSS \6\:VSS) resistor r=0.4757 c=0
Rk43 (\6\:VSS \7\:VSS) resistor r=0.2429 c=0
Rk44 (\7\:VSS \8\:VSS) resistor r=0.1602 c=0
Rk46 (\9\:VSS VSS) resistor r=0.04716 c=0
Rk45 (\8\:VSS \9\:VSS) resistor r=0.3429 c=0
Rk48 (\6\:VSS \13\:VSS) resistor r=0.07334 c=0
Rk49 (\8\:VSS \15\:VSS) resistor r=0.2027 c=0
Rk50 (\9\:VSS \17\:VSS) resistor r=0.07334 c=0
Rk2 (E \4\:E) resistor r=0.06898 c=0
Rk3 (\9\:CKb \10\:CKb) resistor r=0.3855 c=0
Rk4 (\10\:CKb \11\:CKb) resistor r=0.1656 c=0
Rk5 (\11\:CKb \13\:CKb) resistor r=0.07119 c=0
Rk6 (\11\:CKb \15\:CKb) resistor r=0.2069 c=0
Rk10 (\8\:CKbb \9\:CKbb) resistor r=0.9169 c=0
Rk11 (\8\:CKbb \10\:CKbb) resistor r=0.3473 c=0
Rk12 (\10\:CKbb \12\:CKbb) resistor r=0.3564 c=0
Rk13 (\10\:CKbb \13\:CKbb) resistor r=0.4472 c=0
Rk14 (\13\:CKbb \15\:CKbb) resistor r=0.4522 c=0
Rk7 (\4\:n0 \5\:n0) resistor r=0.3006 c=0
Rk8 (\5\:n0 \7\:n0) resistor r=0.4933 c=0
Rk9 (\5\:n0 \9\:n0) resistor r=0.1381 c=0
Rk15 (\7\:Eint \8\:Eint) resistor r=0.3799 c=0
Rk16 (\8\:Eint \9\:Eint) resistor r=0.1542 c=0
Rk17 (\9\:Eint \10\:Eint) resistor r=0.199 c=0
Rk18 (\8\:Eint \12\:Eint) resistor r=0.2956 c=0
Rk19 (\9\:Eint \14\:Eint) resistor r=0.1901 c=0
Rk20 (\12\:ECKb \13\:ECKb) resistor r=0.5024 c=0
Rk21 (\13\:ECKb \15\:ECKb) resistor r=0.3256 c=0
Rl1 (\1\:CK \2\:CK) resistor r=49.7141 c=0
Rl3 (\2\:CK \4\:CK) resistor r=34.3295 c=0
Rl2 (\2\:CK \3\:CK) resistor r=1.2666 c=0
Rl8 (\2\:E \3\:E) resistor r=113.678 c=0
Rl7 (\1\:E \2\:E) resistor r=146.411 c=0
Rl6 (\2\:CKb \4\:CKb) resistor r=174.681 c=0
Rl4 (CKb \2\:CKb) resistor r=67.2856 c=0
Rl5 (\2\:CKb \3\:CKb) resistor r=13.851 c=0
Rl10 (\5\:CKb \6\:CKb) resistor r=159.16 c=0
Rl12 (\6\:CKb \8\:CKb) resistor r=76.7534 c=0
Rl11 (\6\:CKb \7\:CKb) resistor r=77.0603 c=0
Rl19 (\6\:CKbb \7\:CKbb) resistor r=72.3097 c=0
Rl18 (\5\:CKbb \6\:CKbb) resistor r=64.9387 c=0
Rl13 (\3\:CKbb \4\:CKbb) resistor r=48.7687 c=0
Rl9 (CKbb \2\:CKbb) resistor r=62.6944 c=0
Rl17 (\2\:n0 \3\:n0) resistor r=178.149 c=0
Rl16 (n0 \2\:n0) resistor r=36.5385 c=0
Rl20 (\4\:Eint \5\:Eint) resistor r=29.5379 c=0
Rl21 (\5\:Eint \6\:Eint) resistor r=79.5379 c=0
Rl15 (\2\:Eint \3\:Eint) resistor r=83.7912 c=0
Rl14 (Eint \2\:Eint) resistor r=130.769 c=0
Rl25 (ECKb \5\:ECKb) resistor r=4.8851 c=0
Rz8 (\1\:VDD \3\:VDD) resistor r=15 c=0
Rz9 (\8\:VDD \3\:VDD) resistor r=6.25 c=0
Rz12 (\13\:VSS \12\:VSS) resistor r=75 c=0
Rz13 (\15\:VSS \14\:VSS) resistor r=75 c=0
Rz14 (\17\:VSS \16\:VSS) resistor r=75 c=0
Rz1 (\12\:CKb \13\:CKb) resistor r=75 c=0
Rz3 (\11\:CKbb \12\:CKbb) resistor r=75 c=0
Rz2 (\8\:n0 \9\:n0) resistor r=75 c=0
Rz4 (\11\:Eint \12\:Eint) resistor r=75 c=0
Rz5 (\15\:ECKb \14\:ECKb) resistor r=75 c=0
Ry10 (\14\:VDD \13\:VDD) resistor r=62 c=0
Ry11 (\16\:VDD \15\:VDD) resistor r=62 c=0
Ry12 (\18\:VDD \17\:VDD) resistor r=62 c=0
Ry13 (\20\:VDD \19\:VDD) resistor r=62 c=0
Ry14 (\1\:VSS \3\:VSS) resistor r=12.4 c=0
Ry15 (\7\:VSS \3\:VSS) resistor r=5.1667 c=0
Ry1 (\14\:CKb \15\:CKb) resistor r=62 c=0
Ry3 (\14\:CKbb \15\:CKbb) resistor r=62 c=0
Ry2 (\6\:n0 \7\:n0) resistor r=62 c=0
Ry4 (\13\:Eint \14\:Eint) resistor r=62 c=0
Ry5 (\12\:ECKb \11\:ECKb) resistor r=31 c=0
Rx1 (\3\:CK \5\:CK) resistor r=45 c=0
Rx2 (\2\:E \4\:E) resistor r=45 c=0
Rx3 (\7\:CKb \9\:CKb) resistor r=45 c=0
Rx4 (\3\:CKb \10\:CKb) resistor r=45 c=0
Rx6 (\4\:CKbb \8\:CKbb) resistor r=45 c=0
Rx7 (\6\:CKbb \9\:CKbb) resistor r=45 c=0
Rx8 (\2\:CKbb \13\:CKbb) resistor r=45 c=0
Rx5 (\2\:n0 \4\:n0) resistor r=45 c=0
Rx9 (\5\:Eint \7\:Eint) resistor r=45 c=0
Rx10 (\2\:Eint \10\:Eint) resistor r=45 c=0
Rx11 (\13\:ECKb \5\:ECKb) resistor r=45 c=0
mn0 (\12\:CKb \4\:CK \16\:VSS VSS) g45n1hvt w=(1.45e-07) l=4.5e-08 nf=1 \
        as=4.465e-14 ad=2.03e-14 ps=1.5e-06 pd=5.7e-07 nrd=1.16667 \
        nrs=1.16667 sa=1e-07 sb=1.4e-07 sd=160n sca=23.279 scb=0.0230742 \
        scc=0.00267719 m=(1)
mn1 (\11\:CKbb CKb \14\:VSS VSS) g45n1hvt w=(1.45e-07) l=4.5e-08 nf=1 \
        as=5.05e-14 ad=2.03e-14 ps=1.04e-06 pd=5.7e-07 nrd=1.16667 \
        nrs=1.16667 sa=1.4e-07 sb=1.295e-06 sd=160n sca=13.253 \
        scb=0.0137915 scc=0.000695334 m=(1)
mn5 (net254 \1\:E \14\:VSS VSS) g45n1hvt w=(1.45e-07) l=4.5e-08 nf=1 \
        as=5.05e-14 ad=2.682e-14 ps=1.04e-06 pd=6.6e-07 nrd=1.16667 \
        nrs=1.16667 sa=4.05e-07 sb=1.03e-06 sd=160n sca=13.253 \
        scb=0.0137915 scc=0.000695334 m=(1)
mn6 (\8\:n0 \8\:CKb net254 VSS) g45n1hvt w=(1.45e-07) l=4.5e-08 nf=1 \
        as=2.682e-14 ad=2.32e-14 ps=6.6e-07 pd=6.1e-07 nrd=1.16667 \
        nrs=1.16667 sa=6.35e-07 sb=8e-07 sd=160n sca=13.253 scb=0.0137915 \
        scc=0.000695334 m=(1)
mn16 (\8\:n0 \3\:CKbb net230 VSS) g45n1hvt w=(1.45e-07) l=4.5e-08 nf=1 \
        as=8.7e-15 ad=2.32e-14 ps=4.1e-07 pd=6.1e-07 nrd=1.16667 \
        nrs=1.16667 sa=8.4e-07 sb=5.95e-07 sd=160n sca=13.253 \
        scb=0.0137915 scc=0.000695334 m=(1)
mn15 (net230 Eint \12\:VSS VSS) g45n1hvt w=(1.45e-07) l=4.5e-08 nf=1 \
        as=7.39e-14 ad=8.7e-15 ps=1.43e-06 pd=4.1e-07 nrd=1.16667 \
        nrs=1.16667 sa=9.45e-07 sb=4.9e-07 sd=160n sca=13.253 \
        scb=0.0137915 scc=0.000695334 m=(1)
mn10 (\11\:Eint n0 \12\:VSS VSS) g45n1hvt w=(1.45e-07) l=4.5e-08 nf=1 \
        as=7.39e-14 ad=3.263e-14 ps=1.43e-06 pd=7.4e-07 nrd=1.16667 \
        nrs=1.16667 sa=1.21e-06 sb=2.25e-07 sd=160n sca=13.253 \
        scb=0.0137915 scc=0.000695334 m=(1)
mn21 (\14\:ECKb \5\:CKbb net238 VSS) g45n1hvt w=(2.6e-07) l=4.5e-08 nf=1 \
        as=1.56e-14 ad=3.64e-14 ps=6.4e-07 pd=8e-07 nrd=1.16667 \
        nrs=1.16667 sa=1.4e-07 sb=8.6e-07 sd=160n sca=17.5885 \
        scb=0.0172826 scc=0.00162584 m=(1)
mn20 (net238 \6\:Eint \1\:VSS VSS) g45n1hvt w=(2.6e-07) l=4.5e-08 nf=1 \
        as=4.16e-14 ad=1.56e-14 ps=8.4e-07 pd=6.4e-07 nrd=1.16667 \
        nrs=1.16667 sa=2.45e-07 sb=7.55e-07 sd=160n sca=17.5885 \
        scb=0.0172826 scc=0.00162584 m=(1)
mn22_1__rcx (\4\:ECK ECKb \1\:VSS VSS) g45n1hvt w=(2.6e-07) l=4.5e-08 \
        nf=1 as=4.16e-14 ad=3.987e-14 ps=8.4e-07 pd=8.2667e-07 nrd=1.16667 \
        nrs=1.16667 sa=4.5e-07 sb=5.5e-07 sd=160n sca=17.5885 \
        scb=0.0172826 scc=0.00162584 m=(3)
mp21 (\11\:ECKb \7\:CKbb \13\:VDD VDD) g45p1hvt w=(3.9e-07) l=4.5e-08 \
        nf=1 as=5.46e-14 ad=6.24e-14 ps=1.06e-06 pd=1.1e-06 nrd=1.16667 \
        nrs=1.16667 sa=1.4e-07 sb=9.6e-07 sd=160n sca=13.8244 \
        scb=0.0124477 scc=0.000698915 m=(1)
mp20 (\11\:ECKb \4\:Eint \1\:VDD VDD) g45p1hvt w=(3.9e-07) l=4.5e-08 \
        nf=1 as=6.24e-14 ad=6.24e-14 ps=1.1e-06 pd=1.1e-06 nrd=1.16667 \
        nrs=1.16667 sa=3.45e-07 sb=7.55e-07 sd=160n sca=14.1097 \
        scb=0.0125247 scc=0.000698928 m=(1)
mp22_1__rcx (\1\:ECK ECKb \1\:VDD VDD) g45p1hvt w=(3.9e-07) l=4.5e-08 \
        nf=1 as=6.24e-14 ad=5.98e-14 ps=1.1e-06 pd=1.08667e-06 nrd=1.16667 \
        nrs=1.16667 sa=5.5e-07 sb=5.5e-07 sd=160n sca=14.9549 \
        scb=0.0130951 scc=0.000699602 m=(3)
ends TLATNCAX3
// End of subcircuit definition.
