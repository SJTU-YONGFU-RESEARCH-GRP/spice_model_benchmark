// Generated for: spectre (May  1 09:15:17 2013 )
// Library name: gsclib045_hvt
// Cell name: EDFFXL
// View name: extracted

simulator lang=spectre

subckt EDFFXL CK D E Q QN VDD VSS
mp20 (\14\:Ckb \3\:CK \20\:VDD VDD) g45p1hvt w=(2.15e-07) l=4.5e-08 nf=1 \
        as=4.408e-14 ad=3.01e-14 ps=8.4e-07 pd=7.1e-07 nrd=1.16667 \
        nrs=1.16667 sa=1.4e-07 sb=3.9e-07 sd=160n sca=18.237 scb=0.0193375 \
        scc=0.000503065 m=(1)
mp21 (\18\:CKbb \7\:Ckb \20\:VDD VDD) g45p1hvt w=(2.15e-07) l=4.5e-08 \
        nf=1 as=4.408e-14 ad=3.01e-14 ps=8.4e-07 pd=7.1e-07 nrd=1.16667 \
        nrs=1.16667 sa=3.9e-07 sb=1.4e-07 sd=160n sca=12.3202 \
        scb=0.00940859 scc=0.000103219 m=(1)
mp25 (\6\:n20 CKbb \3\:Db VDD) g45p1hvt w=(2.15e-07) l=4.5e-08 nf=1 \
        as=3.655e-14 ad=3.44e-14 ps=7.7e-07 pd=7.5e-07 nrd=1.16667 \
        nrs=1.16667 sa=1.7e-07 sb=2e-06 sd=160n sca=15.2551 scb=0.0150251 \
        scc=0.000885438 m=(1)
mp36 (\6\:n20 \5\:Ckb net342 VDD) g45p1hvt w=(2.15e-07) l=4.5e-08 nf=1 \
        as=6.773e-14 ad=3.44e-14 ps=1.06e-06 pd=7.5e-07 nrd=1.16667 \
        nrs=1.16667 sa=3.75e-07 sb=2e-06 sd=160n sca=15.2551 scb=0.0150251 \
        scc=0.000885438 m=(1)
mp35 (net342 mout \16\:VDD VDD) g45p1hvt w=(2.15e-07) l=4.5e-08 nf=1 \
        as=8.39e-14 ad=6.773e-14 ps=1.48e-06 pd=1.06e-06 nrd=1.16667 \
        nrs=1.16667 sa=7.35e-07 sb=2e-06 sd=160n sca=15.2551 scb=0.0150251 \
        scc=0.000885438 m=(1)
mp30 (\8\:mout n20 \16\:VDD VDD) g45p1hvt w=(2.15e-07) l=4.5e-08 nf=1 \
        as=8.39e-14 ad=9.997e-14 ps=1.48e-06 pd=1.36e-06 nrd=1.16667 \
        nrs=1.16667 sa=1e-06 sb=2e-06 sd=160n sca=15.2551 scb=0.0150251 \
        scc=0.000885438 m=(1)
mp40 (\7\:n30 \10\:Ckb \8\:mout VDD) g45p1hvt w=(2.15e-07) l=4.5e-08 nf=1 \
        as=9.997e-14 ad=4.837e-14 ps=1.36e-06 pd=8.8e-07 nrd=1.16667 \
        nrs=1.16667 sa=1.51e-06 sb=1.98e-06 sd=160n sca=15.2551 \
        scb=0.0150251 scc=0.000885438 m=(1)
mp51 (\7\:n30 \7\:CKbb net362 VDD) g45p1hvt w=(2.15e-07) l=4.5e-08 nf=1 \
        as=1.72e-14 ad=4.837e-14 ps=5.9e-07 pd=8.8e-07 nrd=1.16667 \
        nrs=1.16667 sa=1.78e-06 sb=1.71e-06 sd=160n sca=15.2551 \
        scb=0.0150251 scc=0.000885438 m=(1)
mp50 (net362 \4\:qbint \13\:VDD VDD) g45p1hvt w=(2.15e-07) l=4.5e-08 \
        nf=1 as=9.35e-14 ad=1.72e-14 ps=1.64e-06 pd=5.9e-07 nrd=1.16667 \
        nrs=1.16667 sa=1.905e-06 sb=1.585e-06 sd=160n sca=15.2551 \
        scb=0.0150251 scc=0.000885438 m=(1)
mp45 (\17\:qbint n30 \13\:VDD VDD) g45p1hvt w=(2.15e-07) l=4.5e-08 nf=1 \
        as=9.35e-14 ad=3.87e-14 ps=1.64e-06 pd=7.9e-07 nrd=1.16667 \
        nrs=1.16667 sa=2e-06 sb=1.32e-06 sd=160n sca=15.2551 scb=0.0150251 \
        scc=0.000885438 m=(1)
mp1 (\17\:qbint \1\:E Db VDD) g45p1hvt w=(2.15e-07) l=4.5e-08 nf=1 \
        as=3.44e-14 ad=3.87e-14 ps=7.5e-07 pd=7.9e-07 nrd=1.16667 \
        nrs=1.16667 sa=2e-06 sb=1.095e-06 sd=160n sca=15.2551 \
        scb=0.0150251 scc=0.000885438 m=(1)
mp3 (Db Eb n1 VDD) g45p1hvt w=(2.15e-07) l=4.5e-08 nf=1 as=7.418e-14 \
        ad=3.44e-14 ps=1.12e-06 pd=7.5e-07 nrd=1.16667 nrs=1.16667 \
        sa=2e-06 sb=8.9e-07 sd=160n sca=15.2551 scb=0.0150251 \
        scc=0.000885438 m=(1)
mp2 (n1 \1\:D \9\:VDD VDD) g45p1hvt w=(2.15e-07) l=4.5e-08 nf=1 \
        as=9.093e-14 ad=7.418e-14 ps=1.51e-06 pd=1.12e-06 nrd=1.16667 \
        nrs=1.16667 sa=2e-06 sb=5e-07 sd=160n sca=15.2551 scb=0.0150251 \
        scc=0.000885438 m=(1)
mp0 (\5\:Eb \5\:E \9\:VDD VDD) g45p1hvt w=(2.15e-07) l=4.5e-08 nf=1 \
        as=9.093e-14 ad=3.87e-14 ps=1.51e-06 pd=7.9e-07 nrd=1.16667 \
        nrs=1.16667 sa=2e-06 sb=1.8e-07 sd=160n sca=15.2551 scb=0.0150251 \
        scc=0.000885438 m=(1)
mp55 (\3\:Q \11\:qbint \6\:VDD VDD) g45p1hvt w=(2.15e-07) l=4.5e-08 nf=1 \
        as=4.73e-14 ad=3.01e-14 ps=8.7e-07 pd=7.1e-07 nrd=1.16667 \
        nrs=1.16667 sa=1.4e-07 sb=4.05e-07 sd=160n sca=45.7906 \
        scb=0.0283307 scc=0.00588417 m=(1)
mp56 (\7\:qint \5\:qbint \6\:VDD VDD) g45p1hvt w=(2.15e-07) l=4.5e-08 \
        nf=1 as=4.73e-14 ad=3.01e-14 ps=8.7e-07 pd=7.1e-07 nrd=1.16667 \
        nrs=1.16667 sa=4.05e-07 sb=1.4e-07 sd=160n sca=46.3496 \
        scb=0.0285354 scc=0.00588424 m=(1)
mp57 (\3\:QN qint \1\:VDD VDD) g45p1hvt w=(2.15e-07) l=4.5e-08 nf=1 \
        as=3.01e-14 ad=3.87e-14 ps=7.1e-07 pd=7.9e-07 nrd=1.16667 \
        nrs=1.16667 sa=1.4e-07 sb=1.8e-07 sd=160n sca=24.9702 \
        scb=0.0291896 scc=0.0015765 m=(1)
C1 (D VSS) capacitor c=7.22126e-17
C2 (QN VSS) capacitor c=2.8031e-17
C3 (VDD VSS) capacitor c=3.72761e-16
C4 (CK VSS) capacitor c=7.76437e-17
C5 (E VSS) capacitor c=1.16744e-16
C6 (Q VSS) capacitor c=1.93522e-17
C7 (Ckb VSS) capacitor c=2.40914e-17
C8 (CKbb VSS) capacitor c=4.13607e-17
C9 (n20 VSS) capacitor c=4.18788e-17
C10 (Db VSS) capacitor c=3.08111e-16
C11 (mout VSS) capacitor c=3.37393e-17
C12 (n30 VSS) capacitor c=5.08158e-17
C13 (qbint VSS) capacitor c=1.83435e-17
C14 (Eb VSS) capacitor c=3.06006e-17
C15 (n0 VSS) capacitor c=3.1646e-18
C16 (qint VSS) capacitor c=3.6384e-17
C17 (net342 VSS) capacitor c=6.18079e-18
C18 (net362 VSS) capacitor c=4.46496e-19
C19 (n1 VSS) capacitor c=6.74446e-18
C20 (\5\:qbint VSS) capacitor c=1.97151e-17
C21 (\11\:qbint VSS) capacitor c=2.10634e-17
C22 (\5\:E VSS) capacitor c=3.16289e-17
C23 (\1\:D VSS) capacitor c=3.42528e-17
C24 (\1\:E VSS) capacitor c=5.31613e-17
C25 (\4\:qbint VSS) capacitor c=4.90087e-17
C26 (\7\:CKbb VSS) capacitor c=5.99733e-17
C27 (\10\:Ckb VSS) capacitor c=7.13975e-17
C28 (\5\:Ckb VSS) capacitor c=5.53996e-17
C29 (\7\:Ckb VSS) capacitor c=4.82579e-17
C30 (\3\:CK VSS) capacitor c=4.33429e-17
C31 (\3\:qint VSS) capacitor c=2.54774e-17
C32 (\10\:qbint VSS) capacitor c=1.59388e-17
C33 (\8\:qbint VSS) capacitor c=1.15982e-17
C34 (\7\:E VSS) capacitor c=3.82561e-17
C35 (\3\:D VSS) capacitor c=3.0842e-17
C36 (\3\:E VSS) capacitor c=3.5992e-17
C37 (\3\:Eb VSS) capacitor c=5.27909e-17
C38 (\3\:n30 VSS) capacitor c=2.55653e-17
C39 (\3\:qbint VSS) capacitor c=5.89752e-17
C40 (\9\:Ckb VSS) capacitor c=8.54543e-17
C41 (\5\:CKbb VSS) capacitor c=2.67259e-17
C42 (\3\:n20 VSS) capacitor c=3.14227e-17
C43 (\3\:mout VSS) capacitor c=4.63254e-17
C44 (\3\:CKbb VSS) capacitor c=4.23821e-17
C45 (\8\:Ckb VSS) capacitor c=2.65791e-17
C46 (\1\:CK VSS) capacitor c=3.8352e-17
C47 (\2\:qint VSS) capacitor c=2.00367e-17
C48 (\9\:qbint VSS) capacitor c=1.51158e-17
C49 (\6\:E VSS) capacitor c=2.37713e-17
C50 (\2\:D VSS) capacitor c=3.34921e-17
C51 (\4\:Eb VSS) capacitor c=3.1323e-17
C52 (\4\:E VSS) capacitor c=4.02477e-17
C53 (\2\:E VSS) capacitor c=2.52198e-17
C54 (\2\:n30 VSS) capacitor c=3.82516e-17
C55 (\8\:CKbb VSS) capacitor c=4.1863e-17
C56 (\6\:CKbb VSS) capacitor c=3.21027e-17
C57 (\11\:Ckb VSS) capacitor c=2.93549e-17
C58 (\2\:n20 VSS) capacitor c=3.17532e-17
C59 (\2\:mout VSS) capacitor c=3.69345e-17
C60 (\4\:CKbb VSS) capacitor c=2.02466e-17
C61 (\6\:Ckb VSS) capacitor c=2.46961e-17
C62 (\2\:CKbb VSS) capacitor c=4.05936e-17
C63 (\4\:Ckb VSS) capacitor c=5.48285e-17
C64 (\2\:CK VSS) capacitor c=5.31766e-17
C65 (\3\:QN VSS) capacitor c=2.07962e-17
C66 (\1\:VDD VSS) capacitor c=1.83727e-17
C67 (\7\:qint VSS) capacitor c=2.56596e-17
C68 (\6\:VDD VSS) capacitor c=3.75863e-17
C69 (\3\:Q VSS) capacitor c=4.37745e-17
C70 (\5\:Eb VSS) capacitor c=6.13636e-17
C71 (\9\:VDD VSS) capacitor c=3.36017e-17
C72 (\17\:qbint VSS) capacitor c=3.68187e-17
C73 (\13\:VDD VSS) capacitor c=1.05449e-17
C74 (\7\:n30 VSS) capacitor c=7.03388e-17
C75 (\8\:mout VSS) capacitor c=5.74285e-17
C76 (\16\:VDD VSS) capacitor c=3.05945e-17
C77 (\6\:n20 VSS) capacitor c=4.94772e-17
C78 (\3\:Db VSS) capacitor c=3.06954e-16
C79 (\18\:CKbb VSS) capacitor c=7.90889e-17
C80 (\20\:VDD VSS) capacitor c=2.70794e-17
C81 (\14\:Ckb VSS) capacitor c=7.675e-17
C82 (\3\:VDD VSS) capacitor c=8.36559e-17
C83 (\1\:QN VSS) capacitor c=3.62351e-17
C84 (\5\:qint VSS) capacitor c=3.64661e-17
C85 (\1\:Q VSS) capacitor c=3.45737e-17
C86 (\7\:Eb VSS) capacitor c=1.22019e-16
C87 (\7\:Db VSS) capacitor c=6.86621e-17
C88 (\13\:qbint VSS) capacitor c=1.43538e-16
C89 (\4\:n30 VSS) capacitor c=3.58361e-17
C90 (\6\:mout VSS) capacitor c=5.07504e-17
C91 (\8\:n20 VSS) capacitor c=3.74035e-17
C92 (\5\:Db VSS) capacitor c=7.20559e-17
C93 (\13\:CKbb VSS) capacitor c=9.92866e-17
C94 (\16\:Ckb VSS) capacitor c=1.93206e-17
C95 (\2\:Ckb VSS) capacitor c=4.76401e-17
C96 (\2\:qbint VSS) capacitor c=2.99197e-17
C97 (\2\:Eb VSS) capacitor c=5.61918e-17
C98 (\6\:qbint VSS) capacitor c=1.01211e-17
C99 (\7\:qbint VSS) capacitor c=9.55633e-18
C100 (\4\:CK VSS) capacitor c=3.157e-17
C101 (\12\:Ckb VSS) capacitor c=4.78313e-17
C102 (\13\:Ckb VSS) capacitor c=7.63492e-17
C103 (\4\:n20 VSS) capacitor c=6.95872e-17
C104 (\5\:n20 VSS) capacitor c=6.44023e-17
C105 (\18\:Ckb VSS) capacitor c=1.15647e-16
C106 (\19\:Ckb VSS) capacitor c=1.17625e-16
C107 (\4\:mout VSS) capacitor c=6.19239e-17
C108 (\5\:mout VSS) capacitor c=6.26701e-17
C109 (\9\:CKbb VSS) capacitor c=3.27242e-17
C110 (\10\:CKbb VSS) capacitor c=1.15351e-16
C111 (\11\:CKbb VSS) capacitor c=1.09355e-16
C112 (\12\:CKbb VSS) capacitor c=6.15245e-17
C113 (\15\:CKbb VSS) capacitor c=3.52555e-17
C114 (\16\:CKbb VSS) capacitor c=1.91704e-17
C115 (\17\:CKbb VSS) capacitor c=8.00769e-17
C116 (\6\:n30 VSS) capacitor c=6.50546e-17
C117 (\9\:n30 VSS) capacitor c=5.84014e-17
C118 (\5\:D VSS) capacitor c=6.97749e-17
C119 (\8\:E VSS) capacitor c=8.42355e-17
C120 (\9\:E VSS) capacitor c=1.29608e-16
C121 (\10\:E VSS) capacitor c=5.01329e-17
C122 (\9\:Eb VSS) capacitor c=1.19241e-16
C123 (\12\:qbint VSS) capacitor c=1.39949e-16
C124 (\15\:qbint VSS) capacitor c=4.96668e-17
C125 (\16\:qbint VSS) capacitor c=5.29455e-17
C126 (\4\:qint VSS) capacitor c=4.12788e-17
C127 (\5\:VDD VSS) capacitor c=1.08383e-17
C128 (\8\:VDD VSS) capacitor c=1.5866e-17
C129 (\12\:VDD VSS) capacitor c=4.60375e-17
C130 (\15\:VDD VSS) capacitor c=4.28387e-17
C131 (\19\:VDD VSS) capacitor c=2.23245e-17
Rk28 (\4\:D \5\:D) resistor r=0.01193 c=0
Rk29 (\6\:D D) resistor r=0.01193 c=0
Rk30 (\5\:D \6\:D) resistor r=0.01198 c=0
Rk45 (\2\:QN QN) resistor r=0.2459 c=0
Rk46 (QN \4\:QN) resistor r=0.1533 c=0
Rk47 (\2\:VDD \4\:VDD) resistor r=0.3837 c=0
Rk48 (\4\:VDD \5\:VDD) resistor r=0.243 c=0
Rk49 (\5\:VDD \7\:VDD) resistor r=0.4169 c=0
Rk50 (\5\:VDD \8\:VDD) resistor r=0.4082 c=0
Rk51 (\8\:VDD \10\:VDD) resistor r=0.149 c=0
Rk52 (\8\:VDD \11\:VDD) resistor r=0.1502 c=0
Rk53 (\11\:VDD \12\:VDD) resistor r=0.3784 c=0
Rk54 (\12\:VDD \14\:VDD) resistor r=0.07369 c=0
Rk55 (\12\:VDD \15\:VDD) resistor r=0.5712 c=0
Rk56 (\15\:VDD \17\:VDD) resistor r=0.1224 c=0
Rk57 (\15\:VDD \18\:VDD) resistor r=0.253 c=0
Rk60 (\19\:VDD VDD) resistor r=0.1625 c=0
Rk58 (\18\:VDD \19\:VDD) resistor r=0.3884 c=0
Rk59 (\19\:VDD \21\:VDD) resistor r=0.1736 c=0
Rk3 (\4\:CK CK) resistor r=0.01799 c=0
Rk33 (\9\:E E) resistor r=0.7475 c=0
Rk31 (\8\:E \9\:E) resistor r=0.4181 c=0
Rk32 (\9\:E \10\:E) resistor r=0.2745 c=0
Rk34 (E \11\:E) resistor r=0.002705 c=0
Rk37 (\2\:Q Q) resistor r=0.03458 c=0
Rk38 (Q \4\:Q) resistor r=0.1761 c=0
Rk61 (\2\:VSS \4\:VSS) resistor r=0.3316 c=0
Rk62 (\4\:VSS \5\:VSS) resistor r=0.2279 c=0
Rk63 (\5\:VSS \6\:VSS) resistor r=0.4233 c=0
Rk64 (\6\:VSS \7\:VSS) resistor r=0.1502 c=0
Rk65 (\7\:VSS \8\:VSS) resistor r=0.4084 c=0
Rk66 (\8\:VSS \9\:VSS) resistor r=0.5712 c=0
Rk67 (\9\:VSS \10\:VSS) resistor r=0.2229 c=0
Rk69 (\11\:VSS VSS) resistor r=0.1475 c=0
Rk68 (\10\:VSS \11\:VSS) resistor r=0.4034 c=0
Rk70 (\5\:VSS \13\:VSS) resistor r=0.07369 c=0
Rk71 (\6\:VSS \15\:VSS) resistor r=0.139 c=0
Rk72 (\8\:VSS \17\:VSS) resistor r=0.3556 c=0
Rk73 (\9\:VSS \19\:VSS) resistor r=0.1457 c=0
Rk74 (\11\:VSS \21\:VSS) resistor r=0.2823 c=0
Rk4 (\12\:Ckb \13\:Ckb) resistor r=0.264 c=0
Rk5 (\13\:Ckb \15\:Ckb) resistor r=0.6247 c=0
Rk6 (\13\:Ckb \17\:Ckb) resistor r=0.097 c=0
Rk10 (\18\:Ckb \19\:Ckb) resistor r=0.7787 c=0
Rk14 (\9\:CKbb \10\:CKbb) resistor r=0.06544 c=0
Rk15 (\10\:CKbb \11\:CKbb) resistor r=1.0271 c=0
Rk16 (\11\:CKbb \12\:CKbb) resistor r=0.206 c=0
Rk17 (\12\:CKbb \14\:CKbb) resistor r=0.2701 c=0
Rk18 (\10\:CKbb \15\:CKbb) resistor r=0.1694 c=0
Rk19 (\11\:CKbb \16\:CKbb) resistor r=0.03536 c=0
Rk20 (\12\:CKbb \17\:CKbb) resistor r=0.3682 c=0
Rk21 (\14\:CKbb \19\:CKbb) resistor r=0.6437 c=0
Rk7 (\4\:n20 \5\:n20) resistor r=0.418 c=0
Rk8 (\5\:n20 \7\:n20) resistor r=0.2991 c=0
Rk9 (\5\:n20 \9\:n20) resistor r=0.1276 c=0
Rk25 (\2\:Db \4\:Db) resistor r=2.2342 c=0
Rk26 (\4\:Db \6\:Db) resistor r=0.4026 c=0
Rk27 (\2\:Db \8\:Db) resistor r=0.4021 c=0
Rk11 (\4\:mout \5\:mout) resistor r=0.2686 c=0
Rk12 (\5\:mout \7\:mout) resistor r=0.2496 c=0
Rk13 (\5\:mout \9\:mout) resistor r=0.1967 c=0
Rk22 (\5\:n30 \6\:n30) resistor r=0.1777 c=0
Rk23 (\6\:n30 \8\:n30) resistor r=0.3393 c=0
Rk24 (\6\:n30 \9\:n30) resistor r=0.2477 c=0
Rk39 (\12\:qbint \14\:qbint) resistor r=1.1577 c=0
Rk40 (\14\:qbint \15\:qbint) resistor r=0.2845 c=0
Rk41 (\15\:qbint \16\:qbint) resistor r=0.1978 c=0
Rk42 (\15\:qbint \18\:qbint) resistor r=0.09309 c=0
Rk35 (\6\:Eb \8\:Eb) resistor r=0.4001 c=0
Rk36 (\8\:Eb \9\:Eb) resistor r=0.7067 c=0
Rk43 (\4\:qint \6\:qint) resistor r=0.2017 c=0
Rk44 (\6\:qint \8\:qint) resistor r=0.2148 c=0
Rl30 (\1\:D \2\:D) resistor r=81.461 c=0
Rl31 (\2\:D \3\:D) resistor r=37.2302 c=0
Rl2 (\2\:CK \3\:CK) resistor r=155.002 c=0
Rl1 (\1\:CK \2\:CK) resistor r=99.2328 c=0
Rl32 (\5\:E \6\:E) resistor r=56.461 c=0
Rl33 (\6\:E \7\:E) resistor r=62.2302 c=0
Rl26 (\3\:E \4\:E) resistor r=29.5379 c=0
Rl25 (\1\:E \2\:E) resistor r=60.3072 c=0
Rl18 (\9\:Ckb \10\:Ckb) resistor r=238.027 c=0
Rl19 (\10\:Ckb \11\:Ckb) resistor r=101.436 c=0
Rl8 (\5\:Ckb \6\:Ckb) resistor r=50.6918 c=0
Rl10 (\4\:Ckb \8\:Ckb) resistor r=57.1486 c=0
Rl7 (\2\:Ckb \5\:Ckb) resistor r=168.774 c=0
Rl4 (Ckb \2\:Ckb) resistor r=30.4507 c=0
Rl9 (\3\:Ckb \7\:Ckb) resistor r=193.39 c=0
Rl6 (\3\:Ckb \4\:Ckb) resistor r=14.7598 c=0
Rl5 (\2\:Ckb \3\:Ckb) resistor r=155.844 c=0
Rl17 (\7\:CKbb \8\:CKbb) resistor r=47.0254 c=0
Rl16 (\5\:CKbb \6\:CKbb) resistor r=29.5379 c=0
Rl11 (\3\:CKbb \4\:CKbb) resistor r=64.6174 c=0
Rl3 (CKbb \2\:CKbb) resistor r=39.1533 c=0
Rl14 (n20 \2\:n20) resistor r=89.1533 c=0
Rl15 (\2\:n20 \3\:n20) resistor r=29.5379 c=0
Rl12 (mout \2\:mout) resistor r=24.2328 c=0
Rl13 (\2\:mout \3\:mout) resistor r=91.5405 c=0
Rl23 (n30 \2\:n30) resistor r=85.7134 c=0
Rl24 (\2\:n30 \3\:n30) resistor r=26.098 c=0
Rl37 (\8\:qbint \9\:qbint) resistor r=29.5379 c=0
Rl22 (\2\:qbint \4\:qbint) resistor r=36.2526 c=0
Rl21 (\2\:qbint \3\:qbint) resistor r=99.7141 c=0
Rl20 (qbint \2\:qbint) resistor r=1.2713 c=0
Rl34 (\5\:qbint \6\:qbint) resistor r=44.4949 c=0
Rl38 (\6\:qbint \10\:qbint) resistor r=47.7584 c=0
Rl39 (\7\:qbint \11\:qbint) resistor r=35.772 c=0
Rl36 (\7\:qbint \8\:qbint) resistor r=53.0797 c=0
Rl35 (\6\:qbint \7\:qbint) resistor r=77.7612 c=0
Rl27 (Eb \2\:Eb) resistor r=23.5324 c=0
Rl28 (\2\:Eb \3\:Eb) resistor r=149.587 c=0
Rl29 (\2\:Eb \4\:Eb) resistor r=33.1028 c=0
Rl40 (qint \2\:qint) resistor r=133.848 c=0
Rl41 (\2\:qint \3\:qint) resistor r=26.1559 c=0
Rz12 (\1\:QN \2\:QN) resistor r=75 c=0
Rz13 (\3\:VDD \4\:VDD) resistor r=18.75 c=0
Rz14 (\3\:VDD \11\:VDD) resistor r=6.25 c=0
Rz15 (\3\:VDD \18\:VDD) resistor r=6.25 c=0
Rz9 (\1\:Q \2\:Q) resistor r=75 c=0
Rz16 (\1\:VSS \2\:VSS) resistor r=75 c=0
Rz17 (\12\:VSS \13\:VSS) resistor r=75 c=0
Rz18 (\14\:VSS \15\:VSS) resistor r=75 c=0
Rz19 (\16\:VSS \17\:VSS) resistor r=75 c=0
Rz20 (\18\:VSS \19\:VSS) resistor r=75 c=0
Rz21 (\20\:VSS \21\:VSS) resistor r=75 c=0
Rz1 (\16\:Ckb \17\:Ckb) resistor r=75 c=0
Rz4 (\13\:CKbb \14\:CKbb) resistor r=75 c=0
Rz2 (\8\:n20 \9\:n20) resistor r=75 c=0
Rz6 (\5\:Db \6\:Db) resistor r=75 c=0
Rz7 (\7\:Db \8\:Db) resistor r=75 c=0
Rz3 (\6\:mout \7\:mout) resistor r=75 c=0
Rz5 (\4\:n30 \5\:n30) resistor r=75 c=0
Rz10 (\13\:qbint \14\:qbint) resistor r=75 c=0
Rz8 (\7\:Eb \8\:Eb) resistor r=75 c=0
Rz11 (\5\:qint \6\:qint) resistor r=75 c=0
Ry12 (\3\:QN \4\:QN) resistor r=62 c=0
Ry13 (\1\:VDD \2\:VDD) resistor r=62 c=0
Ry14 (\6\:VDD \7\:VDD) resistor r=62 c=0
Ry15 (\9\:VDD \10\:VDD) resistor r=62 c=0
Ry16 (\13\:VDD \14\:VDD) resistor r=62 c=0
Ry17 (\16\:VDD \17\:VDD) resistor r=62 c=0
Ry18 (\20\:VDD \21\:VDD) resistor r=62 c=0
Ry9 (\3\:Q \4\:Q) resistor r=62 c=0
Ry19 (\3\:VSS \4\:VSS) resistor r=15.5 c=0
Ry20 (\3\:VSS \7\:VSS) resistor r=5.1667 c=0
Ry21 (\3\:VSS \10\:VSS) resistor r=5.1667 c=0
Ry1 (\14\:Ckb \15\:Ckb) resistor r=62 c=0
Ry4 (\18\:CKbb \19\:CKbb) resistor r=62 c=0
Ry2 (\6\:n20 \7\:n20) resistor r=62 c=0
Ry6 (Db \2\:Db) resistor r=62 c=0
Ry7 (\3\:Db \4\:Db) resistor r=62 c=0
Ry3 (\8\:mout \9\:mout) resistor r=62 c=0
Ry5 (\7\:n30 \8\:n30) resistor r=62 c=0
Ry10 (\17\:qbint \18\:qbint) resistor r=62 c=0
Ry8 (\5\:Eb \6\:Eb) resistor r=62 c=0
Ry11 (\7\:qint \8\:qint) resistor r=62 c=0
Rx12 (\2\:D \4\:D) resistor r=45 c=0
Rx1 (\2\:CK \4\:CK) resistor r=45 c=0
Rx13 (\4\:E \8\:E) resistor r=45 c=0
Rx14 (\2\:E \10\:E) resistor r=45 c=0
Rx15 (\6\:E \11\:E) resistor r=45 c=0
Rx2 (\4\:Ckb \12\:Ckb) resistor r=45 c=0
Rx4 (\11\:Ckb \18\:Ckb) resistor r=45 c=0
Rx5 (\6\:Ckb \19\:Ckb) resistor r=45 c=0
Rx7 (\6\:CKbb \9\:CKbb) resistor r=45 c=0
Rx8 (\8\:CKbb \15\:CKbb) resistor r=45 c=0
Rx9 (\4\:CKbb \16\:CKbb) resistor r=45 c=0
Rx10 (\2\:CKbb \17\:CKbb) resistor r=45 c=0
Rx3 (\2\:n20 \4\:n20) resistor r=45 c=0
Rx6 (\2\:mout \4\:mout) resistor r=45 c=0
Rx11 (\2\:n30 \9\:n30) resistor r=45 c=0
Rx17 (\9\:qbint \12\:qbint) resistor r=45 c=0
Rx18 (qbint \16\:qbint) resistor r=45 c=0
Rx16 (\4\:Eb \9\:Eb) resistor r=45 c=0
Rx19 (\2\:qint \4\:qint) resistor r=45 c=0
mn20 (\16\:Ckb \1\:CK \20\:VSS VSS) g45n1hvt w=(1.45e-07) l=4.5e-08 nf=1 \
        as=2.32e-14 ad=2.03e-14 ps=6.1e-07 pd=5.7e-07 nrd=1.16667 \
        nrs=1.16667 sa=1.4e-07 sb=3.75e-07 sd=160n sca=10.7143 \
        scb=0.0101371 scc=0.000327098 m=(1)
mn21 (\13\:CKbb \8\:Ckb \20\:VSS VSS) g45n1hvt w=(1.45e-07) l=4.5e-08 \
        nf=1 as=2.32e-14 ad=2.465e-14 ps=6.1e-07 pd=6.3e-07 nrd=1.16667 \
        nrs=1.16667 sa=3.45e-07 sb=1.7e-07 sd=160n sca=10.7143 \
        scb=0.0101371 scc=0.000327098 m=(1)
mn25 (\5\:Db Ckb \8\:n20 VSS) g45n1hvt w=(1.45e-07) l=4.5e-08 nf=1 \
        as=4.422e-14 ad=2.03e-14 ps=9e-07 pd=5.7e-07 nrd=1.16667 \
        nrs=1.16667 sa=1.4e-07 sb=2e-06 sd=160n sca=22.3376 scb=0.0224607 \
        scc=0.00248252 m=(1)
mn36 (\8\:n20 \3\:CKbb net411 VSS) g45n1hvt w=(1.45e-07) l=4.5e-08 nf=1 \
        as=2.9e-14 ad=4.422e-14 ps=6.9e-07 pd=9e-07 nrd=1.16667 \
        nrs=1.16667 sa=4.9e-07 sb=2e-06 sd=160n sca=22.3376 scb=0.0224607 \
        scc=0.00248252 m=(1)
mn35 (net411 \3\:mout \18\:VSS VSS) g45n1hvt w=(1.45e-07) l=4.5e-08 nf=1 \
        as=6.97e-14 ad=2.9e-14 ps=1.36e-06 pd=6.9e-07 nrd=1.16667 \
        nrs=1.16667 sa=7.35e-07 sb=2e-06 sd=160n sca=22.3376 scb=0.0224607 \
        scc=0.00248252 m=(1)
mn30 (\6\:mout \3\:n20 \18\:VSS VSS) g45n1hvt w=(1.45e-07) l=4.5e-08 \
        nf=1 as=6.97e-14 ad=5.22e-14 ps=1.36e-06 pd=1.01e-06 nrd=1.16667 \
        nrs=1.16667 sa=1e-06 sb=2e-06 sd=160n sca=22.3376 scb=0.0224607 \
        scc=0.00248252 m=(1)
mn40 (\6\:mout \5\:CKbb \4\:n30 VSS) g45n1hvt w=(1.45e-07) l=4.5e-08 nf=1 \
        as=5.075e-14 ad=5.22e-14 ps=9.9e-07 pd=1.01e-06 nrd=1.16667 \
        nrs=1.16667 sa=1.405e-06 sb=2e-06 sd=160n sca=22.3376 \
        scb=0.0224607 scc=0.00248252 m=(1)
mn51 (\4\:n30 \9\:Ckb net415 VSS) g45n1hvt w=(1.45e-07) l=4.5e-08 nf=1 \
        as=8.7e-15 ad=5.075e-14 ps=4.1e-07 pd=9.9e-07 nrd=1.16667 \
        nrs=1.16667 sa=1.8e-06 sb=1.71e-06 sd=160n sca=22.3376 \
        scb=0.0224607 scc=0.00248252 m=(1)
mn50 (net415 \3\:qbint \16\:VSS VSS) g45n1hvt w=(1.45e-07) l=4.5e-08 \
        nf=1 as=3.19e-14 ad=8.7e-15 ps=7.3e-07 pd=4.1e-07 nrd=1.16667 \
        nrs=1.16667 sa=1.905e-06 sb=1.605e-06 sd=160n sca=22.3376 \
        scb=0.0224607 scc=0.00248252 m=(1)
mn45 (\13\:qbint \3\:n30 \16\:VSS VSS) g45n1hvt w=(1.45e-07) l=4.5e-08 \
        nf=1 as=3.19e-14 ad=2.61e-14 ps=7.3e-07 pd=6.5e-07 nrd=1.16667 \
        nrs=1.16667 sa=2e-06 sb=1.34e-06 sd=160n sca=22.3376 scb=0.0224607 \
        scc=0.00248252 m=(1)
mn1 (\13\:qbint \3\:Eb \7\:Db VSS) g45n1hvt w=(1.45e-07) l=4.5e-08 nf=1 \
        as=3.553e-14 ad=2.61e-14 ps=7.8e-07 pd=6.5e-07 nrd=1.16667 \
        nrs=1.16667 sa=2e-06 sb=1.115e-06 sd=160n sca=22.3376 \
        scb=0.0224607 scc=0.00248252 m=(1)
mn3 (\7\:Db \3\:E n0 VSS) g45n1hvt w=(1.45e-07) l=4.5e-08 nf=1 \
        as=3.77e-14 ad=3.553e-14 ps=8.1e-07 pd=7.8e-07 nrd=1.16667 \
        nrs=1.16667 sa=2e-06 sb=8.25e-07 sd=160n sca=22.3376 scb=0.0224607 \
        scc=0.00248252 m=(1)
mn2 (n0 \3\:D \14\:VSS VSS) g45n1hvt w=(1.45e-07) l=4.5e-08 nf=1 \
        as=7.888e-14 ad=3.77e-14 ps=1.49e-06 pd=8.1e-07 nrd=1.16667 \
        nrs=1.16667 sa=2e-06 sb=5.2e-07 sd=160n sca=22.3376 scb=0.0224607 \
        scc=0.00248252 m=(1)
mn0 (\7\:Eb \7\:E \14\:VSS VSS) g45n1hvt w=(1.45e-07) l=4.5e-08 nf=1 \
        as=7.888e-14 ad=2.9e-14 ps=1.49e-06 pd=6.9e-07 nrd=1.16667 \
        nrs=1.16667 sa=2e-06 sb=2e-07 sd=160n sca=22.3376 scb=0.0224607 \
        scc=0.00248252 m=(1)
mn55 (\1\:Q \8\:qbint \12\:VSS VSS) g45n1hvt w=(1.45e-07) l=4.5e-08 nf=1 \
        as=5.625e-14 ad=2.03e-14 ps=1.66e-06 pd=5.7e-07 nrd=1.16667 \
        nrs=1.16667 sa=1.4e-07 sb=3.65e-07 sd=160n sca=23.279 \
        scb=0.0230742 scc=0.00267719 m=(1)
mn56 (\5\:qint \10\:qbint \12\:VSS VSS) g45n1hvt w=(1.45e-07) l=4.5e-08 \
        nf=1 as=5.625e-14 ad=2.03e-14 ps=1.66e-06 pd=5.7e-07 nrd=1.16667 \
        nrs=1.16667 sa=3.65e-07 sb=1.4e-07 sd=160n sca=23.279 \
        scb=0.0230742 scc=0.00267719 m=(1)
mn57 (\1\:QN \3\:qint \1\:VSS VSS) g45n1hvt w=(1.45e-07) l=4.5e-08 nf=1 \
        as=2.248e-14 ad=2.755e-14 ps=6e-07 pd=6.7e-07 nrd=1.16667 \
        nrs=1.16667 sa=1.55e-07 sb=1.9e-07 sd=160n sca=10.9472 \
        scb=0.0104991 scc=0.000356047 m=(1)
ends EDFFXL
// End of subcircuit definition.
