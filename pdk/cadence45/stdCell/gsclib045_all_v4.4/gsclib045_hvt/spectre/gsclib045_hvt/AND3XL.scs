// gsclib045_hvt/AND3XL/schematic

simulator lang=spectre

subckt AND3XL A B C Y VDD VSS
mp1 (net87 B VDD VDD) g45p1hvt w=(215n) l=45n nf=1 m=(1)
mp2 (net87 C VDD VDD) g45p1hvt w=(215n) l=45n nf=1 m=(1)
mp0 (net87 A VDD VDD) g45p1hvt w=(215n) l=45n nf=1 m=(1)
mp3 (Y net87 VDD VDD) g45p1hvt w=(215n) l=45n nf=1 m=(1)
mn3 (Y net87 VSS VSS) g45n1hvt w=(145n) l=45n nf=1 m=(1)
mn1 (net107 B net103 VSS) g45n1hvt w=(145n) l=45n nf=1 m=(1)
mn0 (net103 A VSS VSS) g45n1hvt w=(145n) l=45n nf=1 m=(1)
mn2 (net87 C net107 VSS) g45n1hvt w=(145n) l=45n nf=1 m=(1)
ends AND3XL
