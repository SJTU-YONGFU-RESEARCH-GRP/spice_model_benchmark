// gsclib045_hvt/BMXIX4/schematic

simulator lang=spectre

subckt BMXIX4 A M0 M1 PPN S X2 VSS VDD
mp8 (n1 M1 n8 VDD) g45p1hvt w=(215n) l=45n nf=1 m=(1)
mp7 (n8 S VDD VDD) g45p1hvt w=(215n) l=45n nf=1 m=(1)
mp3 (n4 S VDD VDD) g45p1hvt w=(215n) l=45n nf=1 m=(1)
mp4 (n0 M0 n4 VDD) g45p1hvt w=(215n) l=45n nf=1 m=(1)
mp9 (n10 A VDD VDD) g45p1hvt w=(215n) l=45n nf=1 m=(1)
mp10 (n1 M1b n10 VDD) g45p1hvt w=(215n) l=45n nf=1 m=(1)
mp2 (X2b X2 VDD VDD) g45p1hvt w=(215n) l=45n nf=1 m=(1)
mp6 (n0 M0b n6 VDD) g45p1hvt w=(215n) l=45n nf=1 m=(1)
mp0 (M0b M0 VDD VDD) g45p1hvt w=(215n) l=45n nf=1 m=(1)
mp1 (M1b M1 VDD VDD) g45p1hvt w=(215n) l=45n nf=1 m=(1)
mp13 (PPN net293 VDD VDD) g45p1hvt w=(1.56u) l=45n nf=1 m=(1)
mp12 (n1 X2 net293 VDD) g45p1hvt w=(390n) l=45n nf=1 m=(1)
mp11 (net293 X2b n0 VDD) g45p1hvt w=(390n) l=45n nf=1 m=(1)
mp5 (n6 A VDD VDD) g45p1hvt w=(215n) l=45n nf=1 m=(1)
mn10 (n1 M1 n9 VSS) g45n1hvt w=(145n) l=45n nf=1 m=(1)
mn9 (n9 A VSS VSS) g45n1hvt w=(145n) l=45n nf=1 m=(1)
mn8 (n1 M1b n7 VSS) g45n1hvt w=(145n) l=45n nf=1 m=(1)
mn7 (n7 S VSS VSS) g45n1hvt w=(145n) l=45n nf=1 m=(1)
mn3 (n3 S VSS VSS) g45n1hvt w=(145n) l=45n nf=1 m=(1)
mn4 (n0 M0b n3 VSS) g45n1hvt w=(145n) l=45n nf=1 m=(1)
mn11 (net293 X2 n0 VSS) g45n1hvt w=(260n) l=45n nf=1 m=(1)
mn6 (n0 M0 n5 VSS) g45n1hvt w=(145n) l=45n nf=1 m=(1)
mn13 (PPN net293 VSS VSS) g45n1hvt w=(1.04u) l=45n nf=1 m=(1)
mn5 (n5 A VSS VSS) g45n1hvt w=(145n) l=45n nf=1 m=(1)
mn12 (n1 X2b net293 VSS) g45n1hvt w=(260n) l=45n nf=1 m=(1)
mn0 (M0b M0 VSS VSS) g45n1hvt w=(145n) l=45n nf=1 m=(1)
mn1 (M1b M1 VSS VSS) g45n1hvt w=(145n) l=45n nf=1 m=(1)
mn2 (X2b X2 VSS VSS) g45n1hvt w=(145n) l=45n nf=1 m=(1)
ends BMXIX4
