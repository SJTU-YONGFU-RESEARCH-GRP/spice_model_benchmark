// gsclib045_hvt/EDFFHQX8/schematic

simulator lang=spectre

subckt EDFFHQX8 CK D E Q VDD VSS
mp3 (Db Eb net328 VDD) g45p1hvt w=(390n) l=45n nf=1 m=(1)
mp2 (net328 D VDD VDD) g45p1hvt w=(390n) l=45n nf=1 m=(1)
mp51 (n30 CKbb net317 VDD) g45p1hvt w=(310n) l=45n nf=1 m=(1)
mp50 (net317 qbint VDD VDD) g45p1hvt w=(310n) l=45n nf=1 m=(1)
mp55 (Q qbint VDD VDD) g45p1hvt w=(3.115u) l=45n nf=1 m=(1)
mp35 (net309 mout VDD VDD) g45p1hvt w=(310n) l=45n nf=1 m=(1)
mp36 (n20 CKb net309 VDD) g45p1hvt w=(310n) l=45n nf=1 m=(1)
mp45 (qbint n30 VDD VDD) g45p1hvt w=(1.17u) l=45n nf=1 m=(1)
mp21 (CKbb CKb VDD VDD) g45p1hvt w=(215n) l=45n nf=1 m=(1)
mp40 (mout CKb n30 VDD) g45p1hvt w=(310n) l=45n nf=1 m=(1)
mp30 (mout n20 VDD VDD) g45p1hvt w=(310n) l=45n nf=1 m=(1)
mp1 (qbint E Db VDD) g45p1hvt w=(390n) l=45n nf=1 m=(1)
mp20 (CKb CK VDD VDD) g45p1hvt w=(215n) l=45n nf=1 m=(1)
mp25 (n20 CKbb Db VDD) g45p1hvt w=(310n) l=45n nf=1 m=(1)
mp0 (Eb E VDD VDD) g45p1hvt w=(215n) l=45n nf=1 m=(1)
mn3 (Db E net333 VSS) g45n1hvt w=(260n) l=45n nf=1 m=(1)
mn2 (net333 D VSS VSS) g45n1hvt w=(260n) l=45n nf=1 m=(1)
mn55 (Q qbint VSS VSS) g45n1hvt w=(2.065u) l=45n nf=1 m=(1)
mn51 (n30 CKb net380 VSS) g45n1hvt w=(205n) l=45n nf=1 m=(1)
mn50 (net380 qbint VSS VSS) g45n1hvt w=(205n) l=45n nf=1 m=(1)
mn35 (net340 mout VSS VSS) g45n1hvt w=(205n) l=45n nf=1 m=(1)
mn20 (CKb CK VSS VSS) g45n1hvt w=(145n) l=45n nf=1 m=(1)
mn45 (qbint n30 VSS VSS) g45n1hvt w=(780n) l=45n nf=1 m=(1)
mn21 (CKbb CKb VSS VSS) g45n1hvt w=(145n) l=45n nf=1 m=(1)
mn40 (mout CKbb n30 VSS) g45n1hvt w=(205n) l=45n nf=1 m=(1)
mn30 (mout n20 VSS VSS) g45n1hvt w=(205n) l=45n nf=1 m=(1)
mn0 (Eb E VSS VSS) g45n1hvt w=(145n) l=45n nf=1 m=(1)
mn1 (qbint Eb Db VSS) g45n1hvt w=(260n) l=45n nf=1 m=(1)
mn25 (n20 CKb Db VSS) g45n1hvt w=(205n) l=45n nf=1 m=(1)
mn36 (n20 CKbb net340 VSS) g45n1hvt w=(205n) l=45n nf=1 m=(1)
ends EDFFHQX8
