// gsclib045_hvt/OAI33X2/schematic

simulator lang=spectre

subckt OAI33X2 A0 A1 A2 B0 B1 B2 Y VDD VSS
mp1 (n2 A1 n1 VDD) g45p1hvt w=(790n) l=45n nf=1 m=(1)
mp4 (n4 B0 n3 VDD) g45p1hvt w=(790n) l=45n nf=1 m=(1)
mp3 (n3 B1 VDD VDD) g45p1hvt w=(790n) l=45n nf=1 m=(1)
mp5 (Y B2 n4 VDD) g45p1hvt w=(790n) l=45n nf=1 m=(1)
mp0 (n1 A0 VDD VDD) g45p1hvt w=(790n) l=45n nf=1 m=(1)
mp2 (Y A2 n2 VDD) g45p1hvt w=(790n) l=45n nf=1 m=(1)
mn0 (n0 A0 VSS VSS) g45n1hvt w=(520n) l=45n nf=1 m=(1)
mn4 (Y B0 n0 VSS) g45n1hvt w=(520n) l=45n nf=1 m=(1)
mn3 (Y B1 n0 VSS) g45n1hvt w=(520n) l=45n nf=1 m=(1)
mn1 (n0 A1 VSS VSS) g45n1hvt w=(520n) l=45n nf=1 m=(1)
mn2 (n0 A2 VSS VSS) g45n1hvt w=(520n) l=45n nf=1 m=(1)
mn5 (Y B2 n0 VSS) g45n1hvt w=(520n) l=45n nf=1 m=(1)
ends OAI33X2
