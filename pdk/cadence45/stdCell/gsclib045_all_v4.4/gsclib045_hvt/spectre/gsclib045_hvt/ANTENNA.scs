// Generated for: spectre (Apr  5 14:19:14 2013 )
// Library name: gsclib045_hvt
// Cell name: ANTENNA
// View name: schematic

simulator lang=spectre

subckt ANTENNA A VDD VSS
D1 (A VDD) g45pd1hvt area=188.8f pj=1.82u m=1
D0 (VSS A) g45nd1hvt area=155.1f pj=1.6u m=1
ends ANTENNA
// End of subcircuit definition.
