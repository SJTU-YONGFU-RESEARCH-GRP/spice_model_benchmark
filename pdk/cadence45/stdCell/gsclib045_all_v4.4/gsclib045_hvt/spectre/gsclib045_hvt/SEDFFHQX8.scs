// gsclib045_hvt/SEDFFHQX8/schematic

simulator lang=spectre

subckt SEDFFHQX8 CK D E Q SE SI VDD VSS
mp4 (Db Eb net449 VDD) g45p1hvt w=(390n) l=45n nf=1 m=(1)
mp3 (net449 D VDD VDD) g45p1hvt w=(390n) l=45n nf=1 m=(1)
mp13 (Dbp SEb net441 VDD) g45p1hvt w=(390n) l=45n nf=1 m=(1)
mp12 (net441 SI VDD VDD) g45p1hvt w=(390n) l=45n nf=1 m=(1)
mp51 (n30 Ckbb net426 VDD) g45p1hvt w=(310n) l=45n nf=1 m=(1)
mp50 (net426 qbint VDD VDD) g45p1hvt w=(310n) l=45n nf=1 m=(1)
mp55 (Q qbint VDD VDD) g45p1hvt w=(3.115u) l=45n nf=1 m=(1)
mp35 (net417 mout VDD VDD) g45p1hvt w=(310n) l=45n nf=1 m=(1)
mp36 (n20 CKb net417 VDD) g45p1hvt w=(310n) l=45n nf=1 m=(1)
mp20 (CKb CK VDD VDD) g45p1hvt w=(215n) l=45n nf=1 m=(1)
mp1 (net405 qint VDD VDD) g45p1hvt w=(390n) l=45n nf=1 m=(1)
mp2 (Db E net405 VDD) g45p1hvt w=(390n) l=45n nf=1 m=(1)
mp45 (qbint n30 VDD VDD) g45p1hvt w=(1.17u) l=45n nf=1 m=(1)
mp56 (qint qbint VDD VDD) g45p1hvt w=(780n) l=45n nf=1 m=(1)
mp21 (Ckbb CKb VDD VDD) g45p1hvt w=(215n) l=45n nf=1 m=(1)
mp40 (n30 CKb mout VDD) g45p1hvt w=(310n) l=45n nf=1 m=(1)
mp30 (mout n20 VDD VDD) g45p1hvt w=(310n) l=45n nf=1 m=(1)
mp11 (Db SE Dbp VDD) g45p1hvt w=(390n) l=45n nf=1 m=(1)
mp10 (SEb SE VDD VDD) g45p1hvt w=(215n) l=45n nf=1 m=(1)
mp0 (Eb E VDD VDD) g45p1hvt w=(215n) l=45n nf=1 m=(1)
mp25 (n20 Ckbb Dbp VDD) g45p1hvt w=(310n) l=45n nf=1 m=(1)
mn4 (Db E net526 VSS) g45n1hvt w=(260n) l=45n nf=1 m=(1)
mn3 (net526 D VSS VSS) g45n1hvt w=(260n) l=45n nf=1 m=(1)
mn13 (Dbp SE net518 VSS) g45n1hvt w=(260n) l=45n nf=1 m=(1)
mn12 (net518 SI VSS VSS) g45n1hvt w=(260n) l=45n nf=1 m=(1)
mn55 (Q qbint VSS VSS) g45n1hvt w=(2.065u) l=45n nf=1 m=(1)
mn50 (net509 qbint VSS VSS) g45n1hvt w=(205n) l=45n nf=1 m=(1)
mn51 (n30 CKb net509 VSS) g45n1hvt w=(205n) l=45n nf=1 m=(1)
mn35 (net501 mout VSS VSS) g45n1hvt w=(205n) l=45n nf=1 m=(1)
mn36 (n20 Ckbb net501 VSS) g45n1hvt w=(205n) l=45n nf=1 m=(1)
mn1 (net494 qint VSS VSS) g45n1hvt w=(260n) l=45n nf=1 m=(1)
mn2 (Db Eb net494 VSS) g45n1hvt w=(260n) l=45n nf=1 m=(1)
mn45 (qbint n30 VSS VSS) g45n1hvt w=(780n) l=45n nf=1 m=(1)
mn56 (qint qbint VSS VSS) g45n1hvt w=(520n) l=45n nf=1 m=(1)
mn21 (Ckbb CKb VSS VSS) g45n1hvt w=(145n) l=45n nf=1 m=(1)
mn40 (n30 Ckbb mout VSS) g45n1hvt w=(205n) l=45n nf=1 m=(1)
mn30 (mout n20 VSS VSS) g45n1hvt w=(205n) l=45n nf=1 m=(1)
mn10 (SEb SE VSS VSS) g45n1hvt w=(145n) l=45n nf=1 m=(1)
mn0 (Eb E VSS VSS) g45n1hvt w=(145n) l=45n nf=1 m=(1)
mn25 (n20 CKb Dbp VSS) g45n1hvt w=(205n) l=45n nf=1 m=(1)
mn20 (CKb CK VSS VSS) g45n1hvt w=(145n) l=45n nf=1 m=(1)
mn11 (Db SEb Dbp VSS) g45n1hvt w=(260n) l=45n nf=1 m=(1)
ends SEDFFHQX8
