// gsclib045_hvt/BUFX4/schematic

simulator lang=spectre

subckt BUFX4 A Y VDD VSS
mp1 (Y n0 VDD VDD) g45p1hvt w=(1.56u) l=45n nf=1 m=(1)
mp0 (n0 A VDD VDD) g45p1hvt w=(390n) l=45n nf=1 m=(1)
mn1 (VSS n0 Y VSS) g45n1hvt w=(1.04u) l=45n nf=1 m=(1)
mn0 (VSS A n0 VSS) g45n1hvt w=(260n) l=45n nf=1 m=(1)
ends BUFX4
