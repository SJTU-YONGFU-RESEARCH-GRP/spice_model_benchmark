// gsclib045_hvt/AO22X4/schematic

simulator lang=spectre

subckt AO22X4 A0 A1 B0 B1 Y VDD VSS
mp3 (n0 B1 n3 VDD) g45p1hvt w=(390n) l=45n nf=1 m=(1)
mp2 (n0 B0 n3 VDD) g45p1hvt w=(390n) l=45n nf=1 m=(1)
mp1 (n3 A1 VDD VDD) g45p1hvt w=(390n) l=45n nf=1 m=(1)
mp0 (n3 A0 VDD VDD) g45p1hvt w=(390n) l=45n nf=1 m=(1)
mp4 (Y n0 VDD VDD) g45p1hvt w=(1.56u) l=45n nf=1 m=(1)
mn3 (n0 B1 n2 VSS) g45n1hvt w=(260n) l=45n nf=1 m=(1)
mn2 (n2 B0 VSS VSS) g45n1hvt w=(260n) l=45n nf=1 m=(1)
mn1 (n0 A1 n1 VSS) g45n1hvt w=(260n) l=45n nf=1 m=(1)
mn0 (n1 A0 VSS VSS) g45n1hvt w=(260n) l=45n nf=1 m=(1)
mn4 (Y n0 VSS VSS) g45n1hvt w=(1.04u) l=45n nf=1 m=(1)
ends AO22X4
