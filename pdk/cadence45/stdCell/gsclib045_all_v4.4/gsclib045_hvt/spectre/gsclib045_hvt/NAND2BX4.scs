// gsclib045_hvt/NAND2BX4/schematic

simulator lang=spectre

subckt NAND2BX4 AN B Y VDD VSS
mp1 (Y n0 VDD VDD) g45p1hvt w=(1.56u) l=45n nf=1 m=(1)
mp2 (Y B VDD VDD) g45p1hvt w=(1.56u) l=45n nf=1 m=(1)
mp0 (n0 AN VDD VDD) g45p1hvt w=(390n) l=45n nf=1 m=(1)
mn2 (Y B n1 VSS) g45n1hvt w=(1.04u) l=45n nf=1 m=(1)
mn0 (n0 AN VSS VSS) g45n1hvt w=(260n) l=45n nf=1 m=(1)
mn1 (n1 n0 VSS VSS) g45n1hvt w=(1.04u) l=45n nf=1 m=(1)
ends NAND2BX4
