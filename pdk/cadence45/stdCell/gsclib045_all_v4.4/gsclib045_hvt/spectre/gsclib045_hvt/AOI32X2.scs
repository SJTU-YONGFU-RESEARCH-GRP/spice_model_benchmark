// gsclib045_hvt/AOI32X2/schematic

simulator lang=spectre

subckt AOI32X2 A0 A1 A2 B0 B1 Y VSS VDD
mp3 (Y B0 net47 VDD) g45p1hvt w=(780n) l=45n nf=1 m=(1)
mp4 (Y B1 net47 VDD) g45p1hvt w=(780n) l=45n nf=1 m=(1)
mp2 (net47 A2 VDD VDD) g45p1hvt w=(780n) l=45n nf=1 m=(1)
mp1 (net47 A1 VDD VDD) g45p1hvt w=(780n) l=45n nf=1 m=(1)
mp0 (net47 A0 VDD VDD) g45p1hvt w=(780n) l=45n nf=1 m=(1)
mn3 (net83 B0 VSS VSS) g45n1hvt w=(520n) l=45n nf=1 m=(1)
mn2 (Y A2 net71 VSS) g45n1hvt w=(520n) l=45n nf=1 m=(1)
mn0 (net75 A0 VSS VSS) g45n1hvt w=(520n) l=45n nf=1 m=(1)
mn1 (net71 A1 net75 VSS) g45n1hvt w=(520n) l=45n nf=1 m=(1)
mn4 (Y B1 net83 VSS) g45n1hvt w=(520n) l=45n nf=1 m=(1)
ends AOI32X2
