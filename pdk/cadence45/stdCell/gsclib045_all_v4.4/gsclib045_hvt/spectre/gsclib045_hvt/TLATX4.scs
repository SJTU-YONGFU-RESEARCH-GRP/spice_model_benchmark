// gsclib045_hvt/TLATX4/schematic

simulator lang=spectre

subckt TLATX4 D G Q QN VSS VDD
mp6 (n0 Gb net220 VDD) g45p1hvt w=(215n) l=45n nf=1 m=(1)
mp5 (net220 D VDD VDD) g45p1hvt w=(215n) l=45n nf=1 m=(1)
mp16 (n0 Gbb net212 VDD) g45p1hvt w=(215n) l=45n nf=1 m=(1)
mp15 (net212 Qint VDD VDD) g45p1hvt w=(215n) l=45n nf=1 m=(1)
mp22 (QN Qint VDD VDD) g45p1hvt w=(1.56u) l=45n nf=1 m=(1)
mp21 (Q Qbint VDD VDD) g45p1hvt w=(1.56u) l=45n nf=1 m=(1)
mp0 (Gb G VDD VDD) g45p1hvt w=(215n) l=45n nf=1 m=(1)
mp1 (Gbb Gb VDD VDD) g45p1hvt w=(215n) l=45n nf=1 m=(1)
mp10 (Qint n0 VDD VDD) g45p1hvt w=(620n) l=45n nf=1 m=(1)
mp20 (Qbint Qint VDD VDD) g45p1hvt w=(1.56u) l=45n nf=1 m=(1)
mn5 (net257 D VSS VSS) g45n1hvt w=(145n) l=45n nf=1 m=(1)
mn6 (n0 Gbb net257 VSS) g45n1hvt w=(145n) l=45n nf=1 m=(1)
mn16 (n0 Gb net245 VSS) g45n1hvt w=(145n) l=45n nf=1 m=(1)
mn15 (net245 Qint VSS VSS) g45n1hvt w=(145n) l=45n nf=1 m=(1)
mn22 (QN Qint VSS VSS) g45n1hvt w=(1.04u) l=45n nf=1 m=(1)
mn21 (Q Qbint VSS VSS) g45n1hvt w=(1.04u) l=45n nf=1 m=(1)
mn0 (Gb G VSS VSS) g45n1hvt w=(145n) l=45n nf=1 m=(1)
mn10 (Qint n0 VSS VSS) g45n1hvt w=(410n) l=45n nf=1 m=(1)
mn20 (Qbint Qint VSS VSS) g45n1hvt w=(1.04u) l=45n nf=1 m=(1)
mn1 (Gbb Gb VSS VSS) g45n1hvt w=(145n) l=45n nf=1 m=(1)
ends TLATX4
