// gsclib045_hvt/TLATNSRX4/schematic

simulator lang=spectre

subckt TLATNSRX4 D GN Q QN RN SN VSS VDD
mp6 (n5 GNbb net313 VDD) g45p1hvt w=(215n) l=45n nf=1 m=(1)
mp5 (net313 D VDD VDD) g45p1hvt w=(215n) l=45n nf=1 m=(1)
mp10 (qint SN VDD VDD) g45p1hvt w=(620n) l=45n nf=1 m=(1)
mp22 (QN qint VDD VDD) g45p1hvt w=(1.56u) l=45n nf=1 m=(1)
mp21 (Q qbint VDD VDD) g45p1hvt w=(1.56u) l=45n nf=1 m=(1)
mp0 (GNbp GN VDD VDD) g45p1hvt w=(215n) l=45n nf=1 m=(1)
mp3 (GNb GNbb VDD VDD) g45p1hvt w=(215n) l=45n nf=1 m=(1)
mp17 (n5 GNb net270 VDD) g45p1hvt w=(215n) l=45n nf=1 m=(1)
mp2 (GNbb GNbp VDD VDD) g45p1hvt w=(215n) l=45n nf=1 m=(1)
mp16 (net270 qint VDD VDD) g45p1hvt w=(215n) l=45n nf=1 m=(1)
mp15 (net270 RN VDD VDD) g45p1hvt w=(215n) l=45n nf=1 m=(1)
mp20 (qbint qint VDD VDD) g45p1hvt w=(1.56u) l=45n nf=1 m=(1)
mp1 (GNbb RN VDD VDD) g45p1hvt w=(215n) l=45n nf=1 m=(1)
mp11 (qint n5 VDD VDD) g45p1hvt w=(620n) l=45n nf=1 m=(1)
mn5 (net366 D VSS VSS) g45n1hvt w=(145n) l=45n nf=1 m=(1)
mn6 (n5 GNb net366 VSS) g45n1hvt w=(145n) l=45n nf=1 m=(1)
mn17 (n5 GNbb net354 VSS) g45n1hvt w=(145n) l=45n nf=1 m=(1)
mn16 (net354 qint net350 VSS) g45n1hvt w=(145n) l=45n nf=1 m=(1)
mn15 (net350 RN VSS VSS) g45n1hvt w=(145n) l=45n nf=1 m=(1)
mn11 (qint n5 net342 VSS) g45n1hvt w=(410n) l=45n nf=1 m=(1)
mn10 (net342 SN VSS VSS) g45n1hvt w=(410n) l=45n nf=1 m=(1)
mn21 (Q qbint VSS VSS) g45n1hvt w=(1.04u) l=45n nf=1 m=(1)
mn0 (GNbp GN VSS VSS) g45n1hvt w=(145n) l=45n nf=1 m=(1)
mn2 (GNbb GNbp net326 VSS) g45n1hvt w=(145n) l=45n nf=1 m=(1)
mn1 (net326 RN VSS VSS) g45n1hvt w=(145n) l=45n nf=1 m=(1)
mn3 (GNb GNbb VSS VSS) g45n1hvt w=(145n) l=45n nf=1 m=(1)
mn20 (qbint qint VSS VSS) g45n1hvt w=(1.04u) l=45n nf=1 m=(1)
mn22 (QN qint VSS VSS) g45n1hvt w=(1.04u) l=45n nf=1 m=(1)
ends TLATNSRX4
