// gsclib045_hvt/OAI33X4/schematic

simulator lang=spectre

subckt OAI33X4 A0 A1 A2 B0 B1 B2 Y VDD VSS
mp1 (n2 A1 n1 VDD) g45p1hvt w=(1.56u) l=45n nf=1 m=(1)
mp4 (n4 B0 n3 VDD) g45p1hvt w=(1.56u) l=45n nf=1 m=(1)
mp3 (n3 B1 VDD VDD) g45p1hvt w=(1.56u) l=45n nf=1 m=(1)
mp5 (Y B2 n4 VDD) g45p1hvt w=(1.56u) l=45n nf=1 m=(1)
mp0 (n1 A0 VDD VDD) g45p1hvt w=(1.56u) l=45n nf=1 m=(1)
mp2 (Y A2 n2 VDD) g45p1hvt w=(1.56u) l=45n nf=1 m=(1)
mn0 (no A0 VSS VSS) g45n1hvt w=(1.04u) l=45n nf=1 m=(1)
mn4 (Y B0 no VSS) g45n1hvt w=(1.04u) l=45n nf=1 m=(1)
mn3 (Y B1 no VSS) g45n1hvt w=(1.04u) l=45n nf=1 m=(1)
mn1 (no A1 VSS VSS) g45n1hvt w=(1.04u) l=45n nf=1 m=(1)
mn2 (no A2 VSS VSS) g45n1hvt w=(1.04u) l=45n nf=1 m=(1)
mn5 (Y B2 no VSS) g45n1hvt w=(1.04u) l=45n nf=1 m=(1)
ends OAI33X4
