// gsclib045_hvt/OAI31X4/schematic

simulator lang=spectre

subckt OAI31X4 A0 A1 A2 B0 Y VSS VDD
mp2 (Y A2 n2 VDD) g45p1hvt w=(1.56u) l=45n nf=1 m=(1)
mp1 (n2 A1 n1 VDD) g45p1hvt w=(1.56u) l=45n nf=1 m=(1)
mp3 (Y B0 VDD VDD) g45p1hvt w=(1.56u) l=45n nf=1 m=(1)
mp0 (n1 A0 VDD VDD) g45p1hvt w=(1.56u) l=45n nf=1 m=(1)
mn3 (Y B0 n0 VSS) g45n1hvt w=(1.04u) l=45n nf=1 m=(1)
mn0 (n0 A0 VSS VSS) g45n1hvt w=(1.04u) l=45n nf=1 m=(1)
mn2 (n0 A2 VSS VSS) g45n1hvt w=(1.04u) l=45n nf=1 m=(1)
mn1 (n0 A1 VSS VSS) g45n1hvt w=(1.04u) l=45n nf=1 m=(1)
ends OAI31X4
