// gsclib045_hvt/TLATNTSCAX16/schematic

simulator lang=spectre

subckt TLATNTSCAX16 CK E ECK SE VSS VDD
mp1 (Eb E net246 VDD) g45p1hvt w=(215n) l=45n nf=1 m=(1)
mp0 (net246 SE VDD VDD) g45p1hvt w=(215n) l=45n nf=1 m=(1)
mp22 (ECK ECKb VDD VDD) g45p1hvt w=(6.23u) l=45n nf=1 m=(1)
mp16 (n5 CKb net234 VDD) g45p1hvt w=(215n) l=45n nf=1 m=(1)
mp15 (net234 Eint VDD VDD) g45p1hvt w=(215n) l=45n nf=1 m=(1)
mp2 (CKb CK VDD VDD) g45p1hvt w=(215n) l=45n nf=1 m=(1)
mp10 (Eint n5 VDD VDD) g45p1hvt w=(620n) l=45n nf=1 m=(1)
mp3 (CKbb CKb VDD VDD) g45p1hvt w=(215n) l=45n nf=1 m=(1)
mp5 (n5 CKbb Eb VDD) g45p1hvt w=(215n) l=45n nf=1 m=(1)
mp21 (ECKb CKbb VDD VDD) g45p1hvt w=(1.56u) l=45n nf=1 m=(1)
mp20 (ECKb Eint VDD VDD) g45p1hvt w=(1.56u) l=45n nf=1 m=(1)
mn1 (Eb E VSS VSS) g45n1hvt w=(145n) l=45n nf=1 m=(1)
mn0 (Eb SE VSS VSS) g45n1hvt w=(145n) l=45n nf=1 m=(1)
mn22 (ECK ECKb VSS VSS) g45n1hvt w=(4.13u) l=45n nf=1 m=(1)
mn21 (ECKb CKbb net271 VSS) g45n1hvt w=(1.04u) l=45n nf=1 m=(1)
mn20 (net271 Eint VSS VSS) g45n1hvt w=(1.04u) l=45n nf=1 m=(1)
mn16 (n5 CKbb net263 VSS) g45n1hvt w=(145n) l=45n nf=1 m=(1)
mn15 (net263 Eint VSS VSS) g45n1hvt w=(145n) l=45n nf=1 m=(1)
mn2 (CKb CK VSS VSS) g45n1hvt w=(145n) l=45n nf=1 m=(1)
mn10 (Eint n5 VSS VSS) g45n1hvt w=(410n) l=45n nf=1 m=(1)
mn5 (Eb CKb n5 VSS) g45n1hvt w=(145n) l=45n nf=1 m=(1)
mn3 (CKbb CKb VSS VSS) g45n1hvt w=(145n) l=45n nf=1 m=(1)
ends TLATNTSCAX16
