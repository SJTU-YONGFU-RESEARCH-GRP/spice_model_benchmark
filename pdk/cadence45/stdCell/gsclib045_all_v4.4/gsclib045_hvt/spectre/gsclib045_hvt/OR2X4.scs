// gsclib045_hvt/OR2X4/schematic

simulator lang=spectre

subckt OR2X4 A B Y VSS VDD
mp1 (n0 B n1 VDD) g45p1hvt w=(390n) l=45n nf=1 m=(1)
mp2 (Y n0 VDD VDD) g45p1hvt w=(1.56u) l=45n nf=1 m=(1)
mp0 (n1 A VDD VDD) g45p1hvt w=(390n) l=45n nf=1 m=(1)
mn2 (Y n0 VSS VSS) g45n1hvt w=(1.04u) l=45n nf=1 m=(1)
mn0 (n0 A VSS VSS) g45n1hvt w=(260n) l=45n nf=1 m=(1)
mn1 (n0 B VSS VSS) g45n1hvt w=(260n) l=45n nf=1 m=(1)
ends OR2X4
