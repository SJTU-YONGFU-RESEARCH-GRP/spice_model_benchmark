// gsclib045_hvt/OAI2BB2X4/schematic

simulator lang=spectre

subckt OAI2BB2X4 A0N A1N B0 B1 Y VDD VSS
mp5 (Y B1 n3 VDD) g45p1hvt w=(1.56u) l=45n nf=1 m=(1)
mp4 (n3 B0 VDD VDD) g45p1hvt w=(1.56u) l=45n nf=1 m=(1)
mp0 (n0 A0N VDD VDD) g45p1hvt w=(390n) l=45n nf=1 m=(1)
mp2 (n2 n0 VDD VDD) g45p1hvt w=(1.56u) l=45n nf=1 m=(1)
mp1 (n1 A1N VDD VDD) g45p1hvt w=(390n) l=45n nf=1 m=(1)
mp3 (Y n1 n2 VDD) g45p1hvt w=(1.56u) l=45n nf=1 m=(1)
mn5 (Y B1 n4 VSS) g45n1hvt w=(1.04u) l=45n nf=1 m=(1)
mn4 (Y B0 n4 VSS) g45n1hvt w=(1.04u) l=45n nf=1 m=(1)
mn2 (n4 n0 VSS VSS) g45n1hvt w=(1.04u) l=45n nf=1 m=(1)
mn0 (n0 A0N VSS VSS) g45n1hvt w=(260n) l=45n nf=1 m=(1)
mn1 (n1 A1N VSS VSS) g45n1hvt w=(260n) l=45n nf=1 m=(1)
mn3 (n4 n1 VSS VSS) g45n1hvt w=(1.04u) l=45n nf=1 m=(1)
ends OAI2BB2X4
