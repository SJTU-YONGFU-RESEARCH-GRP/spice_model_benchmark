// gsclib045_hvt/AOI21XL/schematic

simulator lang=spectre

subckt AOI21XL A0 A1 B0 Y VDD VSS
mp2 (Y B0 net70 VDD) g45p1hvt w=(215n) l=45n nf=1 m=(1)
mp1 (net70 A1 VDD VDD) g45p1hvt w=(215n) l=45n nf=1 m=(1)
mp0 (net70 A0 VDD VDD) g45p1hvt w=(215n) l=45n nf=1 m=(1)
mn2 (Y B0 VSS VSS) g45n1hvt w=(145n) l=45n nf=1 m=(1)
mn0 (net74 A0 VSS VSS) g45n1hvt w=(145n) l=45n nf=1 m=(1)
mn1 (Y A1 net74 VSS) g45n1hvt w=(145n) l=45n nf=1 m=(1)
ends AOI21XL
