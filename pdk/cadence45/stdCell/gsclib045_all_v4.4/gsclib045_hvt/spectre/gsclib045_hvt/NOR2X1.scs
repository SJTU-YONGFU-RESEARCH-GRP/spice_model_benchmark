// gsclib045_hvt/NOR2X1/schematic

simulator lang=spectre

subckt NOR2X1 A B Y VSS VDD
mp1 (Y B net41 VDD) g45p1hvt w=(390n) l=45n nf=1 m=(1)
mp0 (net41 A VDD VDD) g45p1hvt w=(390n) l=45n nf=1 m=(1)
mn1 (Y B VSS VSS) g45n1hvt w=(260n) l=45n nf=1 m=(1)
mn0 (Y A VSS VSS) g45n1hvt w=(260n) l=45n nf=1 m=(1)
ends NOR2X1
