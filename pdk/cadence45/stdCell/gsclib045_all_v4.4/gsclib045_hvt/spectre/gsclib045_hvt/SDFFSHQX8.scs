// gsclib045_hvt/SDFFSHQX8/schematic

simulator lang=spectre

subckt SDFFSHQX8 CK D Q SE SI SN VDD VSS
mp14 (Db SEb net398 VDD) g45p1hvt w=(390n) l=45n nf=1 m=(1)
mp13 (net398 SI VDD VDD) g45p1hvt w=(390n) l=45n nf=1 m=(1)
mp12 (Db SE net390 VDD) g45p1hvt w=(390n) l=45n nf=1 m=(1)
mp11 (net390 D VDD VDD) g45p1hvt w=(390n) l=45n nf=1 m=(1)
mp55 (Q qbint VDD VDD) g45p1hvt w=(3.115u) l=45n nf=1 m=(1)
mp36 (n20 CKb net378 VDD) g45p1hvt w=(310n) l=45n nf=1 m=(1)
mp35 (net378 mout VDD VDD) g45p1hvt w=(310n) l=45n nf=1 m=(1)
mp20 (CKb CK VDD VDD) g45p1hvt w=(215n) l=45n nf=1 m=(1)
mp52 (n30 CKbb net355 VDD) g45p1hvt w=(310n) l=45n nf=1 m=(1)
mp51 (net355 qbint VDD VDD) g45p1hvt w=(310n) l=45n nf=1 m=(1)
mp50 (net355 SN VDD VDD) g45p1hvt w=(310n) l=45n nf=1 m=(1)
mp21 (CKbb CKb VDD VDD) g45p1hvt w=(215n) l=45n nf=1 m=(1)
mp31 (mout n20 VDD VDD) g45p1hvt w=(310n) l=45n nf=1 m=(1)
mp45 (qbint n30 VDD VDD) g45p1hvt w=(1.17u) l=45n nf=1 m=(1)
mp30 (mout SN VDD VDD) g45p1hvt w=(310n) l=45n nf=1 m=(1)
mp25 (n20 CKbb Db VDD) g45p1hvt w=(310n) l=45n nf=1 m=(1)
mp40 (n30 CKb mout VDD) g45p1hvt w=(310n) l=45n nf=1 m=(1)
mp10 (SEb SE VDD VDD) g45p1hvt w=(215n) l=45n nf=1 m=(1)
mn51 (net467 qbint net459 VSS) g45n1hvt w=(205n) l=45n nf=1 m=(1)
mn52 (n30 CKb net467 VSS) g45n1hvt w=(205n) l=45n nf=1 m=(1)
mn50 (net459 SN VSS VSS) g45n1hvt w=(205n) l=45n nf=1 m=(1)
mn13 (net455 SI VSS VSS) g45n1hvt w=(260n) l=45n nf=1 m=(1)
mn14 (Db SE net455 VSS) g45n1hvt w=(260n) l=45n nf=1 m=(1)
mn12 (Db SEb net443 VSS) g45n1hvt w=(260n) l=45n nf=1 m=(1)
mn11 (net443 D VSS VSS) g45n1hvt w=(260n) l=45n nf=1 m=(1)
mn55 (Q qbint VSS VSS) g45n1hvt w=(2.065u) l=45n nf=1 m=(1)
mn30 (net435 SN VSS VSS) g45n1hvt w=(205n) l=45n nf=1 m=(1)
mn31 (mout n20 net435 VSS) g45n1hvt w=(205n) l=45n nf=1 m=(1)
mn35 (net427 mout VSS VSS) g45n1hvt w=(205n) l=45n nf=1 m=(1)
mn36 (n20 CKbb net427 VSS) g45n1hvt w=(205n) l=45n nf=1 m=(1)
mn20 (CKb CK VSS VSS) g45n1hvt w=(145n) l=45n nf=1 m=(1)
mn10 (SEb SE VSS VSS) g45n1hvt w=(145n) l=45n nf=1 m=(1)
mn25 (n20 CKb Db VSS) g45n1hvt w=(205n) l=45n nf=1 m=(1)
mn40 (n30 CKbb mout VSS) g45n1hvt w=(205n) l=45n nf=1 m=(1)
mn45 (qbint n30 VSS VSS) g45n1hvt w=(780n) l=45n nf=1 m=(1)
mn21 (CKbb CKb VSS VSS) g45n1hvt w=(145n) l=45n nf=1 m=(1)
ends SDFFSHQX8
