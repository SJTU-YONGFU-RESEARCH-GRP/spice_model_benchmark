// Generated for: spectre (Apr  5 14:26:12 2013 )
// Library name: gsclib045_hvt
// Cell name: TIEHI
// View name: schematic

simulator lang=spectre

subckt TIEHI Y VSS VDD
mp0 (Y net25 VDD VDD) g45p1hvt w=(390n) l=45n nf=1 as=54.6f ad=54.6f \
        ps=1.06u pd=1.06u nrd=358.974m nrs=358.974m sa=140n sb=140n \
        sd=160n sca=114.89040 scb=0.09003 scc=0.01377 m=(1)
mn0 (net25 net25 VSS VSS) g45n1hvt w=(260n) l=45n nf=1 as=36.4f ad=36.4f \
        ps=800n pd=800n nrd=538.462m nrs=538.462m sa=140n sb=140n sd=160n \
        sca=144.98299 scb=0.10251 scc=0.01780 m=(1)
ends TIEHI
// End of subcircuit definition.
