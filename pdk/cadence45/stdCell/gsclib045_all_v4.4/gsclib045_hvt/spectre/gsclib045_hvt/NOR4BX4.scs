// gsclib045_hvt/NOR4BX4/schematic

simulator lang=spectre

subckt NOR4BX4 AN B C D Y VSS VDD
mp4 (Y D n3 VDD) g45p1hvt w=(1.56u) l=45n nf=1 m=(1)
mp0 (n0 AN VDD VDD) g45p1hvt w=(390n) l=45n nf=1 m=(1)
mp3 (n3 C n2 VDD) g45p1hvt w=(1.56u) l=45n nf=1 m=(1)
mp2 (n2 B n1 VDD) g45p1hvt w=(1.56u) l=45n nf=1 m=(1)
mp1 (n1 n0 VDD VDD) g45p1hvt w=(1.56u) l=45n nf=1 m=(1)
mn4 (Y D VSS VSS) g45n1hvt w=(1.04u) l=45n nf=1 m=(1)
mn1 (Y n0 VSS VSS) g45n1hvt w=(1.04u) l=45n nf=1 m=(1)
mn3 (Y C VSS VSS) g45n1hvt w=(1.04u) l=45n nf=1 m=(1)
mn0 (n0 AN VSS VSS) g45n1hvt w=(260n) l=45n nf=1 m=(1)
mn2 (Y B VSS VSS) g45n1hvt w=(1.04u) l=45n nf=1 m=(1)
ends NOR4BX4
