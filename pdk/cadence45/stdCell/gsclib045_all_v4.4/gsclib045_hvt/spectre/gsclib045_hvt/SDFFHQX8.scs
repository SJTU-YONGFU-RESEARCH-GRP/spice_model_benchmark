// gsclib045_hvt/SDFFHQX8/schematic

simulator lang=spectre

subckt SDFFHQX8 CK D Q SE SI VDD VSS
mp14 (Db SEb net350 VDD) g45p1hvt w=(390n) l=45n nf=1 m=(1)
mp13 (net350 SI VDD VDD) g45p1hvt w=(390n) l=45n nf=1 m=(1)
mp12 (Db SE net342 VDD) g45p1hvt w=(390n) l=45n nf=1 m=(1)
mp11 (net342 D VDD VDD) g45p1hvt w=(390n) l=45n nf=1 m=(1)
mp51 (n30 CKbb net334 VDD) g45p1hvt w=(310n) l=45n nf=1 m=(1)
mp50 (net334 qbint VDD VDD) g45p1hvt w=(310n) l=45n nf=1 m=(1)
mp55 (Q qbint VDD VDD) g45p1hvt w=(3.115u) l=45n nf=1 m=(1)
mp35 (net319 mout VDD VDD) g45p1hvt w=(310n) l=45n nf=1 m=(1)
mp25 (Db CKbb n20 VDD) g45p1hvt w=(310n) l=45n nf=1 m=(1)
mp21 (CKbb CKb VDD VDD) g45p1hvt w=(215n) l=45n nf=1 m=(1)
mp30 (mout n20 VDD VDD) g45p1hvt w=(310n) l=45n nf=1 m=(1)
mp36 (n20 CKb net319 VDD) g45p1hvt w=(310n) l=45n nf=1 m=(1)
mp40 (n30 CKb mout VDD) g45p1hvt w=(310n) l=45n nf=1 m=(1)
mp10 (SEb SE VDD VDD) g45p1hvt w=(215n) l=45n nf=1 m=(1)
mp45 (qbint n30 VDD VDD) g45p1hvt w=(1.17u) l=45n nf=1 m=(1)
mp20 (CKb CK VDD VDD) g45p1hvt w=(215n) l=45n nf=1 m=(1)
mn13 (net411 SI VSS VSS) g45n1hvt w=(260n) l=45n nf=1 m=(1)
mn14 (Db SE net411 VSS) g45n1hvt w=(260n) l=45n nf=1 m=(1)
mn12 (Db SEb net399 VSS) g45n1hvt w=(260n) l=45n nf=1 m=(1)
mn11 (net399 D VSS VSS) g45n1hvt w=(260n) l=45n nf=1 m=(1)
mn55 (Q qbint VSS VSS) g45n1hvt w=(2.065u) l=45n nf=1 m=(1)
mn50 (net391 qbint VSS VSS) g45n1hvt w=(205n) l=45n nf=1 m=(1)
mn10 (SEb SE VSS VSS) g45n1hvt w=(145n) l=45n nf=1 m=(1)
mn40 (mout CKbb n30 VSS) g45n1hvt w=(205n) l=45n nf=1 m=(1)
mn35 (net378 mout VSS VSS) g45n1hvt w=(205n) l=45n nf=1 m=(1)
mn36 (n20 CKbb net378 VSS) g45n1hvt w=(205n) l=45n nf=1 m=(1)
mn20 (CKb CK VSS VSS) g45n1hvt w=(145n) l=45n nf=1 m=(1)
mn51 (n30 CKb net391 VSS) g45n1hvt w=(205n) l=45n nf=1 m=(1)
mn21 (CKbb CKb VSS VSS) g45n1hvt w=(145n) l=45n nf=1 m=(1)
mn45 (qbint n30 VSS VSS) g45n1hvt w=(780n) l=45n nf=1 m=(1)
mn25 (n20 CKb Db VSS) g45n1hvt w=(205n) l=45n nf=1 m=(1)
mn30 (mout n20 VSS VSS) g45n1hvt w=(205n) l=45n nf=1 m=(1)
ends SDFFHQX8
