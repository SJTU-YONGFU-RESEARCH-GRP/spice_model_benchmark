// gsclib045_hvt/AOI22X2/schematic

simulator lang=spectre

subckt AOI22X2 A0 A1 B0 B1 Y VSS VDD
mp3 (Y B1 net89 VDD) g45p1hvt w=(780n) l=45n nf=1 m=(1)
mp0 (net89 A0 VDD VDD) g45p1hvt w=(780n) l=45n nf=1 m=(1)
mp1 (net89 A1 VDD VDD) g45p1hvt w=(780n) l=45n nf=1 m=(1)
mp2 (Y B0 net89 VDD) g45p1hvt w=(780n) l=45n nf=1 m=(1)
mn3 (Y B1 net106 VSS) g45n1hvt w=(520n) l=45n nf=1 m=(1)
mn0 (net98 A0 VSS VSS) g45n1hvt w=(520n) l=45n nf=1 m=(1)
mn2 (net106 B0 VSS VSS) g45n1hvt w=(520n) l=45n nf=1 m=(1)
mn1 (Y A1 net98 VSS) g45n1hvt w=(520n) l=45n nf=1 m=(1)
ends AOI22X2
