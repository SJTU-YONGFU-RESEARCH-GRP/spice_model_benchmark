// gsclib045_hvt/BUFX20/schematic

simulator lang=spectre

subckt BUFX20 A Y VSS VDD
mp1 (Y n0 VDD VDD) g45p1hvt w=(7.82u) l=45n nf=1 m=(1)
mp0 (n0 A VDD VDD) g45p1hvt w=(1.95u) l=45n nf=1 m=(1)
mn1 (VSS n0 Y VSS) g45n1hvt w=(5.185u) l=45n nf=1 m=(1)
mn0 (VSS A n0 VSS) g45n1hvt w=(1.3u) l=45n nf=1 m=(1)
ends BUFX20
