// Verilog-AMS netlist generated by the AMS netlister, version  ICADV12.1.main.53 .
// Cadence Design Systems, Inc.

`include "disciplines.vams"

(* cds_ams_schematic *)
module SPDFF2RX1 ( D1,.VDD(\VDD! ),D2,Q1,CK,
Q1N,Q2,RN,SI2,SI1,.VSS(\VSS! ),Q2N,SE );

input   D1;
input  (*
integer inh_conn_prop_name = "VDD";
integer
inh_conn_def_value = "cds_globals.\\VDD! ";
 *)
 \VDD! ;
input   D2;

output   Q1;
input   CK;
output   Q1N;
output   Q2;
input   RN;

input   SI2;
input   SI1;
input  (*
integer inh_conn_prop_name
 = "VSS";
integer inh_conn_def_value = "cds_globals.\\VSS! ";
 *)

 \VSS! ;
output   Q2N;
input   SE;

wire D1;
wire (*
integer inh_conn_prop_name = "VSS";
integer inh_conn_def_value
 = "cds_globals.\\VSS! ";
 *)
\VSS! ;
wire Q1;
wire CK;
wire Q2;
wire RN;
wire Q2N;
wire (*
integer inh_conn_prop_name = "VDD";
integer inh_conn_def_value
 = "cds_globals.\\VDD! ";
 *)
\VDD! ;

SDFFRX1core (*
integer library_binding = "gsclib045";
 *)
I1 ( .SI(
SI1 ), .VDD( \VDD!  ), .QN( Q1N ), .Ckbb( net11 ), .D( D1 ), .RN( RN ),
.VSS( \VSS!  ), .Q( Q1 ), .Ckb( net10 ), .SE( SE ) );
SDFFRX1core (*
integer library_binding = "gsclib045";
 *)
I2 ( .SI(
SI2 ), .VDD( \VDD!  ), .QN( Q2N ), .Ckbb( net11 ), .D( D2 ), .RN( RN ),
.VSS( \VSS!  ), .Q( Q2 ), .Ckb( net10 ), .SE( SE ) );

CLKBUFX2core (*
integer library_binding = "gsclib045";
 *)
I0 ( .VDD(
\VDD!  ), .Ckbb( net11 ), .CK( CK ), .VSS( \VSS!  ), .Ckb( net10 ) );

endmodule
