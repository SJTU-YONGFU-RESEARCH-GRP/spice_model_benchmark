// Verilog-AMS netlist generated by the AMS netlister, version  ICADV12.1.main.53 .
// Cadence Design Systems, Inc.

`include "disciplines.vams"

(* cds_ams_schematic *)
module SPDFF4RX2 ( D1,.VDD(\VDD! ),D3,D2,Q1,D4,
CK,Q1N,Q3,Q2,Q4,Q3N,RN,SI4,SI3,SI2,SI1,.VSS(\VSS! ),Q2N,SE,Q4N );

input   D1;
input  (*
integer inh_conn_prop_name = "VDD";
integer
inh_conn_def_value = "cds_globals.\\VDD! ";
 *)
 \VDD! ;
input   D3;

input   D2;
output   Q1;
input   D4;
input   CK;
output   Q1N;

output   Q3;
output   Q2;
output   Q4;
output   Q3N;
input   RN;

input   SI4;
input   SI3;
input   SI2;
input   SI1;
input  (*
integer
inh_conn_prop_name = "VSS";
integer inh_conn_def_value
 = "cds_globals.\\VSS! ";
 *)
 \VSS! ;
output   Q2N;
input   SE;

output   Q4N;

wire D1;
wire (*
integer inh_conn_prop_name = "VSS";
integer inh_conn_def_value
 = "cds_globals.\\VSS! ";
 *)
\VSS! ;
wire Q1;
wire D4;
wire CK;
wire Q3;
wire Q2;
wire Q4;
wire RN;
wire Q2N;
wire (*
integer inh_conn_prop_name = "VDD";
integer inh_conn_def_value
 = "cds_globals.\\VDD! ";
 *)
\VDD! ;
wire Q4N;

SDFFRX2core (*
integer library_binding = "gsclib045";
 *)
I4 ( .SI(
SI4 ), .VDD( \VDD!  ), .QN( Q4N ), .Ckbb( net11 ), .D( D4 ), .RN( RN ),
.VSS( \VSS!  ), .Q( Q4 ), .Ckb( net10 ), .SE( SE ) );
SDFFRX2core (*
integer library_binding = "gsclib045";
 *)
I1 ( .SI(
SI1 ), .VDD( \VDD!  ), .QN( Q1N ), .Ckbb( net11 ), .D( D1 ), .RN( RN ),
.VSS( \VSS!  ), .Q( Q1 ), .Ckb( net10 ), .SE( SE ) );
SDFFRX2core (*
integer library_binding = "gsclib045";
 *)
I2 ( .SI(
SI2 ), .VDD( \VDD!  ), .QN( Q2N ), .Ckbb( net11 ), .D( D2 ), .RN( RN ),
.VSS( \VSS!  ), .Q( Q2 ), .Ckb( net10 ), .SE( SE ) );
SDFFRX2core (*
integer library_binding = "gsclib045";
 *)
I3 ( .SI(
SI3 ), .VDD( \VDD!  ), .QN( Q3N ), .Ckbb( net11 ), .D( D3 ), .RN( RN ),
.VSS( \VSS!  ), .Q( Q3 ), .Ckb( net10 ), .SE( SE ) );

CLKBUFX2core (*
integer library_binding = "gsclib045";
 *)
I0 ( .VDD(
\VDD!  ), .Ckbb( net11 ), .CK( CK ), .VSS( \VSS!  ), .Ckb( net10 ) );

endmodule
