// Generated for: spectre (May  1 08:12:15 2013 )
// Library name: gsclib045
// Cell name: RDFFNX1
// View name: extracted

simulator lang=spectre

subckt RDFFNX1 CKN D ExtVDD Q QN RT VDD VSS
mp56 (\9\:qint \11\:qbint \12\:VDD VDD) g45p1svt w=(2.15e-07) l=4.5e-08 \
        nf=1 as=3.01e-14 ad=6.535e-14 ps=7.1e-07 pd=1.16e-06 nrd=1.16667 \
        nrs=1.16667 sa=3.75e-07 sb=1.4e-07 sd=160n sca=17.2901 \
        scb=0.0181468 scc=0.000802014 m=(1)
mp21 (\13\:CKNbb \7\:CKNb \14\:VDD VDD) g45p1svt w=(2.15e-07) l=4.5e-08 \
        nf=1 as=3.44e-14 ad=3.01e-14 ps=7.5e-07 pd=7.1e-07 nrd=1.16667 \
        nrs=1.16667 sa=1.4e-07 sb=3.45e-07 sd=160n sca=16.9543 \
        scb=0.0169944 scc=0.00104371 m=(1)
PM3 (\15\:n35g \4\:RTb net205 ExtVDD) g45p1svt w=(2.15e-07) l=4.5e-08 \
        nf=1 as=3.01e-14 ad=1.29e-14 ps=7.1e-07 pd=5.5e-07 nrd=1.16667 \
        nrs=1.16667 sa=8.7e-07 sb=1.4e-07 sd=160n sca=25.3956 \
        scb=0.0259635 scc=0.00265434 m=(1)
mp32 (\5\:mout \3\:n20 \16\:VDD VDD) g45p1svt w=(2.15e-07) l=4.5e-08 \
        nf=1 as=3.44e-14 ad=3.44e-14 ps=7.5e-07 pd=7.5e-07 nrd=1.16667 \
        nrs=1.16667 sa=4.5e-07 sb=3.45e-07 sd=160n sca=13.5042 \
        scb=0.0131605 scc=0.000288614 m=(1)
mp35 (n31 mout \16\:VDD VDD) g45p1svt w=(2.15e-07) l=4.5e-08 nf=1 \
        as=1.29e-14 ad=3.44e-14 ps=5.5e-07 pd=7.5e-07 nrd=1.16667 \
        nrs=1.16667 sa=2.45e-07 sb=5.5e-07 sd=160n sca=11.2521 \
        scb=0.00925046 scc=0.000235422 m=(1)
mp25 (n22 \4\:D \18\:VDD VDD) g45p1svt w=(2.15e-07) l=4.5e-08 nf=1 \
        as=3.01e-14 ad=1.29e-14 ps=7.1e-07 pd=5.5e-07 nrd=1.16667 \
        nrs=1.16667 sa=1.4e-07 sb=2.45e-07 sd=160n sca=20.5104 \
        scb=0.0232403 scc=0.00120911 m=(1)
mp26 (\9\:n20 \4\:CKNb n22 VDD) g45p1svt w=(2.15e-07) l=4.5e-08 nf=1 \
        as=1.29e-14 ad=3.01e-14 ps=5.5e-07 pd=7.1e-07 nrd=1.16667 \
        nrs=1.16667 sa=2.45e-07 sb=1.4e-07 sd=160n sca=17.9596 scb=0.01876 \
        scc=0.00106467 m=(1)
mp36 (\13\:n20 \6\:CKNbb n31 VDD) g45p1svt w=(2.15e-07) l=4.5e-08 nf=1 \
        as=1.29e-14 ad=3.01e-14 ps=5.5e-07 pd=7.1e-07 nrd=1.16667 \
        nrs=1.16667 sa=1.4e-07 sb=6.55e-07 sd=160n sca=11.0284 \
        scb=0.00890057 scc=0.000234415 m=(1)
mp20 (\20\:CKNb \4\:CKN \14\:VDD VDD) g45p1svt w=(2.15e-07) l=4.5e-08 \
        nf=1 as=3.44e-14 ad=3.01e-14 ps=7.5e-07 pd=7.1e-07 nrd=1.16667 \
        nrs=1.16667 sa=3.45e-07 sb=1.4e-07 sd=160n sca=21.0614 \
        scb=0.0241824 scc=0.00125996 m=(1)
mp40 (\4\:n35 \8\:CKNbb \5\:mout VDD) g45p1svt w=(2.15e-07) l=4.5e-08 \
        nf=1 as=3.44e-14 ad=3.01e-14 ps=7.5e-07 pd=7.1e-07 nrd=1.16667 \
        nrs=1.16667 sa=6.55e-07 sb=1.4e-07 sd=160n sca=25.0692 \
        scb=0.0290985 scc=0.00202261 m=(1)
PM0 (\6\:n35g \6\:RT \10\:n35 ExtVDD) g45p1svt w=(2.15e-07) l=4.5e-08 \
        nf=1 as=3.01e-14 ad=3.01e-14 ps=7.1e-07 pd=7.1e-07 nrd=1.16667 \
        nrs=1.16667 sa=1.4e-07 sb=1.4e-07 sd=160n sca=35.8476 \
        scb=0.0407387 scc=0.00396292 m=(1)
PM1 (\17\:qbint \3\:n35g \1\:ExtVDD ExtVDD) g45p1svt w=(2.15e-07) \
        l=4.5e-08 nf=1 as=3.3457e-13 ad=3.01e-14 ps=3.53e-06 pd=7.1e-07 \
        nrd=1.16667 nrs=1.16667 sa=1.4e-07 sb=8.7e-07 sd=160n sca=25.3956 \
        scb=0.0259635 scc=0.00265434 m=(1)
PM2 (net205 \4\:qbint \1\:ExtVDD ExtVDD) g45p1svt w=(2.15e-07) l=4.5e-08 \
        nf=1 as=3.3457e-13 ad=1.29e-14 ps=3.53e-06 pd=5.5e-07 nrd=1.16667 \
        nrs=1.16667 sa=7.65e-07 sb=2.45e-07 sd=160n sca=14.6455 \
        scb=0.014432 scc=0.000486925 m=(1)
mp45 (\6\:RTb \8\:RT \1\:ExtVDD ExtVDD) g45p1svt w=(2.15e-07) l=4.5e-08 \
        nf=1 as=3.3457e-13 ad=3.01e-14 ps=3.53e-06 pd=7.1e-07 nrd=1.16667 \
        nrs=1.16667 sa=3.1e-07 sb=1.4e-07 sd=160n sca=34.1371 \
        scb=0.0394413 scc=0.00358201 m=(1)
mp53 (\15\:n35 \14\:CKNb net082 VDD) g45p1svt w=(2.15e-07) l=4.5e-08 nf=1 \
        as=1.29e-14 ad=3.01e-14 ps=5.5e-07 pd=7.1e-07 nrd=1.16667 \
        nrs=1.16667 sa=1.4e-07 sb=2.45e-07 sd=160n sca=28.3325 \
        scb=0.0311878 scc=0.00281308 m=(1)
mp52 (net082 \13\:qbint \10\:VDD VDD) g45p1svt w=(2.15e-07) l=4.5e-08 \
        nf=1 as=3.01e-14 ad=1.29e-14 ps=7.1e-07 pd=5.5e-07 nrd=1.16667 \
        nrs=1.16667 sa=2.45e-07 sb=1.4e-07 sd=160n sca=17.2921 \
        scb=0.0195483 scc=0.000645631 m=(1)
C1 (Q VSS) capacitor c=6.2133e-17
C2 (CKN VSS) capacitor c=8.80989e-17
C3 (ExtVDD VSS) capacitor c=1.37567e-16
C4 (RT VSS) capacitor c=1.65563e-17
C5 (D VSS) capacitor c=2.50696e-17
C6 (QN VSS) capacitor c=4.04773e-17
C7 (VDD VSS) capacitor c=4.61783e-16
C8 (CKNb VSS) capacitor c=2.30065e-17
C9 (n20 VSS) capacitor c=4.57422e-17
C10 (CKNbb VSS) capacitor c=4.96062e-17
C11 (mout VSS) capacitor c=5.67774e-17
C12 (n35 VSS) capacitor c=1.47074e-16
C13 (n35g VSS) capacitor c=1.8069e-17
C14 (qbint VSS) capacitor c=4.78571e-17
C15 (RTb VSS) capacitor c=4.12189e-17
C16 (qint VSS) capacitor c=2.23934e-17
C17 (\7\:qbint VSS) capacitor c=5.00484e-17
C18 (\11\:qbint VSS) capacitor c=4.65259e-17
C19 (\13\:qbint VSS) capacitor c=1.41e-16
C20 (\3\:qint VSS) capacitor c=5.94767e-17
C21 (\14\:CKNb VSS) capacitor c=8.74031e-17
C22 (\4\:RTb VSS) capacitor c=9.90131e-17
C23 (\8\:RT VSS) capacitor c=2.27152e-17
C24 (\4\:qbint VSS) capacitor c=6.89943e-17
C25 (\3\:n35g VSS) capacitor c=5.04019e-17
C26 (\6\:RT VSS) capacitor c=7.7981e-17
C27 (\8\:CKNbb VSS) capacitor c=3.01385e-17
C28 (\4\:CKN VSS) capacitor c=3.15859e-17
C29 (\3\:n20 VSS) capacitor c=5.79291e-17
C30 (\7\:CKNb VSS) capacitor c=3.05949e-17
C31 (\6\:CKNbb VSS) capacitor c=9.49006e-17
C32 (\4\:CKNb VSS) capacitor c=1.2935e-16
C33 (\4\:D VSS) capacitor c=6.93436e-17
C34 (\6\:qbint VSS) capacitor c=3.72637e-17
C35 (\12\:qbint VSS) capacitor c=4.67968e-17
C36 (\14\:qbint VSS) capacitor c=9.13916e-17
C37 (\4\:qint VSS) capacitor c=3.78241e-17
C38 (\3\:CKNbb VSS) capacitor c=3.42772e-16
C39 (\7\:RT VSS) capacitor c=1.66697e-16
C40 (\1\:RT VSS) capacitor c=4.50975e-17
C41 (\5\:qbint VSS) capacitor c=3.90657e-17
C42 (\5\:n35g VSS) capacitor c=2.84973e-17
C43 (\12\:CKNb VSS) capacitor c=3.16056e-17
C44 (\1\:CKN VSS) capacitor c=4.31631e-17
C45 (\6\:n20 VSS) capacitor c=5.17594e-17
C46 (\6\:CKNb VSS) capacitor c=2.93376e-17
C47 (\3\:mout VSS) capacitor c=4.9392e-17
C48 (\13\:CKNb VSS) capacitor c=5.01877e-17
C49 (\2\:CKNbb VSS) capacitor c=7.89708e-17
C50 (\1\:D VSS) capacitor c=4.75085e-17
C51 (\15\:CKNb VSS) capacitor c=5.6047e-17
C52 (\8\:CKNb VSS) capacitor c=1.28113e-16
C53 (\10\:qbint VSS) capacitor c=5.81261e-17
C54 (\3\:RT VSS) capacitor c=1.71066e-16
C55 (\3\:RTb VSS) capacitor c=7.34036e-17
C56 (\4\:RT VSS) capacitor c=4.31918e-17
C57 (\2\:RT VSS) capacitor c=3.90616e-17
C58 (\3\:qbint VSS) capacitor c=3.56347e-17
C59 (\2\:RTb VSS) capacitor c=4.0126e-17
C60 (\2\:n35 VSS) capacitor c=1.66052e-16
C61 (\4\:n35g VSS) capacitor c=6.77171e-17
C62 (\3\:n35 VSS) capacitor c=4.37673e-17
C63 (\3\:CKN VSS) capacitor c=2.63717e-17
C64 (\2\:mout VSS) capacitor c=3.87945e-17
C65 (\4\:mout VSS) capacitor c=4.04119e-17
C66 (\7\:CKNbb VSS) capacitor c=4.32797e-17
C67 (\5\:n20 VSS) capacitor c=4.33898e-17
C68 (\2\:n20 VSS) capacitor c=4.54609e-17
C69 (\5\:CKNb VSS) capacitor c=6.13327e-17
C70 (\11\:CKNb VSS) capacitor c=3.02463e-17
C71 (\3\:D VSS) capacitor c=1.71566e-17
C72 (\1\:VDD VSS) capacitor c=4.84825e-17
C73 (\3\:Q VSS) capacitor c=7.34497e-17
C74 (\9\:qint VSS) capacitor c=5.46199e-17
C75 (\10\:VDD VSS) capacitor c=2.50771e-17
C76 (\12\:VDD VSS) capacitor c=7.88033e-17
C77 (\4\:QN VSS) capacitor c=5.48475e-17
C78 (\15\:n35 VSS) capacitor c=4.34411e-17
C79 (\15\:n35g VSS) capacitor c=4.67481e-17
C80 (\6\:RTb VSS) capacitor c=5.91872e-17
C81 (\1\:ExtVDD VSS) capacitor c=2.90068e-16
C82 (\10\:n35 VSS) capacitor c=5.11023e-17
C83 (\17\:qbint VSS) capacitor c=6.74665e-17
C84 (\6\:n35g VSS) capacitor c=8.76785e-17
C85 (\4\:n35 VSS) capacitor c=4.01261e-17
C86 (\20\:CKNb VSS) capacitor c=6.52881e-17
C87 (\5\:mout VSS) capacitor c=5.94187e-17
C88 (\14\:VDD VSS) capacitor c=7.69789e-17
C89 (\16\:VDD VSS) capacitor c=5.98421e-17
C90 (\13\:CKNbb VSS) capacitor c=6.20229e-17
C91 (\13\:n20 VSS) capacitor c=4.60065e-17
C92 (\9\:n20 VSS) capacitor c=7.89484e-17
C93 (\18\:VDD VSS) capacitor c=4.35006e-17
C94 (\1\:Q VSS) capacitor c=5.48754e-17
C95 (\5\:qint VSS) capacitor c=4.6906e-17
C96 (\1\:QN VSS) capacitor c=3.97148e-17
C97 (\18\:n35 VSS) capacitor c=6.04282e-17
C98 (\11\:n35g VSS) capacitor c=2.95379e-17
C99 (\10\:RTb VSS) capacitor c=5.97429e-17
C100 (\13\:n35 VSS) capacitor c=5.58118e-17
C101 (\19\:qbint VSS) capacitor c=2.37156e-17
C102 (\9\:n35g VSS) capacitor c=7.65355e-17
C103 (\7\:n35 VSS) capacitor c=4.5014e-17
C104 (\22\:CKNb VSS) capacitor c=3.6593e-17
C105 (\10\:mout VSS) capacitor c=5.24511e-17
C106 (\9\:CKNbb VSS) capacitor c=3.74113e-17
C107 (\16\:n20 VSS) capacitor c=4.37333e-17
C108 (\7\:n20 VSS) capacitor c=8.21073e-17
C109 (\2\:D VSS) capacitor c=4.28148e-17
C110 (\2\:CKNb VSS) capacitor c=2.84516e-17
C111 (\3\:CKNb VSS) capacitor c=5.80879e-17
C112 (\4\:n20 VSS) capacitor c=4.72641e-17
C113 (\2\:CKN VSS) capacitor c=3.42924e-17
C114 (VDD VSS) capacitor c=2.59504e-16
C115 (\2\:n35g VSS) capacitor c=3.02547e-17
C116 (ExtVDD VSS) capacitor c=3.95682e-17
C117 (\2\:qbint VSS) capacitor c=4.11009e-17
C118 (\5\:RT VSS) capacitor c=5.37228e-17
C119 (\9\:CKNb VSS) capacitor c=1.09964e-16
C120 (\10\:CKNb VSS) capacitor c=4.22697e-17
C121 (\4\:CKNbb VSS) capacitor c=2.50166e-16
C122 (\5\:CKNbb VSS) capacitor c=4.20642e-17
C123 (\2\:qint VSS) capacitor c=1.77019e-17
C124 (\8\:qbint VSS) capacitor c=5.68707e-17
C125 (\9\:qbint VSS) capacitor c=1.32128e-16
C126 (\16\:CKNb VSS) capacitor c=9.75062e-17
C127 (\17\:CKNb VSS) capacitor c=8.61505e-17
C128 (\5\:D VSS) capacitor c=2.73232e-17
C129 (\11\:n20 VSS) capacitor c=4.55084e-17
C130 (\12\:n20 VSS) capacitor c=5.21744e-17
C131 (\15\:n20 VSS) capacitor c=5.26385e-17
C132 (\12\:CKNbb VSS) capacitor c=7.60755e-17
C133 (\15\:CKNbb VSS) capacitor c=4.53076e-17
C134 (\7\:mout VSS) capacitor c=4.30233e-17
C135 (\8\:mout VSS) capacitor c=2.73501e-17
C136 (\9\:mout VSS) capacitor c=2.48944e-17
C137 (\12\:mout VSS) capacitor c=2.42345e-17
C138 (\18\:CKNb VSS) capacitor c=5.11398e-17
C139 (\19\:CKNb VSS) capacitor c=4.19873e-17
C140 (\6\:n35 VSS) capacitor c=6.8782e-17
C141 (\9\:n35 VSS) capacitor c=6.21233e-17
C142 (\8\:n35g VSS) capacitor c=3.23398e-17
C143 (\12\:n35 VSS) capacitor c=6.03283e-17
C144 (\15\:qbint VSS) capacitor c=8.86788e-17
C145 (\16\:qbint VSS) capacitor c=1.11089e-16
C146 (\13\:n35g VSS) capacitor c=1.151e-16
C147 (\14\:n35g VSS) capacitor c=1.16642e-16
C148 (\9\:RT VSS) capacitor c=6.33172e-17
C149 (\10\:RT VSS) capacitor c=6.14274e-17
C150 (\5\:RTb VSS) capacitor c=3.69106e-17
C151 (\8\:RTb VSS) capacitor c=1.11059e-16
C152 (\9\:RTb VSS) capacitor c=6.96316e-17
C153 (\11\:RT VSS) capacitor c=2.78624e-17
C154 (\21\:qbint VSS) capacitor c=3.12118e-17
C155 (\22\:qbint VSS) capacitor c=3.08567e-17
C156 (\24\:CKNb VSS) capacitor c=1.08051e-16
C157 (\25\:CKNb VSS) capacitor c=9.79353e-17
C158 (\3\:QN VSS) capacitor c=3.46054e-17
C159 (\17\:n35 VSS) capacitor c=6.21189e-17
C160 (\7\:qint VSS) capacitor c=5.25499e-17
C161 (\8\:qint VSS) capacitor c=3.49781e-17
C162 (\4\:VDD VSS) capacitor c=2.33014e-17
C163 (\5\:VDD VSS) capacitor c=1.18281e-17
C164 (\6\:VDD VSS) capacitor c=8.66176e-17
C165 (\7\:VDD VSS) capacitor c=8.93964e-17
C166 (\9\:VDD VSS) capacitor c=3.19275e-17
Rk56 (\2\:Q Q) resistor r=0.1773 c=0
Rk57 (Q \4\:Q) resistor r=0.3077 c=0
Rk17 (\5\:CKN CKN) resistor r=0.01104 c=0
Rk30 (ExtVDD ExtVDD) resistor r=0.002057 c=0
Rk28 (\2\:ExtVDD ExtVDD) resistor r=0.0221 c=0
Rk31 (ExtVDD \5\:ExtVDD) resistor r=0.0201 c=0
Rk32 (ExtVDD \6\:ExtVDD) resistor r=0.1054 c=0
Rk33 (\7\:ExtVDD \8\:ExtVDD) resistor r=0.02871 c=0
Rk40 (\9\:RT \10\:RT) resistor r=0.4442 c=0
Rk45 (RT \11\:RT) resistor r=0.03113 c=0
Rk2 (D \5\:D) resistor r=0.02139 c=0
Rk49 (\3\:QN QN) resistor r=0.01774 c=0
Rk48 (\2\:QN \3\:QN) resistor r=0.2855 c=0
Rk50 (\3\:QN \5\:QN) resistor r=0.3227 c=0
Rk73 (\2\:VDD \4\:VDD) resistor r=0.5477 c=0
Rk74 (\4\:VDD \5\:VDD) resistor r=0.09133 c=0
Rk76 (\6\:VDD VDD) resistor r=0.8035 c=0
Rk75 (\5\:VDD \6\:VDD) resistor r=0.05156 c=0
Rk77 (VDD \7\:VDD) resistor r=0.7891 c=0
Rk83 (\9\:VDD VDD) resistor r=0.1806 c=0
Rk78 (\7\:VDD \9\:VDD) resistor r=0.05483 c=0
Rk79 (\5\:VDD \11\:VDD) resistor r=0.2895 c=0
Rk80 (\6\:VDD \13\:VDD) resistor r=0.3633 c=0
Rk81 (\7\:VDD \15\:VDD) resistor r=0.4005 c=0
Rk82 (\9\:VDD \17\:VDD) resistor r=0.3557 c=0
Rk84 (VDD \19\:VDD) resistor r=0.5144 c=0
Rk58 (\2\:VSS \3\:VSS) resistor r=0.04928 c=0
Rk59 (\3\:VSS \4\:VSS) resistor r=0.3335 c=0
Rk60 (\4\:VSS \5\:VSS) resistor r=0.309 c=0
Rk62 (\6\:VSS VSS) resistor r=0.1331 c=0
Rk61 (\5\:VSS \6\:VSS) resistor r=0.3609 c=0
Rk63 (VSS \7\:VSS) resistor r=0.07426 c=0
Rk64 (\7\:VSS \8\:VSS) resistor r=0.6182 c=0
Rk66 (\9\:VSS VSS) resistor r=0.02182 c=0
Rk65 (\8\:VSS \9\:VSS) resistor r=0.09627 c=0
Rk67 (VSS \11\:VSS) resistor r=0.5971 c=0
Rk68 (\3\:VSS \13\:VSS) resistor r=0.2598 c=0
Rk69 (\4\:VSS \15\:VSS) resistor r=0.2663 c=0
Rk70 (\6\:VSS \17\:VSS) resistor r=0.1887 c=0
Rk71 (\7\:VSS \19\:VSS) resistor r=0.1938 c=0
Rk72 (\9\:VSS \21\:VSS) resistor r=0.2399 c=0
Rk85 (\23\:VSS \24\:VSS) resistor r=0.3313 c=0
Rk86 (\24\:VSS \25\:VSS) resistor r=0.3609 c=0
Rk88 (\26\:VSS VSS) resistor r=0.1801 c=0
Rk87 (\25\:VSS \26\:VSS) resistor r=0.3139 c=0
Rk90 (\27\:VSS VSS) resistor r=0.1185 c=0
Rk89 (VSS \27\:VSS) resistor r=0.6928 c=0
Rk91 (VSS \29\:VSS) resistor r=0.3451 c=0
Rk92 (\24\:VSS \31\:VSS) resistor r=0.2342 c=0
Rk93 (\26\:VSS \33\:VSS) resistor r=0.3469 c=0
Rk1 (\16\:CKNb \17\:CKNb) resistor r=0.8336 c=0
Rk18 (\18\:CKNb \19\:CKNb) resistor r=0.2067 c=0
Rk19 (\19\:CKNb \21\:CKNb) resistor r=0.3164 c=0
Rk20 (\19\:CKNb \23\:CKNb) resistor r=0.1956 c=0
Rk47 (\24\:CKNb \25\:CKNb) resistor r=0.8444 c=0
Rk3 (\8\:n20 \10\:n20) resistor r=0.4919 c=0
Rk4 (\10\:n20 \11\:n20) resistor r=0.3148 c=0
Rk5 (\12\:n20 \14\:n20) resistor r=0.2757 c=0
Rk6 (\14\:n20 \15\:n20) resistor r=0.2392 c=0
Rk7 (\12\:n20 \17\:n20) resistor r=0.2333 c=0
Rk8 (\10\:CKNbb \11\:CKNbb) resistor r=0.198 c=0
Rk9 (\11\:CKNbb \12\:CKNbb) resistor r=0.02343 c=0
Rk10 (\11\:CKNbb \14\:CKNbb) resistor r=0.3348 c=0
Rk11 (\14\:CKNbb \15\:CKNbb) resistor r=0.2718 c=0
Rk12 (\6\:mout \7\:mout) resistor r=0.3049 c=0
Rk13 (\7\:mout \8\:mout) resistor r=0.1492 c=0
Rk14 (\8\:mout \9\:mout) resistor r=0.1241 c=0
Rk15 (\7\:mout \11\:mout) resistor r=0.2733 c=0
Rk16 (\8\:mout \12\:mout) resistor r=0.1307 c=0
Rk21 (\5\:n35 \6\:n35) resistor r=0.2864 c=0
Rk22 (\6\:n35 \8\:n35) resistor r=0.272 c=0
Rk23 (\6\:n35 \9\:n35) resistor r=0.567 c=0
Rk26 (\11\:n35 \12\:n35) resistor r=0.2719 c=0
Rk27 (\12\:n35 \14\:n35) resistor r=0.3269 c=0
Rk51 (\16\:n35 \17\:n35) resistor r=0.17 c=0
Rk52 (\17\:n35 \19\:n35) resistor r=0.4264 c=0
Rk24 (\7\:n35g \8\:n35g) resistor r=0.2289 c=0
Rk25 (\7\:n35g \10\:n35g) resistor r=0.6049 c=0
Rk37 (\12\:n35g \13\:n35g) resistor r=0.2424 c=0
Rk38 (\13\:n35g \14\:n35g) resistor r=0.5641 c=0
Rk39 (\13\:n35g \16\:n35g) resistor r=0.4309 c=0
Rk34 (\15\:qbint \16\:qbint) resistor r=0.4933 c=0
Rk35 (\16\:qbint \18\:qbint) resistor r=0.5658 c=0
Rk36 (\16\:qbint \20\:qbint) resistor r=0.1459 c=0
Rk46 (\21\:qbint \22\:qbint) resistor r=0.2113 c=0
Rk41 (\5\:RTb \7\:RTb) resistor r=0.226 c=0
Rk42 (\7\:RTb \8\:RTb) resistor r=0.2727 c=0
Rk43 (\8\:RTb \9\:RTb) resistor r=0.669 c=0
Rk44 (\8\:RTb \11\:RTb) resistor r=0.3325 c=0
Rk53 (\6\:qint \7\:qint) resistor r=0.2593 c=0
Rk54 (\7\:qint \8\:qint) resistor r=0.1618 c=0
Rk55 (\7\:qint \10\:qint) resistor r=0.2815 c=0
Rl19 (\2\:CKN \4\:CKN) resistor r=59.3295 c=0
Rl17 (\1\:CKN \2\:CKN) resistor r=151.637 c=0
Rl18 (\2\:CKN \3\:CKN) resistor r=2.0166 c=0
Rl34 (\3\:RT \7\:RT) resistor r=709.9 c=0
Rl31 (\3\:RT \4\:RT) resistor r=72.2057 c=0
Rl25 (\1\:RT \2\:RT) resistor r=125.877 c=0
Rl35 (\5\:RT \8\:RT) resistor r=30.9873 c=0
Rl33 (\5\:RT \6\:RT) resistor r=273.765 c=0
Rl32 (\4\:RT \5\:RT) resistor r=78.204 c=0
Rl3 (\2\:D \4\:D) resistor r=130.483 c=0
Rl1 (\1\:D \2\:D) resistor r=80.4834 c=0
Rl2 (\2\:D \3\:D) resistor r=5.1123 c=0
Rl43 (\14\:CKNb \15\:CKNb) resistor r=115.79 c=0
Rl11 (\4\:CKNb \5\:CKNb) resistor r=246.721 c=0
Rl12 (\2\:CKNb \6\:CKNb) resistor r=73.8796 c=0
Rl8 (CKNb \2\:CKNb) resistor r=0.6084 c=0
Rl13 (\3\:CKNb \7\:CKNb) resistor r=64.6458 c=0
Rl10 (\3\:CKNb \4\:CKNb) resistor r=208.713 c=0
Rl9 (\2\:CKNb \3\:CKNb) resistor r=64.0061 c=0
Rl39 (\9\:CKNb \12\:CKNb) resistor r=64.1356 c=0
Rl36 (\8\:CKNb \9\:CKNb) resistor r=862.964 c=0
Rl40 (\10\:CKNb \13\:CKNb) resistor r=64.1356 c=0
Rl38 (\10\:CKNb \11\:CKNb) resistor r=113.909 c=0
Rl37 (\9\:CKNb \10\:CKNb) resistor r=172.374 c=0
Rl4 (n20 \2\:n20) resistor r=112.885 c=0
Rl14 (\3\:n20 \4\:n20) resistor r=103.572 c=0
Rl16 (\4\:n20 \6\:n20) resistor r=96.5354 c=0
Rl15 (\4\:n20 \5\:n20) resistor r=121.254 c=0
Rl5 (CKNbb \2\:CKNbb) resistor r=157.453 c=0
Rl44 (\3\:CKNbb \4\:CKNbb) resistor r=1441.22 c=0
Rl47 (\4\:CKNbb \7\:CKNbb) resistor r=140.831 c=0
Rl48 (\5\:CKNbb \8\:CKNbb) resistor r=66.684 c=0
Rl46 (\5\:CKNbb \6\:CKNbb) resistor r=229.379 c=0
Rl45 (\4\:CKNbb \5\:CKNbb) resistor r=112.483 c=0
Rl6 (mout \2\:mout) resistor r=24.2328 c=0
Rl7 (\3\:mout \4\:mout) resistor r=24.2328 c=0
Rl41 (n35 \2\:n35) resistor r=499.328 c=0
Rl42 (\2\:n35 \3\:n35) resistor r=104.689 c=0
Rl22 (\3\:n35g \4\:n35g) resistor r=241.174 c=0
Rl21 (\2\:n35g \3\:n35g) resistor r=181.74 c=0
Rl23 (\2\:n35g \5\:n35g) resistor r=94.1963 c=0
Rl20 (n35g \2\:n35g) resistor r=2.4834 c=0
Rl52 (\6\:qbint \7\:qbint) resistor r=149.805 c=0
Rl57 (\11\:qbint \12\:qbint) resistor r=195.609 c=0
Rl59 (\13\:qbint \14\:qbint) resistor r=235.906 c=0
Rl30 (\3\:qbint \5\:qbint) resistor r=35.3072 c=0
Rl29 (\2\:qbint \4\:qbint) resistor r=148.502 c=0
Rl27 (qbint \2\:qbint) resistor r=112.732 c=0
Rl28 (\2\:qbint \3\:qbint) resistor r=74.1915 c=0
Rl53 (\7\:qbint \8\:qbint) resistor r=203.519 c=0
Rl56 (\8\:qbint \11\:qbint) resistor r=92.0202 c=0
Rl58 (\9\:qbint \13\:qbint) resistor r=355.65 c=0
Rl55 (\9\:qbint \10\:qbint) resistor r=244.214 c=0
Rl54 (\8\:qbint \9\:qbint) resistor r=221.574 c=0
Rl26 (\3\:RTb \4\:RTb) resistor r=242.199 c=0
Rl24 (RTb \2\:RTb) resistor r=124.312 c=0
Rl50 (\2\:qint \3\:qint) resistor r=64.1263 c=0
Rl51 (\2\:qint \4\:qint) resistor r=73.7417 c=0
Rl49 (qint \2\:qint) resistor r=3.1216 c=0
Rz16 (\1\:Q \2\:Q) resistor r=37.5 c=0
Rz13 (\1\:QN \2\:QN) resistor r=37.5 c=0
Rz17 (\10\:VSS \11\:VSS) resistor r=75 c=0
Rz18 (\12\:VSS \13\:VSS) resistor r=37.5 c=0
Rz19 (\14\:VSS \15\:VSS) resistor r=37.5 c=0
Rz20 (\16\:VSS \17\:VSS) resistor r=75 c=0
Rz21 (\18\:VSS \19\:VSS) resistor r=75 c=0
Rz22 (\20\:VSS \21\:VSS) resistor r=75 c=0
Rz25 (\28\:VSS \29\:VSS) resistor r=75 c=0
Rz26 (\30\:VSS \31\:VSS) resistor r=75 c=0
Rz27 (\32\:VSS \33\:VSS) resistor r=75 c=0
Rz5 (\22\:CKNb \23\:CKNb) resistor r=75 c=0
Rz1 (\7\:n20 \8\:n20) resistor r=75 c=0
Rz2 (\16\:n20 \17\:n20) resistor r=75 c=0
Rz3 (\9\:CKNbb \10\:CKNbb) resistor r=75 c=0
Rz4 (\10\:mout \11\:mout) resistor r=75 c=0
Rz6 (\7\:n35 \8\:n35) resistor r=75 c=0
Rz8 (\13\:n35 \14\:n35) resistor r=75 c=0
Rz14 (\18\:n35 \19\:n35) resistor r=75 c=0
Rz7 (\9\:n35g \10\:n35g) resistor r=75 c=0
Rz11 (\11\:n35g \12\:n35g) resistor r=75 c=0
Rz10 (\19\:qbint \20\:qbint) resistor r=75 c=0
Rz12 (\10\:RTb \11\:RTb) resistor r=75 c=0
Rz15 (\5\:qint \6\:qint) resistor r=75 c=0
Ry20 (\3\:Q \4\:Q) resistor r=20.6667 c=0
Ry9 (\1\:ExtVDD \2\:ExtVDD) resistor r=62 c=0
Ry10 (\1\:ExtVDD \5\:ExtVDD) resistor r=62 c=0
Ry11 (\1\:ExtVDD \6\:ExtVDD) resistor r=62 c=0
Ry12 (\1\:ExtVDD \7\:ExtVDD) resistor r=62 c=0
Ry13 (\1\:ExtVDD \8\:ExtVDD) resistor r=62 c=0
Ry17 (\4\:QN \5\:QN) resistor r=20.6667 c=0
Ry24 (\1\:VDD \2\:VDD) resistor r=20.6667 c=0
Ry25 (\10\:VDD \11\:VDD) resistor r=62 c=0
Ry26 (\12\:VDD \13\:VDD) resistor r=20.6667 c=0
Ry27 (\14\:VDD \15\:VDD) resistor r=62 c=0
Ry28 (\16\:VDD \17\:VDD) resistor r=62 c=0
Ry29 (\18\:VDD \19\:VDD) resistor r=62 c=0
Ry21 (\1\:VSS \2\:VSS) resistor r=31 c=0
Ry22 (\1\:VSS \5\:VSS) resistor r=5.1667 c=0
Ry23 (\1\:VSS \8\:VSS) resistor r=5.1667 c=0
Ry30 (\22\:VSS \23\:VSS) resistor r=31 c=0
Ry31 (\22\:VSS \25\:VSS) resistor r=5.1667 c=0
Ry32 (\22\:VSS \27\:VSS) resistor r=5.1667 c=0
Ry5 (\20\:CKNb \21\:CKNb) resistor r=62 c=0
Ry1 (\9\:n20 \10\:n20) resistor r=62 c=0
Ry2 (\13\:n20 \14\:n20) resistor r=62 c=0
Ry3 (\13\:CKNbb \14\:CKNbb) resistor r=62 c=0
Ry4 (\5\:mout \6\:mout) resistor r=62 c=0
Ry6 (\4\:n35 \5\:n35) resistor r=62 c=0
Ry8 (\10\:n35 \11\:n35) resistor r=62 c=0
Ry18 (\15\:n35 \16\:n35) resistor r=62 c=0
Ry7 (\6\:n35g \7\:n35g) resistor r=62 c=0
Ry15 (\15\:n35g \16\:n35g) resistor r=62 c=0
Ry14 (\17\:qbint \18\:qbint) resistor r=62 c=0
Ry16 (\6\:RTb \7\:RTb) resistor r=62 c=0
Ry19 (\9\:qint \10\:qint) resistor r=62 c=0
Rx11 (\3\:CKN \5\:CKN) resistor r=45 c=0
Rx18 (\4\:RT \9\:RT) resistor r=45 c=0
Rx19 (\2\:RT \10\:RT) resistor r=45 c=0
Rx22 (\3\:RT \11\:RT) resistor r=45 c=0
Rx3 (\3\:D \5\:D) resistor r=45 c=0
Rx1 (\5\:CKNb \16\:CKNb) resistor r=45 c=0
Rx2 (\11\:CKNb \17\:CKNb) resistor r=45 c=0
Rx12 (CKNb \18\:CKNb) resistor r=45 c=0
Rx25 (\15\:CKNb \24\:CKNb) resistor r=45 c=0
Rx26 (\8\:CKNb \25\:CKNb) resistor r=45 c=0
Rx4 (\2\:n20 \11\:n20) resistor r=45 c=0
Rx5 (\5\:n20 \12\:n20) resistor r=45 c=0
Rx6 (n20 \15\:n20) resistor r=45 c=0
Rx7 (CKNbb \12\:CKNbb) resistor r=45 c=0
Rx8 (\7\:CKNbb \15\:CKNbb) resistor r=45 c=0
Rx9 (\4\:mout \9\:mout) resistor r=45 c=0
Rx10 (\2\:mout \12\:mout) resistor r=45 c=0
Rx13 (\3\:n35 \9\:n35) resistor r=45 c=0
Rx15 (\2\:n35 \12\:n35) resistor r=45 c=0
Rx27 (n35 \17\:n35) resistor r=45 c=0
Rx14 (\4\:n35g \8\:n35g) resistor r=45 c=0
Rx17 (n35g \14\:n35g) resistor r=45 c=0
Rx16 (\3\:qbint \15\:qbint) resistor r=45 c=0
Rx23 (\10\:qbint \21\:qbint) resistor r=45 c=0
Rx24 (qbint \22\:qbint) resistor r=45 c=0
Rx20 (\3\:RTb \5\:RTb) resistor r=45 c=0
Rx21 (\2\:RTb \9\:RTb) resistor r=45 c=0
Rx28 (qint \8\:qint) resistor r=45 c=0
mn56 (\5\:qint \12\:qbint \14\:VSS VSS) g45n1svt w=(1.45e-07) l=4.5e-08 \
        nf=1 as=2.03e-14 ad=4.365e-14 ps=5.7e-07 pd=9e-07 nrd=1.16667 \
        nrs=1.16667 sa=3.75e-07 sb=1.4e-07 sd=160n sca=9.16682 \
        scb=0.00760686 scc=0.000164708 m=(1)
mn21 (\9\:CKNbb \6\:CKNb \20\:VSS VSS) g45n1svt w=(1.45e-07) l=4.5e-08 \
        nf=1 as=2.32e-14 ad=2.03e-14 ps=6.1e-07 pd=5.7e-07 nrd=1.16667 \
        nrs=1.16667 sa=1.4e-07 sb=3.45e-07 sd=160n sca=8.0352 \
        scb=0.00565402 scc=8.19771e-05 m=(1)
mn35 (n30 \3\:mout \28\:VSS VSS) g45n1svt w=(1.45e-07) l=4.5e-08 nf=1 \
        as=2.32e-14 ad=8.7e-15 ps=6.1e-07 pd=4.1e-07 nrd=1.16667 \
        nrs=1.16667 sa=2.45e-07 sb=5.5e-07 sd=160n sca=11.1906 \
        scb=0.0108717 scc=0.000387468 m=(1)
mn20 (\22\:CKNb \1\:CKN \20\:VSS VSS) g45n1svt w=(1.45e-07) l=4.5e-08 \
        nf=1 as=2.03e-14 ad=2.32e-14 ps=5.7e-07 pd=6.1e-07 nrd=1.16667 \
        nrs=1.16667 sa=3.45e-07 sb=1.4e-07 sd=160n sca=8.0352 \
        scb=0.00565402 scc=8.19771e-05 m=(1)
mn32 (\10\:mout \6\:n20 \28\:VSS VSS) g45n1svt w=(1.45e-07) l=4.5e-08 \
        nf=1 as=2.32e-14 ad=2.32e-14 ps=6.1e-07 pd=6.1e-07 nrd=1.16667 \
        nrs=1.16667 sa=4.5e-07 sb=3.45e-07 sd=160n sca=11.1906 \
        scb=0.0108717 scc=0.000387468 m=(1)
mn26 (\7\:n20 \2\:CKNbb n21 VSS) g45n1svt w=(1.45e-07) l=4.5e-08 nf=1 \
        as=8.7e-15 ad=2.03e-14 ps=4.1e-07 pd=5.7e-07 nrd=1.16667 \
        nrs=1.16667 sa=1.4e-07 sb=2.45e-07 sd=160n sca=8.0352 \
        scb=0.00565402 scc=8.19771e-05 m=(1)
mn25 (n21 \1\:D \10\:VSS VSS) g45n1svt w=(1.45e-07) l=4.5e-08 nf=1 \
        as=2.03e-14 ad=8.7e-15 ps=5.7e-07 pd=4.1e-07 nrd=1.16667 \
        nrs=1.16667 sa=1.4e-07 sb=2.45e-07 sd=160n sca=8.0352 \
        scb=0.00565402 scc=8.19771e-05 m=(1)
mn40 (\7\:n35 \12\:CKNb \10\:mout VSS) g45n1svt w=(1.45e-07) l=4.5e-08 \
        nf=1 as=2.03e-14 ad=2.32e-14 ps=5.7e-07 pd=6.1e-07 nrd=1.16667 \
        nrs=1.16667 sa=6.55e-07 sb=1.4e-07 sd=160n sca=11.1906 \
        scb=0.0108717 scc=0.000387468 m=(1)
mn36 (\16\:n20 \13\:CKNb n30 VSS) g45n1svt w=(1.45e-07) l=4.5e-08 nf=1 \
        as=8.7e-15 ad=2.03e-14 ps=4.1e-07 pd=5.7e-07 nrd=1.16667 \
        nrs=1.16667 sa=1.4e-07 sb=6.55e-07 sd=160n sca=11.1906 \
        scb=0.0108717 scc=0.000387468 m=(1)
NM0 (\9\:n35g RTb \13\:n35 VSS) g45n1svt w=(1.45e-07) l=4.5e-08 nf=1 \
        as=2.03e-14 ad=2.03e-14 ps=5.7e-07 pd=5.7e-07 nrd=1.16667 \
        nrs=1.16667 sa=1.4e-07 sb=1.4e-07 sd=160n sca=6.59604 \
        scb=0.00318587 scc=2.16275e-05 m=(1)
NM1 (\19\:qbint \5\:n35g \18\:VSS VSS) g45n1svt w=(1.45e-07) l=4.5e-08 \
        nf=1 as=2.03e-14 ad=2.03e-14 ps=5.7e-07 pd=5.7e-07 nrd=1.16667 \
        nrs=1.16667 sa=1.4e-07 sb=1.4e-07 sd=160n sca=9.33388 \
        scb=0.00788941 scc=0.00017958 m=(1)
NM3 (net0121 \5\:qbint \16\:VSS VSS) g45n1svt w=(1.45e-07) l=4.5e-08 \
        nf=1 as=2.03e-14 ad=8.7e-15 ps=5.7e-07 pd=4.1e-07 nrd=1.16667 \
        nrs=1.16667 sa=1.4e-07 sb=2.45e-07 sd=160n sca=9.33388 \
        scb=0.00788941 scc=0.00017958 m=(1)
mn45 (\10\:RTb \1\:RT \32\:VSS VSS) g45n1svt w=(1.45e-07) l=4.5e-08 nf=1 \
        as=2.03e-14 ad=2.03e-14 ps=5.7e-07 pd=5.7e-07 nrd=1.16667 \
        nrs=1.16667 sa=1.4e-07 sb=1.4e-07 sd=160n sca=6.59604 \
        scb=0.00318587 scc=2.16275e-05 m=(1)
NM2 (\11\:n35g \7\:RT net0121 VSS) g45n1svt w=(1.45e-07) l=4.5e-08 nf=1 \
        as=8.7e-15 ad=2.03e-14 ps=4.1e-07 pd=5.7e-07 nrd=1.16667 \
        nrs=1.16667 sa=2.45e-07 sb=1.4e-07 sd=160n sca=9.33388 \
        scb=0.00788941 scc=0.00017958 m=(1)
mn53 (\18\:n35 \3\:CKNbb net095 VSS) g45n1svt w=(1.45e-07) l=4.5e-08 nf=1 \
        as=8.7e-15 ad=2.03e-14 ps=4.1e-07 pd=5.7e-07 nrd=1.16667 \
        nrs=1.16667 sa=1.4e-07 sb=2.45e-07 sd=160n sca=8.42104 \
        scb=0.00632542 scc=0.000106623 m=(1)
mn52 (net095 \14\:qbint \30\:VSS VSS) g45n1svt w=(1.45e-07) l=4.5e-08 \
        nf=1 as=2.03e-14 ad=8.7e-15 ps=5.7e-07 pd=4.1e-07 nrd=1.16667 \
        nrs=1.16667 sa=2.45e-07 sb=1.4e-07 sd=160n sca=8.42104 \
        scb=0.00632542 scc=0.000106623 m=(1)
mn57 (\1\:QN \4\:qint \14\:VSS VSS) g45n1svt w=(2.6e-07) l=4.5e-08 nf=1 \
        as=4.365e-14 ad=3.64e-14 ps=9e-07 pd=8e-07 nrd=1.16667 nrs=1.16667 \
        sa=1.4e-07 sb=2.71058e-07 sd=160n sca=9.69565 scb=0.00844644 \
        scc=0.000275168 m=(1)
mn55 (\1\:Q \6\:qbint \12\:VSS VSS) g45n1svt w=(2.6e-07) l=4.5e-08 nf=1 \
        as=3.64e-14 ad=3.64e-14 ps=8e-07 pd=8e-07 nrd=1.16667 nrs=1.16667 \
        sa=1.4e-07 sb=1.4e-07 sd=160n sca=9.50447 scb=0.0081528 \
        scc=0.00025289 m=(1)
mp57 (\4\:QN \3\:qint \12\:VDD VDD) g45p1svt w=(3.9e-07) l=4.5e-08 nf=1 \
        as=6.535e-14 ad=5.46e-14 ps=1.16e-06 pd=1.06e-06 nrd=1.16667 \
        nrs=1.16667 sa=1.4e-07 sb=2.69551e-07 sd=160n sca=36.1939 \
        scb=0.0388948 scc=0.0042388 m=(1)
mp55 (\3\:Q \7\:qbint \1\:VDD VDD) g45p1svt w=(3.9e-07) l=4.5e-08 nf=1 \
        as=5.46e-14 ad=5.46e-14 ps=1.06e-06 pd=1.06e-06 nrd=1.16667 \
        nrs=1.16667 sa=1.4e-07 sb=1.4e-07 sd=160n sca=20.1248 \
        scb=0.0190515 scc=0.00152507 m=(1)
ends RDFFNX1
// End of subcircuit definition.
