// Generated for: spectre (May  1 08:11:37 2013 )
// Library name: gsclib045
// Cell name: ISOLX1_OFF
// View name: extracted

simulator lang=spectre

subckt ISOLX1_OFF A ExtVDD ISO VSS Y
mp0 (\8\:n0 \1\:A \13\:ExtVDD ExtVDD) g45p1svt w=(2.15e-07) l=4.5e-08 \
        nf=1 as=3.01e-14 ad=3.44e-14 ps=7.1e-07 pd=7.5e-07 nrd=1.16667 \
        nrs=1.16667 sa=1.4e-07 sb=3.45e-07 sd=160n sca=25.7248 \
        scb=0.0268097 scc=0.00266528 m=(1)
mp1 (\8\:n0 ison \11\:ExtVDD ExtVDD) g45p1svt w=(2.15e-07) l=4.5e-08 \
        nf=1 as=3.01e-14 ad=3.44e-14 ps=7.1e-07 pd=7.5e-07 nrd=1.16667 \
        nrs=1.16667 sa=3.45e-07 sb=1.4e-07 sd=160n sca=10.9495 \
        scb=0.00875135 scc=0.000103322 m=(1)
PM1 (\6\:ison \1\:ISO \4\:ExtVDD ExtVDD) g45p1svt w=(2.15e-07) l=4.5e-08 \
        nf=1 as=3.01e-14 ad=3.01e-14 ps=7.1e-07 pd=7.1e-07 nrd=1.16667 \
        nrs=1.16667 sa=1.4e-07 sb=1.4e-07 sd=160n sca=34.3421 \
        scb=0.0288746 scc=0.00402373 m=(1)
C1 (VDD VSS) capacitor c=1.51725e-16
C2 (ISO VSS) capacitor c=3.25325e-17
C3 (ExtVDD VSS) capacitor c=3.36432e-16
C4 (Y VSS) capacitor c=4.27296e-17
C5 (A VSS) capacitor c=2.00356e-17
C6 (n0 VSS) capacitor c=2.81513e-17
C7 (ison VSS) capacitor c=2.27577e-17
C8 (\3\:n0 VSS) capacitor c=5.33544e-17
C9 (\1\:ISO VSS) capacitor c=3.40571e-17
C10 (\1\:A VSS) capacitor c=4.40155e-17
C11 (\3\:ISO VSS) capacitor c=2.7928e-17
C12 (\3\:ison VSS) capacitor c=8.26254e-17
C13 (\3\:A VSS) capacitor c=6.76645e-17
C14 (\2\:n0 VSS) capacitor c=3.10718e-17
C15 (\1\:ExtVDD VSS) capacitor c=4.16664e-17
C16 (\2\:ExtVDD VSS) capacitor c=1.88595e-17
C17 (\2\:ISO VSS) capacitor c=3.40369e-17
C18 (\4\:ison VSS) capacitor c=9.25967e-17
C19 (\2\:A VSS) capacitor c=6.03849e-17
C20 (\1\:Y VSS) capacitor c=5.63057e-17
C21 (\7\:ExtVDD VSS) capacitor c=4.69883e-17
C22 (\4\:ExtVDD VSS) capacitor c=5.65434e-17
C23 (\11\:ExtVDD VSS) capacitor c=7.75936e-17
C24 (\6\:ison VSS) capacitor c=6.02309e-17
C25 (\8\:n0 VSS) capacitor c=7.40458e-17
C26 (\13\:ExtVDD VSS) capacitor c=7.26491e-17
C27 (\3\:Y VSS) capacitor c=5.5997e-17
C28 (\8\:ison VSS) capacitor c=5.9703e-17
C29 (\6\:n0 VSS) capacitor c=3.49846e-17
C30 (VDD VSS) capacitor c=1.72226e-16
C31 (\2\:ison VSS) capacitor c=9.14429e-17
C32 (\5\:A VSS) capacitor c=1.53619e-17
C33 (\7\:A VSS) capacitor c=3.39962e-17
C34 (\5\:ison VSS) capacitor c=3.67376e-17
C35 (\4\:ISO VSS) capacitor c=3.08268e-17
C36 (\6\:ISO VSS) capacitor c=6.59797e-18
C37 (\3\:ExtVDD VSS) capacitor c=2.17511e-17
C38 (\6\:ExtVDD VSS) capacitor c=1.6366e-17
C39 (\4\:n0 VSS) capacitor c=8.11442e-17
C40 (\5\:n0 VSS) capacitor c=1.24558e-16
Rk35 (VDD VDD) resistor r=0.1722 c=0
Rk32 (VSS VSS) resistor r=0.0291 c=0
Rk27 (VSS VSS) resistor r=0.0291 c=0
Rk26 (\3\:VSS VSS) resistor r=0.1232 c=0
Rk25 (\2\:VSS \3\:VSS) resistor r=0.429 c=0
Rk28 (VSS \4\:VSS) resistor r=0.09723 c=0
Rk29 (\4\:VSS \6\:VSS) resistor r=0.3005 c=0
Rk30 (\3\:VSS \8\:VSS) resistor r=0.226 c=0
Rk31 (\10\:VSS VSS) resistor r=0.5526 c=0
Rk33 (VSS \11\:VSS) resistor r=0.09783 c=0
Rk34 (\11\:VSS \13\:VSS) resistor r=0.2859 c=0
Rk8 (\4\:ISO \5\:ISO) resistor r=0.002341 c=0
Rk9 (ISO \6\:ISO) resistor r=0.002341 c=0
Rk10 (\4\:ISO \6\:ISO) resistor r=0.01479 c=0
Rk11 (\7\:ISO ISO) resistor r=0.002341 c=0
Rk12 (\6\:ISO \7\:ISO) resistor r=0.03273 c=0
Rk16 (ExtVDD ExtVDD) resistor r=0.002425 c=0
Rk13 (\3\:ExtVDD \5\:ExtVDD) resistor r=0.3844 c=0
Rk15 (\8\:ExtVDD ExtVDD) resistor r=0.4363 c=0
Rk14 (\6\:ExtVDD \8\:ExtVDD) resistor r=0.2264 c=0
Rk18 (ExtVDD \12\:ExtVDD) resistor r=0.4354 c=0
Rk19 (\12\:ExtVDD \14\:ExtVDD) resistor r=0.6236 c=0
Rk23 (Y \2\:Y) resistor r=0.287 c=0
Rk24 (Y \4\:Y) resistor r=0.3398 c=0
Rk1 (\4\:A A) resistor r=0.002039 c=0
Rk2 (A \5\:A) resistor r=0.002039 c=0
Rk3 (\4\:A \5\:A) resistor r=0.02546 c=0
Rk5 (\5\:A \7\:A) resistor r=0.06401 c=0
Rk4 (\6\:A \7\:A) resistor r=0.002039 c=0
Rk20 (\4\:n0 \5\:n0) resistor r=0.5573 c=0
Rk21 (\5\:n0 \7\:n0) resistor r=0.3547 c=0
Rk22 (\5\:n0 \9\:n0) resistor r=0.4006 c=0
Rk6 (\5\:ison \7\:ison) resistor r=0.3022 c=0
Rk7 (\7\:ison \9\:ison) resistor r=0.4318 c=0
Rl3 (\1\:ISO \2\:ISO) resistor r=75.732 c=0
Rl4 (\2\:ISO \3\:ISO) resistor r=65.5047 c=0
Rl8 (\1\:ExtVDD \2\:ExtVDD) resistor r=200.144 c=0
Rl1 (\1\:A \2\:A) resistor r=83.2141 c=0
Rl2 (\2\:A \3\:A) resistor r=149.653 c=0
Rl10 (\2\:n0 \3\:n0) resistor r=133.743 c=0
Rl9 (n0 \2\:n0) resistor r=45.3288 c=0
Rl5 (ison \2\:ison) resistor r=30.9873 c=0
Rl6 (\2\:ison \3\:ison) resistor r=233.274 c=0
Rl7 (\2\:ison \4\:ison) resistor r=458.123 c=0
Rz5 (\5\:VSS \6\:VSS) resistor r=75 c=0
Rz6 (\7\:VSS \8\:VSS) resistor r=37.5 c=0
Rz7 (\12\:VSS \13\:VSS) resistor r=75 c=0
Rz4 (\3\:Y \4\:Y) resistor r=37.5 c=0
Rz3 (\6\:n0 \7\:n0) resistor r=75 c=0
Rz1 (\8\:ison \9\:ison) resistor r=75 c=0
Ry8 (\1\:VSS \2\:VSS) resistor r=31 c=0
Ry9 (\1\:VSS \4\:VSS) resistor r=5.1667 c=0
Ry10 (\9\:VSS \10\:VSS) resistor r=31 c=0
Ry11 (\9\:VSS \11\:VSS) resistor r=5.1667 c=0
Ry2 (\4\:ExtVDD \5\:ExtVDD) resistor r=62 c=0
Ry3 (\7\:ExtVDD \8\:ExtVDD) resistor r=20.6667 c=0
Ry4 (\11\:ExtVDD \12\:ExtVDD) resistor r=62 c=0
Ry5 (\13\:ExtVDD \14\:ExtVDD) resistor r=62 c=0
Ry7 (\1\:Y \2\:Y) resistor r=20.6667 c=0
Ry6 (\8\:n0 \9\:n0) resistor r=62 c=0
Ry1 (\6\:ison \7\:ison) resistor r=62 c=0
Rx3 (\2\:ISO \5\:ISO) resistor r=45 c=0
Rx4 (\2\:ExtVDD \3\:ExtVDD) resistor r=45 c=0
Rx5 (\1\:ExtVDD \6\:ExtVDD) resistor r=45 c=0
Rx1 (\2\:A \6\:A) resistor r=45 c=0
Rx6 (\2\:n0 \4\:n0) resistor r=45 c=0
Rx2 (\4\:ison \5\:ison) resistor r=45 c=0
NM1 (\12\:VSS \3\:ISO \8\:ison VSS) g45n1svt w=(1.45e-07) l=4.5e-08 nf=1 \
        as=2.03e-14 ad=2.03e-14 ps=5.7e-07 pd=5.7e-07 nrd=1.16667 \
        nrs=1.16667 sa=1.4e-07 sb=1.4e-07 sd=160n sca=8.55924 \
        scb=0.0065649 scc=0.000116351 m=(1)
mn0 (net127 \3\:ison \5\:VSS VSS) g45n1svt w=(1.45e-07) l=4.5e-08 nf=1 \
        as=2.03e-14 ad=8.7e-15 ps=5.7e-07 pd=4.1e-07 nrd=1.16667 \
        nrs=1.16667 sa=2.45e-07 sb=1.4e-07 sd=160n sca=10.0732 \
        scb=0.00911402 scc=0.000253284 m=(1)
mn1 (\6\:n0 \3\:A net127 VSS) g45n1svt w=(1.45e-07) l=4.5e-08 nf=1 \
        as=8.7e-15 ad=2.03e-14 ps=4.1e-07 pd=5.7e-07 nrd=1.16667 \
        nrs=1.16667 sa=1.4e-07 sb=2.45e-07 sd=160n sca=10.0732 \
        scb=0.00911402 scc=0.000253284 m=(1)
mn2 (\3\:Y n0 \7\:VSS VSS) g45n1svt w=(2.6e-07) l=4.5e-08 nf=1 \
        as=3.64e-14 ad=3.64e-14 ps=8e-07 pd=8e-07 nrd=1.16667 nrs=1.16667 \
        sa=1.4e-07 sb=1.4e-07 sd=160n sca=12.1772 scb=0.0118935 \
        scc=0.000630577 m=(1)
mp2 (\1\:Y \3\:n0 \7\:ExtVDD ExtVDD) g45p1svt w=(3.9e-07) l=4.5e-08 nf=1 \
        as=5.46e-14 ad=5.46e-14 ps=1.06e-06 pd=1.06e-06 nrd=1.16667 \
        nrs=1.16667 sa=1.4e-07 sb=1.4e-07 sd=160n sca=25.7882 \
        scb=0.0272171 scc=0.00268607 m=(1)
ends ISOLX1_OFF
// End of subcircuit definition.
