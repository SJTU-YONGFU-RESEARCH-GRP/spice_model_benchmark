// Generated for: spectre (May  1 08:14:31 2013 )
// Library name: gsclib045
// Cell name: SMDFFHQX8
// View name: extracted

simulator lang=spectre

subckt SMDFFHQX8 CK D0 D1 Q S0 SE SI VDD VSS
mp55_1__rcx (Q qbint \10\:VDD VDD) g45p1svt w=(4.45e-07) l=4.5e-08 nf=1 \
        as=7.073e-14 ad=6.993e-14 ps=1.21e-06 pd=1.20429e-06 nrd=1.16667 \
        nrs=1.16667 sa=1.4e-07 sb=1.90404e-06 sd=160n sca=40.5428 \
        scb=0.0363846 scc=0.00414682 m=(7)
C1 (D0 VSS) capacitor c=6.32161e-17
C2 (CK VSS) capacitor c=7.72213e-17
C3 (S0 VSS) capacitor c=3.18976e-17
C4 (VDD VSS) capacitor c=4.0766e-16
C5 (SE VSS) capacitor c=7.1894e-17
C6 (D1 VSS) capacitor c=1.35393e-16
C7 (Q VSS) capacitor c=5.07427e-16
C8 (SI VSS) capacitor c=4.04237e-17
C9 (qbint VSS) capacitor c=3.74074e-16
C10 (n30 VSS) capacitor c=2.10781e-16
C11 (CKb VSS) capacitor c=4.55519e-17
C12 (net482 VSS) capacitor c=2.62936e-18
C13 (mout VSS) capacitor c=5.93788e-17
C14 (CKbb VSS) capacitor c=2.40475e-17
C15 (n20 VSS) capacitor c=3.75426e-17
C16 (net474 VSS) capacitor c=1.38453e-18
C17 (dbp VSS) capacitor c=6.02402e-17
C18 (net490 VSS) capacitor c=2.07039e-18
C19 (db VSS) capacitor c=1.05645e-16
C20 (SEb VSS) capacitor c=7.24514e-17
C21 (net498 VSS) capacitor c=5.7093e-18
C22 (S0b VSS) capacitor c=3.59515e-17
C23 (net409 VSS) capacitor c=2.7333e-18
C24 (net393 VSS) capacitor c=2.33668e-18
C25 (net417 VSS) capacitor c=2.23037e-18
C26 (net425 VSS) capacitor c=2.05099e-18
C27 (net429 VSS) capacitor c=6.74141e-18
C28 (\7\:S0 VSS) capacitor c=3.80017e-17
C29 (\1\:D1 VSS) capacitor c=4.6473e-17
C30 (\2\:S0 VSS) capacitor c=7.05875e-17
C31 (\4\:D0 VSS) capacitor c=9.07195e-17
C32 (\1\:SE VSS) capacitor c=5.79959e-17
C33 (\6\:SE VSS) capacitor c=3.1443e-17
C34 (\1\:SI VSS) capacitor c=9.19536e-17
C35 (\5\:CKb VSS) capacitor c=7.45847e-17
C36 (\7\:CKbb VSS) capacitor c=3.88523e-17
C37 (\8\:CKb VSS) capacitor c=4.89494e-17
C38 (\3\:CKb VSS) capacitor c=2.46469e-17
C39 (\3\:CKbb VSS) capacitor c=7.62758e-17
C40 (\22\:qbint VSS) capacitor c=4.68773e-17
C41 (\1\:CK VSS) capacitor c=3.26e-17
C42 (\5\:S0 VSS) capacitor c=2.39046e-17
C43 (\3\:D1 VSS) capacitor c=7.21087e-17
C44 (\3\:S0 VSS) capacitor c=7.12869e-17
C45 (\3\:S0b VSS) capacitor c=6.53354e-17
C46 (\1\:D0 VSS) capacitor c=5.53797e-17
C47 (\5\:SE VSS) capacitor c=4.18538e-17
C48 (\3\:SEb VSS) capacitor c=3.42111e-17
C49 (\4\:SE VSS) capacitor c=9.61221e-17
C50 (\4\:SI VSS) capacitor c=8.26922e-17
C51 (\10\:CKb VSS) capacitor c=3.75498e-17
C52 (\11\:CKb VSS) capacitor c=2.41108e-17
C53 (\5\:CKbb VSS) capacitor c=5.92285e-17
C54 (\4\:mout VSS) capacitor c=5.5934e-17
C55 (\3\:n20 VSS) capacitor c=3.86277e-17
C56 (\24\:qbint VSS) capacitor c=5.26567e-17
C57 (\3\:CK VSS) capacitor c=3.11001e-17
C58 (\6\:S0 VSS) capacitor c=2.67833e-17
C59 (\2\:D1 VSS) capacitor c=4.07816e-17
C60 (\4\:S0 VSS) capacitor c=4.33603e-17
C61 (\2\:S0b VSS) capacitor c=5.0605e-17
C62 (\1\:S0 VSS) capacitor c=4.79561e-17
C63 (\3\:D0 VSS) capacitor c=4.1277e-17
C64 (\2\:SE VSS) capacitor c=7.50678e-17
C65 (\4\:SEb VSS) capacitor c=3.96051e-17
C66 (\2\:SEb VSS) capacitor c=5.38415e-17
C67 (\3\:SI VSS) capacitor c=3.95314e-17
C68 (\8\:CKbb VSS) capacitor c=3.73913e-17
C69 (\9\:CKb VSS) capacitor c=2.83488e-17
C70 (\6\:CKbb VSS) capacitor c=4.48179e-17
C71 (\3\:mout VSS) capacitor c=2.01376e-17
C72 (\2\:n20 VSS) capacitor c=2.95901e-17
C73 (\4\:CKbb VSS) capacitor c=2.17637e-17
C74 (\4\:CKb VSS) capacitor c=3.85449e-17
C75 (\2\:CKb VSS) capacitor c=4.19488e-17
C76 (\23\:qbint VSS) capacitor c=4.36797e-17
C77 (\2\:CK VSS) capacitor c=2.94965e-17
C78 (\6\:S0b VSS) capacitor c=9.53129e-17
C79 (\16\:VDD VSS) capacitor c=3.30869e-17
C80 (\6\:db VSS) capacitor c=5.38448e-17
C81 (\18\:VDD VSS) capacitor c=4.00611e-17
C82 (\5\:SEb VSS) capacitor c=9.22151e-17
C83 (\4\:db VSS) capacitor c=1.48807e-16
C84 (\20\:VDD VSS) capacitor c=4.43531e-17
C85 (\14\:CKbb VSS) capacitor c=9.74292e-17
C86 (\4\:dbp VSS) capacitor c=1.01235e-16
C87 (\4\:n20 VSS) capacitor c=6.26358e-17
C88 (\22\:VDD VSS) capacitor c=3.45653e-17
C89 (\5\:mout VSS) capacitor c=4.41662e-17
C90 (\14\:n30 VSS) capacitor c=1.08217e-16
C91 (\24\:VDD VSS) capacitor c=2.61992e-17
C92 (\18\:CKb VSS) capacitor c=1.11618e-16
C93 (\26\:qbint VSS) capacitor c=3.8183e-16
C94 (\1\:VDD VSS) capacitor c=7.52202e-17
C95 (\4\:S0b VSS) capacitor c=5.09675e-17
C96 (\10\:SEb VSS) capacitor c=1.16359e-16
C97 (\8\:db VSS) capacitor c=9.84624e-17
C98 (\6\:dbp VSS) capacitor c=7.18962e-17
C99 (\16\:CKbb VSS) capacitor c=5.12026e-17
C100 (\8\:dbp VSS) capacitor c=8.30085e-17
C101 (\8\:n20 VSS) capacitor c=6.45148e-17
C102 (\8\:mout VSS) capacitor c=4.87884e-17
C103 (\12\:n30 VSS) capacitor c=2.05844e-16
C104 (\15\:CKb VSS) capacitor c=1.51409e-16
C105 (\2\:CKbb VSS) capacitor c=3.86426e-17
C106 (\2\:mout VSS) capacitor c=2.98058e-17
C107 (\6\:CKb VSS) capacitor c=7.05896e-17
C108 (\7\:CKb VSS) capacitor c=5.36359e-17
C109 (\2\:SI VSS) capacitor c=3.83364e-17
C110 (\3\:SE VSS) capacitor c=7.3403e-17
C111 (\2\:D0 VSS) capacitor c=3.38681e-17
C112 (\4\:CK VSS) capacitor c=4.25043e-17
C113 (\25\:qbint VSS) capacitor c=1.27201e-16
C114 (\37\:qbint VSS) capacitor c=2.76634e-17
C115 (\11\:n30 VSS) capacitor c=1.61592e-16
C116 (\7\:mout VSS) capacitor c=6.07742e-17
C117 (\10\:mout VSS) capacitor c=7.36739e-17
C118 (\12\:CKb VSS) capacitor c=1.05321e-16
C119 (\13\:CKb VSS) capacitor c=1.22774e-16
C120 (\14\:CKb VSS) capacitor c=1.6454e-16
C121 (\17\:CKb VSS) capacitor c=6.79525e-17
C122 (\6\:n20 VSS) capacitor c=7.21789e-17
C123 (\7\:n20 VSS) capacitor c=8.36345e-17
C124 (\9\:CKbb VSS) capacitor c=1.29727e-16
C125 (\10\:CKbb VSS) capacitor c=1.45384e-16
C126 (\11\:CKbb VSS) capacitor c=4.56218e-17
C127 (\12\:CKbb VSS) capacitor c=7.67373e-17
C128 (\13\:CKbb VSS) capacitor c=1.49908e-16
C129 (\5\:SI VSS) capacitor c=6.04573e-17
C130 (\3\:dbp VSS) capacitor c=1.03688e-16
C131 (\7\:SE VSS) capacitor c=6.90341e-17
C132 (\7\:SEb VSS) capacitor c=9.49232e-17
C133 (\8\:SEb VSS) capacitor c=3.60134e-17
C134 (\9\:SEb VSS) capacitor c=7.94308e-17
C135 (\5\:D0 VSS) capacitor c=6.97205e-17
C136 (\3\:db VSS) capacitor c=1.28021e-16
C137 (\8\:S0 VSS) capacitor c=6.99848e-17
C138 (\9\:S0 VSS) capacitor c=5.17391e-17
C139 (\10\:S0 VSS) capacitor c=6.39258e-17
C140 (\8\:S0b VSS) capacitor c=1.02357e-16
C141 (\3\:VDD VSS) capacitor c=1.62917e-17
C142 (\4\:VDD VSS) capacitor c=3.14641e-17
C143 (\6\:VDD VSS) capacitor c=4.61088e-17
C144 (\7\:VDD VSS) capacitor c=3.66299e-17
C145 (\9\:VDD VSS) capacitor c=2.75625e-17
C146 (\10\:VDD VSS) capacitor c=5.19606e-16
Rk49 (D0 \5\:D0) resistor r=0.1475 c=0
Rk11 (\4\:CK CK) resistor r=0.1658 c=0
Rk55 (\8\:S0 S0) resistor r=0.2785 c=0
Rk56 (S0 \9\:S0) resistor r=0.02672 c=0
Rk57 (\9\:S0 \10\:S0) resistor r=0.3875 c=0
Rk84 (\2\:VSS \3\:VSS) resistor r=0.1051 c=0
Rk85 (\3\:VSS \4\:VSS) resistor r=0.3984 c=0
Rk86 (\4\:VSS \5\:VSS) resistor r=0.2982 c=0
Rk87 (\5\:VSS \6\:VSS) resistor r=0.2757 c=0
Rk88 (\6\:VSS \7\:VSS) resistor r=0.5965 c=0
Rk89 (\7\:VSS \8\:VSS) resistor r=0.3308 c=0
Rk90 (\8\:VSS \9\:VSS) resistor r=0.3083 c=0
Rk97 (\10\:VSS VSS) resistor r=0.1074 c=0
Rk91 (\9\:VSS \10\:VSS) resistor r=0.5162 c=0
Rk98 (\3\:VSS \17\:VSS) resistor r=0.3045 c=0
Rk99 (\4\:VSS \19\:VSS) resistor r=0.2317 c=0
Rk100 (\6\:VSS \21\:VSS) resistor r=0.2555 c=0
Rk101 (\7\:VSS \23\:VSS) resistor r=0.201 c=0
Rk102 (\9\:VSS \25\:VSS) resistor r=0.1026 c=0
Rk60 (\2\:VDD \3\:VDD) resistor r=0.1051 c=0
Rk61 (\3\:VDD \4\:VDD) resistor r=0.4059 c=0
Rk62 (\4\:VDD \5\:VDD) resistor r=0.2907 c=0
Rk63 (\5\:VDD \6\:VDD) resistor r=0.2757 c=0
Rk64 (\6\:VDD \7\:VDD) resistor r=0.6516 c=0
Rk65 (\7\:VDD \8\:VDD) resistor r=0.2757 c=0
Rk66 (\8\:VDD \9\:VDD) resistor r=0.2957 c=0
Rk73 (\10\:VDD VDD) resistor r=0.1074 c=0
Rk67 (\9\:VDD \10\:VDD) resistor r=0.5288 c=0
Rk74 (\3\:VDD \17\:VDD) resistor r=0.2243 c=0
Rk75 (\4\:VDD \19\:VDD) resistor r=0.2273 c=0
Rk76 (\6\:VDD \21\:VDD) resistor r=0.2365 c=0
Rk77 (\7\:VDD \23\:VDD) resistor r=0.1862 c=0
Rk78 (\9\:VDD \25\:VDD) resistor r=0.2042 c=0
Rk44 (SE \7\:SE) resistor r=0.1249 c=0
Rk54 (\4\:D1 D1) resistor r=0.004469 c=0
Rk39 (SI \5\:SI) resistor r=0.1413 c=0
Rk12 (\25\:qbint \26\:qbint) resistor r=0.9606 c=0
Rk19 (\26\:qbint \37\:qbint) resistor r=0.166 c=0
Rk20 (\11\:n30 \13\:n30) resistor r=1.2746 c=0
Rk21 (\13\:n30 \15\:n30) resistor r=0.4567 c=0
Rk25 (\12\:CKb \13\:CKb) resistor r=0.7396 c=0
Rk26 (\13\:CKb \14\:CKb) resistor r=0.673 c=0
Rk27 (\14\:CKb \16\:CKb) resistor r=0.6287 c=0
Rk28 (\13\:CKb \17\:CKb) resistor r=0.2825 c=0
Rk29 (\16\:CKb \19\:CKb) resistor r=0.6911 c=0
Rk22 (\6\:mout \7\:mout) resistor r=0.2446 c=0
Rk23 (\7\:mout \9\:mout) resistor r=0.1294 c=0
Rk24 (\7\:mout \10\:mout) resistor r=0.3113 c=0
Rk33 (\9\:CKbb \10\:CKbb) resistor r=1.0082 c=0
Rk34 (\10\:CKbb \11\:CKbb) resistor r=0.1502 c=0
Rk35 (\10\:CKbb \12\:CKbb) resistor r=0.365 c=0
Rk36 (\12\:CKbb \13\:CKbb) resistor r=0.3089 c=0
Rk37 (\13\:CKbb \15\:CKbb) resistor r=0.6631 c=0
Rk38 (\12\:CKbb \17\:CKbb) resistor r=0.2756 c=0
Rk30 (\5\:n20 \6\:n20) resistor r=0.1756 c=0
Rk31 (\6\:n20 \7\:n20) resistor r=0.4455 c=0
Rk32 (\6\:n20 \9\:n20) resistor r=0.2541 c=0
Rk40 (\2\:dbp \3\:dbp) resistor r=0.251 c=0
Rk41 (\3\:dbp \5\:dbp) resistor r=0.3815 c=0
Rk42 (\3\:dbp \7\:dbp) resistor r=0.5281 c=0
Rk43 (\5\:dbp \9\:dbp) resistor r=0.4601 c=0
Rk50 (\2\:db \3\:db) resistor r=0.7389 c=0
Rk51 (\3\:db \5\:db) resistor r=0.4683 c=0
Rk52 (\3\:db \7\:db) resistor r=0.2421 c=0
Rk53 (\5\:db \9\:db) resistor r=0.5095 c=0
Rk45 (\6\:SEb \7\:SEb) resistor r=0.6453 c=0
Rk46 (\7\:SEb \8\:SEb) resistor r=0.1632 c=0
Rk47 (\7\:SEb \9\:SEb) resistor r=0.1202 c=0
Rk48 (\9\:SEb \11\:SEb) resistor r=0.7546 c=0
Rk58 (\5\:S0b \7\:S0b) resistor r=0.4812 c=0
Rk59 (\7\:S0b \8\:S0b) resistor r=0.645 c=0
Rl64 (\2\:D0 \4\:D0) resistor r=47.3105 c=0
Rl62 (\1\:D0 \2\:D0) resistor r=115.43 c=0
Rl63 (\2\:D0 \3\:D0) resistor r=58.0656 c=0
Rl30 (\1\:CK \2\:CK) resistor r=73.0769 c=0
Rl31 (\2\:CK \3\:CK) resistor r=29.9451 c=0
Rl72 (\6\:S0 \7\:S0) resistor r=106.868 c=0
Rl71 (\5\:S0 \6\:S0) resistor r=40.3846 c=0
Rl68 (\3\:S0 \4\:S0) resistor r=24.2328 c=0
Rl65 (\1\:S0 \2\:S0) resistor r=33.3481 c=0
Rl57 (\1\:SE \2\:SE) resistor r=146.875 c=0
Rl60 (\2\:SE \5\:SE) resistor r=171.875 c=0
Rl61 (\3\:SE \6\:SE) resistor r=30.4507 c=0
Rl59 (\3\:SE \4\:SE) resistor r=164.928 c=0
Rl58 (\2\:SE \3\:SE) resistor r=145.182 c=0
Rl69 (\1\:D1 \2\:D1) resistor r=56.461 c=0
Rl70 (\2\:D1 \3\:D1) resistor r=87.2302 c=0
Rl52 (\1\:SI \2\:SI) resistor r=55.0028 c=0
Rl54 (\2\:SI \4\:SI) resistor r=93.4643 c=0
Rl53 (\2\:SI \3\:SI) resistor r=62.3759 c=0
Rl32 (\23\:qbint \22\:qbint) resistor r=46.131 c=0
Rl33 (\23\:qbint \24\:qbint) resistor r=57.4874 c=0
Rl49 (\8\:CKb \9\:CKb) resistor r=24.2328 c=0
Rl35 (\3\:CKb \4\:CKb) resistor r=24.2328 c=0
Rl34 (CKb \2\:CKb) resistor r=24.2328 c=0
Rl46 (\5\:CKb \6\:CKb) resistor r=216.555 c=0
Rl50 (\6\:CKb \10\:CKb) resistor r=123.055 c=0
Rl48 (\7\:CKb \8\:CKb) resistor r=136.082 c=0
Rl51 (\7\:CKb \11\:CKb) resistor r=30.4507 c=0
Rl47 (\6\:CKb \7\:CKb) resistor r=163.852 c=0
Rl41 (mout \2\:mout) resistor r=84.3295 c=0
Rl43 (\2\:mout \4\:mout) resistor r=34.3295 c=0
Rl42 (\2\:mout \3\:mout) resistor r=4.3144 c=0
Rl45 (\7\:CKbb \8\:CKbb) resistor r=24.2328 c=0
Rl44 (\5\:CKbb \6\:CKbb) resistor r=24.2328 c=0
Rl37 (\2\:CKbb \3\:CKbb) resistor r=141.851 c=0
Rl36 (CKbb \2\:CKbb) resistor r=22.7584 c=0
Rl38 (\2\:CKbb \4\:CKbb) resistor r=71.5433 c=0
Rl39 (n20 \2\:n20) resistor r=29.5379 c=0
Rl40 (\2\:n20 \3\:n20) resistor r=71.8456 c=0
Rl56 (\3\:SEb \4\:SEb) resistor r=46.8456 c=0
Rl55 (SEb \2\:SEb) resistor r=29.5379 c=0
Rl66 (S0b \2\:S0b) resistor r=25.6167 c=0
Rl67 (\2\:S0b \3\:S0b) resistor r=121.55 c=0
Rz22 (\17\:VSS \16\:VSS) resistor r=75 c=0
Rz23 (\19\:VSS \18\:VSS) resistor r=75 c=0
Rz24 (\21\:VSS \20\:VSS) resistor r=75 c=0
Rz25 (\23\:VSS \22\:VSS) resistor r=75 c=0
Rz26 (\25\:VSS \24\:VSS) resistor r=75 c=0
Rz18 (\2\:VDD \1\:VDD) resistor r=18.75 c=0
Rz19 (\5\:VDD \1\:VDD) resistor r=6.25 c=0
Rz20 (\8\:VDD \1\:VDD) resistor r=6.25 c=0
Rz21 (\10\:VDD \1\:VDD) resistor r=6.25 c=0
Rz7 (\13\:n30 \12\:n30) resistor r=75 c=0
Rz9 (\15\:CKb \16\:CKb) resistor r=75 c=0
Rz8 (\8\:mout \9\:mout) resistor r=75 c=0
Rz11 (\16\:CKbb \17\:CKbb) resistor r=75 c=0
Rz10 (\8\:n20 \9\:n20) resistor r=75 c=0
Rz12 (\6\:dbp \7\:dbp) resistor r=75 c=0
Rz13 (\8\:dbp \9\:dbp) resistor r=75 c=0
Rz15 (db \2\:db) resistor r=75 c=0
Rz16 (\8\:db \9\:db) resistor r=75 c=0
Rz14 (\10\:SEb \11\:SEb) resistor r=75 c=0
Rz17 (\4\:S0b \5\:S0b) resistor r=75 c=0
Ry28 (\2\:VSS \1\:VSS) resistor r=15.5 c=0
Ry29 (\5\:VSS \1\:VSS) resistor r=5.1667 c=0
Ry30 (\8\:VSS \1\:VSS) resistor r=5.1667 c=0
Ry31 (\10\:VSS \1\:VSS) resistor r=5.1667 c=0
Ry18 (\17\:VDD \16\:VDD) resistor r=62 c=0
Ry19 (\19\:VDD \18\:VDD) resistor r=62 c=0
Ry20 (\21\:VDD \20\:VDD) resistor r=62 c=0
Ry21 (\23\:VDD \22\:VDD) resistor r=62 c=0
Ry22 (\25\:VDD \24\:VDD) resistor r=62 c=0
Ry7 (\15\:n30 \14\:n30) resistor r=62 c=0
Ry9 (\18\:CKb \19\:CKb) resistor r=62 c=0
Ry8 (\5\:mout \6\:mout) resistor r=62 c=0
Ry11 (\14\:CKbb \15\:CKbb) resistor r=62 c=0
Ry10 (\4\:n20 \5\:n20) resistor r=31 c=0
Ry12 (dbp \2\:dbp) resistor r=31 c=0
Ry13 (\4\:dbp \5\:dbp) resistor r=62 c=0
Ry15 (\4\:db \5\:db) resistor r=62 c=0
Ry16 (\6\:db \7\:db) resistor r=31 c=0
Ry14 (\5\:SEb \6\:SEb) resistor r=62 c=0
Ry17 (\6\:S0b \7\:S0b) resistor r=62 c=0
Rx17 (\3\:D0 \5\:D0) resistor r=45 c=0
Rx1 (\2\:CK \4\:CK) resistor r=45 c=0
Rx19 (\1\:S0 \8\:S0) resistor r=45 c=0
Rx20 (\4\:S0 \9\:S0) resistor r=45 c=0
Rx21 (\6\:S0 \10\:S0) resistor r=45 c=0
Rx14 (\2\:SE \7\:SE) resistor r=45 c=0
Rx18 (\2\:D1 \4\:D1) resistor r=45 c=0
Rx13 (\3\:SI \5\:SI) resistor r=45 c=0
Rx2 (\25\:qbint \23\:qbint) resistor r=45 c=0
Rx3 (\37\:qbint qbint) resistor r=45 c=0
Rx4 (\11\:n30 n30) resistor r=45 c=0
Rx6 (\9\:CKb \12\:CKb) resistor r=45 c=0
Rx7 (\2\:CKb \14\:CKb) resistor r=45 c=0
Rx8 (\4\:CKb \17\:CKb) resistor r=45 c=0
Rx5 (\3\:mout \10\:mout) resistor r=45 c=0
Rx10 (\4\:CKbb \9\:CKbb) resistor r=45 c=0
Rx11 (\6\:CKbb \11\:CKbb) resistor r=45 c=0
Rx12 (\8\:CKbb \13\:CKbb) resistor r=45 c=0
Rx9 (\2\:n20 \7\:n20) resistor r=45 c=0
Rx15 (\2\:SEb \8\:SEb) resistor r=45 c=0
Rx16 (\4\:SEb \9\:SEb) resistor r=45 c=0
Rx22 (\2\:S0b \8\:S0b) resistor r=45 c=0
mn55_1__rcx (Q qbint \10\:VSS VSS) g45n1svt w=(2.95e-07) l=4.5e-08 nf=1 \
        as=4.69e-14 ad=4.636e-14 ps=9.1e-07 pd=9.0429e-07 nrd=1.16667 \
        nrs=1.16667 sa=1.4e-07 sb=1.92051e-06 sd=160n sca=16.4223 \
        scb=0.0158966 scc=0.0014413 m=(7)
mn12 (net490 \4\:SI \20\:VSS VSS) g45n1svt w=(2.6e-07) l=4.5e-08 nf=1 \
        as=3.47e-14 ad=1.56e-14 ps=8.4e-07 pd=6.4e-07 nrd=1.16667 \
        nrs=1.16667 sa=2.36635e-07 sb=6.25e-07 sd=160n sca=12.4994 \
        scb=0.0122912 scc=0.000683921 m=(1)
mn13 (\6\:dbp \4\:SE net490 VSS) g45n1svt w=(2.6e-07) l=4.5e-08 nf=1 \
        as=1.56e-14 ad=5.72e-14 ps=6.4e-07 pd=9.6e-07 nrd=1.16667 \
        nrs=1.16667 sa=3.41635e-07 sb=5.2e-07 sd=160n sca=12.4994 \
        scb=0.0122912 scc=0.000683921 m=(1)
mn11 (\8\:db \3\:SEb \6\:dbp VSS) g45n1svt w=(2.6e-07) l=4.5e-08 nf=1 \
        as=5.72e-14 ad=6.63e-14 ps=9.6e-07 pd=1.03e-06 nrd=1.16667 \
        nrs=1.16667 sa=6.06635e-07 sb=2.55e-07 sd=160n sca=12.4994 \
        scb=0.0122912 scc=0.000683921 m=(1)
mn1 (net498 \1\:D0 \18\:VSS VSS) g45n1svt w=(2.6e-07) l=4.5e-08 nf=1 \
        as=3.985e-14 ad=6.11e-14 ps=9e-07 pd=9.9e-07 nrd=1.16667 \
        nrs=1.16667 sa=2.56442e-07 sb=9.66058e-07 sd=160n sca=10.79 \
        scb=0.0100512 scc=0.000418069 m=(1)
mn2 (db \3\:S0b net498 VSS) g45n1svt w=(2.6e-07) l=4.5e-08 nf=1 \
        as=6.11e-14 ad=4.16e-14 ps=9.9e-07 pd=8.4e-07 nrd=1.16667 \
        nrs=1.16667 sa=5.36442e-07 sb=6.86058e-07 sd=160n sca=10.79 \
        scb=0.0100512 scc=0.000418069 m=(1)
mn4 (db \3\:S0 net510 VSS) g45n1svt w=(2.6e-07) l=4.5e-08 nf=1 \
        as=1.56e-14 ad=4.16e-14 ps=6.4e-07 pd=8.4e-07 nrd=1.16667 \
        nrs=1.16667 sa=7.41442e-07 sb=4.81058e-07 sd=160n sca=10.79 \
        scb=0.0100512 scc=0.000418069 m=(1)
mn3 (net510 \3\:D1 \16\:VSS VSS) g45n1svt w=(2.6e-07) l=4.5e-08 nf=1 \
        as=6.66e-14 ad=1.56e-14 ps=1.28e-06 pd=6.4e-07 nrd=1.16667 \
        nrs=1.16667 sa=8.46442e-07 sb=3.76058e-07 sd=160n sca=10.79 \
        scb=0.0100512 scc=0.000418069 m=(1)
mn45_1__rcx (\26\:qbint n30 \10\:VSS VSS) g45n1svt w=(2.6e-07) l=4.5e-08 \
        nf=1 as=4.797e-14 ad=4.723e-14 ps=9.0333e-07 pd=8.8333e-07 \
        nrd=1.16667 nrs=1.16667 sa=1.575e-06 sb=6.65e-07 sd=160n \
        sca=13.9783 scb=0.013979 scc=0.000942864 m=(3)
mn20 (\15\:CKb \3\:CK \24\:VSS VSS) g45n1svt w=(1.45e-07) l=4.5e-08 nf=1 \
        as=7.93e-14 ad=4.132e-14 ps=1.47e-06 pd=8.6e-07 nrd=1.16667 \
        nrs=1.16667 sa=2.85e-07 sb=2e-06 sd=160n sca=14.7993 scb=0.0157101 \
        scc=0.000964917 m=(1)
mn21 (\16\:CKbb \10\:CKb \20\:VSS VSS) g45n1svt w=(1.45e-07) l=4.5e-08 \
        nf=1 as=3.47e-14 ad=2.03e-14 ps=8.4e-07 pd=5.7e-07 nrd=1.16667 \
        nrs=1.16667 sa=1.4e-07 sb=8.3e-07 sd=160n sca=9.16682 \
        scb=0.00760686 scc=0.000164708 m=(1)
mn10 (\10\:SEb \5\:SE \18\:VSS VSS) g45n1svt w=(1.45e-07) l=4.5e-08 nf=1 \
        as=3.985e-14 ad=2.03e-14 ps=9e-07 pd=5.7e-07 nrd=1.16667 \
        nrs=1.16667 sa=1.4e-07 sb=1.11276e-06 sd=160n sca=8.85152 \
        scb=0.00706865 scc=0.000138481 m=(1)
mn0 (\4\:S0b \5\:S0 \16\:VSS VSS) g45n1svt w=(1.45e-07) l=4.5e-08 nf=1 \
        as=6.66e-14 ad=2.465e-14 ps=1.28e-06 pd=6.3e-07 nrd=1.16667 \
        nrs=1.16667 sa=1.21931e-06 sb=1.7e-07 sd=160n sca=12.9138 \
        scb=0.0133404 scc=0.000640143 m=(1)
mn50 (net482 \24\:qbint \24\:VSS VSS) g45n1svt w=(2.05e-07) l=4.5e-08 \
        nf=1 as=7.93e-14 ad=2.767e-14 ps=1.47e-06 pd=6.8e-07 nrd=1.16667 \
        nrs=1.16667 sa=4.3878e-07 sb=1.995e-06 sd=160n sca=13.0797 \
        scb=0.0132969 scc=0.000723565 m=(1)
mn51 (\12\:n30 CKb net482 VSS) g45n1svt w=(2.05e-07) l=4.5e-08 nf=1 \
        as=2.767e-14 ad=3.69e-14 ps=6.8e-07 pd=7.7e-07 nrd=1.16667 \
        nrs=1.16667 sa=6.1878e-07 sb=1.815e-06 sd=160n sca=13.0797 \
        scb=0.0132969 scc=0.000723565 m=(1)
mn40 (\8\:mout CKbb \12\:n30 VSS) g45n1svt w=(2.05e-07) l=4.5e-08 nf=1 \
        as=3.69e-14 ad=1.0455e-13 ps=7.7e-07 pd=1.43e-06 nrd=1.16667 \
        nrs=1.16667 sa=8.4378e-07 sb=1.59e-06 sd=160n sca=13.0797 \
        scb=0.0132969 scc=0.000723565 m=(1)
mn30 (\8\:mout \3\:n20 \22\:VSS VSS) g45n1svt w=(2.05e-07) l=4.5e-08 \
        nf=1 as=6.915e-14 ad=1.0455e-13 ps=1.18e-06 pd=1.43e-06 \
        nrd=1.16667 nrs=1.16667 sa=1.39878e-06 sb=1.035e-06 sd=160n \
        sca=13.0797 scb=0.0132969 scc=0.000723565 m=(1)
mn35 (net474 \4\:mout \22\:VSS VSS) g45n1svt w=(2.05e-07) l=4.5e-08 nf=1 \
        as=6.915e-14 ad=1.23e-14 ps=1.18e-06 pd=5.3e-07 nrd=1.16667 \
        nrs=1.16667 sa=1.71378e-06 sb=7.2e-07 sd=160n sca=13.0797 \
        scb=0.0132969 scc=0.000723565 m=(1)
mn36 (\8\:n20 \5\:CKbb net474 VSS) g45n1svt w=(2.05e-07) l=4.5e-08 nf=1 \
        as=1.23e-14 ad=5.227e-14 ps=5.3e-07 pd=9.2e-07 nrd=1.16667 \
        nrs=1.16667 sa=1.81878e-06 sb=6.15e-07 sd=160n sca=13.0797 \
        scb=0.0132969 scc=0.000723565 m=(1)
mn25 (\8\:dbp \11\:CKb \8\:n20 VSS) g45n1svt w=(2.05e-07) l=4.5e-08 nf=1 \
        as=5.227e-14 ad=6.457e-14 ps=9.2e-07 pd=1.04e-06 nrd=1.16667 \
        nrs=1.16667 sa=1.9561e-06 sb=3.15e-07 sd=160n sca=13.0797 \
        scb=0.0132969 scc=0.000723565 m=(1)
mp12 (net417 \1\:SI \20\:VDD VDD) g45p1svt w=(3.9e-07) l=4.5e-08 nf=1 \
        as=5.19e-14 ad=2.34e-14 ps=1.1e-06 pd=9e-07 nrd=1.16667 \
        nrs=1.16667 sa=2.35064e-07 sb=4.57692e-07 sd=160n sca=14.3987 \
        scb=0.0130081 scc=0.000814275 m=(1)
mp13 (dbp SEb net417 VDD) g45p1svt w=(3.9e-07) l=4.5e-08 nf=1 as=2.34e-14 \
        ad=6.24e-14 ps=9e-07 pd=1.1e-06 nrd=1.16667 nrs=1.16667 \
        sa=3.40064e-07 sb=3.52692e-07 sd=160n sca=14.3987 scb=0.0130081 \
        scc=0.000814275 m=(1)
mp11 (dbp \6\:SE \4\:db VDD) g45p1svt w=(3.9e-07) l=4.5e-08 nf=1 \
        as=5.76e-14 ad=6.24e-14 ps=1.29e-06 pd=1.1e-06 nrd=1.16667 \
        nrs=1.16667 sa=5.45064e-07 sb=1.47692e-07 sd=160n sca=14.3987 \
        scb=0.0130081 scc=0.000814275 m=(1)
mp1 (net425 \4\:D0 \18\:VDD VDD) g45p1svt w=(3.9e-07) l=4.5e-08 nf=1 \
        as=5.19e-14 ad=2.34e-14 ps=1.1e-06 pd=9e-07 nrd=1.16667 \
        nrs=1.16667 sa=2.27372e-07 sb=9.48974e-07 sd=160n sca=13.5671 \
        scb=0.012183 scc=0.000647513 m=(1)
mp2 (\6\:db \2\:S0 net425 VDD) g45p1svt w=(3.9e-07) l=4.5e-08 nf=1 \
        as=2.34e-14 ad=7.02e-14 ps=9e-07 pd=1.14e-06 nrd=1.16667 \
        nrs=1.16667 sa=3.32372e-07 sb=8.43974e-07 sd=160n sca=13.5671 \
        scb=0.012183 scc=0.000647513 m=(1)
mp4 (\6\:db S0b net429 VDD) g45p1svt w=(3.9e-07) l=4.5e-08 nf=1 \
        as=8.97e-14 ad=7.02e-14 ps=1.24e-06 pd=1.14e-06 nrd=1.16667 \
        nrs=1.16667 sa=5.57372e-07 sb=6.18974e-07 sd=160n sca=13.5671 \
        scb=0.012183 scc=0.000647513 m=(1)
mp3 (net429 \1\:D1 \16\:VDD VDD) g45p1svt w=(3.9e-07) l=4.5e-08 nf=1 \
        as=9.438e-14 ad=8.97e-14 ps=1.43e-06 pd=1.24e-06 nrd=1.16667 \
        nrs=1.16667 sa=8.32372e-07 sb=3.43974e-07 sd=160n sca=14.2873 \
        scb=0.012489 scc=0.000647666 m=(1)
mp45_1__rcx (\26\:qbint n30 \10\:VDD VDD) g45p1svt w=(3.9e-07) l=4.5e-08 \
        nf=1 as=6.423e-14 ad=5.98e-14 ps=1.13667e-06 pd=1.08667e-06 \
        nrd=1.16667 nrs=1.16667 sa=1.575e-06 sb=5.5e-07 sd=160n \
        sca=18.3796 scb=0.0159892 scc=0.00159615 m=(3)
mp20 (\18\:CKb \1\:CK \24\:VDD VDD) g45p1svt w=(2.15e-07) l=4.5e-08 nf=1 \
        as=8.745e-14 ad=3.01e-14 ps=1.46e-06 pd=7.1e-07 nrd=1.16667 \
        nrs=1.16667 sa=1.4e-07 sb=2e-06 sd=160n sca=33.2772 scb=0.0257934 \
        scc=0.00427133 m=(1)
mp21 (\14\:CKbb \5\:CKb \20\:VDD VDD) g45p1svt w=(2.15e-07) l=4.5e-08 \
        nf=1 as=5.19e-14 ad=3.01e-14 ps=1.1e-06 pd=7.1e-07 nrd=1.16667 \
        nrs=1.16667 sa=1.4e-07 sb=6.15e-07 sd=160n sca=10.3256 \
        scb=0.00769229 scc=9.29431e-05 m=(1)
mp10 (\5\:SEb \1\:SE \18\:VDD VDD) g45p1svt w=(2.15e-07) l=4.5e-08 nf=1 \
        as=5.19e-14 ad=2.71e-14 ps=1.1e-06 pd=7.1e-07 nrd=1.16667 \
        nrs=1.16667 sa=1.26047e-07 sb=1.01884e-06 sd=160n sca=10.2104 \
        scb=0.00747301 scc=8.05149e-05 m=(1)
mp0 (\6\:S0b \7\:S0 \16\:VDD VDD) g45p1svt w=(2.15e-07) l=4.5e-08 nf=1 \
        as=9.438e-14 ad=3.01e-14 ps=1.43e-06 pd=7.1e-07 nrd=1.16667 \
        nrs=1.16667 sa=1.11314e-06 sb=1.4e-07 sd=160n sca=21.7017 \
        scb=0.0235322 scc=0.00125657 m=(1)
mp50 (net409 \22\:qbint \24\:VDD VDD) g45p1svt w=(3.1e-07) l=4.5e-08 \
        nf=1 as=8.745e-14 ad=3.565e-14 ps=1.46e-06 pd=8.5e-07 nrd=1.16667 \
        nrs=1.16667 sa=3.32984e-07 sb=1.91e-06 sd=160n sca=26.7199 \
        scb=0.0211429 scc=0.00304348 m=(1)
mp51 (\14\:n30 \3\:CKbb net409 VDD) g45p1svt w=(3.1e-07) l=4.5e-08 nf=1 \
        as=3.565e-14 ad=7.44e-14 ps=8.5e-07 pd=1.1e-06 nrd=1.16667 \
        nrs=1.16667 sa=4.92984e-07 sb=1.75e-06 sd=160n sca=26.7199 \
        scb=0.0211429 scc=0.00304348 m=(1)
mp40 (\14\:n30 \3\:CKb \5\:mout VDD) g45p1svt w=(3.1e-07) l=4.5e-08 nf=1 \
        as=1.2865e-13 ad=7.44e-14 ps=1.45e-06 pd=1.1e-06 nrd=1.16667 \
        nrs=1.16667 sa=7.77984e-07 sb=1.465e-06 sd=160n sca=26.7199 \
        scb=0.0211429 scc=0.00304348 m=(1)
mp30 (\5\:mout n20 \22\:VDD VDD) g45p1svt w=(3.1e-07) l=4.5e-08 nf=1 \
        as=1.101e-13 ad=1.2865e-13 ps=1.6e-06 pd=1.45e-06 nrd=1.16667 \
        nrs=1.16667 sa=1.23798e-06 sb=1.005e-06 sd=160n sca=26.7199 \
        scb=0.0211429 scc=0.00304348 m=(1)
mp35 (net393 mout \22\:VDD VDD) g45p1svt w=(3.1e-07) l=4.5e-08 nf=1 \
        as=1.101e-13 ad=5.115e-14 ps=1.6e-06 pd=9.5e-07 nrd=1.16667 \
        nrs=1.16667 sa=1.55298e-06 sb=6.9e-07 sd=160n sca=26.7199 \
        scb=0.0211429 scc=0.00304348 m=(1)
mp36 (\4\:n20 \8\:CKb net393 VDD) g45p1svt w=(3.1e-07) l=4.5e-08 nf=1 \
        as=5.115e-14 ad=6.2e-14 ps=9.5e-07 pd=1.02e-06 nrd=1.16667 \
        nrs=1.16667 sa=1.76298e-06 sb=4.8e-07 sd=160n sca=26.7199 \
        scb=0.0211429 scc=0.00304348 m=(1)
mp25 (\4\:n20 \7\:CKbb \4\:dbp VDD) g45p1svt w=(3.1e-07) l=4.5e-08 nf=1 \
        as=7.285e-14 ad=6.2e-14 ps=1.09e-06 pd=1.02e-06 nrd=1.16667 \
        nrs=1.16667 sa=1.9525e-06 sb=2.35e-07 sd=160n sca=26.7199 \
        scb=0.0211429 scc=0.00304348 m=(1)
ends SMDFFHQX8
// End of subcircuit definition.
