// Generated for: spectre (May  1 08:12:26 2013 )
// Library name: gsclib045
// Cell name: RDFFX1
// View name: extracted

simulator lang=spectre

subckt RDFFX1 CK D ExtVDD Q QN RT VDD VSS
mp56 (\9\:qint \11\:qbint \12\:VDD VDD) g45p1svt w=(2.15e-07) l=4.5e-08 \
        nf=1 as=3.01e-14 ad=6.535e-14 ps=7.1e-07 pd=1.16e-06 nrd=1.16667 \
        nrs=1.16667 sa=3.75e-07 sb=1.4e-07 sd=160n sca=17.2901 \
        scb=0.0181468 scc=0.000802014 m=(1)
mp21 (\18\:CKbb \3\:CKb \14\:VDD VDD) g45p1svt w=(2.15e-07) l=4.5e-08 \
        nf=1 as=3.44e-14 ad=3.01e-14 ps=7.5e-07 pd=7.1e-07 nrd=1.16667 \
        nrs=1.16667 sa=1.4e-07 sb=3.45e-07 sd=160n sca=16.9543 \
        scb=0.0169944 scc=0.00104371 m=(1)
PM3 (\15\:n35g \4\:RTb net205 ExtVDD) g45p1svt w=(2.15e-07) l=4.5e-08 \
        nf=1 as=3.01e-14 ad=1.29e-14 ps=7.1e-07 pd=5.5e-07 nrd=1.16667 \
        nrs=1.16667 sa=8.7e-07 sb=1.4e-07 sd=160n sca=25.2796 \
        scb=0.0259458 scc=0.00265434 m=(1)
mp32 (\5\:mout \3\:n20 \16\:VDD VDD) g45p1svt w=(2.15e-07) l=4.5e-08 \
        nf=1 as=3.44e-14 ad=3.44e-14 ps=7.5e-07 pd=7.5e-07 nrd=1.16667 \
        nrs=1.16667 sa=4.5e-07 sb=3.45e-07 sd=160n sca=13.5042 \
        scb=0.0131605 scc=0.000288614 m=(1)
mp35 (n31 mout \16\:VDD VDD) g45p1svt w=(2.15e-07) l=4.5e-08 nf=1 \
        as=1.29e-14 ad=3.44e-14 ps=5.5e-07 pd=7.5e-07 nrd=1.16667 \
        nrs=1.16667 sa=2.45e-07 sb=5.5e-07 sd=160n sca=11.2521 \
        scb=0.00925046 scc=0.000235422 m=(1)
mp25 (n22 \4\:D \18\:VDD VDD) g45p1svt w=(2.15e-07) l=4.5e-08 nf=1 \
        as=3.01e-14 ad=1.29e-14 ps=7.1e-07 pd=5.5e-07 nrd=1.16667 \
        nrs=1.16667 sa=1.4e-07 sb=2.45e-07 sd=160n sca=20.5104 \
        scb=0.0232403 scc=0.00120911 m=(1)
mp26 (\9\:n20 \2\:CKbb n22 VDD) g45p1svt w=(2.15e-07) l=4.5e-08 nf=1 \
        as=1.29e-14 ad=3.01e-14 ps=5.5e-07 pd=7.1e-07 nrd=1.16667 \
        nrs=1.16667 sa=2.45e-07 sb=1.4e-07 sd=160n sca=17.9596 scb=0.01876 \
        scc=0.00106467 m=(1)
mp36 (\13\:n20 \10\:CKb n31 VDD) g45p1svt w=(2.15e-07) l=4.5e-08 nf=1 \
        as=1.29e-14 ad=3.01e-14 ps=5.5e-07 pd=7.1e-07 nrd=1.16667 \
        nrs=1.16667 sa=1.4e-07 sb=6.55e-07 sd=160n sca=11.0284 \
        scb=0.00890057 scc=0.000234415 m=(1)
mp20 (\13\:CKb \4\:CK \14\:VDD VDD) g45p1svt w=(2.15e-07) l=4.5e-08 nf=1 \
        as=3.44e-14 ad=3.01e-14 ps=7.5e-07 pd=7.1e-07 nrd=1.16667 \
        nrs=1.16667 sa=3.45e-07 sb=1.4e-07 sd=160n sca=21.0614 \
        scb=0.0241824 scc=0.00125996 m=(1)
mp40 (\4\:n35 \7\:CKb \5\:mout VDD) g45p1svt w=(2.15e-07) l=4.5e-08 nf=1 \
        as=3.44e-14 ad=3.01e-14 ps=7.5e-07 pd=7.1e-07 nrd=1.16667 \
        nrs=1.16667 sa=6.55e-07 sb=1.4e-07 sd=160n sca=25.0692 \
        scb=0.0290985 scc=0.00202261 m=(1)
PM0 (\6\:n35g \6\:RT \10\:n35 ExtVDD) g45p1svt w=(2.15e-07) l=4.5e-08 \
        nf=1 as=3.01e-14 ad=3.01e-14 ps=7.1e-07 pd=7.1e-07 nrd=1.16667 \
        nrs=1.16667 sa=1.4e-07 sb=1.4e-07 sd=160n sca=25.8707 \
        scb=0.0268423 scc=0.00266528 m=(1)
PM1 (\17\:qbint \3\:n35g \1\:ExtVDD ExtVDD) g45p1svt w=(2.15e-07) \
        l=4.5e-08 nf=1 as=3.3457e-13 ad=3.01e-14 ps=3.53e-06 pd=7.1e-07 \
        nrd=1.16667 nrs=1.16667 sa=1.4e-07 sb=8.7e-07 sd=160n sca=25.2796 \
        scb=0.0259458 scc=0.00265434 m=(1)
PM2 (net205 \4\:qbint \1\:ExtVDD ExtVDD) g45p1svt w=(2.15e-07) l=4.5e-08 \
        nf=1 as=3.3457e-13 ad=1.29e-14 ps=3.53e-06 pd=5.5e-07 nrd=1.16667 \
        nrs=1.16667 sa=7.65e-07 sb=2.45e-07 sd=160n sca=14.5295 \
        scb=0.0144143 scc=0.000486924 m=(1)
mp45 (\6\:RTb \8\:RT \1\:ExtVDD ExtVDD) g45p1svt w=(2.15e-07) l=4.5e-08 \
        nf=1 as=3.3457e-13 ad=3.01e-14 ps=3.53e-06 pd=7.1e-07 nrd=1.16667 \
        nrs=1.16667 sa=3.1e-07 sb=1.4e-07 sd=160n sca=24.1603 \
        scb=0.0255449 scc=0.00228436 m=(1)
mp53 (\15\:n35 \10\:CKbb net084 VDD) g45p1svt w=(2.15e-07) l=4.5e-08 nf=1 \
        as=1.29e-14 ad=3.01e-14 ps=5.5e-07 pd=7.1e-07 nrd=1.16667 \
        nrs=1.16667 sa=1.4e-07 sb=2.45e-07 sd=160n sca=28.3325 \
        scb=0.0311878 scc=0.00281308 m=(1)
mp52 (net084 \13\:qbint \10\:VDD VDD) g45p1svt w=(2.15e-07) l=4.5e-08 \
        nf=1 as=3.01e-14 ad=1.29e-14 ps=7.1e-07 pd=5.5e-07 nrd=1.16667 \
        nrs=1.16667 sa=2.45e-07 sb=1.4e-07 sd=160n sca=17.2921 \
        scb=0.0195483 scc=0.000645631 m=(1)
C1 (Q VSS) capacitor c=4.97289e-17
C2 (RT VSS) capacitor c=3.12264e-17
C3 (ExtVDD VSS) capacitor c=1.81406e-16
C4 (D VSS) capacitor c=2.92065e-17
C5 (QN VSS) capacitor c=3.03634e-17
C6 (VDD VSS) capacitor c=4.55262e-16
C7 (CKbb VSS) capacitor c=5.07233e-17
C8 (n20 VSS) capacitor c=4.57144e-17
C9 (mout VSS) capacitor c=5.68754e-17
C10 (n35 VSS) capacitor c=1.46666e-16
C11 (CKb VSS) capacitor c=3.42781e-16
C12 (n35g VSS) capacitor c=1.8069e-17
C13 (qbint VSS) capacitor c=4.78369e-17
C14 (RTb VSS) capacitor c=4.12189e-17
C15 (qint VSS) capacitor c=2.23934e-17
C16 (\7\:qbint VSS) capacitor c=4.98516e-17
C17 (\11\:qbint VSS) capacitor c=4.59527e-17
C18 (\13\:qbint VSS) capacitor c=1.41013e-16
C19 (\3\:qint VSS) capacitor c=5.94768e-17
C20 (\10\:CKbb VSS) capacitor c=8.73666e-17
C21 (\4\:RTb VSS) capacitor c=9.90131e-17
C22 (\8\:RT VSS) capacitor c=2.27172e-17
C23 (\4\:qbint VSS) capacitor c=6.89943e-17
C24 (\3\:n35g VSS) capacitor c=5.04657e-17
C25 (\6\:RT VSS) capacitor c=7.79758e-17
C26 (\7\:CKb VSS) capacitor c=3.01385e-17
C27 (\4\:CK VSS) capacitor c=3.42229e-17
C28 (\3\:n20 VSS) capacitor c=5.79291e-17
C29 (\3\:CKb VSS) capacitor c=6.00586e-17
C30 (\10\:CKb VSS) capacitor c=9.56695e-17
C31 (\2\:CKbb VSS) capacitor c=1.23207e-16
C32 (\4\:D VSS) capacitor c=6.50414e-17
C33 (\6\:qbint VSS) capacitor c=3.81275e-17
C34 (\12\:qbint VSS) capacitor c=4.65935e-17
C35 (\14\:qbint VSS) capacitor c=9.13916e-17
C36 (\4\:qint VSS) capacitor c=3.78602e-17
C37 (\7\:RT VSS) capacitor c=1.6727e-16
C38 (\1\:RT VSS) capacitor c=4.50975e-17
C39 (\5\:qbint VSS) capacitor c=3.90657e-17
C40 (\5\:n35g VSS) capacitor c=2.84973e-17
C41 (\8\:CKbb VSS) capacitor c=3.16056e-17
C42 (\1\:CK VSS) capacitor c=3.83643e-17
C43 (\6\:n20 VSS) capacitor c=5.17594e-17
C44 (\8\:CKb VSS) capacitor c=2.42269e-17
C45 (\3\:mout VSS) capacitor c=4.9392e-17
C46 (\9\:CKbb VSS) capacitor c=5.01972e-17
C47 (\5\:CKb VSS) capacitor c=8.54717e-17
C48 (\1\:D VSS) capacitor c=5.16777e-17
C49 (\11\:CKbb VSS) capacitor c=5.63201e-17
C50 (\4\:CKbb VSS) capacitor c=1.28407e-16
C51 (\10\:qbint VSS) capacitor c=5.82472e-17
C52 (\3\:RT VSS) capacitor c=1.68085e-16
C53 (\3\:RTb VSS) capacitor c=7.34036e-17
C54 (\4\:RT VSS) capacitor c=4.33227e-17
C55 (\2\:RT VSS) capacitor c=3.90616e-17
C56 (\3\:qbint VSS) capacitor c=3.55573e-17
C57 (\2\:RTb VSS) capacitor c=4.0126e-17
C58 (\2\:n35 VSS) capacitor c=1.66052e-16
C59 (\4\:n35g VSS) capacitor c=6.7863e-17
C60 (\3\:n35 VSS) capacitor c=4.0648e-17
C61 (\3\:CK VSS) capacitor c=2.68173e-17
C62 (\9\:CKb VSS) capacitor c=8.74319e-17
C63 (\2\:mout VSS) capacitor c=3.87978e-17
C64 (\4\:mout VSS) capacitor c=4.04119e-17
C65 (\5\:n20 VSS) capacitor c=4.33768e-17
C66 (\2\:n20 VSS) capacitor c=4.13285e-17
C67 (\3\:CKbb VSS) capacitor c=6.13487e-17
C68 (\7\:CKbb VSS) capacitor c=3.02463e-17
C69 (\3\:D VSS) capacitor c=1.40884e-17
C70 (\1\:VDD VSS) capacitor c=4.84671e-17
C71 (\3\:Q VSS) capacitor c=8.42873e-17
C72 (\9\:qint VSS) capacitor c=5.46199e-17
C73 (\10\:VDD VSS) capacitor c=2.50771e-17
C74 (\12\:VDD VSS) capacitor c=7.88033e-17
C75 (\4\:QN VSS) capacitor c=5.47151e-17
C76 (\15\:n35 VSS) capacitor c=4.34411e-17
C77 (\15\:n35g VSS) capacitor c=4.67481e-17
C78 (\6\:RTb VSS) capacitor c=5.77424e-17
C79 (\1\:ExtVDD VSS) capacitor c=2.90069e-16
C80 (\10\:n35 VSS) capacitor c=5.11023e-17
C81 (\17\:qbint VSS) capacitor c=6.81129e-17
C82 (\6\:n35g VSS) capacitor c=8.7428e-17
C83 (\4\:n35 VSS) capacitor c=4.01261e-17
C84 (\13\:CKb VSS) capacitor c=6.0297e-17
C85 (\5\:mout VSS) capacitor c=5.94187e-17
C86 (\14\:VDD VSS) capacitor c=7.07474e-17
C87 (\16\:VDD VSS) capacitor c=5.98421e-17
C88 (\18\:CKbb VSS) capacitor c=4.69993e-17
C89 (\13\:n20 VSS) capacitor c=4.60065e-17
C90 (\9\:n20 VSS) capacitor c=8.86555e-17
C91 (\18\:VDD VSS) capacitor c=4.33365e-17
C92 (\1\:Q VSS) capacitor c=5.48754e-17
C93 (\5\:qint VSS) capacitor c=4.69466e-17
C94 (\1\:QN VSS) capacitor c=4.72104e-17
C95 (\18\:n35 VSS) capacitor c=6.04282e-17
C96 (\11\:n35g VSS) capacitor c=2.95379e-17
C97 (\10\:RTb VSS) capacitor c=5.97429e-17
C98 (\13\:n35 VSS) capacitor c=5.58118e-17
C99 (\19\:qbint VSS) capacitor c=2.37156e-17
C100 (\9\:n35g VSS) capacitor c=7.65355e-17
C101 (\7\:n35 VSS) capacitor c=4.5014e-17
C102 (\15\:CKb VSS) capacitor c=3.64374e-17
C103 (\10\:mout VSS) capacitor c=5.24511e-17
C104 (\14\:CKbb VSS) capacitor c=4.85076e-17
C105 (\16\:n20 VSS) capacitor c=4.37333e-17
C106 (\7\:n20 VSS) capacitor c=7.43457e-17
C107 (\2\:D VSS) capacitor c=4.32929e-17
C108 (\4\:n20 VSS) capacitor c=4.72641e-17
C109 (\2\:CK VSS) capacitor c=3.36034e-17
C110 (VDD VSS) capacitor c=2.59504e-16
C111 (\2\:n35g VSS) capacitor c=3.01448e-17
C112 (ExtVDD VSS) capacitor c=3.95682e-17
C113 (\2\:qbint VSS) capacitor c=4.10627e-17
C114 (\5\:RT VSS) capacitor c=5.37228e-17
C115 (\5\:CKbb VSS) capacitor c=1.09964e-16
C116 (\6\:CKbb VSS) capacitor c=4.22697e-17
C117 (\2\:CKb VSS) capacitor c=2.588e-16
C118 (\6\:CKb VSS) capacitor c=4.12095e-17
C119 (\2\:qint VSS) capacitor c=1.77053e-17
C120 (\8\:qbint VSS) capacitor c=5.6858e-17
C121 (\9\:qbint VSS) capacitor c=1.32912e-16
C122 (\12\:CKbb VSS) capacitor c=9.75062e-17
C123 (\13\:CKbb VSS) capacitor c=8.61505e-17
C124 (\6\:D VSS) capacitor c=2.55351e-17
C125 (\11\:n20 VSS) capacitor c=3.76398e-17
C126 (\12\:n20 VSS) capacitor c=5.21744e-17
C127 (\15\:n20 VSS) capacitor c=5.26371e-17
C128 (\17\:CKbb VSS) capacitor c=7.84807e-17
C129 (\7\:mout VSS) capacitor c=4.30504e-17
C130 (\8\:mout VSS) capacitor c=2.73726e-17
C131 (\9\:mout VSS) capacitor c=2.48944e-17
C132 (\12\:mout VSS) capacitor c=2.40462e-17
C133 (\5\:CK VSS) capacitor c=3.73463e-17
C134 (\7\:CK VSS) capacitor c=3.75047e-18
C135 (\8\:CK VSS) capacitor c=4.3304e-17
C136 (\11\:CKb VSS) capacitor c=5.03552e-17
C137 (\12\:CKb VSS) capacitor c=4.42515e-17
C138 (\6\:n35 VSS) capacitor c=6.8782e-17
C139 (\9\:n35 VSS) capacitor c=6.18747e-17
C140 (\8\:n35g VSS) capacitor c=3.2254e-17
C141 (\12\:n35 VSS) capacitor c=6.04532e-17
C142 (\15\:qbint VSS) capacitor c=8.86788e-17
C143 (\16\:qbint VSS) capacitor c=1.11032e-16
C144 (\13\:n35g VSS) capacitor c=1.14412e-16
C145 (\14\:n35g VSS) capacitor c=1.16642e-16
C146 (\9\:RT VSS) capacitor c=6.28544e-17
C147 (\10\:RT VSS) capacitor c=6.14274e-17
C148 (\5\:RTb VSS) capacitor c=3.6905e-17
C149 (\8\:RTb VSS) capacitor c=1.11103e-16
C150 (\9\:RTb VSS) capacitor c=6.96316e-17
C151 (\11\:RT VSS) capacitor c=4.12982e-17
C152 (\21\:qbint VSS) capacitor c=2.90256e-17
C153 (\22\:qbint VSS) capacitor c=3.08567e-17
C154 (\20\:CKbb VSS) capacitor c=1.30233e-16
C155 (\21\:CKbb VSS) capacitor c=9.79353e-17
C156 (\3\:QN VSS) capacitor c=3.33349e-17
C157 (\17\:n35 VSS) capacitor c=6.21189e-17
C158 (\7\:qint VSS) capacitor c=5.19712e-17
C159 (\8\:qint VSS) capacitor c=3.5772e-17
C160 (\4\:VDD VSS) capacitor c=2.35769e-17
C161 (\5\:VDD VSS) capacitor c=1.18281e-17
C162 (\6\:VDD VSS) capacitor c=8.7519e-17
C163 (\7\:VDD VSS) capacitor c=8.38002e-17
C164 (\9\:VDD VSS) capacitor c=2.86714e-17
Rk61 (\2\:Q Q) resistor r=0.1682 c=0
Rk62 (Q \4\:Q) resistor r=0.3377 c=0
Rk45 (\9\:RT \10\:RT) resistor r=0.4442 c=0
Rk50 (RT \11\:RT) resistor r=0.01696 c=0
Rk35 (ExtVDD ExtVDD) resistor r=0.002057 c=0
Rk33 (\2\:ExtVDD ExtVDD) resistor r=0.0221 c=0
Rk36 (ExtVDD \5\:ExtVDD) resistor r=0.0201 c=0
Rk37 (ExtVDD \6\:ExtVDD) resistor r=0.1054 c=0
Rk38 (\7\:ExtVDD \8\:ExtVDD) resistor r=0.02871 c=0
Rk2 (\5\:D \6\:D) resistor r=0.009156 c=0
Rk3 (\7\:D D) resistor r=0.009156 c=0
Rk4 (\6\:D \7\:D) resistor r=0.01888 c=0
Rk54 (\3\:QN QN) resistor r=0.0431 c=0
Rk53 (\2\:QN \3\:QN) resistor r=0.3177 c=0
Rk55 (\3\:QN \5\:QN) resistor r=0.2274 c=0
Rk78 (\2\:VDD \4\:VDD) resistor r=0.5477 c=0
Rk79 (\4\:VDD \5\:VDD) resistor r=0.09133 c=0
Rk81 (\6\:VDD VDD) resistor r=0.8035 c=0
Rk80 (\5\:VDD \6\:VDD) resistor r=0.05156 c=0
Rk82 (VDD \7\:VDD) resistor r=0.7891 c=0
Rk88 (\9\:VDD VDD) resistor r=0.1806 c=0
Rk83 (\7\:VDD \9\:VDD) resistor r=0.05483 c=0
Rk84 (\5\:VDD \11\:VDD) resistor r=0.2895 c=0
Rk85 (\6\:VDD \13\:VDD) resistor r=0.3633 c=0
Rk86 (\7\:VDD \15\:VDD) resistor r=0.3788 c=0
Rk87 (\9\:VDD \17\:VDD) resistor r=0.3557 c=0
Rk89 (VDD \19\:VDD) resistor r=0.5144 c=0
Rk63 (\2\:VSS \3\:VSS) resistor r=0.04928 c=0
Rk64 (\3\:VSS \4\:VSS) resistor r=0.3335 c=0
Rk65 (\4\:VSS \5\:VSS) resistor r=0.309 c=0
Rk67 (\6\:VSS VSS) resistor r=0.1331 c=0
Rk66 (\5\:VSS \6\:VSS) resistor r=0.3609 c=0
Rk68 (VSS \7\:VSS) resistor r=0.07426 c=0
Rk69 (\7\:VSS \8\:VSS) resistor r=0.6182 c=0
Rk71 (\9\:VSS VSS) resistor r=0.02182 c=0
Rk70 (\8\:VSS \9\:VSS) resistor r=0.09627 c=0
Rk72 (VSS \11\:VSS) resistor r=0.5971 c=0
Rk73 (\3\:VSS \13\:VSS) resistor r=0.2598 c=0
Rk74 (\4\:VSS \15\:VSS) resistor r=0.2663 c=0
Rk75 (\6\:VSS \17\:VSS) resistor r=0.1887 c=0
Rk76 (\7\:VSS \19\:VSS) resistor r=0.1938 c=0
Rk77 (\9\:VSS \21\:VSS) resistor r=0.2399 c=0
Rk90 (\23\:VSS \24\:VSS) resistor r=0.3313 c=0
Rk91 (\24\:VSS \25\:VSS) resistor r=0.3609 c=0
Rk93 (\26\:VSS VSS) resistor r=0.1801 c=0
Rk92 (\25\:VSS \26\:VSS) resistor r=0.3139 c=0
Rk95 (\27\:VSS VSS) resistor r=0.1185 c=0
Rk94 (VSS \27\:VSS) resistor r=0.6928 c=0
Rk96 (VSS \29\:VSS) resistor r=0.3451 c=0
Rk97 (\24\:VSS \31\:VSS) resistor r=0.2342 c=0
Rk98 (\26\:VSS \33\:VSS) resistor r=0.3469 c=0
Rk18 (\5\:CK \6\:CK) resistor r=0.005021 c=0
Rk19 (CK \7\:CK) resistor r=0.00251 c=0
Rk20 (\5\:CK \7\:CK) resistor r=0.01225 c=0
Rk21 (CK \8\:CK) resistor r=0.005021 c=0
Rk22 (\7\:CK \8\:CK) resistor r=0.01004 c=0
Rk1 (\12\:CKbb \13\:CKbb) resistor r=0.8336 c=0
Rk10 (\15\:CKbb \16\:CKbb) resistor r=0.3218 c=0
Rk11 (\16\:CKbb \17\:CKbb) resistor r=0.02343 c=0
Rk12 (\16\:CKbb \19\:CKbb) resistor r=0.2142 c=0
Rk52 (\20\:CKbb \21\:CKbb) resistor r=0.8679 c=0
Rk5 (\8\:n20 \10\:n20) resistor r=0.4919 c=0
Rk6 (\10\:n20 \11\:n20) resistor r=0.3007 c=0
Rk7 (\12\:n20 \14\:n20) resistor r=0.2757 c=0
Rk8 (\14\:n20 \15\:n20) resistor r=0.2392 c=0
Rk9 (\12\:n20 \17\:n20) resistor r=0.2333 c=0
Rk13 (\6\:mout \7\:mout) resistor r=0.3049 c=0
Rk14 (\7\:mout \8\:mout) resistor r=0.1492 c=0
Rk15 (\8\:mout \9\:mout) resistor r=0.1241 c=0
Rk16 (\7\:mout \11\:mout) resistor r=0.2733 c=0
Rk17 (\8\:mout \12\:mout) resistor r=0.1307 c=0
Rk26 (\5\:n35 \6\:n35) resistor r=0.2864 c=0
Rk27 (\6\:n35 \8\:n35) resistor r=0.272 c=0
Rk28 (\6\:n35 \9\:n35) resistor r=0.567 c=0
Rk31 (\11\:n35 \12\:n35) resistor r=0.2719 c=0
Rk32 (\12\:n35 \14\:n35) resistor r=0.3269 c=0
Rk56 (\16\:n35 \17\:n35) resistor r=0.17 c=0
Rk57 (\17\:n35 \19\:n35) resistor r=0.4264 c=0
Rk23 (\11\:CKb \12\:CKb) resistor r=0.2067 c=0
Rk24 (\12\:CKb \14\:CKb) resistor r=0.3154 c=0
Rk25 (\12\:CKb \16\:CKb) resistor r=0.1956 c=0
Rk29 (\7\:n35g \8\:n35g) resistor r=0.2289 c=0
Rk30 (\7\:n35g \10\:n35g) resistor r=0.6049 c=0
Rk42 (\12\:n35g \13\:n35g) resistor r=0.2424 c=0
Rk43 (\13\:n35g \14\:n35g) resistor r=0.5641 c=0
Rk44 (\13\:n35g \16\:n35g) resistor r=0.4309 c=0
Rk39 (\15\:qbint \16\:qbint) resistor r=0.4933 c=0
Rk40 (\16\:qbint \18\:qbint) resistor r=0.5658 c=0
Rk41 (\16\:qbint \20\:qbint) resistor r=0.1459 c=0
Rk51 (\21\:qbint \22\:qbint) resistor r=0.2113 c=0
Rk46 (\5\:RTb \7\:RTb) resistor r=0.226 c=0
Rk47 (\7\:RTb \8\:RTb) resistor r=0.2727 c=0
Rk48 (\8\:RTb \9\:RTb) resistor r=0.669 c=0
Rk49 (\8\:RTb \11\:RTb) resistor r=0.3325 c=0
Rk58 (\6\:qint \7\:qint) resistor r=0.2591 c=0
Rk59 (\7\:qint \8\:qint) resistor r=0.1618 c=0
Rk60 (\7\:qint \10\:qint) resistor r=0.2767 c=0
Rl29 (\3\:RT \7\:RT) resistor r=709.9 c=0
Rl26 (\3\:RT \4\:RT) resistor r=72.2057 c=0
Rl20 (\1\:RT \2\:RT) resistor r=125.877 c=0
Rl30 (\5\:RT \8\:RT) resistor r=30.9873 c=0
Rl28 (\5\:RT \6\:RT) resistor r=273.765 c=0
Rl27 (\4\:RT \5\:RT) resistor r=78.204 c=0
Rl3 (\2\:D \4\:D) resistor r=111.253 c=0
Rl1 (\1\:D \2\:D) resistor r=99.7141 c=0
Rl2 (\2\:D \3\:D) resistor r=5.1123 c=0
Rl14 (\2\:CK \4\:CK) resistor r=70.868 c=0
Rl12 (\1\:CK \2\:CK) resistor r=140.099 c=0
Rl13 (\2\:CK \3\:CK) resistor r=2.0166 c=0
Rl38 (\10\:CKbb \11\:CKbb) resistor r=115.79 c=0
Rl5 (CKbb \2\:CKbb) resistor r=151.246 c=0
Rl6 (\2\:CKbb \3\:CKbb) resistor r=246.721 c=0
Rl34 (\5\:CKbb \8\:CKbb) resistor r=64.1356 c=0
Rl31 (\4\:CKbb \5\:CKbb) resistor r=862.964 c=0
Rl35 (\6\:CKbb \9\:CKbb) resistor r=64.1356 c=0
Rl33 (\6\:CKbb \7\:CKbb) resistor r=113.909 c=0
Rl32 (\5\:CKbb \6\:CKbb) resistor r=172.374 c=0
Rl4 (n20 \2\:n20) resistor r=112.885 c=0
Rl9 (\3\:n20 \4\:n20) resistor r=103.572 c=0
Rl11 (\4\:n20 \6\:n20) resistor r=96.5354 c=0
Rl10 (\4\:n20 \5\:n20) resistor r=121.254 c=0
Rl7 (mout \2\:mout) resistor r=24.2328 c=0
Rl8 (\3\:mout \4\:mout) resistor r=24.2328 c=0
Rl36 (n35 \2\:n35) resistor r=499.328 c=0
Rl37 (\2\:n35 \3\:n35) resistor r=104.689 c=0
Rl40 (\2\:CKb \3\:CKb) resistor r=213.178 c=0
Rl39 (CKb \2\:CKb) resistor r=1441.22 c=0
Rl41 (\3\:CKb \4\:CKb) resistor r=134.462 c=0
Rl45 (\4\:CKb \8\:CKb) resistor r=72.9234 c=0
Rl42 (\4\:CKb \5\:CKb) resistor r=222.576 c=0
Rl46 (\4\:CKb \9\:CKb) resistor r=3.6978 c=0
Rl44 (\6\:CKb \7\:CKb) resistor r=66.684 c=0
Rl47 (\6\:CKb \10\:CKb) resistor r=229.379 c=0
Rl43 (\2\:CKb \6\:CKb) resistor r=112.483 c=0
Rl17 (\3\:n35g \4\:n35g) resistor r=241.174 c=0
Rl16 (\2\:n35g \3\:n35g) resistor r=181.74 c=0
Rl18 (\2\:n35g \5\:n35g) resistor r=94.1963 c=0
Rl15 (n35g \2\:n35g) resistor r=2.4834 c=0
Rl51 (\6\:qbint \7\:qbint) resistor r=149.805 c=0
Rl56 (\11\:qbint \12\:qbint) resistor r=195.609 c=0
Rl58 (\13\:qbint \14\:qbint) resistor r=235.906 c=0
Rl25 (\3\:qbint \5\:qbint) resistor r=35.3072 c=0
Rl24 (\2\:qbint \4\:qbint) resistor r=148.502 c=0
Rl22 (qbint \2\:qbint) resistor r=112.732 c=0
Rl23 (\2\:qbint \3\:qbint) resistor r=74.1915 c=0
Rl52 (\7\:qbint \8\:qbint) resistor r=203.519 c=0
Rl55 (\8\:qbint \11\:qbint) resistor r=92.0202 c=0
Rl57 (\9\:qbint \13\:qbint) resistor r=355.65 c=0
Rl54 (\9\:qbint \10\:qbint) resistor r=244.214 c=0
Rl53 (\8\:qbint \9\:qbint) resistor r=221.574 c=0
Rl21 (\3\:RTb \4\:RTb) resistor r=242.199 c=0
Rl19 (RTb \2\:RTb) resistor r=124.312 c=0
Rl49 (\2\:qint \3\:qint) resistor r=64.1263 c=0
Rl50 (\2\:qint \4\:qint) resistor r=73.7417 c=0
Rl48 (qint \2\:qint) resistor r=3.1216 c=0
Rz16 (\1\:Q \2\:Q) resistor r=37.5 c=0
Rz13 (\1\:QN \2\:QN) resistor r=37.5 c=0
Rz17 (\10\:VSS \11\:VSS) resistor r=75 c=0
Rz18 (\12\:VSS \13\:VSS) resistor r=37.5 c=0
Rz19 (\14\:VSS \15\:VSS) resistor r=37.5 c=0
Rz20 (\16\:VSS \17\:VSS) resistor r=75 c=0
Rz21 (\18\:VSS \19\:VSS) resistor r=75 c=0
Rz22 (\20\:VSS \21\:VSS) resistor r=75 c=0
Rz25 (\28\:VSS \29\:VSS) resistor r=75 c=0
Rz26 (\30\:VSS \31\:VSS) resistor r=75 c=0
Rz27 (\32\:VSS \33\:VSS) resistor r=75 c=0
Rz3 (\14\:CKbb \15\:CKbb) resistor r=75 c=0
Rz1 (\7\:n20 \8\:n20) resistor r=75 c=0
Rz2 (\16\:n20 \17\:n20) resistor r=75 c=0
Rz4 (\10\:mout \11\:mout) resistor r=75 c=0
Rz6 (\7\:n35 \8\:n35) resistor r=75 c=0
Rz8 (\13\:n35 \14\:n35) resistor r=75 c=0
Rz14 (\18\:n35 \19\:n35) resistor r=75 c=0
Rz5 (\15\:CKb \16\:CKb) resistor r=75 c=0
Rz7 (\9\:n35g \10\:n35g) resistor r=75 c=0
Rz11 (\11\:n35g \12\:n35g) resistor r=75 c=0
Rz10 (\19\:qbint \20\:qbint) resistor r=75 c=0
Rz12 (\10\:RTb \11\:RTb) resistor r=75 c=0
Rz15 (\5\:qint \6\:qint) resistor r=75 c=0
Ry20 (\3\:Q \4\:Q) resistor r=20.6667 c=0
Ry9 (\1\:ExtVDD \2\:ExtVDD) resistor r=62 c=0
Ry10 (\1\:ExtVDD \5\:ExtVDD) resistor r=62 c=0
Ry11 (\1\:ExtVDD \6\:ExtVDD) resistor r=62 c=0
Ry12 (\1\:ExtVDD \7\:ExtVDD) resistor r=62 c=0
Ry13 (\1\:ExtVDD \8\:ExtVDD) resistor r=62 c=0
Ry17 (\4\:QN \5\:QN) resistor r=20.6667 c=0
Ry24 (\1\:VDD \2\:VDD) resistor r=20.6667 c=0
Ry25 (\10\:VDD \11\:VDD) resistor r=62 c=0
Ry26 (\12\:VDD \13\:VDD) resistor r=20.6667 c=0
Ry27 (\14\:VDD \15\:VDD) resistor r=62 c=0
Ry28 (\16\:VDD \17\:VDD) resistor r=62 c=0
Ry29 (\18\:VDD \19\:VDD) resistor r=62 c=0
Ry21 (\1\:VSS \2\:VSS) resistor r=31 c=0
Ry22 (\1\:VSS \5\:VSS) resistor r=5.1667 c=0
Ry23 (\1\:VSS \8\:VSS) resistor r=5.1667 c=0
Ry30 (\22\:VSS \23\:VSS) resistor r=31 c=0
Ry31 (\22\:VSS \25\:VSS) resistor r=5.1667 c=0
Ry32 (\22\:VSS \27\:VSS) resistor r=5.1667 c=0
Ry3 (\18\:CKbb \19\:CKbb) resistor r=62 c=0
Ry1 (\9\:n20 \10\:n20) resistor r=62 c=0
Ry2 (\13\:n20 \14\:n20) resistor r=62 c=0
Ry4 (\5\:mout \6\:mout) resistor r=62 c=0
Ry6 (\4\:n35 \5\:n35) resistor r=62 c=0
Ry8 (\10\:n35 \11\:n35) resistor r=62 c=0
Ry18 (\15\:n35 \16\:n35) resistor r=62 c=0
Ry5 (\13\:CKb \14\:CKb) resistor r=62 c=0
Ry7 (\6\:n35g \7\:n35g) resistor r=62 c=0
Ry15 (\15\:n35g \16\:n35g) resistor r=62 c=0
Ry14 (\17\:qbint \18\:qbint) resistor r=62 c=0
Ry16 (\6\:RTb \7\:RTb) resistor r=62 c=0
Ry19 (\9\:qint \10\:qint) resistor r=62 c=0
Rx17 (\4\:RT \9\:RT) resistor r=45 c=0
Rx18 (\2\:RT \10\:RT) resistor r=45 c=0
Rx21 (\3\:RT \11\:RT) resistor r=45 c=0
Rx3 (\3\:D \5\:D) resistor r=45 c=0
Rx10 (\3\:CK \6\:CK) resistor r=45 c=0
Rx1 (\3\:CKbb \12\:CKbb) resistor r=45 c=0
Rx2 (\7\:CKbb \13\:CKbb) resistor r=45 c=0
Rx7 (CKbb \17\:CKbb) resistor r=45 c=0
Rx24 (\11\:CKbb \20\:CKbb) resistor r=45 c=0
Rx25 (\4\:CKbb \21\:CKbb) resistor r=45 c=0
Rx4 (\2\:n20 \11\:n20) resistor r=45 c=0
Rx5 (\5\:n20 \12\:n20) resistor r=45 c=0
Rx6 (n20 \15\:n20) resistor r=45 c=0
Rx8 (\4\:mout \9\:mout) resistor r=45 c=0
Rx9 (\2\:mout \12\:mout) resistor r=45 c=0
Rx12 (\3\:n35 \9\:n35) resistor r=45 c=0
Rx14 (\2\:n35 \12\:n35) resistor r=45 c=0
Rx26 (n35 \17\:n35) resistor r=45 c=0
Rx11 (\9\:CKb \11\:CKb) resistor r=45 c=0
Rx13 (\4\:n35g \8\:n35g) resistor r=45 c=0
Rx16 (n35g \14\:n35g) resistor r=45 c=0
Rx15 (\3\:qbint \15\:qbint) resistor r=45 c=0
Rx22 (\10\:qbint \21\:qbint) resistor r=45 c=0
Rx23 (qbint \22\:qbint) resistor r=45 c=0
Rx19 (\3\:RTb \5\:RTb) resistor r=45 c=0
Rx20 (\2\:RTb \9\:RTb) resistor r=45 c=0
Rx27 (qint \8\:qint) resistor r=45 c=0
mn56 (\5\:qint \12\:qbint \14\:VSS VSS) g45n1svt w=(1.45e-07) l=4.5e-08 \
        nf=1 as=2.03e-14 ad=4.365e-14 ps=5.7e-07 pd=9e-07 nrd=1.16667 \
        nrs=1.16667 sa=3.75e-07 sb=1.4e-07 sd=160n sca=9.16682 \
        scb=0.00760686 scc=0.000164708 m=(1)
mn21 (\14\:CKbb \8\:CKb \20\:VSS VSS) g45n1svt w=(1.45e-07) l=4.5e-08 \
        nf=1 as=2.32e-14 ad=2.03e-14 ps=6.1e-07 pd=5.7e-07 nrd=1.16667 \
        nrs=1.16667 sa=1.4e-07 sb=3.45e-07 sd=160n sca=8.0352 \
        scb=0.00565402 scc=8.19771e-05 m=(1)
mn35 (n30 \3\:mout \28\:VSS VSS) g45n1svt w=(1.45e-07) l=4.5e-08 nf=1 \
        as=2.32e-14 ad=8.7e-15 ps=6.1e-07 pd=4.1e-07 nrd=1.16667 \
        nrs=1.16667 sa=2.45e-07 sb=5.5e-07 sd=160n sca=11.1906 \
        scb=0.0108717 scc=0.000387468 m=(1)
mn20 (\15\:CKb \1\:CK \20\:VSS VSS) g45n1svt w=(1.45e-07) l=4.5e-08 nf=1 \
        as=2.03e-14 ad=2.32e-14 ps=5.7e-07 pd=6.1e-07 nrd=1.16667 \
        nrs=1.16667 sa=3.45e-07 sb=1.4e-07 sd=160n sca=8.0352 \
        scb=0.00565402 scc=8.19771e-05 m=(1)
mn32 (\10\:mout \6\:n20 \28\:VSS VSS) g45n1svt w=(1.45e-07) l=4.5e-08 \
        nf=1 as=2.32e-14 ad=2.32e-14 ps=6.1e-07 pd=6.1e-07 nrd=1.16667 \
        nrs=1.16667 sa=4.5e-07 sb=3.45e-07 sd=160n sca=11.1906 \
        scb=0.0108717 scc=0.000387468 m=(1)
mn26 (\7\:n20 \5\:CKb n21 VSS) g45n1svt w=(1.45e-07) l=4.5e-08 nf=1 \
        as=8.7e-15 ad=2.03e-14 ps=4.1e-07 pd=5.7e-07 nrd=1.16667 \
        nrs=1.16667 sa=1.4e-07 sb=2.45e-07 sd=160n sca=8.0352 \
        scb=0.00565402 scc=8.19771e-05 m=(1)
mn25 (n21 \1\:D \10\:VSS VSS) g45n1svt w=(1.45e-07) l=4.5e-08 nf=1 \
        as=2.03e-14 ad=8.7e-15 ps=5.7e-07 pd=4.1e-07 nrd=1.16667 \
        nrs=1.16667 sa=1.4e-07 sb=2.45e-07 sd=160n sca=8.0352 \
        scb=0.00565402 scc=8.19771e-05 m=(1)
mn40 (\7\:n35 \8\:CKbb \10\:mout VSS) g45n1svt w=(1.45e-07) l=4.5e-08 \
        nf=1 as=2.03e-14 ad=2.32e-14 ps=5.7e-07 pd=6.1e-07 nrd=1.16667 \
        nrs=1.16667 sa=6.55e-07 sb=1.4e-07 sd=160n sca=11.1906 \
        scb=0.0108717 scc=0.000387468 m=(1)
mn36 (\16\:n20 \9\:CKbb n30 VSS) g45n1svt w=(1.45e-07) l=4.5e-08 nf=1 \
        as=8.7e-15 ad=2.03e-14 ps=4.1e-07 pd=5.7e-07 nrd=1.16667 \
        nrs=1.16667 sa=1.4e-07 sb=6.55e-07 sd=160n sca=11.1906 \
        scb=0.0108717 scc=0.000387468 m=(1)
NM0 (\9\:n35g RTb \13\:n35 VSS) g45n1svt w=(1.45e-07) l=4.5e-08 nf=1 \
        as=2.03e-14 ad=2.03e-14 ps=5.7e-07 pd=5.7e-07 nrd=1.16667 \
        nrs=1.16667 sa=1.4e-07 sb=1.4e-07 sd=160n sca=17.8702 \
        scb=0.0189183 scc=0.00156031 m=(1)
NM1 (\19\:qbint \5\:n35g \18\:VSS VSS) g45n1svt w=(1.45e-07) l=4.5e-08 \
        nf=1 as=2.03e-14 ad=2.03e-14 ps=5.7e-07 pd=5.7e-07 nrd=1.16667 \
        nrs=1.16667 sa=1.4e-07 sb=1.4e-07 sd=160n sca=9.33388 \
        scb=0.00788941 scc=0.00017958 m=(1)
NM3 (net0121 \5\:qbint \16\:VSS VSS) g45n1svt w=(1.45e-07) l=4.5e-08 \
        nf=1 as=2.03e-14 ad=8.7e-15 ps=5.7e-07 pd=4.1e-07 nrd=1.16667 \
        nrs=1.16667 sa=1.4e-07 sb=2.45e-07 sd=160n sca=9.33388 \
        scb=0.00788941 scc=0.00017958 m=(1)
mn45 (\10\:RTb \1\:RT \32\:VSS VSS) g45n1svt w=(1.45e-07) l=4.5e-08 nf=1 \
        as=2.03e-14 ad=2.03e-14 ps=5.7e-07 pd=5.7e-07 nrd=1.16667 \
        nrs=1.16667 sa=1.4e-07 sb=1.4e-07 sd=160n sca=17.8702 \
        scb=0.0189183 scc=0.00156031 m=(1)
NM2 (\11\:n35g \7\:RT net0121 VSS) g45n1svt w=(1.45e-07) l=4.5e-08 nf=1 \
        as=8.7e-15 ad=2.03e-14 ps=4.1e-07 pd=5.7e-07 nrd=1.16667 \
        nrs=1.16667 sa=2.45e-07 sb=1.4e-07 sd=160n sca=9.33388 \
        scb=0.00788941 scc=0.00017958 m=(1)
mn53 (\18\:n35 CKb net095 VSS) g45n1svt w=(1.45e-07) l=4.5e-08 nf=1 \
        as=8.7e-15 ad=2.03e-14 ps=4.1e-07 pd=5.7e-07 nrd=1.16667 \
        nrs=1.16667 sa=1.4e-07 sb=2.45e-07 sd=160n sca=8.42104 \
        scb=0.00632542 scc=0.000106623 m=(1)
mn52 (net095 \14\:qbint \30\:VSS VSS) g45n1svt w=(1.45e-07) l=4.5e-08 \
        nf=1 as=2.03e-14 ad=8.7e-15 ps=5.7e-07 pd=4.1e-07 nrd=1.16667 \
        nrs=1.16667 sa=2.45e-07 sb=1.4e-07 sd=160n sca=8.42104 \
        scb=0.00632542 scc=0.000106623 m=(1)
mn57 (\1\:QN \4\:qint \14\:VSS VSS) g45n1svt w=(2.6e-07) l=4.5e-08 nf=1 \
        as=4.365e-14 ad=3.64e-14 ps=9e-07 pd=8e-07 nrd=1.16667 nrs=1.16667 \
        sa=1.4e-07 sb=2.71058e-07 sd=160n sca=9.69565 scb=0.00844644 \
        scc=0.000275168 m=(1)
mn55 (\1\:Q \6\:qbint \12\:VSS VSS) g45n1svt w=(2.6e-07) l=4.5e-08 nf=1 \
        as=3.64e-14 ad=3.64e-14 ps=8e-07 pd=8e-07 nrd=1.16667 nrs=1.16667 \
        sa=1.4e-07 sb=1.4e-07 sd=160n sca=9.50447 scb=0.0081528 \
        scc=0.00025289 m=(1)
mp57 (\4\:QN \3\:qint \12\:VDD VDD) g45p1svt w=(3.9e-07) l=4.5e-08 nf=1 \
        as=6.535e-14 ad=5.46e-14 ps=1.16e-06 pd=1.06e-06 nrd=1.16667 \
        nrs=1.16667 sa=1.4e-07 sb=2.69551e-07 sd=160n sca=36.1939 \
        scb=0.0388948 scc=0.0042388 m=(1)
mp55 (\3\:Q \7\:qbint \1\:VDD VDD) g45p1svt w=(3.9e-07) l=4.5e-08 nf=1 \
        as=5.46e-14 ad=5.46e-14 ps=1.06e-06 pd=1.06e-06 nrd=1.16667 \
        nrs=1.16667 sa=1.4e-07 sb=1.4e-07 sd=160n sca=20.1248 \
        scb=0.0190515 scc=0.00152507 m=(1)
ends RDFFX1
// End of subcircuit definition.
