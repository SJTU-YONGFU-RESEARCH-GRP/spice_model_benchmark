// Generated for: spectre (May  1 08:12:10 2013 )
// Library name: gsclib045
// Cell name: RDFFNSQX1
// View name: extracted

simulator lang=spectre

subckt RDFFNSQX1 CKN D ExtVDD Q RT SN VDD VSS
mp20 (\21\:CKNb \4\:CKN \20\:VDD VDD) g45p1svt w=(2.15e-07) l=4.5e-08 \
        nf=1 as=3.01e-14 ad=3.44e-14 ps=7.1e-07 pd=7.5e-07 nrd=1.16667 \
        nrs=1.16667 sa=3.45e-07 sb=1.4e-07 sd=160n sca=15.0986 \
        scb=0.0152901 scc=0.00103801 m=(1)
mp21 (\14\:CKNbb \5\:CKNb \20\:VDD VDD) g45p1svt w=(2.15e-07) l=4.5e-08 \
        nf=1 as=3.44e-14 ad=3.01e-14 ps=7.5e-07 pd=7.1e-07 nrd=1.16667 \
        nrs=1.16667 sa=1.4e-07 sb=3.45e-07 sd=160n sca=14.7851 \
        scb=0.0152025 scc=0.00103799 m=(1)
mp35 (n31 mout \18\:VDD VDD) g45p1svt w=(2.15e-07) l=4.5e-08 nf=1 \
        as=1.29e-14 ad=3.44e-14 ps=5.5e-07 pd=7.5e-07 nrd=1.16667 \
        nrs=1.16667 sa=2.45e-07 sb=3.45e-07 sd=160n sca=9.07394 \
        scb=0.00620741 scc=9.13931e-05 m=(1)
mp52 (n41 \10\:qbint \12\:VDD VDD) g45p1svt w=(2.15e-07) l=4.5e-08 nf=1 \
        as=3.44e-14 ad=3.01e-14 ps=7.5e-07 pd=7.1e-07 nrd=1.16667 \
        nrs=1.16667 sa=1.4e-07 sb=3.45e-07 sd=160n sca=13.263 \
        scb=0.0113871 scc=0.000191708 m=(1)
mp25 (n22 \3\:D \22\:VDD VDD) g45p1svt w=(2.15e-07) l=4.5e-08 nf=1 \
        as=3.01e-14 ad=1.29e-14 ps=7.1e-07 pd=5.5e-07 nrd=1.16667 \
        nrs=1.16667 sa=1.4e-07 sb=2.45e-07 sd=160n sca=20.3407 \
        scb=0.022946 scc=0.00119484 m=(1)
mp26 (\16\:n20 \3\:CKNb n22 VDD) g45p1svt w=(2.15e-07) l=4.5e-08 nf=1 \
        as=1.29e-14 ad=3.01e-14 ps=5.5e-07 pd=7.1e-07 nrd=1.16667 \
        nrs=1.16667 sa=2.45e-07 sb=1.4e-07 sd=160n sca=17.8768 \
        scb=0.0186195 scc=0.00106238 m=(1)
mp36 (\8\:n20 \5\:CKNbb n31 VDD) g45p1svt w=(2.15e-07) l=4.5e-08 nf=1 \
        as=1.29e-14 ad=3.01e-14 ps=5.5e-07 pd=7.1e-07 nrd=1.16667 \
        nrs=1.16667 sa=1.4e-07 sb=4.5e-07 sd=160n sca=9.90756 \
        scb=0.00722231 scc=9.58597e-05 m=(1)
mp30 (\16\:mout \1\:SN \18\:VDD VDD) g45p1svt w=(2.15e-07) l=4.5e-08 \
        nf=1 as=3.44e-14 ad=3.01e-14 ps=7.5e-07 pd=7.1e-07 nrd=1.16667 \
        nrs=1.16667 sa=4.5e-07 sb=1.4e-07 sd=160n sca=8.21217 \
        scb=0.00561226 scc=9.0654e-05 m=(1)
mp32 (\19\:mout \3\:n20 \8\:VDD VDD) g45p1svt w=(2.15e-07) l=4.5e-08 \
        nf=1 as=3.01e-14 ad=3.01e-14 ps=7.1e-07 pd=7.1e-07 nrd=1.16667 \
        nrs=1.16667 sa=1.4e-07 sb=1.4e-07 sd=160n sca=8.67743 \
        scb=0.00586726 scc=9.08247e-05 m=(1)
mp40 (\4\:n35 \6\:CKNbb \5\:mout VDD) g45p1svt w=(2.15e-07) l=4.5e-08 \
        nf=1 as=3.01e-14 ad=3.01e-14 ps=7.1e-07 pd=7.1e-07 nrd=1.16667 \
        nrs=1.16667 sa=1.4e-07 sb=1.4e-07 sd=160n sca=16.9261 \
        scb=0.0188038 scc=0.000658122 m=(1)
PM0 (\6\:n35g \5\:RT \9\:n35 ExtVDD) g45p1svt w=(2.15e-07) l=4.5e-08 nf=1 \
        as=3.01e-14 ad=3.01e-14 ps=7.1e-07 pd=7.1e-07 nrd=1.16667 \
        nrs=1.16667 sa=1.4e-07 sb=1.4e-07 sd=160n sca=26.0836 \
        scb=0.0271848 scc=0.00267095 m=(1)
PM1 (\14\:qbint \3\:n35g \1\:ExtVDD ExtVDD) g45p1svt w=(2.15e-07) \
        l=4.5e-08 nf=1 as=3.5882e-13 ad=3.01e-14 ps=3.6e-06 pd=7.1e-07 \
        nrd=1.16667 nrs=1.16667 sa=1.4e-07 sb=8.7e-07 sd=160n sca=25.2796 \
        scb=0.0259458 scc=0.00265434 m=(1)
PM2 (net205 \4\:qbint \1\:ExtVDD ExtVDD) g45p1svt w=(2.15e-07) l=4.5e-08 \
        nf=1 as=3.5882e-13 ad=1.29e-14 ps=3.6e-06 pd=5.5e-07 nrd=1.16667 \
        nrs=1.16667 sa=7.65e-07 sb=2.45e-07 sd=160n sca=14.5295 \
        scb=0.0144143 scc=0.000486924 m=(1)
mp45 (\6\:RTb \6\:RT \1\:ExtVDD ExtVDD) g45p1svt w=(2.15e-07) l=4.5e-08 \
        nf=1 as=3.5882e-13 ad=3.01e-14 ps=3.6e-06 pd=7.1e-07 nrd=1.16667 \
        nrs=1.16667 sa=3.3e-07 sb=1.4e-07 sd=160n sca=24.3731 \
        scb=0.0258873 scc=0.00229004 m=(1)
PM3 (\15\:n35g \4\:RTb net205 ExtVDD) g45p1svt w=(2.15e-07) l=4.5e-08 \
        nf=1 as=1.29e-14 ad=3.01e-14 ps=5.5e-07 pd=7.1e-07 nrd=1.16667 \
        nrs=1.16667 sa=8.7e-07 sb=1.4e-07 sd=160n sca=25.2796 \
        scb=0.0259458 scc=0.00265434 m=(1)
mp53 (\14\:n35 \13\:CKNb \3\:n41 VDD) g45p1svt w=(2.15e-07) l=4.5e-08 \
        nf=1 as=3.01e-14 ad=3.01e-14 ps=7.1e-07 pd=7.1e-07 nrd=1.16667 \
        nrs=1.16667 sa=1.4e-07 sb=1.4e-07 sd=160n sca=28.502 scb=0.031227 \
        scc=0.00281308 m=(1)
mp50 (n41 \7\:SN \1\:VDD VDD) g45p1svt w=(2.15e-07) l=4.5e-08 nf=1 \
        as=3.01e-14 ad=3.44e-14 ps=7.1e-07 pd=7.5e-07 nrd=1.16667 \
        nrs=1.16667 sa=3.45e-07 sb=1.4e-07 sd=160n sca=20.0397 \
        scb=0.0229667 scc=0.00102742 m=(1)
C1 (VDD VSS) capacitor c=5.67767e-16
C2 (ExtVDD VSS) capacitor c=1.90934e-16
C3 (Q VSS) capacitor c=1.93587e-17
C4 (SN VSS) capacitor c=2.9931e-17
C5 (RT VSS) capacitor c=2.3788e-17
C6 (D VSS) capacitor c=4.4901e-17
C7 (CKNb VSS) capacitor c=4.77445e-17
C8 (mout VSS) capacitor c=5.79861e-17
C9 (n20 VSS) capacitor c=9.40744e-17
C10 (CKNbb VSS) capacitor c=5.22642e-17
C11 (n35g VSS) capacitor c=1.81021e-17
C12 (qbint VSS) capacitor c=4.53444e-17
C13 (RTb VSS) capacitor c=5.18504e-17
C14 (n35 VSS) capacitor c=1.71809e-16
C15 (n41 VSS) capacitor c=8.57539e-17
C16 (net095 VSS) capacitor c=3.64797e-17
C17 (\7\:SN VSS) capacitor c=6.83578e-17
C18 (\7\:qbint VSS) capacitor c=3.72364e-17
C19 (\10\:qbint VSS) capacitor c=7.51457e-17
C20 (\13\:CKNb VSS) capacitor c=4.59401e-17
C21 (\4\:RTb VSS) capacitor c=9.85875e-17
C22 (\6\:RT VSS) capacitor c=2.35436e-17
C23 (\4\:qbint VSS) capacitor c=5.41906e-17
C24 (\3\:n35g VSS) capacitor c=6.02016e-17
C25 (\5\:RT VSS) capacitor c=6.50393e-17
C26 (\6\:CKNbb VSS) capacitor c=1.10063e-16
C27 (\3\:n20 VSS) capacitor c=3.34321e-17
C28 (\4\:CKN VSS) capacitor c=4.92223e-17
C29 (\5\:CKNb VSS) capacitor c=2.70743e-17
C30 (\1\:SN VSS) capacitor c=3.8085e-17
C31 (\5\:CKNbb VSS) capacitor c=7.53887e-17
C32 (\3\:CKNb VSS) capacitor c=1.80102e-16
C33 (\3\:D VSS) capacitor c=7.32262e-17
C34 (\8\:SN VSS) capacitor c=1.32218e-16
C35 (\6\:qbint VSS) capacitor c=4.17615e-17
C36 (\11\:qbint VSS) capacitor c=1.03846e-16
C37 (\8\:CKNbb VSS) capacitor c=2.24132e-16
C38 (\7\:RT VSS) capacitor c=1.20915e-16
C39 (\2\:RT VSS) capacitor c=6.24774e-17
C40 (\5\:qbint VSS) capacitor c=3.87746e-17
C41 (\5\:n35g VSS) capacitor c=2.76764e-17
C42 (\2\:RTb VSS) capacitor c=4.94715e-17
C43 (\7\:CKNb VSS) capacitor c=2.69694e-17
C44 (\1\:CKN VSS) capacitor c=3.00087e-17
C45 (\6\:n20 VSS) capacitor c=6.29211e-17
C46 (\6\:SN VSS) capacitor c=6.60206e-17
C47 (\3\:mout VSS) capacitor c=4.5518e-17
C48 (\12\:CKNb VSS) capacitor c=5.02123e-17
C49 (\2\:CKNbb VSS) capacitor c=8.31891e-17
C50 (\1\:D VSS) capacitor c=4.89351e-17
C51 (\9\:qbint VSS) capacitor c=8.59103e-17
C52 (\14\:CKNb VSS) capacitor c=5.13834e-17
C53 (\3\:SN VSS) capacitor c=2.92571e-16
C54 (\9\:SN VSS) capacitor c=8.56667e-17
C55 (\8\:RT VSS) capacitor c=1.46874e-16
C56 (\11\:CKNb VSS) capacitor c=1.77816e-16
C57 (\3\:RT VSS) capacitor c=3.9325e-17
C58 (\1\:RT VSS) capacitor c=5.29734e-17
C59 (\3\:RTb VSS) capacitor c=7.51711e-17
C60 (\3\:qbint VSS) capacitor c=4.42029e-17
C61 (\2\:n35 VSS) capacitor c=2.61512e-16
C62 (\4\:n35g VSS) capacitor c=5.03175e-17
C63 (\7\:CKNbb VSS) capacitor c=5.89243e-17
C64 (\9\:CKNbb VSS) capacitor c=2.19199e-16
C65 (\3\:n35 VSS) capacitor c=1.2147e-16
C66 (\4\:n20 VSS) capacitor c=1.01605e-16
C67 (\7\:n20 VSS) capacitor c=5.53056e-17
C68 (\3\:CKN VSS) capacitor c=2.34295e-17
C69 (\6\:CKNb VSS) capacitor c=2.23121e-17
C70 (\3\:CKNbb VSS) capacitor c=4.7378e-17
C71 (\2\:SN VSS) capacitor c=4.36284e-17
C72 (\5\:SN VSS) capacitor c=2.91534e-17
C73 (\2\:mout VSS) capacitor c=4.85898e-17
C74 (\4\:mout VSS) capacitor c=3.21941e-17
C75 (\5\:n20 VSS) capacitor c=8.55159e-17
C76 (\2\:n20 VSS) capacitor c=6.66004e-17
C77 (\2\:D VSS) capacitor c=5.45299e-17
C78 (\4\:CKNb VSS) capacitor c=7.96317e-17
C79 (\10\:CKNb VSS) capacitor c=3.12539e-17
C80 (\1\:VDD VSS) capacitor c=2.91487e-17
C81 (\10\:VDD VSS) capacitor c=4.74541e-17
C82 (\4\:Q VSS) capacitor c=5.48125e-17
C83 (\12\:VDD VSS) capacitor c=5.28574e-17
C84 (\3\:n41 VSS) capacitor c=8.36652e-17
C85 (\14\:n35 VSS) capacitor c=5.16858e-17
C86 (\15\:n35g VSS) capacitor c=5.76085e-17
C87 (\6\:RTb VSS) capacitor c=7.39214e-17
C88 (\1\:ExtVDD VSS) capacitor c=2.76904e-16
C89 (\9\:n35 VSS) capacitor c=6.27079e-17
C90 (\14\:qbint VSS) capacitor c=6.57962e-17
C91 (\6\:n35g VSS) capacitor c=9.00407e-17
C92 (\4\:n35 VSS) capacitor c=5.02961e-17
C93 (\5\:mout VSS) capacitor c=7.97921e-17
C94 (\8\:VDD VSS) capacitor c=4.70663e-17
C95 (\21\:CKNb VSS) capacitor c=3.05209e-17
C96 (\19\:mout VSS) capacitor c=4.30061e-17
C97 (\20\:VDD VSS) capacitor c=6.55864e-17
C98 (\16\:mout VSS) capacitor c=4.41003e-17
C99 (\14\:CKNbb VSS) capacitor c=5.21616e-17
C100 (\18\:VDD VSS) capacitor c=5.3992e-17
C101 (\16\:n20 VSS) capacitor c=5.08932e-17
C102 (\8\:n20 VSS) capacitor c=2.51745e-17
C103 (\22\:VDD VSS) capacitor c=4.28299e-17
C104 (\1\:Q VSS) capacitor c=3.79401e-17
C105 (\3\:net095 VSS) capacitor c=4.63132e-17
C106 (\17\:n35 VSS) capacitor c=4.64267e-17
C107 (\11\:n35g VSS) capacitor c=2.63099e-17
C108 (\10\:RTb VSS) capacitor c=5.83672e-17
C109 (\12\:n35 VSS) capacitor c=6.36842e-17
C110 (\16\:qbint VSS) capacitor c=2.27998e-17
C111 (\9\:n35g VSS) capacitor c=8.03382e-17
C112 (\7\:n35 VSS) capacitor c=4.06699e-17
C113 (\11\:mout VSS) capacitor c=2.18863e-17
C114 (\17\:CKNb VSS) capacitor c=4.68594e-17
C115 (\13\:mout VSS) capacitor c=1.72243e-17
C116 (\10\:CKNbb VSS) capacitor c=3.49157e-17
C117 (\14\:n20 VSS) capacitor c=7.24439e-17
C118 (\12\:n20 VSS) capacitor c=5.9481e-17
C119 (\2\:CKNb VSS) capacitor c=7.25311e-17
C120 (\2\:CKN VSS) capacitor c=3.37405e-17
C121 (\4\:CKNbb VSS) capacitor c=1.00724e-16
C122 (VDD VSS) capacitor c=2.38791e-16
C123 (\2\:n35g VSS) capacitor c=3.38232e-17
C124 (ExtVDD VSS) capacitor c=3.9375e-17
C125 (\4\:RT VSS) capacitor c=4.76427e-17
C126 (\2\:qbint VSS) capacitor c=4.14073e-17
C127 (\8\:CKNb VSS) capacitor c=1.16001e-16
C128 (\9\:CKNb VSS) capacitor c=8.08231e-17
C129 (\4\:SN VSS) capacitor c=3.14627e-16
C130 (\15\:CKNb VSS) capacitor c=5.46171e-17
C131 (\16\:CKNb VSS) capacitor c=6.86777e-17
C132 (\8\:qbint VSS) capacitor c=9.36755e-17
C133 (\10\:n20 VSS) capacitor c=4.09545e-17
C134 (\11\:n20 VSS) capacitor c=6.20238e-17
C135 (\18\:n20 VSS) capacitor c=4.18208e-17
C136 (\13\:CKNbb VSS) capacitor c=7.89734e-17
C137 (\16\:CKNbb VSS) capacitor c=5.16903e-17
C138 (\10\:SN VSS) capacitor c=3.11526e-17
C139 (\11\:SN VSS) capacitor c=3.59151e-17
C140 (\5\:CKN VSS) capacitor c=4.64277e-17
C141 (\6\:CKN VSS) capacitor c=3.66547e-17
C142 (\19\:CKNb VSS) capacitor c=4.80004e-17
C143 (\20\:CKNb VSS) capacitor c=4.89425e-17
C144 (\19\:n20 VSS) capacitor c=5.11054e-17
C145 (\20\:n20 VSS) capacitor c=6.02061e-17
C146 (\7\:mout VSS) capacitor c=7.3067e-17
C147 (\8\:mout VSS) capacitor c=3.60366e-17
C148 (\9\:mout VSS) capacitor c=7.74496e-17
C149 (\10\:mout VSS) capacitor c=7.9066e-17
C150 (\15\:mout VSS) capacitor c=5.76378e-17
C151 (\18\:mout VSS) capacitor c=6.22004e-17
C152 (\6\:n35 VSS) capacitor c=6.55336e-17
C153 (\17\:CKNbb VSS) capacitor c=2.96685e-17
C154 (\18\:CKNbb VSS) capacitor c=3.26144e-17
C155 (\8\:n35g VSS) capacitor c=3.04431e-17
C156 (\11\:n35 VSS) capacitor c=7.54111e-17
C157 (\12\:qbint VSS) capacitor c=8.80979e-17
C158 (\13\:qbint VSS) capacitor c=1.09829e-16
C159 (\13\:n35g VSS) capacitor c=1.01858e-16
C160 (\14\:n35g VSS) capacitor c=1.16294e-16
C161 (\5\:RTb VSS) capacitor c=4.77363e-17
C162 (\8\:RTb VSS) capacitor c=9.95556e-17
C163 (\9\:RTb VSS) capacitor c=9.13122e-17
C164 (\9\:RT VSS) capacitor c=1.09941e-16
C165 (\10\:RT VSS) capacitor c=1.18397e-16
C166 (\11\:RT VSS) capacitor c=3.87955e-17
C167 (\12\:SN VSS) capacitor c=8.31587e-17
C168 (\13\:SN VSS) capacitor c=7.95671e-17
C169 (\23\:CKNb VSS) capacitor c=1.29808e-16
C170 (\24\:CKNb VSS) capacitor c=1.34293e-16
C171 (\18\:qbint VSS) capacitor c=1.95542e-17
C172 (\19\:qbint VSS) capacitor c=2.98091e-17
C173 (\16\:n35 VSS) capacitor c=4.39589e-17
C174 (\3\:Q VSS) capacitor c=1.72181e-17
C175 (\3\:VDD VSS) capacitor c=2.42163e-17
C176 (\4\:VDD VSS) capacitor c=2.97484e-17
C177 (\6\:VDD VSS) capacitor c=1.12807e-16
C178 (\7\:VDD VSS) capacitor c=3.67715e-17
C179 (\15\:VDD VSS) capacitor c=1.80393e-17
C180 (\16\:VDD VSS) capacitor c=3.56885e-17
C181 (\17\:VDD VSS) capacitor c=4.3058e-17
Rk66 (\2\:VDD \3\:VDD) resistor r=0.3358 c=0
Rk67 (\3\:VDD \4\:VDD) resistor r=0.1655 c=0
Rk69 (\6\:VDD VDD) resistor r=1.011 c=0
Rk68 (\4\:VDD \6\:VDD) resistor r=0.1087 c=0
Rk70 (VDD \7\:VDD) resistor r=0.687 c=0
Rk71 (\7\:VDD \9\:VDD) resistor r=0.2734 c=0
Rk72 (\3\:VDD \11\:VDD) resistor r=0.3558 c=0
Rk73 (\4\:VDD \13\:VDD) resistor r=0.3008 c=0
Rk74 (\7\:VDD \15\:VDD) resistor r=0.0716 c=0
Rk75 (\15\:VDD \16\:VDD) resistor r=0.08893 c=0
Rk79 (\17\:VDD VDD) resistor r=0.1011 c=0
Rk76 (\16\:VDD \17\:VDD) resistor r=0.1754 c=0
Rk77 (\17\:VDD \19\:VDD) resistor r=0.2748 c=0
Rk78 (\16\:VDD \21\:VDD) resistor r=0.4026 c=0
Rk80 (VDD \23\:VDD) resistor r=0.5105 c=0
Rk40 (ExtVDD ExtVDD) resistor r=0.002059 c=0
Rk38 (\2\:ExtVDD ExtVDD) resistor r=0.02212 c=0
Rk41 (ExtVDD \5\:ExtVDD) resistor r=0.02011 c=0
Rk42 (ExtVDD \6\:ExtVDD) resistor r=0.1054 c=0
Rk63 (\3\:Q Q) resistor r=0.01282 c=0
Rk62 (\2\:Q \3\:Q) resistor r=0.2889 c=0
Rk64 (\3\:Q \5\:Q) resistor r=0.3262 c=0
Rk12 (\10\:SN SN) resistor r=0.01917 c=0
Rk13 (SN \11\:SN) resistor r=0.1486 c=0
Rk56 (\12\:SN \13\:SN) resistor r=0.5349 c=0
Rk81 (\2\:VSS \4\:VSS) resistor r=0.3687 c=0
Rk83 (\5\:VSS VSS) resistor r=0.3965 c=0
Rk82 (\4\:VSS \5\:VSS) resistor r=0.7925 c=0
Rk85 (\6\:VSS VSS) resistor r=0.1211 c=0
Rk84 (VSS \6\:VSS) resistor r=0.7924 c=0
Rk86 (VSS \8\:VSS) resistor r=0.3935 c=0
Rk87 (\5\:VSS \10\:VSS) resistor r=0.2884 c=0
Rk88 (\12\:VSS \14\:VSS) resistor r=0.358 c=0
Rk89 (\14\:VSS \15\:VSS) resistor r=0.7922 c=0
Rk90 (\15\:VSS \16\:VSS) resistor r=0.06665 c=0
Rk92 (\17\:VSS VSS) resistor r=0.1209 c=0
Rk91 (\16\:VSS \17\:VSS) resistor r=0.2076 c=0
Rk94 (\18\:VSS VSS) resistor r=0.01956 c=0
Rk93 (VSS \18\:VSS) resistor r=0.7924 c=0
Rk95 (VSS \19\:VSS) resistor r=0.03719 c=0
Rk96 (\19\:VSS \21\:VSS) resistor r=0.6569 c=0
Rk97 (\16\:VSS \23\:VSS) resistor r=0.1888 c=0
Rk98 (\17\:VSS \25\:VSS) resistor r=0.1939 c=0
Rk99 (\19\:VSS \27\:VSS) resistor r=0.236 c=0
Rk53 (RT \9\:RT) resistor r=0.1836 c=0
Rk54 (\9\:RT \10\:RT) resistor r=0.6451 c=0
Rk55 (RT \11\:RT) resistor r=0.01477 c=0
Rk2 (\4\:D D) resistor r=0.006922 c=0
Rk14 (CKN \5\:CKN) resistor r=0.004347 c=0
Rk16 (\5\:CKN \6\:CKN) resistor r=0.01654 c=0
Rk15 (\6\:CKN \7\:CKN) resistor r=0.004528 c=0
Rk1 (\15\:CKNb \16\:CKNb) resistor r=0.6148 c=0
Rk17 (\18\:CKNb \19\:CKNb) resistor r=0.3357 c=0
Rk18 (\19\:CKNb \20\:CKNb) resistor r=0.163 c=0
Rk19 (\19\:CKNb \22\:CKNb) resistor r=0.2006 c=0
Rk57 (\23\:CKNb \24\:CKNb) resistor r=0.8232 c=0
Rk21 (\6\:mout \7\:mout) resistor r=0.5282 c=0
Rk22 (\7\:mout \8\:mout) resistor r=0.2958 c=0
Rk23 (\8\:mout \9\:mout) resistor r=0.1024 c=0
Rk24 (\9\:mout \10\:mout) resistor r=0.3397 c=0
Rk25 (\7\:mout \12\:mout) resistor r=0.1276 c=0
Rk26 (\8\:mout \14\:mout) resistor r=0.09176 c=0
Rk27 (\9\:mout \15\:mout) resistor r=0.4799 c=0
Rk28 (\15\:mout \17\:mout) resistor r=0.04475 c=0
Rk29 (\10\:mout \18\:mout) resistor r=0.3472 c=0
Rk30 (\15\:mout \20\:mout) resistor r=0.03458 c=0
Rk3 (\9\:n20 \10\:n20) resistor r=0.1919 c=0
Rk4 (\9\:n20 \11\:n20) resistor r=0.21 c=0
Rk5 (\11\:n20 \13\:n20) resistor r=0.3756 c=0
Rk6 (\15\:n20 \17\:n20) resistor r=0.4879 c=0
Rk7 (\17\:n20 \18\:n20) resistor r=0.1439 c=0
Rk20 (\19\:n20 \20\:n20) resistor r=0.2682 c=0
Rk8 (\11\:CKNbb \12\:CKNbb) resistor r=0.2126 c=0
Rk9 (\12\:CKNbb \13\:CKNbb) resistor r=0.01511 c=0
Rk10 (\12\:CKNbb \15\:CKNbb) resistor r=0.3377 c=0
Rk11 (\15\:CKNbb \16\:CKNbb) resistor r=0.2711 c=0
Rk33 (\17\:CKNbb \18\:CKNbb) resistor r=0.2992 c=0
Rk34 (\7\:n35g \8\:n35g) resistor r=0.2403 c=0
Rk35 (\7\:n35g \10\:n35g) resistor r=0.6903 c=0
Rk46 (\12\:n35g \13\:n35g) resistor r=0.2425 c=0
Rk47 (\13\:n35g \14\:n35g) resistor r=0.5645 c=0
Rk48 (\13\:n35g \16\:n35g) resistor r=0.4312 c=0
Rk43 (\12\:qbint \13\:qbint) resistor r=0.4937 c=0
Rk44 (\13\:qbint \15\:qbint) resistor r=0.5662 c=0
Rk45 (\13\:qbint \17\:qbint) resistor r=0.146 c=0
Rk58 (\18\:qbint \19\:qbint) resistor r=0.2114 c=0
Rk49 (\5\:RTb \7\:RTb) resistor r=0.2158 c=0
Rk50 (\7\:RTb \8\:RTb) resistor r=0.4158 c=0
Rk51 (\8\:RTb \9\:RTb) resistor r=0.6874 c=0
Rk52 (\8\:RTb \11\:RTb) resistor r=0.3061 c=0
Rk31 (\5\:n35 \6\:n35) resistor r=0.3332 c=0
Rk32 (\6\:n35 \8\:n35) resistor r=0.2898 c=0
Rk36 (\10\:n35 \11\:n35) resistor r=0.4003 c=0
Rk37 (\11\:n35 \13\:n35) resistor r=0.3293 c=0
Rk59 (\15\:n35 \16\:n35) resistor r=0.3032 c=0
Rk60 (\16\:n35 \18\:n35) resistor r=0.2743 c=0
Rk65 (\2\:n41 \4\:n41) resistor r=0.6517 c=0
Rk61 (\2\:net095 \4\:net095) resistor r=0.2043 c=0
Rl55 (\7\:SN \8\:SN) resistor r=234.813 c=0
Rl56 (\8\:SN \9\:SN) resistor r=434.764 c=0
Rl7 (\1\:SN \2\:SN) resistor r=24.2328 c=0
Rl45 (\4\:SN \6\:SN) resistor r=95.229 c=0
Rl43 (\3\:SN \4\:SN) resistor r=1126.2 c=0
Rl44 (\4\:SN \5\:SN) resistor r=14.5488 c=0
Rl42 (\7\:RT \8\:RT) resistor r=650.933 c=0
Rl29 (\1\:RT \2\:RT) resistor r=169.515 c=0
Rl32 (\4\:RT \6\:RT) resistor r=21.372 c=0
Rl31 (\4\:RT \5\:RT) resistor r=264.027 c=0
Rl30 (\3\:RT \4\:RT) resistor r=96.114 c=0
Rl2 (\2\:D \3\:D) resistor r=108.118 c=0
Rl1 (\1\:D \2\:D) resistor r=70.6183 c=0
Rl15 (\2\:CKN \4\:CKN) resistor r=147.791 c=0
Rl13 (\1\:CKN \2\:CKN) resistor r=63.1757 c=0
Rl14 (\2\:CKN \3\:CKN) resistor r=2.0166 c=0
Rl48 (\13\:CKNb \14\:CKNb) resistor r=166.412 c=0
Rl10 (\3\:CKNb \4\:CKNb) resistor r=446.586 c=0
Rl11 (\2\:CKNb \5\:CKNb) resistor r=59.4618 c=0
Rl9 (\2\:CKNb \3\:CKNb) resistor r=237.282 c=0
Rl8 (CKNb \2\:CKNb) resistor r=147.923 c=0
Rl12 (\2\:CKNb \6\:CKNb) resistor r=4.3228 c=0
Rl37 (\7\:CKNb \8\:CKNb) resistor r=66.1349 c=0
Rl40 (\8\:CKNb \11\:CKNb) resistor r=794.708 c=0
Rl41 (\9\:CKNb \12\:CKNb) resistor r=66.8717 c=0
Rl39 (\9\:CKNb \10\:CKNb) resistor r=129.238 c=0
Rl38 (\8\:CKNb \9\:CKNb) resistor r=430.133 c=0
Rl4 (mout \2\:mout) resistor r=24.2328 c=0
Rl5 (\3\:mout \4\:mout) resistor r=24.2328 c=0
Rl16 (\3\:n20 \4\:n20) resistor r=24.848 c=0
Rl18 (\6\:n20 \7\:n20) resistor r=105.531 c=0
Rl17 (\4\:n20 \5\:n20) resistor r=281.721 c=0
Rl3 (n20 \2\:n20) resistor r=236.609 c=0
Rl22 (\6\:CKNbb \7\:CKNbb) resistor r=196.122 c=0
Rl49 (\8\:CKNbb \9\:CKNbb) resistor r=870.726 c=0
Rl6 (CKNbb \2\:CKNbb) resistor r=183.837 c=0
Rl21 (\4\:CKNbb \6\:CKNbb) resistor r=422.225 c=0
Rl20 (\4\:CKNbb \5\:CKNbb) resistor r=113.702 c=0
Rl19 (\3\:CKNbb \4\:CKNbb) resistor r=158.657 c=0
Rl25 (\3\:n35g \4\:n35g) resistor r=250.512 c=0
Rl24 (\2\:n35g \3\:n35g) resistor r=181.74 c=0
Rl26 (\2\:n35g \5\:n35g) resistor r=94.1963 c=0
Rl23 (n35g \2\:n35g) resistor r=2.4834 c=0
Rl50 (\6\:qbint \7\:qbint) resistor r=149.805 c=0
Rl54 (\10\:qbint \11\:qbint) resistor r=252.671 c=0
Rl36 (\3\:qbint \5\:qbint) resistor r=35.3072 c=0
Rl35 (\2\:qbint \4\:qbint) resistor r=70.093 c=0
Rl33 (qbint \2\:qbint) resistor r=112.732 c=0
Rl34 (\2\:qbint \3\:qbint) resistor r=152.601 c=0
Rl51 (\7\:qbint \8\:qbint) resistor r=99.804 c=0
Rl53 (\8\:qbint \10\:qbint) resistor r=180.657 c=0
Rl52 (\8\:qbint \9\:qbint) resistor r=458.889 c=0
Rl28 (\3\:RTb \4\:RTb) resistor r=239.402 c=0
Rl27 (RTb \2\:RTb) resistor r=112.412 c=0
Rl46 (n35 \2\:n35) resistor r=508.667 c=0
Rl47 (\2\:n35 \3\:n35) resistor r=367.189 c=0
Rz17 (\1\:Q \2\:Q) resistor r=37.5 c=0
Rz20 (\1\:VSS \2\:VSS) resistor r=75 c=0
Rz21 (\7\:VSS \8\:VSS) resistor r=37.5 c=0
Rz22 (\9\:VSS \10\:VSS) resistor r=75 c=0
Rz23 (\11\:VSS \12\:VSS) resistor r=37.5 c=0
Rz24 (\20\:VSS \21\:VSS) resistor r=75 c=0
Rz25 (\22\:VSS \23\:VSS) resistor r=75 c=0
Rz26 (\24\:VSS \25\:VSS) resistor r=75 c=0
Rz27 (\26\:VSS \27\:VSS) resistor r=75 c=0
Rz4 (\17\:CKNb \18\:CKNb) resistor r=75 c=0
Rz5 (\11\:mout \12\:mout) resistor r=75 c=0
Rz6 (\13\:mout \14\:mout) resistor r=75 c=0
Rz1 (\12\:n20 \13\:n20) resistor r=75 c=0
Rz2 (\14\:n20 \15\:n20) resistor r=75 c=0
Rz3 (\10\:CKNbb \11\:CKNbb) resistor r=75 c=0
Rz8 (\9\:n35g \10\:n35g) resistor r=75 c=0
Rz12 (\11\:n35g \12\:n35g) resistor r=75 c=0
Rz11 (\16\:qbint \17\:qbint) resistor r=75 c=0
Rz13 (\10\:RTb \11\:RTb) resistor r=75 c=0
Rz7 (\7\:n35 \8\:n35) resistor r=75 c=0
Rz9 (\12\:n35 \13\:n35) resistor r=75 c=0
Rz14 (\17\:n35 \18\:n35) resistor r=75 c=0
Rz15 (net095 \2\:net095) resistor r=75 c=0
Rz16 (\3\:net095 \4\:net095) resistor r=75 c=0
Ry21 (\1\:VDD \2\:VDD) resistor r=62 c=0
Ry22 (\8\:VDD \9\:VDD) resistor r=62 c=0
Ry23 (\10\:VDD \11\:VDD) resistor r=20.6667 c=0
Ry24 (\12\:VDD \13\:VDD) resistor r=62 c=0
Ry25 (\18\:VDD \19\:VDD) resistor r=62 c=0
Ry26 (\20\:VDD \21\:VDD) resistor r=62 c=0
Ry27 (\22\:VDD \23\:VDD) resistor r=62 c=0
Ry11 (\1\:ExtVDD \2\:ExtVDD) resistor r=62 c=0
Ry12 (\1\:ExtVDD \5\:ExtVDD) resistor r=62 c=0
Ry13 (\1\:ExtVDD \6\:ExtVDD) resistor r=62 c=0
Ry18 (\4\:Q \5\:Q) resistor r=20.6667 c=0
Ry28 (\3\:VSS \4\:VSS) resistor r=15.5 c=0
Ry29 (\3\:VSS \5\:VSS) resistor r=5.1667 c=0
Ry30 (\3\:VSS \6\:VSS) resistor r=5.1667 c=0
Ry31 (\13\:VSS \14\:VSS) resistor r=15.5 c=0
Ry32 (\13\:VSS \15\:VSS) resistor r=5.1667 c=0
Ry33 (\13\:VSS \18\:VSS) resistor r=5.1667 c=0
Ry4 (\21\:CKNb \22\:CKNb) resistor r=62 c=0
Ry5 (\5\:mout \6\:mout) resistor r=62 c=0
Ry6 (\16\:mout \17\:mout) resistor r=62 c=0
Ry7 (\19\:mout \20\:mout) resistor r=62 c=0
Ry1 (\8\:n20 \9\:n20) resistor r=62 c=0
Ry2 (\16\:n20 \17\:n20) resistor r=62 c=0
Ry3 (\14\:CKNbb \15\:CKNbb) resistor r=62 c=0
Ry9 (\6\:n35g \7\:n35g) resistor r=62 c=0
Ry15 (\15\:n35g \16\:n35g) resistor r=62 c=0
Ry14 (\14\:qbint \15\:qbint) resistor r=62 c=0
Ry16 (\6\:RTb \7\:RTb) resistor r=62 c=0
Ry8 (\4\:n35 \5\:n35) resistor r=62 c=0
Ry10 (\9\:n35 \10\:n35) resistor r=62 c=0
Ry17 (\14\:n35 \15\:n35) resistor r=62 c=0
Ry19 (n41 \2\:n41) resistor r=62 c=0
Ry20 (\3\:n41 \4\:n41) resistor r=62 c=0
Rx9 (\5\:SN \10\:SN) resistor r=45 c=0
Rx10 (\2\:SN \11\:SN) resistor r=45 c=0
Rx29 (\3\:SN \12\:SN) resistor r=45 c=0
Rx30 (\9\:SN \13\:SN) resistor r=45 c=0
Rx26 (\3\:RT \9\:RT) resistor r=45 c=0
Rx27 (\1\:RT \10\:RT) resistor r=45 c=0
Rx28 (\8\:RT \11\:RT) resistor r=45 c=0
Rx3 (\2\:D \4\:D) resistor r=45 c=0
Rx11 (\3\:CKN \7\:CKN) resistor r=45 c=0
Rx1 (\4\:CKNb \15\:CKNb) resistor r=45 c=0
Rx2 (\10\:CKNb \16\:CKNb) resistor r=45 c=0
Rx12 (\6\:CKNb \20\:CKNb) resistor r=45 c=0
Rx31 (\14\:CKNb \23\:CKNb) resistor r=45 c=0
Rx32 (\11\:CKNb \24\:CKNb) resistor r=45 c=0
Rx15 (\4\:mout \10\:mout) resistor r=45 c=0
Rx16 (\2\:mout \18\:mout) resistor r=45 c=0
Rx4 (\2\:n20 \10\:n20) resistor r=45 c=0
Rx5 (\5\:n20 \11\:n20) resistor r=45 c=0
Rx6 (n20 \18\:n20) resistor r=45 c=0
Rx13 (\4\:n20 \19\:n20) resistor r=45 c=0
Rx14 (\7\:n20 \20\:n20) resistor r=45 c=0
Rx7 (CKNbb \13\:CKNbb) resistor r=45 c=0
Rx8 (\3\:CKNbb \16\:CKNbb) resistor r=45 c=0
Rx18 (\7\:CKNbb \17\:CKNbb) resistor r=45 c=0
Rx19 (\9\:CKNbb \18\:CKNbb) resistor r=45 c=0
Rx20 (\4\:n35g \8\:n35g) resistor r=45 c=0
Rx23 (n35g \14\:n35g) resistor r=45 c=0
Rx22 (\3\:qbint \12\:qbint) resistor r=45 c=0
Rx33 (\9\:qbint \18\:qbint) resistor r=45 c=0
Rx34 (qbint \19\:qbint) resistor r=45 c=0
Rx24 (\3\:RTb \5\:RTb) resistor r=45 c=0
Rx25 (RTb \9\:RTb) resistor r=45 c=0
Rx17 (\3\:n35 \6\:n35) resistor r=45 c=0
Rx21 (\2\:n35 \11\:n35) resistor r=45 c=0
Rx35 (n35 \16\:n35) resistor r=45 c=0
mn20 (\17\:CKNb \1\:CKN \26\:VSS VSS) g45n1svt w=(1.45e-07) l=4.5e-08 \
        nf=1 as=2.03e-14 ad=2.32e-14 ps=5.7e-07 pd=6.1e-07 nrd=1.16667 \
        nrs=1.16667 sa=3.45e-07 sb=1.4e-07 sd=160n sca=8.0352 \
        scb=0.00565402 scc=8.19771e-05 m=(1)
mn26 (\14\:n20 \2\:CKNbb n21 VSS) g45n1svt w=(1.45e-07) l=4.5e-08 nf=1 \
        as=8.7e-15 ad=2.03e-14 ps=4.1e-07 pd=5.7e-07 nrd=1.16667 \
        nrs=1.16667 sa=2.45e-07 sb=1.4e-07 sd=160n sca=8.0352 \
        scb=0.00565402 scc=8.19771e-05 m=(1)
mn25 (n21 \1\:D \20\:VSS VSS) g45n1svt w=(1.45e-07) l=4.5e-08 nf=1 \
        as=2.03e-14 ad=8.7e-15 ps=5.7e-07 pd=4.1e-07 nrd=1.16667 \
        nrs=1.16667 sa=2.45e-07 sb=1.4e-07 sd=160n sca=8.0352 \
        scb=0.00565402 scc=8.19771e-05 m=(1)
mn21 (\10\:CKNbb CKNb \26\:VSS VSS) g45n1svt w=(1.45e-07) l=4.5e-08 nf=1 \
        as=2.32e-14 ad=2.03e-14 ps=6.1e-07 pd=5.7e-07 nrd=1.16667 \
        nrs=1.16667 sa=1.4e-07 sb=3.45e-07 sd=160n sca=8.0352 \
        scb=0.00565402 scc=8.19771e-05 m=(1)
mn36 (\12\:n20 \12\:CKNb n30 VSS) g45n1svt w=(1.45e-07) l=4.5e-08 nf=1 \
        as=8.7e-15 ad=2.03e-14 ps=4.1e-07 pd=5.7e-07 nrd=1.16667 \
        nrs=1.16667 sa=1.4e-07 sb=7.3e-07 sd=160n sca=8.42104 \
        scb=0.00632542 scc=0.000106623 m=(1)
mn35 (n30 \3\:mout \7\:VSS VSS) g45n1svt w=(1.45e-07) l=4.5e-08 nf=1 \
        as=4.858e-14 ad=8.7e-15 ps=9.6e-07 pd=4.1e-07 nrd=1.16667 \
        nrs=1.16667 sa=2.45e-07 sb=6.25e-07 sd=160n sca=8.42104 \
        scb=0.00632542 scc=0.000106623 m=(1)
mn30 (net426 \6\:SN \7\:VSS VSS) g45n1svt w=(1.45e-07) l=4.5e-08 nf=1 \
        as=4.858e-14 ad=8.7e-15 ps=9.6e-07 pd=4.1e-07 nrd=1.16667 \
        nrs=1.16667 sa=6.25e-07 sb=2.45e-07 sd=160n sca=8.42104 \
        scb=0.00632542 scc=0.000106623 m=(1)
mn32 (\13\:mout \6\:n20 net426 VSS) g45n1svt w=(1.45e-07) l=4.5e-08 nf=1 \
        as=8.7e-15 ad=2.03e-14 ps=4.1e-07 pd=5.7e-07 nrd=1.16667 \
        nrs=1.16667 sa=7.3e-07 sb=1.4e-07 sd=160n sca=8.42104 \
        scb=0.00632542 scc=0.000106623 m=(1)
mn40 (\7\:n35 \7\:CKNb \11\:mout VSS) g45n1svt w=(1.45e-07) l=4.5e-08 \
        nf=1 as=2.03e-14 ad=2.03e-14 ps=5.7e-07 pd=5.7e-07 nrd=1.16667 \
        nrs=1.16667 sa=1.4e-07 sb=1.4e-07 sd=160n sca=8.42104 \
        scb=0.00632542 scc=0.000106623 m=(1)
NM0 (\9\:n35g \2\:RTb \12\:n35 VSS) g45n1svt w=(1.45e-07) l=4.5e-08 nf=1 \
        as=2.03e-14 ad=2.03e-14 ps=5.7e-07 pd=5.7e-07 nrd=1.16667 \
        nrs=1.16667 sa=1.4e-07 sb=1.4e-07 sd=160n sca=8.42104 \
        scb=0.00632542 scc=0.000106623 m=(1)
NM1 (\16\:qbint \5\:n35g \24\:VSS VSS) g45n1svt w=(1.45e-07) l=4.5e-08 \
        nf=1 as=2.03e-14 ad=2.03e-14 ps=5.7e-07 pd=5.7e-07 nrd=1.16667 \
        nrs=1.16667 sa=1.4e-07 sb=1.4e-07 sd=160n sca=9.33388 \
        scb=0.00788941 scc=0.00017958 m=(1)
NM3 (net0121 \5\:qbint \22\:VSS VSS) g45n1svt w=(1.45e-07) l=4.5e-08 \
        nf=1 as=2.03e-14 ad=8.7e-15 ps=5.7e-07 pd=4.1e-07 nrd=1.16667 \
        nrs=1.16667 sa=1.4e-07 sb=2.45e-07 sd=160n sca=9.33388 \
        scb=0.00788941 scc=0.00017958 m=(1)
mn45 (\10\:RTb \2\:RT \9\:VSS VSS) g45n1svt w=(1.45e-07) l=4.5e-08 nf=1 \
        as=2.03e-14 ad=2.03e-14 ps=5.7e-07 pd=5.7e-07 nrd=1.16667 \
        nrs=1.16667 sa=1.4e-07 sb=1.4e-07 sd=160n sca=8.42104 \
        scb=0.00632542 scc=0.000106623 m=(1)
NM2 (\11\:n35g \7\:RT net0121 VSS) g45n1svt w=(1.45e-07) l=4.5e-08 nf=1 \
        as=8.7e-15 ad=2.03e-14 ps=4.1e-07 pd=5.7e-07 nrd=1.16667 \
        nrs=1.16667 sa=2.45e-07 sb=1.4e-07 sd=160n sca=9.33388 \
        scb=0.00788941 scc=0.00017958 m=(1)
mn53 (\17\:n35 \8\:CKNbb \3\:net095 VSS) g45n1svt w=(1.45e-07) l=4.5e-08 \
        nf=1 as=2.03e-14 ad=2.03e-14 ps=5.7e-07 pd=5.7e-07 nrd=1.16667 \
        nrs=1.16667 sa=1.4e-07 sb=1.4e-07 sd=160n sca=8.42104 \
        scb=0.00632542 scc=0.000106623 m=(1)
mn52 (net095 \11\:qbint n42 VSS) g45n1svt w=(1.45e-07) l=4.5e-08 nf=1 \
        as=8.7e-15 ad=2.03e-14 ps=4.1e-07 pd=5.7e-07 nrd=1.16667 \
        nrs=1.16667 sa=1.4e-07 sb=2.45e-07 sd=160n sca=8.42104 \
        scb=0.00632542 scc=0.000106623 m=(1)
mn50 (n42 \8\:SN \1\:VSS VSS) g45n1svt w=(1.45e-07) l=4.5e-08 nf=1 \
        as=2.03e-14 ad=8.7e-15 ps=5.7e-07 pd=4.1e-07 nrd=1.16667 \
        nrs=1.16667 sa=2.45e-07 sb=1.4e-07 sd=160n sca=8.42104 \
        scb=0.00632542 scc=0.000106623 m=(1)
mn55 (\1\:Q \6\:qbint \11\:VSS VSS) g45n1svt w=(2.6e-07) l=4.5e-08 nf=1 \
        as=3.64e-14 ad=3.64e-14 ps=8e-07 pd=8e-07 nrd=1.16667 nrs=1.16667 \
        sa=1.4e-07 sb=1.4e-07 sd=160n sca=9.50447 scb=0.0081528 \
        scc=0.00025289 m=(1)
mp55 (\4\:Q \7\:qbint \10\:VDD VDD) g45p1svt w=(3.9e-07) l=4.5e-08 nf=1 \
        as=5.46e-14 ad=5.46e-14 ps=1.06e-06 pd=1.06e-06 nrd=1.16667 \
        nrs=1.16667 sa=1.4e-07 sb=1.4e-07 sd=160n sca=23.2023 \
        scb=0.0240091 scc=0.00172151 m=(1)
ends RDFFNSQX1
// End of subcircuit definition.
