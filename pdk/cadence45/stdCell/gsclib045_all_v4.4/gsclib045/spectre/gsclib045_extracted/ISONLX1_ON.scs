// Generated for: spectre (May  1 08:11:40 2013 )
// Library name: gsclib045
// Cell name: ISONLX1_ON
// View name: extracted

simulator lang=spectre

subckt ISONLX1_ON A ISOn VDD VSS Y
mp1 (\6\:n0 \4\:ISOn \7\:VDD VDD) g45p1svt w=(2.15e-07) l=4.5e-08 nf=1 \
        as=3.44e-14 ad=3.01e-14 ps=7.5e-07 pd=7.1e-07 nrd=1.16667 \
        nrs=1.16667 sa=1.4e-07 sb=3.45e-07 sd=160n sca=18.442 \
        scb=0.0195131 scc=0.00052448 m=(1)
mp0 (\6\:n0 \4\:A \5\:VDD VDD) g45p1svt w=(2.15e-07) l=4.5e-08 nf=1 \
        as=3.01e-14 ad=3.44e-14 ps=7.1e-07 pd=7.5e-07 nrd=1.16667 \
        nrs=1.16667 sa=3.45e-07 sb=1.4e-07 sd=160n sca=13.4311 \
        scb=0.0102779 scc=9.59767e-05 m=(1)
C1 (VDD VSS) capacitor c=1.26547e-16
C2 (Y VSS) capacitor c=1.80975e-17
C3 (ISOn VSS) capacitor c=1.8788e-17
C4 (n0 VSS) capacitor c=4.68906e-17
C5 (\4\:A VSS) capacitor c=4.10177e-17
C6 (\4\:ISOn VSS) capacitor c=5.58765e-17
C7 (\3\:n0 VSS) capacitor c=2.83211e-17
C8 (\3\:A VSS) capacitor c=6.74821e-17
C9 (\1\:ISOn VSS) capacitor c=6.57126e-17
C10 (\2\:n0 VSS) capacitor c=3.02128e-17
C11 (\1\:A VSS) capacitor c=1.52661e-17
C12 (\3\:ISOn VSS) capacitor c=1.21228e-17
C13 (\4\:Y VSS) capacitor c=3.26908e-17
C14 (\1\:VDD VSS) capacitor c=5.27267e-17
C15 (\5\:VDD VSS) capacitor c=3.11761e-17
C16 (\6\:n0 VSS) capacitor c=7.4452e-17
C17 (\7\:VDD VSS) capacitor c=3.31412e-17
C18 (\2\:Y VSS) capacitor c=6.65218e-17
C19 (\8\:n0 VSS) capacitor c=4.24444e-17
C20 (\2\:ISOn VSS) capacitor c=5.62511e-17
C21 (\2\:A VSS) capacitor c=5.12039e-17
C22 (\6\:ISOn VSS) capacitor c=3.52365e-18
C23 (\7\:ISOn VSS) capacitor c=2.89471e-17
C24 (\5\:A VSS) capacitor c=3.58063e-17
C25 (\7\:A VSS) capacitor c=1.08573e-17
C26 (\8\:A VSS) capacitor c=3.00053e-17
C27 (\4\:n0 VSS) capacitor c=4.2831e-17
C28 (\5\:n0 VSS) capacitor c=1.03073e-16
C29 (\1\:Y VSS) capacitor c=4.23901e-17
Rk18 (VDD \4\:VDD) resistor r=0.002814 c=0
Rk17 (\2\:VDD \4\:VDD) resistor r=0.41 c=0
Rk19 (VDD \6\:VDD) resistor r=0.2693 c=0
Rk20 (\4\:VDD \8\:VDD) resistor r=0.4393 c=0
Rk14 (Y \1\:Y) resistor r=0.02098 c=0
Rk15 (\1\:Y \3\:Y) resistor r=0.4671 c=0
Rk16 (\1\:Y \5\:Y) resistor r=0.1861 c=0
Rk1 (ISOn \5\:ISOn) resistor r=0.005145 c=0
Rk2 (ISOn \6\:ISOn) resistor r=0.002205 c=0
Rk3 (\5\:ISOn \6\:ISOn) resistor r=0.01642 c=0
Rk5 (\6\:ISOn \7\:ISOn) resistor r=0.01816 c=0
Rk4 (\7\:ISOn \8\:ISOn) resistor r=0.005145 c=0
Rk21 (\2\:VSS VSS) resistor r=0.2987 c=0
Rk22 (VSS \4\:VSS) resistor r=0.1134 c=0
Rk23 (\4\:VSS \6\:VSS) resistor r=0.3668 c=0
Rk6 (\5\:A \6\:A) resistor r=0.004889 c=0
Rk7 (A \7\:A) resistor r=0.001833 c=0
Rk8 (\5\:A \7\:A) resistor r=0.02582 c=0
Rk9 (A \8\:A) resistor r=0.004889 c=0
Rk10 (\7\:A \8\:A) resistor r=0.02381 c=0
Rk11 (\4\:n0 \5\:n0) resistor r=0.223 c=0
Rk12 (\5\:n0 \7\:n0) resistor r=0.6469 c=0
Rk13 (\5\:n0 \9\:n0) resistor r=0.2085 c=0
Rl3 (\2\:ISOn \4\:ISOn) resistor r=188.659 c=0
Rl1 (\1\:ISOn \2\:ISOn) resistor r=123.156 c=0
Rl2 (\2\:ISOn \3\:ISOn) resistor r=5.1123 c=0
Rl6 (\2\:A \4\:A) resistor r=122.181 c=0
Rl5 (\2\:A \3\:A) resistor r=173.318 c=0
Rl4 (\1\:A \2\:A) resistor r=5.1171 c=0
Rl7 (n0 \2\:n0) resistor r=139.441 c=0
Rl8 (\2\:n0 \3\:n0) resistor r=39.3066 c=0
Rz2 (\2\:Y \3\:Y) resistor r=37.5 c=0
Rz4 (\1\:VSS \2\:VSS) resistor r=37.5 c=0
Rz5 (\5\:VSS \6\:VSS) resistor r=75 c=0
Rz1 (\8\:n0 \9\:n0) resistor r=75 c=0
Ry3 (\1\:VDD \2\:VDD) resistor r=20.6667 c=0
Ry4 (\5\:VDD \6\:VDD) resistor r=62 c=0
Ry5 (\7\:VDD \8\:VDD) resistor r=62 c=0
Ry2 (\4\:Y \5\:Y) resistor r=20.6667 c=0
Ry1 (\6\:n0 \7\:n0) resistor r=62 c=0
Rx1 (\3\:ISOn \8\:ISOn) resistor r=45 c=0
Rx2 (\1\:A \6\:A) resistor r=45 c=0
Rx3 (\2\:n0 \4\:n0) resistor r=45 c=0
mn0 (net127 \1\:ISOn \5\:VSS VSS) g45n1svt w=(1.45e-07) l=4.5e-08 nf=1 \
        as=2.03e-14 ad=8.7e-15 ps=5.7e-07 pd=4.1e-07 nrd=1.16667 \
        nrs=1.16667 sa=1.4e-07 sb=2.45e-07 sd=160n sca=6.83173 \
        scb=0.00357784 scc=2.82929e-05 m=(1)
mn1 (\8\:n0 \3\:A net127 VSS) g45n1svt w=(1.45e-07) l=4.5e-08 nf=1 \
        as=8.7e-15 ad=2.03e-14 ps=4.1e-07 pd=5.7e-07 nrd=1.16667 \
        nrs=1.16667 sa=2.45e-07 sb=1.4e-07 sd=160n sca=6.83173 \
        scb=0.00357784 scc=2.82929e-05 m=(1)
mn2 (\2\:Y \3\:n0 \1\:VSS VSS) g45n1svt w=(2.6e-07) l=4.5e-08 nf=1 \
        as=3.64e-14 ad=3.64e-14 ps=8e-07 pd=8e-07 nrd=1.16667 nrs=1.16667 \
        sa=1.4e-07 sb=1.4e-07 sd=160n sca=8.22858 scb=0.00610564 \
        scc=0.00012768 m=(1)
mp2 (\4\:Y n0 \1\:VDD VDD) g45p1svt w=(3.9e-07) l=4.5e-08 nf=1 \
        as=5.46e-14 ad=5.46e-14 ps=1.06e-06 pd=1.06e-06 nrd=1.16667 \
        nrs=1.16667 sa=1.4e-07 sb=1.4e-07 sd=160n sca=19.5636 \
        scb=0.0214309 scc=0.000678705 m=(1)
ends ISONLX1_ON
// End of subcircuit definition.
