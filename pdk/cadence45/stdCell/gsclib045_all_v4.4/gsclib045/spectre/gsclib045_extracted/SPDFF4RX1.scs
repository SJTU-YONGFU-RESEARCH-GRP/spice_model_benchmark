// Generated for: spectre (May  1 08:13:15 2013 )
// Library name: gsclib045
// Cell name: SPDFF4RX1
// View name: extracted

simulator lang=spectre

subckt SPDFF4RX1 CK D1 D2 D3 D4 Q1 Q1N Q2 Q2N Q3 Q3N Q4 Q4N RN SE SI1 SI2 \
        SI3 SI4 VDD VSS VSS VDD
mp57 (\3\:Q1N \4\:qint \92\:VDD VDD) g45p1svt w=(3.9e-07) l=4.5e-08 nf=1 \
        as=9.842e-14 ad=5.46e-14 ps=1.97e-06 pd=1.06e-06 nrd=1.16667 \
        nrs=1.16667 sa=1.4e-07 sb=2.49744e-07 sd=160n sca=41.7168 \
        scb=0.0364245 scc=0.00429626 m=(1)
mp55 (\3\:Q1 qbint \90\:VDD VDD) g45p1svt w=(3.9e-07) l=4.5e-08 nf=1 \
        as=1.4115e-13 ad=8.385e-14 ps=2.12e-06 pd=1.59e-06 nrd=1.16667 \
        nrs=1.16667 sa=1.4e-07 sb=1.17795e-06 sd=160n sca=30.6824 \
        scb=0.0202434 scc=0.00336098 m=(1)
PM19 (\3\:Q2N \4\:qint_2 \70\:VDD VDD) g45p1svt w=(3.9e-07) l=4.5e-08 \
        nf=1 as=9.843e-14 ad=5.46e-14 ps=1.97e-06 pd=1.06e-06 nrd=1.16667 \
        nrs=1.16667 sa=1.4e-07 sb=2.49744e-07 sd=160n sca=30.5009 \
        scb=0.0202006 scc=0.00336097 m=(1)
PM17 (\3\:Q2 qbint_2 \67\:VDD VDD) g45p1svt w=(3.9e-07) l=4.5e-08 nf=1 \
        as=1.4115e-13 ad=8.385e-14 ps=2.12e-06 pd=1.59e-06 nrd=1.16667 \
        nrs=1.16667 sa=1.4e-07 sb=1.17795e-06 sd=160n sca=30.5009 \
        scb=0.0202006 scc=0.00336097 m=(1)
PM35 (\1\:Q3 \10\:qbint_3 \28\:VDD VDD) g45p1svt w=(3.9e-07) l=4.5e-08 \
        nf=1 as=1.4115e-13 ad=8.385e-14 ps=2.12e-06 pd=1.59e-06 \
        nrd=1.16667 nrs=1.16667 sa=1.17795e-06 sb=1.4e-07 sd=160n \
        sca=30.5009 scb=0.0202006 scc=0.00336097 m=(1)
PM37 (\3\:Q3N qint_3 \25\:VDD VDD) g45p1svt w=(3.9e-07) l=4.5e-08 nf=1 \
        as=9.843e-14 ad=5.46e-14 ps=1.97e-06 pd=1.06e-06 nrd=1.16667 \
        nrs=1.16667 sa=2.49744e-07 sb=1.4e-07 sd=160n sca=30.5009 \
        scb=0.0202006 scc=0.00336097 m=(1)
PM40 (\1\:Q4 \10\:qbint_4 \9\:VDD VDD) g45p1svt w=(3.9e-07) l=4.5e-08 \
        nf=1 as=1.4115e-13 ad=8.385e-14 ps=2.12e-06 pd=1.59e-06 \
        nrd=1.16667 nrs=1.16667 sa=1.17795e-06 sb=1.4e-07 sd=160n \
        sca=30.6824 scb=0.0202434 scc=0.00336098 m=(1)
PM38 (\3\:Q4N qint_4 \1\:VDD VDD) g45p1svt w=(3.9e-07) l=4.5e-08 nf=1 \
        as=9.843e-14 ad=5.46e-14 ps=1.97e-06 pd=1.06e-06 nrd=1.16667 \
        nrs=1.16667 sa=2.49744e-07 sb=1.4e-07 sd=160n sca=41.7168 \
        scb=0.0364245 scc=0.00429626 m=(1)
C1 (Q4N VSS) capacitor c=1.93545e-17
C2 (VDD VSS) capacitor c=1.70232e-15
C3 (SE VSS) capacitor c=2.71758e-17
C4 (Q4 VSS) capacitor c=5.4444e-17
C5 (D4 VSS) capacitor c=2.07156e-17
C6 (RN VSS) capacitor c=3.30614e-17
C7 (CK VSS) capacitor c=4.60785e-17
C8 (Q1N VSS) capacitor c=1.93123e-17
C9 (Q1 VSS) capacitor c=5.49642e-17
C10 (D1 VSS) capacitor c=2.01214e-17
C11 (Q2N VSS) capacitor c=2.5626e-17
C12 (Q2 VSS) capacitor c=5.50384e-17
C13 (D2 VSS) capacitor c=2.01214e-17
C14 (Q3N VSS) capacitor c=2.5663e-17
C15 (Q3 VSS) capacitor c=5.45172e-17
C16 (D3 VSS) capacitor c=2.07156e-17
C17 (Ckbb VSS) capacitor c=2.20379e-17
C18 (CKb VSS) capacitor c=3.43291e-17
C19 (Db VSS) capacitor c=5.02396e-17
C20 (qint VSS) capacitor c=2.28434e-17
C21 (n8 VSS) capacitor c=1.80574e-18
C22 (n6 VSS) capacitor c=6.69683e-17
C23 (SEb VSS) capacitor c=4.29081e-17
C24 (qbint VSS) capacitor c=4.50591e-17
C25 (n20 VSS) capacitor c=2.55522e-17
C26 (n30 VSS) capacitor c=3.62459e-17
C27 (mout VSS) capacitor c=5.23003e-17
C28 (n2 VSS) capacitor c=3.96884e-18
C29 (n4 VSS) capacitor c=1.50247e-18
C30 (n9 VSS) capacitor c=5.88253e-19
C31 (n11 VSS) capacitor c=3.08511e-18
C32 (n5 VSS) capacitor c=2.3104e-19
C33 (n1 VSS) capacitor c=2.88673e-18
C34 (Db_2 VSS) capacitor c=5.02186e-17
C35 (qint_2 VSS) capacitor c=2.28081e-17
C36 (n8_2 VSS) capacitor c=1.80574e-18
C37 (n6_2 VSS) capacitor c=6.69684e-17
C38 (SEb_2 VSS) capacitor c=4.29388e-17
C39 (qbint_2 VSS) capacitor c=4.48737e-17
C40 (n20_2 VSS) capacitor c=2.55521e-17
C41 (n30_2 VSS) capacitor c=3.62459e-17
C42 (mout_2 VSS) capacitor c=5.22992e-17
C43 (n2_2 VSS) capacitor c=3.96884e-18
C44 (n4_2 VSS) capacitor c=1.50187e-18
C45 (n9_2 VSS) capacitor c=5.88253e-19
C46 (n11_2 VSS) capacitor c=3.08511e-18
C47 (n5_2 VSS) capacitor c=2.3104e-19
C48 (n1_2 VSS) capacitor c=2.88673e-18
C49 (Db_3 VSS) capacitor c=1.02153e-16
C50 (qint_3 VSS) capacitor c=5.91694e-17
C51 (n8_3 VSS) capacitor c=1.80578e-18
C52 (n6_3 VSS) capacitor c=7.4595e-17
C53 (SEb_3 VSS) capacitor c=5.68111e-17
C54 (qbint_3 VSS) capacitor c=4.73223e-17
C55 (n20_3 VSS) capacitor c=4.67202e-17
C56 (n30_3 VSS) capacitor c=4.67869e-17
C57 (mout_3 VSS) capacitor c=5.25779e-17
C58 (n2_3 VSS) capacitor c=3.95036e-18
C59 (n4_3 VSS) capacitor c=1.50247e-18
C60 (n9_3 VSS) capacitor c=5.52712e-19
C61 (n11_3 VSS) capacitor c=3.08511e-18
C62 (n5_3 VSS) capacitor c=2.3104e-19
C63 (n1_3 VSS) capacitor c=2.88673e-18
C64 (Db_4 VSS) capacitor c=1.02121e-16
C65 (qint_4 VSS) capacitor c=5.13164e-17
C66 (n8_4 VSS) capacitor c=1.80578e-18
C67 (n6_4 VSS) capacitor c=7.4595e-17
C68 (SEb_4 VSS) capacitor c=5.68047e-17
C69 (qbint_4 VSS) capacitor c=4.73233e-17
C70 (n20_4 VSS) capacitor c=4.67213e-17
C71 (n30_4 VSS) capacitor c=4.6788e-17
C72 (mout_4 VSS) capacitor c=5.25791e-17
C73 (n2_4 VSS) capacitor c=3.95036e-18
C74 (n4_4 VSS) capacitor c=1.50247e-18
C75 (n9_4 VSS) capacitor c=5.52712e-19
C76 (n11_4 VSS) capacitor c=3.08511e-18
C77 (n5_4 VSS) capacitor c=2.3104e-19
C78 (n1_4 VSS) capacitor c=2.88673e-18
C79 (\4\:qbint_4 VSS) capacitor c=3.79706e-17
C80 (\10\:qbint_4 VSS) capacitor c=4.54435e-17
C81 (\27\:RN VSS) capacitor c=3.04484e-17
C82 (\30\:Ckbb VSS) capacitor c=7.65189e-17
C83 (\29\:CKb VSS) capacitor c=2.87143e-17
C84 (\23\:RN VSS) capacitor c=6.5104e-17
C85 (\27\:CKb VSS) capacitor c=3.75016e-17
C86 (\26\:Ckbb VSS) capacitor c=9.0907e-17
C87 (\1\:D4 VSS) capacitor c=4.76436e-17
C88 (\27\:SE VSS) capacitor c=4.14954e-17
C89 (\3\:SEb_4 VSS) capacitor c=4.28873e-17
C90 (\3\:SI4 VSS) capacitor c=8.42174e-17
C91 (\22\:SE VSS) capacitor c=4.63591e-17
C92 (\4\:qbint_3 VSS) capacitor c=3.75885e-17
C93 (\10\:qbint_3 VSS) capacitor c=4.52583e-17
C94 (\20\:RN VSS) capacitor c=3.04484e-17
C95 (\19\:Ckbb VSS) capacitor c=7.49415e-17
C96 (\22\:CKb VSS) capacitor c=2.87199e-17
C97 (\16\:RN VSS) capacitor c=6.5104e-17
C98 (\20\:CKb VSS) capacitor c=3.75016e-17
C99 (\15\:Ckbb VSS) capacitor c=9.09053e-17
C100 (\1\:D3 VSS) capacitor c=4.76416e-17
C101 (\20\:SE VSS) capacitor c=4.13386e-17
C102 (\3\:SEb_3 VSS) capacitor c=4.27899e-17
C103 (\3\:SI3 VSS) capacitor c=8.33703e-17
C104 (\15\:SE VSS) capacitor c=4.64061e-17
C105 (\1\:CK VSS) capacitor c=3.97193e-17
C106 (\18\:CKb VSS) capacitor c=3.4982e-17
C107 (\12\:SE VSS) capacitor c=4.42336e-17
C108 (\3\:SI2 VSS) capacitor c=8.19476e-17
C109 (\8\:SE VSS) capacitor c=4.09455e-17
C110 (\1\:D2 VSS) capacitor c=4.65679e-17
C111 (\13\:Ckbb VSS) capacitor c=9.02256e-17
C112 (\13\:CKb VSS) capacitor c=3.66746e-17
C113 (\13\:RN VSS) capacitor c=6.54428e-17
C114 (\4\:n20_2 VSS) capacitor c=4.61473e-17
C115 (\10\:CKb VSS) capacitor c=2.8504e-17
C116 (\10\:Ckbb VSS) capacitor c=7.66536e-17
C117 (\8\:qbint_2 VSS) capacitor c=4.82934e-17
C118 (\10\:RN VSS) capacitor c=3.05845e-17
C119 (\3\:n30_2 VSS) capacitor c=4.54089e-17
C120 (\7\:qbint_2 VSS) capacitor c=3.70633e-17
C121 (\4\:qint_2 VSS) capacitor c=5.81582e-17
C122 (\5\:SE VSS) capacitor c=4.41226e-17
C123 (\3\:SI1 VSS) capacitor c=8.42521e-17
C124 (\1\:SE VSS) capacitor c=4.09854e-17
C125 (\1\:D1 VSS) capacitor c=4.65697e-17
C126 (\6\:Ckbb VSS) capacitor c=9.02267e-17
C127 (\6\:CKb VSS) capacitor c=3.66746e-17
C128 (\6\:RN VSS) capacitor c=6.54428e-17
C129 (\4\:n20 VSS) capacitor c=4.61484e-17
C130 (\3\:CKb VSS) capacitor c=2.85049e-17
C131 (\3\:Ckbb VSS) capacitor c=7.66779e-17
C132 (\8\:qbint VSS) capacitor c=4.82943e-17
C133 (\3\:RN VSS) capacitor c=3.05845e-17
C134 (\3\:n30 VSS) capacitor c=4.541e-17
C135 (\7\:qbint VSS) capacitor c=3.74466e-17
C136 (\4\:qint VSS) capacitor c=5.02663e-17
C137 (\4\:qint_4 VSS) capacitor c=3.98003e-17
C138 (\8\:qbint_4 VSS) capacitor c=3.52813e-17
C139 (\9\:qbint_4 VSS) capacitor c=3.13044e-17
C140 (\3\:n30_4 VSS) capacitor c=3.69005e-17
C141 (\25\:RN VSS) capacitor c=4.43684e-17
C142 (\3\:qbint_4 VSS) capacitor c=3.89788e-17
C143 (\31\:CKb VSS) capacitor c=3.408e-17
C144 (\31\:Ckbb VSS) capacitor c=6.02148e-17
C145 (\4\:n20_4 VSS) capacitor c=4.02749e-17
C146 (\24\:RN VSS) capacitor c=8.26826e-17
C147 (\3\:mout_4 VSS) capacitor c=4.93331e-17
C148 (\28\:Ckbb VSS) capacitor c=5.79085e-17
C149 (\26\:CKb VSS) capacitor c=5.7991e-17
C150 (\3\:D4 VSS) capacitor c=4.06457e-17
C151 (\25\:SE VSS) capacitor c=4.33001e-17
C152 (\1\:SI4 VSS) capacitor c=5.63886e-17
C153 (\24\:SE VSS) capacitor c=4.0498e-17
C154 (\4\:qint_3 VSS) capacitor c=4.57569e-17
C155 (\8\:qbint_3 VSS) capacitor c=3.51275e-17
C156 (\9\:qbint_3 VSS) capacitor c=3.13391e-17
C157 (\3\:n30_3 VSS) capacitor c=3.69005e-17
C158 (\18\:RN VSS) capacitor c=4.43685e-17
C159 (\3\:qbint_3 VSS) capacitor c=3.89788e-17
C160 (\24\:CKb VSS) capacitor c=3.408e-17
C161 (\20\:Ckbb VSS) capacitor c=6.02148e-17
C162 (\4\:n20_3 VSS) capacitor c=4.02749e-17
C163 (\17\:RN VSS) capacitor c=8.26787e-17
C164 (\3\:mout_3 VSS) capacitor c=4.93331e-17
C165 (\17\:Ckbb VSS) capacitor c=5.79082e-17
C166 (\19\:CKb VSS) capacitor c=5.7991e-17
C167 (\3\:D3 VSS) capacitor c=4.06457e-17
C168 (\18\:SE VSS) capacitor c=4.345e-17
C169 (\1\:SI3 VSS) capacitor c=5.68693e-17
C170 (\17\:SE VSS) capacitor c=4.07218e-17
C171 (\3\:CK VSS) capacitor c=4.14933e-17
C172 (\17\:CKb VSS) capacitor c=3.06741e-17
C173 (\14\:SE VSS) capacitor c=4.05824e-17
C174 (\1\:SI2 VSS) capacitor c=5.49139e-17
C175 (\10\:SE VSS) capacitor c=4.345e-17
C176 (\3\:SEb_2 VSS) capacitor c=5.71893e-17
C177 (\3\:D2 VSS) capacitor c=4.06724e-17
C178 (\14\:CKb VSS) capacitor c=5.81133e-17
C179 (\11\:Ckbb VSS) capacitor c=5.79325e-17
C180 (\3\:mout_2 VSS) capacitor c=4.93391e-17
C181 (\12\:RN VSS) capacitor c=8.2558e-17
C182 (\3\:n20_2 VSS) capacitor c=3.9835e-17
C183 (\9\:Ckbb VSS) capacitor c=6.02498e-17
C184 (\8\:CKb VSS) capacitor c=3.43291e-17
C185 (\10\:qbint_2 VSS) capacitor c=3.89788e-17
C186 (\8\:RN VSS) capacitor c=4.41774e-17
C187 (\5\:qbint_2 VSS) capacitor c=3.10828e-17
C188 (\4\:qbint_2 VSS) capacitor c=3.51243e-17
C189 (\3\:qint_2 VSS) capacitor c=4.57562e-17
C190 (\7\:SE VSS) capacitor c=4.04723e-17
C191 (\1\:SI1 VSS) capacitor c=5.63885e-17
C192 (\3\:SE VSS) capacitor c=4.33001e-17
C193 (\3\:SEb VSS) capacitor c=5.71894e-17
C194 (\3\:D1 VSS) capacitor c=4.06724e-17
C195 (\7\:CKb VSS) capacitor c=5.81134e-17
C196 (\4\:Ckbb VSS) capacitor c=5.79328e-17
C197 (\3\:mout VSS) capacitor c=4.93391e-17
C198 (\5\:RN VSS) capacitor c=8.25597e-17
C199 (\3\:n20 VSS) capacitor c=3.9835e-17
C200 (\2\:Ckbb VSS) capacitor c=6.03046e-17
C201 (\10\:qbint VSS) capacitor c=3.89788e-17
C202 (\1\:RN VSS) capacitor c=4.41774e-17
C203 (\5\:qbint VSS) capacitor c=3.10294e-17
C204 (\4\:qbint VSS) capacitor c=3.52782e-17
C205 (\3\:qint VSS) capacitor c=3.97302e-17
C206 (\3\:qint_4 VSS) capacitor c=2.26451e-17
C207 (\7\:qbint_4 VSS) capacitor c=2.50162e-17
C208 (\2\:n30_4 VSS) capacitor c=4.35839e-17
C209 (\28\:RN VSS) capacitor c=3.13439e-17
C210 (\26\:RN VSS) capacitor c=1.37873e-16
C211 (\2\:qbint_4 VSS) capacitor c=4.34767e-17
C212 (\32\:CKb VSS) capacitor c=5.05398e-17
C213 (\32\:Ckbb VSS) capacitor c=2.20733e-17
C214 (\30\:CKb VSS) capacitor c=3.93205e-17
C215 (\3\:n20_4 VSS) capacitor c=2.51716e-17
C216 (\22\:RN VSS) capacitor c=2.9517e-17
C217 (\2\:mout_4 VSS) capacitor c=4.88215e-17
C218 (\29\:Ckbb VSS) capacitor c=2.1772e-17
C219 (\28\:CKb VSS) capacitor c=4.08633e-17
C220 (\27\:Ckbb VSS) capacitor c=4.46127e-17
C221 (\2\:D4 VSS) capacitor c=3.65529e-17
C222 (\28\:SE VSS) capacitor c=5.0578e-17
C223 (\2\:SEb_4 VSS) capacitor c=7.66707e-17
C224 (\26\:SE VSS) capacitor c=5.01784e-17
C225 (\2\:SI4 VSS) capacitor c=4.89218e-17
C226 (\23\:SE VSS) capacitor c=2.7107e-17
C227 (\3\:qint_3 VSS) capacitor c=2.26244e-17
C228 (\7\:qbint_3 VSS) capacitor c=2.49906e-17
C229 (\2\:n30_3 VSS) capacitor c=4.35835e-17
C230 (\21\:RN VSS) capacitor c=3.13311e-17
C231 (\19\:RN VSS) capacitor c=1.37873e-16
C232 (\2\:qbint_3 VSS) capacitor c=4.34766e-17
C233 (\25\:CKb VSS) capacitor c=5.04875e-17
C234 (\21\:Ckbb VSS) capacitor c=2.20733e-17
C235 (\23\:CKb VSS) capacitor c=3.93205e-17
C236 (\3\:n20_3 VSS) capacitor c=2.51715e-17
C237 (\15\:RN VSS) capacitor c=2.95228e-17
C238 (\2\:mout_3 VSS) capacitor c=4.88215e-17
C239 (\18\:Ckbb VSS) capacitor c=2.17719e-17
C240 (\21\:CKb VSS) capacitor c=4.08635e-17
C241 (\16\:Ckbb VSS) capacitor c=4.46126e-17
C242 (\2\:D3 VSS) capacitor c=3.65529e-17
C243 (\21\:SE VSS) capacitor c=5.0586e-17
C244 (\2\:SEb_3 VSS) capacitor c=7.66847e-17
C245 (\19\:SE VSS) capacitor c=5.02063e-17
C246 (\2\:SI3 VSS) capacitor c=4.89202e-17
C247 (\16\:SE VSS) capacitor c=2.58441e-17
C248 (\2\:CK VSS) capacitor c=3.26581e-17
C249 (\15\:CKb VSS) capacitor c=2.08504e-17
C250 (\13\:SE VSS) capacitor c=2.66573e-17
C251 (\2\:SI2 VSS) capacitor c=4.89409e-17
C252 (\11\:SE VSS) capacitor c=5.02646e-17
C253 (\2\:SEb_2 VSS) capacitor c=7.59001e-17
C254 (\9\:SE VSS) capacitor c=5.05765e-17
C255 (\2\:D2 VSS) capacitor c=3.6536e-17
C256 (\14\:Ckbb VSS) capacitor c=4.45512e-17
C257 (\12\:CKb VSS) capacitor c=4.08476e-17
C258 (\12\:Ckbb VSS) capacitor c=2.17806e-17
C259 (\2\:mout_2 VSS) capacitor c=4.88183e-17
C260 (\14\:RN VSS) capacitor c=2.96329e-17
C261 (\11\:CKb VSS) capacitor c=3.98232e-17
C262 (\8\:Ckbb VSS) capacitor c=2.20379e-17
C263 (\9\:CKb VSS) capacitor c=5.0493e-17
C264 (\9\:qbint_2 VSS) capacitor c=4.34925e-17
C265 (\9\:RN VSS) capacitor c=1.37943e-16
C266 (\11\:RN VSS) capacitor c=3.13013e-17
C267 (\2\:n30_2 VSS) capacitor c=4.36291e-17
C268 (\6\:SE VSS) capacitor c=2.68209e-17
C269 (\2\:SI1 VSS) capacitor c=4.89464e-17
C270 (\4\:SE VSS) capacitor c=5.02531e-17
C271 (\2\:SEb VSS) capacitor c=7.58933e-17
C272 (\2\:SE VSS) capacitor c=5.05765e-17
C273 (\2\:D1 VSS) capacitor c=3.6536e-17
C274 (\7\:Ckbb VSS) capacitor c=4.45377e-17
C275 (\5\:CKb VSS) capacitor c=4.08427e-17
C276 (\5\:Ckbb VSS) capacitor c=2.1772e-17
C277 (\2\:mout VSS) capacitor c=4.88183e-17
C278 (\7\:RN VSS) capacitor c=2.96481e-17
C279 (\4\:CKb VSS) capacitor c=3.98233e-17
C280 (\2\:CKb VSS) capacitor c=5.05453e-17
C281 (\9\:qbint VSS) capacitor c=4.34926e-17
C282 (\2\:RN VSS) capacitor c=1.37944e-16
C283 (\4\:RN VSS) capacitor c=3.13046e-17
C284 (\2\:n30 VSS) capacitor c=4.36321e-17
C285 (\3\:Q4N VSS) capacitor c=6.90746e-17
C286 (\1\:VDD VSS) capacitor c=3.96026e-17
C287 (\9\:qint_4 VSS) capacitor c=3.17828e-17
C288 (\1\:Q4 VSS) capacitor c=6.16361e-17
C289 (\9\:VDD VSS) capacitor c=2.46395e-17
C290 (\13\:qbint_4 VSS) capacitor c=1.24381e-16
C291 (\11\:VDD VSS) capacitor c=2.60276e-17
C292 (\4\:n30_4 VSS) capacitor c=8.565e-17
C293 (\4\:mout_4 VSS) capacitor c=5.58902e-17
C294 (\13\:VDD VSS) capacitor c=1.94658e-17
C295 (\15\:VDD VSS) capacitor c=2.15573e-17
C296 (\3\:n6_4 VSS) capacitor c=6.72001e-17
C297 (\7\:n20_4 VSS) capacitor c=6.84785e-17
C298 (\4\:Db_4 VSS) capacitor c=8.96735e-17
C299 (\18\:VDD VSS) capacitor c=1.92687e-17
C300 (\6\:Db_4 VSS) capacitor c=5.04735e-17
C301 (\21\:VDD VSS) capacitor c=2.4403e-17
C302 (\5\:SEb_4 VSS) capacitor c=1.09193e-16
C303 (\3\:Q3N VSS) capacitor c=6.69863e-17
C304 (\25\:VDD VSS) capacitor c=2.04888e-17
C305 (\9\:qint_3 VSS) capacitor c=3.19078e-17
C306 (\1\:Q3 VSS) capacitor c=6.16224e-17
C307 (\28\:VDD VSS) capacitor c=2.47859e-17
C308 (\13\:qbint_3 VSS) capacitor c=1.24381e-16
C309 (\31\:VDD VSS) capacitor c=2.61741e-17
C310 (\4\:n30_3 VSS) capacitor c=8.54508e-17
C311 (\4\:mout_3 VSS) capacitor c=5.58902e-17
C312 (\34\:VDD VSS) capacitor c=1.96116e-17
C313 (\38\:VDD VSS) capacitor c=2.17031e-17
C314 (\3\:n6_3 VSS) capacitor c=6.72001e-17
C315 (\7\:n20_3 VSS) capacitor c=6.84785e-17
C316 (\4\:Db_3 VSS) capacitor c=8.96735e-17
C317 (\41\:VDD VSS) capacitor c=1.94958e-17
C318 (\6\:Db_3 VSS) capacitor c=5.02548e-17
C319 (\44\:VDD VSS) capacitor c=2.4372e-17
C320 (\5\:SEb_3 VSS) capacitor c=1.07963e-16
C321 (\56\:CKb VSS) capacitor c=3.56648e-17
C322 (\48\:VDD VSS) capacitor c=1.73098e-17
C323 (\24\:Ckbb VSS) capacitor c=1.187e-16
C324 (\6\:SEb_2 VSS) capacitor c=1.08338e-16
C325 (\51\:VDD VSS) capacitor c=2.41317e-17
C326 (\54\:VDD VSS) capacitor c=1.95224e-17
C327 (\4\:Db_2 VSS) capacitor c=8.91209e-17
C328 (\5\:n20_2 VSS) capacitor c=6.86505e-17
C329 (\58\:VDD VSS) capacitor c=2.16244e-17
C330 (\3\:n6_2 VSS) capacitor c=7.53754e-17
C331 (\61\:VDD VSS) capacitor c=1.95991e-17
C332 (\8\:mout_2 VSS) capacitor c=5.58106e-17
C333 (\4\:n30_2 VSS) capacitor c=8.55108e-17
C334 (\64\:VDD VSS) capacitor c=2.61782e-17
C335 (\12\:qbint_2 VSS) capacitor c=1.24029e-16
C336 (\67\:VDD VSS) capacitor c=2.47732e-17
C337 (\3\:Q2 VSS) capacitor c=6.13447e-17
C338 (\5\:qint_2 VSS) capacitor c=3.29245e-17
C339 (\70\:VDD VSS) capacitor c=2.04807e-17
C340 (\3\:Q2N VSS) capacitor c=6.69962e-17
C341 (\6\:SEb VSS) capacitor c=1.08873e-16
C342 (\73\:VDD VSS) capacitor c=2.43996e-17
C343 (\76\:VDD VSS) capacitor c=1.9224e-17
C344 (\4\:Db VSS) capacitor c=8.91209e-17
C345 (\5\:n20 VSS) capacitor c=6.86505e-17
C346 (\80\:VDD VSS) capacitor c=2.1454e-17
C347 (\3\:n6 VSS) capacitor c=7.53754e-17
C348 (\83\:VDD VSS) capacitor c=1.94286e-17
C349 (\8\:mout VSS) capacitor c=5.58106e-17
C350 (\4\:n30 VSS) capacitor c=8.57349e-17
C351 (\86\:VDD VSS) capacitor c=2.60076e-17
C352 (\12\:qbint VSS) capacitor c=1.24029e-16
C353 (\90\:VDD VSS) capacitor c=2.46027e-17
C354 (\3\:Q1 VSS) capacitor c=6.13471e-17
C355 (\5\:qint VSS) capacitor c=3.28002e-17
C356 (\92\:VDD VSS) capacitor c=4.32941e-17
C357 (\3\:Q1N VSS) capacitor c=6.90694e-17
C358 (\3\:VDD VSS) capacitor c=1.53675e-16
C359 (\1\:Q4N VSS) capacitor c=3.11914e-17
C360 (\7\:qint_4 VSS) capacitor c=3.33391e-17
C361 (\3\:Q4 VSS) capacitor c=3.66938e-17
C362 (\16\:qbint_4 VSS) capacitor c=4.64575e-17
C363 (\6\:n30_4 VSS) capacitor c=1.40848e-16
C364 (\8\:mout_4 VSS) capacitor c=2.99275e-17
C365 (\9\:n20_4 VSS) capacitor c=4.63673e-17
C366 (\8\:Db_4 VSS) capacitor c=7.30619e-17
C367 (\7\:SEb_4 VSS) capacitor c=8.43277e-17
C368 (\1\:Q3N VSS) capacitor c=2.74917e-17
C369 (\7\:qint_3 VSS) capacitor c=3.34796e-17
C370 (\3\:Q3 VSS) capacitor c=3.66938e-17
C371 (\16\:qbint_3 VSS) capacitor c=4.63743e-17
C372 (\6\:n30_3 VSS) capacitor c=1.4072e-16
C373 (\8\:mout_3 VSS) capacitor c=2.99275e-17
C374 (\9\:n20_3 VSS) capacitor c=4.63673e-17
C375 (\8\:Db_3 VSS) capacitor c=7.30619e-17
C376 (\7\:SEb_3 VSS) capacitor c=7.84545e-17
C377 (\51\:CKb VSS) capacitor c=5.71647e-17
C378 (\22\:Ckbb VSS) capacitor c=5.36305e-16
C379 (\4\:SEb_2 VSS) capacitor c=7.93173e-17
C380 (\6\:Db_2 VSS) capacitor c=1.02388e-16
C381 (\8\:Db_2 VSS) capacitor c=7.33177e-17
C382 (\9\:n20_2 VSS) capacitor c=4.63855e-17
C383 (\6\:mout_2 VSS) capacitor c=2.99539e-17
C384 (\6\:n30_2 VSS) capacitor c=1.4219e-16
C385 (\16\:qbint_2 VSS) capacitor c=4.62951e-17
C386 (\1\:Q2 VSS) capacitor c=3.6683e-17
C387 (\9\:qint_2 VSS) capacitor c=3.37046e-17
C388 (\1\:Q2N VSS) capacitor c=2.74954e-17
C389 (\4\:SEb VSS) capacitor c=8.46694e-17
C390 (\6\:Db VSS) capacitor c=1.02356e-16
C391 (\8\:Db VSS) capacitor c=7.33177e-17
C392 (\9\:n20 VSS) capacitor c=4.63855e-17
C393 (\6\:mout VSS) capacitor c=2.99539e-17
C394 (\6\:n30 VSS) capacitor c=1.42341e-16
C395 (\16\:qbint VSS) capacitor c=4.63783e-17
C396 (\1\:Q1 VSS) capacitor c=3.61388e-17
C397 (\9\:qint VSS) capacitor c=3.3341e-17
C398 (\1\:Q1N VSS) capacitor c=3.11914e-17
C399 (\2\:qint VSS) capacitor c=7.48686e-18
C400 (\2\:qbint VSS) capacitor c=2.51474e-17
C401 (\3\:qbint VSS) capacitor c=3.82093e-17
C402 (\2\:n20 VSS) capacitor c=2.37037e-17
C403 (\2\:qint_2 VSS) capacitor c=7.99396e-18
C404 (\7\:qint VSS) capacitor c=3.66181e-17
C405 (\8\:qint VSS) capacitor c=2.41783e-17
C406 (\2\:qbint_2 VSS) capacitor c=2.51239e-17
C407 (\3\:qbint_2 VSS) capacitor c=3.81976e-17
C408 (\11\:qbint VSS) capacitor c=9.56896e-17
C409 (\14\:qbint VSS) capacitor c=4.87196e-17
C410 (\15\:qbint VSS) capacitor c=2.06706e-17
C411 (\8\:n30 VSS) capacitor c=1.32679e-16
C412 (\2\:n20_2 VSS) capacitor c=2.37037e-17
C413 (\4\:mout VSS) capacitor c=7.81825e-17
C414 (\5\:mout VSS) capacitor c=7.29173e-17
C415 (\7\:n20 VSS) capacitor c=9.93507e-17
C416 (\8\:n20 VSS) capacitor c=1.0267e-16
C417 (\4\:D1 VSS) capacitor c=5.22623e-17
C418 (\3\:Db VSS) capacitor c=1.03836e-16
C419 (\4\:SI1 VSS) capacitor c=3.03601e-17
C420 (\6\:SI1 VSS) capacitor c=4.21091e-17
C421 (\8\:SEb VSS) capacitor c=9.22895e-17
C422 (\16\:CKb VSS) capacitor c=1.35609e-17
C423 (\7\:qint_2 VSS) capacitor c=3.66478e-17
C424 (\8\:qint_2 VSS) capacitor c=2.42186e-17
C425 (\11\:qbint_2 VSS) capacitor c=9.56008e-17
C426 (\14\:qbint_2 VSS) capacitor c=4.87196e-17
C427 (\15\:qbint_2 VSS) capacitor c=2.06706e-17
C428 (\8\:n30_2 VSS) capacitor c=1.32679e-16
C429 (\4\:mout_2 VSS) capacitor c=7.81825e-17
C430 (\5\:mout_2 VSS) capacitor c=7.29173e-17
C431 (\7\:n20_2 VSS) capacitor c=9.93508e-17
C432 (\8\:n20_2 VSS) capacitor c=1.0267e-16
C433 (\2\:n20_3 VSS) capacitor c=2.31147e-17
C434 (\4\:D2 VSS) capacitor c=5.22623e-17
C435 (\3\:Db_2 VSS) capacitor c=1.03859e-16
C436 (\4\:SI2 VSS) capacitor c=3.03601e-17
C437 (\6\:SI2 VSS) capacitor c=4.19906e-17
C438 (\8\:SEb_2 VSS) capacitor c=9.22845e-17
C439 (\5\:qbint_3 VSS) capacitor c=3.74761e-17
C440 (\5\:CK VSS) capacitor c=4.91349e-17
C441 (\2\:qint_3 VSS) capacitor c=8.04361e-18
C442 (\4\:SI3 VSS) capacitor c=4.21992e-17
C443 (\5\:SI3 VSS) capacitor c=3.02383e-17
C444 (\4\:SEb_3 VSS) capacitor c=9.21032e-17
C445 (\4\:D3 VSS) capacitor c=5.22724e-17
C446 (\3\:Db_3 VSS) capacitor c=1.04652e-16
C447 (\5\:n20_3 VSS) capacitor c=1.0264e-16
C448 (\6\:n20_3 VSS) capacitor c=9.99378e-17
C449 (\2\:n20_4 VSS) capacitor c=2.31147e-17
C450 (\6\:mout_3 VSS) capacitor c=7.30138e-17
C451 (\7\:mout_3 VSS) capacitor c=7.82979e-17
C452 (\8\:n30_3 VSS) capacitor c=1.32992e-16
C453 (\11\:qbint_3 VSS) capacitor c=2.07013e-17
C454 (\12\:qbint_3 VSS) capacitor c=4.87469e-17
C455 (\15\:qbint_3 VSS) capacitor c=9.57045e-17
C456 (\5\:qbint_4 VSS) capacitor c=3.74869e-17
C457 (\5\:qint_3 VSS) capacitor c=2.41683e-17
C458 (\6\:qint_3 VSS) capacitor c=3.64176e-17
C459 (\2\:qint_4 VSS) capacitor c=7.57237e-18
C460 (\4\:SI4 VSS) capacitor c=4.22051e-17
C461 (\5\:SI4 VSS) capacitor c=3.02383e-17
C462 (\4\:SEb_4 VSS) capacitor c=9.20537e-17
C463 (\4\:D4 VSS) capacitor c=5.22724e-17
C464 (\3\:Db_4 VSS) capacitor c=1.04628e-16
C465 (\5\:n20_4 VSS) capacitor c=1.0264e-16
C466 (\6\:n20_4 VSS) capacitor c=9.99378e-17
C467 (\6\:mout_4 VSS) capacitor c=7.30139e-17
C468 (\7\:mout_4 VSS) capacitor c=7.82979e-17
C469 (\8\:n30_4 VSS) capacitor c=1.32992e-16
C470 (\11\:qbint_4 VSS) capacitor c=2.07013e-17
C471 (\12\:qbint_4 VSS) capacitor c=4.87469e-17
C472 (\15\:qbint_4 VSS) capacitor c=9.57939e-17
C473 (\5\:qint_4 VSS) capacitor c=2.41278e-17
C474 (\6\:qint_4 VSS) capacitor c=3.63894e-17
C475 (\33\:CKb VSS) capacitor c=1.12001e-16
C476 (\34\:CKb VSS) capacitor c=6.55717e-16
C477 (\35\:CKb VSS) capacitor c=5.70616e-16
C478 (\36\:CKb VSS) capacitor c=5.10941e-16
C479 (\37\:CKb VSS) capacitor c=1.56195e-16
C480 (\38\:CKb VSS) capacitor c=3.97172e-16
C481 (\39\:CKb VSS) capacitor c=4.80908e-16
C482 (\40\:CKb VSS) capacitor c=3.8269e-16
C483 (\41\:CKb VSS) capacitor c=1.5561e-16
C484 (\42\:CKb VSS) capacitor c=5.1205e-16
C485 (\43\:CKb VSS) capacitor c=5.7071e-16
C486 (\44\:CKb VSS) capacitor c=6.55929e-16
C487 (\45\:CKb VSS) capacitor c=1.12143e-16
C488 (\46\:CKb VSS) capacitor c=7.15436e-17
C489 (\47\:CKb VSS) capacitor c=8.39701e-17
C490 (\48\:CKb VSS) capacitor c=7.15436e-17
C491 (\49\:CKb VSS) capacitor c=3.64179e-17
C492 (\50\:CKb VSS) capacitor c=1.07134e-16
C493 (\53\:CKb VSS) capacitor c=7.24681e-17
C494 (\54\:CKb VSS) capacitor c=8.39705e-17
C495 (\55\:CKb VSS) capacitor c=7.24681e-17
C496 (\29\:RN VSS) capacitor c=4.40118e-16
C497 (\30\:RN VSS) capacitor c=5.50063e-16
C498 (\31\:RN VSS) capacitor c=5.39213e-16
C499 (\32\:RN VSS) capacitor c=4.07935e-16
C500 (\33\:RN VSS) capacitor c=5.88199e-16
C501 (\34\:RN VSS) capacitor c=4.47385e-16
C502 (\35\:RN VSS) capacitor c=5.39293e-16
C503 (\36\:RN VSS) capacitor c=5.48913e-16
C504 (\37\:RN VSS) capacitor c=4.40593e-16
C505 (\29\:SE VSS) capacitor c=5.51509e-17
C506 (\30\:SE VSS) capacitor c=1.09945e-15
C507 (\31\:SE VSS) capacitor c=6.29942e-16
C508 (\32\:SE VSS) capacitor c=5.88519e-16
C509 (\33\:SE VSS) capacitor c=2.06885e-16
C510 (\34\:SE VSS) capacitor c=2.22037e-16
C511 (\35\:SE VSS) capacitor c=5.8924e-16
C512 (\36\:SE VSS) capacitor c=6.29397e-16
C513 (\37\:SE VSS) capacitor c=1.10022e-15
C514 (\38\:SE VSS) capacitor c=5.50795e-17
C515 (\39\:SE VSS) capacitor c=8.53845e-17
C516 (\40\:SE VSS) capacitor c=5.2801e-17
C517 (\41\:SE VSS) capacitor c=5.52961e-17
C518 (\42\:SE VSS) capacitor c=8.53934e-17
C519 (\43\:SE VSS) capacitor c=5.77444e-17
C520 (\44\:SE VSS) capacitor c=5.30465e-17
C521 (\45\:SE VSS) capacitor c=5.50702e-17
C522 (\46\:SE VSS) capacitor c=8.5334e-17
C523 (\33\:Ckbb VSS) capacitor c=6.09713e-16
C524 (\34\:Ckbb VSS) capacitor c=1.58024e-16
C525 (\35\:Ckbb VSS) capacitor c=5.03843e-16
C526 (\36\:Ckbb VSS) capacitor c=5.37077e-16
C527 (\37\:Ckbb VSS) capacitor c=1.58024e-16
C528 (\38\:Ckbb VSS) capacitor c=3.21829e-16
C529 (\40\:Ckbb VSS) capacitor c=2.34409e-16
C530 (\41\:Ckbb VSS) capacitor c=1.57966e-16
C531 (\42\:Ckbb VSS) capacitor c=5.36827e-16
C532 (\43\:Ckbb VSS) capacitor c=5.04417e-16
C533 (\44\:Ckbb VSS) capacitor c=1.57961e-16
C534 (\45\:Ckbb VSS) capacitor c=6.09652e-16
C535 (\5\:VDD VSS) capacitor c=9.14912e-18
C536 (\6\:VDD VSS) capacitor c=2.52943e-17
C537 (\7\:VDD VSS) capacitor c=1.89553e-17
C538 (\17\:VDD VSS) capacitor c=3.01868e-17
C539 (\20\:VDD VSS) capacitor c=2.87919e-17
C540 (\24\:VDD VSS) capacitor c=9.91041e-18
C541 (\27\:VDD VSS) capacitor c=1.91636e-17
C542 (\30\:VDD VSS) capacitor c=2.54856e-17
C543 (\33\:VDD VSS) capacitor c=1.52507e-17
C544 (\37\:VDD VSS) capacitor c=1.81827e-17
C545 (\40\:VDD VSS) capacitor c=3.02777e-17
C546 (\43\:VDD VSS) capacitor c=2.48202e-17
C547 (\47\:VDD VSS) capacitor c=2.53455e-17
C548 (\50\:VDD VSS) capacitor c=3.30331e-17
C549 (\53\:VDD VSS) capacitor c=1.79832e-17
C550 (\57\:VDD VSS) capacitor c=1.30085e-17
C551 (\60\:VDD VSS) capacitor c=2.01155e-17
C552 (\63\:VDD VSS) capacitor c=2.57338e-17
C553 (\69\:VDD VSS) capacitor c=1.23207e-17
C554 (\72\:VDD VSS) capacitor c=2.63752e-17
C555 (\75\:VDD VSS) capacitor c=1.4097e-17
C556 (\79\:VDD VSS) capacitor c=1.73616e-17
C557 (\82\:VDD VSS) capacitor c=1.99419e-17
C558 (\85\:VDD VSS) capacitor c=2.13455e-17
C559 (\89\:VDD VSS) capacitor c=1.14294e-17
Rk248 (\2\:VSS \4\:VSS) resistor r=0.2711 c=0
Rk249 (\4\:VSS \5\:VSS) resistor r=0.08293 c=0
Rk250 (\5\:VSS \6\:VSS) resistor r=0.3162 c=0
Rk251 (\6\:VSS \7\:VSS) resistor r=0.515 c=0
Rk252 (\7\:VSS \8\:VSS) resistor r=0.09822 c=0
Rk253 (\8\:VSS \9\:VSS) resistor r=0.4626 c=0
Rk254 (\9\:VSS \10\:VSS) resistor r=0.413 c=0
Rk255 (\10\:VSS \11\:VSS) resistor r=0.3429 c=0
Rk256 (\11\:VSS \12\:VSS) resistor r=0.08038 c=0
Rk257 (\12\:VSS \13\:VSS) resistor r=0.306 c=0
Rk258 (\13\:VSS \14\:VSS) resistor r=0.3162 c=0
Rk259 (\14\:VSS \15\:VSS) resistor r=0.5142 c=0
Rk260 (\15\:VSS \16\:VSS) resistor r=0.5652 c=0
Rk261 (\16\:VSS \17\:VSS) resistor r=0.413 c=0
Rk262 (\17\:VSS \18\:VSS) resistor r=0.2409 c=0
Rk263 (\18\:VSS \19\:VSS) resistor r=0.209 c=0
Rk264 (\19\:VSS \20\:VSS) resistor r=0.4372 c=0
Rk265 (\20\:VSS \21\:VSS) resistor r=0.413 c=0
Rk266 (\21\:VSS \22\:VSS) resistor r=0.1568 c=0
Rk267 (\22\:VSS \23\:VSS) resistor r=0.404 c=0
Rk268 (\23\:VSS \24\:VSS) resistor r=0.515 c=0
Rk269 (\24\:VSS \25\:VSS) resistor r=0.2995 c=0
Rk270 (\5\:VSS \27\:VSS) resistor r=0.04428 c=0
Rk271 (\6\:VSS \29\:VSS) resistor r=0.04428 c=0
Rk272 (\7\:VSS \31\:VSS) resistor r=0.04428 c=0
Rk273 (\9\:VSS \33\:VSS) resistor r=0.04428 c=0
Rk274 (\10\:VSS \35\:VSS) resistor r=0.04428 c=0
Rk275 (\12\:VSS \37\:VSS) resistor r=0.04428 c=0
Rk276 (\13\:VSS \39\:VSS) resistor r=0.04428 c=0
Rk277 (\14\:VSS \41\:VSS) resistor r=0.04428 c=0
Rk278 (\15\:VSS \43\:VSS) resistor r=0.07263 c=0
Rk279 (\16\:VSS \45\:VSS) resistor r=0.04428 c=0
Rk280 (\17\:VSS \47\:VSS) resistor r=0.04428 c=0
Rk281 (\19\:VSS \49\:VSS) resistor r=0.04234 c=0
Rk282 (\20\:VSS \51\:VSS) resistor r=0.04428 c=0
Rk283 (\21\:VSS \53\:VSS) resistor r=0.04428 c=0
Rk284 (\23\:VSS \55\:VSS) resistor r=0.04428 c=0
Rk285 (\24\:VSS \57\:VSS) resistor r=0.04428 c=0
Rk287 (\58\:VSS VSS) resistor r=0.1311 c=0
Rk286 (\25\:VSS \58\:VSS) resistor r=0.326 c=0
Rk288 (VSS \59\:VSS) resistor r=0.2921 c=0
Rk289 (\59\:VSS \60\:VSS) resistor r=0.413 c=0
Rk290 (\60\:VSS \61\:VSS) resistor r=0.0549 c=0
Rk291 (\61\:VSS \62\:VSS) resistor r=0.5059 c=0
Rk292 (\62\:VSS \63\:VSS) resistor r=0.515 c=0
Rk293 (\63\:VSS \64\:VSS) resistor r=0.1976 c=0
Rk294 (\64\:VSS \65\:VSS) resistor r=0.1186 c=0
Rk295 (\65\:VSS \67\:VSS) resistor r=0.3686 c=0
Rk296 (\25\:VSS \69\:VSS) resistor r=0.07263 c=0
Rk297 (\58\:VSS \71\:VSS) resistor r=0.04428 c=0
Rk298 (\59\:VSS \73\:VSS) resistor r=0.04428 c=0
Rk299 (\60\:VSS \75\:VSS) resistor r=0.04428 c=0
Rk300 (\62\:VSS \77\:VSS) resistor r=0.04428 c=0
Rk301 (\63\:VSS \79\:VSS) resistor r=0.04428 c=0
Rk302 (\65\:VSS \81\:VSS) resistor r=0.04428 c=0
Rk183 (Q4N \2\:Q4N) resistor r=0.03697 c=0
Rk184 (Q4N \4\:Q4N) resistor r=0.2019 c=0
Rk185 (\2\:VDD \4\:VDD) resistor r=0.2711 c=0
Rk186 (\4\:VDD \5\:VDD) resistor r=0.1084 c=0
Rk187 (\5\:VDD \6\:VDD) resistor r=0.2907 c=0
Rk188 (\6\:VDD \7\:VDD) resistor r=0.464 c=0
Rk189 (\7\:VDD \8\:VDD) resistor r=0.1492 c=0
Rk190 (\5\:VDD \10\:VDD) resistor r=0.04428 c=0
Rk191 (\6\:VDD \12\:VDD) resistor r=0.04428 c=0
Rk192 (\7\:VDD \14\:VDD) resistor r=0.04428 c=0
Rk193 (\8\:VDD \16\:VDD) resistor r=0.07263 c=0
Rk194 (\8\:VDD \17\:VDD) resistor r=0.4766 c=0
Rk195 (\17\:VDD \19\:VDD) resistor r=0.04428 c=0
Rk196 (\17\:VDD \20\:VDD) resistor r=0.4003 c=0
Rk197 (\20\:VDD \22\:VDD) resistor r=0.04428 c=0
Rk198 (\20\:VDD \23\:VDD) resistor r=0.3429 c=0
Rk199 (\23\:VDD \24\:VDD) resistor r=0.08038 c=0
Rk200 (\24\:VDD \26\:VDD) resistor r=0.04428 c=0
Rk201 (\24\:VDD \27\:VDD) resistor r=0.3315 c=0
Rk202 (\27\:VDD \29\:VDD) resistor r=0.04428 c=0
Rk203 (\27\:VDD \30\:VDD) resistor r=0.2907 c=0
Rk204 (\30\:VDD \32\:VDD) resistor r=0.04428 c=0
Rk205 (\30\:VDD \33\:VDD) resistor r=0.464 c=0
Rk206 (\33\:VDD \35\:VDD) resistor r=0.04428 c=0
Rk207 (\33\:VDD \36\:VDD) resistor r=0.04725 c=0
Rk208 (\36\:VDD \37\:VDD) resistor r=0.1288 c=0
Rk209 (\37\:VDD \39\:VDD) resistor r=0.04428 c=0
Rk210 (\37\:VDD \40\:VDD) resistor r=0.4462 c=0
Rk211 (\40\:VDD \42\:VDD) resistor r=0.04428 c=0
Rk212 (\40\:VDD \43\:VDD) resistor r=0.4003 c=0
Rk213 (\43\:VDD \45\:VDD) resistor r=0.04428 c=0
Rk214 (\43\:VDD \46\:VDD) resistor r=0.2409 c=0
Rk215 (\46\:VDD \47\:VDD) resistor r=0.2078 c=0
Rk216 (\47\:VDD \49\:VDD) resistor r=0.04428 c=0
Rk217 (\47\:VDD \50\:VDD) resistor r=0.4385 c=0
Rk218 (\50\:VDD \52\:VDD) resistor r=0.04428 c=0
Rk219 (\50\:VDD \53\:VDD) resistor r=0.4003 c=0
Rk220 (\53\:VDD \55\:VDD) resistor r=0.04428 c=0
Rk221 (\53\:VDD \56\:VDD) resistor r=0.1696 c=0
Rk222 (\56\:VDD \57\:VDD) resistor r=0.2766 c=0
Rk223 (\57\:VDD \59\:VDD) resistor r=0.04428 c=0
Rk224 (\57\:VDD \60\:VDD) resistor r=0.1761 c=0
Rk225 (\60\:VDD \62\:VDD) resistor r=0.04428 c=0
Rk226 (\60\:VDD \63\:VDD) resistor r=0.464 c=0
Rk227 (\63\:VDD \65\:VDD) resistor r=0.04428 c=0
Rk228 (\63\:VDD \66\:VDD) resistor r=0.3003 c=0
Rk229 (\66\:VDD \68\:VDD) resistor r=0.07263 c=0
Rk232 (\69\:VDD VDD) resistor r=0.1311 c=0
Rk230 (\66\:VDD \69\:VDD) resistor r=0.3255 c=0
Rk231 (\69\:VDD \71\:VDD) resistor r=0.04428 c=0
Rk233 (VDD \72\:VDD) resistor r=0.2921 c=0
Rk234 (\72\:VDD \74\:VDD) resistor r=0.04428 c=0
Rk235 (\72\:VDD \75\:VDD) resistor r=0.4003 c=0
Rk236 (\75\:VDD \77\:VDD) resistor r=0.04428 c=0
Rk237 (\75\:VDD \78\:VDD) resistor r=0.06764 c=0
Rk238 (\78\:VDD \79\:VDD) resistor r=0.3785 c=0
Rk239 (\79\:VDD \81\:VDD) resistor r=0.04428 c=0
Rk240 (\79\:VDD \82\:VDD) resistor r=0.1761 c=0
Rk241 (\82\:VDD \84\:VDD) resistor r=0.04428 c=0
Rk242 (\82\:VDD \85\:VDD) resistor r=0.464 c=0
Rk243 (\85\:VDD \87\:VDD) resistor r=0.04428 c=0
Rk244 (\85\:VDD \88\:VDD) resistor r=0.1976 c=0
Rk245 (\88\:VDD \89\:VDD) resistor r=0.09312 c=0
Rk246 (\89\:VDD \91\:VDD) resistor r=0.04428 c=0
Rk247 (\89\:VDD \93\:VDD) resistor r=0.3941 c=0
Rk153 (\29\:SE \30\:SE) resistor r=0.2693 c=0
Rk154 (\30\:SE \31\:SE) resistor r=0.6104 c=0
Rk155 (\31\:SE \32\:SE) resistor r=4.2375 c=0
Rk156 (\32\:SE \33\:SE) resistor r=0.3953 c=0
Rk157 (\33\:SE \34\:SE) resistor r=1.2826 c=0
Rk158 (\34\:SE \35\:SE) resistor r=0.3953 c=0
Rk159 (\35\:SE \36\:SE) resistor r=4.2375 c=0
Rk160 (\36\:SE \37\:SE) resistor r=0.7282 c=0
Rk161 (\37\:SE \38\:SE) resistor r=0.2693 c=0
Rk162 (\31\:SE \39\:SE) resistor r=0.2357 c=0
Rk163 (\32\:SE \40\:SE) resistor r=0.2103 c=0
Rk164 (\40\:SE \41\:SE) resistor r=0.2693 c=0
Rk165 (\33\:SE \42\:SE) resistor r=0.2357 c=0
Rk167 (\43\:SE SE) resistor r=0.03339 c=0
Rk166 (\34\:SE \43\:SE) resistor r=0.2357 c=0
Rk168 (\35\:SE \44\:SE) resistor r=0.2103 c=0
Rk169 (\44\:SE \45\:SE) resistor r=0.2693 c=0
Rk170 (\36\:SE \46\:SE) resistor r=0.2357 c=0
Rk117 (Q4 \2\:Q4) resistor r=0.01601 c=0
Rk118 (\2\:Q4 \4\:Q4) resistor r=0.2754 c=0
Rk99 (\4\:D4 D4) resistor r=0.01763 c=0
Rk144 (\29\:RN \30\:RN) resistor r=1.3244 c=0
Rk145 (\30\:RN \31\:RN) resistor r=3.9183 c=0
Rk146 (\31\:RN \32\:RN) resistor r=1.3244 c=0
Rk152 (\33\:RN RN) resistor r=0.01663 c=0
Rk147 (\32\:RN \33\:RN) resistor r=2.5557 c=0
Rk148 (\33\:RN \34\:RN) resistor r=2.9173 c=0
Rk149 (\34\:RN \35\:RN) resistor r=1.3244 c=0
Rk150 (\35\:RN \36\:RN) resistor r=3.9183 c=0
Rk151 (\36\:RN \37\:RN) resistor r=1.3244 c=0
Rk94 (SI4 \4\:SI4) resistor r=0.007782 c=0
Rk96 (\4\:SI4 \5\:SI4) resistor r=0.03299 c=0
Rk95 (\5\:SI4 \6\:SI4) resistor r=0.007782 c=0
Rk63 (CK \5\:CK) resistor r=0.01189 c=0
Rk62 (\4\:CK \5\:CK) resistor r=0.004283 c=0
Rk1 (Q1N \2\:Q1N) resistor r=0.03697 c=0
Rk2 (Q1N \4\:Q1N) resistor r=0.2019 c=0
Rk7 (\4\:Q1 Q1) resistor r=0.01569 c=0
Rk6 (\2\:Q1 \4\:Q1) resistor r=0.2754 c=0
Rk21 (\4\:D1 D1) resistor r=0.01784 c=0
Rk26 (\4\:SI1 \5\:SI1) resistor r=0.007782 c=0
Rk27 (SI1 \6\:SI1) resistor r=0.007782 c=0
Rk28 (\4\:SI1 \6\:SI1) resistor r=0.03341 c=0
Rk31 (Q2N \2\:Q2N) resistor r=0.03697 c=0
Rk32 (Q2N \4\:Q2N) resistor r=0.2019 c=0
Rk37 (\4\:Q2 Q2) resistor r=0.01569 c=0
Rk36 (\2\:Q2 \4\:Q2) resistor r=0.2754 c=0
Rk51 (\4\:D2 D2) resistor r=0.01784 c=0
Rk56 (\4\:SI2 \5\:SI2) resistor r=0.007782 c=0
Rk57 (SI2 \6\:SI2) resistor r=0.007782 c=0
Rk58 (\4\:SI2 \6\:SI2) resistor r=0.03341 c=0
Rk92 (Q3N \2\:Q3N) resistor r=0.03697 c=0
Rk93 (Q3N \4\:Q3N) resistor r=0.2019 c=0
Rk87 (Q3 \2\:Q3) resistor r=0.01601 c=0
Rk88 (\2\:Q3 \4\:Q3) resistor r=0.2754 c=0
Rk69 (\4\:D3 D3) resistor r=0.01763 c=0
Rk64 (SI3 \4\:SI3) resistor r=0.007782 c=0
Rk66 (\4\:SI3 \5\:SI3) resistor r=0.03299 c=0
Rk65 (\5\:SI3 \6\:SI3) resistor r=0.007782 c=0
Rk61 (\23\:Ckbb \25\:Ckbb) resistor r=0.3117 c=0
Rk171 (\33\:Ckbb \34\:Ckbb) resistor r=0.8175 c=0
Rk172 (\34\:Ckbb \35\:Ckbb) resistor r=0.4931 c=0
Rk173 (\35\:Ckbb \36\:Ckbb) resistor r=3.5547 c=0
Rk174 (\36\:Ckbb \37\:Ckbb) resistor r=0.8175 c=0
Rk175 (\37\:Ckbb \38\:Ckbb) resistor r=0.4931 c=0
Rk176 (\38\:Ckbb \39\:Ckbb) resistor r=2.1531 c=0
Rk177 (\39\:Ckbb \40\:Ckbb) resistor r=1.51 c=0
Rk178 (\40\:Ckbb \41\:Ckbb) resistor r=0.4931 c=0
Rk179 (\41\:Ckbb \42\:Ckbb) resistor r=0.8175 c=0
Rk180 (\42\:Ckbb \43\:Ckbb) resistor r=3.5547 c=0
Rk181 (\43\:Ckbb \44\:Ckbb) resistor r=0.4931 c=0
Rk182 (\44\:Ckbb \45\:Ckbb) resistor r=0.8175 c=0
Rk122 (\33\:CKb \34\:CKb) resistor r=0.6853 c=0
Rk123 (\34\:CKb \35\:CKb) resistor r=1.0064 c=0
Rk124 (\35\:CKb \36\:CKb) resistor r=3.4184 c=0
Rk125 (\36\:CKb \37\:CKb) resistor r=0.3071 c=0
Rk126 (\37\:CKb \38\:CKb) resistor r=1.0064 c=0
Rk127 (\38\:CKb \39\:CKb) resistor r=2.0396 c=0
Rk128 (\39\:CKb \40\:CKb) resistor r=1.9091 c=0
Rk129 (\40\:CKb \41\:CKb) resistor r=1.0064 c=0
Rk130 (\41\:CKb \42\:CKb) resistor r=0.3071 c=0
Rk131 (\42\:CKb \43\:CKb) resistor r=3.4184 c=0
Rk132 (\43\:CKb \44\:CKb) resistor r=1.0064 c=0
Rk133 (\44\:CKb \45\:CKb) resistor r=0.7764 c=0
Rk134 (\34\:CKb \46\:CKb) resistor r=0.2841 c=0
Rk135 (\36\:CKb \47\:CKb) resistor r=0.3766 c=0
Rk136 (\37\:CKb \48\:CKb) resistor r=0.2841 c=0
Rk137 (\39\:CKb \49\:CKb) resistor r=0.1135 c=0
Rk138 (\49\:CKb \50\:CKb) resistor r=0.2158 c=0
Rk139 (\50\:CKb \52\:CKb) resistor r=0.2758 c=0
Rk140 (\41\:CKb \53\:CKb) resistor r=0.2841 c=0
Rk141 (\42\:CKb \54\:CKb) resistor r=0.3766 c=0
Rk142 (\44\:CKb \55\:CKb) resistor r=0.2841 c=0
Rk143 (\49\:CKb \57\:CKb) resistor r=0.202 c=0
Rk22 (\2\:Db \3\:Db) resistor r=0.2084 c=0
Rk23 (\3\:Db \5\:Db) resistor r=0.3022 c=0
Rk24 (\3\:Db \7\:Db) resistor r=0.559 c=0
Rk25 (\5\:Db \9\:Db) resistor r=0.4427 c=0
Rk3 (\6\:qint \7\:qint) resistor r=0.1049 c=0
Rk4 (\7\:qint \8\:qint) resistor r=0.1212 c=0
Rk5 (\7\:qint \10\:qint) resistor r=0.1254 c=0
Rk17 (\2\:n6 \4\:n6) resistor r=0.222 c=0
Rk29 (\5\:SEb \7\:SEb) resistor r=0.4204 c=0
Rk30 (\7\:SEb \8\:SEb) resistor r=0.5473 c=0
Rk8 (\11\:qbint \13\:qbint) resistor r=0.5653 c=0
Rk9 (\13\:qbint \14\:qbint) resistor r=0.3414 c=0
Rk10 (\14\:qbint \15\:qbint) resistor r=0.1588 c=0
Rk11 (\14\:qbint \17\:qbint) resistor r=0.206 c=0
Rk18 (\6\:n20 \7\:n20) resistor r=0.269 c=0
Rk19 (\7\:n20 \8\:n20) resistor r=0.5797 c=0
Rk20 (\7\:n20 \10\:n20) resistor r=0.1946 c=0
Rk12 (\5\:n30 \7\:n30) resistor r=0.3718 c=0
Rk13 (\7\:n30 \8\:n30) resistor r=0.5769 c=0
Rk14 (\4\:mout \5\:mout) resistor r=0.4556 c=0
Rk15 (\5\:mout \7\:mout) resistor r=0.1207 c=0
Rk16 (\5\:mout \9\:mout) resistor r=0.2146 c=0
Rk52 (\2\:Db_2 \3\:Db_2) resistor r=0.2084 c=0
Rk53 (\3\:Db_2 \5\:Db_2) resistor r=0.3022 c=0
Rk54 (\3\:Db_2 \7\:Db_2) resistor r=0.559 c=0
Rk55 (\5\:Db_2 \9\:Db_2) resistor r=0.4427 c=0
Rk33 (\6\:qint_2 \7\:qint_2) resistor r=0.1049 c=0
Rk34 (\7\:qint_2 \8\:qint_2) resistor r=0.1212 c=0
Rk35 (\7\:qint_2 \10\:qint_2) resistor r=0.1254 c=0
Rk47 (\2\:n6_2 \4\:n6_2) resistor r=0.222 c=0
Rk59 (\5\:SEb_2 \7\:SEb_2) resistor r=0.4177 c=0
Rk60 (\7\:SEb_2 \8\:SEb_2) resistor r=0.5473 c=0
Rk38 (\11\:qbint_2 \13\:qbint_2) resistor r=0.5653 c=0
Rk39 (\13\:qbint_2 \14\:qbint_2) resistor r=0.3414 c=0
Rk40 (\14\:qbint_2 \15\:qbint_2) resistor r=0.1588 c=0
Rk41 (\14\:qbint_2 \17\:qbint_2) resistor r=0.206 c=0
Rk48 (\6\:n20_2 \7\:n20_2) resistor r=0.269 c=0
Rk49 (\7\:n20_2 \8\:n20_2) resistor r=0.5797 c=0
Rk50 (\7\:n20_2 \10\:n20_2) resistor r=0.1946 c=0
Rk42 (\5\:n30_2 \7\:n30_2) resistor r=0.3718 c=0
Rk43 (\7\:n30_2 \8\:n30_2) resistor r=0.5769 c=0
Rk44 (\4\:mout_2 \5\:mout_2) resistor r=0.4556 c=0
Rk45 (\5\:mout_2 \7\:mout_2) resistor r=0.1207 c=0
Rk46 (\5\:mout_2 \9\:mout_2) resistor r=0.2146 c=0
Rk70 (\2\:Db_3 \3\:Db_3) resistor r=0.6063 c=0
Rk71 (\3\:Db_3 \5\:Db_3) resistor r=0.3022 c=0
Rk72 (\3\:Db_3 \7\:Db_3) resistor r=0.2084 c=0
Rk73 (\5\:Db_3 \9\:Db_3) resistor r=0.4427 c=0
Rk89 (\5\:qint_3 \6\:qint_3) resistor r=0.1212 c=0
Rk90 (\6\:qint_3 \8\:qint_3) resistor r=0.1254 c=0
Rk91 (\6\:qint_3 \10\:qint_3) resistor r=0.1049 c=0
Rk74 (\2\:n6_3 \4\:n6_3) resistor r=0.222 c=0
Rk67 (\4\:SEb_3 \6\:SEb_3) resistor r=0.5488 c=0
Rk68 (\6\:SEb_3 \8\:SEb_3) resistor r=0.4152 c=0
Rk83 (\11\:qbint_3 \12\:qbint_3) resistor r=0.1588 c=0
Rk84 (\12\:qbint_3 \14\:qbint_3) resistor r=0.3414 c=0
Rk85 (\14\:qbint_3 \15\:qbint_3) resistor r=0.5649 c=0
Rk86 (\12\:qbint_3 \17\:qbint_3) resistor r=0.2017 c=0
Rk75 (\5\:n20_3 \6\:n20_3) resistor r=0.5797 c=0
Rk76 (\6\:n20_3 \8\:n20_3) resistor r=0.2666 c=0
Rk77 (\6\:n20_3 \10\:n20_3) resistor r=0.1946 c=0
Rk81 (\5\:n30_3 \7\:n30_3) resistor r=0.3726 c=0
Rk82 (\7\:n30_3 \8\:n30_3) resistor r=0.5799 c=0
Rk78 (\5\:mout_3 \6\:mout_3) resistor r=0.2448 c=0
Rk79 (\6\:mout_3 \7\:mout_3) resistor r=0.4556 c=0
Rk80 (\6\:mout_3 \9\:mout_3) resistor r=0.1207 c=0
Rk100 (\2\:Db_4 \3\:Db_4) resistor r=0.6063 c=0
Rk101 (\3\:Db_4 \5\:Db_4) resistor r=0.3022 c=0
Rk102 (\3\:Db_4 \7\:Db_4) resistor r=0.2084 c=0
Rk103 (\5\:Db_4 \9\:Db_4) resistor r=0.4427 c=0
Rk119 (\5\:qint_4 \6\:qint_4) resistor r=0.1212 c=0
Rk120 (\6\:qint_4 \8\:qint_4) resistor r=0.1254 c=0
Rk121 (\6\:qint_4 \10\:qint_4) resistor r=0.1049 c=0
Rk104 (\2\:n6_4 \4\:n6_4) resistor r=0.222 c=0
Rk97 (\4\:SEb_4 \6\:SEb_4) resistor r=0.5488 c=0
Rk98 (\6\:SEb_4 \8\:SEb_4) resistor r=0.4208 c=0
Rk113 (\11\:qbint_4 \12\:qbint_4) resistor r=0.1588 c=0
Rk114 (\12\:qbint_4 \14\:qbint_4) resistor r=0.3414 c=0
Rk115 (\14\:qbint_4 \15\:qbint_4) resistor r=0.5649 c=0
Rk116 (\12\:qbint_4 \17\:qbint_4) resistor r=0.2017 c=0
Rk105 (\5\:n20_4 \6\:n20_4) resistor r=0.5797 c=0
Rk106 (\6\:n20_4 \8\:n20_4) resistor r=0.2666 c=0
Rk107 (\6\:n20_4 \10\:n20_4) resistor r=0.1946 c=0
Rk111 (\5\:n30_4 \7\:n30_4) resistor r=0.3726 c=0
Rk112 (\7\:n30_4 \8\:n30_4) resistor r=0.5799 c=0
Rk108 (\5\:mout_4 \6\:mout_4) resistor r=0.2448 c=0
Rk109 (\6\:mout_4 \7\:mout_4) resistor r=0.4556 c=0
Rk110 (\6\:mout_4 \9\:mout_4) resistor r=0.1207 c=0
Rl136 (\27\:SE \28\:SE) resistor r=52.6149 c=0
Rl133 (\25\:SE \26\:SE) resistor r=33.3841 c=0
Rl129 (\22\:SE \23\:SE) resistor r=54.5379 c=0
Rl130 (\23\:SE \24\:SE) resistor r=41.0764 c=0
Rl95 (\20\:SE \21\:SE) resistor r=52.6149 c=0
Rl92 (\18\:SE \19\:SE) resistor r=33.3841 c=0
Rl88 (\15\:SE \16\:SE) resistor r=54.5379 c=0
Rl89 (\16\:SE \17\:SE) resistor r=41.0764 c=0
Rl81 (\12\:SE \13\:SE) resistor r=54.5379 c=0
Rl82 (\13\:SE \14\:SE) resistor r=41.0764 c=0
Rl78 (\10\:SE \11\:SE) resistor r=33.3841 c=0
Rl75 (\8\:SE \9\:SE) resistor r=52.6149 c=0
Rl40 (\5\:SE \6\:SE) resistor r=54.5379 c=0
Rl41 (\6\:SE \7\:SE) resistor r=41.0764 c=0
Rl37 (\3\:SE \4\:SE) resistor r=33.3841 c=0
Rl34 (\1\:SE \2\:SE) resistor r=52.6149 c=0
Rl137 (\1\:D4 \2\:D4) resistor r=91.5405 c=0
Rl138 (\2\:D4 \3\:D4) resistor r=35.7713 c=0
Rl146 (\23\:RN \24\:RN) resistor r=147.643 c=0
Rl105 (\16\:RN \17\:RN) resistor r=147.643 c=0
Rl65 (\12\:RN \13\:RN) resistor r=147.643 c=0
Rl24 (\5\:RN \6\:RN) resistor r=147.643 c=0
Rl158 (\27\:RN \28\:RN) resistor r=52.6149 c=0
Rl157 (\26\:RN \27\:RN) resistor r=51.1559 c=0
Rl156 (\25\:RN \26\:RN) resistor r=47.3097 c=0
Rl145 (\22\:RN \23\:RN) resistor r=52.6149 c=0
Rl117 (\20\:RN \21\:RN) resistor r=52.6149 c=0
Rl116 (\19\:RN \20\:RN) resistor r=51.1559 c=0
Rl115 (\18\:RN \19\:RN) resistor r=47.3097 c=0
Rl104 (\15\:RN \16\:RN) resistor r=52.6149 c=0
Rl66 (\13\:RN \14\:RN) resistor r=52.6149 c=0
Rl54 (\9\:RN \10\:RN) resistor r=51.1559 c=0
Rl53 (\8\:RN \9\:RN) resistor r=47.3097 c=0
Rl55 (\10\:RN \11\:RN) resistor r=52.6149 c=0
Rl25 (\6\:RN \7\:RN) resistor r=52.6149 c=0
Rl13 (\2\:RN \3\:RN) resistor r=51.1559 c=0
Rl12 (\1\:RN \2\:RN) resistor r=47.3097 c=0
Rl14 (\3\:RN \4\:RN) resistor r=52.6149 c=0
Rl132 (\2\:SI4 \3\:SI4) resistor r=89.1533 c=0
Rl131 (\1\:SI4 \2\:SI4) resistor r=41.0764 c=0
Rl86 (\1\:CK \2\:CK) resistor r=24.2328 c=0
Rl87 (\2\:CK \3\:CK) resistor r=58.8482 c=0
Rl32 (\1\:D1 \2\:D1) resistor r=91.5405 c=0
Rl33 (\2\:D1 \3\:D1) resistor r=35.7713 c=0
Rl39 (\2\:SI1 \3\:SI1) resistor r=89.1533 c=0
Rl38 (\1\:SI1 \2\:SI1) resistor r=41.0764 c=0
Rl73 (\1\:D2 \2\:D2) resistor r=91.5405 c=0
Rl74 (\2\:D2 \3\:D2) resistor r=35.7713 c=0
Rl80 (\2\:SI2 \3\:SI2) resistor r=89.1533 c=0
Rl79 (\1\:SI2 \2\:SI2) resistor r=41.0764 c=0
Rl96 (\1\:D3 \2\:D3) resistor r=91.5405 c=0
Rl97 (\2\:D3 \3\:D3) resistor r=35.7713 c=0
Rl91 (\2\:SI3 \3\:SI3) resistor r=89.1533 c=0
Rl90 (\1\:SI3 \2\:SI3) resistor r=41.0764 c=0
Rl151 (\30\:Ckbb \31\:Ckbb) resistor r=183.747 c=0
Rl110 (\19\:Ckbb \20\:Ckbb) resistor r=183.747 c=0
Rl60 (\9\:Ckbb \10\:Ckbb) resistor r=183.747 c=0
Rl19 (\2\:Ckbb \3\:Ckbb) resistor r=183.747 c=0
Rl152 (\31\:Ckbb \32\:Ckbb) resistor r=62.6944 c=0
Rl142 (\28\:Ckbb \29\:Ckbb) resistor r=62.6944 c=0
Rl139 (\26\:Ckbb \27\:Ckbb) resistor r=230.67 c=0
Rl111 (\20\:Ckbb \21\:Ckbb) resistor r=62.6944 c=0
Rl101 (\17\:Ckbb \18\:Ckbb) resistor r=62.6944 c=0
Rl98 (\15\:Ckbb \16\:Ckbb) resistor r=230.67 c=0
Rl72 (\13\:Ckbb \14\:Ckbb) resistor r=230.67 c=0
Rl69 (\11\:Ckbb \12\:Ckbb) resistor r=62.6944 c=0
Rl59 (\8\:Ckbb \9\:Ckbb) resistor r=62.6944 c=0
Rl31 (\6\:Ckbb \7\:Ckbb) resistor r=230.67 c=0
Rl28 (\4\:Ckbb \5\:Ckbb) resistor r=62.6944 c=0
Rl18 (Ckbb \2\:Ckbb) resistor r=62.6944 c=0
Rl140 (\26\:CKb \27\:CKb) resistor r=109.983 c=0
Rl99 (\19\:CKb \20\:CKb) resistor r=109.983 c=0
Rl71 (\13\:CKb \14\:CKb) resistor r=109.983 c=0
Rl30 (\6\:CKb \7\:CKb) resistor r=109.983 c=0
Rl153 (\31\:CKb \32\:CKb) resistor r=31.9251 c=0
Rl150 (\29\:CKb \30\:CKb) resistor r=24.2328 c=0
Rl141 (\27\:CKb \28\:CKb) resistor r=32.9066 c=0
Rl112 (\24\:CKb \25\:CKb) resistor r=31.9251 c=0
Rl109 (\22\:CKb \23\:CKb) resistor r=24.2328 c=0
Rl100 (\20\:CKb \21\:CKb) resistor r=32.9066 c=0
Rl70 (\12\:CKb \13\:CKb) resistor r=33.8727 c=0
Rl61 (\10\:CKb \11\:CKb) resistor r=24.2328 c=0
Rl58 (\8\:CKb \9\:CKb) resistor r=31.9251 c=0
Rl29 (\5\:CKb \6\:CKb) resistor r=33.8727 c=0
Rl20 (\3\:CKb \4\:CKb) resistor r=24.2328 c=0
Rl17 (CKb \2\:CKb) resistor r=31.9251 c=0
Rl85 (\16\:CKb \18\:CKb) resistor r=64.2642 c=0
Rl84 (\16\:CKb \17\:CKb) resistor r=37.3411 c=0
Rl83 (\15\:CKb \16\:CKb) resistor r=1.2334 c=0
Rl3 (\2\:qint \4\:qint) resistor r=38.1757 c=0
Rl2 (\2\:qint \3\:qint) resistor r=45.868 c=0
Rl1 (qint \2\:qint) resistor r=5.915 c=0
Rl35 (SEb \2\:SEb) resistor r=26.9231 c=0
Rl36 (\2\:SEb \3\:SEb) resistor r=148.376 c=0
Rl15 (\8\:qbint \9\:qbint) resistor r=62.2302 c=0
Rl16 (\9\:qbint \10\:qbint) resistor r=39.1533 c=0
Rl4 (qbint \2\:qbint) resistor r=41.3231 c=0
Rl7 (\2\:qbint \5\:qbint) resistor r=49.0154 c=0
Rl8 (\2\:qbint \6\:qbint) resistor r=5.6723 c=0
Rl9 (\3\:qbint \7\:qbint) resistor r=30.0028 c=0
Rl6 (\3\:qbint \4\:qbint) resistor r=58.8489 c=0
Rl5 (\2\:qbint \3\:qbint) resistor r=145.337 c=0
Rl23 (\2\:n20 \4\:n20) resistor r=36.2526 c=0
Rl22 (\2\:n20 \3\:n20) resistor r=82.4064 c=0
Rl21 (n20 \2\:n20) resistor r=2.7713 c=0
Rl11 (\2\:n30 \3\:n30) resistor r=58.4254 c=0
Rl10 (n30 \2\:n30) resistor r=49.9532 c=0
Rl26 (mout \2\:mout) resistor r=72.3097 c=0
Rl27 (\2\:mout \3\:mout) resistor r=26.1559 c=0
Rl44 (\2\:qint_2 \4\:qint_2) resistor r=38.1757 c=0
Rl43 (\2\:qint_2 \3\:qint_2) resistor r=45.868 c=0
Rl42 (qint_2 \2\:qint_2) resistor r=5.915 c=0
Rl76 (SEb_2 \2\:SEb_2) resistor r=26.9231 c=0
Rl77 (\2\:SEb_2 \3\:SEb_2) resistor r=148.376 c=0
Rl56 (\8\:qbint_2 \9\:qbint_2) resistor r=62.2302 c=0
Rl57 (\9\:qbint_2 \10\:qbint_2) resistor r=39.1533 c=0
Rl45 (qbint_2 \2\:qbint_2) resistor r=41.3231 c=0
Rl48 (\2\:qbint_2 \5\:qbint_2) resistor r=49.0154 c=0
Rl49 (\2\:qbint_2 \6\:qbint_2) resistor r=5.6723 c=0
Rl50 (\3\:qbint_2 \7\:qbint_2) resistor r=30.0028 c=0
Rl47 (\3\:qbint_2 \4\:qbint_2) resistor r=58.8489 c=0
Rl46 (\2\:qbint_2 \3\:qbint_2) resistor r=145.337 c=0
Rl64 (\2\:n20_2 \4\:n20_2) resistor r=36.2526 c=0
Rl63 (\2\:n20_2 \3\:n20_2) resistor r=82.4064 c=0
Rl62 (n20_2 \2\:n20_2) resistor r=2.7713 c=0
Rl52 (\2\:n30_2 \3\:n30_2) resistor r=58.4254 c=0
Rl51 (n30_2 \2\:n30_2) resistor r=49.9532 c=0
Rl67 (mout_2 \2\:mout_2) resistor r=72.3097 c=0
Rl68 (\2\:mout_2 \3\:mout_2) resistor r=26.1559 c=0
Rl126 (qint_3 \2\:qint_3) resistor r=38.1757 c=0
Rl128 (\2\:qint_3 \4\:qint_3) resistor r=45.868 c=0
Rl127 (\2\:qint_3 \3\:qint_3) resistor r=5.9102 c=0
Rl94 (\2\:SEb_3 \3\:SEb_3) resistor r=26.3736 c=0
Rl93 (SEb_3 \2\:SEb_3) resistor r=147.512 c=0
Rl113 (qbint_3 \2\:qbint_3) resistor r=62.2302 c=0
Rl114 (\2\:qbint_3 \3\:qbint_3) resistor r=39.1533 c=0
Rl120 (\4\:qbint_3 \5\:qbint_3) resistor r=30.0028 c=0
Rl123 (\5\:qbint_3 \8\:qbint_3) resistor r=58.8489 c=0
Rl125 (\6\:qbint_3 \10\:qbint_3) resistor r=41.3231 c=0
Rl124 (\6\:qbint_3 \9\:qbint_3) resistor r=49.0154 c=0
Rl122 (\6\:qbint_3 \7\:qbint_3) resistor r=5.6723 c=0
Rl121 (\5\:qbint_3 \6\:qbint_3) resistor r=145.337 c=0
Rl106 (n20_3 \2\:n20_3) resistor r=36.2526 c=0
Rl108 (\2\:n20_3 \4\:n20_3) resistor r=82.4064 c=0
Rl107 (\2\:n20_3 \3\:n20_3) resistor r=2.7666 c=0
Rl118 (n30_3 \2\:n30_3) resistor r=57.5621 c=0
Rl119 (\2\:n30_3 \3\:n30_3) resistor r=49.8142 c=0
Rl102 (mout_3 \2\:mout_3) resistor r=72.3097 c=0
Rl103 (\2\:mout_3 \3\:mout_3) resistor r=26.1559 c=0
Rl167 (qint_4 \2\:qint_4) resistor r=38.1757 c=0
Rl169 (\2\:qint_4 \4\:qint_4) resistor r=45.868 c=0
Rl168 (\2\:qint_4 \3\:qint_4) resistor r=5.9102 c=0
Rl135 (\2\:SEb_4 \3\:SEb_4) resistor r=26.3736 c=0
Rl134 (SEb_4 \2\:SEb_4) resistor r=147.512 c=0
Rl154 (qbint_4 \2\:qbint_4) resistor r=62.2302 c=0
Rl155 (\2\:qbint_4 \3\:qbint_4) resistor r=39.1533 c=0
Rl161 (\4\:qbint_4 \5\:qbint_4) resistor r=30.0028 c=0
Rl164 (\5\:qbint_4 \8\:qbint_4) resistor r=58.8489 c=0
Rl166 (\6\:qbint_4 \10\:qbint_4) resistor r=41.3231 c=0
Rl165 (\6\:qbint_4 \9\:qbint_4) resistor r=49.0154 c=0
Rl163 (\6\:qbint_4 \7\:qbint_4) resistor r=5.6723 c=0
Rl162 (\5\:qbint_4 \6\:qbint_4) resistor r=145.337 c=0
Rl147 (n20_4 \2\:n20_4) resistor r=36.2526 c=0
Rl149 (\2\:n20_4 \4\:n20_4) resistor r=82.4064 c=0
Rl148 (\2\:n20_4 \3\:n20_4) resistor r=2.7666 c=0
Rl159 (n30_4 \2\:n30_4) resistor r=57.5621 c=0
Rl160 (\2\:n30_4 \3\:n30_4) resistor r=49.8142 c=0
Rl143 (mout_4 \2\:mout_4) resistor r=72.3097 c=0
Rl144 (\2\:mout_4 \3\:mout_4) resistor r=26.1559 c=0
Rz53 (\1\:VSS \2\:VSS) resistor r=75 c=0
Rz54 (\26\:VSS \27\:VSS) resistor r=75 c=0
Rz55 (\28\:VSS \29\:VSS) resistor r=75 c=0
Rz56 (\30\:VSS \31\:VSS) resistor r=75 c=0
Rz57 (\32\:VSS \33\:VSS) resistor r=75 c=0
Rz58 (\34\:VSS \35\:VSS) resistor r=75 c=0
Rz59 (\36\:VSS \37\:VSS) resistor r=75 c=0
Rz60 (\38\:VSS \39\:VSS) resistor r=75 c=0
Rz61 (\40\:VSS \41\:VSS) resistor r=75 c=0
Rz62 (\42\:VSS \43\:VSS) resistor r=75 c=0
Rz63 (\44\:VSS \45\:VSS) resistor r=75 c=0
Rz64 (\46\:VSS \47\:VSS) resistor r=75 c=0
Rz65 (\48\:VSS \49\:VSS) resistor r=75 c=0
Rz66 (\50\:VSS \51\:VSS) resistor r=75 c=0
Rz67 (\52\:VSS \53\:VSS) resistor r=75 c=0
Rz68 (\54\:VSS \55\:VSS) resistor r=75 c=0
Rz69 (\56\:VSS \57\:VSS) resistor r=75 c=0
Rz70 (\66\:VSS \67\:VSS) resistor r=75 c=0
Rz71 (\68\:VSS \69\:VSS) resistor r=75 c=0
Rz72 (\70\:VSS \71\:VSS) resistor r=75 c=0
Rz73 (\72\:VSS \73\:VSS) resistor r=75 c=0
Rz74 (\74\:VSS \75\:VSS) resistor r=75 c=0
Rz75 (\76\:VSS \77\:VSS) resistor r=75 c=0
Rz76 (\78\:VSS \79\:VSS) resistor r=75 c=0
Rz77 (\80\:VSS \81\:VSS) resistor r=75 c=0
Rz43 (\1\:Q4N \2\:Q4N) resistor r=75 c=0
Rz44 (\3\:VDD \4\:VDD) resistor r=9.375 c=0
Rz45 (\3\:VDD \8\:VDD) resistor r=6.25 c=0
Rz46 (\3\:VDD \23\:VDD) resistor r=6.25 c=0
Rz47 (\3\:VDD \36\:VDD) resistor r=6.25 c=0
Rz48 (\3\:VDD \46\:VDD) resistor r=6.25 c=0
Rz49 (\3\:VDD \56\:VDD) resistor r=6.25 c=0
Rz50 (\3\:VDD \66\:VDD) resistor r=6.25 c=0
Rz51 (\3\:VDD \78\:VDD) resistor r=6.25 c=0
Rz52 (\3\:VDD \88\:VDD) resistor r=6.25 c=0
Rz39 (\3\:Q4 \4\:Q4) resistor r=75 c=0
Rz1 (\1\:Q1N \2\:Q1N) resistor r=75 c=0
Rz3 (\1\:Q1 \2\:Q1) resistor r=75 c=0
Rz11 (\1\:Q2N \2\:Q2N) resistor r=75 c=0
Rz13 (\1\:Q2 \2\:Q2) resistor r=75 c=0
Rz31 (\1\:Q3N \2\:Q3N) resistor r=75 c=0
Rz29 (\3\:Q3 \4\:Q3) resistor r=75 c=0
Rz21 (\22\:Ckbb \23\:Ckbb) resistor r=75 c=0
Rz42 (\22\:Ckbb \39\:Ckbb) resistor r=37.5 c=0
Rz41 (\51\:CKb \52\:CKb) resistor r=75 c=0
Rz8 (\6\:Db \7\:Db) resistor r=75 c=0
Rz9 (\8\:Db \9\:Db) resistor r=75 c=0
Rz2 (\9\:qint \10\:qint) resistor r=75 c=0
Rz10 (\4\:SEb \5\:SEb) resistor r=75 c=0
Rz4 (\16\:qbint \17\:qbint) resistor r=75 c=0
Rz7 (\9\:n20 \10\:n20) resistor r=75 c=0
Rz5 (\6\:n30 \7\:n30) resistor r=75 c=0
Rz6 (\6\:mout \7\:mout) resistor r=75 c=0
Rz18 (\6\:Db_2 \7\:Db_2) resistor r=75 c=0
Rz19 (\8\:Db_2 \9\:Db_2) resistor r=75 c=0
Rz12 (\9\:qint_2 \10\:qint_2) resistor r=75 c=0
Rz20 (\4\:SEb_2 \5\:SEb_2) resistor r=75 c=0
Rz14 (\16\:qbint_2 \17\:qbint_2) resistor r=75 c=0
Rz17 (\9\:n20_2 \10\:n20_2) resistor r=75 c=0
Rz15 (\6\:n30_2 \7\:n30_2) resistor r=75 c=0
Rz16 (\6\:mout_2 \7\:mout_2) resistor r=75 c=0
Rz23 (Db_3 \2\:Db_3) resistor r=75 c=0
Rz24 (\8\:Db_3 \9\:Db_3) resistor r=75 c=0
Rz30 (\7\:qint_3 \8\:qint_3) resistor r=75 c=0
Rz22 (\7\:SEb_3 \8\:SEb_3) resistor r=75 c=0
Rz28 (\16\:qbint_3 \17\:qbint_3) resistor r=75 c=0
Rz25 (\9\:n20_3 \10\:n20_3) resistor r=75 c=0
Rz27 (\6\:n30_3 \7\:n30_3) resistor r=75 c=0
Rz26 (\8\:mout_3 \9\:mout_3) resistor r=75 c=0
Rz33 (Db_4 \2\:Db_4) resistor r=75 c=0
Rz34 (\8\:Db_4 \9\:Db_4) resistor r=75 c=0
Rz40 (\7\:qint_4 \8\:qint_4) resistor r=75 c=0
Rz32 (\7\:SEb_4 \8\:SEb_4) resistor r=75 c=0
Rz38 (\16\:qbint_4 \17\:qbint_4) resistor r=75 c=0
Rz35 (\9\:n20_4 \10\:n20_4) resistor r=75 c=0
Rz37 (\6\:n30_4 \7\:n30_4) resistor r=75 c=0
Rz36 (\8\:mout_4 \9\:mout_4) resistor r=75 c=0
Ry80 (\3\:VSS \4\:VSS) resistor r=7.75 c=0
Ry81 (\3\:VSS \8\:VSS) resistor r=5.1667 c=0
Ry82 (\3\:VSS \11\:VSS) resistor r=5.1667 c=0
Ry83 (\3\:VSS \15\:VSS) resistor r=5.1667 c=0
Ry84 (\3\:VSS \18\:VSS) resistor r=5.1667 c=0
Ry85 (\3\:VSS \22\:VSS) resistor r=5.1667 c=0
Ry86 (\3\:VSS \25\:VSS) resistor r=5.1667 c=0
Ry87 (\3\:VSS \61\:VSS) resistor r=5.1667 c=0
Ry88 (\3\:VSS \64\:VSS) resistor r=5.1667 c=0
Ry50 (\3\:Q4N \4\:Q4N) resistor r=31 c=0
Ry51 (\1\:VDD \2\:VDD) resistor r=62 c=0
Ry52 (\9\:VDD \10\:VDD) resistor r=62 c=0
Ry53 (\11\:VDD \12\:VDD) resistor r=62 c=0
Ry54 (\13\:VDD \14\:VDD) resistor r=62 c=0
Ry55 (\15\:VDD \16\:VDD) resistor r=62 c=0
Ry56 (\18\:VDD \19\:VDD) resistor r=62 c=0
Ry57 (\21\:VDD \22\:VDD) resistor r=62 c=0
Ry58 (\25\:VDD \26\:VDD) resistor r=62 c=0
Ry59 (\28\:VDD \29\:VDD) resistor r=62 c=0
Ry60 (\31\:VDD \32\:VDD) resistor r=62 c=0
Ry61 (\34\:VDD \35\:VDD) resistor r=62 c=0
Ry62 (\38\:VDD \39\:VDD) resistor r=62 c=0
Ry63 (\41\:VDD \42\:VDD) resistor r=62 c=0
Ry64 (\44\:VDD \45\:VDD) resistor r=62 c=0
Ry65 (\48\:VDD \49\:VDD) resistor r=62 c=0
Ry66 (\51\:VDD \52\:VDD) resistor r=62 c=0
Ry67 (\54\:VDD \55\:VDD) resistor r=62 c=0
Ry68 (\58\:VDD \59\:VDD) resistor r=62 c=0
Ry69 (\61\:VDD \62\:VDD) resistor r=62 c=0
Ry70 (\64\:VDD \65\:VDD) resistor r=62 c=0
Ry71 (\67\:VDD \68\:VDD) resistor r=62 c=0
Ry72 (\70\:VDD \71\:VDD) resistor r=62 c=0
Ry73 (\73\:VDD \74\:VDD) resistor r=62 c=0
Ry74 (\76\:VDD \77\:VDD) resistor r=62 c=0
Ry75 (\80\:VDD \81\:VDD) resistor r=62 c=0
Ry76 (\83\:VDD \84\:VDD) resistor r=62 c=0
Ry77 (\86\:VDD \87\:VDD) resistor r=62 c=0
Ry78 (\90\:VDD \91\:VDD) resistor r=62 c=0
Ry79 (\92\:VDD \93\:VDD) resistor r=62 c=0
Ry47 (\1\:Q4 \2\:Q4) resistor r=31 c=0
Ry1 (\3\:Q1N \4\:Q1N) resistor r=31 c=0
Ry3 (\3\:Q1 \4\:Q1) resistor r=31 c=0
Ry13 (\3\:Q2N \4\:Q2N) resistor r=31 c=0
Ry15 (\3\:Q2 \4\:Q2) resistor r=31 c=0
Ry37 (\3\:Q3N \4\:Q3N) resistor r=31 c=0
Ry35 (\1\:Q3 \2\:Q3) resistor r=31 c=0
Ry25 (\24\:Ckbb \25\:Ckbb) resistor r=62 c=0
Ry49 (\56\:CKb \57\:CKb) resistor r=62 c=0
Ry10 (Db \2\:Db) resistor r=62 c=0
Ry11 (\4\:Db \5\:Db) resistor r=62 c=0
Ry2 (\5\:qint \6\:qint) resistor r=62 c=0
Ry7 (n6 \2\:n6) resistor r=62 c=0
Ry8 (\3\:n6 \4\:n6) resistor r=62 c=0
Ry12 (\6\:SEb \7\:SEb) resistor r=62 c=0
Ry4 (\12\:qbint \13\:qbint) resistor r=62 c=0
Ry9 (\5\:n20 \6\:n20) resistor r=62 c=0
Ry5 (\4\:n30 \5\:n30) resistor r=62 c=0
Ry6 (\8\:mout \9\:mout) resistor r=62 c=0
Ry22 (Db_2 \2\:Db_2) resistor r=62 c=0
Ry23 (\4\:Db_2 \5\:Db_2) resistor r=62 c=0
Ry14 (\5\:qint_2 \6\:qint_2) resistor r=62 c=0
Ry19 (n6_2 \2\:n6_2) resistor r=62 c=0
Ry20 (\3\:n6_2 \4\:n6_2) resistor r=62 c=0
Ry24 (\6\:SEb_2 \7\:SEb_2) resistor r=62 c=0
Ry16 (\12\:qbint_2 \13\:qbint_2) resistor r=62 c=0
Ry21 (\5\:n20_2 \6\:n20_2) resistor r=62 c=0
Ry17 (\4\:n30_2 \5\:n30_2) resistor r=62 c=0
Ry18 (\8\:mout_2 \9\:mout_2) resistor r=62 c=0
Ry27 (\4\:Db_3 \5\:Db_3) resistor r=62 c=0
Ry28 (\6\:Db_3 \7\:Db_3) resistor r=62 c=0
Ry36 (\9\:qint_3 \10\:qint_3) resistor r=62 c=0
Ry29 (n6_3 \2\:n6_3) resistor r=62 c=0
Ry30 (\3\:n6_3 \4\:n6_3) resistor r=62 c=0
Ry26 (\5\:SEb_3 \6\:SEb_3) resistor r=62 c=0
Ry34 (\13\:qbint_3 \14\:qbint_3) resistor r=62 c=0
Ry31 (\7\:n20_3 \8\:n20_3) resistor r=62 c=0
Ry33 (\4\:n30_3 \5\:n30_3) resistor r=62 c=0
Ry32 (\4\:mout_3 \5\:mout_3) resistor r=62 c=0
Ry39 (\4\:Db_4 \5\:Db_4) resistor r=62 c=0
Ry40 (\6\:Db_4 \7\:Db_4) resistor r=62 c=0
Ry48 (\9\:qint_4 \10\:qint_4) resistor r=62 c=0
Ry41 (n6_4 \2\:n6_4) resistor r=62 c=0
Ry42 (\3\:n6_4 \4\:n6_4) resistor r=62 c=0
Ry38 (\5\:SEb_4 \6\:SEb_4) resistor r=62 c=0
Ry46 (\13\:qbint_4 \14\:qbint_4) resistor r=62 c=0
Ry43 (\7\:n20_4 \8\:n20_4) resistor r=62 c=0
Ry45 (\4\:n30_4 \5\:n30_4) resistor r=62 c=0
Ry44 (\4\:mout_4 \5\:mout_4) resistor r=62 c=0
Rx59 (\28\:SE \29\:SE) resistor r=45 c=0
Rx60 (\26\:SE \30\:SE) resistor r=45 c=0
Rx61 (\4\:SE \37\:SE) resistor r=45 c=0
Rx62 (\2\:SE \38\:SE) resistor r=45 c=0
Rx63 (\23\:SE \39\:SE) resistor r=45 c=0
Rx64 (\19\:SE \40\:SE) resistor r=45 c=0
Rx65 (\21\:SE \41\:SE) resistor r=45 c=0
Rx66 (\16\:SE \42\:SE) resistor r=45 c=0
Rx67 (\13\:SE \43\:SE) resistor r=45 c=0
Rx68 (\11\:SE \44\:SE) resistor r=45 c=0
Rx69 (\9\:SE \45\:SE) resistor r=45 c=0
Rx70 (\6\:SE \46\:SE) resistor r=45 c=0
Rx31 (\2\:D4 \4\:D4) resistor r=45 c=0
Rx51 (\28\:RN \29\:RN) resistor r=45 c=0
Rx52 (\22\:RN \30\:RN) resistor r=45 c=0
Rx53 (\21\:RN \31\:RN) resistor r=45 c=0
Rx54 (\15\:RN \32\:RN) resistor r=45 c=0
Rx55 (\14\:RN \34\:RN) resistor r=45 c=0
Rx56 (\11\:RN \35\:RN) resistor r=45 c=0
Rx57 (\7\:RN \36\:RN) resistor r=45 c=0
Rx58 (\4\:RN \37\:RN) resistor r=45 c=0
Rx29 (\2\:SI4 \6\:SI4) resistor r=45 c=0
Rx19 (\2\:CK \4\:CK) resistor r=45 c=0
Rx7 (\2\:D1 \4\:D1) resistor r=45 c=0
Rx8 (\2\:SI1 \5\:SI1) resistor r=45 c=0
Rx16 (\2\:D2 \4\:D2) resistor r=45 c=0
Rx17 (\2\:SI2 \5\:SI2) resistor r=45 c=0
Rx22 (\2\:D3 \4\:D3) resistor r=45 c=0
Rx20 (\2\:SI3 \6\:SI3) resistor r=45 c=0
Rx71 (\32\:Ckbb \33\:Ckbb) resistor r=45 c=0
Rx72 (\29\:Ckbb \34\:Ckbb) resistor r=45 c=0
Rx73 (\27\:Ckbb \35\:Ckbb) resistor r=45 c=0
Rx74 (\21\:Ckbb \36\:Ckbb) resistor r=45 c=0
Rx75 (\18\:Ckbb \37\:Ckbb) resistor r=45 c=0
Rx76 (\16\:Ckbb \38\:Ckbb) resistor r=45 c=0
Rx77 (\14\:Ckbb \40\:Ckbb) resistor r=45 c=0
Rx78 (\12\:Ckbb \41\:Ckbb) resistor r=45 c=0
Rx79 (\8\:Ckbb \42\:Ckbb) resistor r=45 c=0
Rx80 (\7\:Ckbb \43\:Ckbb) resistor r=45 c=0
Rx81 (\5\:Ckbb \44\:Ckbb) resistor r=45 c=0
Rx82 (Ckbb \45\:Ckbb) resistor r=45 c=0
Rx38 (\32\:CKb \33\:CKb) resistor r=45 c=0
Rx39 (\28\:CKb \35\:CKb) resistor r=45 c=0
Rx40 (\21\:CKb \38\:CKb) resistor r=45 c=0
Rx41 (\12\:CKb \40\:CKb) resistor r=45 c=0
Rx42 (\5\:CKb \43\:CKb) resistor r=45 c=0
Rx43 (\2\:CKb \45\:CKb) resistor r=45 c=0
Rx44 (\30\:CKb \46\:CKb) resistor r=45 c=0
Rx45 (\25\:CKb \47\:CKb) resistor r=45 c=0
Rx46 (\23\:CKb \48\:CKb) resistor r=45 c=0
Rx47 (\15\:CKb \50\:CKb) resistor r=45 c=0
Rx48 (\11\:CKb \53\:CKb) resistor r=45 c=0
Rx49 (\9\:CKb \54\:CKb) resistor r=45 c=0
Rx50 (\4\:CKb \55\:CKb) resistor r=45 c=0
Rx1 (qint \8\:qint) resistor r=45 c=0
Rx9 (\2\:SEb \8\:SEb) resistor r=45 c=0
Rx2 (\9\:qbint \11\:qbint) resistor r=45 c=0
Rx3 (\6\:qbint \15\:qbint) resistor r=45 c=0
Rx6 (n20 \8\:n20) resistor r=45 c=0
Rx4 (\2\:n30 \8\:n30) resistor r=45 c=0
Rx5 (\2\:mout \4\:mout) resistor r=45 c=0
Rx10 (qint_2 \8\:qint_2) resistor r=45 c=0
Rx18 (\2\:SEb_2 \8\:SEb_2) resistor r=45 c=0
Rx11 (\9\:qbint_2 \11\:qbint_2) resistor r=45 c=0
Rx12 (\6\:qbint_2 \15\:qbint_2) resistor r=45 c=0
Rx15 (n20_2 \8\:n20_2) resistor r=45 c=0
Rx13 (\2\:n30_2 \8\:n30_2) resistor r=45 c=0
Rx14 (\2\:mout_2 \4\:mout_2) resistor r=45 c=0
Rx28 (\3\:qint_3 \5\:qint_3) resistor r=45 c=0
Rx21 (\2\:SEb_3 \4\:SEb_3) resistor r=45 c=0
Rx26 (\7\:qbint_3 \11\:qbint_3) resistor r=45 c=0
Rx27 (\2\:qbint_3 \15\:qbint_3) resistor r=45 c=0
Rx23 (\3\:n20_3 \5\:n20_3) resistor r=45 c=0
Rx25 (\2\:n30_3 \8\:n30_3) resistor r=45 c=0
Rx24 (\2\:mout_3 \7\:mout_3) resistor r=45 c=0
Rx37 (\3\:qint_4 \5\:qint_4) resistor r=45 c=0
Rx30 (\2\:SEb_4 \4\:SEb_4) resistor r=45 c=0
Rx35 (\7\:qbint_4 \11\:qbint_4) resistor r=45 c=0
Rx36 (\2\:qbint_4 \15\:qbint_4) resistor r=45 c=0
Rx32 (\3\:n20_4 \5\:n20_4) resistor r=45 c=0
Rx34 (\2\:n30_4 \8\:n30_4) resistor r=45 c=0
Rx33 (\2\:mout_4 \7\:mout_4) resistor r=45 c=0
NM38 (\1\:Q4N \4\:qint_4 \1\:VSS VSS) g45n1svt w=(2.6e-07) l=4.5e-08 \
        nf=1 as=7.48e-14 ad=3.64e-14 ps=1.6e-06 pd=8e-07 nrd=1.16667 \
        nrs=1.16667 sa=2.66058e-07 sb=1.4e-07 sd=160n sca=17.5885 \
        scb=0.0172826 scc=0.00162584 m=(1)
NM40 (\3\:Q4 \9\:qbint_4 \26\:VSS VSS) g45n1svt w=(2.6e-07) l=4.5e-08 \
        nf=1 as=6.97e-14 ad=3.64e-14 ps=1.5e-06 pd=8e-07 nrd=1.16667 \
        nrs=1.16667 sa=1.4e-07 sb=1.4e-07 sd=160n sca=17.5885 \
        scb=0.0172826 scc=0.00162584 m=(1)
NM37 (\1\:Q3N \4\:qint_3 \36\:VSS VSS) g45n1svt w=(2.6e-07) l=4.5e-08 \
        nf=1 as=7.48e-14 ad=3.64e-14 ps=1.6e-06 pd=8e-07 nrd=1.16667 \
        nrs=1.16667 sa=2.66058e-07 sb=1.4e-07 sd=160n sca=17.5885 \
        scb=0.0172826 scc=0.00162584 m=(1)
NM35 (\3\:Q3 \9\:qbint_3 \38\:VSS VSS) g45n1svt w=(2.6e-07) l=4.5e-08 \
        nf=1 as=6.97e-14 ad=3.64e-14 ps=1.5e-06 pd=8e-07 nrd=1.16667 \
        nrs=1.16667 sa=1.4e-07 sb=1.4e-07 sd=160n sca=17.5885 \
        scb=0.0172826 scc=0.00162584 m=(1)
NM19 (\1\:Q2N \3\:qint_2 \70\:VSS VSS) g45n1svt w=(2.6e-07) l=4.5e-08 \
        nf=1 as=7.48e-14 ad=3.64e-14 ps=1.6e-06 pd=8e-07 nrd=1.16667 \
        nrs=1.16667 sa=2.66058e-07 sb=1.4e-07 sd=160n sca=17.5885 \
        scb=0.0172826 scc=0.00162584 m=(1)
NM17 (\1\:Q2 \5\:qbint_2 \68\:VSS VSS) g45n1svt w=(2.6e-07) l=4.5e-08 \
        nf=1 as=6.97e-14 ad=3.64e-14 ps=1.5e-06 pd=8e-07 nrd=1.16667 \
        nrs=1.16667 sa=1.4e-07 sb=1.4e-07 sd=160n sca=17.5885 \
        scb=0.0172826 scc=0.00162584 m=(1)
mn57 (\1\:Q1N \3\:qint \66\:VSS VSS) g45n1svt w=(2.6e-07) l=4.5e-08 nf=1 \
        as=7.48e-14 ad=3.64e-14 ps=1.6e-06 pd=8e-07 nrd=1.16667 \
        nrs=1.16667 sa=2.66058e-07 sb=1.4e-07 sd=160n sca=17.5885 \
        scb=0.0172826 scc=0.00162584 m=(1)
mn55 (\1\:Q1 \5\:qbint \80\:VSS VSS) g45n1svt w=(2.6e-07) l=4.5e-08 nf=1 \
        as=6.97e-14 ad=3.64e-14 ps=1.5e-06 pd=8e-07 nrd=1.16667 \
        nrs=1.16667 sa=1.4e-07 sb=1.4e-07 sd=160n sca=17.5885 \
        scb=0.0172826 scc=0.00162584 m=(1)
mn21 (\22\:Ckbb \17\:CKb \48\:VSS VSS) g45n1svt w=(1.45e-07) l=4.5e-08 \
        nf=1 as=9.708e-14 ad=6.752e-14 ps=1.51e-06 pd=1.56e-06 nrd=1.16667 \
        nrs=1.16667 sa=2.3e-07 sb=3.6e-07 sd=160n sca=19.8813 \
        scb=0.0206549 scc=0.00197265 m=(1)
mn20 (\51\:CKb \3\:CK \48\:VSS VSS) g45n1svt w=(1.45e-07) l=4.5e-08 nf=1 \
        as=2.03e-14 ad=6.752e-14 ps=5.7e-07 pd=1.56e-06 nrd=1.16667 \
        nrs=1.16667 sa=4.5e-07 sb=1.4e-07 sd=160n sca=19.8813 \
        scb=0.0206549 scc=0.00197265 m=(1)
NM39 (\7\:qint_4 \8\:qbint_4 \1\:VSS VSS) g45n1svt w=(1.45e-07) \
        l=4.5e-08 nf=1 as=2.03e-14 ad=7.48e-14 ps=5.7e-07 pd=1.6e-06 \
        nrd=1.16667 nrs=1.16667 sa=3.7e-07 sb=1.4e-07 sd=160n sca=23.279 \
        scb=0.0230742 scc=0.00267719 m=(1)
NM44 (\16\:qbint_4 \3\:n30_4 n9_4 VSS) g45n1svt w=(1.45e-07) l=4.5e-08 \
        nf=1 as=1.45e-14 ad=2.392e-14 ps=4.9e-07 pd=6.2e-07 nrd=1.16667 \
        nrs=1.16667 sa=2e-06 sb=1.65e-07 sd=160n sca=15.7071 scb=0.0167369 \
        scc=0.00113434 m=(1)
NM43 (n9_4 \25\:RN \28\:VSS VSS) g45n1svt w=(1.45e-07) l=4.5e-08 nf=1 \
        as=1.45e-14 ad=7.75e-14 ps=4.9e-07 pd=1.49e-06 nrd=1.16667 \
        nrs=1.16667 sa=3.1e-07 sb=1.91e-06 sd=160n sca=15.7071 \
        scb=0.0167369 scc=0.00113434 m=(1)
NM42 (n11_4 \3\:qbint_4 \28\:VSS VSS) g45n1svt w=(1.45e-07) l=4.5e-08 \
        nf=1 as=1.957e-14 ad=7.75e-14 ps=5.6e-07 pd=1.49e-06 nrd=1.16667 \
        nrs=1.16667 sa=5.75e-07 sb=1.645e-06 sd=160n sca=15.7071 \
        scb=0.0167369 scc=0.00113434 m=(1)
NM41 (\6\:n30_4 \31\:CKb n11_4 VSS) g45n1svt w=(1.45e-07) l=4.5e-08 nf=1 \
        as=1.957e-14 ad=2.9e-14 ps=5.6e-07 pd=6.9e-07 nrd=1.16667 \
        nrs=1.16667 sa=1.465e-06 sb=7.55e-07 sd=160n sca=15.7071 \
        scb=0.0167369 scc=0.00113434 m=(1)
NM45 (\8\:mout_4 \31\:Ckbb \6\:n30_4 VSS) g45n1svt w=(1.45e-07) l=4.5e-08 \
        nf=1 as=3.335e-14 ad=2.9e-14 ps=7.5e-07 pd=6.9e-07 nrd=1.16667 \
        nrs=1.16667 sa=1e-06 sb=1.22e-06 sd=160n sca=15.7071 scb=0.0167369 \
        scc=0.00113434 m=(1)
NM49 (\8\:mout_4 \4\:n20_4 \30\:VSS VSS) g45n1svt w=(1.45e-07) l=4.5e-08 \
        nf=1 as=8.475e-14 ad=3.335e-14 ps=1.59e-06 pd=7.5e-07 nrd=1.16667 \
        nrs=1.16667 sa=9.45e-07 sb=1.275e-06 sd=160n sca=15.7071 \
        scb=0.0167369 scc=0.00113434 m=(1)
NM47 (n7_4 \24\:RN \30\:VSS VSS) g45n1svt w=(1.45e-07) l=4.5e-08 nf=1 \
        as=8.7e-15 ad=8.475e-14 ps=4.1e-07 pd=1.59e-06 nrd=1.16667 \
        nrs=1.16667 sa=1.59e-06 sb=6.3e-07 sd=160n sca=15.7071 \
        scb=0.0167369 scc=0.00113434 m=(1)
NM46 (n5_4 \3\:mout_4 n7_4 VSS) g45n1svt w=(1.45e-07) l=4.5e-08 nf=1 \
        as=1.957e-14 ad=8.7e-15 ps=5.6e-07 pd=4.1e-07 nrd=1.16667 \
        nrs=1.16667 sa=1.695e-06 sb=5.25e-07 sd=160n sca=15.7071 \
        scb=0.0167369 scc=0.00113434 m=(1)
NM48 (\9\:n20_4 \28\:Ckbb n5_4 VSS) g45n1svt w=(1.45e-07) l=4.5e-08 nf=1 \
        as=1.957e-14 ad=2.32e-14 ps=5.6e-07 pd=6.1e-07 nrd=1.16667 \
        nrs=1.16667 sa=3.45e-07 sb=1.875e-06 sd=160n sca=15.7071 \
        scb=0.0167369 scc=0.00113434 m=(1)
NM50 (\8\:Db_4 \26\:CKb \9\:n20_4 VSS) g45n1svt w=(1.45e-07) l=4.5e-08 \
        nf=1 as=2.32e-14 ad=2.03e-14 ps=6.1e-07 pd=5.7e-07 nrd=1.16667 \
        nrs=1.16667 sa=1.4e-07 sb=2e-06 sd=160n sca=15.7071 scb=0.0167369 \
        scc=0.00113434 m=(1)
NM54 (n1_4 \3\:D4 \32\:VSS VSS) g45n1svt w=(1.45e-07) l=4.5e-08 nf=1 \
        as=5.027e-14 ad=2.03e-14 ps=1.33e-06 pd=5.7e-07 nrd=1.16667 \
        nrs=1.16667 sa=8.86379e-07 sb=1.25e-07 sd=160n sca=12.9138 \
        scb=0.0133404 scc=0.000640143 m=(1)
NM53 (Db_4 SEb_4 n1_4 VSS) g45n1svt w=(1.45e-07) l=4.5e-08 nf=1 \
        as=2.03e-14 ad=3.77e-14 ps=5.7e-07 pd=8.1e-07 nrd=1.16667 \
        nrs=1.16667 sa=7.01379e-07 sb=3.1e-07 sd=160n sca=12.9138 \
        scb=0.0133404 scc=0.000640143 m=(1)
NM52 (Db_4 \25\:SE n3_4 VSS) g45n1svt w=(1.45e-07) l=4.5e-08 nf=1 \
        as=3.77e-14 ad=8.7e-15 ps=8.1e-07 pd=4.1e-07 nrd=1.16667 \
        nrs=1.16667 sa=6.15e-07 sb=3.96379e-07 sd=160n sca=12.9138 \
        scb=0.0133404 scc=0.000640143 m=(1)
NM51 (n3_4 \1\:SI4 \34\:VSS VSS) g45n1svt w=(1.45e-07) l=4.5e-08 nf=1 \
        as=8.7e-15 ad=7.87e-14 ps=4.1e-07 pd=1.6e-06 nrd=1.16667 \
        nrs=1.16667 sa=7.2e-07 sb=2.91379e-07 sd=160n sca=12.9138 \
        scb=0.0133404 scc=0.000640143 m=(1)
NM55 (\7\:SEb_4 \24\:SE \34\:VSS VSS) g45n1svt w=(1.45e-07) l=4.5e-08 \
        nf=1 as=7.87e-14 ad=3.262e-14 ps=1.6e-06 pd=7.4e-07 nrd=1.16667 \
        nrs=1.16667 sa=2.25e-07 sb=4.41897e-07 sd=160n sca=23.279 \
        scb=0.0230742 scc=0.00267719 m=(1)
NM36 (\7\:qint_3 \8\:qbint_3 \36\:VSS VSS) g45n1svt w=(1.45e-07) \
        l=4.5e-08 nf=1 as=2.03e-14 ad=7.48e-14 ps=5.7e-07 pd=1.6e-06 \
        nrd=1.16667 nrs=1.16667 sa=3.7e-07 sb=1.4e-07 sd=160n sca=23.279 \
        scb=0.0230742 scc=0.00267719 m=(1)
NM31 (\16\:qbint_3 \3\:n30_3 n9_3 VSS) g45n1svt w=(1.45e-07) l=4.5e-08 \
        nf=1 as=1.45e-14 ad=2.392e-14 ps=4.9e-07 pd=6.2e-07 nrd=1.16667 \
        nrs=1.16667 sa=2e-06 sb=1.65e-07 sd=160n sca=15.7071 scb=0.0167369 \
        scc=0.00113434 m=(1)
NM32 (n9_3 \18\:RN \40\:VSS VSS) g45n1svt w=(1.45e-07) l=4.5e-08 nf=1 \
        as=1.45e-14 ad=7.75e-14 ps=4.9e-07 pd=1.49e-06 nrd=1.16667 \
        nrs=1.16667 sa=3.1e-07 sb=1.91e-06 sd=160n sca=15.7071 \
        scb=0.0167369 scc=0.00113434 m=(1)
NM33 (n11_3 \3\:qbint_3 \40\:VSS VSS) g45n1svt w=(1.45e-07) l=4.5e-08 \
        nf=1 as=1.957e-14 ad=7.75e-14 ps=5.6e-07 pd=1.49e-06 nrd=1.16667 \
        nrs=1.16667 sa=5.75e-07 sb=1.645e-06 sd=160n sca=15.7071 \
        scb=0.0167369 scc=0.00113434 m=(1)
NM34 (\6\:n30_3 \24\:CKb n11_3 VSS) g45n1svt w=(1.45e-07) l=4.5e-08 nf=1 \
        as=1.957e-14 ad=2.9e-14 ps=5.6e-07 pd=6.9e-07 nrd=1.16667 \
        nrs=1.16667 sa=1.465e-06 sb=7.55e-07 sd=160n sca=15.7071 \
        scb=0.0167369 scc=0.00113434 m=(1)
NM30 (\8\:mout_3 \20\:Ckbb \6\:n30_3 VSS) g45n1svt w=(1.45e-07) l=4.5e-08 \
        nf=1 as=3.335e-14 ad=2.9e-14 ps=7.5e-07 pd=6.9e-07 nrd=1.16667 \
        nrs=1.16667 sa=1e-06 sb=1.22e-06 sd=160n sca=15.7071 scb=0.0167369 \
        scc=0.00113434 m=(1)
NM26 (\8\:mout_3 \4\:n20_3 \42\:VSS VSS) g45n1svt w=(1.45e-07) l=4.5e-08 \
        nf=1 as=8.475e-14 ad=3.335e-14 ps=1.59e-06 pd=7.5e-07 nrd=1.16667 \
        nrs=1.16667 sa=9.45e-07 sb=1.275e-06 sd=160n sca=15.7071 \
        scb=0.0167369 scc=0.00113434 m=(1)
NM28 (n7_3 \17\:RN \42\:VSS VSS) g45n1svt w=(1.45e-07) l=4.5e-08 nf=1 \
        as=8.7e-15 ad=8.475e-14 ps=4.1e-07 pd=1.59e-06 nrd=1.16667 \
        nrs=1.16667 sa=1.59e-06 sb=6.3e-07 sd=160n sca=15.7071 \
        scb=0.0167369 scc=0.00113434 m=(1)
NM29 (n5_3 \3\:mout_3 n7_3 VSS) g45n1svt w=(1.45e-07) l=4.5e-08 nf=1 \
        as=1.957e-14 ad=8.7e-15 ps=5.6e-07 pd=4.1e-07 nrd=1.16667 \
        nrs=1.16667 sa=1.695e-06 sb=5.25e-07 sd=160n sca=15.7071 \
        scb=0.0167369 scc=0.00113434 m=(1)
NM27 (\9\:n20_3 \17\:Ckbb n5_3 VSS) g45n1svt w=(1.45e-07) l=4.5e-08 nf=1 \
        as=1.957e-14 ad=2.32e-14 ps=5.6e-07 pd=6.1e-07 nrd=1.16667 \
        nrs=1.16667 sa=3.45e-07 sb=1.875e-06 sd=160n sca=15.7071 \
        scb=0.0167369 scc=0.00113434 m=(1)
NM25 (\8\:Db_3 \19\:CKb \9\:n20_3 VSS) g45n1svt w=(1.45e-07) l=4.5e-08 \
        nf=1 as=2.32e-14 ad=2.03e-14 ps=6.1e-07 pd=5.7e-07 nrd=1.16667 \
        nrs=1.16667 sa=1.4e-07 sb=2e-06 sd=160n sca=15.7071 scb=0.0167369 \
        scc=0.00113434 m=(1)
NM21 (n1_3 \3\:D3 \44\:VSS VSS) g45n1svt w=(1.45e-07) l=4.5e-08 nf=1 \
        as=5.027e-14 ad=2.03e-14 ps=1.33e-06 pd=5.7e-07 nrd=1.16667 \
        nrs=1.16667 sa=8.86379e-07 sb=1.25e-07 sd=160n sca=12.9138 \
        scb=0.0133404 scc=0.000640143 m=(1)
NM22 (Db_3 SEb_3 n1_3 VSS) g45n1svt w=(1.45e-07) l=4.5e-08 nf=1 \
        as=2.03e-14 ad=3.77e-14 ps=5.7e-07 pd=8.1e-07 nrd=1.16667 \
        nrs=1.16667 sa=7.01379e-07 sb=3.1e-07 sd=160n sca=12.9138 \
        scb=0.0133404 scc=0.000640143 m=(1)
NM23 (Db_3 \18\:SE n3_3 VSS) g45n1svt w=(1.45e-07) l=4.5e-08 nf=1 \
        as=3.77e-14 ad=8.7e-15 ps=8.1e-07 pd=4.1e-07 nrd=1.16667 \
        nrs=1.16667 sa=6.15e-07 sb=3.96379e-07 sd=160n sca=12.9138 \
        scb=0.0133404 scc=0.000640143 m=(1)
NM24 (n3_3 \1\:SI3 \46\:VSS VSS) g45n1svt w=(1.45e-07) l=4.5e-08 nf=1 \
        as=8.7e-15 ad=7.87e-14 ps=4.1e-07 pd=1.6e-06 nrd=1.16667 \
        nrs=1.16667 sa=7.2e-07 sb=2.91379e-07 sd=160n sca=12.9138 \
        scb=0.0133404 scc=0.000640143 m=(1)
NM20 (\7\:SEb_3 \17\:SE \46\:VSS VSS) g45n1svt w=(1.45e-07) l=4.5e-08 \
        nf=1 as=7.87e-14 ad=3.262e-14 ps=1.6e-06 pd=7.4e-07 nrd=1.16667 \
        nrs=1.16667 sa=2.25e-07 sb=4.41897e-07 sd=160n sca=23.279 \
        scb=0.0230742 scc=0.00267719 m=(1)
NM18 (\9\:qint_2 \4\:qbint_2 \70\:VSS VSS) g45n1svt w=(1.45e-07) \
        l=4.5e-08 nf=1 as=2.03e-14 ad=7.48e-14 ps=5.7e-07 pd=1.6e-06 \
        nrd=1.16667 nrs=1.16667 sa=3.7e-07 sb=1.4e-07 sd=160n sca=23.279 \
        scb=0.0230742 scc=0.00267719 m=(1)
NM13 (\16\:qbint_2 n30_2 n9_2 VSS) g45n1svt w=(1.45e-07) l=4.5e-08 nf=1 \
        as=1.45e-14 ad=2.392e-14 ps=4.9e-07 pd=6.2e-07 nrd=1.16667 \
        nrs=1.16667 sa=2e-06 sb=1.65e-07 sd=160n sca=15.7071 scb=0.0167369 \
        scc=0.00113434 m=(1)
NM14 (n9_2 \8\:RN \56\:VSS VSS) g45n1svt w=(1.45e-07) l=4.5e-08 nf=1 \
        as=1.45e-14 ad=7.75e-14 ps=4.9e-07 pd=1.49e-06 nrd=1.16667 \
        nrs=1.16667 sa=3.1e-07 sb=1.91e-06 sd=160n sca=15.7071 \
        scb=0.0167369 scc=0.00113434 m=(1)
NM15 (n11_2 \10\:qbint_2 \56\:VSS VSS) g45n1svt w=(1.45e-07) l=4.5e-08 \
        nf=1 as=1.957e-14 ad=7.75e-14 ps=5.6e-07 pd=1.49e-06 nrd=1.16667 \
        nrs=1.16667 sa=5.75e-07 sb=1.645e-06 sd=160n sca=15.7071 \
        scb=0.0167369 scc=0.00113434 m=(1)
NM16 (\6\:n30_2 \8\:CKb n11_2 VSS) g45n1svt w=(1.45e-07) l=4.5e-08 nf=1 \
        as=1.957e-14 ad=2.9e-14 ps=5.6e-07 pd=6.9e-07 nrd=1.16667 \
        nrs=1.16667 sa=1.465e-06 sb=7.55e-07 sd=160n sca=15.7071 \
        scb=0.0167369 scc=0.00113434 m=(1)
NM12 (\6\:mout_2 \9\:Ckbb \6\:n30_2 VSS) g45n1svt w=(1.45e-07) l=4.5e-08 \
        nf=1 as=3.335e-14 ad=2.9e-14 ps=7.5e-07 pd=6.9e-07 nrd=1.16667 \
        nrs=1.16667 sa=1e-06 sb=1.22e-06 sd=160n sca=15.7071 scb=0.0167369 \
        scc=0.00113434 m=(1)
NM8 (\6\:mout_2 \3\:n20_2 \54\:VSS VSS) g45n1svt w=(1.45e-07) l=4.5e-08 \
        nf=1 as=8.475e-14 ad=3.335e-14 ps=1.59e-06 pd=7.5e-07 nrd=1.16667 \
        nrs=1.16667 sa=9.45e-07 sb=1.275e-06 sd=160n sca=15.7071 \
        scb=0.0167369 scc=0.00113434 m=(1)
NM10 (n7_2 \12\:RN \54\:VSS VSS) g45n1svt w=(1.45e-07) l=4.5e-08 nf=1 \
        as=8.7e-15 ad=8.475e-14 ps=4.1e-07 pd=1.59e-06 nrd=1.16667 \
        nrs=1.16667 sa=1.59e-06 sb=6.3e-07 sd=160n sca=15.7071 \
        scb=0.0167369 scc=0.00113434 m=(1)
NM11 (n5_2 \3\:mout_2 n7_2 VSS) g45n1svt w=(1.45e-07) l=4.5e-08 nf=1 \
        as=1.957e-14 ad=8.7e-15 ps=5.6e-07 pd=4.1e-07 nrd=1.16667 \
        nrs=1.16667 sa=1.695e-06 sb=5.25e-07 sd=160n sca=15.7071 \
        scb=0.0167369 scc=0.00113434 m=(1)
NM9 (\9\:n20_2 \11\:Ckbb n5_2 VSS) g45n1svt w=(1.45e-07) l=4.5e-08 nf=1 \
        as=1.957e-14 ad=2.32e-14 ps=5.6e-07 pd=6.1e-07 nrd=1.16667 \
        nrs=1.16667 sa=3.45e-07 sb=1.875e-06 sd=160n sca=15.7071 \
        scb=0.0167369 scc=0.00113434 m=(1)
NM7 (\8\:Db_2 \14\:CKb \9\:n20_2 VSS) g45n1svt w=(1.45e-07) l=4.5e-08 \
        nf=1 as=2.32e-14 ad=2.03e-14 ps=6.1e-07 pd=5.7e-07 nrd=1.16667 \
        nrs=1.16667 sa=1.4e-07 sb=2e-06 sd=160n sca=15.7071 scb=0.0167369 \
        scc=0.00113434 m=(1)
NM1 (n1_2 \3\:D2 \52\:VSS VSS) g45n1svt w=(1.45e-07) l=4.5e-08 nf=1 \
        as=5.027e-14 ad=2.03e-14 ps=1.33e-06 pd=5.7e-07 nrd=1.16667 \
        nrs=1.16667 sa=8.86379e-07 sb=1.25e-07 sd=160n sca=12.9138 \
        scb=0.0133404 scc=0.000640143 m=(1)
NM2 (\6\:Db_2 \3\:SEb_2 n1_2 VSS) g45n1svt w=(1.45e-07) l=4.5e-08 nf=1 \
        as=2.03e-14 ad=3.77e-14 ps=5.7e-07 pd=8.1e-07 nrd=1.16667 \
        nrs=1.16667 sa=7.01379e-07 sb=3.1e-07 sd=160n sca=12.9138 \
        scb=0.0133404 scc=0.000640143 m=(1)
NM3 (\6\:Db_2 \10\:SE n3_2 VSS) g45n1svt w=(1.45e-07) l=4.5e-08 nf=1 \
        as=3.77e-14 ad=8.7e-15 ps=8.1e-07 pd=4.1e-07 nrd=1.16667 \
        nrs=1.16667 sa=6.15e-07 sb=3.96379e-07 sd=160n sca=12.9138 \
        scb=0.0133404 scc=0.000640143 m=(1)
NM4 (n3_2 \1\:SI2 \50\:VSS VSS) g45n1svt w=(1.45e-07) l=4.5e-08 nf=1 \
        as=8.7e-15 ad=7.87e-14 ps=4.1e-07 pd=1.6e-06 nrd=1.16667 \
        nrs=1.16667 sa=7.2e-07 sb=2.91379e-07 sd=160n sca=12.9138 \
        scb=0.0133404 scc=0.000640143 m=(1)
NM0 (\4\:SEb_2 \14\:SE \50\:VSS VSS) g45n1svt w=(1.45e-07) l=4.5e-08 \
        nf=1 as=7.87e-14 ad=3.262e-14 ps=1.6e-06 pd=7.4e-07 nrd=1.16667 \
        nrs=1.16667 sa=2.25e-07 sb=4.41897e-07 sd=160n sca=23.279 \
        scb=0.0230742 scc=0.00267719 m=(1)
mn56 (\9\:qint \4\:qbint \66\:VSS VSS) g45n1svt w=(1.45e-07) l=4.5e-08 \
        nf=1 as=2.03e-14 ad=7.48e-14 ps=5.7e-07 pd=1.6e-06 nrd=1.16667 \
        nrs=1.16667 sa=3.7e-07 sb=1.4e-07 sd=160n sca=23.279 scb=0.0230742 \
        scc=0.00267719 m=(1)
mn46 (\16\:qbint n30 n9 VSS) g45n1svt w=(1.45e-07) l=4.5e-08 nf=1 \
        as=1.45e-14 ad=2.392e-14 ps=4.9e-07 pd=6.2e-07 nrd=1.16667 \
        nrs=1.16667 sa=2e-06 sb=1.65e-07 sd=160n sca=15.7071 scb=0.0167369 \
        scc=0.00113434 m=(1)
mn45 (n9 \1\:RN \78\:VSS VSS) g45n1svt w=(1.45e-07) l=4.5e-08 nf=1 \
        as=1.45e-14 ad=7.75e-14 ps=4.9e-07 pd=1.49e-06 nrd=1.16667 \
        nrs=1.16667 sa=3.1e-07 sb=1.91e-06 sd=160n sca=15.7071 \
        scb=0.0167369 scc=0.00113434 m=(1)
mn50 (n11 \10\:qbint \78\:VSS VSS) g45n1svt w=(1.45e-07) l=4.5e-08 nf=1 \
        as=1.957e-14 ad=7.75e-14 ps=5.6e-07 pd=1.49e-06 nrd=1.16667 \
        nrs=1.16667 sa=5.75e-07 sb=1.645e-06 sd=160n sca=15.7071 \
        scb=0.0167369 scc=0.00113434 m=(1)
mn51 (\6\:n30 CKb n11 VSS) g45n1svt w=(1.45e-07) l=4.5e-08 nf=1 \
        as=1.957e-14 ad=2.9e-14 ps=5.6e-07 pd=6.9e-07 nrd=1.16667 \
        nrs=1.16667 sa=1.465e-06 sb=7.55e-07 sd=160n sca=15.7071 \
        scb=0.0167369 scc=0.00113434 m=(1)
mn40 (\6\:mout \2\:Ckbb \6\:n30 VSS) g45n1svt w=(1.45e-07) l=4.5e-08 nf=1 \
        as=3.335e-14 ad=2.9e-14 ps=7.5e-07 pd=6.9e-07 nrd=1.16667 \
        nrs=1.16667 sa=1e-06 sb=1.22e-06 sd=160n sca=15.7071 scb=0.0167369 \
        scc=0.00113434 m=(1)
mn30 (\6\:mout \3\:n20 \76\:VSS VSS) g45n1svt w=(1.45e-07) l=4.5e-08 \
        nf=1 as=8.475e-14 ad=3.335e-14 ps=1.59e-06 pd=7.5e-07 nrd=1.16667 \
        nrs=1.16667 sa=9.45e-07 sb=1.275e-06 sd=160n sca=15.7071 \
        scb=0.0167369 scc=0.00113434 m=(1)
mn35 (n7 \5\:RN \76\:VSS VSS) g45n1svt w=(1.45e-07) l=4.5e-08 nf=1 \
        as=8.7e-15 ad=8.475e-14 ps=4.1e-07 pd=1.59e-06 nrd=1.16667 \
        nrs=1.16667 sa=1.59e-06 sb=6.3e-07 sd=160n sca=15.7071 \
        scb=0.0167369 scc=0.00113434 m=(1)
mn36 (n5 \3\:mout n7 VSS) g45n1svt w=(1.45e-07) l=4.5e-08 nf=1 \
        as=1.957e-14 ad=8.7e-15 ps=5.6e-07 pd=4.1e-07 nrd=1.16667 \
        nrs=1.16667 sa=1.695e-06 sb=5.25e-07 sd=160n sca=15.7071 \
        scb=0.0167369 scc=0.00113434 m=(1)
mn37 (\9\:n20 \4\:Ckbb n5 VSS) g45n1svt w=(1.45e-07) l=4.5e-08 nf=1 \
        as=1.957e-14 ad=2.32e-14 ps=5.6e-07 pd=6.1e-07 nrd=1.16667 \
        nrs=1.16667 sa=3.45e-07 sb=1.875e-06 sd=160n sca=15.7071 \
        scb=0.0167369 scc=0.00113434 m=(1)
mn25 (\8\:Db \7\:CKb \9\:n20 VSS) g45n1svt w=(1.45e-07) l=4.5e-08 nf=1 \
        as=2.32e-14 ad=2.03e-14 ps=6.1e-07 pd=5.7e-07 nrd=1.16667 \
        nrs=1.16667 sa=1.4e-07 sb=2e-06 sd=160n sca=15.7071 scb=0.0167369 \
        scc=0.00113434 m=(1)
mn11 (n1 \3\:D1 \74\:VSS VSS) g45n1svt w=(1.45e-07) l=4.5e-08 nf=1 \
        as=5.027e-14 ad=2.03e-14 ps=1.33e-06 pd=5.7e-07 nrd=1.16667 \
        nrs=1.16667 sa=8.86379e-07 sb=1.25e-07 sd=160n sca=12.9138 \
        scb=0.0133404 scc=0.000640143 m=(1)
mn12 (\6\:Db \3\:SEb n1 VSS) g45n1svt w=(1.45e-07) l=4.5e-08 nf=1 \
        as=2.03e-14 ad=3.77e-14 ps=5.7e-07 pd=8.1e-07 nrd=1.16667 \
        nrs=1.16667 sa=7.01379e-07 sb=3.1e-07 sd=160n sca=12.9138 \
        scb=0.0133404 scc=0.000640143 m=(1)
mn14 (\6\:Db \3\:SE n3 VSS) g45n1svt w=(1.45e-07) l=4.5e-08 nf=1 \
        as=3.77e-14 ad=8.7e-15 ps=8.1e-07 pd=4.1e-07 nrd=1.16667 \
        nrs=1.16667 sa=6.15e-07 sb=3.96379e-07 sd=160n sca=12.9138 \
        scb=0.0133404 scc=0.000640143 m=(1)
mn13 (n3 \1\:SI1 \72\:VSS VSS) g45n1svt w=(1.45e-07) l=4.5e-08 nf=1 \
        as=8.7e-15 ad=7.87e-14 ps=4.1e-07 pd=1.6e-06 nrd=1.16667 \
        nrs=1.16667 sa=7.2e-07 sb=2.91379e-07 sd=160n sca=12.9138 \
        scb=0.0133404 scc=0.000640143 m=(1)
mn10 (\4\:SEb \7\:SE \72\:VSS VSS) g45n1svt w=(1.45e-07) l=4.5e-08 nf=1 \
        as=7.87e-14 ad=3.262e-14 ps=1.6e-06 pd=7.4e-07 nrd=1.16667 \
        nrs=1.16667 sa=2.25e-07 sb=4.41897e-07 sd=160n sca=23.279 \
        scb=0.0230742 scc=0.00267719 m=(1)
mp21 (\24\:Ckbb \18\:CKb \48\:VDD VDD) g45p1svt w=(2.15e-07) l=4.5e-08 \
        nf=1 as=3.01e-14 ad=8.732e-14 ps=7.1e-07 pd=1.85e-06 nrd=1.16667 \
        nrs=1.16667 sa=1.4e-07 sb=3.6e-07 sd=160n sca=31.508 scb=0.0252524 \
        scc=0.00399199 m=(1)
mp20 (\56\:CKb \1\:CK \48\:VDD VDD) g45p1svt w=(2.15e-07) l=4.5e-08 nf=1 \
        as=3.01e-14 ad=8.732e-14 ps=7.1e-07 pd=1.85e-06 nrd=1.16667 \
        nrs=1.16667 sa=3.6e-07 sb=1.4e-07 sd=160n sca=31.508 scb=0.0252524 \
        scc=0.00399199 m=(1)
PM43 (\13\:qbint_4 n30_4 \9\:VDD VDD) g45p1svt w=(2.15e-07) l=4.5e-08 \
        nf=1 as=1.4115e-13 ad=3.44e-14 ps=2.12e-06 pd=7.5e-07 nrd=1.16667 \
        nrs=1.16667 sa=1.69e-06 sb=5.15e-07 sd=160n sca=29.9075 \
        scb=0.0247057 scc=0.00372713 m=(1)
PM44 (\13\:qbint_4 \27\:RN \11\:VDD VDD) g45p1svt w=(2.15e-07) l=4.5e-08 \
        nf=1 as=3.44e-14 ad=1.049e-13 ps=7.5e-07 pd=1.83e-06 nrd=1.16667 \
        nrs=1.16667 sa=7.2e-07 sb=1.485e-06 sd=160n sca=29.9075 \
        scb=0.0247057 scc=0.00372713 m=(1)
PM42 (n8_4 qbint_4 \11\:VDD VDD) g45p1svt w=(2.15e-07) l=4.5e-08 nf=1 \
        as=1.049e-13 ad=3.01e-14 ps=1.83e-06 pd=7.1e-07 nrd=1.16667 \
        nrs=1.16667 sa=1.22e-06 sb=9.85e-07 sd=160n sca=29.9075 \
        scb=0.0247057 scc=0.00372713 m=(1)
PM41 (\4\:n30_4 \30\:Ckbb n8_4 VDD) g45p1svt w=(2.15e-07) l=4.5e-08 nf=1 \
        as=3.01e-14 ad=5.375e-14 ps=7.1e-07 pd=9.3e-07 nrd=1.16667 \
        nrs=1.16667 sa=1.035e-06 sb=1.17e-06 sd=160n sca=29.9075 \
        scb=0.0247057 scc=0.00372713 m=(1)
PM45 (\4\:n30_4 \29\:CKb \4\:mout_4 VDD) g45p1svt w=(2.15e-07) l=4.5e-08 \
        nf=1 as=3.762e-14 ad=5.375e-14 ps=7.8e-07 pd=9.3e-07 nrd=1.16667 \
        nrs=1.16667 sa=7.4e-07 sb=1.465e-06 sd=160n sca=29.9075 \
        scb=0.0247057 scc=0.00372713 m=(1)
PM49 (\4\:mout_4 n20_4 \13\:VDD VDD) g45p1svt w=(2.15e-07) l=4.5e-08 \
        nf=1 as=8.415e-14 ad=3.762e-14 ps=1.83e-06 pd=7.8e-07 nrd=1.16667 \
        nrs=1.16667 sa=5.2e-07 sb=1.685e-06 sd=160n sca=29.9075 \
        scb=0.0247057 scc=0.00372713 m=(1)
PM48 (n6_4 \23\:RN \13\:VDD VDD) g45p1svt w=(2.15e-07) l=4.5e-08 nf=1 \
        as=3.44e-14 ad=8.415e-14 ps=7.5e-07 pd=1.83e-06 nrd=1.16667 \
        nrs=1.16667 sa=1.9e-06 sb=3.05e-07 sd=160n sca=29.9075 \
        scb=0.0247057 scc=0.00372713 m=(1)
PM46 (n6_4 mout_4 \15\:VDD VDD) g45p1svt w=(2.15e-07) l=4.5e-08 nf=1 \
        as=3.44e-14 ad=6.29e-14 ps=7.5e-07 pd=1.83e-06 nrd=1.16667 \
        nrs=1.16667 sa=2e-06 sb=1e-07 sd=160n sca=29.9075 scb=0.0247057 \
        scc=0.00372713 m=(1)
PM47 (\7\:n20_4 \27\:CKb \3\:n6_4 VDD) g45p1svt w=(2.15e-07) l=4.5e-08 \
        nf=1 as=3.44e-14 ad=3.01e-14 ps=7.5e-07 pd=7.1e-07 nrd=1.16667 \
        nrs=1.16667 sa=1.4e-07 sb=3.31977e-07 sd=160n sca=45.7906 \
        scb=0.0283307 scc=0.00588417 m=(1)
PM50 (\7\:n20_4 \26\:Ckbb \4\:Db_4 VDD) g45p1svt w=(2.15e-07) l=4.5e-08 \
        nf=1 as=2.73e-14 ad=3.44e-14 ps=7.1e-07 pd=7.5e-07 nrd=1.16667 \
        nrs=1.16667 sa=1.26977e-07 sb=3.45e-07 sd=160n sca=45.7906 \
        scb=0.0283307 scc=0.00588417 m=(1)
PM54 (n2_4 \1\:D4 \18\:VDD VDD) g45p1svt w=(2.15e-07) l=4.5e-08 nf=1 \
        as=7.005e-14 ad=3.87e-14 ps=1.71e-06 pd=7.9e-07 nrd=1.16667 \
        nrs=1.16667 sa=1e-06 sb=1.10465e-07 sd=160n sca=21.1782 \
        scb=0.0203295 scc=0.00208843 m=(1)
PM53 (\6\:Db_4 \27\:SE n2_4 VDD) g45p1svt w=(2.15e-07) l=4.5e-08 nf=1 \
        as=3.87e-14 ad=3.44e-14 ps=7.9e-07 pd=7.5e-07 nrd=1.16667 \
        nrs=1.16667 sa=7.75e-07 sb=3.35465e-07 sd=160n sca=21.1782 \
        scb=0.0203295 scc=0.00208843 m=(1)
PM51 (\6\:Db_4 \3\:SEb_4 n4_4 VDD) g45p1svt w=(2.15e-07) l=4.5e-08 nf=1 \
        as=3.44e-14 ad=2.58e-14 ps=7.5e-07 pd=6.7e-07 nrd=1.16667 \
        nrs=1.16667 sa=5.40465e-07 sb=5.7e-07 sd=160n sca=21.1782 \
        scb=0.0203295 scc=0.00208843 m=(1)
PM52 (n4_4 \3\:SI4 \21\:VDD VDD) g45p1svt w=(2.15e-07) l=4.5e-08 nf=1 \
        as=2.58e-14 ad=1.001e-13 ps=6.7e-07 pd=1.75e-06 nrd=1.16667 \
        nrs=1.16667 sa=7.05465e-07 sb=4.05e-07 sd=160n sca=21.1782 \
        scb=0.0203295 scc=0.00208843 m=(1)
PM55 (\5\:SEb_4 \22\:SE \21\:VDD VDD) g45p1svt w=(2.15e-07) l=4.5e-08 \
        nf=1 as=1.001e-13 ad=3.01e-14 ps=1.75e-06 pd=7.1e-07 nrd=1.16667 \
        nrs=1.16667 sa=1.4e-07 sb=9.70465e-07 sd=160n sca=21.1782 \
        scb=0.0203295 scc=0.00208843 m=(1)
PM32 (\13\:qbint_3 n30_3 \28\:VDD VDD) g45p1svt w=(2.15e-07) l=4.5e-08 \
        nf=1 as=1.4115e-13 ad=3.44e-14 ps=2.12e-06 pd=7.5e-07 nrd=1.16667 \
        nrs=1.16667 sa=1.69e-06 sb=5.15e-07 sd=160n sca=29.9075 \
        scb=0.0247057 scc=0.00372713 m=(1)
PM31 (\13\:qbint_3 \20\:RN \31\:VDD VDD) g45p1svt w=(2.15e-07) l=4.5e-08 \
        nf=1 as=3.44e-14 ad=1.049e-13 ps=7.5e-07 pd=1.83e-06 nrd=1.16667 \
        nrs=1.16667 sa=7.2e-07 sb=1.485e-06 sd=160n sca=29.9075 \
        scb=0.0247057 scc=0.00372713 m=(1)
PM33 (n8_3 qbint_3 \31\:VDD VDD) g45p1svt w=(2.15e-07) l=4.5e-08 nf=1 \
        as=1.049e-13 ad=3.01e-14 ps=1.83e-06 pd=7.1e-07 nrd=1.16667 \
        nrs=1.16667 sa=1.22e-06 sb=9.85e-07 sd=160n sca=29.9075 \
        scb=0.0247057 scc=0.00372713 m=(1)
PM34 (\4\:n30_3 \19\:Ckbb n8_3 VDD) g45p1svt w=(2.15e-07) l=4.5e-08 nf=1 \
        as=3.01e-14 ad=5.375e-14 ps=7.1e-07 pd=9.3e-07 nrd=1.16667 \
        nrs=1.16667 sa=1.035e-06 sb=1.17e-06 sd=160n sca=29.9075 \
        scb=0.0247057 scc=0.00372713 m=(1)
PM30 (\4\:n30_3 \22\:CKb \4\:mout_3 VDD) g45p1svt w=(2.15e-07) l=4.5e-08 \
        nf=1 as=3.762e-14 ad=5.375e-14 ps=7.8e-07 pd=9.3e-07 nrd=1.16667 \
        nrs=1.16667 sa=7.4e-07 sb=1.465e-06 sd=160n sca=29.9075 \
        scb=0.0247057 scc=0.00372713 m=(1)
PM26 (\4\:mout_3 n20_3 \34\:VDD VDD) g45p1svt w=(2.15e-07) l=4.5e-08 \
        nf=1 as=8.415e-14 ad=3.762e-14 ps=1.83e-06 pd=7.8e-07 nrd=1.16667 \
        nrs=1.16667 sa=5.2e-07 sb=1.685e-06 sd=160n sca=29.9075 \
        scb=0.0247057 scc=0.00372713 m=(1)
PM27 (n6_3 \16\:RN \34\:VDD VDD) g45p1svt w=(2.15e-07) l=4.5e-08 nf=1 \
        as=3.44e-14 ad=8.415e-14 ps=7.5e-07 pd=1.83e-06 nrd=1.16667 \
        nrs=1.16667 sa=1.9e-06 sb=3.05e-07 sd=160n sca=29.9075 \
        scb=0.0247057 scc=0.00372713 m=(1)
PM29 (n6_3 mout_3 \38\:VDD VDD) g45p1svt w=(2.15e-07) l=4.5e-08 nf=1 \
        as=3.44e-14 ad=6.29e-14 ps=7.5e-07 pd=1.83e-06 nrd=1.16667 \
        nrs=1.16667 sa=2e-06 sb=1e-07 sd=160n sca=29.9075 scb=0.0247057 \
        scc=0.00372713 m=(1)
PM28 (\7\:n20_3 \20\:CKb \3\:n6_3 VDD) g45p1svt w=(2.15e-07) l=4.5e-08 \
        nf=1 as=3.44e-14 ad=3.01e-14 ps=7.5e-07 pd=7.1e-07 nrd=1.16667 \
        nrs=1.16667 sa=1.4e-07 sb=3.31977e-07 sd=160n sca=45.7906 \
        scb=0.0283307 scc=0.00588417 m=(1)
PM25 (\7\:n20_3 \15\:Ckbb \4\:Db_3 VDD) g45p1svt w=(2.15e-07) l=4.5e-08 \
        nf=1 as=2.73e-14 ad=3.44e-14 ps=7.1e-07 pd=7.5e-07 nrd=1.16667 \
        nrs=1.16667 sa=1.26977e-07 sb=3.45e-07 sd=160n sca=45.7906 \
        scb=0.0283307 scc=0.00588417 m=(1)
PM21 (n2_3 \1\:D3 \41\:VDD VDD) g45p1svt w=(2.15e-07) l=4.5e-08 nf=1 \
        as=7.005e-14 ad=3.87e-14 ps=1.71e-06 pd=7.9e-07 nrd=1.16667 \
        nrs=1.16667 sa=1e-06 sb=1.10465e-07 sd=160n sca=21.1782 \
        scb=0.0203295 scc=0.00208843 m=(1)
PM22 (\6\:Db_3 \20\:SE n2_3 VDD) g45p1svt w=(2.15e-07) l=4.5e-08 nf=1 \
        as=3.87e-14 ad=3.44e-14 ps=7.9e-07 pd=7.5e-07 nrd=1.16667 \
        nrs=1.16667 sa=7.75e-07 sb=3.35465e-07 sd=160n sca=21.1782 \
        scb=0.0203295 scc=0.00208843 m=(1)
PM24 (\6\:Db_3 \3\:SEb_3 n4_3 VDD) g45p1svt w=(2.15e-07) l=4.5e-08 nf=1 \
        as=3.44e-14 ad=2.58e-14 ps=7.5e-07 pd=6.7e-07 nrd=1.16667 \
        nrs=1.16667 sa=5.40465e-07 sb=5.7e-07 sd=160n sca=21.1782 \
        scb=0.0203295 scc=0.00208843 m=(1)
PM23 (n4_3 \3\:SI3 \44\:VDD VDD) g45p1svt w=(2.15e-07) l=4.5e-08 nf=1 \
        as=2.58e-14 ad=1.001e-13 ps=6.7e-07 pd=1.75e-06 nrd=1.16667 \
        nrs=1.16667 sa=7.05465e-07 sb=4.05e-07 sd=160n sca=21.1782 \
        scb=0.0203295 scc=0.00208843 m=(1)
PM20 (\5\:SEb_3 \15\:SE \44\:VDD VDD) g45p1svt w=(2.15e-07) l=4.5e-08 \
        nf=1 as=1.001e-13 ad=3.01e-14 ps=1.75e-06 pd=7.1e-07 nrd=1.16667 \
        nrs=1.16667 sa=1.4e-07 sb=9.70465e-07 sd=160n sca=21.1782 \
        scb=0.0203295 scc=0.00208843 m=(1)
PM14 (\12\:qbint_2 \3\:n30_2 \67\:VDD VDD) g45p1svt w=(2.15e-07) \
        l=4.5e-08 nf=1 as=1.4115e-13 ad=3.44e-14 ps=2.12e-06 pd=7.5e-07 \
        nrd=1.16667 nrs=1.16667 sa=1.69e-06 sb=5.15e-07 sd=160n \
        sca=29.9075 scb=0.0247057 scc=0.00372713 m=(1)
PM13 (\12\:qbint_2 \10\:RN \64\:VDD VDD) g45p1svt w=(2.15e-07) l=4.5e-08 \
        nf=1 as=3.44e-14 ad=1.049e-13 ps=7.5e-07 pd=1.83e-06 nrd=1.16667 \
        nrs=1.16667 sa=7.2e-07 sb=1.485e-06 sd=160n sca=29.9075 \
        scb=0.0247057 scc=0.00372713 m=(1)
PM15 (n8_2 \8\:qbint_2 \64\:VDD VDD) g45p1svt w=(2.15e-07) l=4.5e-08 \
        nf=1 as=1.049e-13 ad=3.01e-14 ps=1.83e-06 pd=7.1e-07 nrd=1.16667 \
        nrs=1.16667 sa=1.22e-06 sb=9.85e-07 sd=160n sca=29.9075 \
        scb=0.0247057 scc=0.00372713 m=(1)
PM16 (\4\:n30_2 \10\:Ckbb n8_2 VDD) g45p1svt w=(2.15e-07) l=4.5e-08 nf=1 \
        as=3.01e-14 ad=5.375e-14 ps=7.1e-07 pd=9.3e-07 nrd=1.16667 \
        nrs=1.16667 sa=1.035e-06 sb=1.17e-06 sd=160n sca=29.9075 \
        scb=0.0247057 scc=0.00372713 m=(1)
PM12 (\4\:n30_2 \10\:CKb \8\:mout_2 VDD) g45p1svt w=(2.15e-07) l=4.5e-08 \
        nf=1 as=3.762e-14 ad=5.375e-14 ps=7.8e-07 pd=9.3e-07 nrd=1.16667 \
        nrs=1.16667 sa=7.4e-07 sb=1.465e-06 sd=160n sca=29.9075 \
        scb=0.0247057 scc=0.00372713 m=(1)
PM8 (\8\:mout_2 \4\:n20_2 \61\:VDD VDD) g45p1svt w=(2.15e-07) l=4.5e-08 \
        nf=1 as=8.415e-14 ad=3.762e-14 ps=1.83e-06 pd=7.8e-07 nrd=1.16667 \
        nrs=1.16667 sa=5.2e-07 sb=1.685e-06 sd=160n sca=29.9075 \
        scb=0.0247057 scc=0.00372713 m=(1)
PM9 (\3\:n6_2 \13\:RN \61\:VDD VDD) g45p1svt w=(2.15e-07) l=4.5e-08 nf=1 \
        as=3.44e-14 ad=8.415e-14 ps=7.5e-07 pd=1.83e-06 nrd=1.16667 \
        nrs=1.16667 sa=1.9e-06 sb=3.05e-07 sd=160n sca=29.9075 \
        scb=0.0247057 scc=0.00372713 m=(1)
PM11 (\3\:n6_2 mout_2 \58\:VDD VDD) g45p1svt w=(2.15e-07) l=4.5e-08 nf=1 \
        as=3.44e-14 ad=6.29e-14 ps=7.5e-07 pd=1.83e-06 nrd=1.16667 \
        nrs=1.16667 sa=2e-06 sb=1e-07 sd=160n sca=29.9075 scb=0.0247057 \
        scc=0.00372713 m=(1)
PM10 (\5\:n20_2 \13\:CKb n6_2 VDD) g45p1svt w=(2.15e-07) l=4.5e-08 nf=1 \
        as=3.44e-14 ad=3.01e-14 ps=7.5e-07 pd=7.1e-07 nrd=1.16667 \
        nrs=1.16667 sa=1.4e-07 sb=3.31977e-07 sd=160n sca=45.7906 \
        scb=0.0283307 scc=0.00588417 m=(1)
PM7 (\5\:n20_2 \13\:Ckbb \4\:Db_2 VDD) g45p1svt w=(2.15e-07) l=4.5e-08 \
        nf=1 as=2.73e-14 ad=3.44e-14 ps=7.1e-07 pd=7.5e-07 nrd=1.16667 \
        nrs=1.16667 sa=1.26977e-07 sb=3.45e-07 sd=160n sca=45.7906 \
        scb=0.0283307 scc=0.00588417 m=(1)
PM1 (n2_2 \1\:D2 \54\:VDD VDD) g45p1svt w=(2.15e-07) l=4.5e-08 nf=1 \
        as=7.005e-14 ad=3.87e-14 ps=1.71e-06 pd=7.9e-07 nrd=1.16667 \
        nrs=1.16667 sa=1e-06 sb=1.10465e-07 sd=160n sca=21.1782 \
        scb=0.0203295 scc=0.00208843 m=(1)
PM2 (Db_2 \8\:SE n2_2 VDD) g45p1svt w=(2.15e-07) l=4.5e-08 nf=1 \
        as=3.87e-14 ad=3.44e-14 ps=7.9e-07 pd=7.5e-07 nrd=1.16667 \
        nrs=1.16667 sa=7.75e-07 sb=3.35465e-07 sd=160n sca=21.1782 \
        scb=0.0203295 scc=0.00208843 m=(1)
PM4 (Db_2 SEb_2 n4_2 VDD) g45p1svt w=(2.15e-07) l=4.5e-08 nf=1 \
        as=3.44e-14 ad=2.58e-14 ps=7.5e-07 pd=6.7e-07 nrd=1.16667 \
        nrs=1.16667 sa=5.40465e-07 sb=5.7e-07 sd=160n sca=21.1782 \
        scb=0.0203295 scc=0.00208843 m=(1)
PM3 (n4_2 \3\:SI2 \51\:VDD VDD) g45p1svt w=(2.15e-07) l=4.5e-08 nf=1 \
        as=2.58e-14 ad=1.001e-13 ps=6.7e-07 pd=1.75e-06 nrd=1.16667 \
        nrs=1.16667 sa=7.05465e-07 sb=4.05e-07 sd=160n sca=21.1782 \
        scb=0.0203295 scc=0.00208843 m=(1)
PM0 (\6\:SEb_2 \12\:SE \51\:VDD VDD) g45p1svt w=(2.15e-07) l=4.5e-08 \
        nf=1 as=1.001e-13 ad=3.01e-14 ps=1.75e-06 pd=7.1e-07 nrd=1.16667 \
        nrs=1.16667 sa=1.4e-07 sb=9.70465e-07 sd=160n sca=21.1782 \
        scb=0.0203295 scc=0.00208843 m=(1)
mp46 (\12\:qbint \3\:n30 \90\:VDD VDD) g45p1svt w=(2.15e-07) l=4.5e-08 \
        nf=1 as=1.4115e-13 ad=3.44e-14 ps=2.12e-06 pd=7.5e-07 nrd=1.16667 \
        nrs=1.16667 sa=1.69e-06 sb=5.15e-07 sd=160n sca=29.9075 \
        scb=0.0247057 scc=0.00372713 m=(1)
mp45 (\12\:qbint \3\:RN \86\:VDD VDD) g45p1svt w=(2.15e-07) l=4.5e-08 \
        nf=1 as=3.44e-14 ad=1.049e-13 ps=7.5e-07 pd=1.83e-06 nrd=1.16667 \
        nrs=1.16667 sa=7.2e-07 sb=1.485e-06 sd=160n sca=29.9075 \
        scb=0.0247057 scc=0.00372713 m=(1)
mp50 (n8 \8\:qbint \86\:VDD VDD) g45p1svt w=(2.15e-07) l=4.5e-08 nf=1 \
        as=1.049e-13 ad=3.01e-14 ps=1.83e-06 pd=7.1e-07 nrd=1.16667 \
        nrs=1.16667 sa=1.22e-06 sb=9.85e-07 sd=160n sca=29.9075 \
        scb=0.0247057 scc=0.00372713 m=(1)
mp51 (\4\:n30 \3\:Ckbb n8 VDD) g45p1svt w=(2.15e-07) l=4.5e-08 nf=1 \
        as=3.01e-14 ad=5.375e-14 ps=7.1e-07 pd=9.3e-07 nrd=1.16667 \
        nrs=1.16667 sa=1.035e-06 sb=1.17e-06 sd=160n sca=29.9075 \
        scb=0.0247057 scc=0.00372713 m=(1)
mp40 (\4\:n30 \3\:CKb \8\:mout VDD) g45p1svt w=(2.15e-07) l=4.5e-08 nf=1 \
        as=3.762e-14 ad=5.375e-14 ps=7.8e-07 pd=9.3e-07 nrd=1.16667 \
        nrs=1.16667 sa=7.4e-07 sb=1.465e-06 sd=160n sca=29.9075 \
        scb=0.0247057 scc=0.00372713 m=(1)
mp30 (\8\:mout \4\:n20 \83\:VDD VDD) g45p1svt w=(2.15e-07) l=4.5e-08 \
        nf=1 as=8.415e-14 ad=3.762e-14 ps=1.83e-06 pd=7.8e-07 nrd=1.16667 \
        nrs=1.16667 sa=5.2e-07 sb=1.685e-06 sd=160n sca=29.9075 \
        scb=0.0247057 scc=0.00372713 m=(1)
mp35 (\3\:n6 \6\:RN \83\:VDD VDD) g45p1svt w=(2.15e-07) l=4.5e-08 nf=1 \
        as=3.44e-14 ad=8.415e-14 ps=7.5e-07 pd=1.83e-06 nrd=1.16667 \
        nrs=1.16667 sa=1.9e-06 sb=3.05e-07 sd=160n sca=29.9075 \
        scb=0.0247057 scc=0.00372713 m=(1)
mp36 (\3\:n6 mout \80\:VDD VDD) g45p1svt w=(2.15e-07) l=4.5e-08 nf=1 \
        as=3.44e-14 ad=6.29e-14 ps=7.5e-07 pd=1.83e-06 nrd=1.16667 \
        nrs=1.16667 sa=2e-06 sb=1e-07 sd=160n sca=29.9075 scb=0.0247057 \
        scc=0.00372713 m=(1)
mp37 (\5\:n20 \6\:CKb n6 VDD) g45p1svt w=(2.15e-07) l=4.5e-08 nf=1 \
        as=3.44e-14 ad=3.01e-14 ps=7.5e-07 pd=7.1e-07 nrd=1.16667 \
        nrs=1.16667 sa=1.4e-07 sb=3.31977e-07 sd=160n sca=45.7906 \
        scb=0.0283307 scc=0.00588417 m=(1)
mp25 (\5\:n20 \6\:Ckbb \4\:Db VDD) g45p1svt w=(2.15e-07) l=4.5e-08 nf=1 \
        as=2.73e-14 ad=3.44e-14 ps=7.1e-07 pd=7.5e-07 nrd=1.16667 \
        nrs=1.16667 sa=1.26977e-07 sb=3.45e-07 sd=160n sca=45.7906 \
        scb=0.0283307 scc=0.00588417 m=(1)
mp11 (n2 \1\:D1 \76\:VDD VDD) g45p1svt w=(2.15e-07) l=4.5e-08 nf=1 \
        as=7.005e-14 ad=3.87e-14 ps=1.71e-06 pd=7.9e-07 nrd=1.16667 \
        nrs=1.16667 sa=1e-06 sb=1.10465e-07 sd=160n sca=21.1782 \
        scb=0.0203295 scc=0.00208843 m=(1)
mp12 (Db \1\:SE n2 VDD) g45p1svt w=(2.15e-07) l=4.5e-08 nf=1 as=3.87e-14 \
        ad=3.44e-14 ps=7.9e-07 pd=7.5e-07 nrd=1.16667 nrs=1.16667 \
        sa=7.75e-07 sb=3.35465e-07 sd=160n sca=21.1782 scb=0.0203295 \
        scc=0.00208843 m=(1)
mp14 (Db SEb n4 VDD) g45p1svt w=(2.15e-07) l=4.5e-08 nf=1 as=3.44e-14 \
        ad=2.58e-14 ps=7.5e-07 pd=6.7e-07 nrd=1.16667 nrs=1.16667 \
        sa=5.40465e-07 sb=5.7e-07 sd=160n sca=21.1782 scb=0.0203295 \
        scc=0.00208843 m=(1)
mp13 (n4 \3\:SI1 \73\:VDD VDD) g45p1svt w=(2.15e-07) l=4.5e-08 nf=1 \
        as=2.58e-14 ad=1.001e-13 ps=6.7e-07 pd=1.75e-06 nrd=1.16667 \
        nrs=1.16667 sa=7.05465e-07 sb=4.05e-07 sd=160n sca=21.1782 \
        scb=0.0203295 scc=0.00208843 m=(1)
mp10 (\6\:SEb \5\:SE \73\:VDD VDD) g45p1svt w=(2.15e-07) l=4.5e-08 nf=1 \
        as=1.001e-13 ad=3.01e-14 ps=1.75e-06 pd=7.1e-07 nrd=1.16667 \
        nrs=1.16667 sa=1.4e-07 sb=9.70465e-07 sd=160n sca=21.1782 \
        scb=0.0203295 scc=0.00208843 m=(1)
mp56 (\5\:qint \7\:qbint \92\:VDD VDD) g45p1svt w=(2.15e-07) l=4.5e-08 \
        nf=1 as=9.842e-14 ad=3.01e-14 ps=1.97e-06 pd=7.1e-07 nrd=1.16667 \
        nrs=1.16667 sa=3.7e-07 sb=1.4e-07 sd=160n sca=48.5748 \
        scb=0.0312356 scc=0.00590118 m=(1)
PM18 (\5\:qint_2 \7\:qbint_2 \70\:VDD VDD) g45p1svt w=(2.15e-07) \
        l=4.5e-08 nf=1 as=9.843e-14 ad=3.01e-14 ps=1.97e-06 pd=7.1e-07 \
        nrd=1.16667 nrs=1.16667 sa=3.7e-07 sb=1.4e-07 sd=160n sca=45.7906 \
        scb=0.0283307 scc=0.00588417 m=(1)
PM36 (\9\:qint_3 \4\:qbint_3 \25\:VDD VDD) g45p1svt w=(2.15e-07) \
        l=4.5e-08 nf=1 as=9.843e-14 ad=3.01e-14 ps=1.97e-06 pd=7.1e-07 \
        nrd=1.16667 nrs=1.16667 sa=1.4e-07 sb=3.7e-07 sd=160n sca=45.7906 \
        scb=0.0283307 scc=0.00588417 m=(1)
PM39 (\9\:qint_4 \4\:qbint_4 \1\:VDD VDD) g45p1svt w=(2.15e-07) \
        l=4.5e-08 nf=1 as=9.843e-14 ad=3.01e-14 ps=1.97e-06 pd=7.1e-07 \
        nrd=1.16667 nrs=1.16667 sa=1.4e-07 sb=3.7e-07 sd=160n sca=48.5748 \
        scb=0.0312356 scc=0.00590118 m=(1)
ends SPDFF4RX1
// End of subcircuit definition.
