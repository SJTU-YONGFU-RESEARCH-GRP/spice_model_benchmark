// Generated for: spectre (May  1 08:12:09 2013 )
// Library name: gsclib045
// Cell name: RDFFNRX1
// View name: extracted

simulator lang=spectre

subckt RDFFNRX1 CKN D ExtVDD Q QN RN RT VDD VSS
mp20 (\21\:CKNb \4\:CKN \23\:VDD VDD) g45p1svt w=(2.15e-07) l=4.5e-08 \
        nf=1 as=3.01e-14 ad=3.44e-14 ps=7.1e-07 pd=7.5e-07 nrd=1.16667 \
        nrs=1.16667 sa=3.45e-07 sb=1.4e-07 sd=160n sca=15.0986 \
        scb=0.0152901 scc=0.00103801 m=(1)
mp21 (\13\:CKNbb \5\:CKNb \23\:VDD VDD) g45p1svt w=(2.15e-07) l=4.5e-08 \
        nf=1 as=3.44e-14 ad=3.01e-14 ps=7.5e-07 pd=7.1e-07 nrd=1.16667 \
        nrs=1.16667 sa=1.4e-07 sb=3.45e-07 sd=160n sca=14.7851 \
        scb=0.0152025 scc=0.00103799 m=(1)
mp56 (\9\:qint \13\:qbint \17\:VDD VDD) g45p1svt w=(2.15e-07) l=4.5e-08 \
        nf=1 as=3.01e-14 ad=6.535e-14 ps=7.1e-07 pd=1.16e-06 nrd=1.16667 \
        nrs=1.16667 sa=3.75e-07 sb=1.4e-07 sd=160n sca=16.5977 \
        scb=0.0172903 scc=0.000688737 m=(1)
mp25 (n22 \3\:D \13\:VDD VDD) g45p1svt w=(2.15e-07) l=4.5e-08 nf=1 \
        as=3.01e-14 ad=1.29e-14 ps=7.1e-07 pd=5.5e-07 nrd=1.16667 \
        nrs=1.16667 sa=1.4e-07 sb=2.45e-07 sd=160n sca=20.3407 \
        scb=0.022946 scc=0.00119484 m=(1)
mp26 (\15\:n20 \3\:CKNb n22 VDD) g45p1svt w=(2.15e-07) l=4.5e-08 nf=1 \
        as=1.29e-14 ad=3.01e-14 ps=5.5e-07 pd=7.1e-07 nrd=1.16667 \
        nrs=1.16667 sa=2.45e-07 sb=1.4e-07 sd=160n sca=17.8768 \
        scb=0.0186195 scc=0.00106238 m=(1)
mp36 (\7\:n20 \4\:CKNbb n31 VDD) g45p1svt w=(2.15e-07) l=4.5e-08 nf=1 \
        as=1.29e-14 ad=3.01e-14 ps=5.5e-07 pd=7.1e-07 nrd=1.16667 \
        nrs=1.16667 sa=1.4e-07 sb=2.45e-07 sd=160n sca=6.79882 \
        scb=0.00278203 scc=1.42286e-05 m=(1)
mp35 (n31 mout \25\:VDD VDD) g45p1svt w=(2.15e-07) l=4.5e-08 nf=1 \
        as=3.01e-14 ad=1.29e-14 ps=7.1e-07 pd=5.5e-07 nrd=1.16667 \
        nrs=1.16667 sa=2.45e-07 sb=1.4e-07 sd=160n sca=6.42122 \
        scb=0.00257522 scc=1.4095e-05 m=(1)
mp32 (\17\:mout \3\:n20 net402 VDD) g45p1svt w=(2.15e-07) l=4.5e-08 nf=1 \
        as=1.29e-14 ad=3.01e-14 ps=5.5e-07 pd=7.1e-07 nrd=1.16667 \
        nrs=1.16667 sa=1.4e-07 sb=2.45e-07 sd=160n sca=6.63763 \
        scb=0.00268079 scc=1.41468e-05 m=(1)
mp31 (net402 \5\:RNb \21\:VDD VDD) g45p1svt w=(2.15e-07) l=4.5e-08 nf=1 \
        as=3.01e-14 ad=1.29e-14 ps=7.1e-07 pd=5.5e-07 nrd=1.16667 \
        nrs=1.16667 sa=2.45e-07 sb=1.4e-07 sd=160n sca=7.12147 \
        scb=0.00304089 scc=1.45946e-05 m=(1)
mp22 (\11\:RNb \4\:RN \19\:VDD VDD) g45p1svt w=(2.15e-07) l=4.5e-08 nf=1 \
        as=3.01e-14 ad=3.01e-14 ps=7.1e-07 pd=7.1e-07 nrd=1.16667 \
        nrs=1.16667 sa=1.4e-07 sb=1.4e-07 sd=160n sca=17.717 scb=0.0191019 \
        scc=0.000880768 m=(1)
mp40 (\4\:n35 \5\:CKNbb \5\:mout VDD) g45p1svt w=(2.15e-07) l=4.5e-08 \
        nf=1 as=3.01e-14 ad=3.01e-14 ps=7.1e-07 pd=7.1e-07 nrd=1.16667 \
        nrs=1.16667 sa=1.4e-07 sb=1.4e-07 sd=160n sca=19.7416 \
        scb=0.0214921 scc=0.00142044 m=(1)
PM0 (\6\:n35g \5\:RT \9\:n35 ExtVDD) g45p1svt w=(2.15e-07) l=4.5e-08 nf=1 \
        as=3.01e-14 ad=3.01e-14 ps=7.1e-07 pd=7.1e-07 nrd=1.16667 \
        nrs=1.16667 sa=1.4e-07 sb=1.4e-07 sd=160n sca=26.0836 \
        scb=0.0271848 scc=0.00267095 m=(1)
PM1 (\17\:qbint \3\:n35g \1\:ExtVDD ExtVDD) g45p1svt w=(2.15e-07) \
        l=4.5e-08 nf=1 as=3.5882e-13 ad=3.01e-14 ps=3.6e-06 pd=7.1e-07 \
        nrd=1.16667 nrs=1.16667 sa=1.4e-07 sb=8.7e-07 sd=160n sca=25.2796 \
        scb=0.0259458 scc=0.00265434 m=(1)
PM2 (net205 \4\:qbint \1\:ExtVDD ExtVDD) g45p1svt w=(2.15e-07) l=4.5e-08 \
        nf=1 as=3.5882e-13 ad=1.29e-14 ps=3.6e-06 pd=5.5e-07 nrd=1.16667 \
        nrs=1.16667 sa=7.65e-07 sb=2.45e-07 sd=160n sca=14.5295 \
        scb=0.0144143 scc=0.000486924 m=(1)
mp45 (\6\:RTb \6\:RT \1\:ExtVDD ExtVDD) g45p1svt w=(2.15e-07) l=4.5e-08 \
        nf=1 as=3.5882e-13 ad=3.01e-14 ps=3.6e-06 pd=7.1e-07 nrd=1.16667 \
        nrs=1.16667 sa=3.3e-07 sb=1.4e-07 sd=160n sca=24.3731 \
        scb=0.0258873 scc=0.00229004 m=(1)
PM3 (\15\:n35g \4\:RTb net205 ExtVDD) g45p1svt w=(2.15e-07) l=4.5e-08 \
        nf=1 as=1.29e-14 ad=3.01e-14 ps=5.5e-07 pd=7.1e-07 nrd=1.16667 \
        nrs=1.16667 sa=8.7e-07 sb=1.4e-07 sd=160n sca=25.2796 \
        scb=0.0259458 scc=0.00265434 m=(1)
mp53 (\14\:n35 \13\:CKNb \3\:net098 VDD) g45p1svt w=(2.15e-07) l=4.5e-08 \
        nf=1 as=3.01e-14 ad=3.01e-14 ps=7.1e-07 pd=7.1e-07 nrd=1.16667 \
        nrs=1.16667 sa=1.4e-07 sb=1.4e-07 sd=160n sca=28.3325 \
        scb=0.0311878 scc=0.00281308 m=(1)
mp51 (n43 \2\:RNb \15\:VDD VDD) g45p1svt w=(2.15e-07) l=4.5e-08 nf=1 \
        as=3.01e-14 ad=1.29e-14 ps=7.1e-07 pd=5.5e-07 nrd=1.16667 \
        nrs=1.16667 sa=1.4e-07 sb=2.45e-07 sd=160n sca=11.272 \
        scb=0.00858882 scc=0.000167946 m=(1)
mp52 (net098 \11\:qbint n43 VDD) g45p1svt w=(2.15e-07) l=4.5e-08 nf=1 \
        as=1.29e-14 ad=3.01e-14 ps=5.5e-07 pd=7.1e-07 nrd=1.16667 \
        nrs=1.16667 sa=2.45e-07 sb=1.4e-07 sd=160n sca=11.4972 \
        scb=0.00902054 scc=0.000170728 m=(1)
C1 (RT VSS) capacitor c=2.16282e-17
C2 (Q VSS) capacitor c=5.02501e-17
C3 (RN VSS) capacitor c=7.00445e-17
C4 (D VSS) capacitor c=5.46753e-17
C5 (QN VSS) capacitor c=1.94743e-17
C6 (VDD VSS) capacitor c=6.4642e-16
C7 (CKN VSS) capacitor c=5.26028e-17
C8 (ExtVDD VSS) capacitor c=1.8927e-16
C9 (CKNb VSS) capacitor c=4.78714e-17
C10 (mout VSS) capacitor c=5.02221e-17
C11 (CKNbb VSS) capacitor c=5.25089e-17
C12 (n20 VSS) capacitor c=8.33177e-17
C13 (RNb VSS) capacitor c=5.65849e-17
C14 (n35g VSS) capacitor c=1.80883e-17
C15 (qbint VSS) capacitor c=4.47222e-17
C16 (RTb VSS) capacitor c=4.52606e-17
C17 (qint VSS) capacitor c=2.23579e-17
C18 (n35 VSS) capacitor c=1.82008e-16
C19 (net098 VSS) capacitor c=6.44428e-17
C20 (n40 VSS) capacitor c=7.48881e-17
C21 (\7\:qbint VSS) capacitor c=3.32719e-17
C22 (\11\:qbint VSS) capacitor c=1.21111e-16
C23 (\2\:RNb VSS) capacitor c=3.02292e-16
C24 (\13\:qbint VSS) capacitor c=4.64115e-17
C25 (\3\:qint VSS) capacitor c=6.10172e-17
C26 (\13\:CKNb VSS) capacitor c=7.0645e-17
C27 (\4\:RTb VSS) capacitor c=9.95385e-17
C28 (\6\:RT VSS) capacitor c=2.33402e-17
C29 (\4\:qbint VSS) capacitor c=5.43107e-17
C30 (\3\:n35g VSS) capacitor c=6.36976e-17
C31 (\5\:RT VSS) capacitor c=8.6036e-17
C32 (\5\:CKNbb VSS) capacitor c=1.04182e-16
C33 (\4\:RN VSS) capacitor c=3.21164e-17
C34 (\5\:RNb VSS) capacitor c=6.43347e-17
C35 (\3\:n20 VSS) capacitor c=7.4544e-17
C36 (\4\:CKN VSS) capacitor c=5.55868e-17
C37 (\5\:CKNb VSS) capacitor c=3.12581e-17
C38 (\4\:CKNbb VSS) capacitor c=8.45259e-17
C39 (\3\:CKNb VSS) capacitor c=1.6436e-16
C40 (\3\:D VSS) capacitor c=5.81175e-17
C41 (\6\:qbint VSS) capacitor c=3.70332e-17
C42 (\12\:qbint VSS) capacitor c=5.85221e-17
C43 (\14\:qbint VSS) capacitor c=4.72232e-17
C44 (\4\:qint VSS) capacitor c=3.84237e-17
C45 (\7\:CKNbb VSS) capacitor c=1.95834e-16
C46 (\8\:RT VSS) capacitor c=1.22296e-16
C47 (\2\:RT VSS) capacitor c=5.70341e-17
C48 (\5\:qbint VSS) capacitor c=3.89021e-17
C49 (\5\:n35g VSS) capacitor c=3.49293e-17
C50 (\2\:RTb VSS) capacitor c=5.13883e-17
C51 (\7\:CKNb VSS) capacitor c=3.43089e-17
C52 (\1\:RN VSS) capacitor c=3.31675e-17
C53 (\7\:RNb VSS) capacitor c=6.18371e-17
C54 (\1\:CKN VSS) capacitor c=2.85199e-17
C55 (\6\:n20 VSS) capacitor c=6.33352e-17
C56 (\3\:mout VSS) capacitor c=5.04497e-17
C57 (\12\:CKNb VSS) capacitor c=4.99683e-17
C58 (\2\:CKNbb VSS) capacitor c=8.20957e-17
C59 (\1\:D VSS) capacitor c=6.41344e-17
C60 (\10\:qbint VSS) capacitor c=8.64747e-17
C61 (\14\:CKNb VSS) capacitor c=7.1227e-17
C62 (\7\:RT VSS) capacitor c=1.54925e-16
C63 (\11\:CKNb VSS) capacitor c=1.43599e-16
C64 (\3\:RT VSS) capacitor c=5.76507e-17
C65 (\1\:RT VSS) capacitor c=4.86946e-17
C66 (\3\:RTb VSS) capacitor c=7.61221e-17
C67 (\3\:qbint VSS) capacitor c=4.4544e-17
C68 (\2\:n35 VSS) capacitor c=2.6359e-16
C69 (\4\:n35g VSS) capacitor c=7.15763e-17
C70 (\6\:CKNbb VSS) capacitor c=5.61759e-17
C71 (\8\:CKNbb VSS) capacitor c=2.31476e-16
C72 (\3\:n35 VSS) capacitor c=1.2108e-16
C73 (\6\:RNb VSS) capacitor c=8.02224e-17
C74 (\3\:RN VSS) capacitor c=1.56154e-17
C75 (\3\:CKN VSS) capacitor c=2.28812e-17
C76 (\6\:CKNb VSS) capacitor c=2.30208e-17
C77 (\3\:CKNbb VSS) capacitor c=1.07115e-16
C78 (\2\:mout VSS) capacitor c=4.00613e-17
C79 (\4\:mout VSS) capacitor c=3.90906e-17
C80 (\5\:n20 VSS) capacitor c=4.02502e-17
C81 (\2\:n20 VSS) capacitor c=7.16585e-17
C82 (\4\:CKNb VSS) capacitor c=8.289e-17
C83 (\10\:CKNb VSS) capacitor c=3.21327e-17
C84 (\2\:D VSS) capacitor c=5.57132e-17
C85 (\1\:VDD VSS) capacitor c=4.94671e-17
C86 (\3\:Q VSS) capacitor c=8.4142e-17
C87 (\15\:VDD VSS) capacitor c=4.90408e-17
C88 (\9\:qint VSS) capacitor c=5.44514e-17
C89 (\17\:VDD VSS) capacitor c=7.86602e-17
C90 (\3\:net098 VSS) capacitor c=9.94279e-17
C91 (\4\:QN VSS) capacitor c=6.24664e-17
C92 (\14\:n35 VSS) capacitor c=4.13723e-17
C93 (\15\:n35g VSS) capacitor c=5.6279e-17
C94 (\6\:RTb VSS) capacitor c=8.44107e-17
C95 (\1\:ExtVDD VSS) capacitor c=2.81139e-16
C96 (\9\:n35 VSS) capacitor c=5.48437e-17
C97 (\17\:qbint VSS) capacitor c=7.03785e-17
C98 (\6\:n35g VSS) capacitor c=9.18322e-17
C99 (\4\:n35 VSS) capacitor c=5.58055e-17
C100 (\11\:RNb VSS) capacitor c=2.80278e-17
C101 (\5\:mout VSS) capacitor c=7.03725e-17
C102 (\19\:VDD VSS) capacitor c=5.57894e-17
C103 (\21\:VDD VSS) capacitor c=4.3932e-17
C104 (\21\:CKNb VSS) capacitor c=4.74098e-17
C105 (\17\:mout VSS) capacitor c=3.49518e-17
C106 (\23\:VDD VSS) capacitor c=6.43393e-17
C107 (\25\:VDD VSS) capacitor c=4.59835e-17
C108 (\13\:CKNbb VSS) capacitor c=5.20416e-17
C109 (\7\:n20 VSS) capacitor c=4.09649e-17
C110 (\15\:n20 VSS) capacitor c=6.38705e-17
C111 (\13\:VDD VSS) capacitor c=4.84353e-17
C112 (\1\:Q VSS) capacitor c=5.32656e-17
C113 (\5\:qint VSS) capacitor c=4.88336e-17
C114 (\3\:n40 VSS) capacitor c=7.85431e-17
C115 (\1\:QN VSS) capacitor c=4.74573e-17
C116 (\17\:n35 VSS) capacitor c=4.88491e-17
C117 (\11\:n35g VSS) capacitor c=2.98291e-17
C118 (\10\:RTb VSS) capacitor c=4.83367e-17
C119 (\12\:n35 VSS) capacitor c=6.14996e-17
C120 (\19\:qbint VSS) capacitor c=2.31764e-17
C121 (\9\:n35g VSS) capacitor c=7.79231e-17
C122 (\7\:n35 VSS) capacitor c=4.56427e-17
C123 (\8\:RNb VSS) capacitor c=4.53565e-17
C124 (\13\:mout VSS) capacitor c=5.52845e-17
C125 (\17\:CKNb VSS) capacitor c=6.59437e-17
C126 (\15\:mout VSS) capacitor c=3.61507e-17
C127 (\9\:CKNbb VSS) capacitor c=3.47523e-17
C128 (\11\:n20 VSS) capacitor c=6.15914e-17
C129 (\13\:n20 VSS) capacitor c=5.8038e-17
C130 (\2\:CKNb VSS) capacitor c=7.23265e-17
C131 (\2\:CKN VSS) capacitor c=3.3563e-17
C132 (\4\:n20 VSS) capacitor c=6.75316e-17
C133 (\2\:RN VSS) capacitor c=3.23691e-17
C134 (VDD VSS) capacitor c=2.38916e-16
C135 (\2\:n35g VSS) capacitor c=3.33648e-17
C136 (ExtVDD VSS) capacitor c=3.93557e-17
C137 (\4\:RT VSS) capacitor c=7.53549e-17
C138 (\2\:qbint VSS) capacitor c=4.14475e-17
C139 (\8\:CKNb VSS) capacitor c=1.25277e-16
C140 (\9\:CKNb VSS) capacitor c=6.33461e-17
C141 (\2\:qint VSS) capacitor c=1.60038e-17
C142 (\3\:RNb VSS) capacitor c=4.9757e-16
C143 (\4\:RNb VSS) capacitor c=1.14107e-16
C144 (\15\:CKNb VSS) capacitor c=6.32965e-17
C145 (\16\:CKNb VSS) capacitor c=7.36636e-17
C146 (\8\:qbint VSS) capacitor c=5.1953e-17
C147 (\9\:qbint VSS) capacitor c=8.2436e-17
C148 (\9\:n20 VSS) capacitor c=2.9868e-17
C149 (\10\:n20 VSS) capacitor c=4.94899e-17
C150 (\17\:n20 VSS) capacitor c=3.71686e-17
C151 (\12\:CKNbb VSS) capacitor c=8.61346e-17
C152 (\15\:CKNbb VSS) capacitor c=5.06012e-17
C153 (\5\:CKN VSS) capacitor c=4.1738e-17
C154 (\19\:CKNb VSS) capacitor c=7.86352e-17
C155 (\20\:CKNb VSS) capacitor c=5.1791e-17
C156 (\5\:RN VSS) capacitor c=7.50101e-17
C157 (\7\:mout VSS) capacitor c=5.47382e-17
C158 (\8\:mout VSS) capacitor c=4.7021e-17
C159 (\9\:mout VSS) capacitor c=1.13215e-17
C160 (\10\:mout VSS) capacitor c=2.79057e-17
C161 (\11\:mout VSS) capacitor c=1.49137e-17
C162 (\12\:mout VSS) capacitor c=2.90257e-17
C163 (\10\:RNb VSS) capacitor c=6.59802e-17
C164 (\6\:n35 VSS) capacitor c=5.94256e-17
C165 (\16\:CKNbb VSS) capacitor c=3.3263e-17
C166 (\17\:CKNbb VSS) capacitor c=3.22576e-17
C167 (\8\:n35g VSS) capacitor c=3.24153e-17
C168 (\11\:n35 VSS) capacitor c=6.19327e-17
C169 (\15\:qbint VSS) capacitor c=8.79791e-17
C170 (\16\:qbint VSS) capacitor c=1.04691e-16
C171 (\13\:n35g VSS) capacitor c=1.03358e-16
C172 (\14\:n35g VSS) capacitor c=1.16391e-16
C173 (\5\:RTb VSS) capacitor c=4.92115e-17
C174 (\8\:RTb VSS) capacitor c=8.78209e-17
C175 (\9\:RTb VSS) capacitor c=5.17236e-17
C176 (\9\:RT VSS) capacitor c=1.06424e-16
C177 (\10\:RT VSS) capacitor c=1.18512e-16
C178 (\11\:RT VSS) capacitor c=3.82092e-17
C179 (\23\:CKNb VSS) capacitor c=9.52869e-17
C180 (\24\:CKNb VSS) capacitor c=9.41391e-17
C181 (\21\:qbint VSS) capacitor c=2.43147e-17
C182 (\22\:qbint VSS) capacitor c=2.99231e-17
C183 (\3\:QN VSS) capacitor c=3.16997e-17
C184 (\16\:n35 VSS) capacitor c=4.41528e-17
C185 (\7\:qint VSS) capacitor c=5.06882e-17
C186 (\8\:qint VSS) capacitor c=3.56681e-17
C187 (\3\:VDD VSS) capacitor c=5.1347e-17
C188 (\5\:VDD VSS) capacitor c=1.00137e-17
C189 (\6\:VDD VSS) capacitor c=1.23819e-16
C190 (\7\:VDD VSS) capacitor c=6.29812e-17
C191 (\8\:VDD VSS) capacitor c=8.55803e-18
C192 (\10\:VDD VSS) capacitor c=2.16858e-17
C193 (\11\:VDD VSS) capacitor c=2.63691e-17
C194 (\12\:VDD VSS) capacitor c=3.22743e-17
Rk52 (RT \9\:RT) resistor r=0.1837 c=0
Rk53 (\9\:RT \10\:RT) resistor r=0.641 c=0
Rk54 (RT \11\:RT) resistor r=0.01478 c=0
Rk66 (\2\:Q Q) resistor r=0.1691 c=0
Rk67 (Q \4\:Q) resistor r=0.3374 c=0
Rk18 (RN \5\:RN) resistor r=0.009391 c=0
Rk58 (\3\:QN QN) resistor r=0.04556 c=0
Rk57 (\2\:QN \3\:QN) resistor r=0.321 c=0
Rk59 (\3\:QN \5\:QN) resistor r=0.231 c=0
Rk85 (\2\:VDD \3\:VDD) resistor r=0.5756 c=0
Rk86 (\3\:VDD \5\:VDD) resistor r=0.0667 c=0
Rk88 (\6\:VDD VDD) resistor r=0.9522 c=0
Rk87 (\5\:VDD \6\:VDD) resistor r=0.05184 c=0
Rk89 (VDD \7\:VDD) resistor r=0.6777 c=0
Rk90 (\7\:VDD \8\:VDD) resistor r=0.02934 c=0
Rk91 (\8\:VDD \10\:VDD) resistor r=0.1014 c=0
Rk92 (\10\:VDD \11\:VDD) resistor r=0.089 c=0
Rk94 (\12\:VDD VDD) resistor r=0.1953 c=0
Rk93 (\11\:VDD \12\:VDD) resistor r=0.08137 c=0
Rk95 (VDD \14\:VDD) resistor r=0.5108 c=0
Rk96 (\3\:VDD \16\:VDD) resistor r=0.2925 c=0
Rk97 (\6\:VDD \18\:VDD) resistor r=0.3607 c=0
Rk98 (\7\:VDD \20\:VDD) resistor r=0.3587 c=0
Rk99 (\8\:VDD \22\:VDD) resistor r=0.2013 c=0
Rk100 (\11\:VDD \24\:VDD) resistor r=0.4029 c=0
Rk101 (\12\:VDD \26\:VDD) resistor r=0.2013 c=0
Rk14 (CKN \5\:CKN) resistor r=0.0156 c=0
Rk13 (\5\:CKN \6\:CKN) resistor r=0.004531 c=0
Rk69 (\2\:VSS \4\:VSS) resistor r=0.361 c=0
Rk70 (\4\:VSS \5\:VSS) resistor r=0.2377 c=0
Rk71 (\5\:VSS \6\:VSS) resistor r=0.6043 c=0
Rk72 (\6\:VSS \7\:VSS) resistor r=0.0667 c=0
Rk74 (\8\:VSS VSS) resistor r=0.07141 c=0
Rk73 (\7\:VSS \8\:VSS) resistor r=0.2077 c=0
Rk75 (VSS \9\:VSS) resistor r=0.6789 c=0
Rk77 (\10\:VSS VSS) resistor r=0.01957 c=0
Rk76 (\9\:VSS \10\:VSS) resistor r=0.1633 c=0
Rk78 (VSS \11\:VSS) resistor r=0.03722 c=0
Rk79 (\11\:VSS \13\:VSS) resistor r=0.6574 c=0
Rk80 (\5\:VSS \15\:VSS) resistor r=0.2632 c=0
Rk81 (\7\:VSS \17\:VSS) resistor r=0.189 c=0
Rk82 (\8\:VSS \19\:VSS) resistor r=0.194 c=0
Rk83 (\9\:VSS \21\:VSS) resistor r=0.2356 c=0
Rk84 (\11\:VSS \23\:VSS) resistor r=0.2362 c=0
Rk102 (\25\:VSS \27\:VSS) resistor r=0.3059 c=0
Rk103 (\27\:VSS \28\:VSS) resistor r=0.1386 c=0
Rk106 (\29\:VSS VSS) resistor r=0.3472 c=0
Rk104 (\28\:VSS \29\:VSS) resistor r=0.7037 c=0
Rk105 (\28\:VSS \31\:VSS) resistor r=0.2459 c=0
Rk107 (VSS \32\:VSS) resistor r=0.7557 c=0
Rk109 (\33\:VSS VSS) resistor r=0.1212 c=0
Rk108 (\32\:VSS \33\:VSS) resistor r=0.08652 c=0
Rk110 (VSS \35\:VSS) resistor r=0.2966 c=0
Rk111 (\29\:VSS \37\:VSS) resistor r=0.2886 c=0
Rk112 (\32\:VSS \39\:VSS) resistor r=0.2396 c=0
Rk39 (ExtVDD ExtVDD) resistor r=0.00206 c=0
Rk37 (\2\:ExtVDD ExtVDD) resistor r=0.02213 c=0
Rk40 (ExtVDD \5\:ExtVDD) resistor r=0.02012 c=0
Rk41 (ExtVDD \6\:ExtVDD) resistor r=0.1068 c=0
Rk1 (\15\:CKNb \16\:CKNb) resistor r=0.6835 c=0
Rk15 (\18\:CKNb \19\:CKNb) resistor r=0.3598 c=0
Rk16 (\19\:CKNb \20\:CKNb) resistor r=0.1631 c=0
Rk17 (\19\:CKNb \22\:CKNb) resistor r=0.2097 c=0
Rk55 (\23\:CKNb \24\:CKNb) resistor r=0.7181 c=0
Rk19 (\6\:mout \7\:mout) resistor r=0.4259 c=0
Rk20 (\7\:mout \8\:mout) resistor r=0.3627 c=0
Rk21 (\8\:mout \9\:mout) resistor r=0.1415 c=0
Rk22 (\9\:mout \10\:mout) resistor r=0.1932 c=0
Rk23 (\7\:mout \11\:mout) resistor r=0.1187 c=0
Rk24 (\11\:mout \12\:mout) resistor r=0.216 c=0
Rk25 (\8\:mout \14\:mout) resistor r=0.3231 c=0
Rk26 (\9\:mout \16\:mout) resistor r=0.1038 c=0
Rk27 (\11\:mout \18\:mout) resistor r=0.1204 c=0
Rk9 (\10\:CKNbb \11\:CKNbb) resistor r=0.2133 c=0
Rk10 (\11\:CKNbb \12\:CKNbb) resistor r=0.01512 c=0
Rk11 (\11\:CKNbb \14\:CKNbb) resistor r=0.3381 c=0
Rk12 (\14\:CKNbb \15\:CKNbb) resistor r=0.2712 c=0
Rk32 (\16\:CKNbb \17\:CKNbb) resistor r=0.2962 c=0
Rk4 (\8\:n20 \9\:n20) resistor r=0.2065 c=0
Rk5 (\8\:n20 \10\:n20) resistor r=0.2094 c=0
Rk6 (\10\:n20 \12\:n20) resistor r=0.4405 c=0
Rk7 (\14\:n20 \16\:n20) resistor r=0.4882 c=0
Rk8 (\16\:n20 \17\:n20) resistor r=0.1576 c=0
Rk28 (\9\:RNb \10\:RNb) resistor r=0.3415 c=0
Rk29 (\10\:RNb \12\:RNb) resistor r=0.1481 c=0
Rk33 (\7\:n35g \8\:n35g) resistor r=0.2405 c=0
Rk34 (\7\:n35g \10\:n35g) resistor r=0.6908 c=0
Rk45 (\12\:n35g \13\:n35g) resistor r=0.2427 c=0
Rk46 (\13\:n35g \14\:n35g) resistor r=0.5649 c=0
Rk47 (\13\:n35g \16\:n35g) resistor r=0.4315 c=0
Rk42 (\15\:qbint \16\:qbint) resistor r=0.494 c=0
Rk43 (\16\:qbint \18\:qbint) resistor r=0.5666 c=0
Rk44 (\16\:qbint \20\:qbint) resistor r=0.1462 c=0
Rk56 (\21\:qbint \22\:qbint) resistor r=0.2116 c=0
Rk48 (\5\:RTb \7\:RTb) resistor r=0.216 c=0
Rk49 (\7\:RTb \8\:RTb) resistor r=0.521 c=0
Rk50 (\8\:RTb \9\:RTb) resistor r=0.3884 c=0
Rk51 (\8\:RTb \11\:RTb) resistor r=0.2014 c=0
Rk62 (\6\:qint \7\:qint) resistor r=0.2581 c=0
Rk63 (\7\:qint \8\:qint) resistor r=0.1613 c=0
Rk64 (\7\:qint \10\:qint) resistor r=0.2803 c=0
Rk30 (\5\:n35 \6\:n35) resistor r=0.3197 c=0
Rk31 (\6\:n35 \8\:n35) resistor r=0.4238 c=0
Rk35 (\10\:n35 \11\:n35) resistor r=0.3183 c=0
Rk36 (\11\:n35 \13\:n35) resistor r=0.3874 c=0
Rk60 (\15\:n35 \16\:n35) resistor r=0.2318 c=0
Rk61 (\16\:n35 \18\:n35) resistor r=0.3588 c=0
Rk68 (\2\:net098 \4\:net098) resistor r=0.7065 c=0
Rk65 (\2\:n40 \4\:n40) resistor r=0.625 c=0
Rl43 (\7\:RT \8\:RT) resistor r=651.902 c=0
Rl30 (\1\:RT \2\:RT) resistor r=169.515 c=0
Rl33 (\4\:RT \6\:RT) resistor r=21.372 c=0
Rl32 (\4\:RT \5\:RT) resistor r=264.027 c=0
Rl31 (\3\:RT \4\:RT) resistor r=96.114 c=0
Rl20 (\2\:RN \4\:RN) resistor r=62.3411 c=0
Rl18 (\1\:RN \2\:RN) resistor r=152.726 c=0
Rl19 (\2\:RN \3\:RN) resistor r=3.1183 c=0
Rl2 (\2\:D \3\:D) resistor r=50.0257 c=0
Rl1 (\1\:D \2\:D) resistor r=128.573 c=0
Rl14 (\2\:CKN \4\:CKN) resistor r=147.791 c=0
Rl12 (\1\:CKN \2\:CKN) resistor r=63.1757 c=0
Rl13 (\2\:CKN \3\:CKN) resistor r=2.0166 c=0
Rl46 (\13\:CKNb \14\:CKNb) resistor r=159.438 c=0
Rl9 (\3\:CKNb \4\:CKNb) resistor r=349.426 c=0
Rl10 (\2\:CKNb \5\:CKNb) resistor r=59.4618 c=0
Rl8 (\2\:CKNb \3\:CKNb) resistor r=237.282 c=0
Rl7 (CKNb \2\:CKNb) resistor r=147.923 c=0
Rl11 (\2\:CKNb \6\:CKNb) resistor r=4.3228 c=0
Rl38 (\7\:CKNb \8\:CKNb) resistor r=66.1349 c=0
Rl41 (\8\:CKNb \11\:CKNb) resistor r=820.277 c=0
Rl42 (\9\:CKNb \12\:CKNb) resistor r=66.8717 c=0
Rl40 (\9\:CKNb \10\:CKNb) resistor r=132.647 c=0
Rl39 (\8\:CKNb \9\:CKNb) resistor r=339.792 c=0
Rl5 (mout \2\:mout) resistor r=24.2328 c=0
Rl6 (\3\:mout \4\:mout) resistor r=24.2328 c=0
Rl23 (\5\:CKNbb \6\:CKNbb) resistor r=177.372 c=0
Rl47 (\7\:CKNbb \8\:CKNbb) resistor r=908.226 c=0
Rl22 (\3\:CKNbb \5\:CKNbb) resistor r=446.949 c=0
Rl21 (\3\:CKNbb \4\:CKNbb) resistor r=188.95 c=0
Rl4 (CKNbb \2\:CKNbb) resistor r=183.837 c=0
Rl3 (n20 \2\:n20) resistor r=205.495 c=0
Rl15 (\3\:n20 \4\:n20) resistor r=154.568 c=0
Rl17 (\4\:n20 \6\:n20) resistor r=191.976 c=0
Rl16 (\4\:n20 \5\:n20) resistor r=128.737 c=0
Rl51 (RNb \2\:RNb) resistor r=234.8 c=0
Rl52 (\2\:RNb \3\:RNb) resistor r=1125.6 c=0
Rl55 (\3\:RNb \6\:RNb) resistor r=707.521 c=0
Rl54 (\4\:RNb \5\:RNb) resistor r=106.884 c=0
Rl56 (\4\:RNb \7\:RNb) resistor r=197.09 c=0
Rl53 (\3\:RNb \4\:RNb) resistor r=336.011 c=0
Rl26 (\3\:n35g \4\:n35g) resistor r=250.512 c=0
Rl25 (\2\:n35g \3\:n35g) resistor r=181.74 c=0
Rl27 (\2\:n35g \5\:n35g) resistor r=94.1963 c=0
Rl24 (n35g \2\:n35g) resistor r=2.4834 c=0
Rl57 (\6\:qbint \7\:qbint) resistor r=149.805 c=0
Rl62 (\11\:qbint \12\:qbint) resistor r=237.758 c=0
Rl64 (\13\:qbint \14\:qbint) resistor r=199.892 c=0
Rl37 (\3\:qbint \5\:qbint) resistor r=35.3072 c=0
Rl36 (\2\:qbint \4\:qbint) resistor r=70.093 c=0
Rl34 (qbint \2\:qbint) resistor r=112.732 c=0
Rl35 (\2\:qbint \3\:qbint) resistor r=152.601 c=0
Rl58 (\7\:qbint \8\:qbint) resistor r=99.804 c=0
Rl61 (\8\:qbint \11\:qbint) resistor r=180.657 c=0
Rl63 (\9\:qbint \13\:qbint) resistor r=88.6112 c=0
Rl60 (\9\:qbint \10\:qbint) resistor r=387.298 c=0
Rl59 (\8\:qbint \9\:qbint) resistor r=104.193 c=0
Rl29 (\3\:RTb \4\:RTb) resistor r=239.402 c=0
Rl28 (RTb \2\:RTb) resistor r=121.113 c=0
Rl49 (\2\:qint \3\:qint) resistor r=64.1263 c=0
Rl50 (\2\:qint \4\:qint) resistor r=77.1508 c=0
Rl48 (qint \2\:qint) resistor r=3.1216 c=0
Rl44 (n35 \2\:n35) resistor r=508.667 c=0
Rl45 (\2\:n35 \3\:n35) resistor r=358.667 c=0
Rz20 (\1\:Q \2\:Q) resistor r=37.5 c=0
Rz15 (\1\:QN \2\:QN) resistor r=37.5 c=0
Rz21 (\1\:VSS \2\:VSS) resistor r=37.5 c=0
Rz22 (\12\:VSS \13\:VSS) resistor r=75 c=0
Rz23 (\14\:VSS \15\:VSS) resistor r=37.5 c=0
Rz24 (\16\:VSS \17\:VSS) resistor r=75 c=0
Rz25 (\18\:VSS \19\:VSS) resistor r=75 c=0
Rz26 (\20\:VSS \21\:VSS) resistor r=75 c=0
Rz27 (\22\:VSS \23\:VSS) resistor r=75 c=0
Rz30 (\24\:VSS \25\:VSS) resistor r=75 c=0
Rz31 (\30\:VSS \31\:VSS) resistor r=75 c=0
Rz32 (\34\:VSS \35\:VSS) resistor r=75 c=0
Rz33 (\36\:VSS \37\:VSS) resistor r=75 c=0
Rz34 (\38\:VSS \39\:VSS) resistor r=75 c=0
Rz4 (\17\:CKNb \18\:CKNb) resistor r=75 c=0
Rz5 (\13\:mout \14\:mout) resistor r=75 c=0
Rz6 (\15\:mout \16\:mout) resistor r=75 c=0
Rz3 (\9\:CKNbb \10\:CKNbb) resistor r=75 c=0
Rz1 (\11\:n20 \12\:n20) resistor r=75 c=0
Rz2 (\13\:n20 \14\:n20) resistor r=75 c=0
Rz7 (\8\:RNb \9\:RNb) resistor r=75 c=0
Rz9 (\9\:n35g \10\:n35g) resistor r=75 c=0
Rz13 (\11\:n35g \12\:n35g) resistor r=75 c=0
Rz12 (\19\:qbint \20\:qbint) resistor r=75 c=0
Rz14 (\10\:RTb \11\:RTb) resistor r=75 c=0
Rz17 (\5\:qint \6\:qint) resistor r=75 c=0
Rz8 (\7\:n35 \8\:n35) resistor r=75 c=0
Rz10 (\12\:n35 \13\:n35) resistor r=75 c=0
Rz16 (\17\:n35 \18\:n35) resistor r=75 c=0
Rz18 (n40 \2\:n40) resistor r=75 c=0
Rz19 (\3\:n40 \4\:n40) resistor r=75 c=0
Ry20 (\3\:Q \4\:Q) resistor r=20.6667 c=0
Ry17 (\4\:QN \5\:QN) resistor r=20.6667 c=0
Ry26 (\1\:VDD \2\:VDD) resistor r=20.6667 c=0
Ry27 (\13\:VDD \14\:VDD) resistor r=62 c=0
Ry28 (\15\:VDD \16\:VDD) resistor r=62 c=0
Ry29 (\17\:VDD \18\:VDD) resistor r=20.6667 c=0
Ry30 (\19\:VDD \20\:VDD) resistor r=62 c=0
Ry31 (\21\:VDD \22\:VDD) resistor r=62 c=0
Ry32 (\23\:VDD \24\:VDD) resistor r=62 c=0
Ry33 (\25\:VDD \26\:VDD) resistor r=62 c=0
Ry23 (\3\:VSS \4\:VSS) resistor r=12.4 c=0
Ry24 (\3\:VSS \6\:VSS) resistor r=5.1667 c=0
Ry25 (\3\:VSS \10\:VSS) resistor r=5.1667 c=0
Ry34 (\26\:VSS \27\:VSS) resistor r=12.4 c=0
Ry35 (\26\:VSS \29\:VSS) resistor r=5.1667 c=0
Ry36 (\26\:VSS \33\:VSS) resistor r=5.1667 c=0
Ry11 (\1\:ExtVDD \2\:ExtVDD) resistor r=62 c=0
Ry12 (\1\:ExtVDD \5\:ExtVDD) resistor r=62 c=0
Ry13 (\1\:ExtVDD \6\:ExtVDD) resistor r=62 c=0
Ry4 (\21\:CKNb \22\:CKNb) resistor r=62 c=0
Ry5 (\5\:mout \6\:mout) resistor r=62 c=0
Ry6 (\17\:mout \18\:mout) resistor r=62 c=0
Ry3 (\13\:CKNbb \14\:CKNbb) resistor r=62 c=0
Ry1 (\7\:n20 \8\:n20) resistor r=62 c=0
Ry2 (\15\:n20 \16\:n20) resistor r=62 c=0
Ry7 (\11\:RNb \12\:RNb) resistor r=62 c=0
Ry9 (\6\:n35g \7\:n35g) resistor r=62 c=0
Ry15 (\15\:n35g \16\:n35g) resistor r=62 c=0
Ry14 (\17\:qbint \18\:qbint) resistor r=62 c=0
Ry16 (\6\:RTb \7\:RTb) resistor r=62 c=0
Ry19 (\9\:qint \10\:qint) resistor r=62 c=0
Ry8 (\4\:n35 \5\:n35) resistor r=62 c=0
Ry10 (\9\:n35 \10\:n35) resistor r=62 c=0
Ry18 (\14\:n35 \15\:n35) resistor r=62 c=0
Ry21 (net098 \2\:net098) resistor r=62 c=0
Ry22 (\3\:net098 \4\:net098) resistor r=62 c=0
Rx24 (\3\:RT \9\:RT) resistor r=45 c=0
Rx25 (\1\:RT \10\:RT) resistor r=45 c=0
Rx26 (\7\:RT \11\:RT) resistor r=45 c=0
Rx11 (\3\:RN \5\:RN) resistor r=45 c=0
Rx3 (\2\:D D) resistor r=45 c=0
Rx9 (\3\:CKN \6\:CKN) resistor r=45 c=0
Rx1 (\4\:CKNb \15\:CKNb) resistor r=45 c=0
Rx2 (\10\:CKNb \16\:CKNb) resistor r=45 c=0
Rx10 (\6\:CKNb \20\:CKNb) resistor r=45 c=0
Rx27 (\14\:CKNb \23\:CKNb) resistor r=45 c=0
Rx28 (\11\:CKNb \24\:CKNb) resistor r=45 c=0
Rx12 (\4\:mout \10\:mout) resistor r=45 c=0
Rx13 (\2\:mout \12\:mout) resistor r=45 c=0
Rx7 (CKNbb \12\:CKNbb) resistor r=45 c=0
Rx8 (\3\:CKNbb \15\:CKNbb) resistor r=45 c=0
Rx16 (\6\:CKNbb \16\:CKNbb) resistor r=45 c=0
Rx17 (\8\:CKNbb \17\:CKNbb) resistor r=45 c=0
Rx4 (\2\:n20 \9\:n20) resistor r=45 c=0
Rx5 (\5\:n20 \10\:n20) resistor r=45 c=0
Rx6 (n20 \17\:n20) resistor r=45 c=0
Rx14 (\6\:RNb \10\:RNb) resistor r=45 c=0
Rx18 (\4\:n35g \8\:n35g) resistor r=45 c=0
Rx21 (n35g \14\:n35g) resistor r=45 c=0
Rx20 (\3\:qbint \15\:qbint) resistor r=45 c=0
Rx29 (\10\:qbint \21\:qbint) resistor r=45 c=0
Rx30 (qbint \22\:qbint) resistor r=45 c=0
Rx22 (\3\:RTb \5\:RTb) resistor r=45 c=0
Rx23 (RTb \9\:RTb) resistor r=45 c=0
Rx32 (qint \8\:qint) resistor r=45 c=0
Rx15 (\3\:n35 \6\:n35) resistor r=45 c=0
Rx19 (\2\:n35 \11\:n35) resistor r=45 c=0
Rx31 (n35 \16\:n35) resistor r=45 c=0
mn26 (\13\:n20 \2\:CKNbb n21 VSS) g45n1svt w=(1.45e-07) l=4.5e-08 nf=1 \
        as=8.7e-15 ad=2.03e-14 ps=4.1e-07 pd=5.7e-07 nrd=1.16667 \
        nrs=1.16667 sa=2.45e-07 sb=1.4e-07 sd=160n sca=8.0352 \
        scb=0.00565402 scc=8.19771e-05 m=(1)
mn25 (n21 \1\:D \12\:VSS VSS) g45n1svt w=(1.45e-07) l=4.5e-08 nf=1 \
        as=2.03e-14 ad=8.7e-15 ps=5.7e-07 pd=4.1e-07 nrd=1.16667 \
        nrs=1.16667 sa=2.45e-07 sb=1.4e-07 sd=160n sca=8.0352 \
        scb=0.00565402 scc=8.19771e-05 m=(1)
mn56 (\5\:qint \14\:qbint \14\:VSS VSS) g45n1svt w=(1.45e-07) l=4.5e-08 \
        nf=1 as=2.03e-14 ad=4.365e-14 ps=5.7e-07 pd=9e-07 nrd=1.16667 \
        nrs=1.16667 sa=3.75e-07 sb=1.4e-07 sd=160n sca=9.16682 \
        scb=0.00760686 scc=0.000164708 m=(1)
NM3 (net0121 \5\:qbint \16\:VSS VSS) g45n1svt w=(1.45e-07) l=4.5e-08 \
        nf=1 as=8.7e-15 ad=2.03e-14 ps=4.1e-07 pd=5.7e-07 nrd=1.16667 \
        nrs=1.16667 sa=1.4e-07 sb=2.45e-07 sd=160n sca=9.33388 \
        scb=0.00788941 scc=0.00017958 m=(1)
mn35 (n30 \3\:mout \34\:VSS VSS) g45n1svt w=(1.45e-07) l=4.5e-08 nf=1 \
        as=2.32e-14 ad=8.7e-15 ps=6.1e-07 pd=4.1e-07 nrd=1.16667 \
        nrs=1.16667 sa=2.45e-07 sb=3.45e-07 sd=160n sca=8.42104 \
        scb=0.00632542 scc=0.000106623 m=(1)
mn52 (n40 \12\:qbint \24\:VSS VSS) g45n1svt w=(1.45e-07) l=4.5e-08 nf=1 \
        as=2.03e-14 ad=2.32e-14 ps=5.7e-07 pd=6.1e-07 nrd=1.16667 \
        nrs=1.16667 sa=3.45e-07 sb=1.4e-07 sd=160n sca=8.42104 \
        scb=0.00632542 scc=0.000106623 m=(1)
mn51 (n40 RNb \30\:VSS VSS) g45n1svt w=(1.45e-07) l=4.5e-08 nf=1 \
        as=2.32e-14 ad=2.03e-14 ps=6.1e-07 pd=5.7e-07 nrd=1.16667 \
        nrs=1.16667 sa=1.4e-07 sb=3.45e-07 sd=160n sca=8.42104 \
        scb=0.00632542 scc=0.000106623 m=(1)
mn36 (\11\:n20 \12\:CKNb n30 VSS) g45n1svt w=(1.45e-07) l=4.5e-08 nf=1 \
        as=8.7e-15 ad=2.03e-14 ps=4.1e-07 pd=5.7e-07 nrd=1.16667 \
        nrs=1.16667 sa=1.4e-07 sb=4.5e-07 sd=160n sca=8.42104 \
        scb=0.00632542 scc=0.000106623 m=(1)
mn21 (\9\:CKNbb CKNb \22\:VSS VSS) g45n1svt w=(1.45e-07) l=4.5e-08 nf=1 \
        as=2.32e-14 ad=2.03e-14 ps=6.1e-07 pd=5.7e-07 nrd=1.16667 \
        nrs=1.16667 sa=1.4e-07 sb=3.45e-07 sd=160n sca=8.0352 \
        scb=0.00565402 scc=8.19771e-05 m=(1)
mn32 (\15\:mout \6\:n20 \34\:VSS VSS) g45n1svt w=(1.45e-07) l=4.5e-08 \
        nf=1 as=2.32e-14 ad=2.03e-14 ps=6.1e-07 pd=5.7e-07 nrd=1.16667 \
        nrs=1.16667 sa=4.5e-07 sb=1.4e-07 sd=160n sca=8.42104 \
        scb=0.00632542 scc=0.000106623 m=(1)
mn20 (\17\:CKNb \1\:CKN \22\:VSS VSS) g45n1svt w=(1.45e-07) l=4.5e-08 \
        nf=1 as=2.32e-14 ad=2.03e-14 ps=6.1e-07 pd=5.7e-07 nrd=1.16667 \
        nrs=1.16667 sa=3.45e-07 sb=1.4e-07 sd=160n sca=8.0352 \
        scb=0.00565402 scc=8.19771e-05 m=(1)
mn31 (\13\:mout \7\:RNb \38\:VSS VSS) g45n1svt w=(1.45e-07) l=4.5e-08 \
        nf=1 as=2.03e-14 ad=2.32e-14 ps=5.7e-07 pd=6.1e-07 nrd=1.16667 \
        nrs=1.16667 sa=1.4e-07 sb=3.45e-07 sd=160n sca=8.42104 \
        scb=0.00632542 scc=0.000106623 m=(1)
mn22 (\8\:RNb \1\:RN \20\:VSS VSS) g45n1svt w=(1.45e-07) l=4.5e-08 nf=1 \
        as=2.03e-14 ad=2.03e-14 ps=5.7e-07 pd=5.7e-07 nrd=1.16667 \
        nrs=1.16667 sa=1.4e-07 sb=1.4e-07 sd=160n sca=8.0352 \
        scb=0.00565402 scc=8.19771e-05 m=(1)
mn40 (\7\:n35 \7\:CKNb \13\:mout VSS) g45n1svt w=(1.45e-07) l=4.5e-08 \
        nf=1 as=2.32e-14 ad=2.03e-14 ps=6.1e-07 pd=5.7e-07 nrd=1.16667 \
        nrs=1.16667 sa=3.45e-07 sb=1.4e-07 sd=160n sca=8.42104 \
        scb=0.00632542 scc=0.000106623 m=(1)
NM0 (\9\:n35g \2\:RTb \12\:n35 VSS) g45n1svt w=(1.45e-07) l=4.5e-08 nf=1 \
        as=2.03e-14 ad=2.03e-14 ps=5.7e-07 pd=5.7e-07 nrd=1.16667 \
        nrs=1.16667 sa=1.4e-07 sb=1.4e-07 sd=160n sca=8.42104 \
        scb=0.00632542 scc=0.000106623 m=(1)
NM1 (\19\:qbint \5\:n35g \18\:VSS VSS) g45n1svt w=(1.45e-07) l=4.5e-08 \
        nf=1 as=2.03e-14 ad=2.03e-14 ps=5.7e-07 pd=5.7e-07 nrd=1.16667 \
        nrs=1.16667 sa=1.4e-07 sb=1.4e-07 sd=160n sca=9.33388 \
        scb=0.00788941 scc=0.00017958 m=(1)
mn45 (\10\:RTb \2\:RT \36\:VSS VSS) g45n1svt w=(1.45e-07) l=4.5e-08 nf=1 \
        as=2.03e-14 ad=2.03e-14 ps=5.7e-07 pd=5.7e-07 nrd=1.16667 \
        nrs=1.16667 sa=1.4e-07 sb=1.4e-07 sd=160n sca=8.42104 \
        scb=0.00632542 scc=0.000106623 m=(1)
NM2 (\11\:n35g \8\:RT net0121 VSS) g45n1svt w=(1.45e-07) l=4.5e-08 nf=1 \
        as=8.7e-15 ad=2.03e-14 ps=4.1e-07 pd=5.7e-07 nrd=1.16667 \
        nrs=1.16667 sa=2.45e-07 sb=1.4e-07 sd=160n sca=9.33388 \
        scb=0.00788941 scc=0.00017958 m=(1)
mn53 (\17\:n35 \7\:CKNbb \3\:n40 VSS) g45n1svt w=(1.45e-07) l=4.5e-08 \
        nf=1 as=2.03e-14 ad=2.03e-14 ps=5.7e-07 pd=5.7e-07 nrd=1.16667 \
        nrs=1.16667 sa=1.4e-07 sb=1.4e-07 sd=160n sca=8.42104 \
        scb=0.00632542 scc=0.000106623 m=(1)
mn57 (\1\:QN \4\:qint \14\:VSS VSS) g45n1svt w=(2.6e-07) l=4.5e-08 nf=1 \
        as=4.365e-14 ad=3.64e-14 ps=9e-07 pd=8e-07 nrd=1.16667 nrs=1.16667 \
        sa=1.4e-07 sb=2.71058e-07 sd=160n sca=9.50447 scb=0.0081528 \
        scc=0.00025289 m=(1)
mn55 (\1\:Q \6\:qbint \1\:VSS VSS) g45n1svt w=(2.6e-07) l=4.5e-08 nf=1 \
        as=3.64e-14 ad=3.64e-14 ps=8e-07 pd=8e-07 nrd=1.16667 nrs=1.16667 \
        sa=1.4e-07 sb=1.4e-07 sd=160n sca=9.50447 scb=0.0081528 \
        scc=0.00025289 m=(1)
mp55 (\3\:Q \7\:qbint \1\:VDD VDD) g45p1svt w=(3.9e-07) l=4.5e-08 nf=1 \
        as=5.46e-14 ad=5.46e-14 ps=1.06e-06 pd=1.06e-06 nrd=1.16667 \
        nrs=1.16667 sa=1.4e-07 sb=1.4e-07 sd=160n sca=20.1111 \
        scb=0.0190466 scc=0.00152507 m=(1)
mp57 (\4\:QN \3\:qint \17\:VDD VDD) g45p1svt w=(3.9e-07) l=4.5e-08 nf=1 \
        as=6.535e-14 ad=5.46e-14 ps=1.16e-06 pd=1.06e-06 nrd=1.16667 \
        nrs=1.16667 sa=1.4e-07 sb=2.69551e-07 sd=160n sca=35.5616 \
        scb=0.0384837 scc=0.00412627 m=(1)
ends RDFFNRX1
// End of subcircuit definition.
