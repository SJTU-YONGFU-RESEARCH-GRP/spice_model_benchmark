// Generated for: spectre (May  1 08:12:57 2013 )
// Library name: gsclib045
// Cell name: DFF2RX2
// View name: extracted

simulator lang=spectre

subckt DFF2RX2 CK D1 D2 Q1 Q1N Q2 Q2N RN VDD VSS
mp55 (\1\:Q1 qbint \42\:VDD VDD) g45p1svt w=(3.9e-07) l=4.5e-08 nf=1 \
        as=9.459e-14 ad=7.514e-14 ps=1.6e-06 pd=1.455e-06 nrd=1.16667 \
        nrs=1.16667 sa=3.45e-07 sb=1.17365e-06 sd=160n sca=30.5009 \
        scb=0.0202006 scc=0.00336097 m=(2)
PM19 (\3\:Q2N qint_2 \1\:VDD VDD) g45p1svt w=(3.9e-07) l=4.5e-08 nf=1 \
        as=7.546e-14 ad=6.24e-14 ps=1.855e-06 pd=1.1e-06 nrd=1.16667 \
        nrs=1.16667 sa=3.25e-07 sb=2.19808e-07 sd=160n sca=34.23 \
        scb=0.0247192 scc=0.00340661 m=(2)
mp57_1__rcx (\3\:Q1N qint \49\:VDD VDD) g45p1svt w=(3.9e-07) l=4.5e-08 \
        nf=1 as=7.546e-14 ad=6.24e-14 ps=1.855e-06 pd=1.1e-06 nrd=1.16667 \
        nrs=1.16667 sa=3.25e-07 sb=2.19808e-07 sd=160n sca=34.23 \
        scb=0.0247192 scc=0.00340661 m=(2)
PM17 (\1\:Q2 \7\:qbint_2 \5\:VDD VDD) g45p1svt w=(3.9e-07) l=4.5e-08 \
        nf=1 as=9.459e-14 ad=7.514e-14 ps=1.6e-06 pd=1.455e-06 nrd=1.16667 \
        nrs=1.16667 sa=3.45e-07 sb=1.17365e-06 sd=160n sca=30.5009 \
        scb=0.0202006 scc=0.00336097 m=(2)
C1 (RN VSS) capacitor c=4.44885e-16
C2 (CK VSS) capacitor c=4.64541e-17
C3 (Q2 VSS) capacitor c=4.01548e-17
C4 (VDD VSS) capacitor c=6.86064e-16
C5 (Q1 VSS) capacitor c=4.00319e-17
C6 (Q1N VSS) capacitor c=1.74736e-17
C7 (D1 VSS) capacitor c=3.0687e-17
C8 (Q2N VSS) capacitor c=1.74405e-17
C9 (Ckbb VSS) capacitor c=5.83339e-17
C10 (CKb VSS) capacitor c=1.02427e-16
C11 (qint VSS) capacitor c=1.53088e-16
C12 (Db VSS) capacitor c=8.10388e-17
C13 (n20 VSS) capacitor c=4.70784e-17
C14 (n6 VSS) capacitor c=5.26552e-17
C15 (n30 VSS) capacitor c=4.98669e-17
C16 (mout VSS) capacitor c=5.20555e-17
C17 (n8 VSS) capacitor c=8.35306e-19
C18 (qbint VSS) capacitor c=1.03369e-16
C19 (n11 VSS) capacitor c=8.47661e-19
C20 (qint_2 VSS) capacitor c=1.53163e-16
C21 (Db_2 VSS) capacitor c=7.88288e-17
C22 (n20_2 VSS) capacitor c=4.82796e-17
C23 (n6_2 VSS) capacitor c=5.20549e-17
C24 (n30_2 VSS) capacitor c=5.72641e-17
C25 (mout_2 VSS) capacitor c=5.24469e-17
C26 (n8_2 VSS) capacitor c=8.266e-19
C27 (qbint_2 VSS) capacitor c=2.83176e-17
C28 (n11_2 VSS) capacitor c=8.47661e-19
C29 (\5\:qbint_2 VSS) capacitor c=3.63421e-17
C30 (\10\:RN VSS) capacitor c=7.29281e-17
C31 (\4\:qbint_2 VSS) capacitor c=5.55804e-17
C32 (\15\:Ckbb VSS) capacitor c=5.61589e-17
C33 (\15\:CKb VSS) capacitor c=7.41128e-17
C34 (\8\:RN VSS) capacitor c=7.04243e-17
C35 (\11\:CKb VSS) capacitor c=4.32926e-17
C36 (\9\:Ckbb VSS) capacitor c=3.86994e-17
C37 (\1\:D2 VSS) capacitor c=3.98024e-17
C38 (\1\:CK VSS) capacitor c=4.17887e-17
C39 (\10\:CKb VSS) capacitor c=3.3164e-17
C40 (\1\:D1 VSS) capacitor c=3.87823e-17
C41 (\7\:Ckbb VSS) capacitor c=3.81148e-17
C42 (\4\:CKb VSS) capacitor c=4.35091e-17
C43 (\5\:RN VSS) capacitor c=7.05073e-17
C44 (\2\:CKb VSS) capacitor c=7.41944e-17
C45 (\2\:Ckbb VSS) capacitor c=5.66293e-17
C46 (\11\:qbint VSS) capacitor c=5.63828e-17
C47 (\1\:RN VSS) capacitor c=7.34168e-17
C48 (\3\:n30 VSS) capacitor c=5.5893e-17
C49 (\10\:qbint VSS) capacitor c=3.62389e-17
C50 (\10\:qbint_2 VSS) capacitor c=3.10848e-17
C51 (\3\:n30_2 VSS) capacitor c=5.00592e-17
C52 (\11\:RN VSS) capacitor c=9.09456e-17
C53 (\3\:qbint_2 VSS) capacitor c=7.1099e-17
C54 (\14\:CKb VSS) capacitor c=1.02426e-16
C55 (\13\:Ckbb VSS) capacitor c=3.28474e-17
C56 (\3\:n20_2 VSS) capacitor c=4.95251e-17
C57 (\9\:RN VSS) capacitor c=8.33164e-17
C58 (\3\:mout_2 VSS) capacitor c=5.15496e-17
C59 (\11\:Ckbb VSS) capacitor c=3.74541e-17
C60 (\12\:CKb VSS) capacitor c=4.36382e-17
C61 (\3\:D2 VSS) capacitor c=2.39062e-17
C62 (\3\:CK VSS) capacitor c=4.2874e-17
C63 (\9\:CKb VSS) capacitor c=3.16246e-17
C64 (\3\:D1 VSS) capacitor c=2.15307e-17
C65 (\6\:CKb VSS) capacitor c=4.41211e-17
C66 (\5\:Ckbb VSS) capacitor c=3.74533e-17
C67 (\3\:mout VSS) capacitor c=5.15827e-17
C68 (\4\:RN VSS) capacitor c=8.31365e-17
C69 (\3\:n20 VSS) capacitor c=4.95361e-17
C70 (\3\:Ckbb VSS) capacitor c=3.26485e-17
C71 (\14\:qbint VSS) capacitor c=7.10999e-17
C72 (\3\:RN VSS) capacitor c=9.13204e-17
C73 (\5\:qbint VSS) capacitor c=3.10841e-17
C74 (\9\:qbint_2 VSS) capacitor c=1.6724e-17
C75 (\2\:n30_2 VSS) capacitor c=4.13733e-17
C76 (\12\:RN VSS) capacitor c=2.62526e-17
C77 (\16\:Ckbb VSS) capacitor c=5.94942e-17
C78 (\16\:CKb VSS) capacitor c=3.39585e-17
C79 (\14\:Ckbb VSS) capacitor c=2.29083e-17
C80 (\2\:n20_2 VSS) capacitor c=4.65923e-17
C81 (\7\:RN VSS) capacitor c=2.8243e-17
C82 (\2\:mout_2 VSS) capacitor c=4.56189e-17
C83 (\12\:Ckbb VSS) capacitor c=3.56467e-17
C84 (\13\:CKb VSS) capacitor c=2.90859e-17
C85 (\10\:Ckbb VSS) capacitor c=2.79425e-17
C86 (\2\:D2 VSS) capacitor c=2.952e-17
C87 (\2\:CK VSS) capacitor c=3.38334e-17
C88 (\7\:CKb VSS) capacitor c=2.05344e-17
C89 (\2\:D1 VSS) capacitor c=2.98022e-17
C90 (\8\:Ckbb VSS) capacitor c=2.82544e-17
C91 (\5\:CKb VSS) capacitor c=2.9019e-17
C92 (\6\:Ckbb VSS) capacitor c=3.56504e-17
C93 (\2\:mout VSS) capacitor c=4.59934e-17
C94 (\6\:RN VSS) capacitor c=2.82712e-17
C95 (\2\:n20 VSS) capacitor c=4.77105e-17
C96 (\3\:CKb VSS) capacitor c=3.38894e-17
C97 (\4\:Ckbb VSS) capacitor c=2.47585e-17
C98 (\13\:qbint VSS) capacitor c=2.61923e-17
C99 (\2\:RN VSS) capacitor c=2.62285e-17
C100 (\2\:n30 VSS) capacitor c=4.06856e-17
C101 (\7\:qbint VSS) capacitor c=1.67767e-17
C102 (\1\:VDD VSS) capacitor c=1.65554e-17
C103 (\3\:Q2N VSS) capacitor c=3.94449e-17
C104 (\7\:qint_2 VSS) capacitor c=1.64474e-17
C105 (\1\:Q2 VSS) capacitor c=3.91205e-17
C106 (\17\:qbint_2 VSS) capacitor c=7.10105e-17
C107 (\14\:VDD VSS) capacitor c=3.63997e-17
C108 (\6\:n30_2 VSS) capacitor c=7.85236e-17
C109 (\4\:mout_2 VSS) capacitor c=4.62945e-17
C110 (\17\:VDD VSS) capacitor c=3.14642e-17
C111 (\21\:VDD VSS) capacitor c=3.49448e-17
C112 (\3\:n6_2 VSS) capacitor c=5.28019e-17
C113 (\6\:n20_2 VSS) capacitor c=7.22038e-17
C114 (\24\:VDD VSS) capacitor c=3.26775e-17
C115 (\26\:CKb VSS) capacitor c=3.60094e-17
C116 (\27\:VDD VSS) capacitor c=3.70773e-17
C117 (\30\:Ckbb VSS) capacitor c=1.09972e-16
C118 (\30\:VDD VSS) capacitor c=3.25405e-17
C119 (\4\:n20 VSS) capacitor c=5.06579e-17
C120 (\34\:VDD VSS) capacitor c=3.48721e-17
C121 (\3\:n6 VSS) capacitor c=5.2265e-17
C122 (\37\:VDD VSS) capacitor c=3.13801e-17
C123 (\8\:mout VSS) capacitor c=4.54225e-17
C124 (\4\:n30 VSS) capacitor c=7.88271e-17
C125 (\40\:VDD VSS) capacitor c=3.64593e-17
C126 (\16\:qbint VSS) capacitor c=7.12959e-17
C127 (\1\:Q1 VSS) capacitor c=3.91136e-17
C128 (\7\:qint VSS) capacitor c=1.64753e-17
C129 (\3\:Q1N VSS) capacitor c=3.9396e-17
C130 (\4\:VDD VSS) capacitor c=6.27427e-17
C131 (\1\:Q2N VSS) capacitor c=2.17167e-17
C132 (\10\:qint_2 VSS) capacitor c=1.99304e-17
C133 (\3\:Q2 VSS) capacitor c=3.47349e-17
C134 (\20\:qbint_2 VSS) capacitor c=4.59905e-17
C135 (\8\:n30_2 VSS) capacitor c=7.22661e-17
C136 (\8\:mout_2 VSS) capacitor c=5.07111e-17
C137 (\8\:n20_2 VSS) capacitor c=3.37869e-17
C138 (\3\:Db_2 VSS) capacitor c=1.00715e-16
C139 (\24\:CKb VSS) capacitor c=5.23524e-17
C140 (\28\:Ckbb VSS) capacitor c=4.57828e-17
C141 (\3\:Db VSS) capacitor c=1.0032e-16
C142 (\8\:n20 VSS) capacitor c=3.37983e-17
C143 (\6\:mout VSS) capacitor c=5.07098e-17
C144 (\8\:n30 VSS) capacitor c=7.23853e-17
C145 (\20\:qbint VSS) capacitor c=4.58997e-17
C146 (\3\:Q1 VSS) capacitor c=3.44057e-17
C147 (\11\:qint VSS) capacitor c=1.99539e-17
C148 (\1\:Q1N VSS) capacitor c=2.17167e-17
C149 (\4\:qbint VSS) capacitor c=3.12466e-17
C150 (\12\:qbint VSS) capacitor c=3.91929e-17
C151 (\8\:CKb VSS) capacitor c=1.51165e-17
C152 (\9\:qint VSS) capacitor c=1.78677e-17
C153 (\10\:qint VSS) capacitor c=3.08758e-17
C154 (\15\:qbint VSS) capacitor c=5.68885e-17
C155 (\18\:qbint VSS) capacitor c=4.00577e-17
C156 (\19\:qbint VSS) capacitor c=2.38214e-17
C157 (\2\:qbint_2 VSS) capacitor c=4.0236e-17
C158 (\6\:n30 VSS) capacitor c=9.47089e-17
C159 (\7\:n30 VSS) capacitor c=4.66543e-17
C160 (\4\:mout VSS) capacitor c=6.47948e-17
C161 (\5\:mout VSS) capacitor c=8.83548e-17
C162 (\6\:qbint_2 VSS) capacitor c=3.12624e-17
C163 (\7\:qbint_2 VSS) capacitor c=1.03319e-16
C164 (\6\:n20 VSS) capacitor c=1.07298e-16
C165 (\7\:n20 VSS) capacitor c=9.53614e-17
C166 (\6\:D1 VSS) capacitor c=6.6617e-17
C167 (\5\:CK VSS) capacitor c=5.13762e-17
C168 (\4\:D2 VSS) capacitor c=3.06872e-17
C169 (\5\:D2 VSS) capacitor c=5.82214e-17
C170 (\4\:n20_2 VSS) capacitor c=9.53804e-17
C171 (\5\:n20_2 VSS) capacitor c=7.93893e-17
C172 (\6\:mout_2 VSS) capacitor c=8.8519e-17
C173 (\7\:mout_2 VSS) capacitor c=6.49093e-17
C174 (\17\:CKb VSS) capacitor c=2.61041e-16
C175 (\18\:CKb VSS) capacitor c=2.69028e-16
C176 (\19\:CKb VSS) capacitor c=1.98909e-16
C177 (\20\:CKb VSS) capacitor c=2.2756e-16
C178 (\21\:CKb VSS) capacitor c=2.60118e-16
C179 (\22\:CKb VSS) capacitor c=4.59184e-17
C180 (\23\:CKb VSS) capacitor c=1.0117e-16
C181 (\13\:RN VSS) capacitor c=1.6054e-16
C182 (\14\:RN VSS) capacitor c=4.3045e-16
C183 (\15\:RN VSS) capacitor c=2.2851e-16
C184 (\16\:RN VSS) capacitor c=1.60942e-16
C185 (\17\:Ckbb VSS) capacitor c=1.03346e-16
C186 (\18\:Ckbb VSS) capacitor c=2.60488e-16
C187 (\20\:Ckbb VSS) capacitor c=1.4107e-16
C188 (\21\:Ckbb VSS) capacitor c=1.35613e-16
C189 (\22\:Ckbb VSS) capacitor c=1.00569e-16
C190 (\24\:Ckbb VSS) capacitor c=2.61556e-16
C191 (\25\:Ckbb VSS) capacitor c=1.03384e-16
C192 (\26\:Ckbb VSS) capacitor c=9.86559e-17
C193 (\27\:Ckbb VSS) capacitor c=8.54051e-17
C194 (\32\:Ckbb VSS) capacitor c=8.93782e-17
C195 (\33\:Ckbb VSS) capacitor c=9.74798e-17
C196 (\4\:n30_2 VSS) capacitor c=4.65923e-17
C197 (\5\:n30_2 VSS) capacitor c=9.6741e-17
C198 (\15\:qbint_2 VSS) capacitor c=2.3842e-17
C199 (\16\:qbint_2 VSS) capacitor c=4.00539e-17
C200 (\19\:qbint_2 VSS) capacitor c=5.86346e-17
C201 (\9\:qint_2 VSS) capacitor c=1.78538e-17
C202 (\12\:qint_2 VSS) capacitor c=3.04349e-17
C203 (\5\:VDD VSS) capacitor c=2.65762e-17
C204 (\13\:VDD VSS) capacitor c=3.50322e-17
C205 (\16\:VDD VSS) capacitor c=2.01967e-17
C206 (\20\:VDD VSS) capacitor c=2.80199e-17
C207 (\23\:VDD VSS) capacitor c=3.72624e-17
C208 (\26\:VDD VSS) capacitor c=1.53883e-17
C209 (\29\:VDD VSS) capacitor c=5.61864e-18
C210 (\33\:VDD VSS) capacitor c=2.22867e-17
C211 (\36\:VDD VSS) capacitor c=2.84357e-17
C212 (\39\:VDD VSS) capacitor c=3.51778e-17
C213 (\42\:VDD VSS) capacitor c=2.70388e-17
C214 (\49\:VDD VSS) capacitor c=1.70758e-17
Rk48 (\14\:RN RN) resistor r=2.1269 c=0
Rk47 (\13\:RN \14\:RN) resistor r=0.9838 c=0
Rk49 (RN \15\:RN) resistor r=0.8098 c=0
Rk50 (\15\:RN \16\:RN) resistor r=0.9838 c=0
Rk28 (D2 \4\:D2) resistor r=0.005018 c=0
Rk30 (\4\:D2 \5\:D2) resistor r=0.02312 c=0
Rk29 (\5\:D2 \6\:D2) resistor r=0.005132 c=0
Rk115 (\1\:VSS \5\:VSS) resistor r=0.1193 c=0
Rk116 (\5\:VSS \6\:VSS) resistor r=0.05655 c=0
Rk118 (\6\:VSS \8\:VSS) resistor r=0.2621 c=0
Rk119 (\8\:VSS \10\:VSS) resistor r=0.0369 c=0
Rk123 (\8\:VSS \17\:VSS) resistor r=0.4227 c=0
Rk124 (\17\:VSS \18\:VSS) resistor r=0.0691 c=0
Rk125 (\18\:VSS \19\:VSS) resistor r=0.5469 c=0
Rk127 (\20\:VSS VSS) resistor r=0.1428 c=0
Rk126 (\19\:VSS \20\:VSS) resistor r=0.2584 c=0
Rk128 (VSS \21\:VSS) resistor r=0.1031 c=0
Rk129 (\21\:VSS \22\:VSS) resistor r=0.1455 c=0
Rk130 (\22\:VSS \23\:VSS) resistor r=0.4705 c=0
Rk131 (\23\:VSS \24\:VSS) resistor r=0.4227 c=0
Rk132 (\24\:VSS \25\:VSS) resistor r=0.3071 c=0
Rk134 (\25\:VSS \27\:VSS) resistor r=0.1758 c=0
Rk136 (\17\:VSS \31\:VSS) resistor r=0.04333 c=0
Rk137 (\19\:VSS \33\:VSS) resistor r=0.0415 c=0
Rk138 (\20\:VSS \35\:VSS) resistor r=0.0415 c=0
Rk139 (\21\:VSS \37\:VSS) resistor r=0.0415 c=0
Rk140 (\23\:VSS \39\:VSS) resistor r=0.04333 c=0
Rk141 (\24\:VSS \41\:VSS) resistor r=0.0369 c=0
Rk27 (CK \5\:CK) resistor r=0.01178 c=0
Rk26 (\4\:CK \5\:CK) resistor r=0.004226 c=0
Rk72 (\2\:Q2 Q2) resistor r=0.2463 c=0
Rk73 (Q2 \4\:Q2) resistor r=0.06912 c=0
Rk80 (\1\:VDD \5\:VDD) resistor r=0.1318 c=0
Rk85 (\5\:VDD \13\:VDD) resistor r=0.2812 c=0
Rk86 (\13\:VDD \15\:VDD) resistor r=0.04333 c=0
Rk87 (\13\:VDD \16\:VDD) resistor r=0.3514 c=0
Rk88 (\16\:VDD \18\:VDD) resistor r=0.04333 c=0
Rk89 (\16\:VDD \19\:VDD) resistor r=0.1067 c=0
Rk90 (\19\:VDD \20\:VDD) resistor r=0.09033 c=0
Rk91 (\20\:VDD \22\:VDD) resistor r=0.0415 c=0
Rk92 (\20\:VDD \23\:VDD) resistor r=0.4554 c=0
Rk93 (\23\:VDD \25\:VDD) resistor r=0.04333 c=0
Rk96 (\26\:VDD VDD) resistor r=0.1441 c=0
Rk94 (\23\:VDD \26\:VDD) resistor r=0.2561 c=0
Rk95 (\26\:VDD \28\:VDD) resistor r=0.04333 c=0
Rk97 (VDD \29\:VDD) resistor r=0.102 c=0
Rk98 (\29\:VDD \31\:VDD) resistor r=0.04333 c=0
Rk99 (\29\:VDD \32\:VDD) resistor r=0.1469 c=0
Rk100 (\32\:VDD \33\:VDD) resistor r=0.3086 c=0
Rk101 (\33\:VDD \35\:VDD) resistor r=0.0415 c=0
Rk102 (\33\:VDD \36\:VDD) resistor r=0.1971 c=0
Rk103 (\36\:VDD \38\:VDD) resistor r=0.04333 c=0
Rk104 (\36\:VDD \39\:VDD) resistor r=0.3514 c=0
Rk105 (\39\:VDD \41\:VDD) resistor r=0.04333 c=0
Rk106 (\39\:VDD \42\:VDD) resistor r=0.2812 c=0
Rk111 (\42\:VDD \49\:VDD) resistor r=0.1708 c=0
Rk6 (\2\:Q1 Q1) resistor r=0.2549 c=0
Rk7 (Q1 \4\:Q1) resistor r=0.06912 c=0
Rk1 (Q1N \2\:Q1N) resistor r=0.07346 c=0
Rk2 (Q1N \4\:Q1N) resistor r=0.2048 c=0
Rk23 (\4\:D1 D1) resistor r=0.005246 c=0
Rk25 (\4\:D1 \6\:D1) resistor r=0.02312 c=0
Rk24 (\5\:D1 \6\:D1) resistor r=0.005132 c=0
Rk77 (Q2N \2\:Q2N) resistor r=0.07346 c=0
Rk78 (Q2N \4\:Q2N) resistor r=0.2048 c=0
Rk51 (\17\:Ckbb \18\:Ckbb) resistor r=0.5977 c=0
Rk52 (\18\:Ckbb \19\:Ckbb) resistor r=0.553 c=0
Rk53 (\19\:Ckbb \20\:Ckbb) resistor r=0.3792 c=0
Rk54 (\20\:Ckbb \21\:Ckbb) resistor r=0.7751 c=0
Rk55 (\21\:Ckbb \22\:Ckbb) resistor r=0.4439 c=0
Rk56 (\22\:Ckbb \23\:Ckbb) resistor r=0.3792 c=0
Rk57 (\23\:Ckbb \24\:Ckbb) resistor r=0.553 c=0
Rk58 (\24\:Ckbb \25\:Ckbb) resistor r=0.5963 c=0
Rk59 (\19\:Ckbb \26\:Ckbb) resistor r=0.02468 c=0
Rk60 (\20\:Ckbb \27\:Ckbb) resistor r=0.372 c=0
Rk61 (\21\:Ckbb \29\:Ckbb) resistor r=0.1983 c=0
Rk62 (\29\:Ckbb \31\:Ckbb) resistor r=0.3034 c=0
Rk63 (\22\:Ckbb \32\:Ckbb) resistor r=0.372 c=0
Rk64 (\23\:Ckbb \33\:Ckbb) resistor r=0.02468 c=0
Rk39 (\17\:CKb \18\:CKb) resistor r=0.8545 c=0
Rk40 (\18\:CKb \19\:CKb) resistor r=0.9273 c=0
Rk41 (\19\:CKb \20\:CKb) resistor r=0.8136 c=0
Rk42 (\20\:CKb \21\:CKb) resistor r=0.8545 c=0
Rk43 (\19\:CKb \22\:CKb) resistor r=0.1956 c=0
Rk44 (\22\:CKb \23\:CKb) resistor r=0.2092 c=0
Rk45 (\23\:CKb \25\:CKb) resistor r=0.2708 c=0
Rk46 (\22\:CKb \27\:CKb) resistor r=0.1732 c=0
Rk3 (\8\:qint \9\:qint) resistor r=0.1181 c=0
Rk4 (\9\:qint \10\:qint) resistor r=0.147 c=0
Rk5 (\9\:qint \12\:qint) resistor r=0.1449 c=0
Rk22 (\2\:Db \4\:Db) resistor r=0.4724 c=0
Rk19 (\5\:n20 \6\:n20) resistor r=0.3245 c=0
Rk20 (\6\:n20 \7\:n20) resistor r=0.507 c=0
Rk21 (\6\:n20 \9\:n20) resistor r=0.201 c=0
Rk18 (\2\:n6 \4\:n6) resistor r=0.3046 c=0
Rk12 (\5\:n30 \6\:n30) resistor r=0.4174 c=0
Rk13 (\6\:n30 \7\:n30) resistor r=0.2897 c=0
Rk14 (\6\:n30 \9\:n30) resistor r=0.266 c=0
Rk15 (\4\:mout \5\:mout) resistor r=0.3824 c=0
Rk16 (\5\:mout \7\:mout) resistor r=0.2069 c=0
Rk17 (\5\:mout \9\:mout) resistor r=0.251 c=0
Rk8 (\15\:qbint \17\:qbint) resistor r=0.3542 c=0
Rk9 (\17\:qbint \18\:qbint) resistor r=0.3837 c=0
Rk10 (\18\:qbint \19\:qbint) resistor r=0.05483 c=0
Rk11 (\18\:qbint \21\:qbint) resistor r=0.3515 c=0
Rk74 (\8\:qint_2 \9\:qint_2) resistor r=0.1181 c=0
Rk75 (\9\:qint_2 \11\:qint_2) resistor r=0.1449 c=0
Rk76 (\9\:qint_2 \12\:qint_2) resistor r=0.147 c=0
Rk31 (\2\:Db_2 \4\:Db_2) resistor r=0.4724 c=0
Rk33 (\4\:n20_2 \5\:n20_2) resistor r=0.507 c=0
Rk34 (\5\:n20_2 \7\:n20_2) resistor r=0.3237 c=0
Rk35 (\5\:n20_2 \9\:n20_2) resistor r=0.201 c=0
Rk32 (\2\:n6_2 \4\:n6_2) resistor r=0.3046 c=0
Rk65 (\4\:n30_2 \5\:n30_2) resistor r=0.2897 c=0
Rk66 (\5\:n30_2 \7\:n30_2) resistor r=0.418 c=0
Rk67 (\5\:n30_2 \9\:n30_2) resistor r=0.2637 c=0
Rk36 (\5\:mout_2 \6\:mout_2) resistor r=0.251 c=0
Rk37 (\6\:mout_2 \7\:mout_2) resistor r=0.3824 c=0
Rk38 (\6\:mout_2 \9\:mout_2) resistor r=0.2069 c=0
Rk68 (\15\:qbint_2 \16\:qbint_2) resistor r=0.05483 c=0
Rk69 (\16\:qbint_2 \18\:qbint_2) resistor r=0.3837 c=0
Rk70 (\18\:qbint_2 \19\:qbint_2) resistor r=0.34 c=0
Rk71 (\16\:qbint_2 \21\:qbint_2) resistor r=0.3481 c=0
Rl62 (\10\:RN \11\:RN) resistor r=140.385 c=0
Rl52 (\8\:RN \9\:RN) resistor r=147.643 c=0
Rl28 (\4\:RN \5\:RN) resistor r=147.643 c=0
Rl18 (\1\:RN \3\:RN) resistor r=140.385 c=0
Rl63 (\10\:RN \12\:RN) resistor r=66.0764 c=0
Rl51 (\7\:RN \8\:RN) resistor r=102.615 c=0
Rl29 (\5\:RN \6\:RN) resistor r=102.615 c=0
Rl17 (\1\:RN \2\:RN) resistor r=66.0764 c=0
Rl43 (\1\:D2 \2\:D2) resistor r=70.7448 c=0
Rl44 (\2\:D2 \3\:D2) resistor r=40.6058 c=0
Rl41 (\1\:CK \2\:CK) resistor r=24.2328 c=0
Rl42 (\2\:CK \3\:CK) resistor r=58.8482 c=0
Rl36 (\1\:D1 \2\:D1) resistor r=70.7448 c=0
Rl37 (\2\:D1 \3\:D1) resistor r=40.6058 c=0
Rl56 (\15\:Ckbb \16\:Ckbb) resistor r=32.9066 c=0
Rl55 (\13\:Ckbb \14\:Ckbb) resistor r=26.098 c=0
Rl48 (\11\:Ckbb \12\:Ckbb) resistor r=26.1559 c=0
Rl45 (\9\:Ckbb \10\:Ckbb) resistor r=40.3645 c=0
Rl35 (\7\:Ckbb \8\:Ckbb) resistor r=40.3645 c=0
Rl32 (\5\:Ckbb \6\:Ckbb) resistor r=26.1559 c=0
Rl23 (\3\:Ckbb \4\:Ckbb) resistor r=26.098 c=0
Rl22 (Ckbb \2\:Ckbb) resistor r=33.8727 c=0
Rl57 (\14\:CKb \15\:CKb) resistor r=232.258 c=0
Rl46 (\11\:CKb \12\:CKb) resistor r=136.538 c=0
Rl34 (\4\:CKb \6\:CKb) resistor r=136.538 c=0
Rl24 (CKb \2\:CKb) resistor r=232.258 c=0
Rl58 (\15\:CKb \16\:CKb) resistor r=55.0021 c=0
Rl47 (\11\:CKb \13\:CKb) resistor r=55.0021 c=0
Rl33 (\4\:CKb \5\:CKb) resistor r=55.0021 c=0
Rl25 (\2\:CKb \3\:CKb) resistor r=55.0021 c=0
Rl40 (\8\:CKb \10\:CKb) resistor r=64.2642 c=0
Rl39 (\8\:CKb \9\:CKb) resistor r=37.3411 c=0
Rl38 (\7\:CKb \8\:CKb) resistor r=1.2334 c=0
Rl26 (n20 \2\:n20) resistor r=24.2328 c=0
Rl27 (\2\:n20 \3\:n20) resistor r=114.617 c=0
Rl16 (\2\:n30 \3\:n30) resistor r=89.6978 c=0
Rl15 (n30 \2\:n30) resistor r=30.8129 c=0
Rl30 (mout \2\:mout) resistor r=83.8482 c=0
Rl31 (\2\:mout \3\:mout) resistor r=24.2328 c=0
Rl11 (qbint \7\:qbint) resistor r=4.1351 c=0
Rl8 (\4\:qbint qbint) resistor r=151.24 c=0
Rl14 (\4\:qbint \10\:qbint) resistor r=37.6951 c=0
Rl9 (\4\:qbint \5\:qbint) resistor r=51.1566 c=0
Rl19 (\12\:qbint \11\:qbint) resistor r=37.3411 c=0
Rl21 (\12\:qbint \14\:qbint) resistor r=120.033 c=0
Rl20 (\12\:qbint \13\:qbint) resistor r=3.1183 c=0
Rl53 (n20_2 \2\:n20_2) resistor r=24.2328 c=0
Rl54 (\2\:n20_2 \3\:n20_2) resistor r=114.617 c=0
Rl64 (n30_2 \2\:n30_2) resistor r=90.3846 c=0
Rl65 (\2\:n30_2 \3\:n30_2) resistor r=31.7061 c=0
Rl49 (mout_2 \2\:mout_2) resistor r=83.8482 c=0
Rl50 (\2\:mout_2 \3\:mout_2) resistor r=24.2328 c=0
Rl61 (\2\:qbint_2 \4\:qbint_2) resistor r=37.3411 c=0
Rl60 (\2\:qbint_2 \3\:qbint_2) resistor r=120.033 c=0
Rl59 (\2\:qbint_2 qbint_2) resistor r=3.1216 c=0
Rl66 (\6\:qbint_2 \5\:qbint_2) resistor r=37.6951 c=0
Rl70 (\6\:qbint_2 \10\:qbint_2) resistor r=51.1566 c=0
Rl69 (\7\:qbint_2 \9\:qbint_2) resistor r=4.1351 c=0
Rl67 (\7\:qbint_2 \6\:qbint_2) resistor r=151.24 c=0
Rz24 (\10\:VSS \9\:VSS) resistor r=75 c=0
Rz29 (\31\:VSS \30\:VSS) resistor r=75 c=0
Rz30 (\33\:VSS \32\:VSS) resistor r=75 c=0
Rz31 (\35\:VSS \34\:VSS) resistor r=75 c=0
Rz32 (\37\:VSS \36\:VSS) resistor r=75 c=0
Rz33 (\39\:VSS \38\:VSS) resistor r=75 c=0
Rz34 (\41\:VSS \40\:VSS) resistor r=75 c=0
Rz16 (\4\:Q2 \3\:Q2) resistor r=37.5 c=0
Rz19 (\5\:VDD \4\:VDD) resistor r=9.375 c=0
Rz20 (\19\:VDD \4\:VDD) resistor r=6.25 c=0
Rz21 (\32\:VDD \4\:VDD) resistor r=6.25 c=0
Rz22 (\42\:VDD \4\:VDD) resistor r=6.25 c=0
Rz3 (\4\:Q1 \3\:Q1) resistor r=37.5 c=0
Rz1 (\2\:Q1N \1\:Q1N) resistor r=37.5 c=0
Rz18 (\2\:Q2N \1\:Q2N) resistor r=37.5 c=0
Rz13 (\28\:Ckbb \29\:Ckbb) resistor r=75 c=0
Rz12 (\24\:CKb \25\:CKb) resistor r=75 c=0
Rz2 (\12\:qint \11\:qint) resistor r=75 c=0
Rz8 (\3\:Db \4\:Db) resistor r=75 c=0
Rz7 (\8\:n20 \9\:n20) resistor r=75 c=0
Rz5 (\8\:n30 \9\:n30) resistor r=75 c=0
Rz6 (\6\:mout \7\:mout) resistor r=75 c=0
Rz4 (\21\:qbint \20\:qbint) resistor r=75 c=0
Rz17 (\11\:qint_2 \10\:qint_2) resistor r=75 c=0
Rz9 (\3\:Db_2 \4\:Db_2) resistor r=75 c=0
Rz10 (\8\:n20_2 \9\:n20_2) resistor r=75 c=0
Rz14 (\8\:n30_2 \9\:n30_2) resistor r=75 c=0
Rz11 (\8\:mout_2 \9\:mout_2) resistor r=75 c=0
Rz15 (\21\:qbint_2 \20\:qbint_2) resistor r=75 c=0
Ry40 (\5\:VSS \4\:VSS) resistor r=7.75 c=0
Ry41 (\18\:VSS \4\:VSS) resistor r=5.1667 c=0
Ry42 (\22\:VSS \4\:VSS) resistor r=5.1667 c=0
Ry43 (\25\:VSS \4\:VSS) resistor r=5.1667 c=0
Ry20 (\2\:Q2 \1\:Q2) resistor r=31 c=0
Ry27 (\15\:VDD \14\:VDD) resistor r=62 c=0
Ry28 (\18\:VDD \17\:VDD) resistor r=62 c=0
Ry29 (\22\:VDD \21\:VDD) resistor r=62 c=0
Ry30 (\25\:VDD \24\:VDD) resistor r=62 c=0
Ry31 (\28\:VDD \27\:VDD) resistor r=62 c=0
Ry32 (\31\:VDD \30\:VDD) resistor r=62 c=0
Ry33 (\35\:VDD \34\:VDD) resistor r=62 c=0
Ry34 (\38\:VDD \37\:VDD) resistor r=62 c=0
Ry35 (\41\:VDD \40\:VDD) resistor r=62 c=0
Ry3 (\2\:Q1 \1\:Q1) resistor r=31 c=0
Ry1 (\4\:Q1N \3\:Q1N) resistor r=31 c=0
Ry22 (\4\:Q2N \3\:Q2N) resistor r=31 c=0
Ry17 (\30\:Ckbb \31\:Ckbb) resistor r=62 c=0
Ry16 (\26\:CKb \27\:CKb) resistor r=62 c=0
Ry2 (\8\:qint \7\:qint) resistor r=62 c=0
Ry10 (Db \2\:Db) resistor r=62 c=0
Ry9 (\4\:n20 \5\:n20) resistor r=62 c=0
Ry7 (n6 \2\:n6) resistor r=62 c=0
Ry8 (\3\:n6 \4\:n6) resistor r=62 c=0
Ry5 (\4\:n30 \5\:n30) resistor r=62 c=0
Ry6 (\8\:mout \9\:mout) resistor r=62 c=0
Ry4 (\17\:qbint \16\:qbint) resistor r=62 c=0
Ry21 (\8\:qint_2 \7\:qint_2) resistor r=62 c=0
Ry11 (Db_2 \2\:Db_2) resistor r=62 c=0
Ry14 (\6\:n20_2 \7\:n20_2) resistor r=62 c=0
Ry12 (n6_2 \2\:n6_2) resistor r=62 c=0
Ry13 (\3\:n6_2 \4\:n6_2) resistor r=62 c=0
Ry18 (\6\:n30_2 \7\:n30_2) resistor r=62 c=0
Ry15 (\4\:mout_2 \5\:mout_2) resistor r=62 c=0
Ry19 (\18\:qbint_2 \17\:qbint_2) resistor r=62 c=0
Rx17 (\12\:RN \13\:RN) resistor r=45 c=0
Rx18 (\7\:RN \14\:RN) resistor r=45 c=0
Rx19 (\6\:RN \15\:RN) resistor r=45 c=0
Rx20 (\2\:RN \16\:RN) resistor r=45 c=0
Rx9 (\2\:D2 \6\:D2) resistor r=45 c=0
Rx8 (\2\:CK \4\:CK) resistor r=45 c=0
Rx7 (\2\:D1 \5\:D1) resistor r=45 c=0
Rx21 (\16\:Ckbb \17\:Ckbb) resistor r=45 c=0
Rx22 (\14\:Ckbb \18\:Ckbb) resistor r=45 c=0
Rx23 (\4\:Ckbb \24\:Ckbb) resistor r=45 c=0
Rx24 (Ckbb \25\:Ckbb) resistor r=45 c=0
Rx25 (\12\:Ckbb \26\:Ckbb) resistor r=45 c=0
Rx26 (\10\:Ckbb \27\:Ckbb) resistor r=45 c=0
Rx27 (\8\:Ckbb \32\:Ckbb) resistor r=45 c=0
Rx28 (\6\:Ckbb \33\:Ckbb) resistor r=45 c=0
Rx12 (\16\:CKb \17\:CKb) resistor r=45 c=0
Rx13 (\13\:CKb \18\:CKb) resistor r=45 c=0
Rx14 (\5\:CKb \20\:CKb) resistor r=45 c=0
Rx15 (\3\:CKb \21\:CKb) resistor r=45 c=0
Rx16 (\7\:CKb \23\:CKb) resistor r=45 c=0
Rx1 (\10\:qint qint) resistor r=45 c=0
Rx6 (\2\:n20 \7\:n20) resistor r=45 c=0
Rx4 (\2\:n30 \7\:n30) resistor r=45 c=0
Rx5 (\2\:mout \4\:mout) resistor r=45 c=0
Rx2 (\15\:qbint \13\:qbint) resistor r=45 c=0
Rx3 (\19\:qbint \7\:qbint) resistor r=45 c=0
Rx32 (\12\:qint_2 qint_2) resistor r=45 c=0
Rx10 (\2\:n20_2 \4\:n20_2) resistor r=45 c=0
Rx29 (\2\:n30_2 \4\:n30_2) resistor r=45 c=0
Rx11 (\2\:mout_2 \7\:mout_2) resistor r=45 c=0
Rx30 (\15\:qbint_2 \9\:qbint_2) resistor r=45 c=0
Rx31 (\19\:qbint_2 qbint_2) resistor r=45 c=0
NM19_1__rcx (\1\:Q2N qint_2 \1\:VSS VSS) g45n1svt w=(2.6e-07) l=4.5e-08 \
        nf=1 as=5.136e-14 ad=5.085e-14 ps=1.245e-06 pd=1.17e-06 \
        nrd=1.16667 nrs=1.16667 sa=3.25e-07 sb=2.31058e-07 sd=160n \
        sca=17.5885 scb=0.0172826 scc=0.00162584 m=(2)
mn55_1__rcx (\3\:Q1 qbint \25\:VSS VSS) g45n1svt w=(2.6e-07) l=4.5e-08 \
        nf=1 as=4.16e-14 ad=6.395e-14 ps=8.4e-07 pd=1.55e-06 nrd=1.16667 \
        nrs=1.16667 sa=1.08654e-07 sb=3.45e-07 sd=160n sca=17.5885 \
        scb=0.0172826 scc=0.00162584 m=(2)
NM17 (\3\:Q2 \7\:qbint_2 \6\:VSS VSS) g45n1svt w=(2.6e-07) l=4.5e-08 \
        nf=1 as=4.16e-14 ad=6.395e-14 ps=8.4e-07 pd=1.55e-06 nrd=1.16667 \
        nrs=1.16667 sa=1.08654e-07 sb=3.45e-07 sd=160n sca=17.5885 \
        scb=0.0172826 scc=0.00162584 m=(2)
mn57 (\1\:Q1N qint \27\:VSS VSS) g45n1svt w=(2.6e-07) l=4.5e-08 nf=1 \
        as=5.136e-14 ad=5.085e-14 ps=1.245e-06 pd=1.17e-06 nrd=1.16667 \
        nrs=1.16667 sa=3.25e-07 sb=2.31058e-07 sd=160n sca=17.5885 \
        scb=0.0172826 scc=0.00162584 m=(2)
mn21 (\28\:Ckbb \9\:CKb \34\:VSS VSS) g45n1svt w=(1.45e-07) l=4.5e-08 \
        nf=1 as=2.03e-14 ad=6.752e-14 ps=5.7e-07 pd=1.56e-06 nrd=1.16667 \
        nrs=1.16667 sa=1.4e-07 sb=3.6e-07 sd=160n sca=19.8813 \
        scb=0.0206549 scc=0.00197265 m=(1)
mn20 (\24\:CKb \3\:CK \34\:VSS VSS) g45n1svt w=(1.45e-07) l=4.5e-08 nf=1 \
        as=2.03e-14 ad=6.752e-14 ps=5.7e-07 pd=1.56e-06 nrd=1.16667 \
        nrs=1.16667 sa=3.6e-07 sb=1.4e-07 sd=160n sca=19.8813 \
        scb=0.0206549 scc=0.00197265 m=(1)
NM1 (\3\:Db_2 \3\:D2 \32\:VSS VSS) g45n1svt w=(1.45e-07) l=4.5e-08 nf=1 \
        as=6.163e-14 ad=4.725e-14 ps=1.14e-06 pd=1.35e-06 nrd=1.16667 \
        nrs=1.16667 sa=1.15e-07 sb=1.54207e-06 sd=160n sca=13.6097 \
        scb=0.014254 scc=0.000755054 m=(1)
NM7 (\3\:Db_2 \12\:CKb \8\:n20_2 VSS) g45n1svt w=(1.45e-07) l=4.5e-08 \
        nf=1 as=2.9e-14 ad=6.163e-14 ps=6.9e-07 pd=1.14e-06 nrd=1.16667 \
        nrs=1.16667 sa=1.21552e-06 sb=5.85e-07 sd=160n sca=13.6097 \
        scb=0.014254 scc=0.000755054 m=(1)
NM9 (\8\:n20_2 \11\:Ckbb n5_2 VSS) g45n1svt w=(1.45e-07) l=4.5e-08 nf=1 \
        as=1.957e-14 ad=2.9e-14 ps=5.6e-07 pd=6.9e-07 nrd=1.16667 \
        nrs=1.16667 sa=9.70517e-07 sb=8.3e-07 sd=160n sca=13.6097 \
        scb=0.014254 scc=0.000755054 m=(1)
NM11 (n5_2 \3\:mout_2 n7_2 VSS) g45n1svt w=(1.45e-07) l=4.5e-08 nf=1 \
        as=1.957e-14 ad=1.233e-14 ps=5.6e-07 pd=4.6e-07 nrd=1.16667 \
        nrs=1.16667 sa=1.01e-06 sb=7.90517e-07 sd=160n sca=13.6097 \
        scb=0.014254 scc=0.000755054 m=(1)
NM10 (n7_2 \9\:RN \30\:VSS VSS) g45n1svt w=(1.45e-07) l=4.5e-08 nf=1 \
        as=1.232e-14 ad=7.322e-14 ps=4.6e-07 pd=1.45e-06 nrd=1.16667 \
        nrs=1.16667 sa=1.14e-06 sb=6.60517e-07 sd=160n sca=13.6097 \
        scb=0.014254 scc=0.000755054 m=(1)
NM8 (\8\:mout_2 \3\:n20_2 \30\:VSS VSS) g45n1svt w=(1.45e-07) l=4.5e-08 \
        nf=1 as=2.682e-14 ad=7.322e-14 ps=6.6e-07 pd=1.45e-06 nrd=1.16667 \
        nrs=1.16667 sa=7.28621e-07 sb=1.00121e-06 sd=160n sca=9.50767 \
        scb=0.00818119 scc=0.00019576 m=(1)
NM12 (\8\:mout_2 \13\:Ckbb \8\:n30_2 VSS) g45n1svt w=(1.45e-07) l=4.5e-08 \
        nf=1 as=2.682e-14 ad=2.755e-14 ps=6.6e-07 pd=6.7e-07 nrd=1.16667 \
        nrs=1.16667 sa=9.58621e-07 sb=7.71207e-07 sd=160n sca=9.50767 \
        scb=0.00818119 scc=0.00019576 m=(1)
NM16 (\8\:n30_2 \14\:CKb n11_2 VSS) g45n1svt w=(1.45e-07) l=4.5e-08 nf=1 \
        as=8.7e-15 ad=2.755e-14 ps=4.1e-07 pd=6.7e-07 nrd=1.16667 \
        nrs=1.16667 sa=5.36207e-07 sb=1.19362e-06 sd=160n sca=9.50767 \
        scb=0.00818119 scc=0.00019576 m=(1)
NM15 (n11_2 \3\:qbint_2 \9\:VSS VSS) g45n1svt w=(1.45e-07) l=4.5e-08 \
        nf=1 as=5.59e-14 ad=8.7e-15 ps=1.45e-06 pd=4.1e-07 nrd=1.16667 \
        nrs=1.16667 sa=4.31207e-07 sb=1.29862e-06 sd=160n sca=9.50767 \
        scb=0.00818119 scc=0.00019576 m=(1)
NM18 (\10\:qint_2 \10\:qbint_2 \1\:VSS VSS) g45n1svt w=(1.45e-07) \
        l=4.5e-08 nf=1 as=6.112e-14 ad=2.03e-14 ps=1.65e-06 pd=5.7e-07 \
        nrd=1.16667 nrs=1.16667 sa=5.2e-07 sb=1.4e-07 sd=160n sca=23.279 \
        scb=0.0230742 scc=0.00267719 m=(1)
mn11 (\3\:Db \3\:D1 \36\:VSS VSS) g45n1svt w=(1.45e-07) l=4.5e-08 nf=1 \
        as=6.163e-14 ad=4.725e-14 ps=1.14e-06 pd=1.35e-06 nrd=1.16667 \
        nrs=1.16667 sa=1.15e-07 sb=1.54207e-06 sd=160n sca=13.6097 \
        scb=0.014254 scc=0.000755054 m=(1)
mn25 (\3\:Db \6\:CKb \8\:n20 VSS) g45n1svt w=(1.45e-07) l=4.5e-08 nf=1 \
        as=2.9e-14 ad=6.163e-14 ps=6.9e-07 pd=1.14e-06 nrd=1.16667 \
        nrs=1.16667 sa=1.21552e-06 sb=5.85e-07 sd=160n sca=13.6097 \
        scb=0.014254 scc=0.000755054 m=(1)
mn37 (\8\:n20 \5\:Ckbb n5 VSS) g45n1svt w=(1.45e-07) l=4.5e-08 nf=1 \
        as=1.957e-14 ad=2.9e-14 ps=5.6e-07 pd=6.9e-07 nrd=1.16667 \
        nrs=1.16667 sa=9.70517e-07 sb=8.3e-07 sd=160n sca=13.6097 \
        scb=0.014254 scc=0.000755054 m=(1)
mn36 (n5 \3\:mout n7 VSS) g45n1svt w=(1.45e-07) l=4.5e-08 nf=1 \
        as=1.957e-14 ad=1.233e-14 ps=5.6e-07 pd=4.6e-07 nrd=1.16667 \
        nrs=1.16667 sa=1.01e-06 sb=7.90517e-07 sd=160n sca=13.6097 \
        scb=0.014254 scc=0.000755054 m=(1)
mn35 (n7 \4\:RN \38\:VSS VSS) g45n1svt w=(1.45e-07) l=4.5e-08 nf=1 \
        as=1.232e-14 ad=7.322e-14 ps=4.6e-07 pd=1.45e-06 nrd=1.16667 \
        nrs=1.16667 sa=1.14e-06 sb=6.60517e-07 sd=160n sca=13.6097 \
        scb=0.014254 scc=0.000755054 m=(1)
mn30 (\6\:mout \3\:n20 \38\:VSS VSS) g45n1svt w=(1.45e-07) l=4.5e-08 \
        nf=1 as=2.682e-14 ad=7.322e-14 ps=6.6e-07 pd=1.45e-06 nrd=1.16667 \
        nrs=1.16667 sa=7.28621e-07 sb=1.00121e-06 sd=160n sca=9.50767 \
        scb=0.00818119 scc=0.00019576 m=(1)
mn40 (\6\:mout \3\:Ckbb \8\:n30 VSS) g45n1svt w=(1.45e-07) l=4.5e-08 nf=1 \
        as=2.682e-14 ad=2.755e-14 ps=6.6e-07 pd=6.7e-07 nrd=1.16667 \
        nrs=1.16667 sa=9.58621e-07 sb=7.71207e-07 sd=160n sca=9.50767 \
        scb=0.00818119 scc=0.00019576 m=(1)
mn51 (\8\:n30 CKb n11 VSS) g45n1svt w=(1.45e-07) l=4.5e-08 nf=1 \
        as=8.7e-15 ad=2.755e-14 ps=4.1e-07 pd=6.7e-07 nrd=1.16667 \
        nrs=1.16667 sa=5.36207e-07 sb=1.19362e-06 sd=160n sca=9.50767 \
        scb=0.00818119 scc=0.00019576 m=(1)
mn50 (n11 \14\:qbint \40\:VSS VSS) g45n1svt w=(1.45e-07) l=4.5e-08 nf=1 \
        as=5.59e-14 ad=8.7e-15 ps=1.45e-06 pd=4.1e-07 nrd=1.16667 \
        nrs=1.16667 sa=4.31207e-07 sb=1.29862e-06 sd=160n sca=9.50767 \
        scb=0.00818119 scc=0.00019576 m=(1)
mn56 (\11\:qint \5\:qbint \27\:VSS VSS) g45n1svt w=(1.45e-07) l=4.5e-08 \
        nf=1 as=6.112e-14 ad=2.03e-14 ps=1.65e-06 pd=5.7e-07 nrd=1.16667 \
        nrs=1.16667 sa=5.2e-07 sb=1.4e-07 sd=160n sca=23.279 scb=0.0230742 \
        scc=0.00267719 m=(1)
NM14 (n9_2 \11\:RN \9\:VSS VSS) g45n1svt w=(2.05e-07) l=4.5e-08 nf=1 \
        as=5.59e-14 ad=1.23e-14 ps=1.45e-06 pd=5.3e-07 nrd=1.16667 \
        nrs=1.16667 sa=2.5e-07 sb=9.96098e-07 sd=160n sca=11.535 \
        scb=0.0112489 scc=0.00047927 m=(1)
NM13 (\20\:qbint_2 \3\:n30_2 n9_2 VSS) g45n1svt w=(2.05e-07) l=4.5e-08 \
        nf=1 as=2.973e-14 ad=1.23e-14 ps=7e-07 pd=5.3e-07 nrd=1.16667 \
        nrs=1.16667 sa=1.0678e-06 sb=1.45e-07 sd=160n sca=11.535 \
        scb=0.0112489 scc=0.00047927 m=(1)
mn45 (n9 \3\:RN \40\:VSS VSS) g45n1svt w=(2.05e-07) l=4.5e-08 nf=1 \
        as=5.59e-14 ad=1.23e-14 ps=1.45e-06 pd=5.3e-07 nrd=1.16667 \
        nrs=1.16667 sa=2.5e-07 sb=9.96098e-07 sd=160n sca=11.535 \
        scb=0.0112489 scc=0.00047927 m=(1)
mn46 (\20\:qbint n30 n9 VSS) g45n1svt w=(2.05e-07) l=4.5e-08 nf=1 \
        as=2.973e-14 ad=1.23e-14 ps=7e-07 pd=5.3e-07 nrd=1.16667 \
        nrs=1.16667 sa=1.0678e-06 sb=1.45e-07 sd=160n sca=11.535 \
        scb=0.0112489 scc=0.00047927 m=(1)
mp21 (\30\:Ckbb \10\:CKb \27\:VDD VDD) g45p1svt w=(2.15e-07) l=4.5e-08 \
        nf=1 as=3.01e-14 ad=8.732e-14 ps=7.1e-07 pd=1.85e-06 nrd=1.16667 \
        nrs=1.16667 sa=1.4e-07 sb=3.6e-07 sd=160n sca=31.508 scb=0.0252524 \
        scc=0.00399199 m=(1)
mp20 (\26\:CKb \1\:CK \27\:VDD VDD) g45p1svt w=(2.15e-07) l=4.5e-08 nf=1 \
        as=3.01e-14 ad=8.732e-14 ps=7.1e-07 pd=1.85e-06 nrd=1.16667 \
        nrs=1.16667 sa=3.6e-07 sb=1.4e-07 sd=160n sca=31.508 scb=0.0252524 \
        scc=0.00399199 m=(1)
PM1 (Db_2 \1\:D2 \24\:VDD VDD) g45p1svt w=(2.15e-07) l=4.5e-08 nf=1 \
        as=6.28e-14 ad=4.3e-14 ps=1.73e-06 pd=8.3e-07 nrd=1.16667 \
        nrs=1.16667 sa=6.25e-07 sb=1.15e-07 sd=160n sca=29.9075 \
        scb=0.0247057 scc=0.00372713 m=(1)
PM7 (\6\:n20_2 \9\:Ckbb Db_2 VDD) g45p1svt w=(2.15e-07) l=4.5e-08 nf=1 \
        as=4.3e-14 ad=3.87e-14 ps=8.3e-07 pd=7.9e-07 nrd=1.16667 \
        nrs=1.16667 sa=3.8e-07 sb=3.6e-07 sd=160n sca=29.9075 \
        scb=0.0247057 scc=0.00372713 m=(1)
PM10 (\6\:n20_2 \11\:CKb \3\:n6_2 VDD) g45p1svt w=(2.15e-07) l=4.5e-08 \
        nf=1 as=3.332e-14 ad=3.87e-14 ps=7.4e-07 pd=7.9e-07 nrd=1.16667 \
        nrs=1.16667 sa=1.55e-07 sb=5.85e-07 sd=160n sca=29.9075 \
        scb=0.0247057 scc=0.00372713 m=(1)
PM11 (n6_2 mout_2 \21\:VDD VDD) g45p1svt w=(2.15e-07) l=4.5e-08 nf=1 \
        as=5.487e-14 ad=3.44e-14 ps=1.74e-06 pd=7.5e-07 nrd=1.16667 \
        nrs=1.16667 sa=2e-06 sb=1e-07 sd=160n sca=29.9075 scb=0.0247057 \
        scc=0.00372713 m=(1)
PM9 (n6_2 \8\:RN \17\:VDD VDD) g45p1svt w=(2.15e-07) l=4.5e-08 nf=1 \
        as=3.44e-14 ad=6.5e-14 ps=7.5e-07 pd=1.83e-06 nrd=1.16667 \
        nrs=1.16667 sa=3.05e-07 sb=1.84e-06 sd=160n sca=29.9075 \
        scb=0.0247057 scc=0.00372713 m=(1)
PM8 (\4\:mout_2 n20_2 \17\:VDD VDD) g45p1svt w=(2.15e-07) l=4.5e-08 nf=1 \
        as=4.407e-14 ad=6.5e-14 ps=8.4e-07 pd=1.83e-06 nrd=1.16667 \
        nrs=1.16667 sa=5e-07 sb=1.645e-06 sd=160n sca=29.9075 \
        scb=0.0247057 scc=0.00372713 m=(1)
PM12 (\6\:n30_2 \15\:CKb \4\:mout_2 VDD) g45p1svt w=(2.15e-07) l=4.5e-08 \
        nf=1 as=3.44e-14 ad=4.407e-14 ps=7.5e-07 pd=8.4e-07 nrd=1.16667 \
        nrs=1.16667 sa=7.5e-07 sb=1.395e-06 sd=160n sca=29.9075 \
        scb=0.0247057 scc=0.00372713 m=(1)
PM16 (\6\:n30_2 \15\:Ckbb n8_2 VDD) g45p1svt w=(2.15e-07) l=4.5e-08 nf=1 \
        as=1.505e-14 ad=3.44e-14 ps=5.7e-07 pd=7.5e-07 nrd=1.16667 \
        nrs=1.16667 sa=1.19e-06 sb=9.55e-07 sd=160n sca=29.9075 \
        scb=0.0247057 scc=0.00372713 m=(1)
PM15 (n8_2 \4\:qbint_2 \14\:VDD VDD) g45p1svt w=(2.15e-07) l=4.5e-08 \
        nf=1 as=7.575e-14 ad=1.505e-14 ps=1.83e-06 pd=5.7e-07 nrd=1.16667 \
        nrs=1.16667 sa=1.075e-06 sb=1.07e-06 sd=160n sca=29.9075 \
        scb=0.0247057 scc=0.00372713 m=(1)
PM18 (\7\:qint_2 \5\:qbint_2 \1\:VDD VDD) g45p1svt w=(2.15e-07) \
        l=4.5e-08 nf=1 as=7.515e-14 ad=2.63e-14 ps=1.9e-06 pd=7.1e-07 \
        nrd=1.16667 nrs=1.16667 sa=5.2e-07 sb=1.22326e-07 sd=160n \
        sca=47.1496 scb=0.0292159 scc=0.00588548 m=(1)
mp11 (Db \1\:D1 \30\:VDD VDD) g45p1svt w=(2.15e-07) l=4.5e-08 nf=1 \
        as=6.28e-14 ad=4.3e-14 ps=1.73e-06 pd=8.3e-07 nrd=1.16667 \
        nrs=1.16667 sa=6.25e-07 sb=1.15e-07 sd=160n sca=29.9075 \
        scb=0.0247057 scc=0.00372713 m=(1)
mp25 (\4\:n20 \7\:Ckbb Db VDD) g45p1svt w=(2.15e-07) l=4.5e-08 nf=1 \
        as=4.3e-14 ad=3.87e-14 ps=8.3e-07 pd=7.9e-07 nrd=1.16667 \
        nrs=1.16667 sa=3.8e-07 sb=3.6e-07 sd=160n sca=29.9075 \
        scb=0.0247057 scc=0.00372713 m=(1)
mp37 (\4\:n20 \4\:CKb n6 VDD) g45p1svt w=(2.15e-07) l=4.5e-08 nf=1 \
        as=3.333e-14 ad=3.87e-14 ps=7.4e-07 pd=7.9e-07 nrd=1.16667 \
        nrs=1.16667 sa=1.55e-07 sb=5.85e-07 sd=160n sca=29.9075 \
        scb=0.0247057 scc=0.00372713 m=(1)
mp36 (\3\:n6 mout \34\:VDD VDD) g45p1svt w=(2.15e-07) l=4.5e-08 nf=1 \
        as=5.488e-14 ad=3.44e-14 ps=1.74e-06 pd=7.5e-07 nrd=1.16667 \
        nrs=1.16667 sa=2e-06 sb=1e-07 sd=160n sca=29.9075 scb=0.0247057 \
        scc=0.00372713 m=(1)
mp35 (\3\:n6 \5\:RN \37\:VDD VDD) g45p1svt w=(2.15e-07) l=4.5e-08 nf=1 \
        as=3.44e-14 ad=6.5e-14 ps=7.5e-07 pd=1.83e-06 nrd=1.16667 \
        nrs=1.16667 sa=3.05e-07 sb=1.84e-06 sd=160n sca=29.9075 \
        scb=0.0247057 scc=0.00372713 m=(1)
mp30 (\8\:mout n20 \37\:VDD VDD) g45p1svt w=(2.15e-07) l=4.5e-08 nf=1 \
        as=4.408e-14 ad=6.5e-14 ps=8.4e-07 pd=1.83e-06 nrd=1.16667 \
        nrs=1.16667 sa=5e-07 sb=1.645e-06 sd=160n sca=29.9075 \
        scb=0.0247057 scc=0.00372713 m=(1)
mp40 (\4\:n30 \2\:CKb \8\:mout VDD) g45p1svt w=(2.15e-07) l=4.5e-08 nf=1 \
        as=3.44e-14 ad=4.408e-14 ps=7.5e-07 pd=8.4e-07 nrd=1.16667 \
        nrs=1.16667 sa=7.5e-07 sb=1.395e-06 sd=160n sca=29.9075 \
        scb=0.0247057 scc=0.00372713 m=(1)
mp51 (\4\:n30 \2\:Ckbb n8 VDD) g45p1svt w=(2.15e-07) l=4.5e-08 nf=1 \
        as=1.505e-14 ad=3.44e-14 ps=5.7e-07 pd=7.5e-07 nrd=1.16667 \
        nrs=1.16667 sa=1.19e-06 sb=9.55e-07 sd=160n sca=29.9075 \
        scb=0.0247057 scc=0.00372713 m=(1)
mp50 (n8 \11\:qbint \40\:VDD VDD) g45p1svt w=(2.15e-07) l=4.5e-08 nf=1 \
        as=7.575e-14 ad=1.505e-14 ps=1.83e-06 pd=5.7e-07 nrd=1.16667 \
        nrs=1.16667 sa=1.075e-06 sb=1.07e-06 sd=160n sca=29.9075 \
        scb=0.0247057 scc=0.00372713 m=(1)
mp56 (\7\:qint \10\:qbint \49\:VDD VDD) g45p1svt w=(2.15e-07) l=4.5e-08 \
        nf=1 as=7.515e-14 ad=2.63e-14 ps=1.9e-06 pd=7.1e-07 nrd=1.16667 \
        nrs=1.16667 sa=5.2e-07 sb=1.22326e-07 sd=160n sca=47.1496 \
        scb=0.0292159 scc=0.00588548 m=(1)
PM13 (\17\:qbint_2 \10\:RN \14\:VDD VDD) g45p1svt w=(3.1e-07) l=4.5e-08 \
        nf=1 as=7.575e-14 ad=4.96e-14 ps=1.83e-06 pd=9.4e-07 nrd=1.16667 \
        nrs=1.16667 sa=8.7e-07 sb=9.17984e-07 sd=160n sca=24.2842 \
        scb=0.0202139 scc=0.00265344 m=(1)
PM14 (\17\:qbint_2 n30_2 \5\:VDD VDD) g45p1svt w=(3.1e-07) l=4.5e-08 \
        nf=1 as=4.96e-14 ad=1.2677e-13 ps=9.4e-07 pd=2.1e-06 nrd=1.16667 \
        nrs=1.16667 sa=1.12298e-06 sb=6.65e-07 sd=160n sca=24.2842 \
        scb=0.0202139 scc=0.00265344 m=(1)
mp45 (\16\:qbint \1\:RN \40\:VDD VDD) g45p1svt w=(3.1e-07) l=4.5e-08 \
        nf=1 as=7.575e-14 ad=4.96e-14 ps=1.83e-06 pd=9.4e-07 nrd=1.16667 \
        nrs=1.16667 sa=8.7e-07 sb=9.17984e-07 sd=160n sca=24.2842 \
        scb=0.0202139 scc=0.00265344 m=(1)
mp46 (\16\:qbint \3\:n30 \42\:VDD VDD) g45p1svt w=(3.1e-07) l=4.5e-08 \
        nf=1 as=4.96e-14 ad=1.2677e-13 ps=9.4e-07 pd=2.1e-06 nrd=1.16667 \
        nrs=1.16667 sa=1.12298e-06 sb=6.65e-07 sd=160n sca=24.2842 \
        scb=0.0202139 scc=0.00265344 m=(1)
ends DFF2RX2
// End of subcircuit definition.
