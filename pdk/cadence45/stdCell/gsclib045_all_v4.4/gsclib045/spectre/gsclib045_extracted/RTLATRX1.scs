// Generated for: spectre (May  1 08:12:27 2013 )
// Library name: gsclib045
// Cell name: RTLATRX1
// View name: extracted

simulator lang=spectre

subckt RTLATRX1 D ExtVDD G Q QN RN RT VDD VSS
mp5 (net142 \3\:D \19\:VDD VDD) g45p1svt w=(2.15e-07) l=4.5e-08 nf=1 \
        as=1.29e-14 ad=3.44e-14 ps=5.5e-07 pd=7.5e-07 nrd=1.16667 \
        nrs=1.16667 sa=3.45e-07 sb=2.45e-07 sd=160n sca=19.7192 \
        scb=0.0218524 scc=0.000619363 m=(1)
mp0 (\13\:Gb \5\:RN \16\:VDD VDD) g45p1svt w=(2.15e-07) l=4.5e-08 nf=1 \
        as=3.44e-14 ad=3.01e-14 ps=7.5e-07 pd=7.1e-07 nrd=1.16667 \
        nrs=1.16667 sa=1.4e-07 sb=3.45e-07 sd=160n sca=18.3563 \
        scb=0.019721 scc=0.000431169 m=(1)
mp16 (net103 \2\:Qint \12\:VDD VDD) g45p1svt w=(2.15e-07) l=4.5e-08 nf=1 \
        as=3.44e-14 ad=3.01e-14 ps=7.5e-07 pd=7.1e-07 nrd=1.16667 \
        nrs=1.16667 sa=1.4e-07 sb=3.45e-07 sd=160n sca=12.7038 \
        scb=0.0109783 scc=0.00016343 m=(1)
mp15 (net103 \1\:RN \1\:VDD VDD) g45p1svt w=(2.15e-07) l=4.5e-08 nf=1 \
        as=3.01e-14 ad=3.44e-14 ps=7.1e-07 pd=7.5e-07 nrd=1.16667 \
        nrs=1.16667 sa=3.45e-07 sb=1.4e-07 sd=160n sca=22.6068 \
        scb=0.0258052 scc=0.00164196 m=(1)
PM2 (net94 \12\:Qint \6\:ExtVDD ExtVDD) g45p1svt w=(2.15e-07) l=4.5e-08 \
        nf=1 as=1.29e-14 ad=3.01e-14 ps=5.5e-07 pd=7.1e-07 nrd=1.16667 \
        nrs=1.16667 sa=1.4e-07 sb=2.45e-07 sd=160n sca=15.9786 \
        scb=0.0173297 scc=0.000549121 m=(1)
mp2 (\8\:Gbb \4\:Gb \19\:VDD VDD) g45p1svt w=(2.15e-07) l=4.5e-08 nf=1 \
        as=3.44e-14 ad=3.01e-14 ps=7.5e-07 pd=7.1e-07 nrd=1.16667 \
        nrs=1.16667 sa=1.4e-07 sb=4.5e-07 sd=160n sca=21.2798 \
        scb=0.0239423 scc=0.000923328 m=(1)
mp1 (\18\:Gb \1\:G \16\:VDD VDD) g45p1svt w=(2.15e-07) l=4.5e-08 nf=1 \
        as=3.44e-14 ad=3.01e-14 ps=7.5e-07 pd=7.1e-07 nrd=1.16667 \
        nrs=1.16667 sa=3.45e-07 sb=1.4e-07 sd=160n sca=22.6619 \
        scb=0.0252789 scc=0.00128716 m=(1)
mp6 (\7\:n5 Gb net142 VDD) g45p1svt w=(2.15e-07) l=4.5e-08 nf=1 \
        as=1.29e-14 ad=3.01e-14 ps=5.5e-07 pd=7.1e-07 nrd=1.16667 \
        nrs=1.16667 sa=4.5e-07 sb=1.4e-07 sd=160n sca=29.5047 \
        scb=0.0315778 scc=0.00276782 m=(1)
PM0 (\7\:n5g \7\:RT \11\:n5 ExtVDD) g45p1svt w=(2.15e-07) l=4.5e-08 nf=1 \
        as=3.01e-14 ad=3.01e-14 ps=7.1e-07 pd=7.1e-07 nrd=1.16667 \
        nrs=1.16667 sa=1.4e-07 sb=1.4e-07 sd=160n sca=29.8246 scb=0.033558 \
        scc=0.00297535 m=(1)
mp11 (\17\:Qint \4\:n5g \10\:ExtVDD ExtVDD) g45p1svt w=(2.15e-07) \
        l=4.5e-08 nf=1 as=3.01e-14 ad=3.01e-14 ps=7.1e-07 pd=7.1e-07 \
        nrd=1.16667 nrs=1.16667 sa=1.4e-07 sb=1.4e-07 sd=160n sca=12.1365 \
        scb=0.0108856 scc=0.000154611 m=(1)
mp45 (\7\:RTb \5\:RT \3\:ExtVDD ExtVDD) g45p1svt w=(2.15e-07) l=4.5e-08 \
        nf=1 as=3.01e-14 ad=3.01e-14 ps=7.1e-07 pd=7.1e-07 nrd=1.16667 \
        nrs=1.16667 sa=1.4e-07 sb=1.4e-07 sd=160n sca=13.1336 scb=0.011983 \
        scc=0.00033933 m=(1)
PM3 (\11\:n5g \3\:RTb net94 ExtVDD) g45p1svt w=(2.15e-07) l=4.5e-08 nf=1 \
        as=1.29e-14 ad=3.01e-14 ps=5.5e-07 pd=7.1e-07 nrd=1.16667 \
        nrs=1.16667 sa=2.45e-07 sb=1.4e-07 sd=160n sca=27.0191 \
        scb=0.0289692 scc=0.00271657 m=(1)
mp17 (\21\:n5 \4\:Gbb \3\:net103 VDD) g45p1svt w=(2.15e-07) l=4.5e-08 \
        nf=1 as=3.01e-14 ad=3.01e-14 ps=7.1e-07 pd=7.1e-07 nrd=1.16667 \
        nrs=1.16667 sa=1.4e-07 sb=1.4e-07 sd=160n sca=17.2208 \
        scb=0.0190615 scc=0.000639328 m=(1)
C1 (D VSS) capacitor c=5.30547e-17
C2 (RT VSS) capacitor c=2.55244e-17
C3 (QN VSS) capacitor c=3.9013e-17
C4 (Q VSS) capacitor c=2.81806e-17
C5 (RN VSS) capacitor c=3.96789e-17
C6 (VDD VSS) capacitor c=3.83999e-16
C7 (ExtVDD VSS) capacitor c=2.97194e-16
C8 (G VSS) capacitor c=5.47749e-17
C9 (Gb VSS) capacitor c=7.78482e-17
C10 (Gbb VSS) capacitor c=1.28641e-16
C11 (n5 VSS) capacitor c=6.90508e-17
C12 (Qbint VSS) capacitor c=3.06904e-17
C13 (Qint VSS) capacitor c=9.92953e-17
C14 (n5g VSS) capacitor c=4.74102e-17
C15 (RTb VSS) capacitor c=5.2146e-17
C16 (net103 VSS) capacitor c=9.0501e-17
C17 (net171 VSS) capacitor c=3.8522e-17
C18 (\1\:RN VSS) capacitor c=6.55803e-17
C19 (\4\:Qbint VSS) capacitor c=3.63641e-17
C20 (\2\:Qint VSS) capacitor c=9.27281e-17
C21 (\3\:Qint VSS) capacitor c=6.43202e-17
C22 (\4\:Gbb VSS) capacitor c=4.14812e-17
C23 (\10\:Qint VSS) capacitor c=2.40706e-17
C24 (\3\:RTb VSS) capacitor c=9.32555e-17
C25 (\12\:Qint VSS) capacitor c=6.72113e-17
C26 (\5\:RT VSS) capacitor c=5.32068e-17
C27 (\4\:n5g VSS) capacitor c=9.24699e-17
C28 (\7\:RT VSS) capacitor c=3.43531e-17
C29 (\1\:G VSS) capacitor c=4.19219e-17
C30 (\3\:D VSS) capacitor c=7.32375e-17
C31 (\5\:RN VSS) capacitor c=5.29463e-17
C32 (\4\:Gb VSS) capacitor c=5.76646e-17
C33 (\2\:RN VSS) capacitor c=2.57188e-16
C34 (\9\:Qint VSS) capacitor c=2.62505e-17
C35 (\8\:Gb VSS) capacitor c=7.55536e-17
C36 (\11\:Qint VSS) capacitor c=2.49102e-17
C37 (\13\:Qint VSS) capacitor c=5.79216e-17
C38 (\9\:RT VSS) capacitor c=9.31889e-17
C39 (\1\:RT VSS) capacitor c=5.95534e-17
C40 (\3\:n5g VSS) capacitor c=2.34422e-17
C41 (\2\:RTb VSS) capacitor c=5.67535e-17
C42 (\3\:Gbb VSS) capacitor c=4.2823e-17
C43 (\1\:D VSS) capacitor c=7.08013e-17
C44 (\3\:G VSS) capacitor c=7.81799e-17
C45 (\3\:RN VSS) capacitor c=2.17994e-16
C46 (\5\:Gb VSS) capacitor c=6.1267e-17
C47 (\3\:Qbint VSS) capacitor c=2.75597e-17
C48 (\5\:Gbb VSS) capacitor c=3.37203e-17
C49 (\9\:Gb VSS) capacitor c=6.54652e-17
C50 (\8\:RT VSS) capacitor c=6.09055e-17
C51 (\4\:RTb VSS) capacitor c=7.01871e-17
C52 (\5\:RTb VSS) capacitor c=4.86236e-17
C53 (\6\:RT VSS) capacitor c=5.62751e-17
C54 (\3\:n5 VSS) capacitor c=7.73542e-17
C55 (\2\:ExtVDD VSS) capacitor c=5.34762e-17
C56 (\1\:ExtVDD VSS) capacitor c=4.85819e-17
C57 (\5\:n5g VSS) capacitor c=1.02014e-16
C58 (\6\:Gb VSS) capacitor c=1.43017e-16
C59 (\8\:Qint VSS) capacitor c=7.77175e-17
C60 (\4\:n5 VSS) capacitor c=8.08526e-17
C61 (\4\:RT VSS) capacitor c=3.69748e-17
C62 (\2\:n5 VSS) capacitor c=6.47687e-17
C63 (\7\:Gb VSS) capacitor c=7.21456e-17
C64 (\2\:Gbb VSS) capacitor c=1.04541e-16
C65 (\2\:D VSS) capacitor c=5.66148e-17
C66 (\2\:G VSS) capacitor c=6.83807e-17
C67 (\4\:RN VSS) capacitor c=7.66933e-17
C68 (\3\:Gb VSS) capacitor c=3.78407e-17
C69 (\1\:VDD VSS) capacitor c=3.05903e-17
C70 (\3\:Q VSS) capacitor c=5.75007e-17
C71 (\10\:VDD VSS) capacitor c=7.42986e-17
C72 (\12\:VDD VSS) capacitor c=5.19314e-17
C73 (\7\:Qbint VSS) capacitor c=8.16843e-17
C74 (\14\:VDD VSS) capacitor c=8.73856e-17
C75 (\3\:net103 VSS) capacitor c=8.37879e-17
C76 (\21\:n5 VSS) capacitor c=3.72594e-17
C77 (\1\:QN VSS) capacitor c=6.4932e-17
C78 (\11\:n5g VSS) capacitor c=1.18862e-16
C79 (\6\:ExtVDD VSS) capacitor c=5.90551e-17
C80 (\7\:RTb VSS) capacitor c=4.69295e-17
C81 (\3\:ExtVDD VSS) capacitor c=4.33524e-17
C82 (\10\:ExtVDD VSS) capacitor c=6.25717e-17
C83 (\17\:Qint VSS) capacitor c=4.7337e-17
C84 (\7\:n5g VSS) capacitor c=7.96787e-17
C85 (\11\:n5 VSS) capacitor c=8.80848e-17
C86 (\7\:n5 VSS) capacitor c=2.57896e-17
C87 (\18\:Gb VSS) capacitor c=4.45231e-17
C88 (\16\:VDD VSS) capacitor c=6.73631e-17
C89 (\19\:VDD VSS) capacitor c=5.17503e-17
C90 (\13\:Gb VSS) capacitor c=4.80962e-17
C91 (\8\:Gbb VSS) capacitor c=5.2881e-17
C92 (\1\:Q VSS) capacitor c=4.68539e-17
C93 (\9\:Qbint VSS) capacitor c=5.5743e-17
C94 (\3\:net171 VSS) capacitor c=4.44701e-17
C95 (\17\:n5 VSS) capacitor c=3.65952e-17
C96 (\3\:QN VSS) capacitor c=4.66833e-17
C97 (\12\:RTb VSS) capacitor c=2.51282e-17
C98 (\15\:n5g VSS) capacitor c=1.89428e-17
C99 (\14\:Qint VSS) capacitor c=3.89939e-17
C100 (\9\:n5g VSS) capacitor c=9.1095e-17
C101 (\15\:n5 VSS) capacitor c=4.11773e-17
C102 (\9\:n5 VSS) capacitor c=6.85076e-17
C103 (\16\:Gb VSS) capacitor c=3.75469e-17
C104 (\10\:Gbb VSS) capacitor c=2.54525e-17
C105 (\2\:Gb VSS) capacitor c=4.87037e-17
C106 (ExtVDD VSS) capacitor c=4.58572e-17
C107 (VDD VSS) capacitor c=3.45563e-16
C108 (\2\:n5g VSS) capacitor c=4.73098e-17
C109 (\2\:RT VSS) capacitor c=8.42122e-17
C110 (\3\:RT VSS) capacitor c=7.53149e-17
C111 (\4\:Qint VSS) capacitor c=2.52279e-17
C112 (\5\:Qint VSS) capacitor c=4.727e-17
C113 (\6\:Qint VSS) capacitor c=6.55146e-17
C114 (\7\:Qint VSS) capacitor c=4.06507e-17
C115 (\2\:Qbint VSS) capacitor c=1.88387e-17
C116 (\6\:Gbb VSS) capacitor c=5.63239e-17
C117 (\7\:Gbb VSS) capacitor c=5.58707e-17
C118 (\10\:Gb VSS) capacitor c=7.75943e-18
C119 (\11\:Gb VSS) capacitor c=4.32308e-17
C120 (\12\:Gb VSS) capacitor c=6.72786e-17
C121 (\15\:Gb VSS) capacitor c=4.98527e-17
C122 (\5\:n5 VSS) capacitor c=1.84626e-17
C123 (\6\:n5 VSS) capacitor c=5.34956e-17
C124 (\12\:RT VSS) capacitor c=2.27954e-17
C125 (\13\:n5 VSS) capacitor c=5.99914e-17
C126 (\14\:n5 VSS) capacitor c=5.02263e-17
C127 (\16\:Qint VSS) capacitor c=6.27899e-17
C128 (\6\:n5g VSS) capacitor c=2.50885e-17
C129 (\5\:ExtVDD VSS) capacitor c=5.58112e-17
C130 (\12\:ExtVDD VSS) capacitor c=2.93542e-17
C131 (\6\:RTb VSS) capacitor c=2.79722e-17
C132 (\9\:RTb VSS) capacitor c=3.78362e-17
C133 (\10\:RTb VSS) capacitor c=5.90777e-17
C134 (\11\:RTb VSS) capacitor c=6.21442e-17
C135 (\13\:n5g VSS) capacitor c=9.84353e-17
C136 (\14\:n5g VSS) capacitor c=2.88726e-17
C137 (\13\:RT VSS) capacitor c=1.29416e-16
C138 (\14\:RT VSS) capacitor c=1.30722e-16
C139 (\20\:Gb VSS) capacitor c=1.38581e-16
C140 (\21\:Gb VSS) capacitor c=1.58544e-16
C141 (\12\:Gbb VSS) capacitor c=1.89845e-16
C142 (\13\:Gbb VSS) capacitor c=2.42089e-16
C143 (\19\:n5 VSS) capacitor c=1.09501e-16
C144 (\20\:n5 VSS) capacitor c=1.8119e-16
C145 (\5\:Qbint VSS) capacitor c=2.85393e-17
C146 (\3\:VDD VSS) capacitor c=3.14226e-17
C147 (\4\:VDD VSS) capacitor c=2.04072e-17
C148 (\6\:VDD VSS) capacitor c=1.19069e-17
C149 (\7\:VDD VSS) capacitor c=1.00074e-16
C150 (\18\:VDD VSS) capacitor c=1.22815e-16
Rk2 (D \4\:D) resistor r=0.003154 c=0
Rk19 (RT \12\:RT) resistor r=0.02094 c=0
Rk18 (\11\:RT \12\:RT) resistor r=0.004255 c=0
Rk40 (\13\:RT \14\:RT) resistor r=1.038 c=0
Rk44 (QN \4\:QN) resistor r=0.09154 c=0
Rk43 (\2\:QN \4\:QN) resistor r=0.5727 c=0
Rk53 (\2\:Q Q) resistor r=0.2149 c=0
Rk54 (Q \4\:Q) resistor r=0.3578 c=0
Rk55 (\2\:VDD \3\:VDD) resistor r=0.3851 c=0
Rk56 (\3\:VDD \4\:VDD) resistor r=0.09839 c=0
Rk57 (\4\:VDD \6\:VDD) resistor r=0.09118 c=0
Rk59 (\7\:VDD VDD) resistor r=0.8244 c=0
Rk58 (\6\:VDD \7\:VDD) resistor r=0.03932 c=0
Rk60 (VDD \9\:VDD) resistor r=0.9831 c=0
Rk61 (\3\:VDD \11\:VDD) resistor r=0.355 c=0
Rk62 (\4\:VDD \13\:VDD) resistor r=0.2804 c=0
Rk63 (\7\:VDD \15\:VDD) resistor r=0.3726 c=0
Rk64 (\9\:VDD \17\:VDD) resistor r=0.3402 c=0
Rk66 (\18\:VDD VDD) resistor r=0.05142 c=0
Rk65 (\9\:VDD \18\:VDD) resistor r=0.05469 c=0
Rk67 (\18\:VDD \20\:VDD) resistor r=0.284 c=0
Rk30 (ExtVDD ExtVDD) resistor r=0.00378 c=0
Rk27 (\4\:ExtVDD \5\:ExtVDD) resistor r=0.2262 c=0
Rk28 (\7\:ExtVDD ExtVDD) resistor r=0.1402 c=0
Rk31 (ExtVDD \11\:ExtVDD) resistor r=0.1481 c=0
Rk32 (\11\:ExtVDD \12\:ExtVDD) resistor r=0.2301 c=0
Rk68 (\2\:VSS \4\:VSS) resistor r=0.2894 c=0
Rk70 (\5\:VSS VSS) resistor r=0.5434 c=0
Rk69 (\4\:VSS \5\:VSS) resistor r=0.6421 c=0
Rk72 (\6\:VSS VSS) resistor r=0.185 c=0
Rk71 (VSS \6\:VSS) resistor r=0.6425 c=0
Rk73 (VSS \8\:VSS) resistor r=0.5479 c=0
Rk74 (VSS \10\:VSS) resistor r=0.304 c=0
Rk75 (\12\:VSS \13\:VSS) resistor r=0.1307 c=0
Rk76 (\13\:VSS \14\:VSS) resistor r=0.2293 c=0
Rk77 (\14\:VSS \15\:VSS) resistor r=0.2813 c=0
Rk79 (\16\:VSS VSS) resistor r=0.2095 c=0
Rk78 (\15\:VSS \16\:VSS) resistor r=0.3332 c=0
Rk80 (VSS \17\:VSS) resistor r=0.2717 c=0
Rk82 (\18\:VSS VSS) resistor r=0.3806 c=0
Rk81 (\17\:VSS \18\:VSS) resistor r=0.3702 c=0
Rk83 (VSS \20\:VSS) resistor r=0.2838 c=0
Rk84 (\13\:VSS \22\:VSS) resistor r=0.2465 c=0
Rk85 (\14\:VSS \24\:VSS) resistor r=0.2582 c=0
Rk86 (\16\:VSS \26\:VSS) resistor r=0.2761 c=0
Rk87 (\17\:VSS \28\:VSS) resistor r=0.2422 c=0
Rk3 (G \4\:G) resistor r=0.01003 c=0
Rk7 (\10\:Gb \11\:Gb) resistor r=0.04285 c=0
Rk8 (\11\:Gb \12\:Gb) resistor r=0.2417 c=0
Rk9 (\12\:Gb \14\:Gb) resistor r=0.4574 c=0
Rk10 (\14\:Gb \15\:Gb) resistor r=0.2366 c=0
Rk11 (\11\:Gb \17\:Gb) resistor r=0.3131 c=0
Rk12 (\12\:Gb \19\:Gb) resistor r=0.1901 c=0
Rk41 (\20\:Gb \21\:Gb) resistor r=0.8004 c=0
Rk4 (\6\:Gbb \7\:Gbb) resistor r=0.2858 c=0
Rk5 (\7\:Gbb \9\:Gbb) resistor r=0.44 c=0
Rk6 (\7\:Gbb \11\:Gbb) resistor r=0.1685 c=0
Rk42 (\12\:Gbb \13\:Gbb) resistor r=1.6094 c=0
Rk13 (\5\:n5 \6\:n5) resistor r=0.2053 c=0
Rk14 (\6\:n5 \8\:n5) resistor r=0.1991 c=0
Rk15 (\6\:n5 \10\:n5) resistor r=0.4678 c=0
Rk20 (\12\:n5 \13\:n5) resistor r=0.5931 c=0
Rk21 (\12\:n5 \14\:n5) resistor r=0.2471 c=0
Rk22 (\14\:n5 \16\:n5) resistor r=0.321 c=0
Rk45 (\18\:n5 \19\:n5) resistor r=0.343 c=0
Rk46 (\19\:n5 \20\:n5) resistor r=1.0784 c=0
Rk47 (\19\:n5 \22\:n5) resistor r=0.2535 c=0
Rk48 (\5\:Qbint \6\:Qbint) resistor r=0.02337 c=0
Rk49 (\6\:Qbint \8\:Qbint) resistor r=0.3091 c=0
Rk50 (\6\:Qbint \10\:Qbint) resistor r=0.2053 c=0
Rk23 (\15\:Qint \16\:Qint) resistor r=0.2105 c=0
Rk24 (\16\:Qint \18\:Qint) resistor r=0.4299 c=0
Rk25 (\6\:n5g \8\:n5g) resistor r=0.1081 c=0
Rk26 (\8\:n5g \10\:n5g) resistor r=0.5648 c=0
Rk37 (\12\:n5g \13\:n5g) resistor r=0.7336 c=0
Rk38 (\13\:n5g \14\:n5g) resistor r=0.1076 c=0
Rk39 (\13\:n5g \16\:n5g) resistor r=0.0884 c=0
Rk33 (\6\:RTb \8\:RTb) resistor r=0.132 c=0
Rk34 (\9\:RTb \10\:RTb) resistor r=0.167 c=0
Rk35 (\10\:RTb \11\:RTb) resistor r=0.328 c=0
Rk36 (\10\:RTb \13\:RTb) resistor r=0.09334 c=0
Rk52 (\2\:net103 \4\:net103) resistor r=0.6373 c=0
Rk51 (\2\:net171 \4\:net171) resistor r=0.3523 c=0
Rl2 (\2\:D \3\:D) resistor r=87.7202 c=0
Rl1 (\1\:D \2\:D) resistor r=133.743 c=0
Rl28 (\8\:RT \9\:RT) resistor r=350.785 c=0
Rl24 (\5\:RT \6\:RT) resistor r=204.389 c=0
Rl23 (\2\:RT \5\:RT) resistor r=26.665 c=0
Rl20 (\1\:RT \2\:RT) resistor r=182.259 c=0
Rl25 (\3\:RT \7\:RT) resistor r=21.372 c=0
Rl22 (\3\:RT \4\:RT) resistor r=104.717 c=0
Rl21 (\2\:RT \3\:RT) resistor r=218.989 c=0
Rl46 (\1\:RN \2\:RN) resistor r=215.452 c=0
Rl47 (\2\:RN \3\:RN) resistor r=1636.76 c=0
Rl49 (\4\:RN \5\:RN) resistor r=164.425 c=0
Rl48 (\3\:RN \4\:RN) resistor r=46.604 c=0
Rl14 (\1\:ExtVDD \2\:ExtVDD) resistor r=176.713 c=0
Rl3 (\1\:G \2\:G) resistor r=88.3245 c=0
Rl4 (\2\:G \3\:G) resistor r=127.297 c=0
Rl8 (\4\:Gb \5\:Gb) resistor r=249.542 c=0
Rl30 (\8\:Gb \9\:Gb) resistor r=361.066 c=0
Rl12 (\6\:Gb \7\:Gb) resistor r=452.417 c=0
Rl5 (Gb \2\:Gb) resistor r=168.204 c=0
Rl7 (\2\:Gb \4\:Gb) resistor r=64.1356 c=0
Rl6 (\2\:Gb \3\:Gb) resistor r=143.548 c=0
Rl29 (\4\:Gbb \5\:Gbb) resistor r=178.565 c=0
Rl11 (\2\:Gbb \3\:Gbb) resistor r=44.0258 c=0
Rl10 (Gbb \2\:Gbb) resistor r=696.861 c=0
Rl19 (\3\:n5 \4\:n5) resistor r=172.871 c=0
Rl9 (n5 \2\:n5) resistor r=331.394 c=0
Rl45 (\2\:Qbint \4\:Qbint) resistor r=93.3448 c=0
Rl43 (Qbint \2\:Qbint) resistor r=60.9354 c=0
Rl44 (\2\:Qbint \3\:Qbint) resistor r=83.7545 c=0
Rl32 (\2\:Qint \3\:Qint) resistor r=322.396 c=0
Rl31 (Qint \2\:Qint) resistor r=232.216 c=0
Rl33 (\3\:Qint \4\:Qint) resistor r=60.9354 c=0
Rl38 (\4\:Qint \9\:Qint) resistor r=93.3448 c=0
Rl39 (\5\:Qint \10\:Qint) resistor r=59.4143 c=0
Rl40 (\5\:Qint \11\:Qint) resistor r=91.8237 c=0
Rl34 (\4\:Qint \5\:Qint) resistor r=59.826 c=0
Rl41 (\6\:Qint \12\:Qint) resistor r=101.868 c=0
Rl35 (\5\:Qint \6\:Qint) resistor r=412.667 c=0
Rl42 (\7\:Qint \13\:Qint) resistor r=67.7766 c=0
Rl37 (\7\:Qint \8\:Qint) resistor r=192.03 c=0
Rl36 (\6\:Qint \7\:Qint) resistor r=20.6699 c=0
Rl18 (\4\:n5g \5\:n5g) resistor r=317.727 c=0
Rl17 (\2\:n5g \4\:n5g) resistor r=191.281 c=0
Rl16 (\2\:n5g \3\:n5g) resistor r=38.4366 c=0
Rl15 (n5g \2\:n5g) resistor r=109.66 c=0
Rl26 (\3\:RTb \4\:RTb) resistor r=306.661 c=0
Rl27 (\4\:RTb \5\:RTb) resistor r=184.803 c=0
Rl13 (RTb \2\:RTb) resistor r=124.916 c=0
Rz10 (\3\:QN \4\:QN) resistor r=37.5 c=0
Rz15 (\1\:Q \2\:Q) resistor r=37.5 c=0
Rz18 (\1\:VSS \2\:VSS) resistor r=75 c=0
Rz19 (\7\:VSS \8\:VSS) resistor r=75 c=0
Rz20 (\9\:VSS \10\:VSS) resistor r=75 c=0
Rz21 (\19\:VSS \20\:VSS) resistor r=75 c=0
Rz22 (\21\:VSS \22\:VSS) resistor r=37.5 c=0
Rz23 (\23\:VSS \24\:VSS) resistor r=37.5 c=0
Rz24 (\25\:VSS \26\:VSS) resistor r=75 c=0
Rz25 (\27\:VSS \28\:VSS) resistor r=75 c=0
Rz2 (\16\:Gb \17\:Gb) resistor r=75 c=0
Rz1 (\10\:Gbb \11\:Gbb) resistor r=75 c=0
Rz3 (\9\:n5 \10\:n5) resistor r=75 c=0
Rz4 (\15\:n5 \16\:n5) resistor r=75 c=0
Rz11 (\17\:n5 \18\:n5) resistor r=75 c=0
Rz12 (\9\:Qbint \10\:Qbint) resistor r=37.5 c=0
Rz5 (\14\:Qint \15\:Qint) resistor r=75 c=0
Rz6 (\9\:n5g \10\:n5g) resistor r=75 c=0
Rz9 (\15\:n5g \16\:n5g) resistor r=75 c=0
Rz8 (\12\:RTb \13\:RTb) resistor r=75 c=0
Rz13 (net171 \2\:net171) resistor r=75 c=0
Rz14 (\3\:net171 \4\:net171) resistor r=75 c=0
Ry13 (\1\:QN \2\:QN) resistor r=20.6667 c=0
Ry18 (\3\:Q \4\:Q) resistor r=20.6667 c=0
Ry19 (\1\:VDD \2\:VDD) resistor r=62 c=0
Ry20 (\10\:VDD \11\:VDD) resistor r=20.6667 c=0
Ry21 (\12\:VDD \13\:VDD) resistor r=62 c=0
Ry22 (\14\:VDD \15\:VDD) resistor r=20.6667 c=0
Ry23 (\16\:VDD \17\:VDD) resistor r=62 c=0
Ry24 (\19\:VDD \20\:VDD) resistor r=62 c=0
Ry8 (\3\:ExtVDD \4\:ExtVDD) resistor r=62 c=0
Ry9 (\6\:ExtVDD \7\:ExtVDD) resistor r=62 c=0
Ry10 (\10\:ExtVDD \11\:ExtVDD) resistor r=62 c=0
Ry25 (\3\:VSS \4\:VSS) resistor r=62 c=0
Ry26 (\3\:VSS \5\:VSS) resistor r=5.1667 c=0
Ry27 (\3\:VSS \6\:VSS) resistor r=5.1667 c=0
Ry28 (\11\:VSS \12\:VSS) resistor r=62 c=0
Ry29 (\11\:VSS \15\:VSS) resistor r=5.1667 c=0
Ry30 (\11\:VSS \18\:VSS) resistor r=5.1667 c=0
Ry2 (\13\:Gb \14\:Gb) resistor r=62 c=0
Ry3 (\18\:Gb \19\:Gb) resistor r=62 c=0
Ry1 (\8\:Gbb \9\:Gbb) resistor r=62 c=0
Ry4 (\7\:n5 \8\:n5) resistor r=62 c=0
Ry5 (\11\:n5 \12\:n5) resistor r=62 c=0
Ry14 (\21\:n5 \22\:n5) resistor r=62 c=0
Ry15 (\7\:Qbint \8\:Qbint) resistor r=20.6667 c=0
Ry6 (\17\:Qint \18\:Qint) resistor r=62 c=0
Ry7 (\7\:n5g \8\:n5g) resistor r=62 c=0
Ry12 (\11\:n5g \12\:n5g) resistor r=62 c=0
Ry11 (\7\:RTb \8\:RTb) resistor r=62 c=0
Ry16 (net103 \2\:net103) resistor r=62 c=0
Ry17 (\3\:net103 \4\:net103) resistor r=62 c=0
Rx2 (\2\:D \4\:D) resistor r=45 c=0
Rx8 (\4\:RT \11\:RT) resistor r=45 c=0
Rx19 (\8\:RT \13\:RT) resistor r=45 c=0
Rx20 (\6\:RT \14\:RT) resistor r=45 c=0
Rx1 (\4\:RN RN) resistor r=45 c=0
Rx13 (\2\:ExtVDD \5\:ExtVDD) resistor r=45 c=0
Rx14 (\1\:ExtVDD \12\:ExtVDD) resistor r=45 c=0
Rx3 (\2\:G \4\:G) resistor r=45 c=0
Rx5 (\7\:Gb \10\:Gb) resistor r=45 c=0
Rx6 (\3\:Gb \15\:Gb) resistor r=45 c=0
Rx21 (\9\:Gb \20\:Gb) resistor r=45 c=0
Rx22 (\6\:Gb \21\:Gb) resistor r=45 c=0
Rx4 (\2\:Gbb \6\:Gbb) resistor r=45 c=0
Rx23 (\5\:Gbb \12\:Gbb) resistor r=45 c=0
Rx24 (Gbb \13\:Gbb) resistor r=45 c=0
Rx7 (n5 \5\:n5) resistor r=45 c=0
Rx9 (\2\:n5 \13\:n5) resistor r=45 c=0
Rx10 (\4\:n5 \14\:n5) resistor r=45 c=0
Rx25 (\3\:n5 \20\:n5) resistor r=45 c=0
Rx26 (\3\:Qbint \5\:Qbint) resistor r=45 c=0
Rx11 (\8\:Qint \16\:Qint) resistor r=45 c=0
Rx12 (\5\:n5g \6\:n5g) resistor r=45 c=0
Rx18 (n5g \14\:n5g) resistor r=45 c=0
Rx15 (\4\:RTb \6\:RTb) resistor r=45 c=0
Rx16 (\5\:RTb \9\:RTb) resistor r=45 c=0
Rx17 (RTb \11\:RTb) resistor r=45 c=0
mn1 (\16\:Gb \3\:G net159 VSS) g45n1svt w=(1.45e-07) l=4.5e-08 nf=1 \
        as=8.7e-15 ad=2.03e-14 ps=4.1e-07 pd=5.7e-07 nrd=1.16667 \
        nrs=1.16667 sa=2.45e-07 sb=1.4e-07 sd=160n sca=9.33388 \
        scb=0.00788941 scc=0.00017958 m=(1)
mn0 (net159 \3\:RN \7\:VSS VSS) g45n1svt w=(1.45e-07) l=4.5e-08 nf=1 \
        as=2.03e-14 ad=8.7e-15 ps=5.7e-07 pd=4.1e-07 nrd=1.16667 \
        nrs=1.16667 sa=2.45e-07 sb=1.4e-07 sd=160n sca=9.33388 \
        scb=0.00788941 scc=0.00017958 m=(1)
mn5 (net191 \1\:D \19\:VSS VSS) g45n1svt w=(1.45e-07) l=4.5e-08 nf=1 \
        as=8.7e-15 ad=2.32e-14 ps=4.1e-07 pd=6.1e-07 nrd=1.16667 \
        nrs=1.16667 sa=3.45e-07 sb=2.45e-07 sd=160n sca=7.91544 \
        scb=0.00544522 scc=7.50774e-05 m=(1)
mn2 (\10\:Gbb \5\:Gb \19\:VSS VSS) g45n1svt w=(1.45e-07) l=4.5e-08 nf=1 \
        as=2.32e-14 ad=2.03e-14 ps=6.1e-07 pd=5.7e-07 nrd=1.16667 \
        nrs=1.16667 sa=1.4e-07 sb=4.5e-07 sd=160n sca=7.91544 \
        scb=0.00544522 scc=7.50774e-05 m=(1)
mn6 (\9\:n5 \3\:Gbb net191 VSS) g45n1svt w=(1.45e-07) l=4.5e-08 nf=1 \
        as=8.7e-15 ad=2.03e-14 ps=4.1e-07 pd=5.7e-07 nrd=1.16667 \
        nrs=1.16667 sa=4.5e-07 sb=1.4e-07 sd=160n sca=7.91544 \
        scb=0.00544522 scc=7.50774e-05 m=(1)
NM0 (\9\:n5g \2\:RTb \15\:n5 VSS) g45n1svt w=(1.45e-07) l=4.5e-08 nf=1 \
        as=2.03e-14 ad=2.03e-14 ps=5.7e-07 pd=5.7e-07 nrd=1.16667 \
        nrs=1.16667 sa=1.4e-07 sb=1.4e-07 sd=160n sca=9.50767 \
        scb=0.00818119 scc=0.00019576 m=(1)
mn11 (\14\:Qint \3\:n5g \27\:VSS VSS) g45n1svt w=(1.45e-07) l=4.5e-08 \
        nf=1 as=2.03e-14 ad=2.03e-14 ps=5.7e-07 pd=5.7e-07 nrd=1.16667 \
        nrs=1.16667 sa=1.4e-07 sb=1.4e-07 sd=160n sca=12.9138 \
        scb=0.0133404 scc=0.000640143 m=(1)
mn45 (\12\:RTb \1\:RT \9\:VSS VSS) g45n1svt w=(1.45e-07) l=4.5e-08 nf=1 \
        as=2.03e-14 ad=2.03e-14 ps=5.7e-07 pd=5.7e-07 nrd=1.16667 \
        nrs=1.16667 sa=1.4e-07 sb=1.4e-07 sd=160n sca=9.16682 \
        scb=0.00760686 scc=0.000164708 m=(1)
NM2 (\15\:n5g \9\:RT net094 VSS) g45n1svt w=(1.45e-07) l=4.5e-08 nf=1 \
        as=8.7e-15 ad=2.03e-14 ps=4.1e-07 pd=5.7e-07 nrd=1.16667 \
        nrs=1.16667 sa=1.4e-07 sb=2.45e-07 sd=160n sca=18.4982 \
        scb=0.0194884 scc=0.00168796 m=(1)
NM3 (net094 \13\:Qint \25\:VSS VSS) g45n1svt w=(1.45e-07) l=4.5e-08 nf=1 \
        as=2.03e-14 ad=8.7e-15 ps=5.7e-07 pd=4.1e-07 nrd=1.16667 \
        nrs=1.16667 sa=2.45e-07 sb=1.4e-07 sd=160n sca=18.4982 \
        scb=0.0194884 scc=0.00168796 m=(1)
mn17 (\17\:n5 \8\:Gb \3\:net171 VSS) g45n1svt w=(1.45e-07) l=4.5e-08 nf=1 \
        as=2.03e-14 ad=2.03e-14 ps=5.7e-07 pd=5.7e-07 nrd=1.16667 \
        nrs=1.16667 sa=1.4e-07 sb=1.4e-07 sd=160n sca=11.4452 \
        scb=0.0112553 scc=0.00042156 m=(1)
mn16 (net171 Qint net167 VSS) g45n1svt w=(1.45e-07) l=4.5e-08 nf=1 \
        as=8.7e-15 ad=2.03e-14 ps=4.1e-07 pd=5.7e-07 nrd=1.16667 \
        nrs=1.16667 sa=1.4e-07 sb=2.45e-07 sd=160n sca=11.4452 \
        scb=0.0112553 scc=0.00042156 m=(1)
mn15 (net167 \2\:RN \1\:VSS VSS) g45n1svt w=(1.45e-07) l=4.5e-08 nf=1 \
        as=2.03e-14 ad=8.7e-15 ps=5.7e-07 pd=4.1e-07 nrd=1.16667 \
        nrs=1.16667 sa=2.45e-07 sb=1.4e-07 sd=160n sca=11.4452 \
        scb=0.0112553 scc=0.00042156 m=(1)
mn20 (\9\:Qbint \9\:Qint \23\:VSS VSS) g45n1svt w=(2.6e-07) l=4.5e-08 \
        nf=1 as=3.64e-14 ad=4.16e-14 ps=8e-07 pd=8.4e-07 nrd=1.16667 \
        nrs=1.16667 sa=3.45e-07 sb=1.4e-07 sd=160n sca=8.81533 \
        scb=0.00706435 scc=0.000179997 m=(1)
mn22 (\3\:QN \11\:Qint \23\:VSS VSS) g45n1svt w=(2.6e-07) l=4.5e-08 nf=1 \
        as=3.64e-14 ad=4.16e-14 ps=8e-07 pd=8.4e-07 nrd=1.16667 \
        nrs=1.16667 sa=1.4e-07 sb=3.45e-07 sd=160n sca=8.81533 \
        scb=0.00706435 scc=0.000179997 m=(1)
mn21 (\1\:Q Qbint \21\:VSS VSS) g45n1svt w=(2.6e-07) l=4.5e-08 nf=1 \
        as=3.64e-14 ad=3.64e-14 ps=8e-07 pd=8e-07 nrd=1.16667 nrs=1.16667 \
        sa=1.4e-07 sb=1.4e-07 sd=160n sca=8.81533 scb=0.00706435 \
        scc=0.000179997 m=(1)
mp20 (\7\:Qbint \3\:Qint \14\:VDD VDD) g45p1svt w=(3.9e-07) l=4.5e-08 \
        nf=1 as=5.46e-14 ad=6.24e-14 ps=1.06e-06 pd=1.1e-06 nrd=1.16667 \
        nrs=1.16667 sa=3.45e-07 sb=1.4e-07 sd=160n sca=19.8289 \
        scb=0.0178306 scc=0.00149679 m=(1)
mp22 (\1\:QN \10\:Qint \14\:VDD VDD) g45p1svt w=(3.9e-07) l=4.5e-08 nf=1 \
        as=5.46e-14 ad=6.24e-14 ps=1.06e-06 pd=1.1e-06 nrd=1.16667 \
        nrs=1.16667 sa=1.4e-07 sb=3.45e-07 sd=160n sca=25.6406 \
        scb=0.0282369 scc=0.00209661 m=(1)
mp21 (\3\:Q \4\:Qbint \10\:VDD VDD) g45p1svt w=(3.9e-07) l=4.5e-08 nf=1 \
        as=5.46e-14 ad=5.46e-14 ps=1.06e-06 pd=1.06e-06 nrd=1.16667 \
        nrs=1.16667 sa=1.4e-07 sb=1.4e-07 sd=160n sca=29.8529 \
        scb=0.0334882 scc=0.00288579 m=(1)
ends RTLATRX1
// End of subcircuit definition.
