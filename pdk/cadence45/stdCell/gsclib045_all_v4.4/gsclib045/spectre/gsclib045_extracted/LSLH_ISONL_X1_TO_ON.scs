// Generated for: spectre (May  1 08:12:03 2013 )
// Library name: gsclib045
// Cell name: LSLH_ISONL_X1_TO_ON
// View name: extracted

simulator lang=spectre

subckt LSLH_ISONL_X1_TO_ON A ExtVDD ISOn VDD VSS Y
PM2 (\7\:Ab \9\:A \3\:ExtVDD ExtVDD) g45p1svt w=(2.15e-07) l=4.5e-08 \
        nf=1 as=3.01e-14 ad=3.01e-14 ps=7.1e-07 pd=7.1e-07 nrd=1.16667 \
        nrs=1.16667 sa=1.4e-07 sb=1.4e-07 sd=160n sca=25.5239 \
        scb=0.0309509 scc=0.00146851 m=(1)
PM0 (\15\:Ybint \4\:Yint \11\:VDD VDD) g45p1svt w=(2.15e-07) l=4.5e-08 \
        nf=1 as=3.01e-14 ad=3.01e-14 ps=7.1e-07 pd=7.1e-07 nrd=1.16667 \
        nrs=1.16667 sa=1.4e-07 sb=1.4e-07 sd=160n sca=23.0829 \
        scb=0.0252371 scc=0.00197374 m=(1)
PM1 (\11\:Yint Ybint \9\:VDD VDD) g45p1svt w=(2.15e-07) l=4.5e-08 nf=1 \
        as=3.01e-14 ad=3.01e-14 ps=7.1e-07 pd=7.1e-07 nrd=1.16667 \
        nrs=1.16667 sa=1.4e-07 sb=1.4e-07 sd=160n sca=7.11886 \
        scb=0.00384538 scc=3.76076e-05 m=(1)
PM3 (\8\:Ybint \1\:ISOn \7\:VDD VDD) g45p1svt w=(2.15e-07) l=4.5e-08 \
        nf=1 as=3.01e-14 ad=3.01e-14 ps=7.1e-07 pd=7.1e-07 nrd=1.16667 \
        nrs=1.16667 sa=1.4e-07 sb=1.4e-07 sd=160n sca=8.6528 \
        scb=0.00546691 scc=6.4685e-05 m=(1)
C1 (ISOn VSS) capacitor c=3.31557e-17
C2 (Y VSS) capacitor c=2.58426e-17
C3 (A VSS) capacitor c=1.71854e-17
C4 (ExtVDD VSS) capacitor c=9.71991e-17
C5 (VDD VSS) capacitor c=3.88675e-16
C6 (Yint VSS) capacitor c=3.77984e-17
C7 (Ab VSS) capacitor c=1.55274e-16
C8 (Ybint VSS) capacitor c=2.67672e-17
C9 (GatedVSS VSS) capacitor c=3.46682e-17
C10 (\6\:Ybint VSS) capacitor c=3.24874e-17
C11 (\1\:ISOn VSS) capacitor c=3.06657e-17
C12 (\4\:Yint VSS) capacitor c=2.71704e-17
C13 (\9\:A VSS) capacitor c=4.88716e-17
C14 (\3\:Ybint VSS) capacitor c=3.90633e-17
C15 (\1\:A VSS) capacitor c=2.07204e-16
C16 (\10\:A VSS) capacitor c=2.4381e-17
C17 (\7\:Ybint VSS) capacitor c=3.95107e-17
C18 (\5\:Ybint VSS) capacitor c=7.48991e-18
C19 (\2\:ISOn VSS) capacitor c=2.51379e-17
C20 (\2\:Ybint VSS) capacitor c=2.65135e-17
C21 (\3\:Yint VSS) capacitor c=2.4391e-17
C22 (\2\:GatedVSS VSS) capacitor c=3.09364e-17
C23 (\4\:Ab VSS) capacitor c=6.1308e-17
C24 (\6\:A VSS) capacitor c=2.23588e-17
C25 (\2\:Y VSS) capacitor c=3.40182e-17
C26 (\1\:VDD VSS) capacitor c=5.55338e-17
C27 (\8\:Ybint VSS) capacitor c=3.86026e-17
C28 (\7\:VDD VSS) capacitor c=3.34962e-17
C29 (\9\:VDD VSS) capacitor c=3.56026e-17
C30 (\11\:Yint VSS) capacitor c=5.52453e-17
C31 (\15\:Ybint VSS) capacitor c=8.49833e-17
C32 (\11\:VDD VSS) capacitor c=5.20669e-17
C33 (\7\:Ab VSS) capacitor c=8.9116e-17
C34 (\3\:ExtVDD VSS) capacitor c=3.5259e-17
C35 (\4\:Y VSS) capacitor c=4.58839e-17
C36 (\15\:GatedVSS VSS) capacitor c=2.50388e-16
C37 (\3\:GatedVSS VSS) capacitor c=3.68324e-16
C38 (\5\:Yint VSS) capacitor c=1.8895e-16
C39 (\10\:Ab VSS) capacitor c=6.66311e-17
C40 (\8\:GatedVSS VSS) capacitor c=1.10853e-16
C41 (ExtVDD VSS) capacitor c=4.36156e-17
C42 (VDD VSS) capacitor c=3.97165e-17
C43 (\2\:Yint VSS) capacitor c=2.51841e-17
C44 (\4\:A VSS) capacitor c=1.66716e-16
C45 (\5\:A VSS) capacitor c=2.48273e-17
C46 (\3\:ISOn VSS) capacitor c=1.47214e-16
C47 (\4\:Ybint VSS) capacitor c=2.02864e-17
C48 (\12\:A VSS) capacitor c=4.36523e-18
C49 (\13\:A VSS) capacitor c=4.31659e-17
C50 (\9\:Ab VSS) capacitor c=1.06263e-16
C51 (\8\:Yint VSS) capacitor c=3.90103e-17
C52 (\13\:Yint VSS) capacitor c=3.21753e-17
C53 (\7\:GatedVSS VSS) capacitor c=1.8743e-16
C54 (\14\:GatedVSS VSS) capacitor c=1.03977e-16
C55 (\18\:GatedVSS VSS) capacitor c=7.50814e-17
C56 (\10\:Ybint VSS) capacitor c=4.76132e-17
C57 (\11\:Ybint VSS) capacitor c=3.93125e-17
C58 (\12\:Ybint VSS) capacitor c=1.86005e-16
C59 (\14\:Ybint VSS) capacitor c=5.96089e-17
C60 (\10\:ISOn VSS) capacitor c=2.1348e-17
C61 (\1\:Y VSS) capacitor c=5.54708e-17
C62 (\3\:VDD VSS) capacitor c=6.64648e-17
C63 (\4\:VDD VSS) capacitor c=1.69106e-17
C64 (\6\:VDD VSS) capacitor c=4.44884e-17
Rk51 (VSS VSS) resistor r=0.3214 c=0
Rk50 (\6\:VSS VSS) resistor r=0.294 c=0
Rk37 (VSS VSS) resistor r=0.2821 c=0
Rk36 (\4\:VSS VSS) resistor r=0.5886 c=0
Rk35 (\2\:VSS \4\:VSS) resistor r=0.3532 c=0
Rk38 (VSS \5\:VSS) resistor r=0.1106 c=0
Rk52 (VSS \12\:VSS) resistor r=0.07139 c=0
Rk31 (ISOn \10\:ISOn) resistor r=0.04068 c=0
Rk32 (Y \1\:Y) resistor r=0.002001 c=0
Rk33 (\1\:Y \3\:Y) resistor r=0.2712 c=0
Rk34 (\1\:Y \5\:Y) resistor r=0.4419 c=0
Rk1 (\11\:A A) resistor r=0.002027 c=0
Rk2 (A \12\:A) resistor r=0.002027 c=0
Rk3 (\11\:A \12\:A) resistor r=0.03576 c=0
Rk4 (\12\:A \13\:A) resistor r=0.02298 c=0
Rk5 (ExtVDD ExtVDD) resistor r=0.02314 c=0
Rk7 (ExtVDD \4\:ExtVDD) resistor r=0.321 c=0
Rk43 (VDD VDD) resistor r=0.3093 c=0
Rk39 (\2\:VDD \3\:VDD) resistor r=0.3988 c=0
Rk40 (\3\:VDD \4\:VDD) resistor r=0.1591 c=0
Rk42 (\6\:VDD VDD) resistor r=0.2185 c=0
Rk41 (\4\:VDD \6\:VDD) resistor r=0.2182 c=0
Rk44 (\3\:VDD \8\:VDD) resistor r=0.2637 c=0
Rk45 (\4\:VDD \10\:VDD) resistor r=0.2404 c=0
Rk46 (VDD \12\:VDD) resistor r=0.2855 c=0
Rk11 (\5\:Yint \8\:Yint) resistor r=0.2009 c=0
Rk13 (\12\:Yint \13\:Yint) resistor r=0.2043 c=0
Rk8 (\8\:Ab \9\:Ab) resistor r=0.6822 c=0
Rk9 (\9\:Ab \11\:Ab) resistor r=0.4465 c=0
Rk24 (\9\:Ybint \10\:Ybint) resistor r=0.1874 c=0
Rk25 (\11\:Ybint \12\:Ybint) resistor r=0.2117 c=0
Rk27 (\12\:Ybint \14\:Ybint) resistor r=0.06776 c=0
Rk28 (\14\:Ybint \16\:Ybint) resistor r=0.577 c=0
Rk16 (\3\:GatedVSS \7\:GatedVSS) resistor r=0.3555 c=0
Rk17 (\7\:GatedVSS \9\:GatedVSS) resistor r=0.7646 c=0
Rk20 (\7\:GatedVSS \14\:GatedVSS) resistor r=0.8107 c=0
Rk22 (\15\:GatedVSS \18\:GatedVSS) resistor r=1.1309 c=0
Rl20 (\2\:ISOn \1\:ISOn) resistor r=42.9995 c=0
Rl21 (\3\:ISOn \2\:ISOn) resistor r=106.578 c=0
Rl18 (\4\:A \9\:A) resistor r=239.672 c=0
Rl13 (\4\:A \1\:A) resistor r=494.483 c=0
Rl19 (\5\:A \10\:A) resistor r=59.022 c=0
Rl15 (\5\:A \6\:A) resistor r=46.4864 c=0
Rl14 (\5\:A \4\:A) resistor r=192.732 c=0
Rl9 (\2\:Yint \4\:Yint) resistor r=41.7694 c=0
Rl7 (\2\:Yint Yint) resistor r=148.662 c=0
Rl8 (\2\:Yint \3\:Yint) resistor r=34.5546 c=0
Rl4 (Ab \4\:Ab) resistor r=178.013 c=0
Rl31 (\7\:Ybint \6\:Ybint) resistor r=138.8 c=0
Rl10 (\2\:Ybint Ybint) resistor r=58.6635 c=0
Rl30 (\4\:Ybint \6\:Ybint) resistor r=53.7923 c=0
Rl28 (\4\:Ybint \3\:Ybint) resistor r=146.045 c=0
Rl29 (\4\:Ybint \5\:Ybint) resistor r=1.2666 c=0
Rl1 (\2\:GatedVSS GatedVSS) resistor r=171.167 c=0
Rz14 (\2\:VSS \1\:VSS) resistor r=37.5 c=0
Rz13 (\4\:Y \5\:Y) resistor r=37.5 c=0
Rz2 (\11\:Ab \10\:Ab) resistor r=75 c=0
Rz6 (\9\:GatedVSS \8\:GatedVSS) resistor r=75 c=0
Ry13 (\6\:VSS \8\:VSS) resistor r=7.75 c=0
Ry7 (\4\:VSS \3\:VSS) resistor r=7.75 c=0
Ry8 (\5\:VSS \3\:VSS) resistor r=5.1667 c=0
Ry14 (\12\:VSS \8\:VSS) resistor r=5.1667 c=0
Ry6 (\2\:Y \3\:Y) resistor r=20.6667 c=0
Ry1 (\3\:ExtVDD \4\:ExtVDD) resistor r=62 c=0
Ry9 (\1\:VDD \2\:VDD) resistor r=20.6667 c=0
Ry10 (\7\:VDD \8\:VDD) resistor r=62 c=0
Ry11 (\9\:VDD \10\:VDD) resistor r=62 c=0
Ry12 (\11\:VDD \12\:VDD) resistor r=62 c=0
Ry3 (\12\:Yint \11\:Yint) resistor r=62 c=0
Ry2 (\8\:Ab \7\:Ab) resistor r=62 c=0
Ry4 (\9\:Ybint \8\:Ybint) resistor r=62 c=0
Ry5 (\16\:Ybint \15\:Ybint) resistor r=62 c=0
Rx10 (\10\:ISOn \2\:ISOn) resistor r=45 c=0
Rx1 (\13\:A \6\:A) resistor r=45 c=0
Rx3 (\8\:Yint \3\:Yint) resistor r=45 c=0
Rx4 (\13\:Yint Yint) resistor r=45 c=0
Rx2 (\9\:Ab \4\:Ab) resistor r=45 c=0
Rx7 (\10\:Ybint \7\:Ybint) resistor r=45 c=0
Rx8 (\11\:Ybint \5\:Ybint) resistor r=45 c=0
Rx9 (\14\:Ybint \2\:Ybint) resistor r=45 c=0
Rx5 (\14\:GatedVSS GatedVSS) resistor r=45 c=0
Rx6 (\18\:GatedVSS \2\:GatedVSS) resistor r=45 c=0
NM2 (\8\:GatedVSS \10\:A \10\:Ab VSS) g45n1svt w=(1.45e-07) l=4.5e-08 \
        nf=1 as=2.03e-14 ad=2.03e-14 ps=5.7e-07 pd=5.7e-07 nrd=1.16667 \
        nrs=1.16667 sa=1.4e-07 sb=1.4e-07 sd=160n sca=12.9138 \
        scb=0.0133404 scc=0.000640143 m=(1)
mn0 (\4\:Y \3\:Ybint \1\:VSS VSS) g45n1svt w=(2.6e-07) l=4.5e-08 nf=1 \
        as=3.64e-14 ad=3.64e-14 ps=8e-07 pd=8e-07 nrd=1.16667 nrs=1.16667 \
        sa=1.4e-07 sb=1.4e-07 sd=160n sca=7.96722 scb=0.00567143 \
        scc=0.000107411 m=(1)
NM3_1__rcx (\15\:GatedVSS \3\:ISOn \6\:VSS VSS) g45n1svt w=(2.6e-07) \
        l=4.5e-08 nf=1 as=4.16e-14 ad=3.9e-14 ps=8.4e-07 pd=8.2e-07 \
        nrd=1.16667 nrs=1.16667 sa=1.4e-07 sb=7.55e-07 sd=160n sca=9.14564 \
        scb=0.00759168 scc=0.000213449 m=(4)
NM0_1__rcx (\12\:Ybint \1\:A \3\:GatedVSS VSS) g45n1svt w=(2.6e-07) \
        l=4.5e-08 nf=1 as=3.987e-14 ad=4.16e-14 ps=8.2667e-07 pd=8.4e-07 \
        nrd=1.16667 nrs=1.16667 sa=7.55e-07 sb=5.5e-07 sd=160n sca=15.3338 \
        scb=0.0153436 scc=0.00119435 m=(3)
NM1_1__rcx (\5\:Yint Ab \3\:GatedVSS VSS) g45n1svt w=(2.6e-07) l=4.5e-08 \
        nf=1 as=4.16e-14 ad=3.987e-14 ps=8.4e-07 pd=8.2667e-07 nrd=1.16667 \
        nrs=1.16667 sa=5.5e-07 sb=7.55e-07 sd=160n sca=15.3338 \
        scb=0.0153436 scc=0.00119435 m=(3)
mp0 (\2\:Y \6\:Ybint \1\:VDD VDD) g45p1svt w=(3.9e-07) l=4.5e-08 nf=1 \
        as=5.46e-14 ad=5.46e-14 ps=1.06e-06 pd=1.06e-06 nrd=1.16667 \
        nrs=1.16667 sa=1.4e-07 sb=1.4e-07 sd=160n sca=12.8766 \
        scb=0.0121784 scc=0.000303293 m=(1)
ends LSLH_ISONL_X1_TO_ON
// End of subcircuit definition.
