// Generated for: spectre (May  1 08:16:32 2013 )
// Library name: gsclib045
// Cell name: NOR4BX4
// View name: extracted

simulator lang=spectre

subckt NOR4BX4 AN B C D VDD VSS Y
mp0 (\20\:n0 \1\:AN \11\:VDD VDD) g45p1svt w=(3.9e-07) l=4.5e-08 nf=1 \
        as=5.46e-14 ad=4.8e-14 ps=1.06e-06 pd=1.13e-06 nrd=1.16667 \
        nrs=1.16667 sa=1.4e-07 sb=1.23077e-07 sd=160n sca=38.3623 \
        scb=0.0317516 scc=0.00376558 m=(1)
mp3_1__rcx (n3 C n2 VDD) g45p1svt w=(3.9e-07) l=4.5e-08 nf=1 as=6.24e-14 \
        ad=6.045e-14 ps=1.1e-06 pd=1.09e-06 nrd=1.16667 nrs=1.16667 \
        sa=1.4e-07 sb=1.575e-06 sd=160n sca=13.5671 scb=0.012183 \
        scc=0.000647513 m=(4)
mp2_1__rcx (\4\:n2 B n1 VDD) g45p1svt w=(3.9e-07) l=4.5e-08 nf=1 \
        as=6.386e-14 ad=6.24e-14 ps=1.1075e-06 pd=1.1e-06 nrd=1.16667 \
        nrs=1.16667 sa=9.60641e-07 sb=7.65e-07 sd=160n sca=12.3656 \
        scb=0.0108222 scc=0.000412413 m=(4)
mp4_1__rcx (\18\:Y D n3 VDD) g45p1svt w=(3.9e-07) l=4.5e-08 nf=1 \
        as=6.045e-14 ad=6.24e-14 ps=1.09e-06 pd=1.1e-06 nrd=1.16667 \
        nrs=1.16667 sa=9.6e-07 sb=7.55e-07 sd=160n sca=13.6362 \
        scb=0.0121968 scc=0.000647514 m=(4)
mp1_1__rcx (n1 n0 \3\:VDD VDD) g45p1svt w=(3.9e-07) l=4.5e-08 nf=1 \
        as=6.24e-14 ad=6.051e-14 ps=1.1e-06 pd=1.0975e-06 nrd=1.16667 \
        nrs=1.16667 sa=1.25641e-07 sb=1.6e-06 sd=160n sca=12.8019 \
        scb=0.0109628 scc=0.00041245 m=(4)
C1 (C VSS) capacitor c=4.40254e-16
C2 (Y VSS) capacitor c=2.39114e-16
C3 (VDD VSS) capacitor c=2.47283e-16
C4 (B VSS) capacitor c=3.97884e-16
C5 (AN VSS) capacitor c=3.16387e-17
C6 (D VSS) capacitor c=3.95504e-16
C7 (n0 VSS) capacitor c=3.306e-16
C8 (n1 VSS) capacitor c=4.01476e-16
C9 (n2 VSS) capacitor c=1.73855e-16
C10 (n3 VSS) capacitor c=3.63303e-16
C11 (\1\:AN VSS) capacitor c=3.45106e-17
C12 (\3\:AN VSS) capacitor c=2.82929e-17
C13 (\2\:AN VSS) capacitor c=1.73094e-17
C14 (\18\:Y VSS) capacitor c=3.46618e-16
C15 (\4\:n2 VSS) capacitor c=1.63791e-16
C16 (\20\:n0 VSS) capacitor c=2.1481e-17
C17 (\11\:VDD VSS) capacitor c=2.67551e-17
C18 (\1\:VDD VSS) capacitor c=1.47134e-16
C19 (\1\:Y VSS) capacitor c=9.63472e-17
C20 (\5\:Y VSS) capacitor c=1.17002e-16
C21 (\9\:Y VSS) capacitor c=9.29682e-17
C22 (\14\:Y VSS) capacitor c=1.15427e-16
C23 (\18\:n0 VSS) capacitor c=1.89329e-17
C24 (\4\:AN VSS) capacitor c=6.1599e-17
C25 (\17\:n0 VSS) capacitor c=4.43246e-17
C26 (\13\:Y VSS) capacitor c=4.05608e-17
C27 (\3\:VDD VSS) capacitor c=1.40902e-16
C28 (\6\:VDD VSS) capacitor c=9.18494e-18
Rk48 (\14\:VSS VSS) resistor r=0.03712 c=0
Rk47 (\1\:VSS \14\:VSS) resistor r=0.2501 c=0
Rk57 (\14\:VSS \32\:VSS) resistor r=0.272 c=0
Rk31 (Y \18\:Y) resistor r=1.4551 c=0
Rk23 (\1\:Y \5\:Y) resistor r=0.2626 c=0
Rk25 (\5\:Y \9\:Y) resistor r=0.2626 c=0
Rk30 (\13\:Y Y) resistor r=0.3021 c=0
Rk27 (\9\:Y \13\:Y) resistor r=0.04705 c=0
Rk28 (\13\:Y \14\:Y) resistor r=0.237 c=0
Rk58 (\2\:VDD \3\:VDD) resistor r=1.0667 c=0
Rk62 (\6\:VDD VDD) resistor r=0.03712 c=0
Rk61 (\3\:VDD \6\:VDD) resistor r=0.3427 c=0
Rk65 (\6\:VDD \12\:VDD) resistor r=0.3383 c=0
Rk1 (\4\:AN AN) resistor r=0.08125 c=0
Rk3 (n0 \17\:n0) resistor r=0.3699 c=0
Rk4 (\17\:n0 \19\:n0) resistor r=0.1248 c=0
Rk5 (\17\:n0 \21\:n0) resistor r=0.1664 c=0
Rk16 (n2 \4\:n2) resistor r=0.4476 c=0
Rl1 (\1\:AN \2\:AN) resistor r=47.3097 c=0
Rl2 (\2\:AN \3\:AN) resistor r=24.2328 c=0
Rz19 (\32\:VSS \31\:VSS) resistor r=75 c=0
Rz20 (\2\:VDD \1\:VDD) resistor r=7.5 c=0
Rz21 (\3\:VDD \1\:VDD) resistor r=6.25 c=0
Rz1 (\19\:n0 \18\:n0) resistor r=75 c=0
Ry22 (\12\:VDD \11\:VDD) resistor r=62 c=0
Ry1 (\21\:n0 \20\:n0) resistor r=62 c=0
Rx1 (\2\:AN \4\:AN) resistor r=45 c=0
mn0 (\18\:n0 \3\:AN \31\:VSS VSS) g45n1svt w=(2.6e-07) l=4.5e-08 nf=1 \
        as=3.64e-14 ad=5.06e-14 ps=8e-07 pd=1.13e-06 nrd=1.16667 \
        nrs=1.16667 sa=1.4e-07 sb=1.94615e-07 sd=160n sca=15.3338 \
        scb=0.0153436 scc=0.00119435 m=(1)
mn4_1__rcx (\1\:Y D \1\:VSS VSS) g45n1svt w=(2.6e-07) l=4.5e-08 nf=1 \
        as=4.03e-14 ad=4.16e-14 ps=8.3e-07 pd=8.4e-07 nrd=1.16667 \
        nrs=1.16667 sa=2e-06 sb=7.55e-07 sd=160n sca=11.8713 scb=0.0115056 \
        scc=0.000581193 m=(4)
mn3 (\5\:Y C \1\:VSS VSS) g45n1svt w=(2.6e-07) l=4.5e-08 nf=1 \
        as=4.16e-14 ad=4.16e-14 ps=8.4e-07 pd=8.4e-07 nrd=1.16667 \
        nrs=1.16667 sa=1.74e-06 sb=1.575e-06 sd=160n sca=11.8713 \
        scb=0.0115056 scc=0.000581193 m=(4)
mn2_1__rcx (\9\:Y B \1\:VSS VSS) g45n1svt w=(2.6e-07) l=4.5e-08 nf=1 \
        as=4.16e-14 ad=4.16e-14 ps=8.4e-07 pd=8.4e-07 nrd=1.16667 \
        nrs=1.16667 sa=9.2e-07 sb=2e-06 sd=160n sca=11.8713 scb=0.0115056 \
        scc=0.000581193 m=(4)
mn1_1__rcx (\14\:Y n0 \1\:VSS VSS) g45n1svt w=(2.6e-07) l=4.5e-08 nf=1 \
        as=4.299e-14 ad=4.16e-14 ps=9.725e-07 pd=8.4e-07 nrd=1.16667 \
        nrs=1.16667 sa=1e-07 sb=2e-06 sd=160n sca=11.8713 scb=0.0115056 \
        scc=0.000581193 m=(4)
ends NOR4BX4
// End of subcircuit definition.
