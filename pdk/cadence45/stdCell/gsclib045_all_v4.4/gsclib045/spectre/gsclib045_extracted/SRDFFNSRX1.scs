// Generated for: spectre (May  1 08:12:37 2013 )
// Library name: gsclib045
// Cell name: SRDFFNSRX1
// View name: extracted

simulator lang=spectre

subckt SRDFFNSRX1 CKN D ExtVDD Q QN RN RT SE SI SN VDD VSS
mp11 (n1 \4\:D \25\:VDD VDD) g45p1svt w=(2.15e-07) l=4.5e-08 nf=1 \
        as=1.362e-13 ad=1.29e-14 ps=2.93e-06 pd=5.5e-07 nrd=1.16667 \
        nrs=1.16667 sa=1.7e-07 sb=7.6e-07 sd=160n sca=15.238 scb=0.0153511 \
        scc=0.00103803 m=(1)
mp20 (\20\:CKNb \4\:CKN \25\:VDD VDD) g45p1svt w=(2.15e-07) l=4.5e-08 \
        nf=1 as=3.01e-14 ad=1.362e-13 ps=7.1e-07 pd=2.93e-06 nrd=1.16667 \
        nrs=1.16667 sa=3.45e-07 sb=1.4e-07 sd=160n sca=14.7851 \
        scb=0.0152025 scc=0.00103799 m=(1)
mp21 (\12\:CKNbb \4\:CKNb \25\:VDD VDD) g45p1svt w=(2.15e-07) l=4.5e-08 \
        nf=1 as=1.362e-13 ad=3.01e-14 ps=2.93e-06 pd=7.1e-07 nrd=1.16667 \
        nrs=1.16667 sa=1.4e-07 sb=3.45e-07 sd=160n sca=14.7851 \
        scb=0.0152025 scc=0.00103799 m=(1)
mp10 (\8\:SEb \3\:SE \18\:VDD VDD) g45p1svt w=(2.15e-07) l=4.5e-08 nf=1 \
        as=3.44e-14 ad=3.01e-14 ps=7.5e-07 pd=7.1e-07 nrd=1.16667 \
        nrs=1.16667 sa=7.9e-07 sb=1.4e-07 sd=160n sca=34.2363 \
        scb=0.0392303 scc=0.00368484 m=(1)
mp14 (\3\:Db SEb n3 VDD) g45p1svt w=(2.15e-07) l=4.5e-08 nf=1 as=1.29e-14 \
        ad=3.44e-14 ps=5.5e-07 pd=7.5e-07 nrd=1.16667 nrs=1.16667 \
        sa=4.8e-07 sb=4.5e-07 sd=160n sca=17.3611 scb=0.0177712 \
        scc=0.00105096 m=(1)
mp56 (\9\:net573 \13\:qbint \16\:VDD VDD) g45p1svt w=(2.15e-07) \
        l=4.5e-08 nf=1 as=3.01e-14 ad=6.535e-14 ps=7.1e-07 pd=1.16e-06 \
        nrd=1.16667 nrs=1.16667 sa=3.75e-07 sb=1.4e-07 sd=160n sca=18.0318 \
        scb=0.0190355 scc=0.000934132 m=(1)
mp22 (\10\:RNb \1\:RN \27\:VDD VDD) g45p1svt w=(2.15e-07) l=4.5e-08 nf=1 \
        as=3.01e-14 ad=3.01e-14 ps=7.1e-07 pd=7.1e-07 nrd=1.16667 \
        nrs=1.16667 sa=1.4e-07 sb=1.4e-07 sd=160n sca=16.7887 scb=0.018018 \
        scc=0.000709984 m=(1)
mp25 (\10\:n20 \3\:CKNb \5\:Db VDD) g45p1svt w=(2.15e-07) l=4.5e-08 nf=1 \
        as=3.01e-14 ad=3.01e-14 ps=7.1e-07 pd=7.1e-07 nrd=1.16667 \
        nrs=1.16667 sa=1.4e-07 sb=1.4e-07 sd=160n sca=16.6808 \
        scb=0.0167571 scc=0.00104234 m=(1)
mp36 (\13\:n20 \8\:CKNbb n7 VDD) g45p1svt w=(2.15e-07) l=4.5e-08 nf=1 \
        as=1.29e-14 ad=3.01e-14 ps=5.5e-07 pd=7.1e-07 nrd=1.16667 \
        nrs=1.16667 sa=1.4e-07 sb=4.5e-07 sd=160n sca=6.17959 \
        scb=0.00249724 scc=1.4077e-05 m=(1)
mp35 (n7 mout \23\:VDD VDD) g45p1svt w=(2.15e-07) l=4.5e-08 nf=1 \
        as=3.44e-14 ad=1.29e-14 ps=7.5e-07 pd=5.5e-07 nrd=1.16667 \
        nrs=1.16667 sa=2.45e-07 sb=3.45e-07 sd=160n sca=6.07861 \
        scb=0.00247604 scc=1.40748e-05 m=(1)
mp30 (\16\:mout \1\:SN \23\:VDD VDD) g45p1svt w=(2.15e-07) l=4.5e-08 \
        nf=1 as=3.44e-14 ad=3.01e-14 ps=7.5e-07 pd=7.1e-07 nrd=1.16667 \
        nrs=1.16667 sa=4.5e-07 sb=1.4e-07 sd=160n sca=6.07861 \
        scb=0.00247604 scc=1.40748e-05 m=(1)
mp32 (\19\:mout \3\:n20 n5 VDD) g45p1svt w=(2.15e-07) l=4.5e-08 nf=1 \
        as=1.29e-14 ad=3.01e-14 ps=5.5e-07 pd=7.1e-07 nrd=1.16667 \
        nrs=1.16667 sa=1.4e-07 sb=2.45e-07 sd=160n sca=6.79882 \
        scb=0.00278203 scc=1.42286e-05 m=(1)
mp12 (\3\:Db \4\:SE n1 VDD) g45p1svt w=(2.15e-07) l=4.5e-08 nf=1 \
        as=1.29e-14 ad=3.44e-14 ps=5.5e-07 pd=7.5e-07 nrd=1.16667 \
        nrs=1.16667 sa=2.75e-07 sb=6.55e-07 sd=160n sca=15.6684 \
        scb=0.0156302 scc=0.00103829 m=(1)
mp31 (n5 \9\:RNb \20\:VDD VDD) g45p1svt w=(2.15e-07) l=4.5e-08 nf=1 \
        as=3.01e-14 ad=1.29e-14 ps=7.1e-07 pd=5.5e-07 nrd=1.16667 \
        nrs=1.16667 sa=2.45e-07 sb=1.4e-07 sd=160n sca=7.36861 \
        scb=0.00328614 scc=1.51674e-05 m=(1)
mp13 (n3 \3\:SI \18\:VDD VDD) g45p1svt w=(2.15e-07) l=4.5e-08 nf=1 \
        as=3.44e-14 ad=1.29e-14 ps=7.5e-07 pd=5.5e-07 nrd=1.16667 \
        nrs=1.16667 sa=5.85e-07 sb=3.45e-07 sd=160n sca=19.3151 \
        scb=0.0211393 scc=0.00112289 m=(1)
mp40 (\4\:n35 \7\:CKNbb \5\:mout VDD) g45p1svt w=(2.15e-07) l=4.5e-08 \
        nf=1 as=3.01e-14 ad=3.01e-14 ps=7.1e-07 pd=7.1e-07 nrd=1.16667 \
        nrs=1.16667 sa=1.4e-07 sb=1.4e-07 sd=160n sca=25.5298 \
        scb=0.0265038 scc=0.00266093 m=(1)
PM0 (\6\:n35g \5\:RT \9\:n35 ExtVDD) g45p1svt w=(2.15e-07) l=4.5e-08 nf=1 \
        as=3.01e-14 ad=3.01e-14 ps=7.1e-07 pd=7.1e-07 nrd=1.16667 \
        nrs=1.16667 sa=1.4e-07 sb=1.4e-07 sd=160n sca=26.0836 \
        scb=0.0271848 scc=0.00267095 m=(1)
mp45 (\17\:qbint \3\:n35g \1\:ExtVDD ExtVDD) g45p1svt w=(2.15e-07) \
        l=4.5e-08 nf=1 as=3.5882e-13 ad=3.01e-14 ps=3.6e-06 pd=7.1e-07 \
        nrd=1.16667 nrs=1.16667 sa=1.4e-07 sb=8.7e-07 sd=160n sca=25.2796 \
        scb=0.0259458 scc=0.00265434 m=(1)
PM2 (net234 \4\:qbint \1\:ExtVDD ExtVDD) g45p1svt w=(2.15e-07) l=4.5e-08 \
        nf=1 as=3.5882e-13 ad=1.29e-14 ps=3.6e-06 pd=5.5e-07 nrd=1.16667 \
        nrs=1.16667 sa=7.65e-07 sb=2.45e-07 sd=160n sca=14.5295 \
        scb=0.0144143 scc=0.000486924 m=(1)
PM1 (\6\:RTb \6\:RT \1\:ExtVDD ExtVDD) g45p1svt w=(2.15e-07) l=4.5e-08 \
        nf=1 as=3.5882e-13 ad=3.01e-14 ps=3.6e-06 pd=7.1e-07 nrd=1.16667 \
        nrs=1.16667 sa=3.3e-07 sb=1.4e-07 sd=160n sca=24.3731 \
        scb=0.0258873 scc=0.00229004 m=(1)
PM3 (\15\:n35g \4\:RTb net234 ExtVDD) g45p1svt w=(2.15e-07) l=4.5e-08 \
        nf=1 as=1.29e-14 ad=3.01e-14 ps=5.5e-07 pd=7.1e-07 nrd=1.16667 \
        nrs=1.16667 sa=8.7e-07 sb=1.4e-07 sd=160n sca=25.2796 \
        scb=0.0259458 scc=0.00265434 m=(1)
mp53 (\14\:n35 \12\:CKNb \3\:n11 VDD) g45p1svt w=(2.15e-07) l=4.5e-08 \
        nf=1 as=3.01e-14 ad=3.01e-14 ps=7.1e-07 pd=7.1e-07 nrd=1.16667 \
        nrs=1.16667 sa=1.4e-07 sb=1.4e-07 sd=160n sca=28.3325 \
        scb=0.0311878 scc=0.00281308 m=(1)
mp51 (n9 \4\:RNb \14\:VDD VDD) g45p1svt w=(2.15e-07) l=4.5e-08 nf=1 \
        as=3.01e-14 ad=1.29e-14 ps=7.1e-07 pd=5.5e-07 nrd=1.16667 \
        nrs=1.16667 sa=1.4e-07 sb=4.5e-07 sd=160n sca=11.272 \
        scb=0.00858882 scc=0.000167946 m=(1)
mp52 (n11 \11\:qbint n9 VDD) g45p1svt w=(2.15e-07) l=4.5e-08 nf=1 \
        as=1.29e-14 ad=3.44e-14 ps=5.5e-07 pd=7.5e-07 nrd=1.16667 \
        nrs=1.16667 sa=2.45e-07 sb=3.45e-07 sd=160n sca=11.4972 \
        scb=0.00902054 scc=0.000170728 m=(1)
mp50 (n11 \7\:SN \1\:VDD VDD) g45p1svt w=(2.15e-07) l=4.5e-08 nf=1 \
        as=3.01e-14 ad=3.44e-14 ps=7.1e-07 pd=7.5e-07 nrd=1.16667 \
        nrs=1.16667 sa=4.5e-07 sb=1.4e-07 sd=160n sca=14.6968 \
        scb=0.0152164 scc=0.000337347 m=(1)
C1 (QN VSS) capacitor c=1.85291e-17
C2 (VDD VSS) capacitor c=7.36133e-16
C3 (Q VSS) capacitor c=6.71361e-17
C4 (SE VSS) capacitor c=3.38471e-17
C5 (D VSS) capacitor c=3.98991e-17
C6 (ExtVDD VSS) capacitor c=2.33907e-16
C7 (CKN VSS) capacitor c=4.35902e-17
C8 (RN VSS) capacitor c=7.24848e-17
C9 (RT VSS) capacitor c=2.37219e-17
C10 (SI VSS) capacitor c=8.71323e-17
C11 (SN VSS) capacitor c=3.96585e-17
C12 (n20 VSS) capacitor c=3.8975e-17
C13 (CKNb VSS) capacitor c=4.74009e-17
C14 (mout VSS) capacitor c=5.41376e-17
C15 (RNb VSS) capacitor c=3.88111e-17
C16 (CKNbb VSS) capacitor c=3.41408e-17
C17 (SEb VSS) capacitor c=7.81389e-17
C18 (n35g VSS) capacitor c=1.81021e-17
C19 (qbint VSS) capacitor c=4.47303e-17
C20 (RTb VSS) capacitor c=5.18605e-17
C21 (net573 VSS) capacitor c=2.25178e-17
C22 (n35 VSS) capacitor c=1.72343e-16
C23 (Db VSS) capacitor c=9.70103e-17
C24 (n11 VSS) capacitor c=8.43602e-17
C25 (n8 VSS) capacitor c=7.94551e-17
C26 (n10 VSS) capacitor c=8.44127e-17
C27 (n4 VSS) capacitor c=8.69113e-17
C28 (n1 VSS) capacitor c=1.02126e-18
C29 (\7\:SN VSS) capacitor c=7.0739e-17
C30 (\7\:qbint VSS) capacitor c=3.42488e-17
C31 (\11\:qbint VSS) capacitor c=1.41883e-16
C32 (\4\:RNb VSS) capacitor c=4.04222e-16
C33 (\13\:qbint VSS) capacitor c=4.46873e-17
C34 (\3\:net573 VSS) capacitor c=5.8881e-17
C35 (\12\:CKNb VSS) capacitor c=5.81687e-17
C36 (\4\:RTb VSS) capacitor c=9.92226e-17
C37 (\6\:RT VSS) capacitor c=2.30242e-17
C38 (\4\:qbint VSS) capacitor c=5.43131e-17
C39 (\3\:n35g VSS) capacitor c=5.42452e-17
C40 (\5\:RT VSS) capacitor c=8.4001e-17
C41 (\3\:SE VSS) capacitor c=7.79809e-17
C42 (\7\:CKNbb VSS) capacitor c=3.92996e-17
C43 (\3\:SI VSS) capacitor c=9.77912e-17
C44 (\9\:RNb VSS) capacitor c=6.01657e-17
C45 (\4\:SE VSS) capacitor c=1.23651e-16
C46 (\3\:n20 VSS) capacitor c=4.73671e-17
C47 (\4\:D VSS) capacitor c=6.98699e-17
C48 (\1\:SN VSS) capacitor c=3.03254e-17
C49 (\4\:CKN VSS) capacitor c=5.73565e-17
C50 (\4\:CKNb VSS) capacitor c=4.5203e-17
C51 (\8\:CKNbb VSS) capacitor c=8.26211e-17
C52 (\3\:CKNb VSS) capacitor c=1.13137e-16
C53 (\1\:RN VSS) capacitor c=4.27071e-17
C54 (\8\:SN VSS) capacitor c=1.3559e-16
C55 (\6\:qbint VSS) capacitor c=3.80082e-17
C56 (\12\:qbint VSS) capacitor c=8.09839e-17
C57 (\3\:RNb VSS) capacitor c=6.84518e-17
C58 (\14\:qbint VSS) capacitor c=4.66717e-17
C59 (\4\:net573 VSS) capacitor c=3.67833e-17
C60 (\9\:CKNbb VSS) capacitor c=2.24376e-16
C61 (\8\:RT VSS) capacitor c=1.22499e-16
C62 (\2\:RT VSS) capacitor c=6.2495e-17
C63 (\5\:qbint VSS) capacitor c=3.89021e-17
C64 (\5\:n35g VSS) capacitor c=3.28666e-17
C65 (\2\:RTb VSS) capacitor c=4.95913e-17
C66 (\5\:SE VSS) capacitor c=5.82411e-17
C67 (\6\:CKNb VSS) capacitor c=3.28382e-17
C68 (\1\:SI VSS) capacitor c=4.92085e-17
C69 (\6\:SE VSS) capacitor c=8.72795e-17
C70 (\3\:SEb VSS) capacitor c=6.6814e-17
C71 (\1\:D VSS) capacitor c=4.95122e-17
C72 (\6\:n20 VSS) capacitor c=6.17351e-17
C73 (\6\:SN VSS) capacitor c=4.73813e-17
C74 (\1\:CKN VSS) capacitor c=2.87015e-17
C75 (\3\:mout VSS) capacitor c=4.58426e-17
C76 (\11\:CKNb VSS) capacitor c=4.92133e-17
C77 (\4\:RN VSS) capacitor c=3.70146e-17
C78 (\10\:qbint VSS) capacitor c=8.58395e-17
C79 (\13\:CKNb VSS) capacitor c=7.94778e-17
C80 (\3\:SN VSS) capacitor c=3.75715e-16
C81 (\9\:SN VSS) capacitor c=9.18522e-17
C82 (\7\:RT VSS) capacitor c=1.54269e-16
C83 (\10\:CKNb VSS) capacitor c=1.67984e-16
C84 (\3\:RT VSS) capacitor c=5.76705e-17
C85 (\1\:RT VSS) capacitor c=5.31416e-17
C86 (\3\:RTb VSS) capacitor c=7.61699e-17
C87 (\3\:qbint VSS) capacitor c=4.4688e-17
C88 (\2\:n35 VSS) capacitor c=2.52702e-16
C89 (\4\:n35g VSS) capacitor c=6.75812e-17
C90 (\3\:CKNbb VSS) capacitor c=5.59848e-17
C91 (\10\:CKNbb VSS) capacitor c=2.18316e-16
C92 (\3\:n35 VSS) capacitor c=1.15993e-16
C93 (\1\:SE VSS) capacitor c=2.36248e-17
C94 (\2\:SI VSS) capacitor c=7.7958e-17
C95 (\2\:RNb VSS) capacitor c=3.49956e-17
C96 (\8\:RNb VSS) capacitor c=1.24508e-17
C97 (\2\:SEb VSS) capacitor c=7.77921e-17
C98 (\7\:n20 VSS) capacitor c=5.41963e-17
C99 (\4\:n20 VSS) capacitor c=1.15192e-16
C100 (\3\:D VSS) capacitor c=1.38601e-17
C101 (\2\:SN VSS) capacitor c=4.20787e-17
C102 (\5\:SN VSS) capacitor c=2.64339e-17
C103 (\3\:CKN VSS) capacitor c=2.3447e-17
C104 (\2\:mout VSS) capacitor c=4.66118e-17
C105 (\4\:mout VSS) capacitor c=3.22064e-17
C106 (\2\:CKNb VSS) capacitor c=8.01819e-17
C107 (\6\:CKNbb VSS) capacitor c=3.65398e-17
C108 (\5\:n20 VSS) capacitor c=1.15122e-16
C109 (\2\:CKNbb VSS) capacitor c=5.81201e-17
C110 (\5\:CKNb VSS) capacitor c=7.95375e-17
C111 (\9\:CKNb VSS) capacitor c=2.69077e-17
C112 (\7\:RNb VSS) capacitor c=1.3317e-16
C113 (\2\:n20 VSS) capacitor c=4.61667e-17
C114 (\3\:RN VSS) capacitor c=4.62844e-17
C115 (\1\:VDD VSS) capacitor c=2.99217e-17
C116 (\12\:VDD VSS) capacitor c=4.46723e-17
C117 (\3\:Q VSS) capacitor c=6.86484e-17
C118 (\14\:VDD VSS) capacitor c=4.88861e-17
C119 (\9\:net573 VSS) capacitor c=5.67096e-17
C120 (\16\:VDD VSS) capacitor c=7.88719e-17
C121 (\3\:n11 VSS) capacitor c=9.93052e-17
C122 (\4\:QN VSS) capacitor c=6.85131e-17
C123 (\14\:n35 VSS) capacitor c=5.33787e-17
C124 (\15\:n35g VSS) capacitor c=5.5845e-17
C125 (\6\:RTb VSS) capacitor c=7.33331e-17
C126 (\1\:ExtVDD VSS) capacitor c=2.7808e-16
C127 (\9\:n35 VSS) capacitor c=6.17749e-17
C128 (\17\:qbint VSS) capacitor c=6.8043e-17
C129 (\6\:n35g VSS) capacitor c=9.39949e-17
C130 (\8\:SEb VSS) capacitor c=4.91832e-17
C131 (\4\:n35 VSS) capacitor c=7.23172e-17
C132 (\18\:VDD VSS) capacitor c=5.87309e-17
C133 (\5\:mout VSS) capacitor c=1.33584e-16
C134 (\20\:VDD VSS) capacitor c=4.32362e-17
C135 (\3\:Db VSS) capacitor c=1.84294e-16
C136 (\19\:mout VSS) capacitor c=3.68274e-17
C137 (\25\:VDD VSS) capacitor c=3.53135e-17
C138 (\16\:mout VSS) capacitor c=4.3699e-17
C139 (\20\:CKNb VSS) capacitor c=2.94023e-17
C140 (\23\:VDD VSS) capacitor c=4.82106e-17
C141 (\12\:CKNbb VSS) capacitor c=5.92881e-17
C142 (\13\:n20 VSS) capacitor c=6.20964e-17
C143 (\5\:Db VSS) capacitor c=2.29187e-16
C144 (\10\:RNb VSS) capacitor c=5.03256e-17
C145 (\10\:n20 VSS) capacitor c=6.31976e-17
C146 (\27\:VDD VSS) capacitor c=6.95799e-17
C147 (\1\:Q VSS) capacitor c=5.27858e-17
C148 (\5\:net573 VSS) capacitor c=4.29604e-17
C149 (\3\:n8 VSS) capacitor c=8.08016e-17
C150 (\3\:n10 VSS) capacitor c=7.84072e-17
C151 (\1\:QN VSS) capacitor c=3.92318e-17
C152 (\17\:n35 VSS) capacitor c=4.81079e-17
C153 (\11\:n35g VSS) capacitor c=2.95902e-17
C154 (\10\:RTb VSS) capacitor c=5.8031e-17
C155 (\12\:n35 VSS) capacitor c=6.33333e-17
C156 (\19\:qbint VSS) capacitor c=2.42623e-17
C157 (\9\:n35g VSS) capacitor c=7.99906e-17
C158 (\4\:SEb VSS) capacitor c=3.81839e-17
C159 (\7\:n35 VSS) capacitor c=4.88692e-17
C160 (\11\:mout VSS) capacitor c=3.70969e-17
C161 (\13\:mout VSS) capacitor c=3.81444e-17
C162 (\3\:n4 VSS) capacitor c=1.00303e-16
C163 (\16\:CKNb VSS) capacitor c=6.3228e-17
C164 (\15\:CKNbb VSS) capacitor c=5.92363e-17
C165 (\17\:n20 VSS) capacitor c=8.56794e-17
C166 (\7\:Db VSS) capacitor c=1.10152e-16
C167 (\13\:RNb VSS) capacitor c=7.33683e-17
C168 (\8\:n20 VSS) capacitor c=5.95221e-17
C169 (\2\:CKN VSS) capacitor c=3.36864e-17
C170 (\2\:D VSS) capacitor c=3.55423e-17
C171 (\2\:SE VSS) capacitor c=2.73469e-17
C172 (\4\:CKNbb VSS) capacitor c=1.5596e-16
C173 (\5\:CKNbb VSS) capacitor c=8.74772e-17
C174 (VDD VSS) capacitor c=2.24358e-16
C175 (\2\:n35g VSS) capacitor c=2.90477e-17
C176 (\4\:RT VSS) capacitor c=7.55784e-17
C177 (\2\:qbint VSS) capacitor c=4.15774e-17
C178 (\7\:CKNb VSS) capacitor c=1.37751e-16
C179 (\8\:CKNb VSS) capacitor c=7.42378e-17
C180 (\4\:SN VSS) capacitor c=3.61363e-16
C181 (\2\:net573 VSS) capacitor c=1.51903e-17
C182 (\12\:n20 VSS) capacitor c=4.6283e-17
C183 (\5\:RNb VSS) capacitor c=3.89934e-16
C184 (\6\:RNb VSS) capacitor c=1.81092e-16
C185 (\12\:RNb VSS) capacitor c=1.15853e-16
C186 (\14\:CKNb VSS) capacitor c=1.55149e-16
C187 (\15\:CKNb VSS) capacitor c=1.36638e-16
C188 (\8\:qbint VSS) capacitor c=5.18538e-17
C189 (\9\:qbint VSS) capacitor c=7.89689e-17
C190 (\15\:n20 VSS) capacitor c=7.3302e-17
C191 (\16\:n20 VSS) capacitor c=9.17042e-17
C192 (\11\:CKNbb VSS) capacitor c=5.34694e-17
C193 (\14\:CKNbb VSS) capacitor c=7.93839e-17
C194 (\5\:CKN VSS) capacitor c=3.45174e-18
C195 (\6\:CKN VSS) capacitor c=3.32249e-17
C196 (\18\:CKNb VSS) capacitor c=6.51459e-17
C197 (\19\:CKNb VSS) capacitor c=3.73509e-17
C198 (\10\:SN VSS) capacitor c=4.4105e-17
C199 (\11\:SN VSS) capacitor c=4.4329e-17
C200 (\7\:D VSS) capacitor c=3.84446e-17
C201 (\19\:n20 VSS) capacitor c=8.01928e-17
C202 (\20\:n20 VSS) capacitor c=7.96759e-17
C203 (\15\:RNb VSS) capacitor c=7.0743e-17
C204 (\16\:RNb VSS) capacitor c=8.26329e-17
C205 (\7\:SE VSS) capacitor c=5.09788e-17
C206 (\7\:mout VSS) capacitor c=1.55942e-16
C207 (\8\:mout VSS) capacitor c=5.28789e-17
C208 (\9\:mout VSS) capacitor c=1.04111e-16
C209 (\10\:mout VSS) capacitor c=8.84085e-17
C210 (\15\:mout VSS) capacitor c=6.02185e-17
C211 (\18\:mout VSS) capacitor c=7.12359e-17
C212 (\6\:SEb VSS) capacitor c=8.4399e-17
C213 (\7\:SEb VSS) capacitor c=6.34591e-17
C214 (\6\:n35 VSS) capacitor c=1.06351e-16
C215 (\17\:CKNbb VSS) capacitor c=3.86037e-17
C216 (\18\:CKNbb VSS) capacitor c=4.15812e-17
C217 (\8\:n35g VSS) capacitor c=3.509e-17
C218 (\11\:n35 VSS) capacitor c=7.53656e-17
C219 (\15\:qbint VSS) capacitor c=8.75444e-17
C220 (\16\:qbint VSS) capacitor c=1.11701e-16
C221 (\13\:n35g VSS) capacitor c=1.03515e-16
C222 (\14\:n35g VSS) capacitor c=1.15853e-16
C223 (\5\:RTb VSS) capacitor c=4.91842e-17
C224 (\8\:RTb VSS) capacitor c=1.00399e-16
C225 (\9\:RTb VSS) capacitor c=9.13158e-17
C226 (\9\:RT VSS) capacitor c=1.10626e-16
C227 (\10\:RT VSS) capacitor c=1.17706e-16
C228 (\11\:RT VSS) capacitor c=3.80911e-17
C229 (\12\:SN VSS) capacitor c=8.24345e-17
C230 (\13\:SN VSS) capacitor c=8.01926e-17
C231 (\22\:CKNb VSS) capacitor c=1.30996e-16
C232 (\23\:CKNb VSS) capacitor c=1.33504e-16
C233 (\21\:qbint VSS) capacitor c=2.42399e-17
C234 (\22\:qbint VSS) capacitor c=2.98149e-17
C235 (\3\:QN VSS) capacitor c=3.16337e-17
C236 (\16\:n35 VSS) capacitor c=4.76532e-17
C237 (\7\:net573 VSS) capacitor c=4.92638e-17
C238 (\8\:net573 VSS) capacitor c=3.42582e-17
C239 (\3\:VDD VSS) capacitor c=3.05739e-17
C240 (\4\:VDD VSS) capacitor c=3.16689e-17
C241 (\6\:VDD VSS) capacitor c=9.94728e-18
C242 (\7\:VDD VSS) capacitor c=1.38897e-16
C243 (\8\:VDD VSS) capacitor c=6.31626e-17
C244 (\9\:VDD VSS) capacitor c=2.72729e-17
C245 (\11\:VDD VSS) capacitor c=5.15952e-17
C246 (\22\:VDD VSS) capacitor c=4.77796e-17
Rk76 (\3\:QN QN) resistor r=0.03436 c=0
Rk75 (\2\:QN \3\:QN) resistor r=0.1964 c=0
Rk77 (\3\:QN \5\:QN) resistor r=0.3478 c=0
Rk98 (\2\:VDD \3\:VDD) resistor r=0.3391 c=0
Rk99 (\3\:VDD \4\:VDD) resistor r=0.2189 c=0
Rk100 (\4\:VDD \6\:VDD) resistor r=0.06709 c=0
Rk102 (\7\:VDD VDD) resistor r=1.0574 c=0
Rk101 (\6\:VDD \7\:VDD) resistor r=0.05214 c=0
Rk103 (VDD \8\:VDD) resistor r=0.4723 c=0
Rk104 (\8\:VDD \9\:VDD) resistor r=0.1192 c=0
Rk105 (\9\:VDD \11\:VDD) resistor r=0.2222 c=0
Rk106 (\3\:VDD \13\:VDD) resistor r=0.3594 c=0
Rk107 (\4\:VDD \15\:VDD) resistor r=0.2953 c=0
Rk108 (\7\:VDD \17\:VDD) resistor r=0.3773 c=0
Rk109 (\8\:VDD \19\:VDD) resistor r=0.3693 c=0
Rk110 (\9\:VDD \21\:VDD) resistor r=0.2033 c=0
Rk114 (\22\:VDD VDD) resistor r=0.1964 c=0
Rk111 (\11\:VDD \22\:VDD) resistor r=0.1718 c=0
Rk112 (\22\:VDD \24\:VDD) resistor r=0.2087 c=0
Rk113 (\11\:VDD \26\:VDD) resistor r=0.2369 c=0
Rk115 (VDD \28\:VDD) resistor r=0.6017 c=0
Rk84 (\2\:Q Q) resistor r=0.1737 c=0
Rk85 (Q \4\:Q) resistor r=0.3034 c=0
Rk33 (SE \7\:SE) resistor r=0.04875 c=0
Rk22 (\5\:D D) resistor r=0.007231 c=0
Rk24 (\5\:D \7\:D) resistor r=0.02109 c=0
Rk23 (\6\:D \7\:D) resistor r=0.007231 c=0
Rk56 (ExtVDD ExtVDD) resistor r=0.00207 c=0
Rk54 (\2\:ExtVDD ExtVDD) resistor r=0.02224 c=0
Rk57 (ExtVDD \5\:ExtVDD) resistor r=0.02022 c=0
Rk58 (ExtVDD \6\:ExtVDD) resistor r=0.1502 c=0
Rk88 (\2\:VSS \4\:VSS) resistor r=0.5183 c=0
Rk89 (\4\:VSS \5\:VSS) resistor r=0.7677 c=0
Rk91 (\6\:VSS VSS) resistor r=0.1991 c=0
Rk90 (\5\:VSS \6\:VSS) resistor r=0.1792 c=0
Rk93 (\7\:VSS VSS) resistor r=0.02218 c=0
Rk92 (VSS \7\:VSS) resistor r=0.9971 c=0
Rk94 (VSS \8\:VSS) resistor r=0.0175 c=0
Rk95 (\8\:VSS \10\:VSS) resistor r=0.6752 c=0
Rk96 (\5\:VSS \12\:VSS) resistor r=0.2456 c=0
Rk97 (\8\:VSS \14\:VSS) resistor r=0.2532 c=0
Rk116 (\16\:VSS \18\:VSS) resistor r=0.4636 c=0
Rk117 (\18\:VSS \19\:VSS) resistor r=0.1394 c=0
Rk118 (\19\:VSS \20\:VSS) resistor r=0.6749 c=0
Rk119 (\20\:VSS \21\:VSS) resistor r=0.1319 c=0
Rk121 (\22\:VSS VSS) resistor r=0.1217 c=0
Rk120 (\21\:VSS \22\:VSS) resistor r=0.07706 c=0
Rk122 (VSS \23\:VSS) resistor r=0.5234 c=0
Rk123 (\23\:VSS \24\:VSS) resistor r=0.3086 c=0
Rk125 (\25\:VSS VSS) resistor r=0.02218 c=0
Rk124 (\24\:VSS \25\:VSS) resistor r=0.1643 c=0
Rk126 (VSS \27\:VSS) resistor r=0.3193 c=0
Rk127 (\19\:VSS \29\:VSS) resistor r=0.269 c=0
Rk128 (\20\:VSS \31\:VSS) resistor r=0.1908 c=0
Rk129 (\22\:VSS \33\:VSS) resistor r=0.1959 c=0
Rk130 (\23\:VSS \35\:VSS) resistor r=0.2554 c=0
Rk131 (\24\:VSS \37\:VSS) resistor r=0.251 c=0
Rk13 (CKN \5\:CKN) resistor r=0.001728 c=0
Rk16 (\5\:CKN \6\:CKN) resistor r=0.008627 c=0
Rk15 (\6\:CKN \7\:CKN) resistor r=0.003641 c=0
Rk1 (\5\:RN RN) resistor r=0.007307 c=0
Rk69 (RT \9\:RT) resistor r=0.1851 c=0
Rk70 (\9\:RT \10\:RT) resistor r=0.6516 c=0
Rk71 (RT \11\:RT) resistor r=0.01485 c=0
Rk32 (\4\:SI SI) resistor r=0.001105 c=0
Rk20 (SN \10\:SN) resistor r=0.008876 c=0
Rk21 (SN \11\:SN) resistor r=0.2633 c=0
Rk72 (\12\:SN \13\:SN) resistor r=0.5402 c=0
Rk2 (\9\:n20 \11\:n20) resistor r=0.5475 c=0
Rk3 (\11\:n20 \12\:n20) resistor r=0.2562 c=0
Rk7 (\14\:n20 \15\:n20) resistor r=0.3483 c=0
Rk8 (\14\:n20 \16\:n20) resistor r=0.2313 c=0
Rk9 (\16\:n20 \18\:n20) resistor r=0.5005 c=0
Rk28 (\19\:n20 \20\:n20) resistor r=0.4651 c=0
Rk6 (\14\:CKNb \15\:CKNb) resistor r=0.8559 c=0
Rk17 (\17\:CKNb \18\:CKNb) resistor r=0.347 c=0
Rk18 (\18\:CKNb \19\:CKNb) resistor r=0.1808 c=0
Rk19 (\18\:CKNb \21\:CKNb) resistor r=0.1683 c=0
Rk73 (\22\:CKNb \23\:CKNb) resistor r=0.8314 c=0
Rk34 (\6\:mout \7\:mout) resistor r=0.7682 c=0
Rk35 (\7\:mout \8\:mout) resistor r=0.3554 c=0
Rk36 (\8\:mout \9\:mout) resistor r=0.1724 c=0
Rk37 (\9\:mout \10\:mout) resistor r=0.3459 c=0
Rk38 (\7\:mout \12\:mout) resistor r=0.124 c=0
Rk39 (\8\:mout \14\:mout) resistor r=0.1005 c=0
Rk40 (\9\:mout \15\:mout) resistor r=0.5287 c=0
Rk41 (\15\:mout \17\:mout) resistor r=0.04499 c=0
Rk42 (\10\:mout \18\:mout) resistor r=0.4285 c=0
Rk43 (\15\:mout \20\:mout) resistor r=0.03476 c=0
Rk4 (\11\:RNb \12\:RNb) resistor r=0.1647 c=0
Rk5 (\12\:RNb \14\:RNb) resistor r=0.3836 c=0
Rk30 (\15\:RNb \16\:RNb) resistor r=0.3493 c=0
Rk10 (\11\:CKNbb \13\:CKNbb) resistor r=0.1431 c=0
Rk11 (\13\:CKNbb \14\:CKNbb) resistor r=0.4261 c=0
Rk12 (\14\:CKNbb \16\:CKNbb) resistor r=0.2381 c=0
Rk49 (\17\:CKNbb \18\:CKNbb) resistor r=0.3745 c=0
Rk44 (\5\:SEb \6\:SEb) resistor r=0.2187 c=0
Rk45 (\6\:SEb \7\:SEb) resistor r=0.3476 c=0
Rk46 (\6\:SEb \9\:SEb) resistor r=0.312 c=0
Rk50 (\7\:n35g \8\:n35g) resistor r=0.2755 c=0
Rk51 (\7\:n35g \10\:n35g) resistor r=0.6972 c=0
Rk62 (\12\:n35g \13\:n35g) resistor r=0.245 c=0
Rk63 (\13\:n35g \14\:n35g) resistor r=0.5703 c=0
Rk64 (\13\:n35g \16\:n35g) resistor r=0.4355 c=0
Rk59 (\15\:qbint \16\:qbint) resistor r=0.4987 c=0
Rk60 (\16\:qbint \18\:qbint) resistor r=0.5718 c=0
Rk61 (\16\:qbint \20\:qbint) resistor r=0.1475 c=0
Rk74 (\21\:qbint \22\:qbint) resistor r=0.2135 c=0
Rk65 (\5\:RTb \7\:RTb) resistor r=0.218 c=0
Rk66 (\7\:RTb \8\:RTb) resistor r=0.42 c=0
Rk67 (\8\:RTb \9\:RTb) resistor r=0.6944 c=0
Rk68 (\8\:RTb \11\:RTb) resistor r=0.3091 c=0
Rk80 (\6\:net573 \7\:net573) resistor r=0.2388 c=0
Rk81 (\7\:net573 \8\:net573) resistor r=0.1663 c=0
Rk82 (\7\:net573 \10\:net573) resistor r=0.2945 c=0
Rk47 (\5\:n35 \6\:n35) resistor r=0.4325 c=0
Rk48 (\6\:n35 \8\:n35) resistor r=0.3052 c=0
Rk52 (\10\:n35 \11\:n35) resistor r=0.4043 c=0
Rk53 (\11\:n35 \13\:n35) resistor r=0.3326 c=0
Rk78 (\15\:n35 \16\:n35) resistor r=0.3062 c=0
Rk79 (\16\:n35 \18\:n35) resistor r=0.2898 c=0
Rk25 (\2\:Db \4\:Db) resistor r=0.6409 c=0
Rk26 (\4\:Db \6\:Db) resistor r=1.3668 c=0
Rk27 (\6\:Db \8\:Db) resistor r=0.6396 c=0
Rk86 (\2\:n11 \4\:n11) resistor r=0.7195 c=0
Rk87 (\2\:n8 \4\:n8) resistor r=0.5345 c=0
Rk83 (\2\:n10 \4\:n10) resistor r=0.6308 c=0
Rk29 (\2\:n4 \4\:n4) resistor r=0.5568 c=0
Rl29 (\3\:SE \4\:SE) resistor r=294.192 c=0
Rl31 (\5\:SE \6\:SE) resistor r=241.873 c=0
Rl28 (\2\:SE \3\:SE) resistor r=49.6369 c=0
Rl30 (\2\:SE \5\:SE) resistor r=147.714 c=0
Rl27 (\1\:SE \2\:SE) resistor r=0.767 c=0
Rl18 (\2\:D \4\:D) resistor r=115.099 c=0
Rl16 (\1\:D \2\:D) resistor r=84.3295 c=0
Rl17 (\2\:D \3\:D) resistor r=5.1123 c=0
Rl14 (\2\:CKN \4\:CKN) resistor r=147.791 c=0
Rl12 (\1\:CKN \2\:CKN) resistor r=63.1757 c=0
Rl13 (\2\:CKN \3\:CKN) resistor r=2.0166 c=0
Rl1 (\1\:RN \2\:RN) resistor r=62.3411 c=0
Rl3 (\2\:RN \4\:RN) resistor r=152.726 c=0
Rl2 (\2\:RN \3\:RN) resistor r=0.6051 c=0
Rl56 (\7\:RT \8\:RT) resistor r=651.902 c=0
Rl43 (\1\:RT \2\:RT) resistor r=169.515 c=0
Rl46 (\4\:RT \6\:RT) resistor r=21.372 c=0
Rl45 (\4\:RT \5\:RT) resistor r=264.027 c=0
Rl44 (\3\:RT \4\:RT) resistor r=96.114 c=0
Rl26 (\2\:SI \3\:SI) resistor r=155.002 c=0
Rl25 (\1\:SI \2\:SI) resistor r=24.2328 c=0
Rl81 (\7\:SN \8\:SN) resistor r=237.735 c=0
Rl82 (\8\:SN \9\:SN) resistor r=491.014 c=0
Rl15 (\1\:SN \2\:SN) resistor r=24.2328 c=0
Rl59 (\4\:SN \6\:SN) resistor r=95.229 c=0
Rl57 (\3\:SN \4\:SN) resistor r=1129.61 c=0
Rl58 (\4\:SN \5\:SN) resistor r=14.5488 c=0
Rl21 (\6\:n20 \7\:n20) resistor r=136.213 c=0
Rl19 (\3\:n20 \4\:n20) resistor r=24.848 c=0
Rl20 (\4\:n20 \5\:n20) resistor r=281.721 c=0
Rl4 (n20 \2\:n20) resistor r=123.512 c=0
Rl62 (\12\:CKNb \13\:CKNb) resistor r=166.412 c=0
Rl8 (\2\:CKNb \4\:CKNb) resistor r=51.7181 c=0
Rl7 (\2\:CKNb \3\:CKNb) resistor r=216.019 c=0
Rl6 (CKNb \2\:CKNb) resistor r=132.176 c=0
Rl9 (\3\:CKNb \5\:CKNb) resistor r=330.626 c=0
Rl51 (\6\:CKNb \7\:CKNb) resistor r=66.1349 c=0
Rl54 (\7\:CKNb \10\:CKNb) resistor r=762.322 c=0
Rl55 (\8\:CKNb \11\:CKNb) resistor r=60.7265 c=0
Rl53 (\8\:CKNb \9\:CKNb) resistor r=81.3209 c=0
Rl52 (\7\:CKNb \8\:CKNb) resistor r=462.851 c=0
Rl10 (mout \2\:mout) resistor r=24.2328 c=0
Rl11 (\3\:mout \4\:mout) resistor r=24.2328 c=0
Rl67 (\3\:RNb \4\:RNb) resistor r=234.8 c=0
Rl24 (RNb \2\:RNb) resistor r=62.7075 c=0
Rl68 (\4\:RNb \5\:RNb) resistor r=1411.82 c=0
Rl71 (\5\:RNb \8\:RNb) resistor r=2.7666 c=0
Rl72 (\6\:RNb \9\:RNb) resistor r=75.8186 c=0
Rl70 (\6\:RNb \7\:RNb) resistor r=458.889 c=0
Rl69 (\5\:RNb \6\:RNb) resistor r=64.6153 c=0
Rl63 (\9\:CKNbb \10\:CKNbb) resistor r=870.726 c=0
Rl5 (CKNbb \2\:CKNbb) resistor r=138.16 c=0
Rl35 (\4\:CKNbb \7\:CKNbb) resistor r=127.816 c=0
Rl32 (\3\:CKNbb \4\:CKNbb) resistor r=349.798 c=0
Rl36 (\5\:CKNbb \8\:CKNbb) resistor r=128.908 c=0
Rl34 (\5\:CKNbb \6\:CKNbb) resistor r=84.3215 c=0
Rl33 (\4\:CKNbb \5\:CKNbb) resistor r=453.624 c=0
Rl22 (SEb \2\:SEb) resistor r=101.718 c=0
Rl23 (\2\:SEb \3\:SEb) resistor r=132.669 c=0
Rl39 (\3\:n35g \4\:n35g) resistor r=265.853 c=0
Rl38 (\2\:n35g \3\:n35g) resistor r=181.74 c=0
Rl40 (\2\:n35g \5\:n35g) resistor r=94.1963 c=0
Rl37 (n35g \2\:n35g) resistor r=2.4834 c=0
Rl73 (\6\:qbint \7\:qbint) resistor r=149.805 c=0
Rl78 (\11\:qbint \12\:qbint) resistor r=237.758 c=0
Rl80 (\13\:qbint \14\:qbint) resistor r=189.403 c=0
Rl50 (\3\:qbint \5\:qbint) resistor r=35.3072 c=0
Rl49 (\2\:qbint \4\:qbint) resistor r=70.093 c=0
Rl47 (qbint \2\:qbint) resistor r=112.732 c=0
Rl48 (\2\:qbint \3\:qbint) resistor r=152.601 c=0
Rl74 (\7\:qbint \8\:qbint) resistor r=99.804 c=0
Rl77 (\8\:qbint \11\:qbint) resistor r=180.657 c=0
Rl79 (\9\:qbint \13\:qbint) resistor r=95.4293 c=0
Rl76 (\9\:qbint \10\:qbint) resistor r=387.298 c=0
Rl75 (\8\:qbint \9\:qbint) resistor r=104.193 c=0
Rl42 (\3\:RTb \4\:RTb) resistor r=239.402 c=0
Rl41 (RTb \2\:RTb) resistor r=112.412 c=0
Rl65 (\2\:net573 \3\:net573) resistor r=67.5354 c=0
Rl66 (\2\:net573 \4\:net573) resistor r=64.1263 c=0
Rl64 (net573 \2\:net573) resistor r=3.1216 c=0
Rl60 (n35 \2\:n35) resistor r=508.667 c=0
Rl61 (\2\:n35 \3\:n35) resistor r=334.803 c=0
Rz20 (\1\:QN \2\:QN) resistor r=37.5 c=0
Rz25 (\1\:Q \2\:Q) resistor r=37.5 c=0
Rz28 (\1\:VSS \2\:VSS) resistor r=75 c=0
Rz29 (\9\:VSS \10\:VSS) resistor r=75 c=0
Rz30 (\11\:VSS \12\:VSS) resistor r=75 c=0
Rz31 (\13\:VSS \14\:VSS) resistor r=37.5 c=0
Rz34 (\15\:VSS \16\:VSS) resistor r=37.5 c=0
Rz35 (\26\:VSS \27\:VSS) resistor r=75 c=0
Rz36 (\28\:VSS \29\:VSS) resistor r=37.5 c=0
Rz37 (\30\:VSS \31\:VSS) resistor r=75 c=0
Rz38 (\32\:VSS \33\:VSS) resistor r=75 c=0
Rz39 (\34\:VSS \35\:VSS) resistor r=75 c=0
Rz40 (\36\:VSS \37\:VSS) resistor r=75 c=0
Rz1 (\8\:n20 \9\:n20) resistor r=75 c=0
Rz3 (\17\:n20 \18\:n20) resistor r=75 c=0
Rz5 (\16\:CKNb \17\:CKNb) resistor r=75 c=0
Rz10 (\11\:mout \12\:mout) resistor r=75 c=0
Rz11 (\13\:mout \14\:mout) resistor r=75 c=0
Rz2 (\13\:RNb \14\:RNb) resistor r=75 c=0
Rz4 (\15\:CKNbb \16\:CKNbb) resistor r=75 c=0
Rz12 (\4\:SEb \5\:SEb) resistor r=75 c=0
Rz14 (\9\:n35g \10\:n35g) resistor r=75 c=0
Rz18 (\11\:n35g \12\:n35g) resistor r=75 c=0
Rz17 (\19\:qbint \20\:qbint) resistor r=75 c=0
Rz19 (\10\:RTb \11\:RTb) resistor r=75 c=0
Rz22 (\5\:net573 \6\:net573) resistor r=75 c=0
Rz13 (\7\:n35 \8\:n35) resistor r=75 c=0
Rz15 (\12\:n35 \13\:n35) resistor r=75 c=0
Rz21 (\17\:n35 \18\:n35) resistor r=75 c=0
Rz6 (Db \2\:Db) resistor r=75 c=0
Rz7 (\7\:Db \8\:Db) resistor r=75 c=0
Rz26 (n8 \2\:n8) resistor r=75 c=0
Rz27 (\3\:n8 \4\:n8) resistor r=75 c=0
Rz23 (n10 \2\:n10) resistor r=75 c=0
Rz24 (\3\:n10 \4\:n10) resistor r=75 c=0
Rz8 (n4 \2\:n4) resistor r=75 c=0
Rz9 (\3\:n4 \4\:n4) resistor r=75 c=0
Ry21 (\4\:QN \5\:QN) resistor r=20.6667 c=0
Ry30 (\1\:VDD \2\:VDD) resistor r=62 c=0
Ry31 (\12\:VDD \13\:VDD) resistor r=20.6667 c=0
Ry32 (\14\:VDD \15\:VDD) resistor r=62 c=0
Ry33 (\16\:VDD \17\:VDD) resistor r=20.6667 c=0
Ry34 (\18\:VDD \19\:VDD) resistor r=62 c=0
Ry35 (\20\:VDD \21\:VDD) resistor r=62 c=0
Ry36 (\23\:VDD \24\:VDD) resistor r=62 c=0
Ry37 (\25\:VDD \26\:VDD) resistor r=62 c=0
Ry38 (\27\:VDD \28\:VDD) resistor r=62 c=0
Ry24 (\3\:Q \4\:Q) resistor r=20.6667 c=0
Ry15 (\1\:ExtVDD \2\:ExtVDD) resistor r=62 c=0
Ry16 (\1\:ExtVDD \5\:ExtVDD) resistor r=62 c=0
Ry17 (\1\:ExtVDD \6\:ExtVDD) resistor r=62 c=0
Ry27 (\3\:VSS \4\:VSS) resistor r=8.8571 c=0
Ry28 (\3\:VSS \6\:VSS) resistor r=5.1667 c=0
Ry29 (\3\:VSS \7\:VSS) resistor r=5.1667 c=0
Ry39 (\17\:VSS \18\:VSS) resistor r=8.8571 c=0
Ry40 (\17\:VSS \21\:VSS) resistor r=5.1667 c=0
Ry41 (\17\:VSS \25\:VSS) resistor r=5.1667 c=0
Ry1 (\10\:n20 \11\:n20) resistor r=62 c=0
Ry3 (\13\:n20 \14\:n20) resistor r=62 c=0
Ry5 (\20\:CKNb \21\:CKNb) resistor r=62 c=0
Ry8 (\5\:mout \6\:mout) resistor r=62 c=0
Ry9 (\16\:mout \17\:mout) resistor r=62 c=0
Ry10 (\19\:mout \20\:mout) resistor r=62 c=0
Ry2 (\10\:RNb \11\:RNb) resistor r=62 c=0
Ry4 (\12\:CKNbb \13\:CKNbb) resistor r=62 c=0
Ry11 (\8\:SEb \9\:SEb) resistor r=62 c=0
Ry13 (\6\:n35g \7\:n35g) resistor r=62 c=0
Ry19 (\15\:n35g \16\:n35g) resistor r=62 c=0
Ry18 (\17\:qbint \18\:qbint) resistor r=62 c=0
Ry20 (\6\:RTb \7\:RTb) resistor r=62 c=0
Ry23 (\9\:net573 \10\:net573) resistor r=62 c=0
Ry12 (\4\:n35 \5\:n35) resistor r=62 c=0
Ry14 (\9\:n35 \10\:n35) resistor r=62 c=0
Ry22 (\14\:n35 \15\:n35) resistor r=62 c=0
Ry6 (\3\:Db \4\:Db) resistor r=62 c=0
Ry7 (\5\:Db \6\:Db) resistor r=62 c=0
Ry25 (n11 \2\:n11) resistor r=62 c=0
Ry26 (\3\:n11 \4\:n11) resistor r=62 c=0
Rx20 (\1\:SE \7\:SE) resistor r=45 c=0
Rx14 (\3\:D \6\:D) resistor r=45 c=0
Rx10 (\3\:CKN \7\:CKN) resistor r=45 c=0
Rx1 (\3\:RN \5\:RN) resistor r=45 c=0
Rx33 (\3\:RT \9\:RT) resistor r=45 c=0
Rx34 (\1\:RT \10\:RT) resistor r=45 c=0
Rx35 (\7\:RT \11\:RT) resistor r=45 c=0
Rx19 (\2\:SI \4\:SI) resistor r=45 c=0
Rx12 (\5\:SN \10\:SN) resistor r=45 c=0
Rx13 (\2\:SN \11\:SN) resistor r=45 c=0
Rx36 (\3\:SN \12\:SN) resistor r=45 c=0
Rx37 (\9\:SN \13\:SN) resistor r=45 c=0
Rx2 (n20 \12\:n20) resistor r=45 c=0
Rx6 (\2\:n20 \15\:n20) resistor r=45 c=0
Rx7 (\5\:n20 \16\:n20) resistor r=45 c=0
Rx15 (\7\:n20 \19\:n20) resistor r=45 c=0
Rx16 (\4\:n20 \20\:n20) resistor r=45 c=0
Rx4 (\5\:CKNb \14\:CKNb) resistor r=45 c=0
Rx5 (\9\:CKNb \15\:CKNb) resistor r=45 c=0
Rx11 (\2\:CKNb \19\:CKNb) resistor r=45 c=0
Rx38 (\13\:CKNb \22\:CKNb) resistor r=45 c=0
Rx39 (\10\:CKNb \23\:CKNb) resistor r=45 c=0
Rx21 (\4\:mout \10\:mout) resistor r=45 c=0
Rx22 (\2\:mout \18\:mout) resistor r=45 c=0
Rx3 (\7\:RNb \12\:RNb) resistor r=45 c=0
Rx17 (\8\:RNb \15\:RNb) resistor r=45 c=0
Rx18 (\2\:RNb \16\:RNb) resistor r=45 c=0
Rx8 (\6\:CKNbb \11\:CKNbb) resistor r=45 c=0
Rx9 (\2\:CKNbb \14\:CKNbb) resistor r=45 c=0
Rx25 (\3\:CKNbb \17\:CKNbb) resistor r=45 c=0
Rx26 (\10\:CKNbb \18\:CKNbb) resistor r=45 c=0
Rx23 (\2\:SEb \7\:SEb) resistor r=45 c=0
Rx27 (\4\:n35g \8\:n35g) resistor r=45 c=0
Rx30 (n35g \14\:n35g) resistor r=45 c=0
Rx29 (\3\:qbint \15\:qbint) resistor r=45 c=0
Rx40 (\10\:qbint \21\:qbint) resistor r=45 c=0
Rx41 (qbint \22\:qbint) resistor r=45 c=0
Rx31 (\3\:RTb \5\:RTb) resistor r=45 c=0
Rx32 (RTb \9\:RTb) resistor r=45 c=0
Rx43 (net573 \8\:net573) resistor r=45 c=0
Rx24 (\3\:n35 \6\:n35) resistor r=45 c=0
Rx28 (\2\:n35 \11\:n35) resistor r=45 c=0
Rx42 (n35 \16\:n35) resistor r=45 c=0
mn30 (\3\:n4 \6\:SN \13\:VSS VSS) g45n1svt w=(1.45e-07) l=4.5e-08 nf=1 \
        as=2.32e-14 ad=4.858e-14 ps=6.1e-07 pd=9.6e-07 nrd=1.16667 \
        nrs=1.16667 sa=6.25e-07 sb=3.45e-07 sd=160n sca=8.42104 \
        scb=0.00632542 scc=0.000106623 m=(1)
mn12 (Db \3\:SEb n0 VSS) g45n1svt w=(1.45e-07) l=4.5e-08 nf=1 as=2.32e-14 \
        ad=8.7e-15 ps=6.1e-07 pd=4.1e-07 nrd=1.16667 nrs=1.16667 \
        sa=2.45e-07 sb=6.55e-07 sd=160n sca=8.85152 scb=0.00706865 \
        scc=0.000138481 m=(1)
mn14 (Db \6\:SE n2 VSS) g45n1svt w=(1.45e-07) l=4.5e-08 nf=1 as=8.7e-15 \
        ad=2.32e-14 ps=4.1e-07 pd=6.1e-07 nrd=1.16667 nrs=1.16667 \
        sa=4.5e-07 sb=4.5e-07 sd=160n sca=8.85152 scb=0.00706865 \
        scc=0.000138481 m=(1)
mn56 (\5\:net573 \14\:qbint \28\:VSS VSS) g45n1svt w=(1.45e-07) \
        l=4.5e-08 nf=1 as=2.03e-14 ad=4.365e-14 ps=5.7e-07 pd=9e-07 \
        nrd=1.16667 nrs=1.16667 sa=3.75e-07 sb=1.4e-07 sd=160n sca=9.33388 \
        scb=0.00788941 scc=0.00017958 m=(1)
mn52 (n10 \12\:qbint n8 VSS) g45n1svt w=(1.45e-07) l=4.5e-08 nf=1 \
        as=2.32e-14 ad=2.32e-14 ps=6.1e-07 pd=6.1e-07 nrd=1.16667 \
        nrs=1.16667 sa=3.45e-07 sb=3.45e-07 sd=160n sca=8.42104 \
        scb=0.00632542 scc=0.000106623 m=(1)
mn51 (n10 \3\:RNb \3\:n8 VSS) g45n1svt w=(1.45e-07) l=4.5e-08 nf=1 \
        as=2.32e-14 ad=2.03e-14 ps=6.1e-07 pd=5.7e-07 nrd=1.16667 \
        nrs=1.16667 sa=1.4e-07 sb=5.5e-07 sd=160n sca=8.42104 \
        scb=0.00632542 scc=0.000106623 m=(1)
mn13 (n2 \1\:SI \34\:VSS VSS) g45n1svt w=(1.45e-07) l=4.5e-08 nf=1 \
        as=2.32e-14 ad=8.7e-15 ps=6.1e-07 pd=4.1e-07 nrd=1.16667 \
        nrs=1.16667 sa=5.55e-07 sb=3.45e-07 sd=160n sca=8.85152 \
        scb=0.00706865 scc=0.000138481 m=(1)
mn32 (\13\:mout \6\:n20 \3\:n4 VSS) g45n1svt w=(1.45e-07) l=4.5e-08 nf=1 \
        as=2.03e-14 ad=2.32e-14 ps=5.7e-07 pd=6.1e-07 nrd=1.16667 \
        nrs=1.16667 sa=8.3e-07 sb=1.4e-07 sd=160n sca=8.42104 \
        scb=0.00632542 scc=0.000106623 m=(1)
mn22 (\13\:RNb \4\:RN \9\:VSS VSS) g45n1svt w=(1.45e-07) l=4.5e-08 nf=1 \
        as=2.03e-14 ad=2.03e-14 ps=5.7e-07 pd=5.7e-07 nrd=1.16667 \
        nrs=1.16667 sa=1.4e-07 sb=1.4e-07 sd=160n sca=8.42104 \
        scb=0.00632542 scc=0.000106623 m=(1)
mn25 (\7\:Db CKNbb \8\:n20 VSS) g45n1svt w=(1.45e-07) l=4.5e-08 nf=1 \
        as=2.03e-14 ad=2.03e-14 ps=5.7e-07 pd=5.7e-07 nrd=1.16667 \
        nrs=1.16667 sa=1.4e-07 sb=1.4e-07 sd=160n sca=8.0352 \
        scb=0.00565402 scc=8.19771e-05 m=(1)
mn36 (\17\:n20 \11\:CKNb n6 VSS) g45n1svt w=(1.45e-07) l=4.5e-08 nf=1 \
        as=8.7e-15 ad=2.03e-14 ps=4.1e-07 pd=5.7e-07 nrd=1.16667 \
        nrs=1.16667 sa=1.4e-07 sb=8.3e-07 sd=160n sca=8.42104 \
        scb=0.00632542 scc=0.000106623 m=(1)
mn21 (\15\:CKNbb CKNb \26\:VSS VSS) g45n1svt w=(1.45e-07) l=4.5e-08 nf=1 \
        as=2.32e-14 ad=2.03e-14 ps=6.1e-07 pd=5.7e-07 nrd=1.16667 \
        nrs=1.16667 sa=1.4e-07 sb=3.45e-07 sd=160n sca=8.0352 \
        scb=0.00565402 scc=8.19771e-05 m=(1)
mn35 (n6 \3\:mout \13\:VSS VSS) g45n1svt w=(1.45e-07) l=4.5e-08 nf=1 \
        as=4.858e-14 ad=8.7e-15 ps=9.6e-07 pd=4.1e-07 nrd=1.16667 \
        nrs=1.16667 sa=2.45e-07 sb=7.25e-07 sd=160n sca=8.42104 \
        scb=0.00632542 scc=0.000106623 m=(1)
mn20 (\16\:CKNb \1\:CKN \26\:VSS VSS) g45n1svt w=(1.45e-07) l=4.5e-08 \
        nf=1 as=2.32e-14 ad=2.03e-14 ps=6.1e-07 pd=5.7e-07 nrd=1.16667 \
        nrs=1.16667 sa=3.45e-07 sb=1.4e-07 sd=160n sca=8.0352 \
        scb=0.00565402 scc=8.19771e-05 m=(1)
mn11 (n0 \1\:D \36\:VSS VSS) g45n1svt w=(1.45e-07) l=4.5e-08 nf=1 \
        as=2.03e-14 ad=8.7e-15 ps=5.7e-07 pd=4.1e-07 nrd=1.16667 \
        nrs=1.16667 sa=1.4e-07 sb=7.6e-07 sd=160n sca=8.85152 \
        scb=0.00706865 scc=0.000138481 m=(1)
mn31 (\11\:mout RNb n4 VSS) g45n1svt w=(1.45e-07) l=4.5e-08 nf=1 \
        as=2.03e-14 ad=2.32e-14 ps=5.7e-07 pd=6.1e-07 nrd=1.16667 \
        nrs=1.16667 sa=1.4e-07 sb=3.45e-07 sd=160n sca=8.42104 \
        scb=0.00632542 scc=0.000106623 m=(1)
mn40 (\7\:n35 \6\:CKNb \11\:mout VSS) g45n1svt w=(1.45e-07) l=4.5e-08 \
        nf=1 as=2.32e-14 ad=2.03e-14 ps=6.1e-07 pd=5.7e-07 nrd=1.16667 \
        nrs=1.16667 sa=3.45e-07 sb=1.4e-07 sd=160n sca=8.42104 \
        scb=0.00632542 scc=0.000106623 m=(1)
mn10 (\4\:SEb \5\:SE \34\:VSS VSS) g45n1svt w=(1.45e-07) l=4.5e-08 nf=1 \
        as=2.32e-14 ad=2.03e-14 ps=6.1e-07 pd=5.7e-07 nrd=1.16667 \
        nrs=1.16667 sa=7.6e-07 sb=1.4e-07 sd=160n sca=8.85152 \
        scb=0.00706865 scc=0.000138481 m=(1)
NM0 (\9\:n35g \2\:RTb \12\:n35 VSS) g45n1svt w=(1.45e-07) l=4.5e-08 nf=1 \
        as=2.03e-14 ad=2.03e-14 ps=5.7e-07 pd=5.7e-07 nrd=1.16667 \
        nrs=1.16667 sa=1.4e-07 sb=1.4e-07 sd=160n sca=8.42104 \
        scb=0.00632542 scc=0.000106623 m=(1)
mn45 (\19\:qbint \5\:n35g \32\:VSS VSS) g45n1svt w=(1.45e-07) l=4.5e-08 \
        nf=1 as=2.03e-14 ad=2.03e-14 ps=5.7e-07 pd=5.7e-07 nrd=1.16667 \
        nrs=1.16667 sa=1.4e-07 sb=1.4e-07 sd=160n sca=9.33388 \
        scb=0.00788941 scc=0.00017958 m=(1)
NM3 (net0134 \5\:qbint \30\:VSS VSS) g45n1svt w=(1.45e-07) l=4.5e-08 \
        nf=1 as=2.03e-14 ad=8.7e-15 ps=5.7e-07 pd=4.1e-07 nrd=1.16667 \
        nrs=1.16667 sa=1.4e-07 sb=2.45e-07 sd=160n sca=9.33388 \
        scb=0.00788941 scc=0.00017958 m=(1)
NM1 (\10\:RTb \2\:RT \11\:VSS VSS) g45n1svt w=(1.45e-07) l=4.5e-08 nf=1 \
        as=2.03e-14 ad=2.03e-14 ps=5.7e-07 pd=5.7e-07 nrd=1.16667 \
        nrs=1.16667 sa=1.4e-07 sb=1.4e-07 sd=160n sca=8.42104 \
        scb=0.00632542 scc=0.000106623 m=(1)
NM2 (\11\:n35g \8\:RT net0134 VSS) g45n1svt w=(1.45e-07) l=4.5e-08 nf=1 \
        as=8.7e-15 ad=2.03e-14 ps=4.1e-07 pd=5.7e-07 nrd=1.16667 \
        nrs=1.16667 sa=2.45e-07 sb=1.4e-07 sd=160n sca=9.33388 \
        scb=0.00788941 scc=0.00017958 m=(1)
mn53 (\17\:n35 \9\:CKNbb \3\:n10 VSS) g45n1svt w=(1.45e-07) l=4.5e-08 \
        nf=1 as=2.03e-14 ad=2.03e-14 ps=5.7e-07 pd=5.7e-07 nrd=1.16667 \
        nrs=1.16667 sa=1.4e-07 sb=1.4e-07 sd=160n sca=8.42104 \
        scb=0.00632542 scc=0.000106623 m=(1)
mn50 (n8 \8\:SN \1\:VSS VSS) g45n1svt w=(1.45e-07) l=4.5e-08 nf=1 \
        as=2.03e-14 ad=2.32e-14 ps=5.7e-07 pd=6.1e-07 nrd=1.16667 \
        nrs=1.16667 sa=5.5e-07 sb=1.4e-07 sd=160n sca=8.42104 \
        scb=0.00632542 scc=0.000106623 m=(1)
mn57 (\1\:QN \4\:net573 \28\:VSS VSS) g45n1svt w=(2.6e-07) l=4.5e-08 \
        nf=1 as=4.365e-14 ad=3.64e-14 ps=9e-07 pd=8e-07 nrd=1.16667 \
        nrs=1.16667 sa=1.4e-07 sb=2.71058e-07 sd=160n sca=9.69565 \
        scb=0.00844644 scc=0.000275168 m=(1)
mn55 (\1\:Q \6\:qbint \15\:VSS VSS) g45n1svt w=(2.6e-07) l=4.5e-08 nf=1 \
        as=3.64e-14 ad=3.64e-14 ps=8e-07 pd=8e-07 nrd=1.16667 nrs=1.16667 \
        sa=1.4e-07 sb=1.4e-07 sd=160n sca=9.50447 scb=0.0081528 \
        scc=0.00025289 m=(1)
mp57 (\4\:QN \3\:net573 \16\:VDD VDD) g45p1svt w=(3.9e-07) l=4.5e-08 \
        nf=1 as=5.46e-14 ad=6.535e-14 ps=1.06e-06 pd=1.16e-06 nrd=1.16667 \
        nrs=1.16667 sa=1.4e-07 sb=2.69551e-07 sd=160n sca=38.4244 \
        scb=0.0401517 scc=0.00462137 m=(1)
mp55 (\3\:Q \7\:qbint \12\:VDD VDD) g45p1svt w=(3.9e-07) l=4.5e-08 nf=1 \
        as=5.46e-14 ad=5.46e-14 ps=1.06e-06 pd=1.06e-06 nrd=1.16667 \
        nrs=1.16667 sa=1.4e-07 sb=1.4e-07 sd=160n sca=20.1111 \
        scb=0.0190466 scc=0.00152507 m=(1)
ends SRDFFNSRX1
// End of subcircuit definition.
