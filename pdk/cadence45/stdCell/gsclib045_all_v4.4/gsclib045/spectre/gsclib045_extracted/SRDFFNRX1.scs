// Generated for: spectre (May  1 08:12:33 2013 )
// Library name: gsclib045
// Cell name: SRDFFNRX1
// View name: extracted

simulator lang=spectre

subckt SRDFFNRX1 CKN D ExtVDD Q QN RN RT SE SI VDD VSS
mp11 (n1 \4\:D \22\:VDD VDD) g45p1svt w=(2.15e-07) l=4.5e-08 nf=1 \
        as=1.362e-13 ad=1.29e-14 ps=2.93e-06 pd=5.5e-07 nrd=1.16667 \
        nrs=1.16667 sa=1.7e-07 sb=7.6e-07 sd=160n sca=15.238 scb=0.0153511 \
        scc=0.00103803 m=(1)
mp20 (\20\:CKNb \4\:CKN \22\:VDD VDD) g45p1svt w=(2.15e-07) l=4.5e-08 \
        nf=1 as=3.01e-14 ad=1.362e-13 ps=7.1e-07 pd=2.93e-06 nrd=1.16667 \
        nrs=1.16667 sa=3.45e-07 sb=1.4e-07 sd=160n sca=14.7851 \
        scb=0.0152025 scc=0.00103799 m=(1)
mp21 (\12\:CKNbb \4\:CKNb \22\:VDD VDD) g45p1svt w=(2.15e-07) l=4.5e-08 \
        nf=1 as=1.362e-13 ad=3.01e-14 ps=2.93e-06 pd=7.1e-07 nrd=1.16667 \
        nrs=1.16667 sa=1.4e-07 sb=3.45e-07 sd=160n sca=14.7851 \
        scb=0.0152025 scc=0.00103799 m=(1)
mp10 (\8\:SEb \3\:SE \15\:VDD VDD) g45p1svt w=(2.15e-07) l=4.5e-08 nf=1 \
        as=3.44e-14 ad=3.01e-14 ps=7.5e-07 pd=7.1e-07 nrd=1.16667 \
        nrs=1.16667 sa=7.9e-07 sb=1.4e-07 sd=160n sca=34.2363 \
        scb=0.0392303 scc=0.00368484 m=(1)
mp56 (\9\:net573 \13\:qbint \13\:VDD VDD) g45p1svt w=(2.15e-07) \
        l=4.5e-08 nf=1 as=3.01e-14 ad=6.535e-14 ps=7.1e-07 pd=1.16e-06 \
        nrd=1.16667 nrs=1.16667 sa=3.75e-07 sb=1.4e-07 sd=160n sca=18.0318 \
        scb=0.0190355 scc=0.000934132 m=(1)
mp22 (\8\:RNb \1\:RN \24\:VDD VDD) g45p1svt w=(2.15e-07) l=4.5e-08 nf=1 \
        as=3.01e-14 ad=3.01e-14 ps=7.1e-07 pd=7.1e-07 nrd=1.16667 \
        nrs=1.16667 sa=1.4e-07 sb=1.4e-07 sd=160n sca=16.7887 scb=0.018018 \
        scc=0.000709984 m=(1)
mp25 (\10\:n20 \3\:CKNb \5\:Db VDD) g45p1svt w=(2.15e-07) l=4.5e-08 nf=1 \
        as=3.01e-14 ad=3.01e-14 ps=7.1e-07 pd=7.1e-07 nrd=1.16667 \
        nrs=1.16667 sa=1.4e-07 sb=1.4e-07 sd=160n sca=16.6808 \
        scb=0.0167571 scc=0.00104234 m=(1)
mp36 (\13\:n20 \8\:CKNbb n7 VDD) g45p1svt w=(2.15e-07) l=4.5e-08 nf=1 \
        as=1.29e-14 ad=3.01e-14 ps=5.5e-07 pd=7.1e-07 nrd=1.16667 \
        nrs=1.16667 sa=1.4e-07 sb=2.95e-07 sd=160n sca=6.17959 \
        scb=0.00249724 scc=1.4077e-05 m=(1)
mp35 (n7 mout \20\:VDD VDD) g45p1svt w=(2.15e-07) l=4.5e-08 nf=1 \
        as=4.085e-14 ad=1.29e-14 ps=8.1e-07 pd=5.5e-07 nrd=1.16667 \
        nrs=1.16667 sa=2.45e-07 sb=1.9e-07 sd=160n sca=6.07861 \
        scb=0.00247604 scc=1.40748e-05 m=(1)
mp32 (\13\:mout \5\:n20 n5 VDD) g45p1svt w=(2.15e-07) l=4.5e-08 nf=1 \
        as=1.29e-14 ad=3.01e-14 ps=5.5e-07 pd=7.1e-07 nrd=1.16667 \
        nrs=1.16667 sa=1.4e-07 sb=2.45e-07 sd=160n sca=6.33666 \
        scb=0.00254331 scc=1.40857e-05 m=(1)
mp31 (n5 \7\:RNb \17\:VDD VDD) g45p1svt w=(2.15e-07) l=4.5e-08 nf=1 \
        as=3.01e-14 ad=1.29e-14 ps=7.1e-07 pd=5.5e-07 nrd=1.16667 \
        nrs=1.16667 sa=2.45e-07 sb=1.4e-07 sd=160n sca=6.67567 \
        scb=0.00270295 scc=1.41619e-05 m=(1)
mp12 (\3\:Db \4\:SE n1 VDD) g45p1svt w=(2.15e-07) l=4.5e-08 nf=1 \
        as=1.29e-14 ad=3.44e-14 ps=5.5e-07 pd=7.5e-07 nrd=1.16667 \
        nrs=1.16667 sa=2.75e-07 sb=6.55e-07 sd=160n sca=15.6684 \
        scb=0.0156302 scc=0.00103829 m=(1)
mp14 (\3\:Db SEb n3 VDD) g45p1svt w=(2.15e-07) l=4.5e-08 nf=1 as=1.29e-14 \
        ad=3.44e-14 ps=5.5e-07 pd=7.5e-07 nrd=1.16667 nrs=1.16667 \
        sa=4.8e-07 sb=4.5e-07 sd=160n sca=17.3611 scb=0.0177712 \
        scc=0.00105096 m=(1)
mp13 (n3 \3\:SI \15\:VDD VDD) g45p1svt w=(2.15e-07) l=4.5e-08 nf=1 \
        as=3.44e-14 ad=1.29e-14 ps=7.5e-07 pd=5.5e-07 nrd=1.16667 \
        nrs=1.16667 sa=5.85e-07 sb=3.45e-07 sd=160n sca=19.3151 \
        scb=0.0211393 scc=0.00112289 m=(1)
mp40 (\4\:n35 \7\:CKNbb \5\:mout VDD) g45p1svt w=(2.15e-07) l=4.5e-08 \
        nf=1 as=3.01e-14 ad=3.01e-14 ps=7.1e-07 pd=7.1e-07 nrd=1.16667 \
        nrs=1.16667 sa=1.4e-07 sb=1.4e-07 sd=160n sca=12.9771 \
        scb=0.0124914 scc=0.000301526 m=(1)
PM0 (\6\:n35g \5\:RT \9\:n35 ExtVDD) g45p1svt w=(2.15e-07) l=4.5e-08 nf=1 \
        as=3.01e-14 ad=3.01e-14 ps=7.1e-07 pd=7.1e-07 nrd=1.16667 \
        nrs=1.16667 sa=1.4e-07 sb=1.4e-07 sd=160n sca=26.0836 \
        scb=0.0271848 scc=0.00267095 m=(1)
mp45 (\17\:qbint \3\:n35g \1\:ExtVDD ExtVDD) g45p1svt w=(2.15e-07) \
        l=4.5e-08 nf=1 as=3.5882e-13 ad=3.01e-14 ps=3.6e-06 pd=7.1e-07 \
        nrd=1.16667 nrs=1.16667 sa=1.4e-07 sb=8.7e-07 sd=160n sca=25.2796 \
        scb=0.0259458 scc=0.00265434 m=(1)
PM2 (net234 \4\:qbint \1\:ExtVDD ExtVDD) g45p1svt w=(2.15e-07) l=4.5e-08 \
        nf=1 as=3.5882e-13 ad=1.29e-14 ps=3.6e-06 pd=5.5e-07 nrd=1.16667 \
        nrs=1.16667 sa=7.65e-07 sb=2.45e-07 sd=160n sca=14.5295 \
        scb=0.0144143 scc=0.000486924 m=(1)
PM1 (\6\:RTb \6\:RT \1\:ExtVDD ExtVDD) g45p1svt w=(2.15e-07) l=4.5e-08 \
        nf=1 as=3.5882e-13 ad=3.01e-14 ps=3.6e-06 pd=7.1e-07 nrd=1.16667 \
        nrs=1.16667 sa=3.3e-07 sb=1.4e-07 sd=160n sca=24.3731 \
        scb=0.0258873 scc=0.00229004 m=(1)
PM3 (\15\:n35g \4\:RTb net234 ExtVDD) g45p1svt w=(2.15e-07) l=4.5e-08 \
        nf=1 as=1.29e-14 ad=3.01e-14 ps=5.5e-07 pd=7.1e-07 nrd=1.16667 \
        nrs=1.16667 sa=8.7e-07 sb=1.4e-07 sd=160n sca=25.2796 \
        scb=0.0259458 scc=0.00265434 m=(1)
mp53 (\14\:n35 \12\:CKNb \3\:n11 VDD) g45p1svt w=(2.15e-07) l=4.5e-08 \
        nf=1 as=3.01e-14 ad=3.01e-14 ps=7.1e-07 pd=7.1e-07 nrd=1.16667 \
        nrs=1.16667 sa=1.4e-07 sb=1.4e-07 sd=160n sca=28.3325 \
        scb=0.0311878 scc=0.00281308 m=(1)
mp51 (n9 \2\:RNb \11\:VDD VDD) g45p1svt w=(2.15e-07) l=4.5e-08 nf=1 \
        as=3.01e-14 ad=1.29e-14 ps=7.1e-07 pd=5.5e-07 nrd=1.16667 \
        nrs=1.16667 sa=1.4e-07 sb=2.45e-07 sd=160n sca=11.272 \
        scb=0.00858882 scc=0.000167946 m=(1)
mp52 (n11 \11\:qbint n9 VDD) g45p1svt w=(2.15e-07) l=4.5e-08 nf=1 \
        as=1.29e-14 ad=3.01e-14 ps=5.5e-07 pd=7.1e-07 nrd=1.16667 \
        nrs=1.16667 sa=2.45e-07 sb=1.4e-07 sd=160n sca=11.4972 \
        scb=0.00902054 scc=0.000170728 m=(1)
C1 (ExtVDD VSS) capacitor c=2.22101e-16
C2 (RN VSS) capacitor c=8.14895e-17
C3 (RT VSS) capacitor c=2.13793e-17
C4 (SI VSS) capacitor c=5.24682e-17
C5 (Q VSS) capacitor c=6.19768e-17
C6 (VDD VSS) capacitor c=7.00199e-16
C7 (QN VSS) capacitor c=2.25485e-17
C8 (SE VSS) capacitor c=3.97056e-17
C9 (CKN VSS) capacitor c=3.89813e-17
C10 (D VSS) capacitor c=8.84608e-17
C11 (n20 VSS) capacitor c=3.898e-17
C12 (CKNb VSS) capacitor c=4.51387e-17
C13 (mout VSS) capacitor c=4.79505e-17
C14 (CKNbb VSS) capacitor c=3.41732e-17
C15 (RNb VSS) capacitor c=5.83879e-17
C16 (SEb VSS) capacitor c=7.78741e-17
C17 (n35g VSS) capacitor c=1.81054e-17
C18 (qbint VSS) capacitor c=4.47387e-17
C19 (RTb VSS) capacitor c=5.18691e-17
C20 (net573 VSS) capacitor c=2.25178e-17
C21 (n35 VSS) capacitor c=1.5169e-16
C22 (Db VSS) capacitor c=9.99999e-17
C23 (n11 VSS) capacitor c=6.41351e-17
C24 (n10 VSS) capacitor c=7.49536e-17
C25 (n1 VSS) capacitor c=1.02126e-18
C26 (\7\:qbint VSS) capacitor c=3.35414e-17
C27 (\11\:qbint VSS) capacitor c=1.20781e-16
C28 (\2\:RNb VSS) capacitor c=3.69885e-16
C29 (\13\:qbint VSS) capacitor c=4.44846e-17
C30 (\3\:net573 VSS) capacitor c=5.8881e-17
C31 (\12\:CKNb VSS) capacitor c=5.77647e-17
C32 (\4\:RTb VSS) capacitor c=9.92226e-17
C33 (\6\:RT VSS) capacitor c=2.3032e-17
C34 (\4\:qbint VSS) capacitor c=5.43131e-17
C35 (\3\:n35g VSS) capacitor c=5.41903e-17
C36 (\5\:RT VSS) capacitor c=7.12379e-17
C37 (\3\:SE VSS) capacitor c=7.71972e-17
C38 (\7\:CKNbb VSS) capacitor c=3.6035e-17
C39 (\3\:SI VSS) capacitor c=9.50254e-17
C40 (\4\:SE VSS) capacitor c=1.2412e-16
C41 (\7\:RNb VSS) capacitor c=5.99721e-17
C42 (\4\:D VSS) capacitor c=7.13996e-17
C43 (\5\:n20 VSS) capacitor c=9.57037e-17
C44 (\4\:CKN VSS) capacitor c=5.53782e-17
C45 (\4\:CKNb VSS) capacitor c=4.65772e-17
C46 (\8\:CKNbb VSS) capacitor c=8.16585e-17
C47 (\3\:CKNb VSS) capacitor c=1.13243e-16
C48 (\1\:RN VSS) capacitor c=4.16764e-17
C49 (\6\:qbint VSS) capacitor c=3.78771e-17
C50 (\12\:qbint VSS) capacitor c=5.85303e-17
C51 (\14\:qbint VSS) capacitor c=4.69939e-17
C52 (\4\:net573 VSS) capacitor c=3.68408e-17
C53 (\9\:CKNbb VSS) capacitor c=2.04725e-16
C54 (\8\:RT VSS) capacitor c=1.22653e-16
C55 (\2\:RT VSS) capacitor c=6.26006e-17
C56 (\5\:qbint VSS) capacitor c=3.89021e-17
C57 (\5\:n35g VSS) capacitor c=3.28666e-17
C58 (\2\:RTb VSS) capacitor c=5.21815e-17
C59 (\5\:SE VSS) capacitor c=5.82411e-17
C60 (\6\:CKNb VSS) capacitor c=3.55314e-17
C61 (\1\:SI VSS) capacitor c=4.92085e-17
C62 (\6\:SE VSS) capacitor c=8.72704e-17
C63 (\6\:RNb VSS) capacitor c=5.33002e-17
C64 (\3\:SEb VSS) capacitor c=6.68683e-17
C65 (\1\:D VSS) capacitor c=4.95201e-17
C66 (\3\:n20 VSS) capacitor c=4.43914e-17
C67 (\1\:CKN VSS) capacitor c=2.86971e-17
C68 (\3\:mout VSS) capacitor c=5.03273e-17
C69 (\11\:CKNb VSS) capacitor c=4.92799e-17
C70 (\4\:RN VSS) capacitor c=3.69315e-17
C71 (\13\:CKNb VSS) capacitor c=5.18101e-17
C72 (\10\:qbint VSS) capacitor c=8.57994e-17
C73 (\7\:RT VSS) capacitor c=1.54143e-16
C74 (\10\:CKNb VSS) capacitor c=1.68007e-16
C75 (\3\:RT VSS) capacitor c=5.06894e-17
C76 (\1\:RT VSS) capacitor c=5.25041e-17
C77 (\3\:RTb VSS) capacitor c=7.61699e-17
C78 (\3\:qbint VSS) capacitor c=4.46922e-17
C79 (\2\:n35 VSS) capacitor c=2.32481e-16
C80 (\4\:n35g VSS) capacitor c=6.72843e-17
C81 (\3\:CKNbb VSS) capacitor c=6.09633e-17
C82 (\10\:CKNbb VSS) capacitor c=2.18614e-16
C83 (\3\:n35 VSS) capacitor c=1.05907e-16
C84 (\1\:SE VSS) capacitor c=2.47163e-17
C85 (\2\:SI VSS) capacitor c=7.78927e-17
C86 (\2\:SEb VSS) capacitor c=7.74615e-17
C87 (\3\:D VSS) capacitor c=1.46878e-17
C88 (\6\:n20 VSS) capacitor c=8.12476e-17
C89 (\4\:n20 VSS) capacitor c=3.86271e-17
C90 (\3\:CKN VSS) capacitor c=2.41712e-17
C91 (\2\:mout VSS) capacitor c=3.17706e-17
C92 (\4\:mout VSS) capacitor c=3.93486e-17
C93 (\2\:CKNb VSS) capacitor c=8.09977e-17
C94 (\6\:CKNbb VSS) capacitor c=3.65744e-17
C95 (\7\:n20 VSS) capacitor c=5.40315e-17
C96 (\2\:CKNbb VSS) capacitor c=5.81726e-17
C97 (\5\:CKNb VSS) capacitor c=7.90839e-17
C98 (\9\:CKNb VSS) capacitor c=2.70725e-17
C99 (\5\:RNb VSS) capacitor c=1.20433e-16
C100 (\2\:n20 VSS) capacitor c=4.5975e-17
C101 (\3\:RN VSS) capacitor c=4.63064e-17
C102 (\1\:VDD VSS) capacitor c=4.93143e-17
C103 (\3\:Q VSS) capacitor c=8.18765e-17
C104 (\11\:VDD VSS) capacitor c=4.89264e-17
C105 (\9\:net573 VSS) capacitor c=5.57414e-17
C106 (\13\:VDD VSS) capacitor c=7.91073e-17
C107 (\3\:n11 VSS) capacitor c=9.94969e-17
C108 (\4\:QN VSS) capacitor c=6.75241e-17
C109 (\14\:n35 VSS) capacitor c=5.0162e-17
C110 (\15\:n35g VSS) capacitor c=5.59688e-17
C111 (\6\:RTb VSS) capacitor c=7.41463e-17
C112 (\1\:ExtVDD VSS) capacitor c=2.78478e-16
C113 (\9\:n35 VSS) capacitor c=6.2038e-17
C114 (\17\:qbint VSS) capacitor c=6.81663e-17
C115 (\6\:n35g VSS) capacitor c=9.61352e-17
C116 (\8\:SEb VSS) capacitor c=5.05757e-17
C117 (\4\:n35 VSS) capacitor c=6.13618e-17
C118 (\15\:VDD VSS) capacitor c=6.07516e-17
C119 (\5\:mout VSS) capacitor c=7.75493e-17
C120 (\3\:Db VSS) capacitor c=1.86193e-16
C121 (\17\:VDD VSS) capacitor c=3.84529e-17
C122 (\22\:VDD VSS) capacitor c=3.54122e-17
C123 (\13\:mout VSS) capacitor c=5.85555e-17
C124 (\20\:CKNb VSS) capacitor c=2.98845e-17
C125 (\20\:VDD VSS) capacitor c=4.11881e-17
C126 (\12\:CKNbb VSS) capacitor c=5.87832e-17
C127 (\13\:n20 VSS) capacitor c=6.43414e-17
C128 (\5\:Db VSS) capacitor c=2.2823e-16
C129 (\8\:RNb VSS) capacitor c=5.40084e-17
C130 (\10\:n20 VSS) capacitor c=6.3332e-17
C131 (\24\:VDD VSS) capacitor c=6.43661e-17
C132 (\1\:Q VSS) capacitor c=5.2658e-17
C133 (\5\:net573 VSS) capacitor c=4.31503e-17
C134 (\3\:n10 VSS) capacitor c=7.5774e-17
C135 (\1\:QN VSS) capacitor c=3.72481e-17
C136 (\17\:n35 VSS) capacitor c=4.13048e-17
C137 (\11\:n35g VSS) capacitor c=2.96646e-17
C138 (\10\:RTb VSS) capacitor c=5.81998e-17
C139 (\12\:n35 VSS) capacitor c=6.34736e-17
C140 (\19\:qbint VSS) capacitor c=2.43285e-17
C141 (\9\:n35g VSS) capacitor c=7.78734e-17
C142 (\4\:SEb VSS) capacitor c=3.82811e-17
C143 (\7\:n35 VSS) capacitor c=3.8411e-17
C144 (\11\:mout VSS) capacitor c=3.75393e-17
C145 (\15\:mout VSS) capacitor c=2.96821e-17
C146 (\16\:CKNb VSS) capacitor c=5.35775e-17
C147 (\15\:CKNbb VSS) capacitor c=5.89208e-17
C148 (\17\:n20 VSS) capacitor c=8.29512e-17
C149 (\7\:Db VSS) capacitor c=1.10483e-16
C150 (\11\:RNb VSS) capacitor c=7.08114e-17
C151 (\8\:n20 VSS) capacitor c=5.96542e-17
C152 (\2\:CKN VSS) capacitor c=3.53977e-17
C153 (\2\:D VSS) capacitor c=3.53004e-17
C154 (\2\:SE VSS) capacitor c=2.67073e-17
C155 (\4\:CKNbb VSS) capacitor c=1.49462e-16
C156 (\5\:CKNbb VSS) capacitor c=7.75673e-17
C157 (VDD VSS) capacitor c=2.24953e-16
C158 (\2\:n35g VSS) capacitor c=2.908e-17
C159 (\4\:RT VSS) capacitor c=5.38132e-17
C160 (\2\:qbint VSS) capacitor c=4.15535e-17
C161 (\7\:CKNb VSS) capacitor c=1.28175e-16
C162 (\8\:CKNb VSS) capacitor c=6.46518e-17
C163 (\2\:net573 VSS) capacitor c=1.52582e-17
C164 (\12\:n20 VSS) capacitor c=4.63583e-17
C165 (\3\:RNb VSS) capacitor c=2.92574e-16
C166 (\4\:RNb VSS) capacitor c=1.20159e-16
C167 (\10\:RNb VSS) capacitor c=1.20163e-16
C168 (\14\:CKNb VSS) capacitor c=1.55246e-16
C169 (\15\:CKNb VSS) capacitor c=1.37118e-16
C170 (\15\:n20 VSS) capacitor c=7.29014e-17
C171 (\16\:n20 VSS) capacitor c=9.20084e-17
C172 (\8\:qbint VSS) capacitor c=5.18339e-17
C173 (\9\:qbint VSS) capacitor c=7.91812e-17
C174 (\11\:CKNbb VSS) capacitor c=5.36585e-17
C175 (\14\:CKNbb VSS) capacitor c=8.16036e-17
C176 (\5\:CKN VSS) capacitor c=4.07493e-18
C177 (\6\:CKN VSS) capacitor c=2.80976e-17
C178 (\19\:n20 VSS) capacitor c=4.89141e-17
C179 (\20\:n20 VSS) capacitor c=4.82516e-17
C180 (\18\:CKNb VSS) capacitor c=6.98184e-17
C181 (\19\:CKNb VSS) capacitor c=4.28999e-17
C182 (\7\:mout VSS) capacitor c=8.39624e-17
C183 (\8\:mout VSS) capacitor c=5.32068e-17
C184 (\9\:mout VSS) capacitor c=1.96362e-17
C185 (\10\:mout VSS) capacitor c=7.49438e-17
C186 (\17\:mout VSS) capacitor c=7.30407e-17
C187 (\5\:SI VSS) capacitor c=3.47723e-17
C188 (\7\:SE VSS) capacitor c=5.2429e-17
C189 (\6\:n35 VSS) capacitor c=7.08674e-17
C190 (\6\:SEb VSS) capacitor c=8.28709e-17
C191 (\7\:SEb VSS) capacitor c=6.73388e-17
C192 (\17\:CKNbb VSS) capacitor c=3.49118e-17
C193 (\18\:CKNbb VSS) capacitor c=3.64742e-17
C194 (\8\:n35g VSS) capacitor c=3.4094e-17
C195 (\11\:n35 VSS) capacitor c=7.48701e-17
C196 (\15\:qbint VSS) capacitor c=8.77851e-17
C197 (\16\:qbint VSS) capacitor c=1.11935e-16
C198 (\13\:n35g VSS) capacitor c=1.04108e-16
C199 (\14\:n35g VSS) capacitor c=1.16164e-16
C200 (\5\:RTb VSS) capacitor c=4.92449e-17
C201 (\8\:RTb VSS) capacitor c=9.95941e-17
C202 (\9\:RTb VSS) capacitor c=9.09809e-17
C203 (\9\:RT VSS) capacitor c=1.05253e-16
C204 (\10\:RT VSS) capacitor c=1.1825e-16
C205 (\11\:RT VSS) capacitor c=3.81586e-17
C206 (\21\:qbint VSS) capacitor c=2.4301e-17
C207 (\22\:qbint VSS) capacitor c=2.98233e-17
C208 (\22\:CKNb VSS) capacitor c=9.4907e-17
C209 (\23\:CKNb VSS) capacitor c=1.00313e-16
C210 (\3\:QN VSS) capacitor c=3.37427e-17
C211 (\16\:n35 VSS) capacitor c=4.15463e-17
C212 (\7\:net573 VSS) capacitor c=5.64554e-17
C213 (\8\:net573 VSS) capacitor c=3.41404e-17
C214 (\3\:VDD VSS) capacitor c=5.13058e-17
C215 (\5\:VDD VSS) capacitor c=9.95955e-18
C216 (\6\:VDD VSS) capacitor c=1.39524e-16
C217 (\7\:VDD VSS) capacitor c=6.65792e-17
C218 (\8\:VDD VSS) capacitor c=2.35062e-17
C219 (\10\:VDD VSS) capacitor c=3.25114e-17
C220 (\19\:VDD VSS) capacitor c=6.25851e-17
Rk54 (ExtVDD ExtVDD) resistor r=0.002064 c=0
Rk52 (\2\:ExtVDD ExtVDD) resistor r=0.02218 c=0
Rk55 (ExtVDD \5\:ExtVDD) resistor r=0.02017 c=0
Rk56 (ExtVDD \6\:ExtVDD) resistor r=0.1498 c=0
Rk1 (\5\:RN RN) resistor r=0.006377 c=0
Rk67 (RT \9\:RT) resistor r=0.1843 c=0
Rk68 (\9\:RT \10\:RT) resistor r=0.6425 c=0
Rk69 (RT \11\:RT) resistor r=0.01481 c=0
Rk36 (SI \4\:SI) resistor r=0.01024 c=0
Rk40 (\5\:SI SI) resistor r=0.01024 c=0
Rk37 (\5\:SI \4\:SI) resistor r=0.001852 c=0
Rk81 (\2\:Q Q) resistor r=0.1644 c=0
Rk82 (Q \4\:Q) resistor r=0.3286 c=0
Rk101 (\2\:VDD \3\:VDD) resistor r=0.5774 c=0
Rk102 (\3\:VDD \5\:VDD) resistor r=0.06687 c=0
Rk104 (\6\:VDD VDD) resistor r=1.0527 c=0
Rk103 (\5\:VDD \6\:VDD) resistor r=0.05196 c=0
Rk105 (VDD \7\:VDD) resistor r=0.472 c=0
Rk106 (\7\:VDD \8\:VDD) resistor r=0.1859 c=0
Rk107 (\8\:VDD \10\:VDD) resistor r=0.1544 c=0
Rk108 (\3\:VDD \12\:VDD) resistor r=0.2936 c=0
Rk109 (\6\:VDD \14\:VDD) resistor r=0.3752 c=0
Rk110 (\7\:VDD \16\:VDD) resistor r=0.3672 c=0
Rk111 (\8\:VDD \18\:VDD) resistor r=0.2021 c=0
Rk115 (\19\:VDD VDD) resistor r=0.2926 c=0
Rk112 (\10\:VDD \19\:VDD) resistor r=0.1712 c=0
Rk113 (\19\:VDD \21\:VDD) resistor r=0.1995 c=0
Rk114 (\10\:VDD \23\:VDD) resistor r=0.2356 c=0
Rk116 (VDD \25\:VDD) resistor r=0.5018 c=0
Rk73 (\3\:QN QN) resistor r=0.02725 c=0
Rk72 (\2\:QN \3\:QN) resistor r=0.2037 c=0
Rk74 (\3\:QN \5\:QN) resistor r=0.3526 c=0
Rk41 (SE \7\:SE) resistor r=0.04325 c=0
Rk13 (CKN \5\:CKN) resistor r=0.002291 c=0
Rk16 (\5\:CKN \6\:CKN) resistor r=0.009863 c=0
Rk15 (\6\:CKN \7\:CKN) resistor r=0.007814 c=0
Rk84 (\2\:VSS \4\:VSS) resistor r=0.4615 c=0
Rk85 (\4\:VSS \5\:VSS) resistor r=0.1389 c=0
Rk86 (\5\:VSS \6\:VSS) resistor r=0.6727 c=0
Rk87 (\6\:VSS \7\:VSS) resistor r=0.1314 c=0
Rk89 (\8\:VSS VSS) resistor r=0.1213 c=0
Rk88 (\7\:VSS \8\:VSS) resistor r=0.0768 c=0
Rk90 (VSS \9\:VSS) resistor r=0.5216 c=0
Rk91 (\9\:VSS \10\:VSS) resistor r=0.3076 c=0
Rk92 (\10\:VSS \11\:VSS) resistor r=0.1637 c=0
Rk94 (\12\:VSS VSS) resistor r=0.2479 c=0
Rk93 (\11\:VSS \12\:VSS) resistor r=0.05942 c=0
Rk95 (\5\:VSS \14\:VSS) resistor r=0.2675 c=0
Rk96 (\6\:VSS \16\:VSS) resistor r=0.1897 c=0
Rk97 (\8\:VSS \18\:VSS) resistor r=0.1948 c=0
Rk98 (\9\:VSS \20\:VSS) resistor r=0.2539 c=0
Rk99 (\10\:VSS \22\:VSS) resistor r=0.2495 c=0
Rk100 (\12\:VSS \24\:VSS) resistor r=0.2371 c=0
Rk117 (\26\:VSS \28\:VSS) resistor r=0.4062 c=0
Rk118 (\28\:VSS \29\:VSS) resistor r=0.03955 c=0
Rk119 (\29\:VSS \30\:VSS) resistor r=0.7251 c=0
Rk121 (\31\:VSS VSS) resistor r=0.1985 c=0
Rk120 (\30\:VSS \31\:VSS) resistor r=0.1786 c=0
Rk122 (VSS \32\:VSS) resistor r=0.6905 c=0
Rk123 (\32\:VSS \33\:VSS) resistor r=0.3028 c=0
Rk125 (\34\:VSS VSS) resistor r=0.263 c=0
Rk124 (\33\:VSS \34\:VSS) resistor r=0.03955 c=0
Rk126 (VSS \36\:VSS) resistor r=0.4094 c=0
Rk127 (\29\:VSS \38\:VSS) resistor r=0.2469 c=0
Rk128 (\30\:VSS \40\:VSS) resistor r=0.2441 c=0
Rk129 (\32\:VSS \42\:VSS) resistor r=0.2405 c=0
Rk130 (\34\:VSS \44\:VSS) resistor r=0.2405 c=0
Rk21 (\5\:D D) resistor r=0.007212 c=0
Rk22 (D \6\:D) resistor r=0.007212 c=0
Rk24 (\5\:D \6\:D) resistor r=0.01654 c=0
Rk2 (\9\:n20 \11\:n20) resistor r=0.5445 c=0
Rk3 (\11\:n20 \12\:n20) resistor r=0.2548 c=0
Rk7 (\14\:n20 \15\:n20) resistor r=0.3464 c=0
Rk8 (\14\:n20 \16\:n20) resistor r=0.2522 c=0
Rk9 (\16\:n20 \18\:n20) resistor r=0.4755 c=0
Rk17 (\19\:n20 \20\:n20) resistor r=0.2141 c=0
Rk6 (\14\:CKNb \15\:CKNb) resistor r=0.8511 c=0
Rk18 (\17\:CKNb \18\:CKNb) resistor r=0.3237 c=0
Rk19 (\18\:CKNb \19\:CKNb) resistor r=0.1837 c=0
Rk20 (\18\:CKNb \21\:CKNb) resistor r=0.187 c=0
Rk71 (\22\:CKNb \23\:CKNb) resistor r=0.7625 c=0
Rk28 (\6\:mout \7\:mout) resistor r=0.6068 c=0
Rk29 (\7\:mout \8\:mout) resistor r=0.3642 c=0
Rk30 (\8\:mout \9\:mout) resistor r=0.1126 c=0
Rk31 (\9\:mout \10\:mout) resistor r=0.2019 c=0
Rk32 (\7\:mout \12\:mout) resistor r=0.135 c=0
Rk33 (\8\:mout \14\:mout) resistor r=0.5243 c=0
Rk34 (\9\:mout \16\:mout) resistor r=0.09768 c=0
Rk35 (\10\:mout \17\:mout) resistor r=0.4254 c=0
Rk10 (\11\:CKNbb \13\:CKNbb) resistor r=0.1424 c=0
Rk11 (\13\:CKNbb \14\:CKNbb) resistor r=0.4219 c=0
Rk12 (\14\:CKNbb \16\:CKNbb) resistor r=0.2368 c=0
Rk47 (\17\:CKNbb \18\:CKNbb) resistor r=0.3724 c=0
Rk4 (\9\:RNb \10\:RNb) resistor r=0.1928 c=0
Rk5 (\10\:RNb \12\:RNb) resistor r=0.3632 c=0
Rk44 (\5\:SEb \6\:SEb) resistor r=0.2175 c=0
Rk45 (\6\:SEb \7\:SEb) resistor r=0.3477 c=0
Rk46 (\6\:SEb \9\:SEb) resistor r=0.3105 c=0
Rk48 (\7\:n35g \8\:n35g) resistor r=0.274 c=0
Rk49 (\7\:n35g \10\:n35g) resistor r=0.6933 c=0
Rk60 (\12\:n35g \13\:n35g) resistor r=0.2436 c=0
Rk61 (\13\:n35g \14\:n35g) resistor r=0.567 c=0
Rk62 (\13\:n35g \16\:n35g) resistor r=0.4331 c=0
Rk57 (\15\:qbint \16\:qbint) resistor r=0.4959 c=0
Rk58 (\16\:qbint \18\:qbint) resistor r=0.5686 c=0
Rk59 (\16\:qbint \20\:qbint) resistor r=0.1467 c=0
Rk70 (\21\:qbint \22\:qbint) resistor r=0.2123 c=0
Rk63 (\5\:RTb \7\:RTb) resistor r=0.2168 c=0
Rk64 (\7\:RTb \8\:RTb) resistor r=0.4177 c=0
Rk65 (\8\:RTb \9\:RTb) resistor r=0.6904 c=0
Rk66 (\8\:RTb \11\:RTb) resistor r=0.3074 c=0
Rk77 (\6\:net573 \7\:net573) resistor r=0.2377 c=0
Rk78 (\7\:net573 \8\:net573) resistor r=0.1653 c=0
Rk79 (\7\:net573 \10\:net573) resistor r=0.2845 c=0
Rk42 (\5\:n35 \6\:n35) resistor r=0.4109 c=0
Rk43 (\6\:n35 \8\:n35) resistor r=0.2911 c=0
Rk50 (\10\:n35 \11\:n35) resistor r=0.402 c=0
Rk51 (\11\:n35 \13\:n35) resistor r=0.3308 c=0
Rk75 (\15\:n35 \16\:n35) resistor r=0.3071 c=0
Rk76 (\16\:n35 \18\:n35) resistor r=0.2882 c=0
Rk25 (\2\:Db \4\:Db) resistor r=0.638 c=0
Rk26 (\4\:Db \6\:Db) resistor r=1.3592 c=0
Rk27 (\6\:Db \8\:Db) resistor r=0.6337 c=0
Rk83 (\2\:n11 \4\:n11) resistor r=0.709 c=0
Rk80 (\2\:n10 \4\:n10) resistor r=0.6272 c=0
Rl1 (\1\:RN \2\:RN) resistor r=62.3411 c=0
Rl3 (\2\:RN \4\:RN) resistor r=152.726 c=0
Rl2 (\2\:RN \3\:RN) resistor r=0.6051 c=0
Rl54 (\7\:RT \8\:RT) resistor r=651.902 c=0
Rl41 (\1\:RT \2\:RT) resistor r=169.515 c=0
Rl44 (\4\:RT \6\:RT) resistor r=21.372 c=0
Rl43 (\4\:RT \5\:RT) resistor r=264.027 c=0
Rl42 (\3\:RT \4\:RT) resistor r=96.114 c=0
Rl24 (\2\:SI \3\:SI) resistor r=155.002 c=0
Rl23 (\1\:SI \2\:SI) resistor r=24.2328 c=0
Rl27 (\3\:SE \4\:SE) resistor r=294.192 c=0
Rl29 (\5\:SE \6\:SE) resistor r=241.873 c=0
Rl26 (\2\:SE \3\:SE) resistor r=49.6369 c=0
Rl28 (\2\:SE \5\:SE) resistor r=147.714 c=0
Rl25 (\1\:SE \2\:SE) resistor r=0.767 c=0
Rl14 (\2\:CKN \4\:CKN) resistor r=147.791 c=0
Rl12 (\1\:CKN \2\:CKN) resistor r=63.1757 c=0
Rl13 (\2\:CKN \3\:CKN) resistor r=2.0166 c=0
Rl20 (\2\:D \4\:D) resistor r=115.099 c=0
Rl18 (\1\:D \2\:D) resistor r=84.3295 c=0
Rl19 (\2\:D \3\:D) resistor r=5.1123 c=0
Rl16 (\5\:n20 \6\:n20) resistor r=190.564 c=0
Rl15 (\3\:n20 \4\:n20) resistor r=90.3645 c=0
Rl17 (\6\:n20 \7\:n20) resistor r=117.486 c=0
Rl4 (n20 \2\:n20) resistor r=123.512 c=0
Rl57 (\12\:CKNb \13\:CKNb) resistor r=137.716 c=0
Rl8 (\2\:CKNb \4\:CKNb) resistor r=63.2566 c=0
Rl7 (\2\:CKNb \3\:CKNb) resistor r=216.019 c=0
Rl6 (CKNb \2\:CKNb) resistor r=120.949 c=0
Rl9 (\3\:CKNb \5\:CKNb) resistor r=330.626 c=0
Rl49 (\6\:CKNb \7\:CKNb) resistor r=65.0422 c=0
Rl52 (\7\:CKNb \10\:CKNb) resistor r=808.345 c=0
Rl53 (\8\:CKNb \11\:CKNb) resistor r=60.7265 c=0
Rl51 (\8\:CKNb \9\:CKNb) resistor r=81.3209 c=0
Rl50 (\7\:CKNb \8\:CKNb) resistor r=416.829 c=0
Rl10 (mout \2\:mout) resistor r=24.2328 c=0
Rl11 (\3\:mout \4\:mout) resistor r=24.2328 c=0
Rl58 (\9\:CKNbb \10\:CKNbb) resistor r=870.726 c=0
Rl5 (CKNbb \2\:CKNbb) resistor r=138.16 c=0
Rl33 (\4\:CKNbb \7\:CKNbb) resistor r=127.816 c=0
Rl30 (\3\:CKNbb \4\:CKNbb) resistor r=395.821 c=0
Rl34 (\5\:CKNbb \8\:CKNbb) resistor r=128.908 c=0
Rl32 (\5\:CKNbb \6\:CKNbb) resistor r=84.3215 c=0
Rl31 (\4\:CKNbb \5\:CKNbb) resistor r=407.602 c=0
Rl62 (RNb \2\:RNb) resistor r=234.8 c=0
Rl63 (\2\:RNb \3\:RNb) resistor r=1469.68 c=0
Rl66 (\3\:RNb \6\:RNb) resistor r=180.888 c=0
Rl67 (\4\:RNb \7\:RNb) resistor r=75.8186 c=0
Rl65 (\4\:RNb \5\:RNb) resistor r=424.798 c=0
Rl64 (\3\:RNb \4\:RNb) resistor r=83.4088 c=0
Rl21 (SEb \2\:SEb) resistor r=101.718 c=0
Rl22 (\2\:SEb \3\:SEb) resistor r=132.669 c=0
Rl37 (\3\:n35g \4\:n35g) resistor r=265.853 c=0
Rl36 (\2\:n35g \3\:n35g) resistor r=181.74 c=0
Rl38 (\2\:n35g \5\:n35g) resistor r=94.1963 c=0
Rl35 (n35g \2\:n35g) resistor r=2.4834 c=0
Rl68 (\6\:qbint \7\:qbint) resistor r=149.805 c=0
Rl73 (\11\:qbint \12\:qbint) resistor r=237.758 c=0
Rl75 (\13\:qbint \14\:qbint) resistor r=189.403 c=0
Rl48 (\3\:qbint \5\:qbint) resistor r=35.3072 c=0
Rl47 (\2\:qbint \4\:qbint) resistor r=70.093 c=0
Rl45 (qbint \2\:qbint) resistor r=112.732 c=0
Rl46 (\2\:qbint \3\:qbint) resistor r=152.601 c=0
Rl69 (\7\:qbint \8\:qbint) resistor r=99.804 c=0
Rl72 (\8\:qbint \11\:qbint) resistor r=180.657 c=0
Rl74 (\9\:qbint \13\:qbint) resistor r=95.4293 c=0
Rl71 (\9\:qbint \10\:qbint) resistor r=387.298 c=0
Rl70 (\8\:qbint \9\:qbint) resistor r=104.193 c=0
Rl40 (\3\:RTb \4\:RTb) resistor r=239.402 c=0
Rl39 (RTb \2\:RTb) resistor r=112.412 c=0
Rl60 (\2\:net573 \3\:net573) resistor r=67.5354 c=0
Rl61 (\2\:net573 \4\:net573) resistor r=64.1263 c=0
Rl59 (net573 \2\:net573) resistor r=3.1216 c=0
Rl55 (n35 \2\:n35) resistor r=508.667 c=0
Rl56 (\2\:n35 \3\:n35) resistor r=380.826 c=0
Rz23 (\1\:Q \2\:Q) resistor r=37.5 c=0
Rz18 (\1\:QN \2\:QN) resistor r=37.5 c=0
Rz24 (\1\:VSS \2\:VSS) resistor r=37.5 c=0
Rz25 (\13\:VSS \14\:VSS) resistor r=37.5 c=0
Rz26 (\15\:VSS \16\:VSS) resistor r=75 c=0
Rz27 (\17\:VSS \18\:VSS) resistor r=75 c=0
Rz28 (\19\:VSS \20\:VSS) resistor r=75 c=0
Rz29 (\21\:VSS \22\:VSS) resistor r=75 c=0
Rz30 (\23\:VSS \24\:VSS) resistor r=75 c=0
Rz33 (\25\:VSS \26\:VSS) resistor r=75 c=0
Rz34 (\35\:VSS \36\:VSS) resistor r=75 c=0
Rz35 (\37\:VSS \38\:VSS) resistor r=75 c=0
Rz36 (\39\:VSS \40\:VSS) resistor r=75 c=0
Rz37 (\41\:VSS \42\:VSS) resistor r=75 c=0
Rz38 (\43\:VSS \44\:VSS) resistor r=75 c=0
Rz1 (\8\:n20 \9\:n20) resistor r=75 c=0
Rz3 (\17\:n20 \18\:n20) resistor r=75 c=0
Rz5 (\16\:CKNb \17\:CKNb) resistor r=75 c=0
Rz8 (\11\:mout \12\:mout) resistor r=75 c=0
Rz9 (\15\:mout \16\:mout) resistor r=75 c=0
Rz4 (\15\:CKNbb \16\:CKNbb) resistor r=75 c=0
Rz2 (\11\:RNb \12\:RNb) resistor r=75 c=0
Rz11 (\4\:SEb \5\:SEb) resistor r=75 c=0
Rz12 (\9\:n35g \10\:n35g) resistor r=75 c=0
Rz16 (\11\:n35g \12\:n35g) resistor r=75 c=0
Rz15 (\19\:qbint \20\:qbint) resistor r=75 c=0
Rz17 (\10\:RTb \11\:RTb) resistor r=75 c=0
Rz20 (\5\:net573 \6\:net573) resistor r=75 c=0
Rz10 (\7\:n35 \8\:n35) resistor r=75 c=0
Rz13 (\12\:n35 \13\:n35) resistor r=75 c=0
Rz19 (\17\:n35 \18\:n35) resistor r=75 c=0
Rz6 (Db \2\:Db) resistor r=75 c=0
Rz7 (\7\:Db \8\:Db) resistor r=75 c=0
Rz21 (n10 \2\:n10) resistor r=75 c=0
Rz22 (\3\:n10 \4\:n10) resistor r=75 c=0
Ry14 (\1\:ExtVDD \2\:ExtVDD) resistor r=62 c=0
Ry15 (\1\:ExtVDD \5\:ExtVDD) resistor r=62 c=0
Ry16 (\1\:ExtVDD \6\:ExtVDD) resistor r=62 c=0
Ry23 (\3\:Q \4\:Q) resistor r=20.6667 c=0
Ry29 (\1\:VDD \2\:VDD) resistor r=20.6667 c=0
Ry30 (\11\:VDD \12\:VDD) resistor r=62 c=0
Ry31 (\13\:VDD \14\:VDD) resistor r=20.6667 c=0
Ry32 (\15\:VDD \16\:VDD) resistor r=62 c=0
Ry33 (\17\:VDD \18\:VDD) resistor r=62 c=0
Ry34 (\20\:VDD \21\:VDD) resistor r=62 c=0
Ry35 (\22\:VDD \23\:VDD) resistor r=62 c=0
Ry36 (\24\:VDD \25\:VDD) resistor r=62 c=0
Ry20 (\4\:QN \5\:QN) resistor r=20.6667 c=0
Ry26 (\3\:VSS \4\:VSS) resistor r=8.8571 c=0
Ry27 (\3\:VSS \7\:VSS) resistor r=5.1667 c=0
Ry28 (\3\:VSS \11\:VSS) resistor r=5.1667 c=0
Ry37 (\27\:VSS \28\:VSS) resistor r=8.8571 c=0
Ry38 (\27\:VSS \31\:VSS) resistor r=5.1667 c=0
Ry39 (\27\:VSS \33\:VSS) resistor r=5.1667 c=0
Ry1 (\10\:n20 \11\:n20) resistor r=62 c=0
Ry3 (\13\:n20 \14\:n20) resistor r=62 c=0
Ry5 (\20\:CKNb \21\:CKNb) resistor r=62 c=0
Ry8 (\5\:mout \6\:mout) resistor r=62 c=0
Ry9 (\13\:mout \14\:mout) resistor r=62 c=0
Ry4 (\12\:CKNbb \13\:CKNbb) resistor r=62 c=0
Ry2 (\8\:RNb \9\:RNb) resistor r=62 c=0
Ry11 (\8\:SEb \9\:SEb) resistor r=62 c=0
Ry12 (\6\:n35g \7\:n35g) resistor r=62 c=0
Ry18 (\15\:n35g \16\:n35g) resistor r=62 c=0
Ry17 (\17\:qbint \18\:qbint) resistor r=62 c=0
Ry19 (\6\:RTb \7\:RTb) resistor r=62 c=0
Ry22 (\9\:net573 \10\:net573) resistor r=62 c=0
Ry10 (\4\:n35 \5\:n35) resistor r=62 c=0
Ry13 (\9\:n35 \10\:n35) resistor r=62 c=0
Ry21 (\14\:n35 \15\:n35) resistor r=62 c=0
Ry6 (\3\:Db \4\:Db) resistor r=62 c=0
Ry7 (\5\:Db \6\:Db) resistor r=62 c=0
Ry24 (n11 \2\:n11) resistor r=62 c=0
Ry25 (\3\:n11 \4\:n11) resistor r=62 c=0
Rx1 (\3\:RN \5\:RN) resistor r=45 c=0
Rx29 (\3\:RT \9\:RT) resistor r=45 c=0
Rx30 (\1\:RT \10\:RT) resistor r=45 c=0
Rx31 (\7\:RT \11\:RT) resistor r=45 c=0
Rx17 (\2\:SI \4\:SI) resistor r=45 c=0
Rx18 (\1\:SE \7\:SE) resistor r=45 c=0
Rx10 (\3\:CKN \7\:CKN) resistor r=45 c=0
Rx14 (\3\:D D) resistor r=45 c=0
Rx2 (n20 \12\:n20) resistor r=45 c=0
Rx6 (\2\:n20 \15\:n20) resistor r=45 c=0
Rx7 (\7\:n20 \16\:n20) resistor r=45 c=0
Rx11 (\6\:n20 \19\:n20) resistor r=45 c=0
Rx12 (\4\:n20 \20\:n20) resistor r=45 c=0
Rx4 (\5\:CKNb \14\:CKNb) resistor r=45 c=0
Rx5 (\9\:CKNb \15\:CKNb) resistor r=45 c=0
Rx13 (\2\:CKNb \19\:CKNb) resistor r=45 c=0
Rx34 (\13\:CKNb \22\:CKNb) resistor r=45 c=0
Rx35 (\10\:CKNb \23\:CKNb) resistor r=45 c=0
Rx15 (\4\:mout \10\:mout) resistor r=45 c=0
Rx16 (\2\:mout \17\:mout) resistor r=45 c=0
Rx8 (\6\:CKNbb \11\:CKNbb) resistor r=45 c=0
Rx9 (\2\:CKNbb \14\:CKNbb) resistor r=45 c=0
Rx21 (\3\:CKNbb \17\:CKNbb) resistor r=45 c=0
Rx22 (\10\:CKNbb \18\:CKNbb) resistor r=45 c=0
Rx3 (\5\:RNb \10\:RNb) resistor r=45 c=0
Rx20 (\2\:SEb \7\:SEb) resistor r=45 c=0
Rx23 (\4\:n35g \8\:n35g) resistor r=45 c=0
Rx26 (n35g \14\:n35g) resistor r=45 c=0
Rx25 (\3\:qbint \15\:qbint) resistor r=45 c=0
Rx32 (\10\:qbint \21\:qbint) resistor r=45 c=0
Rx33 (qbint \22\:qbint) resistor r=45 c=0
Rx27 (\3\:RTb \5\:RTb) resistor r=45 c=0
Rx28 (RTb \9\:RTb) resistor r=45 c=0
Rx37 (net573 \8\:net573) resistor r=45 c=0
Rx19 (\3\:n35 \6\:n35) resistor r=45 c=0
Rx24 (\2\:n35 \11\:n35) resistor r=45 c=0
Rx36 (n35 \16\:n35) resistor r=45 c=0
mn12 (Db \3\:SEb n0 VSS) g45n1svt w=(1.45e-07) l=4.5e-08 nf=1 as=2.32e-14 \
        ad=8.7e-15 ps=6.1e-07 pd=4.1e-07 nrd=1.16667 nrs=1.16667 \
        sa=2.45e-07 sb=6.55e-07 sd=160n sca=8.85152 scb=0.00706865 \
        scc=0.000138481 m=(1)
mn14 (Db \6\:SE n2 VSS) g45n1svt w=(1.45e-07) l=4.5e-08 nf=1 as=8.7e-15 \
        ad=2.32e-14 ps=4.1e-07 pd=6.1e-07 nrd=1.16667 nrs=1.16667 \
        sa=4.5e-07 sb=4.5e-07 sd=160n sca=8.85152 scb=0.00706865 \
        scc=0.000138481 m=(1)
mn35 (n6 \3\:mout \43\:VSS VSS) g45n1svt w=(1.45e-07) l=4.5e-08 nf=1 \
        as=2.32e-14 ad=8.7e-15 ps=6.1e-07 pd=4.1e-07 nrd=1.16667 \
        nrs=1.16667 sa=2.45e-07 sb=3.45e-07 sd=160n sca=8.42104 \
        scb=0.00632542 scc=0.000106623 m=(1)
mn56 (\5\:net573 \14\:qbint \13\:VSS VSS) g45n1svt w=(1.45e-07) \
        l=4.5e-08 nf=1 as=2.03e-14 ad=4.365e-14 ps=5.7e-07 pd=9e-07 \
        nrd=1.16667 nrs=1.16667 sa=3.75e-07 sb=1.4e-07 sd=160n sca=9.33388 \
        scb=0.00788941 scc=0.00017958 m=(1)
mn52 (n10 \12\:qbint \25\:VSS VSS) g45n1svt w=(1.45e-07) l=4.5e-08 nf=1 \
        as=2.03e-14 ad=2.32e-14 ps=5.7e-07 pd=6.1e-07 nrd=1.16667 \
        nrs=1.16667 sa=3.45e-07 sb=1.4e-07 sd=160n sca=8.42104 \
        scb=0.00632542 scc=0.000106623 m=(1)
mn51 (n10 RNb \37\:VSS VSS) g45n1svt w=(1.45e-07) l=4.5e-08 nf=1 \
        as=2.32e-14 ad=2.03e-14 ps=6.1e-07 pd=5.7e-07 nrd=1.16667 \
        nrs=1.16667 sa=1.4e-07 sb=3.45e-07 sd=160n sca=8.42104 \
        scb=0.00632542 scc=0.000106623 m=(1)
mn13 (n2 \1\:SI \19\:VSS VSS) g45n1svt w=(1.45e-07) l=4.5e-08 nf=1 \
        as=2.32e-14 ad=8.7e-15 ps=6.1e-07 pd=4.1e-07 nrd=1.16667 \
        nrs=1.16667 sa=5.55e-07 sb=3.45e-07 sd=160n sca=8.85152 \
        scb=0.00706865 scc=0.000138481 m=(1)
mn10 (\4\:SEb \5\:SE \19\:VSS VSS) g45n1svt w=(1.45e-07) l=4.5e-08 nf=1 \
        as=2.32e-14 ad=2.03e-14 ps=6.1e-07 pd=5.7e-07 nrd=1.16667 \
        nrs=1.16667 sa=7.6e-07 sb=1.4e-07 sd=160n sca=8.85152 \
        scb=0.00706865 scc=0.000138481 m=(1)
mn22 (\11\:RNb \4\:RN \35\:VSS VSS) g45n1svt w=(1.45e-07) l=4.5e-08 nf=1 \
        as=2.03e-14 ad=2.03e-14 ps=5.7e-07 pd=5.7e-07 nrd=1.16667 \
        nrs=1.16667 sa=1.4e-07 sb=1.4e-07 sd=160n sca=8.42104 \
        scb=0.00632542 scc=0.000106623 m=(1)
mn25 (\7\:Db CKNbb \8\:n20 VSS) g45n1svt w=(1.45e-07) l=4.5e-08 nf=1 \
        as=2.03e-14 ad=2.03e-14 ps=5.7e-07 pd=5.7e-07 nrd=1.16667 \
        nrs=1.16667 sa=1.4e-07 sb=1.4e-07 sd=160n sca=8.0352 \
        scb=0.00565402 scc=8.19771e-05 m=(1)
mn36 (\17\:n20 \11\:CKNb n6 VSS) g45n1svt w=(1.45e-07) l=4.5e-08 nf=1 \
        as=8.7e-15 ad=2.03e-14 ps=4.1e-07 pd=5.7e-07 nrd=1.16667 \
        nrs=1.16667 sa=1.4e-07 sb=4.5e-07 sd=160n sca=8.42104 \
        scb=0.00632542 scc=0.000106623 m=(1)
mn21 (\15\:CKNbb CKNb \23\:VSS VSS) g45n1svt w=(1.45e-07) l=4.5e-08 nf=1 \
        as=2.32e-14 ad=2.03e-14 ps=6.1e-07 pd=5.7e-07 nrd=1.16667 \
        nrs=1.16667 sa=1.4e-07 sb=3.45e-07 sd=160n sca=8.0352 \
        scb=0.00565402 scc=8.19771e-05 m=(1)
mn20 (\16\:CKNb \1\:CKN \23\:VSS VSS) g45n1svt w=(1.45e-07) l=4.5e-08 \
        nf=1 as=2.32e-14 ad=2.03e-14 ps=6.1e-07 pd=5.7e-07 nrd=1.16667 \
        nrs=1.16667 sa=3.45e-07 sb=1.4e-07 sd=160n sca=8.0352 \
        scb=0.00565402 scc=8.19771e-05 m=(1)
mn32 (\15\:mout \3\:n20 \43\:VSS VSS) g45n1svt w=(1.45e-07) l=4.5e-08 \
        nf=1 as=2.32e-14 ad=2.03e-14 ps=6.1e-07 pd=5.7e-07 nrd=1.16667 \
        nrs=1.16667 sa=4.5e-07 sb=1.4e-07 sd=160n sca=8.42104 \
        scb=0.00632542 scc=0.000106623 m=(1)
mn11 (n0 \1\:D \21\:VSS VSS) g45n1svt w=(1.45e-07) l=4.5e-08 nf=1 \
        as=2.03e-14 ad=8.7e-15 ps=5.7e-07 pd=4.1e-07 nrd=1.16667 \
        nrs=1.16667 sa=1.4e-07 sb=7.6e-07 sd=160n sca=8.85152 \
        scb=0.00706865 scc=0.000138481 m=(1)
mn31 (\11\:mout \6\:RNb \41\:VSS VSS) g45n1svt w=(1.45e-07) l=4.5e-08 \
        nf=1 as=2.03e-14 ad=2.32e-14 ps=5.7e-07 pd=6.1e-07 nrd=1.16667 \
        nrs=1.16667 sa=1.4e-07 sb=3.45e-07 sd=160n sca=8.42104 \
        scb=0.00632542 scc=0.000106623 m=(1)
mn40 (\7\:n35 \6\:CKNb \11\:mout VSS) g45n1svt w=(1.45e-07) l=4.5e-08 \
        nf=1 as=2.32e-14 ad=2.03e-14 ps=6.1e-07 pd=5.7e-07 nrd=1.16667 \
        nrs=1.16667 sa=3.45e-07 sb=1.4e-07 sd=160n sca=8.42104 \
        scb=0.00632542 scc=0.000106623 m=(1)
NM0 (\9\:n35g \2\:RTb \12\:n35 VSS) g45n1svt w=(1.45e-07) l=4.5e-08 nf=1 \
        as=2.03e-14 ad=2.03e-14 ps=5.7e-07 pd=5.7e-07 nrd=1.16667 \
        nrs=1.16667 sa=1.4e-07 sb=1.4e-07 sd=160n sca=8.42104 \
        scb=0.00632542 scc=0.000106623 m=(1)
mn45 (\19\:qbint \5\:n35g \17\:VSS VSS) g45n1svt w=(1.45e-07) l=4.5e-08 \
        nf=1 as=2.03e-14 ad=2.03e-14 ps=5.7e-07 pd=5.7e-07 nrd=1.16667 \
        nrs=1.16667 sa=1.4e-07 sb=1.4e-07 sd=160n sca=9.33388 \
        scb=0.00788941 scc=0.00017958 m=(1)
NM3 (net0134 \5\:qbint \15\:VSS VSS) g45n1svt w=(1.45e-07) l=4.5e-08 \
        nf=1 as=2.03e-14 ad=8.7e-15 ps=5.7e-07 pd=4.1e-07 nrd=1.16667 \
        nrs=1.16667 sa=1.4e-07 sb=2.45e-07 sd=160n sca=9.33388 \
        scb=0.00788941 scc=0.00017958 m=(1)
NM1 (\10\:RTb \2\:RT \39\:VSS VSS) g45n1svt w=(1.45e-07) l=4.5e-08 nf=1 \
        as=2.03e-14 ad=2.03e-14 ps=5.7e-07 pd=5.7e-07 nrd=1.16667 \
        nrs=1.16667 sa=1.4e-07 sb=1.4e-07 sd=160n sca=8.42104 \
        scb=0.00632542 scc=0.000106623 m=(1)
NM2 (\11\:n35g \8\:RT net0134 VSS) g45n1svt w=(1.45e-07) l=4.5e-08 nf=1 \
        as=8.7e-15 ad=2.03e-14 ps=4.1e-07 pd=5.7e-07 nrd=1.16667 \
        nrs=1.16667 sa=2.45e-07 sb=1.4e-07 sd=160n sca=9.33388 \
        scb=0.00788941 scc=0.00017958 m=(1)
mn53 (\17\:n35 \9\:CKNbb \3\:n10 VSS) g45n1svt w=(1.45e-07) l=4.5e-08 \
        nf=1 as=2.03e-14 ad=2.03e-14 ps=5.7e-07 pd=5.7e-07 nrd=1.16667 \
        nrs=1.16667 sa=1.4e-07 sb=1.4e-07 sd=160n sca=8.42104 \
        scb=0.00632542 scc=0.000106623 m=(1)
mn57 (\1\:QN \4\:net573 \13\:VSS VSS) g45n1svt w=(2.6e-07) l=4.5e-08 \
        nf=1 as=4.365e-14 ad=3.64e-14 ps=9e-07 pd=8e-07 nrd=1.16667 \
        nrs=1.16667 sa=1.4e-07 sb=2.71058e-07 sd=160n sca=9.69565 \
        scb=0.00844644 scc=0.000275168 m=(1)
mn55 (\1\:Q \6\:qbint \1\:VSS VSS) g45n1svt w=(2.6e-07) l=4.5e-08 nf=1 \
        as=3.64e-14 ad=3.64e-14 ps=8e-07 pd=8e-07 nrd=1.16667 nrs=1.16667 \
        sa=1.4e-07 sb=1.4e-07 sd=160n sca=9.50447 scb=0.0081528 \
        scc=0.00025289 m=(1)
mp57 (\4\:QN \3\:net573 \13\:VDD VDD) g45p1svt w=(3.9e-07) l=4.5e-08 \
        nf=1 as=5.46e-14 ad=6.535e-14 ps=1.06e-06 pd=1.16e-06 nrd=1.16667 \
        nrs=1.16667 sa=1.4e-07 sb=2.69551e-07 sd=160n sca=38.4244 \
        scb=0.0401517 scc=0.00462137 m=(1)
mp55 (\3\:Q \7\:qbint \1\:VDD VDD) g45p1svt w=(3.9e-07) l=4.5e-08 nf=1 \
        as=5.46e-14 ad=5.46e-14 ps=1.06e-06 pd=1.06e-06 nrd=1.16667 \
        nrs=1.16667 sa=1.4e-07 sb=1.4e-07 sd=160n sca=20.1111 \
        scb=0.0190466 scc=0.00152507 m=(1)
ends SRDFFNRX1
// End of subcircuit definition.
