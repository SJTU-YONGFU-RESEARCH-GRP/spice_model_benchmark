// Generated for: spectre (May  1 08:13:06 2013 )
// Library name: gsclib045
// Cell name: DFF4X2
// View name: extracted

simulator lang=spectre

subckt DFF4X2 CK D1 D2 D3 D4 Q1 Q1N Q2 Q2N Q3 Q3N Q4 Q4N VDD VSS
mp55 (\3\:Q1 qbint \34\:VDD VDD) g45p1svt w=(3.9e-07) l=4.5e-08 nf=1 \
        as=6.688e-14 ad=6.869e-14 ps=1.455e-06 pd=1.47e-06 nrd=1.16667 \
        nrs=1.16667 sa=1.03654e-07 sb=3.15e-07 sd=160n sca=30.5009 \
        scb=0.0202006 scc=0.00336097 m=(2)
PM19_1__rcx (\1\:Q2N qint_2 \28\:VDD VDD) g45p1svt w=(3.9e-07) l=4.5e-08 \
        nf=1 as=8.348e-14 ad=6.24e-14 ps=1.85e-06 pd=1.1e-06 nrd=1.16667 \
        nrs=1.16667 sa=1.2e-07 sb=4.54551e-07 sd=160n sca=30.5009 \
        scb=0.0202006 scc=0.00336097 m=(2)
mp57 (\1\:Q1N qint \37\:VDD VDD) g45p1svt w=(3.9e-07) l=4.5e-08 nf=1 \
        as=8.348e-14 ad=6.24e-14 ps=1.85e-06 pd=1.1e-06 nrd=1.16667 \
        nrs=1.16667 sa=1.2e-07 sb=4.54551e-07 sd=160n sca=39.514 \
        scb=0.0334743 scc=0.00392846 m=(2)
PM37 (\4\:Q3N qint_3 \12\:VDD VDD) g45p1svt w=(3.9e-07) l=4.5e-08 nf=1 \
        as=8.348e-14 ad=6.24e-14 ps=1.85e-06 pd=1.1e-06 nrd=1.16667 \
        nrs=1.16667 sa=2.49551e-07 sb=3.25e-07 sd=160n sca=30.5009 \
        scb=0.0202006 scc=0.00336097 m=(2)
PM17_1__rcx (\3\:Q2 qbint_2 \26\:VDD VDD) g45p1svt w=(3.9e-07) l=4.5e-08 \
        nf=1 as=6.688e-14 ad=6.869e-14 ps=1.455e-06 pd=1.47e-06 \
        nrd=1.16667 nrs=1.16667 sa=1.03654e-07 sb=3.15e-07 sd=160n \
        sca=30.5009 scb=0.0202006 scc=0.00336097 m=(2)
PM35_1__rcx (\3\:Q3 \7\:qbint_3 \15\:VDD VDD) g45p1svt w=(3.9e-07) \
        l=4.5e-08 nf=1 as=6.688e-14 ad=6.869e-14 ps=1.455e-06 pd=1.47e-06 \
        nrd=1.16667 nrs=1.16667 sa=1.03654e-07 sb=3.15e-07 sd=160n \
        sca=30.5009 scb=0.0202006 scc=0.00336097 m=(2)
PM38 (\4\:Q4N qint_4 \1\:VDD VDD) g45p1svt w=(3.9e-07) l=4.5e-08 nf=1 \
        as=8.348e-14 ad=6.24e-14 ps=1.85e-06 pd=1.1e-06 nrd=1.16667 \
        nrs=1.16667 sa=2.49551e-07 sb=3.25e-07 sd=160n sca=33.2136 \
        scb=0.0229892 scc=0.00337651 m=(2)
PM40_1__rcx (\3\:Q4 \7\:qbint_4 \6\:VDD VDD) g45p1svt w=(3.9e-07) \
        l=4.5e-08 nf=1 as=6.688e-14 ad=6.869e-14 ps=1.455e-06 pd=1.47e-06 \
        nrd=1.16667 nrs=1.16667 sa=1.03654e-07 sb=3.15e-07 sd=160n \
        sca=30.5009 scb=0.0202006 scc=0.00336097 m=(2)
C1 (CK VSS) capacitor c=4.68846e-17
C2 (VDD VSS) capacitor c=1.0922e-15
C3 (Q1N VSS) capacitor c=4.06552e-17
C4 (Q1 VSS) capacitor c=5.11329e-17
C5 (D1 VSS) capacitor c=3.31875e-17
C6 (Q2N VSS) capacitor c=2.57376e-17
C7 (Q2 VSS) capacitor c=5.39485e-17
C8 (D2 VSS) capacitor c=4.29312e-17
C9 (Q3N VSS) capacitor c=2.55542e-17
C10 (Q3 VSS) capacitor c=5.31046e-17
C11 (Q4N VSS) capacitor c=2.12719e-17
C12 (Q4 VSS) capacitor c=5.00804e-17
C13 (D4 VSS) capacitor c=3.54567e-17
C14 (CKb VSS) capacitor c=2.59997e-17
C15 (Ckbb VSS) capacitor c=5.34612e-17
C16 (qint VSS) capacitor c=1.44395e-16
C17 (qbint VSS) capacitor c=1.10646e-16
C18 (n8 VSS) capacitor c=2.18955e-18
C19 (n30 VSS) capacitor c=5.06612e-17
C20 (mout VSS) capacitor c=5.68379e-17
C21 (n20 VSS) capacitor c=2.65732e-17
C22 (n6 VSS) capacitor c=5.22432e-19
C23 (Db VSS) capacitor c=9.22468e-17
C24 (n11 VSS) capacitor c=1.91055e-18
C25 (n5 VSS) capacitor c=1.66244e-18
C26 (qint_2 VSS) capacitor c=1.83917e-16
C27 (qbint_2 VSS) capacitor c=1.30448e-16
C28 (n8_2 VSS) capacitor c=1.52675e-18
C29 (n30_2 VSS) capacitor c=4.991e-17
C30 (mout_2 VSS) capacitor c=5.68316e-17
C31 (n20_2 VSS) capacitor c=2.65618e-17
C32 (n6_2 VSS) capacitor c=5.22432e-19
C33 (Db_2 VSS) capacitor c=9.22798e-17
C34 (n11_2 VSS) capacitor c=1.32601e-18
C35 (n5_2 VSS) capacitor c=1.66244e-18
C36 (qint_3 VSS) capacitor c=1.82778e-16
C37 (qbint_3 VSS) capacitor c=2.63055e-17
C38 (n8_3 VSS) capacitor c=1.51986e-18
C39 (n30_3 VSS) capacitor c=4.98983e-17
C40 (mout_3 VSS) capacitor c=8.72747e-17
C41 (n20_3 VSS) capacitor c=4.06708e-17
C42 (n6_3 VSS) capacitor c=5.1413e-19
C43 (Db_3 VSS) capacitor c=9.21078e-17
C44 (n11_3 VSS) capacitor c=1.32601e-18
C45 (n5_3 VSS) capacitor c=1.66244e-18
C46 (qint_4 VSS) capacitor c=1.43238e-16
C47 (qbint_4 VSS) capacitor c=2.59268e-17
C48 (n8_4 VSS) capacitor c=2.1296e-18
C49 (n30_4 VSS) capacitor c=5.06166e-17
C50 (mout_4 VSS) capacitor c=8.72781e-17
C51 (n20_4 VSS) capacitor c=4.06729e-17
C52 (n6_4 VSS) capacitor c=5.1413e-19
C53 (Db_4 VSS) capacitor c=9.20403e-17
C54 (n11_4 VSS) capacitor c=1.9105e-18
C55 (n5_4 VSS) capacitor c=1.66244e-18
C56 (\5\:qbint_4 VSS) capacitor c=3.61538e-17
C57 (\4\:qbint_4 VSS) capacitor c=6.53431e-17
C58 (\27\:Ckbb VSS) capacitor c=4.62497e-17
C59 (\32\:CKb VSS) capacitor c=2.63962e-17
C60 (\28\:CKb VSS) capacitor c=5.79244e-17
C61 (\24\:Ckbb VSS) capacitor c=6.37898e-17
C62 (\1\:D4 VSS) capacitor c=2.99075e-17
C63 (\5\:qbint_3 VSS) capacitor c=3.92615e-17
C64 (\4\:qbint_3 VSS) capacitor c=6.80573e-17
C65 (\20\:Ckbb VSS) capacitor c=4.63411e-17
C66 (\25\:CKb VSS) capacitor c=2.63996e-17
C67 (\21\:CKb VSS) capacitor c=5.79244e-17
C68 (\17\:Ckbb VSS) capacitor c=6.38939e-17
C69 (\1\:D3 VSS) capacitor c=2.57529e-17
C70 (\1\:CK VSS) capacitor c=3.69332e-17
C71 (\18\:CKb VSS) capacitor c=3.61642e-17
C72 (\4\:D2 VSS) capacitor c=2.62229e-17
C73 (\12\:Ckbb VSS) capacitor c=6.38983e-17
C74 (\11\:CKb VSS) capacitor c=5.81525e-17
C75 (\4\:mout_2 VSS) capacitor c=8.81831e-17
C76 (\4\:n20_2 VSS) capacitor c=3.99264e-17
C77 (\8\:CKb VSS) capacitor c=2.60057e-17
C78 (\9\:Ckbb VSS) capacitor c=4.67348e-17
C79 (\10\:qbint_2 VSS) capacitor c=6.82241e-17
C80 (\9\:qbint_2 VSS) capacitor c=3.88708e-17
C81 (\4\:D1 VSS) capacitor c=2.87898e-17
C82 (\5\:Ckbb VSS) capacitor c=6.37504e-17
C83 (\4\:CKb VSS) capacitor c=5.81525e-17
C84 (\4\:mout VSS) capacitor c=8.81892e-17
C85 (\4\:n20 VSS) capacitor c=3.98723e-17
C86 (\2\:Ckbb VSS) capacitor c=4.66435e-17
C87 (\10\:qbint VSS) capacitor c=6.52687e-17
C88 (\9\:qbint VSS) capacitor c=3.60137e-17
C89 (\9\:qbint_4 VSS) capacitor c=2.60087e-17
C90 (\3\:n30_4 VSS) capacitor c=5.34485e-17
C91 (\3\:qbint_4 VSS) capacitor c=4.45915e-17
C92 (\30\:CKb VSS) capacitor c=8.39064e-17
C93 (\25\:Ckbb VSS) capacitor c=3.97624e-17
C94 (\4\:n20_4 VSS) capacitor c=4.61473e-17
C95 (\3\:mout_4 VSS) capacitor c=5.70674e-17
C96 (\23\:Ckbb VSS) capacitor c=6.38815e-17
C97 (\26\:CKb VSS) capacitor c=3.49466e-17
C98 (\4\:D4 VSS) capacitor c=4.5124e-17
C99 (\9\:qbint_3 VSS) capacitor c=2.97834e-17
C100 (\3\:n30_3 VSS) capacitor c=5.90085e-17
C101 (\3\:qbint_3 VSS) capacitor c=4.66775e-17
C102 (\23\:CKb VSS) capacitor c=8.39063e-17
C103 (\18\:Ckbb VSS) capacitor c=3.97472e-17
C104 (\4\:n20_3 VSS) capacitor c=4.61247e-17
C105 (\3\:mout_3 VSS) capacitor c=5.70409e-17
C106 (\16\:Ckbb VSS) capacitor c=6.38392e-17
C107 (\19\:CKb VSS) capacitor c=3.45131e-17
C108 (\4\:D3 VSS) capacitor c=4.04473e-17
C109 (\3\:CK VSS) capacitor c=4.24326e-17
C110 (\17\:CKb VSS) capacitor c=3.02908e-17
C111 (\3\:D2 VSS) capacitor c=3.69734e-17
C112 (\13\:CKb VSS) capacitor c=3.49679e-17
C113 (\13\:Ckbb VSS) capacitor c=6.42404e-17
C114 (\3\:n20_2 VSS) capacitor c=4.54287e-17
C115 (\10\:Ckbb VSS) capacitor c=3.97195e-17
C116 (\10\:CKb VSS) capacitor c=8.3037e-17
C117 (\13\:qbint_2 VSS) capacitor c=4.71189e-17
C118 (\3\:n30_2 VSS) capacitor c=5.86418e-17
C119 (\7\:qbint_2 VSS) capacitor c=2.99412e-17
C120 (\3\:D1 VSS) capacitor c=4.51981e-17
C121 (\6\:CKb VSS) capacitor c=3.4939e-17
C122 (\6\:Ckbb VSS) capacitor c=6.42967e-17
C123 (\3\:n20 VSS) capacitor c=4.53815e-17
C124 (\3\:Ckbb VSS) capacitor c=3.97297e-17
C125 (\3\:CKb VSS) capacitor c=8.3037e-17
C126 (\13\:qbint VSS) capacitor c=4.43965e-17
C127 (\3\:n30 VSS) capacitor c=5.30727e-17
C128 (\7\:qbint VSS) capacitor c=2.61776e-17
C129 (\2\:n30_4 VSS) capacitor c=4.63317e-17
C130 (\28\:Ckbb VSS) capacitor c=5.35955e-17
C131 (\26\:Ckbb VSS) capacitor c=2.07593e-17
C132 (\31\:CKb VSS) capacitor c=7.58059e-17
C133 (\3\:n20_4 VSS) capacitor c=2.62699e-17
C134 (\4\:mout_4 VSS) capacitor c=2.48223e-17
C135 (\29\:CKb VSS) capacitor c=2.79814e-17
C136 (\22\:Ckbb VSS) capacitor c=3.32917e-17
C137 (\27\:CKb VSS) capacitor c=3.41817e-17
C138 (\3\:D4 VSS) capacitor c=1.76455e-17
C139 (\2\:n30_3 VSS) capacitor c=4.63653e-17
C140 (\21\:Ckbb VSS) capacitor c=5.35955e-17
C141 (\19\:Ckbb VSS) capacitor c=2.05309e-17
C142 (\24\:CKb VSS) capacitor c=7.58049e-17
C143 (\3\:n20_3 VSS) capacitor c=2.62608e-17
C144 (\4\:mout_3 VSS) capacitor c=2.48223e-17
C145 (\22\:CKb VSS) capacitor c=2.78912e-17
C146 (\15\:Ckbb VSS) capacitor c=3.3297e-17
C147 (\20\:CKb VSS) capacitor c=3.39393e-17
C148 (\3\:D3 VSS) capacitor c=1.77737e-17
C149 (\2\:CK VSS) capacitor c=3.439e-17
C150 (\15\:CKb VSS) capacitor c=2.04394e-17
C151 (\1\:D2 VSS) capacitor c=1.78488e-17
C152 (\14\:CKb VSS) capacitor c=3.41151e-17
C153 (\14\:Ckbb VSS) capacitor c=3.29873e-17
C154 (\12\:CKb VSS) capacitor c=2.78752e-17
C155 (\3\:mout_2 VSS) capacitor c=2.48297e-17
C156 (\9\:CKb VSS) capacitor c=7.61019e-17
C157 (\11\:Ckbb VSS) capacitor c=2.05217e-17
C158 (\8\:Ckbb VSS) capacitor c=5.34588e-17
C159 (\12\:qbint_2 VSS) capacitor c=2.59294e-17
C160 (\2\:n30_2 VSS) capacitor c=4.62731e-17
C161 (\1\:D1 VSS) capacitor c=1.77798e-17
C162 (\7\:CKb VSS) capacitor c=3.41732e-17
C163 (\7\:Ckbb VSS) capacitor c=3.35053e-17
C164 (\5\:CKb VSS) capacitor c=2.81312e-17
C165 (\3\:mout VSS) capacitor c=2.48297e-17
C166 (\2\:CKb VSS) capacitor c=7.61125e-17
C167 (\4\:Ckbb VSS) capacitor c=2.07569e-17
C168 (\12\:qbint VSS) capacitor c=2.55507e-17
C169 (\2\:n30 VSS) capacitor c=4.62395e-17
C170 (\1\:VDD VSS) capacitor c=8.86547e-18
C171 (\4\:Q4N VSS) capacitor c=3.17883e-19
C172 (\7\:qint_4 VSS) capacitor c=2.3497e-17
C173 (\3\:Q4 VSS) capacitor c=4.53244e-17
C174 (\18\:qbint_4 VSS) capacitor c=4.36672e-17
C175 (\46\:VDD VSS) capacitor c=6.03911e-18
C176 (\6\:n30_4 VSS) capacitor c=4.89313e-17
C177 (\5\:mout_4 VSS) capacitor c=6.79869e-17
C178 (\48\:VDD VSS) capacitor c=3.03395e-17
C179 (\5\:n20_4 VSS) capacitor c=3.74348e-17
C180 (\50\:VDD VSS) capacitor c=3.50612e-17
C181 (\4\:Q3N VSS) capacitor c=6.85065e-19
C182 (\7\:qint_3 VSS) capacitor c=2.54727e-17
C183 (\3\:Q3 VSS) capacitor c=5.30255e-17
C184 (\18\:qbint_3 VSS) capacitor c=5.53235e-17
C185 (\60\:VDD VSS) capacitor c=3.12467e-17
C186 (\6\:n30_3 VSS) capacitor c=4.74869e-17
C187 (\5\:mout_3 VSS) capacitor c=6.80467e-17
C188 (\62\:VDD VSS) capacitor c=3.01909e-17
C189 (\5\:n20_3 VSS) capacitor c=3.74417e-17
C190 (\64\:VDD VSS) capacitor c=3.50856e-17
C191 (\56\:CKb VSS) capacitor c=3.63483e-17
C192 (\66\:VDD VSS) capacitor c=3.75352e-17
C193 (\44\:Ckbb VSS) capacitor c=1.17682e-16
C194 (\68\:VDD VSS) capacitor c=3.48856e-17
C195 (\9\:n20_2 VSS) capacitor c=3.82732e-17
C196 (\70\:VDD VSS) capacitor c=3.01909e-17
C197 (\9\:mout_2 VSS) capacitor c=6.84241e-17
C198 (\4\:n30_2 VSS) capacitor c=4.84092e-17
C199 (\72\:VDD VSS) capacitor c=3.12836e-17
C200 (\14\:qbint_2 VSS) capacitor c=5.51032e-17
C201 (\3\:Q2 VSS) capacitor c=5.31685e-17
C202 (\7\:qint_2 VSS) capacitor c=2.46778e-17
C203 (\1\:Q2N VSS) capacitor c=4.1911e-17
C204 (\82\:VDD VSS) capacitor c=3.50612e-17
C205 (\9\:n20 VSS) capacitor c=3.82661e-17
C206 (\84\:VDD VSS) capacitor c=3.03395e-17
C207 (\9\:mout VSS) capacitor c=6.83643e-17
C208 (\4\:n30 VSS) capacitor c=4.92795e-17
C209 (\86\:VDD VSS) capacitor c=6.13472e-18
C210 (\14\:qbint VSS) capacitor c=4.34469e-17
C211 (\3\:Q1 VSS) capacitor c=4.57972e-17
C212 (\7\:qint VSS) capacitor c=2.2708e-17
C213 (\1\:Q1N VSS) capacitor c=4.16445e-17
C214 (\3\:VDD VSS) capacitor c=1.37545e-16
C215 (\2\:Q4N VSS) capacitor c=1.53671e-17
C216 (\10\:qint_4 VSS) capacitor c=1.92466e-17
C217 (\1\:Q4 VSS) capacitor c=6.99612e-17
C218 (\20\:qbint_4 VSS) capacitor c=2.5605e-17
C219 (\8\:n30_4 VSS) capacitor c=5.98372e-17
C220 (\9\:mout_4 VSS) capacitor c=4.7077e-17
C221 (\8\:n20_4 VSS) capacitor c=5.61916e-17
C222 (\3\:Db_4 VSS) capacitor c=7.54907e-17
C223 (\2\:Q3N VSS) capacitor c=2.96956e-17
C224 (\10\:qint_3 VSS) capacitor c=2.36239e-17
C225 (\1\:Q3 VSS) capacitor c=8.41605e-17
C226 (\20\:qbint_3 VSS) capacitor c=3.4626e-17
C227 (\8\:n30_3 VSS) capacitor c=5.87849e-17
C228 (\9\:mout_3 VSS) capacitor c=4.69274e-17
C229 (\8\:n20_3 VSS) capacitor c=5.61917e-17
C230 (\3\:Db_3 VSS) capacitor c=7.73843e-17
C231 (\51\:CKb VSS) capacitor c=4.62022e-17
C232 (\42\:Ckbb VSS) capacitor c=4.07891e-17
C233 (\3\:Db_2 VSS) capacitor c=7.57983e-17
C234 (\5\:n20_2 VSS) capacitor c=5.70296e-17
C235 (\7\:mout_2 VSS) capacitor c=4.69236e-17
C236 (\8\:n30_2 VSS) capacitor c=5.74954e-17
C237 (\19\:qbint_2 VSS) capacitor c=3.4626e-17
C238 (\1\:Q2 VSS) capacitor c=8.51579e-17
C239 (\11\:qint_2 VSS) capacitor c=2.36239e-17
C240 (\4\:Q2N VSS) capacitor c=2.9111e-17
C241 (\3\:Db VSS) capacitor c=7.56825e-17
C242 (\5\:n20 VSS) capacitor c=5.70296e-17
C243 (\7\:mout VSS) capacitor c=4.69236e-17
C244 (\8\:n30 VSS) capacitor c=5.85477e-17
C245 (\19\:qbint VSS) capacitor c=2.5605e-17
C246 (\1\:Q1 VSS) capacitor c=7.0444e-17
C247 (\11\:qint VSS) capacitor c=1.91979e-17
C248 (\3\:Q1N VSS) capacitor c=1.52766e-17
C249 (\6\:qbint VSS) capacitor c=2.74617e-17
C250 (\11\:qbint VSS) capacitor c=4.19112e-17
C251 (\2\:n20 VSS) capacitor c=3.65493e-17
C252 (\2\:mout VSS) capacitor c=4.51139e-17
C253 (\2\:D1 VSS) capacitor c=1.89848e-17
C254 (\6\:qbint_2 VSS) capacitor c=3.12712e-17
C255 (\11\:qbint_2 VSS) capacitor c=4.19062e-17
C256 (\9\:qint VSS) capacitor c=2.59337e-17
C257 (\10\:qint VSS) capacitor c=3.61101e-17
C258 (\2\:n20_2 VSS) capacitor c=3.65493e-17
C259 (\2\:mout_2 VSS) capacitor c=4.51139e-17
C260 (\17\:qbint VSS) capacitor c=5.25527e-17
C261 (\18\:qbint VSS) capacitor c=4.78008e-17
C262 (\21\:qbint VSS) capacitor c=4.76106e-17
C263 (\6\:n30 VSS) capacitor c=7.2874e-17
C264 (\7\:n30 VSS) capacitor c=4.30279e-17
C265 (\2\:D2 VSS) capacitor c=1.85123e-17
C266 (\16\:CKb VSS) capacitor c=1.38364e-17
C267 (\5\:mout VSS) capacitor c=3.90081e-17
C268 (\6\:mout VSS) capacitor c=6.89236e-17
C269 (\7\:n20 VSS) capacitor c=4.96659e-17
C270 (\8\:n20 VSS) capacitor c=4.42232e-17
C271 (\2\:D3 VSS) capacitor c=1.95169e-17
C272 (\6\:D1 VSS) capacitor c=4.14802e-17
C273 (\2\:mout_3 VSS) capacitor c=4.46851e-17
C274 (\3\:Q2N VSS) capacitor c=3.78915e-17
C275 (\2\:n20_3 VSS) capacitor c=3.58959e-17
C276 (\9\:qint_2 VSS) capacitor c=2.68112e-17
C277 (\10\:qint_2 VSS) capacitor c=3.70129e-17
C278 (\2\:qbint_3 VSS) capacitor c=4.26718e-17
C279 (\17\:qbint_2 VSS) capacitor c=5.40736e-17
C280 (\18\:qbint_2 VSS) capacitor c=5.00148e-17
C281 (\21\:qbint_2 VSS) capacitor c=4.94073e-17
C282 (\6\:n30_2 VSS) capacitor c=7.40565e-17
C283 (\7\:n30_2 VSS) capacitor c=4.36817e-17
C284 (\6\:qbint_3 VSS) capacitor c=3.17478e-17
C285 (\7\:qbint_3 VSS) capacitor c=1.33358e-16
C286 (\5\:mout_2 VSS) capacitor c=3.90081e-17
C287 (\6\:mout_2 VSS) capacitor c=6.89236e-17
C288 (\7\:n20_2 VSS) capacitor c=4.96667e-17
C289 (\8\:n20_2 VSS) capacitor c=4.41828e-17
C290 (\2\:D4 VSS) capacitor c=1.90605e-17
C291 (\6\:D2 VSS) capacitor c=5.18848e-17
C292 (\2\:mout_4 VSS) capacitor c=4.46851e-17
C293 (\2\:n20_4 VSS) capacitor c=3.58959e-17
C294 (\5\:CK VSS) capacitor c=4.44502e-17
C295 (\5\:D3 VSS) capacitor c=4.12478e-17
C296 (\7\:D3 VSS) capacitor c=3.83595e-17
C297 (\2\:qbint_4 VSS) capacitor c=4.2911e-17
C298 (\7\:n20_3 VSS) capacitor c=4.96707e-17
C299 (\10\:n20_3 VSS) capacitor c=4.42288e-17
C300 (\7\:mout_3 VSS) capacitor c=6.8921e-17
C301 (\8\:mout_3 VSS) capacitor c=3.90385e-17
C302 (\6\:qbint_4 VSS) capacitor c=2.79939e-17
C303 (\7\:qbint_4 VSS) capacitor c=1.12643e-16
C304 (\4\:n30_3 VSS) capacitor c=4.35129e-17
C305 (\5\:n30_3 VSS) capacitor c=7.45119e-17
C306 (\14\:qbint_3 VSS) capacitor c=5.2157e-17
C307 (\16\:qbint_3 VSS) capacitor c=5.01516e-17
C308 (\17\:qbint_3 VSS) capacitor c=4.93783e-17
C309 (\9\:qint_3 VSS) capacitor c=2.70835e-17
C310 (\12\:qint_3 VSS) capacitor c=3.70672e-17
C311 (\1\:Q3N VSS) capacitor c=7.77859e-17
C312 (\5\:D4 VSS) capacitor c=3.97775e-17
C313 (\7\:n20_4 VSS) capacitor c=4.96699e-17
C314 (\10\:n20_4 VSS) capacitor c=4.42693e-17
C315 (\7\:mout_4 VSS) capacitor c=6.8921e-17
C316 (\8\:mout_4 VSS) capacitor c=3.90385e-17
C317 (\33\:CKb VSS) capacitor c=1.56896e-16
C318 (\34\:CKb VSS) capacitor c=1.00345e-16
C319 (\35\:CKb VSS) capacitor c=3.00375e-16
C320 (\36\:CKb VSS) capacitor c=3.06426e-16
C321 (\37\:CKb VSS) capacitor c=6.17673e-17
C322 (\38\:CKb VSS) capacitor c=1.42363e-16
C323 (\39\:CKb VSS) capacitor c=1.29885e-16
C324 (\40\:CKb VSS) capacitor c=1.24819e-16
C325 (\41\:CKb VSS) capacitor c=6.24448e-17
C326 (\42\:CKb VSS) capacitor c=3.0682e-16
C327 (\43\:CKb VSS) capacitor c=3.0283e-16
C328 (\44\:CKb VSS) capacitor c=1.00161e-16
C329 (\45\:CKb VSS) capacitor c=1.57286e-16
C330 (\46\:CKb VSS) capacitor c=8.68583e-17
C331 (\47\:CKb VSS) capacitor c=8.3712e-17
C332 (\48\:CKb VSS) capacitor c=8.68583e-17
C333 (\49\:CKb VSS) capacitor c=5.74072e-17
C334 (\50\:CKb VSS) capacitor c=1.0106e-16
C335 (\53\:CKb VSS) capacitor c=8.66976e-17
C336 (\54\:CKb VSS) capacitor c=8.37999e-17
C337 (\55\:CKb VSS) capacitor c=8.66976e-17
C338 (\29\:Ckbb VSS) capacitor c=1.21521e-16
C339 (\30\:Ckbb VSS) capacitor c=1.42619e-16
C340 (\31\:Ckbb VSS) capacitor c=3.11877e-16
C341 (\32\:Ckbb VSS) capacitor c=3.40419e-16
C342 (\33\:Ckbb VSS) capacitor c=1.73918e-16
C343 (\34\:Ckbb VSS) capacitor c=1.63324e-16
C344 (\35\:Ckbb VSS) capacitor c=1.303e-16
C345 (\36\:Ckbb VSS) capacitor c=3.39141e-16
C346 (\37\:Ckbb VSS) capacitor c=3.15441e-16
C347 (\38\:Ckbb VSS) capacitor c=1.41971e-16
C348 (\39\:Ckbb VSS) capacitor c=1.14562e-17
C349 (\40\:Ckbb VSS) capacitor c=1.21564e-16
C350 (\41\:Ckbb VSS) capacitor c=1.2032e-17
C351 (\46\:Ckbb VSS) capacitor c=1.15311e-17
C352 (\47\:Ckbb VSS) capacitor c=1.21096e-16
C353 (\48\:Ckbb VSS) capacitor c=1.20643e-17
C354 (\49\:Ckbb VSS) capacitor c=1.21095e-16
C355 (\4\:n30_4 VSS) capacitor c=4.28634e-17
C356 (\5\:n30_4 VSS) capacitor c=7.36739e-17
C357 (\14\:qbint_4 VSS) capacitor c=5.02842e-17
C358 (\16\:qbint_4 VSS) capacitor c=4.79434e-17
C359 (\17\:qbint_4 VSS) capacitor c=4.75815e-17
C360 (\9\:qint_4 VSS) capacitor c=2.62043e-17
C361 (\12\:qint_4 VSS) capacitor c=3.69582e-17
C362 (\1\:Q4N VSS) capacitor c=5.95904e-17
C363 (\6\:VDD VSS) capacitor c=3.57325e-17
C364 (\8\:VDD VSS) capacitor c=8.72383e-18
C365 (\10\:VDD VSS) capacitor c=4.50692e-17
C366 (\11\:VDD VSS) capacitor c=3.48603e-17
C367 (\12\:VDD VSS) capacitor c=8.67084e-17
C368 (\15\:VDD VSS) capacitor c=9.22402e-17
C369 (\17\:VDD VSS) capacitor c=3.41202e-17
C370 (\18\:VDD VSS) capacitor c=4.26457e-17
C371 (\20\:VDD VSS) capacitor c=1.83615e-17
C372 (\21\:VDD VSS) capacitor c=2.52151e-17
C373 (\22\:VDD VSS) capacitor c=1.30104e-17
C374 (\23\:VDD VSS) capacitor c=2.43039e-17
C375 (\25\:VDD VSS) capacitor c=2.86766e-17
C376 (\26\:VDD VSS) capacitor c=1.01354e-16
C377 (\28\:VDD VSS) capacitor c=8.91864e-17
C378 (\31\:VDD VSS) capacitor c=2.95409e-17
C379 (\32\:VDD VSS) capacitor c=5.37038e-17
C380 (\33\:VDD VSS) capacitor c=3.12292e-17
C381 (\34\:VDD VSS) capacitor c=2.93005e-17
C382 (\37\:VDD VSS) capacitor c=1.72554e-17
Rk53 (CK \5\:CK) resistor r=0.01178 c=0
Rk52 (\4\:CK \5\:CK) resistor r=0.004226 c=0
Rk209 (\1\:VSS \6\:VSS) resistor r=0.226 c=0
Rk211 (\6\:VSS \8\:VSS) resistor r=0.2109 c=0
Rk212 (\8\:VSS \9\:VSS) resistor r=0.1168 c=0
Rk213 (\9\:VSS \10\:VSS) resistor r=0.3375 c=0
Rk214 (\10\:VSS \11\:VSS) resistor r=0.3991 c=0
Rk215 (\11\:VSS \12\:VSS) resistor r=0.1482 c=0
Rk217 (\12\:VSS \14\:VSS) resistor r=0.1268 c=0
Rk218 (\14\:VSS \15\:VSS) resistor r=0.0992 c=0
Rk220 (\15\:VSS \17\:VSS) resistor r=0.2109 c=0
Rk221 (\17\:VSS \18\:VSS) resistor r=0.4543 c=0
Rk222 (\18\:VSS \19\:VSS) resistor r=0.2623 c=0
Rk223 (\19\:VSS \20\:VSS) resistor r=0.1368 c=0
Rk224 (\20\:VSS \21\:VSS) resistor r=0.2673 c=0
Rk226 (\22\:VSS VSS) resistor r=0.08641 c=0
Rk225 (\21\:VSS \22\:VSS) resistor r=0.2548 c=0
Rk227 (VSS \23\:VSS) resistor r=0.3127 c=0
Rk228 (\23\:VSS \24\:VSS) resistor r=0.1368 c=0
Rk229 (\24\:VSS \25\:VSS) resistor r=0.3175 c=0
Rk230 (\25\:VSS \26\:VSS) resistor r=0.2109 c=0
Rk232 (\26\:VSS \28\:VSS) resistor r=0.226 c=0
Rk234 (\28\:VSS \30\:VSS) resistor r=0.08666 c=0
Rk235 (\30\:VSS \31\:VSS) resistor r=0.06157 c=0
Rk236 (\31\:VSS \32\:VSS) resistor r=0.3991 c=0
Rk237 (\32\:VSS \33\:VSS) resistor r=0.4543 c=0
Rk238 (\33\:VSS \34\:VSS) resistor r=0.2109 c=0
Rk241 (\34\:VSS \37\:VSS) resistor r=0.226 c=0
Rk246 (\8\:VSS \47\:VSS) resistor r=0.04333 c=0
Rk247 (\10\:VSS \49\:VSS) resistor r=0.04333 c=0
Rk248 (\11\:VSS \51\:VSS) resistor r=0.04333 c=0
Rk253 (\17\:VSS \61\:VSS) resistor r=0.04333 c=0
Rk254 (\18\:VSS \63\:VSS) resistor r=0.04333 c=0
Rk255 (\20\:VSS \65\:VSS) resistor r=0.04333 c=0
Rk256 (\21\:VSS \67\:VSS) resistor r=0.0415 c=0
Rk257 (\22\:VSS \69\:VSS) resistor r=0.04333 c=0
Rk258 (\23\:VSS \71\:VSS) resistor r=0.04333 c=0
Rk259 (\25\:VSS \73\:VSS) resistor r=0.04333 c=0
Rk264 (\31\:VSS \83\:VSS) resistor r=0.04333 c=0
Rk265 (\32\:VSS \85\:VSS) resistor r=0.04333 c=0
Rk266 (\33\:VSS \87\:VSS) resistor r=0.04333 c=0
Rk146 (\1\:VDD \6\:VDD) resistor r=0.226 c=0
Rk148 (\6\:VDD \8\:VDD) resistor r=0.226 c=0
Rk149 (\8\:VDD \9\:VDD) resistor r=0.1017 c=0
Rk150 (\9\:VDD \10\:VDD) resistor r=0.2798 c=0
Rk151 (\10\:VDD \11\:VDD) resistor r=0.4568 c=0
Rk152 (\11\:VDD \12\:VDD) resistor r=0.1482 c=0
Rk154 (\12\:VDD \14\:VDD) resistor r=0.1268 c=0
Rk155 (\14\:VDD \15\:VDD) resistor r=0.0992 c=0
Rk157 (\15\:VDD \17\:VDD) resistor r=0.226 c=0
Rk158 (\17\:VDD \18\:VDD) resistor r=0.3815 c=0
Rk159 (\18\:VDD \19\:VDD) resistor r=0.32 c=0
Rk160 (\19\:VDD \20\:VDD) resistor r=0.1368 c=0
Rk161 (\20\:VDD \21\:VDD) resistor r=0.2661 c=0
Rk163 (\22\:VDD VDD) resistor r=0.08641 c=0
Rk162 (\21\:VDD \22\:VDD) resistor r=0.2561 c=0
Rk164 (VDD \23\:VDD) resistor r=0.3704 c=0
Rk165 (\23\:VDD \24\:VDD) resistor r=0.07913 c=0
Rk166 (\24\:VDD \25\:VDD) resistor r=0.3024 c=0
Rk167 (\25\:VDD \26\:VDD) resistor r=0.226 c=0
Rk169 (\26\:VDD \28\:VDD) resistor r=0.226 c=0
Rk171 (\28\:VDD \30\:VDD) resistor r=0.08666 c=0
Rk172 (\30\:VDD \31\:VDD) resistor r=0.06157 c=0
Rk173 (\31\:VDD \32\:VDD) resistor r=0.4568 c=0
Rk174 (\32\:VDD \33\:VDD) resistor r=0.3815 c=0
Rk175 (\33\:VDD \34\:VDD) resistor r=0.226 c=0
Rk178 (\34\:VDD \37\:VDD) resistor r=0.226 c=0
Rk183 (\8\:VDD \47\:VDD) resistor r=0.04333 c=0
Rk184 (\10\:VDD \49\:VDD) resistor r=0.04333 c=0
Rk185 (\11\:VDD \51\:VDD) resistor r=0.04333 c=0
Rk190 (\17\:VDD \61\:VDD) resistor r=0.04333 c=0
Rk191 (\18\:VDD \63\:VDD) resistor r=0.04333 c=0
Rk192 (\20\:VDD \65\:VDD) resistor r=0.04333 c=0
Rk193 (\21\:VDD \67\:VDD) resistor r=0.04333 c=0
Rk194 (\22\:VDD \69\:VDD) resistor r=0.04333 c=0
Rk195 (\23\:VDD \71\:VDD) resistor r=0.04333 c=0
Rk196 (\25\:VDD \73\:VDD) resistor r=0.04333 c=0
Rk201 (\31\:VDD \83\:VDD) resistor r=0.04333 c=0
Rk202 (\32\:VDD \85\:VDD) resistor r=0.04333 c=0
Rk203 (\33\:VDD \87\:VDD) resistor r=0.04333 c=0
Rk1 (\2\:Q1N Q1N) resistor r=0.2561 c=0
Rk2 (Q1N \4\:Q1N) resistor r=0.0741 c=0
Rk6 (\2\:Q1 Q1) resistor r=0.4294 c=0
Rk7 (Q1 \4\:Q1) resistor r=0.02514 c=0
Rk23 (\5\:D1 \6\:D1) resistor r=0.004716 c=0
Rk24 (\7\:D1 D1) resistor r=0.004801 c=0
Rk25 (\6\:D1 \7\:D1) resistor r=0.04416 c=0
Rk27 (\3\:Q2N Q2N) resistor r=0.005827 c=0
Rk26 (\2\:Q2N \3\:Q2N) resistor r=0.2799 c=0
Rk28 (\3\:Q2N \5\:Q2N) resistor r=0.2095 c=0
Rk32 (\2\:Q2 Q2) resistor r=0.431 c=0
Rk33 (Q2 \4\:Q2) resistor r=0.02345 c=0
Rk49 (\5\:D2 \6\:D2) resistor r=0.004716 c=0
Rk50 (\7\:D2 D2) resistor r=0.004801 c=0
Rk51 (\6\:D2 \7\:D2) resistor r=0.04416 c=0
Rk77 (Q3N \1\:Q3N) resistor r=0.006021 c=0
Rk78 (\1\:Q3N \3\:Q3N) resistor r=0.2095 c=0
Rk79 (\1\:Q3N \5\:Q3N) resistor r=0.2799 c=0
Rk72 (\2\:Q3 Q3) resistor r=0.4307 c=0
Rk73 (Q3 \4\:Q3) resistor r=0.02379 c=0
Rk54 (\5\:D3 \6\:D3) resistor r=0.004716 c=0
Rk55 (D3 \7\:D3) resistor r=0.00463 c=0
Rk56 (\5\:D3 \7\:D3) resistor r=0.04416 c=0
Rk141 (Q4N \1\:Q4N) resistor r=0.006021 c=0
Rk142 (\1\:Q4N \3\:Q4N) resistor r=0.2095 c=0
Rk143 (\1\:Q4N \5\:Q4N) resistor r=0.2799 c=0
Rk136 (\2\:Q4 Q4) resistor r=0.4307 c=0
Rk137 (Q4 \4\:Q4) resistor r=0.02379 c=0
Rk80 (\5\:D4 D4) resistor r=0.04389 c=0
Rk88 (\33\:CKb \34\:CKb) resistor r=0.8006 c=0
Rk89 (\34\:CKb \35\:CKb) resistor r=0.1871 c=0
Rk90 (\35\:CKb \36\:CKb) resistor r=2.0539 c=0
Rk91 (\36\:CKb \37\:CKb) resistor r=0.4468 c=0
Rk92 (\37\:CKb \38\:CKb) resistor r=0.1871 c=0
Rk93 (\38\:CKb \39\:CKb) resistor r=0.7023 c=0
Rk94 (\39\:CKb \40\:CKb) resistor r=0.5839 c=0
Rk95 (\40\:CKb \41\:CKb) resistor r=0.1871 c=0
Rk96 (\41\:CKb \42\:CKb) resistor r=0.4468 c=0
Rk97 (\42\:CKb \43\:CKb) resistor r=2.0539 c=0
Rk98 (\43\:CKb \44\:CKb) resistor r=0.1871 c=0
Rk99 (\44\:CKb \45\:CKb) resistor r=0.827 c=0
Rk100 (\35\:CKb \46\:CKb) resistor r=0.4672 c=0
Rk101 (\36\:CKb \47\:CKb) resistor r=0.3534 c=0
Rk102 (\38\:CKb \48\:CKb) resistor r=0.4672 c=0
Rk103 (\39\:CKb \49\:CKb) resistor r=0.2519 c=0
Rk104 (\49\:CKb \50\:CKb) resistor r=0.1893 c=0
Rk105 (\50\:CKb \52\:CKb) resistor r=0.2708 c=0
Rk106 (\40\:CKb \53\:CKb) resistor r=0.4616 c=0
Rk107 (\42\:CKb \54\:CKb) resistor r=0.3534 c=0
Rk108 (\43\:CKb \55\:CKb) resistor r=0.4616 c=0
Rk109 (\49\:CKb \57\:CKb) resistor r=0.1769 c=0
Rk110 (\29\:Ckbb \30\:Ckbb) resistor r=0.6674 c=0
Rk111 (\30\:Ckbb \31\:Ckbb) resistor r=0.502 c=0
Rk112 (\31\:Ckbb \32\:Ckbb) resistor r=1.9687 c=0
Rk113 (\32\:Ckbb \33\:Ckbb) resistor r=0.502 c=0
Rk114 (\33\:Ckbb \34\:Ckbb) resistor r=0.8529 c=0
Rk115 (\34\:Ckbb \35\:Ckbb) resistor r=0.5342 c=0
Rk116 (\35\:Ckbb \36\:Ckbb) resistor r=0.502 c=0
Rk117 (\36\:Ckbb \37\:Ckbb) resistor r=1.9687 c=0
Rk118 (\37\:Ckbb \38\:Ckbb) resistor r=0.502 c=0
Rk119 (\31\:Ckbb \39\:Ckbb) resistor r=0.04059 c=0
Rk120 (\32\:Ckbb \40\:Ckbb) resistor r=0.6656 c=0
Rk121 (\33\:Ckbb \41\:Ckbb) resistor r=0.04059 c=0
Rk122 (\34\:Ckbb \43\:Ckbb) resistor r=0.1914 c=0
Rk123 (\43\:Ckbb \45\:Ckbb) resistor r=0.3034 c=0
Rk124 (\35\:Ckbb \46\:Ckbb) resistor r=0.04059 c=0
Rk125 (\36\:Ckbb \47\:Ckbb) resistor r=0.6656 c=0
Rk126 (\37\:Ckbb \48\:Ckbb) resistor r=0.04059 c=0
Rk127 (\38\:Ckbb \49\:Ckbb) resistor r=0.6656 c=0
Rk3 (\8\:qint \9\:qint) resistor r=0.1677 c=0
Rk4 (\9\:qint \10\:qint) resistor r=0.1397 c=0
Rk5 (\9\:qint \12\:qint) resistor r=0.1175 c=0
Rk8 (\15\:qbint \16\:qbint) resistor r=0.3105 c=0
Rk9 (\16\:qbint \17\:qbint) resistor r=0.2274 c=0
Rk10 (\16\:qbint \18\:qbint) resistor r=0.04936 c=0
Rk11 (\18\:qbint \20\:qbint) resistor r=0.1382 c=0
Rk12 (\18\:qbint \21\:qbint) resistor r=0.1528 c=0
Rk13 (\5\:n30 \6\:n30) resistor r=0.2688 c=0
Rk14 (\6\:n30 \7\:n30) resistor r=0.1495 c=0
Rk15 (\6\:n30 \9\:n30) resistor r=0.392 c=0
Rk16 (\5\:mout \6\:mout) resistor r=0.1614 c=0
Rk17 (\6\:mout \8\:mout) resistor r=0.1669 c=0
Rk18 (\6\:mout \10\:mout) resistor r=0.2936 c=0
Rk19 (\6\:n20 \7\:n20) resistor r=0.3683 c=0
Rk20 (\7\:n20 \8\:n20) resistor r=0.1525 c=0
Rk21 (\7\:n20 \10\:n20) resistor r=0.2424 c=0
Rk22 (\2\:Db \4\:Db) resistor r=0.4759 c=0
Rk29 (\8\:qint_2 \9\:qint_2) resistor r=0.1677 c=0
Rk30 (\9\:qint_2 \10\:qint_2) resistor r=0.1397 c=0
Rk31 (\9\:qint_2 \12\:qint_2) resistor r=0.1175 c=0
Rk34 (\15\:qbint_2 \16\:qbint_2) resistor r=0.3105 c=0
Rk35 (\16\:qbint_2 \17\:qbint_2) resistor r=0.2274 c=0
Rk36 (\16\:qbint_2 \18\:qbint_2) resistor r=0.04936 c=0
Rk37 (\18\:qbint_2 \20\:qbint_2) resistor r=0.1382 c=0
Rk38 (\18\:qbint_2 \21\:qbint_2) resistor r=0.1528 c=0
Rk39 (\5\:n30_2 \6\:n30_2) resistor r=0.2688 c=0
Rk40 (\6\:n30_2 \7\:n30_2) resistor r=0.1495 c=0
Rk41 (\6\:n30_2 \9\:n30_2) resistor r=0.392 c=0
Rk42 (\5\:mout_2 \6\:mout_2) resistor r=0.1614 c=0
Rk43 (\6\:mout_2 \8\:mout_2) resistor r=0.1669 c=0
Rk44 (\6\:mout_2 \10\:mout_2) resistor r=0.2936 c=0
Rk45 (\6\:n20_2 \7\:n20_2) resistor r=0.3683 c=0
Rk46 (\7\:n20_2 \8\:n20_2) resistor r=0.1525 c=0
Rk47 (\7\:n20_2 \10\:n20_2) resistor r=0.2424 c=0
Rk48 (\2\:Db_2 \4\:Db_2) resistor r=0.4759 c=0
Rk74 (\8\:qint_3 \9\:qint_3) resistor r=0.1677 c=0
Rk75 (\9\:qint_3 \11\:qint_3) resistor r=0.1175 c=0
Rk76 (\9\:qint_3 \12\:qint_3) resistor r=0.1397 c=0
Rk67 (\14\:qbint_3 \15\:qbint_3) resistor r=0.2205 c=0
Rk68 (\15\:qbint_3 \16\:qbint_3) resistor r=0.06189 c=0
Rk69 (\16\:qbint_3 \17\:qbint_3) resistor r=0.1528 c=0
Rk70 (\15\:qbint_3 \19\:qbint_3) resistor r=0.306 c=0
Rk71 (\16\:qbint_3 \21\:qbint_3) resistor r=0.1382 c=0
Rk64 (\4\:n30_3 \5\:n30_3) resistor r=0.1495 c=0
Rk65 (\5\:n30_3 \7\:n30_3) resistor r=0.2688 c=0
Rk66 (\5\:n30_3 \9\:n30_3) resistor r=0.4139 c=0
Rk61 (\6\:mout_3 \7\:mout_3) resistor r=0.3339 c=0
Rk62 (\7\:mout_3 \8\:mout_3) resistor r=0.1614 c=0
Rk63 (\7\:mout_3 \10\:mout_3) resistor r=0.1669 c=0
Rk58 (\6\:n20_3 \7\:n20_3) resistor r=0.243 c=0
Rk59 (\7\:n20_3 \9\:n20_3) resistor r=0.3749 c=0
Rk60 (\7\:n20_3 \10\:n20_3) resistor r=0.1525 c=0
Rk57 (\2\:Db_3 \4\:Db_3) resistor r=0.4759 c=0
Rk138 (\8\:qint_4 \9\:qint_4) resistor r=0.1677 c=0
Rk139 (\9\:qint_4 \11\:qint_4) resistor r=0.1175 c=0
Rk140 (\9\:qint_4 \12\:qint_4) resistor r=0.1397 c=0
Rk131 (\14\:qbint_4 \15\:qbint_4) resistor r=0.2205 c=0
Rk132 (\15\:qbint_4 \16\:qbint_4) resistor r=0.06189 c=0
Rk133 (\16\:qbint_4 \17\:qbint_4) resistor r=0.1528 c=0
Rk134 (\15\:qbint_4 \19\:qbint_4) resistor r=0.306 c=0
Rk135 (\16\:qbint_4 \21\:qbint_4) resistor r=0.1382 c=0
Rk128 (\4\:n30_4 \5\:n30_4) resistor r=0.1495 c=0
Rk129 (\5\:n30_4 \7\:n30_4) resistor r=0.2688 c=0
Rk130 (\5\:n30_4 \9\:n30_4) resistor r=0.4139 c=0
Rk85 (\6\:mout_4 \7\:mout_4) resistor r=0.3339 c=0
Rk86 (\7\:mout_4 \8\:mout_4) resistor r=0.1614 c=0
Rk87 (\7\:mout_4 \10\:mout_4) resistor r=0.1669 c=0
Rk82 (\6\:n20_4 \7\:n20_4) resistor r=0.243 c=0
Rk83 (\7\:n20_4 \9\:n20_4) resistor r=0.3749 c=0
Rk84 (\7\:n20_4 \10\:n20_4) resistor r=0.1525 c=0
Rk81 (\2\:Db_4 \4\:Db_4) resistor r=0.4759 c=0
Rl74 (\1\:CK \2\:CK) resistor r=24.2328 c=0
Rl75 (\2\:CK \3\:CK) resistor r=58.8482 c=0
Rl35 (\2\:D1 \4\:D1) resistor r=46.9565 c=0
Rl34 (\2\:D1 \3\:D1) resistor r=120.033 c=0
Rl33 (\1\:D1 \2\:D1) resistor r=6.99 c=0
Rl70 (\2\:D2 \4\:D2) resistor r=46.9565 c=0
Rl69 (\2\:D2 \3\:D2) resistor r=120.033 c=0
Rl68 (\1\:D2 \2\:D2) resistor r=6.99 c=0
Rl76 (\1\:D3 \2\:D3) resistor r=46.9565 c=0
Rl78 (\2\:D3 \4\:D3) resistor r=120.033 c=0
Rl77 (\2\:D3 \3\:D3) resistor r=6.9867 c=0
Rl111 (\1\:D4 \2\:D4) resistor r=46.9565 c=0
Rl113 (\2\:D4 \4\:D4) resistor r=120.033 c=0
Rl112 (\2\:D4 \3\:D4) resistor r=6.9867 c=0
Rl127 (\31\:CKb \32\:CKb) resistor r=24.2328 c=0
Rl126 (\30\:CKb \31\:CKb) resistor r=193.029 c=0
Rl117 (\28\:CKb \29\:CKb) resistor r=41.5405 c=0
Rl114 (\26\:CKb \27\:CKb) resistor r=37.6944 c=0
Rl92 (\24\:CKb \25\:CKb) resistor r=24.2328 c=0
Rl91 (\23\:CKb \24\:CKb) resistor r=193.029 c=0
Rl82 (\21\:CKb \22\:CKb) resistor r=41.5405 c=0
Rl79 (\19\:CKb \20\:CKb) resistor r=37.6944 c=0
Rl67 (\13\:CKb \14\:CKb) resistor r=37.6944 c=0
Rl64 (\11\:CKb \12\:CKb) resistor r=41.5405 c=0
Rl56 (\8\:CKb \9\:CKb) resistor r=24.2328 c=0
Rl57 (\9\:CKb \10\:CKb) resistor r=193.029 c=0
Rl32 (\6\:CKb \7\:CKb) resistor r=37.6944 c=0
Rl29 (\4\:CKb \5\:CKb) resistor r=41.5405 c=0
Rl21 (CKb \2\:CKb) resistor r=24.2328 c=0
Rl22 (\2\:CKb \3\:CKb) resistor r=193.029 c=0
Rl73 (\16\:CKb \18\:CKb) resistor r=64.2642 c=0
Rl72 (\16\:CKb \17\:CKb) resistor r=37.3411 c=0
Rl71 (\15\:CKb \16\:CKb) resistor r=1.2334 c=0
Rl116 (\23\:Ckbb \24\:Ckbb) resistor r=195.72 c=0
Rl81 (\16\:Ckbb \17\:Ckbb) resistor r=195.72 c=0
Rl65 (\12\:Ckbb \13\:Ckbb) resistor r=195.72 c=0
Rl30 (\5\:Ckbb \6\:Ckbb) resistor r=195.72 c=0
Rl125 (\27\:Ckbb \28\:Ckbb) resistor r=38.4387 c=0
Rl124 (\25\:Ckbb \26\:Ckbb) resistor r=66.0764 c=0
Rl115 (\22\:Ckbb \23\:Ckbb) resistor r=26.1559 c=0
Rl90 (\20\:Ckbb \21\:Ckbb) resistor r=38.4387 c=0
Rl89 (\18\:Ckbb \19\:Ckbb) resistor r=66.0764 c=0
Rl80 (\15\:Ckbb \16\:Ckbb) resistor r=26.1559 c=0
Rl66 (\13\:Ckbb \14\:Ckbb) resistor r=26.1559 c=0
Rl55 (\10\:Ckbb \11\:Ckbb) resistor r=66.0764 c=0
Rl54 (\8\:Ckbb \9\:Ckbb) resistor r=38.4387 c=0
Rl31 (\6\:Ckbb \7\:Ckbb) resistor r=26.1559 c=0
Rl20 (\3\:Ckbb \4\:Ckbb) resistor r=66.0764 c=0
Rl19 (Ckbb \2\:Ckbb) resistor r=38.4387 c=0
Rl10 (\6\:qbint qbint) resistor r=142 c=0
Rl13 (\6\:qbint \9\:qbint) resistor r=60.772 c=0
Rl11 (\6\:qbint \7\:qbint) resistor r=28.0797 c=0
Rl16 (\11\:qbint \10\:qbint) resistor r=120.868 c=0
Rl18 (\11\:qbint \13\:qbint) resistor r=47.791 c=0
Rl17 (\11\:qbint \12\:qbint) resistor r=2.7666 c=0
Rl14 (n30 \2\:n30) resistor r=49.2328 c=0
Rl15 (\2\:n30 \3\:n30) resistor r=99.2328 c=0
Rl28 (\2\:mout \4\:mout) resistor r=114.125 c=0
Rl26 (mout \2\:mout) resistor r=73.3853 c=0
Rl27 (\2\:mout \3\:mout) resistor r=5.8511 c=0
Rl25 (\2\:n20 \4\:n20) resistor r=51.6372 c=0
Rl24 (\2\:n20 \3\:n20) resistor r=117.022 c=0
Rl23 (n20 \2\:n20) resistor r=3.5213 c=0
Rl45 (\6\:qbint_2 qbint_2) resistor r=142 c=0
Rl48 (\6\:qbint_2 \9\:qbint_2) resistor r=60.772 c=0
Rl46 (\6\:qbint_2 \7\:qbint_2) resistor r=28.0797 c=0
Rl51 (\11\:qbint_2 \10\:qbint_2) resistor r=120.868 c=0
Rl53 (\11\:qbint_2 \13\:qbint_2) resistor r=47.791 c=0
Rl52 (\11\:qbint_2 \12\:qbint_2) resistor r=2.7666 c=0
Rl49 (n30_2 \2\:n30_2) resistor r=49.2328 c=0
Rl50 (\2\:n30_2 \3\:n30_2) resistor r=99.2328 c=0
Rl63 (\2\:mout_2 \4\:mout_2) resistor r=114.125 c=0
Rl61 (mout_2 \2\:mout_2) resistor r=73.3853 c=0
Rl62 (\2\:mout_2 \3\:mout_2) resistor r=5.8511 c=0
Rl60 (\2\:n20_2 \4\:n20_2) resistor r=51.6372 c=0
Rl59 (\2\:n20_2 \3\:n20_2) resistor r=117.022 c=0
Rl58 (n20_2 \2\:n20_2) resistor r=3.5213 c=0
Rl95 (\2\:qbint_3 \4\:qbint_3) resistor r=120.868 c=0
Rl94 (\2\:qbint_3 \3\:qbint_3) resistor r=47.791 c=0
Rl93 (\2\:qbint_3 qbint_3) resistor r=2.7713 c=0
Rl98 (\6\:qbint_3 \5\:qbint_3) resistor r=60.772 c=0
Rl101 (\6\:qbint_3 \9\:qbint_3) resistor r=28.0797 c=0
Rl99 (\7\:qbint_3 \6\:qbint_3) resistor r=142 c=0
Rl96 (n30_3 \2\:n30_3) resistor r=49.2328 c=0
Rl97 (\2\:n30_3 \3\:n30_3) resistor r=99.2328 c=0
Rl83 (mout_3 \2\:mout_3) resistor r=114.125 c=0
Rl84 (\2\:mout_3 \3\:mout_3) resistor r=73.3853 c=0
Rl85 (\2\:mout_3 \4\:mout_3) resistor r=5.8511 c=0
Rl86 (n20_3 \2\:n20_3) resistor r=51.6372 c=0
Rl88 (\2\:n20_3 \4\:n20_3) resistor r=117.022 c=0
Rl87 (\2\:n20_3 \3\:n20_3) resistor r=3.5166 c=0
Rl130 (\2\:qbint_4 \4\:qbint_4) resistor r=120.868 c=0
Rl129 (\2\:qbint_4 \3\:qbint_4) resistor r=47.791 c=0
Rl128 (\2\:qbint_4 qbint_4) resistor r=2.7713 c=0
Rl133 (\6\:qbint_4 \5\:qbint_4) resistor r=60.772 c=0
Rl136 (\6\:qbint_4 \9\:qbint_4) resistor r=28.0797 c=0
Rl134 (\7\:qbint_4 \6\:qbint_4) resistor r=142 c=0
Rl131 (n30_4 \2\:n30_4) resistor r=49.2328 c=0
Rl132 (\2\:n30_4 \3\:n30_4) resistor r=99.2328 c=0
Rl118 (mout_4 \2\:mout_4) resistor r=114.125 c=0
Rl119 (\2\:mout_4 \3\:mout_4) resistor r=73.3853 c=0
Rl120 (\2\:mout_4 \4\:mout_4) resistor r=5.8511 c=0
Rl121 (n20_4 \2\:n20_4) resistor r=51.6372 c=0
Rl123 (\2\:n20_4 \4\:n20_4) resistor r=117.022 c=0
Rl122 (\2\:n20_4 \3\:n20_4) resistor r=3.5166 c=0
Rz47 (\47\:VSS \46\:VSS) resistor r=75 c=0
Rz48 (\49\:VSS \48\:VSS) resistor r=75 c=0
Rz49 (\51\:VSS \50\:VSS) resistor r=75 c=0
Rz54 (\61\:VSS \60\:VSS) resistor r=75 c=0
Rz55 (\63\:VSS \62\:VSS) resistor r=75 c=0
Rz56 (\65\:VSS \64\:VSS) resistor r=75 c=0
Rz57 (\67\:VSS \66\:VSS) resistor r=75 c=0
Rz58 (\69\:VSS \68\:VSS) resistor r=75 c=0
Rz59 (\71\:VSS \70\:VSS) resistor r=75 c=0
Rz60 (\73\:VSS \72\:VSS) resistor r=75 c=0
Rz65 (\83\:VSS \82\:VSS) resistor r=75 c=0
Rz66 (\85\:VSS \84\:VSS) resistor r=75 c=0
Rz67 (\87\:VSS \86\:VSS) resistor r=75 c=0
Rz35 (\1\:VDD \3\:VDD) resistor r=18.75 c=0
Rz36 (\9\:VDD \3\:VDD) resistor r=6.25 c=0
Rz37 (\14\:VDD \3\:VDD) resistor r=6.25 c=0
Rz38 (\19\:VDD \3\:VDD) resistor r=6.25 c=0
Rz39 (\24\:VDD \3\:VDD) resistor r=6.25 c=0
Rz40 (\30\:VDD \3\:VDD) resistor r=6.25 c=0
Rz41 (\34\:VDD \3\:VDD) resistor r=6.25 c=0
Rz1 (\4\:Q1N \3\:Q1N) resistor r=37.5 c=0
Rz3 (\2\:Q1 \1\:Q1) resistor r=37.5 c=0
Rz9 (\5\:Q2N \4\:Q2N) resistor r=37.5 c=0
Rz11 (\2\:Q2 \1\:Q2) resistor r=37.5 c=0
Rz24 (\3\:Q3N \2\:Q3N) resistor r=37.5 c=0
Rz22 (\2\:Q3 \1\:Q3) resistor r=37.5 c=0
Rz34 (\3\:Q4N \2\:Q4N) resistor r=37.5 c=0
Rz32 (\2\:Q4 \1\:Q4) resistor r=37.5 c=0
Rz28 (\51\:CKb \52\:CKb) resistor r=75 c=0
Rz29 (\42\:Ckbb \43\:Ckbb) resistor r=75 c=0
Rz2 (\12\:qint \11\:qint) resistor r=75 c=0
Rz4 (\20\:qbint \19\:qbint) resistor r=75 c=0
Rz5 (\8\:n30 \9\:n30) resistor r=75 c=0
Rz6 (\7\:mout \8\:mout) resistor r=75 c=0
Rz7 (\5\:n20 \6\:n20) resistor r=75 c=0
Rz8 (\3\:Db \4\:Db) resistor r=75 c=0
Rz10 (\12\:qint_2 \11\:qint_2) resistor r=75 c=0
Rz12 (\20\:qbint_2 \19\:qbint_2) resistor r=75 c=0
Rz13 (\8\:n30_2 \9\:n30_2) resistor r=75 c=0
Rz14 (\7\:mout_2 \8\:mout_2) resistor r=75 c=0
Rz15 (\5\:n20_2 \6\:n20_2) resistor r=75 c=0
Rz16 (\3\:Db_2 \4\:Db_2) resistor r=75 c=0
Rz23 (\11\:qint_3 \10\:qint_3) resistor r=75 c=0
Rz21 (\21\:qbint_3 \20\:qbint_3) resistor r=75 c=0
Rz20 (\8\:n30_3 \9\:n30_3) resistor r=75 c=0
Rz19 (\9\:mout_3 \10\:mout_3) resistor r=75 c=0
Rz18 (\8\:n20_3 \9\:n20_3) resistor r=75 c=0
Rz17 (\3\:Db_3 \4\:Db_3) resistor r=75 c=0
Rz33 (\11\:qint_4 \10\:qint_4) resistor r=75 c=0
Rz31 (\21\:qbint_4 \20\:qbint_4) resistor r=75 c=0
Rz30 (\8\:n30_4 \9\:n30_4) resistor r=75 c=0
Rz27 (\9\:mout_4 \10\:mout_4) resistor r=75 c=0
Rz26 (\8\:n20_4 \9\:n20_4) resistor r=75 c=0
Rz25 (\3\:Db_4 \4\:Db_4) resistor r=75 c=0
Ry64 (\1\:VSS \3\:VSS) resistor r=15.5 c=0
Ry65 (\9\:VSS \3\:VSS) resistor r=5.1667 c=0
Ry66 (\14\:VSS \3\:VSS) resistor r=5.1667 c=0
Ry67 (\19\:VSS \3\:VSS) resistor r=5.1667 c=0
Ry68 (\24\:VSS \3\:VSS) resistor r=5.1667 c=0
Ry69 (\30\:VSS \3\:VSS) resistor r=5.1667 c=0
Ry70 (\34\:VSS \3\:VSS) resistor r=5.1667 c=0
Ry40 (\47\:VDD \46\:VDD) resistor r=62 c=0
Ry41 (\49\:VDD \48\:VDD) resistor r=62 c=0
Ry42 (\51\:VDD \50\:VDD) resistor r=62 c=0
Ry47 (\61\:VDD \60\:VDD) resistor r=62 c=0
Ry48 (\63\:VDD \62\:VDD) resistor r=62 c=0
Ry49 (\65\:VDD \64\:VDD) resistor r=62 c=0
Ry50 (\67\:VDD \66\:VDD) resistor r=62 c=0
Ry51 (\69\:VDD \68\:VDD) resistor r=62 c=0
Ry52 (\71\:VDD \70\:VDD) resistor r=62 c=0
Ry53 (\73\:VDD \72\:VDD) resistor r=62 c=0
Ry58 (\83\:VDD \82\:VDD) resistor r=62 c=0
Ry59 (\85\:VDD \84\:VDD) resistor r=62 c=0
Ry60 (\87\:VDD \86\:VDD) resistor r=62 c=0
Ry1 (\2\:Q1N \1\:Q1N) resistor r=20.6667 c=0
Ry3 (\4\:Q1 \3\:Q1) resistor r=20.6667 c=0
Ry9 (\2\:Q2N \1\:Q2N) resistor r=20.6667 c=0
Ry11 (\4\:Q2 \3\:Q2) resistor r=20.6667 c=0
Ry24 (\5\:Q3N \4\:Q3N) resistor r=20.6667 c=0
Ry22 (\4\:Q3 \3\:Q3) resistor r=20.6667 c=0
Ry34 (\5\:Q4N \4\:Q4N) resistor r=20.6667 c=0
Ry32 (\4\:Q4 \3\:Q4) resistor r=20.6667 c=0
Ry28 (\56\:CKb \57\:CKb) resistor r=62 c=0
Ry29 (\44\:Ckbb \45\:Ckbb) resistor r=62 c=0
Ry2 (\8\:qint \7\:qint) resistor r=62 c=0
Ry4 (\15\:qbint \14\:qbint) resistor r=31 c=0
Ry5 (\4\:n30 \5\:n30) resistor r=62 c=0
Ry6 (\9\:mout \10\:mout) resistor r=62 c=0
Ry7 (\9\:n20 \10\:n20) resistor r=62 c=0
Ry8 (Db \2\:Db) resistor r=62 c=0
Ry10 (\8\:qint_2 \7\:qint_2) resistor r=62 c=0
Ry12 (\15\:qbint_2 \14\:qbint_2) resistor r=31 c=0
Ry13 (\4\:n30_2 \5\:n30_2) resistor r=62 c=0
Ry14 (\9\:mout_2 \10\:mout_2) resistor r=62 c=0
Ry15 (\9\:n20_2 \10\:n20_2) resistor r=62 c=0
Ry16 (Db_2 \2\:Db_2) resistor r=62 c=0
Ry23 (\8\:qint_3 \7\:qint_3) resistor r=62 c=0
Ry21 (\19\:qbint_3 \18\:qbint_3) resistor r=31 c=0
Ry20 (\6\:n30_3 \7\:n30_3) resistor r=62 c=0
Ry19 (\5\:mout_3 \6\:mout_3) resistor r=62 c=0
Ry18 (\5\:n20_3 \6\:n20_3) resistor r=62 c=0
Ry17 (Db_3 \2\:Db_3) resistor r=62 c=0
Ry33 (\8\:qint_4 \7\:qint_4) resistor r=62 c=0
Ry31 (\19\:qbint_4 \18\:qbint_4) resistor r=31 c=0
Ry30 (\6\:n30_4 \7\:n30_4) resistor r=62 c=0
Ry27 (\5\:mout_4 \6\:mout_4) resistor r=62 c=0
Ry26 (\5\:n20_4 \6\:n20_4) resistor r=62 c=0
Ry25 (Db_4 \2\:Db_4) resistor r=62 c=0
Rx15 (\2\:CK \4\:CK) resistor r=45 c=0
Rx7 (\1\:D1 \5\:D1) resistor r=45 c=0
Rx14 (\1\:D2 \5\:D2) resistor r=45 c=0
Rx16 (\3\:D3 \6\:D3) resistor r=45 c=0
Rx23 (\3\:D4 \5\:D4) resistor r=45 c=0
Rx26 (\31\:CKb \33\:CKb) resistor r=45 c=0
Rx27 (\29\:CKb \34\:CKb) resistor r=45 c=0
Rx28 (\22\:CKb \37\:CKb) resistor r=45 c=0
Rx29 (\12\:CKb \41\:CKb) resistor r=45 c=0
Rx30 (\5\:CKb \44\:CKb) resistor r=45 c=0
Rx31 (\2\:CKb \45\:CKb) resistor r=45 c=0
Rx32 (\27\:CKb \46\:CKb) resistor r=45 c=0
Rx33 (\24\:CKb \47\:CKb) resistor r=45 c=0
Rx34 (\20\:CKb \48\:CKb) resistor r=45 c=0
Rx35 (\15\:CKb \50\:CKb) resistor r=45 c=0
Rx36 (\14\:CKb \53\:CKb) resistor r=45 c=0
Rx37 (\9\:CKb \54\:CKb) resistor r=45 c=0
Rx38 (\7\:CKb \55\:CKb) resistor r=45 c=0
Rx39 (\28\:Ckbb \29\:Ckbb) resistor r=45 c=0
Rx40 (\26\:Ckbb \30\:Ckbb) resistor r=45 c=0
Rx41 (\19\:Ckbb \32\:Ckbb) resistor r=45 c=0
Rx42 (\11\:Ckbb \36\:Ckbb) resistor r=45 c=0
Rx43 (\4\:Ckbb \38\:Ckbb) resistor r=45 c=0
Rx44 (\22\:Ckbb \39\:Ckbb) resistor r=45 c=0
Rx45 (\21\:Ckbb \40\:Ckbb) resistor r=45 c=0
Rx46 (\15\:Ckbb \41\:Ckbb) resistor r=45 c=0
Rx47 (\14\:Ckbb \46\:Ckbb) resistor r=45 c=0
Rx48 (\8\:Ckbb \47\:Ckbb) resistor r=45 c=0
Rx49 (\7\:Ckbb \48\:Ckbb) resistor r=45 c=0
Rx50 (Ckbb \49\:Ckbb) resistor r=45 c=0
Rx1 (\10\:qint qint) resistor r=45 c=0
Rx2 (\17\:qbint qbint) resistor r=22.5 c=0
Rx3 (\21\:qbint \12\:qbint) resistor r=45 c=0
Rx4 (\2\:n30 \7\:n30) resistor r=45 c=0
Rx5 (\3\:mout \5\:mout) resistor r=45 c=0
Rx6 (n20 \8\:n20) resistor r=45 c=0
Rx8 (\10\:qint_2 qint_2) resistor r=45 c=0
Rx9 (\17\:qbint_2 qbint_2) resistor r=22.5 c=0
Rx10 (\21\:qbint_2 \12\:qbint_2) resistor r=45 c=0
Rx11 (\2\:n30_2 \7\:n30_2) resistor r=45 c=0
Rx12 (\3\:mout_2 \5\:mout_2) resistor r=45 c=0
Rx13 (n20_2 \8\:n20_2) resistor r=45 c=0
Rx22 (\12\:qint_3 qint_3) resistor r=45 c=0
Rx20 (\14\:qbint_3 \7\:qbint_3) resistor r=22.5 c=0
Rx21 (\17\:qbint_3 qbint_3) resistor r=45 c=0
Rx19 (\2\:n30_3 \4\:n30_3) resistor r=45 c=0
Rx18 (\4\:mout_3 \8\:mout_3) resistor r=45 c=0
Rx17 (\3\:n20_3 \10\:n20_3) resistor r=45 c=0
Rx54 (\12\:qint_4 qint_4) resistor r=45 c=0
Rx52 (\14\:qbint_4 \7\:qbint_4) resistor r=22.5 c=0
Rx53 (\17\:qbint_4 qbint_4) resistor r=45 c=0
Rx51 (\2\:n30_4 \4\:n30_4) resistor r=45 c=0
Rx25 (\4\:mout_4 \8\:mout_4) resistor r=45 c=0
Rx24 (\3\:n20_4 \10\:n20_4) resistor r=45 c=0
NM38 (\2\:Q4N qint_4 \1\:VSS VSS) g45n1svt w=(2.6e-07) l=4.5e-08 nf=1 \
        as=5.085e-14 ad=5.448e-14 ps=1.17e-06 pd=1.22e-06 nrd=1.16667 \
        nrs=1.16667 sa=4.56058e-07 sb=1.2e-07 sd=160n sca=17.5885 \
        scb=0.0172826 scc=0.00162584 m=(2)
mn55 (\1\:Q1 qbint \34\:VSS VSS) g45n1svt w=(2.6e-07) l=4.5e-08 nf=1 \
        as=5.24e-14 ad=4.813e-14 ps=1.205e-06 pd=1.175e-06 nrd=1.16667 \
        nrs=1.16667 sa=3.15e-07 sb=1.04615e-07 sd=160n sca=17.5885 \
        scb=0.0172826 scc=0.00162584 m=(2)
NM19 (\4\:Q2N qint_2 \28\:VSS VSS) g45n1svt w=(2.6e-07) l=4.5e-08 nf=1 \
        as=5.085e-14 ad=5.448e-14 ps=1.17e-06 pd=1.22e-06 nrd=1.16667 \
        nrs=1.16667 sa=4.56058e-07 sb=1.2e-07 sd=160n sca=17.5885 \
        scb=0.0172826 scc=0.00162584 m=(2)
NM40_1__rcx (\1\:Q4 \7\:qbint_4 \6\:VSS VSS) g45n1svt w=(2.6e-07) \
        l=4.5e-08 nf=1 as=5.24e-14 ad=4.813e-14 ps=1.205e-06 pd=1.175e-06 \
        nrd=1.16667 nrs=1.16667 sa=3.15e-07 sb=1.04615e-07 sd=160n \
        sca=17.5885 scb=0.0172826 scc=0.00162584 m=(2)
NM17_1__rcx (\1\:Q2 qbint_2 \26\:VSS VSS) g45n1svt w=(2.6e-07) l=4.5e-08 \
        nf=1 as=5.24e-14 ad=4.813e-14 ps=1.205e-06 pd=1.175e-06 \
        nrd=1.16667 nrs=1.16667 sa=3.15e-07 sb=1.04615e-07 sd=160n \
        sca=17.5885 scb=0.0172826 scc=0.00162584 m=(2)
NM37_1__rcx (\2\:Q3N qint_3 \12\:VSS VSS) g45n1svt w=(2.6e-07) l=4.5e-08 \
        nf=1 as=5.085e-14 ad=5.448e-14 ps=1.17e-06 pd=1.22e-06 nrd=1.16667 \
        nrs=1.16667 sa=4.56058e-07 sb=1.2e-07 sd=160n sca=17.5885 \
        scb=0.0172826 scc=0.00162584 m=(2)
NM35_1__rcx (\1\:Q3 \7\:qbint_3 \15\:VSS VSS) g45n1svt w=(2.6e-07) \
        l=4.5e-08 nf=1 as=5.24e-14 ad=4.813e-14 ps=1.205e-06 pd=1.175e-06 \
        nrd=1.16667 nrs=1.16667 sa=3.15e-07 sb=1.04615e-07 sd=160n \
        sca=17.5885 scb=0.0172826 scc=0.00162584 m=(2)
mn57_1__rcx (\3\:Q1N qint \37\:VSS VSS) g45n1svt w=(2.6e-07) l=4.5e-08 \
        nf=1 as=5.085e-14 ad=5.448e-14 ps=1.17e-06 pd=1.22e-06 nrd=1.16667 \
        nrs=1.16667 sa=4.56058e-07 sb=1.2e-07 sd=160n sca=17.5885 \
        scb=0.0172826 scc=0.00162584 m=(2)
NM39 (\10\:qint_4 \9\:qbint_4 \1\:VSS VSS) g45n1svt w=(1.45e-07) \
        l=4.5e-08 nf=1 as=6.735e-14 ad=2.03e-14 ps=1.6e-06 pd=5.7e-07 \
        nrd=1.16667 nrs=1.16667 sa=1.4e-07 sb=5.4e-07 sd=160n sca=23.279 \
        scb=0.0230742 scc=0.00267719 m=(1)
NM42 (n11_4 \3\:qbint_4 \46\:VSS VSS) g45n1svt w=(1.45e-07) l=4.5e-08 \
        nf=1 as=1.088e-14 ad=6.303e-14 ps=4.4e-07 pd=1.54e-06 nrd=1.16667 \
        nrs=1.16667 sa=3.5e-07 sb=1.64e-06 sd=160n sca=18.4982 \
        scb=0.0194884 scc=0.00168796 m=(1)
NM41 (\8\:n30_4 \30\:CKb n11_4 VSS) g45n1svt w=(1.45e-07) l=4.5e-08 nf=1 \
        as=2.537e-14 ad=1.088e-14 ps=6.4e-07 pd=4.4e-07 nrd=1.16667 \
        nrs=1.16667 sa=4.7e-07 sb=1.52e-06 sd=160n sca=18.4982 \
        scb=0.0194884 scc=0.00168796 m=(1)
NM45 (\9\:mout_4 \25\:Ckbb \8\:n30_4 VSS) g45n1svt w=(1.45e-07) l=4.5e-08 \
        nf=1 as=3.19e-14 ad=2.537e-14 ps=7.3e-07 pd=6.4e-07 nrd=1.16667 \
        nrs=1.16667 sa=6.9e-07 sb=1.3e-06 sd=160n sca=18.4982 \
        scb=0.0194884 scc=0.00168796 m=(1)
NM49 (\9\:mout_4 \4\:n20_4 \48\:VSS VSS) g45n1svt w=(1.45e-07) l=4.5e-08 \
        nf=1 as=3.19e-14 ad=8.993e-14 ps=7.3e-07 pd=1.67e-06 nrd=1.16667 \
        nrs=1.16667 sa=9.55e-07 sb=1.035e-06 sd=160n sca=18.4982 \
        scb=0.0194884 scc=0.00168796 m=(1)
NM46 (n5_4 \3\:mout_4 \48\:VSS VSS) g45n1svt w=(1.45e-07) l=4.5e-08 nf=1 \
        as=8.7e-15 ad=8.993e-14 ps=4.1e-07 pd=1.67e-06 nrd=1.16667 \
        nrs=1.16667 sa=1.285e-06 sb=7.05e-07 sd=160n sca=18.4982 \
        scb=0.0194884 scc=0.00168796 m=(1)
NM48 (\8\:n20_4 \23\:Ckbb n5_4 VSS) g45n1svt w=(1.45e-07) l=4.5e-08 nf=1 \
        as=8.7e-15 ad=2.32e-14 ps=4.1e-07 pd=6.1e-07 nrd=1.16667 \
        nrs=1.16667 sa=6e-07 sb=1.39e-06 sd=160n sca=18.4982 scb=0.0194884 \
        scc=0.00168796 m=(1)
NM50 (\3\:Db_4 \26\:CKb \8\:n20_4 VSS) g45n1svt w=(1.45e-07) l=4.5e-08 \
        nf=1 as=2.32e-14 ad=2.61e-14 ps=6.1e-07 pd=6.5e-07 nrd=1.16667 \
        nrs=1.16667 sa=3.95e-07 sb=1.595e-06 sd=160n sca=18.4982 \
        scb=0.0194884 scc=0.00168796 m=(1)
NM54 (\3\:Db_4 \4\:D4 \50\:VSS VSS) g45n1svt w=(1.45e-07) l=4.5e-08 nf=1 \
        as=7.325e-14 ad=2.61e-14 ps=1.44e-06 pd=6.5e-07 nrd=1.16667 \
        nrs=1.16667 sa=1.7e-07 sb=1.82e-06 sd=160n sca=18.4982 \
        scb=0.0194884 scc=0.00168796 m=(1)
NM36 (\10\:qint_3 \9\:qbint_3 \12\:VSS VSS) g45n1svt w=(1.45e-07) \
        l=4.5e-08 nf=1 as=6.735e-14 ad=2.03e-14 ps=1.6e-06 pd=5.7e-07 \
        nrd=1.16667 nrs=1.16667 sa=1.4e-07 sb=5.4e-07 sd=160n sca=23.279 \
        scb=0.0230742 scc=0.00267719 m=(1)
NM33 (n11_3 \3\:qbint_3 \60\:VSS VSS) g45n1svt w=(1.45e-07) l=4.5e-08 \
        nf=1 as=1.088e-14 ad=6.303e-14 ps=4.4e-07 pd=1.54e-06 nrd=1.16667 \
        nrs=1.16667 sa=3.5e-07 sb=1.64e-06 sd=160n sca=18.4982 \
        scb=0.0194884 scc=0.00168796 m=(1)
NM34 (\8\:n30_3 \23\:CKb n11_3 VSS) g45n1svt w=(1.45e-07) l=4.5e-08 nf=1 \
        as=2.537e-14 ad=1.088e-14 ps=6.4e-07 pd=4.4e-07 nrd=1.16667 \
        nrs=1.16667 sa=4.7e-07 sb=1.52e-06 sd=160n sca=18.4982 \
        scb=0.0194884 scc=0.00168796 m=(1)
NM30 (\9\:mout_3 \18\:Ckbb \8\:n30_3 VSS) g45n1svt w=(1.45e-07) l=4.5e-08 \
        nf=1 as=3.19e-14 ad=2.537e-14 ps=7.3e-07 pd=6.4e-07 nrd=1.16667 \
        nrs=1.16667 sa=6.9e-07 sb=1.3e-06 sd=160n sca=18.4982 \
        scb=0.0194884 scc=0.00168796 m=(1)
NM26 (\9\:mout_3 \4\:n20_3 \62\:VSS VSS) g45n1svt w=(1.45e-07) l=4.5e-08 \
        nf=1 as=3.19e-14 ad=8.993e-14 ps=7.3e-07 pd=1.67e-06 nrd=1.16667 \
        nrs=1.16667 sa=9.55e-07 sb=1.035e-06 sd=160n sca=18.4982 \
        scb=0.0194884 scc=0.00168796 m=(1)
NM29 (n5_3 \3\:mout_3 \62\:VSS VSS) g45n1svt w=(1.45e-07) l=4.5e-08 nf=1 \
        as=8.7e-15 ad=8.993e-14 ps=4.1e-07 pd=1.67e-06 nrd=1.16667 \
        nrs=1.16667 sa=1.285e-06 sb=7.05e-07 sd=160n sca=18.4982 \
        scb=0.0194884 scc=0.00168796 m=(1)
NM27 (\8\:n20_3 \16\:Ckbb n5_3 VSS) g45n1svt w=(1.45e-07) l=4.5e-08 nf=1 \
        as=8.7e-15 ad=2.32e-14 ps=4.1e-07 pd=6.1e-07 nrd=1.16667 \
        nrs=1.16667 sa=6e-07 sb=1.39e-06 sd=160n sca=18.4982 scb=0.0194884 \
        scc=0.00168796 m=(1)
NM25 (\3\:Db_3 \19\:CKb \8\:n20_3 VSS) g45n1svt w=(1.45e-07) l=4.5e-08 \
        nf=1 as=2.32e-14 ad=2.61e-14 ps=6.1e-07 pd=6.5e-07 nrd=1.16667 \
        nrs=1.16667 sa=3.95e-07 sb=1.595e-06 sd=160n sca=18.4982 \
        scb=0.0194884 scc=0.00168796 m=(1)
NM21 (\3\:Db_3 \4\:D3 \64\:VSS VSS) g45n1svt w=(1.45e-07) l=4.5e-08 nf=1 \
        as=7.325e-14 ad=2.61e-14 ps=1.44e-06 pd=6.5e-07 nrd=1.16667 \
        nrs=1.16667 sa=1.7e-07 sb=1.82e-06 sd=160n sca=18.4982 \
        scb=0.0194884 scc=0.00168796 m=(1)
NM18 (\11\:qint_2 \7\:qbint_2 \28\:VSS VSS) g45n1svt w=(1.45e-07) \
        l=4.5e-08 nf=1 as=6.735e-14 ad=2.03e-14 ps=1.6e-06 pd=5.7e-07 \
        nrd=1.16667 nrs=1.16667 sa=1.4e-07 sb=5.4e-07 sd=160n sca=23.279 \
        scb=0.0230742 scc=0.00267719 m=(1)
NM15 (n11_2 \13\:qbint_2 \72\:VSS VSS) g45n1svt w=(1.45e-07) l=4.5e-08 \
        nf=1 as=1.088e-14 ad=6.303e-14 ps=4.4e-07 pd=1.54e-06 nrd=1.16667 \
        nrs=1.16667 sa=3.5e-07 sb=1.64e-06 sd=160n sca=18.4982 \
        scb=0.0194884 scc=0.00168796 m=(1)
NM16 (\8\:n30_2 \10\:CKb n11_2 VSS) g45n1svt w=(1.45e-07) l=4.5e-08 nf=1 \
        as=2.537e-14 ad=1.088e-14 ps=6.4e-07 pd=4.4e-07 nrd=1.16667 \
        nrs=1.16667 sa=4.7e-07 sb=1.52e-06 sd=160n sca=18.4982 \
        scb=0.0194884 scc=0.00168796 m=(1)
NM12 (\7\:mout_2 \10\:Ckbb \8\:n30_2 VSS) g45n1svt w=(1.45e-07) l=4.5e-08 \
        nf=1 as=3.19e-14 ad=2.537e-14 ps=7.3e-07 pd=6.4e-07 nrd=1.16667 \
        nrs=1.16667 sa=6.9e-07 sb=1.3e-06 sd=160n sca=18.4982 \
        scb=0.0194884 scc=0.00168796 m=(1)
NM8 (\7\:mout_2 \3\:n20_2 \70\:VSS VSS) g45n1svt w=(1.45e-07) l=4.5e-08 \
        nf=1 as=3.19e-14 ad=8.993e-14 ps=7.3e-07 pd=1.67e-06 nrd=1.16667 \
        nrs=1.16667 sa=9.55e-07 sb=1.035e-06 sd=160n sca=18.4982 \
        scb=0.0194884 scc=0.00168796 m=(1)
NM11 (n5_2 mout_2 \70\:VSS VSS) g45n1svt w=(1.45e-07) l=4.5e-08 nf=1 \
        as=8.7e-15 ad=8.993e-14 ps=4.1e-07 pd=1.67e-06 nrd=1.16667 \
        nrs=1.16667 sa=1.285e-06 sb=7.05e-07 sd=160n sca=18.4982 \
        scb=0.0194884 scc=0.00168796 m=(1)
NM9 (\5\:n20_2 \13\:Ckbb n5_2 VSS) g45n1svt w=(1.45e-07) l=4.5e-08 nf=1 \
        as=8.7e-15 ad=2.32e-14 ps=4.1e-07 pd=6.1e-07 nrd=1.16667 \
        nrs=1.16667 sa=6e-07 sb=1.39e-06 sd=160n sca=18.4982 scb=0.0194884 \
        scc=0.00168796 m=(1)
NM7 (\3\:Db_2 \13\:CKb \5\:n20_2 VSS) g45n1svt w=(1.45e-07) l=4.5e-08 \
        nf=1 as=2.32e-14 ad=2.61e-14 ps=6.1e-07 pd=6.5e-07 nrd=1.16667 \
        nrs=1.16667 sa=3.95e-07 sb=1.595e-06 sd=160n sca=18.4982 \
        scb=0.0194884 scc=0.00168796 m=(1)
NM1 (\3\:Db_2 \3\:D2 \68\:VSS VSS) g45n1svt w=(1.45e-07) l=4.5e-08 nf=1 \
        as=7.325e-14 ad=2.61e-14 ps=1.44e-06 pd=6.5e-07 nrd=1.16667 \
        nrs=1.16667 sa=1.7e-07 sb=1.82e-06 sd=160n sca=18.4982 \
        scb=0.0194884 scc=0.00168796 m=(1)
mn56 (\11\:qint \7\:qbint \37\:VSS VSS) g45n1svt w=(1.45e-07) l=4.5e-08 \
        nf=1 as=6.735e-14 ad=2.03e-14 ps=1.6e-06 pd=5.7e-07 nrd=1.16667 \
        nrs=1.16667 sa=1.4e-07 sb=5.4e-07 sd=160n sca=23.279 scb=0.0230742 \
        scc=0.00267719 m=(1)
mn50 (n11 \13\:qbint \86\:VSS VSS) g45n1svt w=(1.45e-07) l=4.5e-08 nf=1 \
        as=1.088e-14 ad=6.303e-14 ps=4.4e-07 pd=1.54e-06 nrd=1.16667 \
        nrs=1.16667 sa=3.5e-07 sb=1.64e-06 sd=160n sca=18.4982 \
        scb=0.0194884 scc=0.00168796 m=(1)
mn51 (\8\:n30 \3\:CKb n11 VSS) g45n1svt w=(1.45e-07) l=4.5e-08 nf=1 \
        as=2.537e-14 ad=1.088e-14 ps=6.4e-07 pd=4.4e-07 nrd=1.16667 \
        nrs=1.16667 sa=4.7e-07 sb=1.52e-06 sd=160n sca=18.4982 \
        scb=0.0194884 scc=0.00168796 m=(1)
mn40 (\7\:mout \3\:Ckbb \8\:n30 VSS) g45n1svt w=(1.45e-07) l=4.5e-08 nf=1 \
        as=3.19e-14 ad=2.537e-14 ps=7.3e-07 pd=6.4e-07 nrd=1.16667 \
        nrs=1.16667 sa=6.9e-07 sb=1.3e-06 sd=160n sca=18.4982 \
        scb=0.0194884 scc=0.00168796 m=(1)
mn30 (\7\:mout \3\:n20 \84\:VSS VSS) g45n1svt w=(1.45e-07) l=4.5e-08 \
        nf=1 as=3.19e-14 ad=8.993e-14 ps=7.3e-07 pd=1.67e-06 nrd=1.16667 \
        nrs=1.16667 sa=9.55e-07 sb=1.035e-06 sd=160n sca=18.4982 \
        scb=0.0194884 scc=0.00168796 m=(1)
mn36 (n5 mout \84\:VSS VSS) g45n1svt w=(1.45e-07) l=4.5e-08 nf=1 \
        as=8.7e-15 ad=8.993e-14 ps=4.1e-07 pd=1.67e-06 nrd=1.16667 \
        nrs=1.16667 sa=1.285e-06 sb=7.05e-07 sd=160n sca=18.4982 \
        scb=0.0194884 scc=0.00168796 m=(1)
mn37 (\5\:n20 \6\:Ckbb n5 VSS) g45n1svt w=(1.45e-07) l=4.5e-08 nf=1 \
        as=8.7e-15 ad=2.32e-14 ps=4.1e-07 pd=6.1e-07 nrd=1.16667 \
        nrs=1.16667 sa=6e-07 sb=1.39e-06 sd=160n sca=18.4982 scb=0.0194884 \
        scc=0.00168796 m=(1)
mn25 (\3\:Db \6\:CKb \5\:n20 VSS) g45n1svt w=(1.45e-07) l=4.5e-08 nf=1 \
        as=2.32e-14 ad=2.61e-14 ps=6.1e-07 pd=6.5e-07 nrd=1.16667 \
        nrs=1.16667 sa=3.95e-07 sb=1.595e-06 sd=160n sca=18.4982 \
        scb=0.0194884 scc=0.00168796 m=(1)
mn11 (\3\:Db \3\:D1 \82\:VSS VSS) g45n1svt w=(1.45e-07) l=4.5e-08 nf=1 \
        as=7.325e-14 ad=2.61e-14 ps=1.44e-06 pd=6.5e-07 nrd=1.16667 \
        nrs=1.16667 sa=1.7e-07 sb=1.82e-06 sd=160n sca=18.4982 \
        scb=0.0194884 scc=0.00168796 m=(1)
mn21 (\42\:Ckbb \17\:CKb \66\:VSS VSS) g45n1svt w=(1.45e-07) l=4.5e-08 \
        nf=1 as=2.03e-14 ad=6.753e-14 ps=5.7e-07 pd=1.56e-06 nrd=1.16667 \
        nrs=1.16667 sa=1.4e-07 sb=3.6e-07 sd=160n sca=19.8813 \
        scb=0.0206549 scc=0.00197265 m=(1)
mn20 (\51\:CKb \3\:CK \66\:VSS VSS) g45n1svt w=(1.45e-07) l=4.5e-08 nf=1 \
        as=2.03e-14 ad=6.753e-14 ps=5.7e-07 pd=1.56e-06 nrd=1.16667 \
        nrs=1.16667 sa=3.6e-07 sb=1.4e-07 sd=160n sca=19.8813 \
        scb=0.0206549 scc=0.00197265 m=(1)
NM44 (\20\:qbint_4 \3\:n30_4 \46\:VSS VSS) g45n1svt w=(2.05e-07) \
        l=4.5e-08 nf=1 as=6.303e-14 ad=2.87e-14 ps=1.54e-06 pd=6.9e-07 \
        nrd=1.16667 nrs=1.16667 sa=1.3422e-06 sb=1.4e-07 sd=160n \
        sca=16.0682 scb=0.0166045 scc=0.00126927 m=(1)
NM31 (\20\:qbint_3 \3\:n30_3 \60\:VSS VSS) g45n1svt w=(2.05e-07) \
        l=4.5e-08 nf=1 as=6.303e-14 ad=2.87e-14 ps=1.54e-06 pd=6.9e-07 \
        nrd=1.16667 nrs=1.16667 sa=1.3422e-06 sb=1.4e-07 sd=160n \
        sca=16.0682 scb=0.0166045 scc=0.00126927 m=(1)
NM13 (\19\:qbint_2 \3\:n30_2 \72\:VSS VSS) g45n1svt w=(2.05e-07) \
        l=4.5e-08 nf=1 as=6.303e-14 ad=2.87e-14 ps=1.54e-06 pd=6.9e-07 \
        nrd=1.16667 nrs=1.16667 sa=1.3422e-06 sb=1.4e-07 sd=160n \
        sca=16.0682 scb=0.0166045 scc=0.00126927 m=(1)
mn46 (\19\:qbint \3\:n30 \86\:VSS VSS) g45n1svt w=(2.05e-07) l=4.5e-08 \
        nf=1 as=6.303e-14 ad=2.87e-14 ps=1.54e-06 pd=6.9e-07 nrd=1.16667 \
        nrs=1.16667 sa=1.3422e-06 sb=1.4e-07 sd=160n sca=16.0682 \
        scb=0.0166045 scc=0.00126927 m=(1)
PM42 (n8_4 \4\:qbint_4 \46\:VDD VDD) g45p1svt w=(2.15e-07) l=4.5e-08 \
        nf=1 as=1.828e-14 ad=6.96e-14 ps=6e-07 pd=1.52e-06 nrd=1.16667 \
        nrs=1.16667 sa=3.5e-07 sb=1.64e-06 sd=160n sca=12.1244 \
        scb=0.0107968 scc=0.000332109 m=(1)
PM41 (\6\:n30_4 \27\:Ckbb n8_4 VDD) g45p1svt w=(2.15e-07) l=4.5e-08 nf=1 \
        as=3.655e-14 ad=1.828e-14 ps=7.7e-07 pd=6e-07 nrd=1.16667 \
        nrs=1.16667 sa=4.8e-07 sb=1.51e-06 sd=160n sca=12.1244 \
        scb=0.0107968 scc=0.000332109 m=(1)
PM45 (\6\:n30_4 \32\:CKb \5\:mout_4 VDD) g45p1svt w=(2.15e-07) l=4.5e-08 \
        nf=1 as=4.623e-14 ad=3.655e-14 ps=8.6e-07 pd=7.7e-07 nrd=1.16667 \
        nrs=1.16667 sa=1.295e-06 sb=6.95e-07 sd=160n sca=12.1244 \
        scb=0.0107968 scc=0.000332109 m=(1)
PM49 (\5\:mout_4 n20_4 \48\:VDD VDD) g45p1svt w=(2.15e-07) l=4.5e-08 \
        nf=1 as=4.623e-14 ad=6.593e-14 ps=8.6e-07 pd=1.53e-06 nrd=1.16667 \
        nrs=1.16667 sa=9.55e-07 sb=1.035e-06 sd=160n sca=12.1244 \
        scb=0.0107968 scc=0.000332109 m=(1)
PM46 (n6_4 mout_4 \48\:VDD VDD) g45p1svt w=(2.15e-07) l=4.5e-08 nf=1 \
        as=1.398e-14 ad=6.593e-14 ps=5.6e-07 pd=1.53e-06 nrd=1.16667 \
        nrs=1.16667 sa=1.17e-06 sb=8.2e-07 sd=160n sca=12.1244 \
        scb=0.0107968 scc=0.000332109 m=(1)
PM47 (\5\:n20_4 \28\:CKb n6_4 VDD) g45p1svt w=(2.15e-07) l=4.5e-08 nf=1 \
        as=1.398e-14 ad=3.44e-14 ps=5.6e-07 pd=7.5e-07 nrd=1.16667 \
        nrs=1.16667 sa=7.1e-07 sb=1.28e-06 sd=160n sca=12.1244 \
        scb=0.0107968 scc=0.000332109 m=(1)
PM50 (\5\:n20_4 \24\:Ckbb Db_4 VDD) g45p1svt w=(2.15e-07) l=4.5e-08 nf=1 \
        as=6.235e-14 ad=3.44e-14 ps=1.01e-06 pd=7.5e-07 nrd=1.16667 \
        nrs=1.16667 sa=5.05e-07 sb=1.485e-06 sd=160n sca=12.1244 \
        scb=0.0107968 scc=0.000332109 m=(1)
PM54 (Db_4 \1\:D4 \50\:VDD VDD) g45p1svt w=(2.15e-07) l=4.5e-08 nf=1 \
        as=7.555e-14 ad=6.235e-14 ps=1.42e-06 pd=1.01e-06 nrd=1.16667 \
        nrs=1.16667 sa=1.7e-07 sb=1.82e-06 sd=160n sca=12.1244 \
        scb=0.0107968 scc=0.000332109 m=(1)
PM33 (n8_3 \4\:qbint_3 \60\:VDD VDD) g45p1svt w=(2.15e-07) l=4.5e-08 \
        nf=1 as=1.828e-14 ad=6.96e-14 ps=6e-07 pd=1.52e-06 nrd=1.16667 \
        nrs=1.16667 sa=3.5e-07 sb=1.64e-06 sd=160n sca=12.1244 \
        scb=0.0107968 scc=0.000332109 m=(1)
PM34 (\6\:n30_3 \20\:Ckbb n8_3 VDD) g45p1svt w=(2.15e-07) l=4.5e-08 nf=1 \
        as=3.655e-14 ad=1.828e-14 ps=7.7e-07 pd=6e-07 nrd=1.16667 \
        nrs=1.16667 sa=4.8e-07 sb=1.51e-06 sd=160n sca=12.1244 \
        scb=0.0107968 scc=0.000332109 m=(1)
PM30 (\6\:n30_3 \25\:CKb \5\:mout_3 VDD) g45p1svt w=(2.15e-07) l=4.5e-08 \
        nf=1 as=4.623e-14 ad=3.655e-14 ps=8.6e-07 pd=7.7e-07 nrd=1.16667 \
        nrs=1.16667 sa=1.295e-06 sb=6.95e-07 sd=160n sca=12.1244 \
        scb=0.0107968 scc=0.000332109 m=(1)
PM26 (\5\:mout_3 n20_3 \62\:VDD VDD) g45p1svt w=(2.15e-07) l=4.5e-08 \
        nf=1 as=4.623e-14 ad=6.593e-14 ps=8.6e-07 pd=1.53e-06 nrd=1.16667 \
        nrs=1.16667 sa=9.55e-07 sb=1.035e-06 sd=160n sca=12.1244 \
        scb=0.0107968 scc=0.000332109 m=(1)
PM29 (n6_3 mout_3 \62\:VDD VDD) g45p1svt w=(2.15e-07) l=4.5e-08 nf=1 \
        as=1.398e-14 ad=6.593e-14 ps=5.6e-07 pd=1.53e-06 nrd=1.16667 \
        nrs=1.16667 sa=1.17e-06 sb=8.2e-07 sd=160n sca=12.1244 \
        scb=0.0107968 scc=0.000332109 m=(1)
PM28 (\5\:n20_3 \21\:CKb n6_3 VDD) g45p1svt w=(2.15e-07) l=4.5e-08 nf=1 \
        as=1.398e-14 ad=3.44e-14 ps=5.6e-07 pd=7.5e-07 nrd=1.16667 \
        nrs=1.16667 sa=7.1e-07 sb=1.28e-06 sd=160n sca=12.1244 \
        scb=0.0107968 scc=0.000332109 m=(1)
PM25 (\5\:n20_3 \17\:Ckbb Db_3 VDD) g45p1svt w=(2.15e-07) l=4.5e-08 nf=1 \
        as=6.235e-14 ad=3.44e-14 ps=1.01e-06 pd=7.5e-07 nrd=1.16667 \
        nrs=1.16667 sa=5.05e-07 sb=1.485e-06 sd=160n sca=12.1244 \
        scb=0.0107968 scc=0.000332109 m=(1)
PM21 (Db_3 \1\:D3 \64\:VDD VDD) g45p1svt w=(2.15e-07) l=4.5e-08 nf=1 \
        as=7.555e-14 ad=6.235e-14 ps=1.42e-06 pd=1.01e-06 nrd=1.16667 \
        nrs=1.16667 sa=1.7e-07 sb=1.82e-06 sd=160n sca=12.1244 \
        scb=0.0107968 scc=0.000332109 m=(1)
PM15 (n8_2 \10\:qbint_2 \72\:VDD VDD) g45p1svt w=(2.15e-07) l=4.5e-08 \
        nf=1 as=1.828e-14 ad=6.96e-14 ps=6e-07 pd=1.52e-06 nrd=1.16667 \
        nrs=1.16667 sa=3.5e-07 sb=1.64e-06 sd=160n sca=12.1244 \
        scb=0.0107968 scc=0.000332109 m=(1)
PM16 (\4\:n30_2 \9\:Ckbb n8_2 VDD) g45p1svt w=(2.15e-07) l=4.5e-08 nf=1 \
        as=3.655e-14 ad=1.828e-14 ps=7.7e-07 pd=6e-07 nrd=1.16667 \
        nrs=1.16667 sa=4.8e-07 sb=1.51e-06 sd=160n sca=12.1244 \
        scb=0.0107968 scc=0.000332109 m=(1)
PM12 (\4\:n30_2 \8\:CKb \9\:mout_2 VDD) g45p1svt w=(2.15e-07) l=4.5e-08 \
        nf=1 as=4.623e-14 ad=3.655e-14 ps=8.6e-07 pd=7.7e-07 nrd=1.16667 \
        nrs=1.16667 sa=1.295e-06 sb=6.95e-07 sd=160n sca=12.1244 \
        scb=0.0107968 scc=0.000332109 m=(1)
PM8 (\9\:mout_2 \4\:n20_2 \70\:VDD VDD) g45p1svt w=(2.15e-07) l=4.5e-08 \
        nf=1 as=4.623e-14 ad=6.593e-14 ps=8.6e-07 pd=1.53e-06 nrd=1.16667 \
        nrs=1.16667 sa=9.55e-07 sb=1.035e-06 sd=160n sca=12.1244 \
        scb=0.0107968 scc=0.000332109 m=(1)
PM11 (n6_2 \4\:mout_2 \70\:VDD VDD) g45p1svt w=(2.15e-07) l=4.5e-08 nf=1 \
        as=1.398e-14 ad=6.593e-14 ps=5.6e-07 pd=1.53e-06 nrd=1.16667 \
        nrs=1.16667 sa=1.17e-06 sb=8.2e-07 sd=160n sca=12.1244 \
        scb=0.0107968 scc=0.000332109 m=(1)
PM10 (\9\:n20_2 \11\:CKb n6_2 VDD) g45p1svt w=(2.15e-07) l=4.5e-08 nf=1 \
        as=1.398e-14 ad=3.44e-14 ps=5.6e-07 pd=7.5e-07 nrd=1.16667 \
        nrs=1.16667 sa=7.1e-07 sb=1.28e-06 sd=160n sca=12.1244 \
        scb=0.0107968 scc=0.000332109 m=(1)
PM7 (\9\:n20_2 \12\:Ckbb Db_2 VDD) g45p1svt w=(2.15e-07) l=4.5e-08 nf=1 \
        as=6.235e-14 ad=3.44e-14 ps=1.01e-06 pd=7.5e-07 nrd=1.16667 \
        nrs=1.16667 sa=5.05e-07 sb=1.485e-06 sd=160n sca=12.1244 \
        scb=0.0107968 scc=0.000332109 m=(1)
PM1 (Db_2 \4\:D2 \68\:VDD VDD) g45p1svt w=(2.15e-07) l=4.5e-08 nf=1 \
        as=7.555e-14 ad=6.235e-14 ps=1.42e-06 pd=1.01e-06 nrd=1.16667 \
        nrs=1.16667 sa=1.7e-07 sb=1.82e-06 sd=160n sca=12.1244 \
        scb=0.0107968 scc=0.000332109 m=(1)
mp50 (n8 \10\:qbint \86\:VDD VDD) g45p1svt w=(2.15e-07) l=4.5e-08 nf=1 \
        as=1.828e-14 ad=6.96e-14 ps=6e-07 pd=1.52e-06 nrd=1.16667 \
        nrs=1.16667 sa=3.5e-07 sb=1.64e-06 sd=160n sca=12.1244 \
        scb=0.0107968 scc=0.000332109 m=(1)
mp51 (\4\:n30 \2\:Ckbb n8 VDD) g45p1svt w=(2.15e-07) l=4.5e-08 nf=1 \
        as=3.655e-14 ad=1.828e-14 ps=7.7e-07 pd=6e-07 nrd=1.16667 \
        nrs=1.16667 sa=4.8e-07 sb=1.51e-06 sd=160n sca=12.1244 \
        scb=0.0107968 scc=0.000332109 m=(1)
mp40 (\4\:n30 CKb \9\:mout VDD) g45p1svt w=(2.15e-07) l=4.5e-08 nf=1 \
        as=4.623e-14 ad=3.655e-14 ps=8.6e-07 pd=7.7e-07 nrd=1.16667 \
        nrs=1.16667 sa=1.295e-06 sb=6.95e-07 sd=160n sca=12.1244 \
        scb=0.0107968 scc=0.000332109 m=(1)
mp30 (\9\:mout \4\:n20 \84\:VDD VDD) g45p1svt w=(2.15e-07) l=4.5e-08 \
        nf=1 as=4.623e-14 ad=6.593e-14 ps=8.6e-07 pd=1.53e-06 nrd=1.16667 \
        nrs=1.16667 sa=9.55e-07 sb=1.035e-06 sd=160n sca=12.1244 \
        scb=0.0107968 scc=0.000332109 m=(1)
mp36 (n6 \4\:mout \84\:VDD VDD) g45p1svt w=(2.15e-07) l=4.5e-08 nf=1 \
        as=1.398e-14 ad=6.593e-14 ps=5.6e-07 pd=1.53e-06 nrd=1.16667 \
        nrs=1.16667 sa=1.17e-06 sb=8.2e-07 sd=160n sca=12.1244 \
        scb=0.0107968 scc=0.000332109 m=(1)
mp37 (\9\:n20 \4\:CKb n6 VDD) g45p1svt w=(2.15e-07) l=4.5e-08 nf=1 \
        as=1.398e-14 ad=3.44e-14 ps=5.6e-07 pd=7.5e-07 nrd=1.16667 \
        nrs=1.16667 sa=7.1e-07 sb=1.28e-06 sd=160n sca=12.1244 \
        scb=0.0107968 scc=0.000332109 m=(1)
mp25 (\9\:n20 \5\:Ckbb Db VDD) g45p1svt w=(2.15e-07) l=4.5e-08 nf=1 \
        as=6.235e-14 ad=3.44e-14 ps=1.01e-06 pd=7.5e-07 nrd=1.16667 \
        nrs=1.16667 sa=5.05e-07 sb=1.485e-06 sd=160n sca=12.1244 \
        scb=0.0107968 scc=0.000332109 m=(1)
mp11 (Db \4\:D1 \82\:VDD VDD) g45p1svt w=(2.15e-07) l=4.5e-08 nf=1 \
        as=7.555e-14 ad=6.235e-14 ps=1.42e-06 pd=1.01e-06 nrd=1.16667 \
        nrs=1.16667 sa=1.7e-07 sb=1.82e-06 sd=160n sca=12.1244 \
        scb=0.0107968 scc=0.000332109 m=(1)
mp21 (\44\:Ckbb \18\:CKb \66\:VDD VDD) g45p1svt w=(2.15e-07) l=4.5e-08 \
        nf=1 as=3.01e-14 ad=8.733e-14 ps=7.1e-07 pd=1.85e-06 nrd=1.16667 \
        nrs=1.16667 sa=1.4e-07 sb=3.6e-07 sd=160n sca=31.508 scb=0.0252524 \
        scc=0.00399199 m=(1)
mp20 (\56\:CKb \1\:CK \66\:VDD VDD) g45p1svt w=(2.15e-07) l=4.5e-08 nf=1 \
        as=3.01e-14 ad=8.733e-14 ps=7.1e-07 pd=1.85e-06 nrd=1.16667 \
        nrs=1.16667 sa=3.6e-07 sb=1.4e-07 sd=160n sca=31.508 scb=0.0252524 \
        scc=0.00399199 m=(1)
mp56 (\7\:qint \9\:qbint \37\:VDD VDD) g45p1svt w=(2.15e-07) l=4.5e-08 \
        nf=1 as=8.885e-14 ad=3.01e-14 ps=1.9e-06 pd=7.1e-07 nrd=1.16667 \
        nrs=1.16667 sa=5.4e-07 sb=1.4e-07 sd=160n sca=46.674 scb=0.0287584 \
        scc=0.00588446 m=(1)
PM18 (\7\:qint_2 \9\:qbint_2 \28\:VDD VDD) g45p1svt w=(2.15e-07) \
        l=4.5e-08 nf=1 as=8.885e-14 ad=3.01e-14 ps=1.9e-06 pd=7.1e-07 \
        nrd=1.16667 nrs=1.16667 sa=5.4e-07 sb=1.4e-07 sd=160n sca=45.7906 \
        scb=0.0283307 scc=0.00588417 m=(1)
PM36 (\7\:qint_3 \5\:qbint_3 \12\:VDD VDD) g45p1svt w=(2.15e-07) \
        l=4.5e-08 nf=1 as=8.885e-14 ad=3.01e-14 ps=1.9e-06 pd=7.1e-07 \
        nrd=1.16667 nrs=1.16667 sa=1.4e-07 sb=5.4e-07 sd=160n sca=45.7906 \
        scb=0.0283307 scc=0.00588417 m=(1)
PM39 (\7\:qint_4 \5\:qbint_4 \1\:VDD VDD) g45p1svt w=(2.15e-07) \
        l=4.5e-08 nf=1 as=8.885e-14 ad=3.01e-14 ps=1.9e-06 pd=7.1e-07 \
        nrd=1.16667 nrs=1.16667 sa=1.4e-07 sb=5.4e-07 sd=160n sca=46.674 \
        scb=0.0287584 scc=0.00588446 m=(1)
PM43 (\18\:qbint_4 n30_4 \46\:VDD VDD) g45p1svt w=(3.1e-07) l=4.5e-08 \
        nf=1 as=4.34e-14 ad=6.96e-14 ps=9e-07 pd=1.52e-06 nrd=1.16667 \
        nrs=1.16667 sa=1.4e-07 sb=1.31831e-06 sd=160n sca=11.4422 \
        scb=0.00958599 scc=0.000246391 m=(1)
PM32 (\18\:qbint_3 n30_3 \60\:VDD VDD) g45p1svt w=(3.1e-07) l=4.5e-08 \
        nf=1 as=4.34e-14 ad=6.96e-14 ps=9e-07 pd=1.52e-06 nrd=1.16667 \
        nrs=1.16667 sa=1.4e-07 sb=1.31831e-06 sd=160n sca=11.4422 \
        scb=0.00958599 scc=0.000246391 m=(1)
PM14 (\14\:qbint_2 n30_2 \72\:VDD VDD) g45p1svt w=(3.1e-07) l=4.5e-08 \
        nf=1 as=4.34e-14 ad=6.96e-14 ps=9e-07 pd=1.52e-06 nrd=1.16667 \
        nrs=1.16667 sa=1.4e-07 sb=1.31831e-06 sd=160n sca=11.4422 \
        scb=0.00958599 scc=0.000246391 m=(1)
mp46 (\14\:qbint n30 \86\:VDD VDD) g45p1svt w=(3.1e-07) l=4.5e-08 nf=1 \
        as=4.34e-14 ad=6.96e-14 ps=9e-07 pd=1.52e-06 nrd=1.16667 \
        nrs=1.16667 sa=1.4e-07 sb=1.31831e-06 sd=160n sca=11.4422 \
        scb=0.00958599 scc=0.000246391 m=(1)
ends DFF4X2
// End of subcircuit definition.
