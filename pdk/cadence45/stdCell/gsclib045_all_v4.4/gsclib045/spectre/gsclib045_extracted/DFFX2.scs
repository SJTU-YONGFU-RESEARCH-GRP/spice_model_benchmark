// Generated for: spectre (May  1 08:11:06 2013 )
// Library name: gsclib045
// Cell name: DFFX2
// View name: extracted

simulator lang=spectre

subckt DFFX2 CK D Q QN VDD VSS
mp21 (\13\:CKbb CKb \19\:VDD VDD) g45p1svt w=(2.15e-07) l=4.5e-08 nf=1 \
        as=7.43e-14 ad=3.01e-14 ps=1.32e-06 pd=7.1e-07 nrd=1.16667 \
        nrs=1.16667 sa=1.4e-07 sb=2e-06 sd=160n sca=27.3372 scb=0.0320686 \
        scc=0.00199675 m=(1)
mp25 (n22 \1\:D \19\:VDD VDD) g45p1svt w=(2.15e-07) l=4.5e-08 nf=1 \
        as=7.43e-14 ad=1.29e-14 ps=1.32e-06 pd=5.5e-07 nrd=1.16667 \
        nrs=1.16667 sa=4.05e-07 sb=1.94e-06 sd=160n sca=16.3177 \
        scb=0.0157291 scc=0.00060458 m=(1)
mp26 (\7\:n20 CKbb n22 VDD) g45p1svt w=(2.15e-07) l=4.5e-08 nf=1 \
        as=1.29e-14 ad=3.44e-14 ps=5.5e-07 pd=7.5e-07 nrd=1.16667 \
        nrs=1.16667 sa=5.1e-07 sb=1.835e-06 sd=160n sca=15.2202 \
        scb=0.0141545 scc=0.000592469 m=(1)
mp36 (\7\:n20 \4\:CKb n26 VDD) g45p1svt w=(2.15e-07) l=4.5e-08 nf=1 \
        as=2.902e-14 ad=3.44e-14 ps=7e-07 pd=7.5e-07 nrd=1.16667 \
        nrs=1.16667 sa=7.15e-07 sb=1.63e-06 sd=160n sca=14.1441 \
        scb=0.0132095 scc=0.000590428 m=(1)
mp35 (n26 \3\:mout \17\:VDD VDD) g45p1svt w=(2.15e-07) l=4.5e-08 nf=1 \
        as=9.05e-14 ad=2.902e-14 ps=1.59e-06 pd=7e-07 nrd=1.16667 \
        nrs=1.16667 sa=8.95e-07 sb=1.45e-06 sd=160n sca=13.6837 \
        scb=0.0130542 scc=0.000590384 m=(1)
mp30 (\8\:mout n20 \17\:VDD VDD) g45p1svt w=(2.15e-07) l=4.5e-08 nf=1 \
        as=9.05e-14 ad=8.062e-14 ps=1.59e-06 pd=1.18e-06 nrd=1.16667 \
        nrs=1.16667 sa=1.16e-06 sb=1.185e-06 sd=160n sca=13.6743 \
        scb=0.0130525 scc=0.000590384 m=(1)
mp40 (\4\:n30 \7\:CKb \8\:mout VDD) g45p1svt w=(2.15e-07) l=4.5e-08 nf=1 \
        as=8.062e-14 ad=4.515e-14 ps=1.18e-06 pd=8.5e-07 nrd=1.16667 \
        nrs=1.16667 sa=1.58e-06 sb=7.65e-07 sd=160n sca=13.6743 \
        scb=0.0130525 scc=0.000590384 m=(1)
mp51 (\4\:n30 \7\:CKbb n36 VDD) g45p1svt w=(2.15e-07) l=4.5e-08 nf=1 \
        as=1.29e-14 ad=4.515e-14 ps=5.5e-07 pd=8.5e-07 nrd=1.16667 \
        nrs=1.16667 sa=1.835e-06 sb=5.1e-07 sd=160n sca=13.6743 \
        scb=0.0130525 scc=0.000590384 m=(1)
mp50 (n36 \4\:qbint \15\:VDD VDD) g45p1svt w=(2.15e-07) l=4.5e-08 nf=1 \
        as=9.65e-14 ad=1.29e-14 ps=1.64e-06 pd=5.5e-07 nrd=1.16667 \
        nrs=1.16667 sa=1.94e-06 sb=4.05e-07 sd=160n sca=13.6743 \
        scb=0.0130525 scc=0.000590384 m=(1)
mp20 (\9\:CKb \1\:CK \1\:VDD VDD) g45p1svt w=(2.15e-07) l=4.5e-08 nf=1 \
        as=8.9e-14 ad=3.655e-14 ps=1.38e-06 pd=7.7e-07 nrd=1.16667 \
        nrs=1.16667 sa=1.7e-07 sb=1.485e-06 sd=160n sca=45.7906 \
        scb=0.0283307 scc=0.00588417 m=(1)
mp56 (\7\:qint \12\:qbint \1\:VDD VDD) g45p1svt w=(2.15e-07) l=4.5e-08 \
        nf=1 as=6.535e-14 ad=3.01e-14 ps=1.16e-06 pd=7.1e-07 nrd=1.16667 \
        nrs=1.16667 sa=1.515e-06 sb=1.4e-07 sd=160n sca=47.1852 \
        scb=0.0292558 scc=0.00588561 m=(1)
C1 (CK VSS) capacitor c=4.54277e-17
C2 (D VSS) capacitor c=4.67477e-17
C3 (Q VSS) capacitor c=3.71826e-17
C4 (VDD VSS) capacitor c=2.6362e-16
C5 (QN VSS) capacitor c=3.34674e-17
C6 (CKb VSS) capacitor c=4.89776e-17
C7 (CKbb VSS) capacitor c=6.86649e-17
C8 (n20 VSS) capacitor c=4.45398e-17
C9 (mout VSS) capacitor c=7.38836e-17
C10 (n30 VSS) capacitor c=5.61324e-17
C11 (qbint VSS) capacitor c=2.84337e-17
C12 (qint VSS) capacitor c=1.58936e-16
C13 (n26 VSS) capacitor c=3.60107e-19
C14 (n36 VSS) capacitor c=1.11793e-18
C15 (\12\:qbint VSS) capacitor c=5.82287e-17
C16 (\5\:qbint VSS) capacitor c=4.46585e-16
C17 (\1\:CK VSS) capacitor c=2.39054e-17
C18 (\4\:qbint VSS) capacitor c=5.91845e-17
C19 (\7\:CKbb VSS) capacitor c=5.64563e-17
C20 (\7\:CKb VSS) capacitor c=4.68617e-17
C21 (\3\:mout VSS) capacitor c=4.77953e-17
C22 (\4\:CKb VSS) capacitor c=6.5606e-17
C23 (\1\:D VSS) capacitor c=5.41182e-17
C24 (\13\:qbint VSS) capacitor c=2.47188e-17
C25 (\3\:CK VSS) capacitor c=3.04619e-17
C26 (\3\:n30 VSS) capacitor c=3.15079e-17
C27 (\3\:qbint VSS) capacitor c=4.1629e-17
C28 (\6\:CKb VSS) capacitor c=7.55252e-17
C29 (\5\:CKbb VSS) capacitor c=3.50853e-17
C30 (\4\:n20 VSS) capacitor c=3.43246e-17
C31 (\3\:CKbb VSS) capacitor c=6.1774e-17
C32 (\3\:CKb VSS) capacitor c=1.13811e-16
C33 (\3\:D VSS) capacitor c=7.18738e-17
C34 (\2\:CKb VSS) capacitor c=6.08575e-17
C35 (\14\:qbint VSS) capacitor c=1.9913e-17
C36 (\2\:CK VSS) capacitor c=2.32997e-17
C37 (\2\:n30 VSS) capacitor c=3.12842e-17
C38 (\8\:CKbb VSS) capacitor c=5.95526e-17
C39 (\8\:CKb VSS) capacitor c=2.11285e-17
C40 (\6\:CKbb VSS) capacitor c=3.73295e-17
C41 (\3\:n20 VSS) capacitor c=2.69575e-17
C42 (\2\:mout VSS) capacitor c=4.96781e-17
C43 (\4\:CKbb VSS) capacitor c=2.77645e-17
C44 (\5\:CKb VSS) capacitor c=2.97319e-17
C45 (\2\:CKbb VSS) capacitor c=5.67094e-17
C46 (\2\:D VSS) capacitor c=5.32839e-17
C47 (\7\:qint VSS) capacitor c=1.53191e-17
C48 (\1\:VDD VSS) capacitor c=2.19065e-16
C49 (\1\:QN VSS) capacitor c=7.02553e-17
C50 (\3\:Q VSS) capacitor c=9.85202e-17
C51 (\9\:CKb VSS) capacitor c=1.29649e-16
C52 (\24\:qbint VSS) capacitor c=2.57335e-17
C53 (\15\:VDD VSS) capacitor c=2.48513e-17
C54 (\4\:n30 VSS) capacitor c=5.7071e-17
C55 (\8\:mout VSS) capacitor c=2.56755e-17
C56 (\17\:VDD VSS) capacitor c=2.47627e-17
C57 (\7\:n20 VSS) capacitor c=5.05353e-17
C58 (\19\:VDD VSS) capacitor c=2.7511e-17
C59 (\13\:CKbb VSS) capacitor c=3.13432e-17
C60 (\3\:VDD VSS) capacitor c=5.47434e-17
C61 (\11\:qint VSS) capacitor c=3.30773e-17
C62 (\4\:QN VSS) capacitor c=3.24977e-17
C63 (\1\:Q VSS) capacitor c=4.27058e-17
C64 (\13\:CKb VSS) capacitor c=7.07412e-17
C65 (\18\:qbint VSS) capacitor c=8.88957e-17
C66 (\7\:n30 VSS) capacitor c=5.815e-17
C67 (\4\:mout VSS) capacitor c=5.83417e-17
C68 (\9\:n20 VSS) capacitor c=3.08619e-17
C69 (\18\:CKbb VSS) capacitor c=1.72153e-17
C70 (\2\:n20 VSS) capacitor c=2.5097e-17
C71 (\2\:qbint VSS) capacitor c=2.95806e-17
C72 (\4\:D VSS) capacitor c=5.70554e-17
C73 (\5\:n20 VSS) capacitor c=4.5273e-17
C74 (\6\:n20 VSS) capacitor c=5.53271e-17
C75 (\6\:mout VSS) capacitor c=5.03318e-17
C76 (\7\:mout VSS) capacitor c=4.66426e-17
C77 (\9\:CKbb VSS) capacitor c=1.75361e-17
C78 (\10\:CKbb VSS) capacitor c=1.05541e-16
C79 (\11\:CKbb VSS) capacitor c=6.01192e-17
C80 (\12\:CKbb VSS) capacitor c=4.35398e-17
C81 (\15\:CKbb VSS) capacitor c=1.16592e-16
C82 (\16\:CKbb VSS) capacitor c=5.47997e-17
C83 (\17\:CKbb VSS) capacitor c=3.03904e-17
C84 (\6\:n30 VSS) capacitor c=6.23998e-17
C85 (\9\:n30 VSS) capacitor c=6.34561e-17
C86 (\11\:CKb VSS) capacitor c=1.5422e-16
C87 (\12\:CKb VSS) capacitor c=7.40395e-17
C88 (\4\:CK VSS) capacitor c=6.61869e-17
C89 (\3\:QN VSS) capacitor c=2.81532e-17
C90 (\20\:qbint VSS) capacitor c=1.49268e-16
C91 (\22\:qbint VSS) capacitor c=5.82474e-17
C92 (\23\:qbint VSS) capacitor c=4.20114e-17
C93 (\9\:qint VSS) capacitor c=4.86701e-17
C94 (\10\:qint VSS) capacitor c=4.23797e-17
C95 (\7\:VDD VSS) capacitor c=4.4048e-17
C96 (\9\:VDD VSS) capacitor c=2.03654e-17
C97 (\10\:VDD VSS) capacitor c=1.53442e-17
Rk22 (CK \4\:CK) resistor r=0.07473 c=0
Rk1 (\4\:D D) resistor r=0.1894 c=0
Rk23 (Q \2\:Q) resistor r=0.04484 c=0
Rk24 (Q \4\:Q) resistor r=0.2571 c=0
Rk53 (\1\:VDD \7\:VDD) resistor r=0.5001 c=0
Rk54 (\7\:VDD \8\:VDD) resistor r=0.4527 c=0
Rk55 (\8\:VDD \9\:VDD) resistor r=0.06987 c=0
Rk57 (\10\:VDD VDD) resistor r=0.1172 c=0
Rk56 (\9\:VDD \10\:VDD) resistor r=0.3625 c=0
Rk60 (\7\:VDD \16\:VDD) resistor r=0.1017 c=0
Rk61 (\9\:VDD \18\:VDD) resistor r=0.1017 c=0
Rk62 (\10\:VDD \20\:VDD) resistor r=0.1624 c=0
Rk26 (\3\:QN QN) resistor r=0.08956 c=0
Rk25 (\2\:QN \3\:QN) resistor r=0.307 c=0
Rk27 (\3\:QN \5\:QN) resistor r=0.07512 c=0
Rk41 (\1\:VSS \6\:VSS) resistor r=0.4541 c=0
Rk42 (\6\:VSS \7\:VSS) resistor r=0.4828 c=0
Rk44 (\8\:VSS VSS) resistor r=0.1047 c=0
Rk43 (\7\:VSS \8\:VSS) resistor r=0.4463 c=0
Rk47 (\6\:VSS \14\:VSS) resistor r=0.3319 c=0
Rk48 (\7\:VSS \16\:VSS) resistor r=0.07132 c=0
Rk49 (\8\:VSS \18\:VSS) resistor r=0.3635 c=0
Rk19 (\10\:CKb \11\:CKb) resistor r=0.9655 c=0
Rk20 (\11\:CKb \12\:CKb) resistor r=0.5379 c=0
Rk21 (\10\:CKb \14\:CKb) resistor r=0.3446 c=0
Rk8 (\9\:CKbb \10\:CKbb) resistor r=0.0378 c=0
Rk9 (\10\:CKbb \11\:CKbb) resistor r=0.4739 c=0
Rk10 (\11\:CKbb \12\:CKbb) resistor r=0.3013 c=0
Rk11 (\12\:CKbb \14\:CKbb) resistor r=0.2545 c=0
Rk12 (\10\:CKbb \15\:CKbb) resistor r=0.7637 c=0
Rk13 (\15\:CKbb \16\:CKbb) resistor r=0.239 c=0
Rk14 (\11\:CKbb \17\:CKbb) resistor r=0.09366 c=0
Rk15 (\12\:CKbb \19\:CKbb) resistor r=0.121 c=0
Rk2 (\5\:n20 \6\:n20) resistor r=0.2396 c=0
Rk3 (\6\:n20 \8\:n20) resistor r=0.3054 c=0
Rk4 (\6\:n20 \10\:n20) resistor r=0.1335 c=0
Rk5 (\5\:mout \6\:mout) resistor r=0.2787 c=0
Rk6 (\6\:mout \7\:mout) resistor r=0.2396 c=0
Rk7 (\6\:mout \9\:mout) resistor r=0.112 c=0
Rk16 (\5\:n30 \6\:n30) resistor r=0.3462 c=0
Rk17 (\6\:n30 \8\:n30) resistor r=0.2937 c=0
Rk18 (\6\:n30 \9\:n30) resistor r=0.2642 c=0
Rk30 (\5\:qbint \19\:qbint) resistor r=0.6139 c=0
Rk31 (\5\:qbint \20\:qbint) resistor r=0.9605 c=0
Rk33 (\19\:qbint \22\:qbint) resistor r=0.4051 c=0
Rk34 (\22\:qbint \23\:qbint) resistor r=0.2148 c=0
Rk35 (\22\:qbint \25\:qbint) resistor r=0.08579 c=0
Rk36 (\8\:qint \9\:qint) resistor r=0.09136 c=0
Rk37 (\9\:qint \10\:qint) resistor r=0.1964 c=0
Rk38 (\9\:qint \12\:qint) resistor r=0.2833 c=0
Rl23 (\1\:CK \2\:CK) resistor r=29.5379 c=0
Rl24 (\2\:CK \3\:CK) resistor r=41.0764 c=0
Rl1 (\1\:D \2\:D) resistor r=24.2328 c=0
Rl2 (\2\:D \3\:D) resistor r=99.2328 c=0
Rl15 (\6\:CKb \7\:CKb) resistor r=184.181 c=0
Rl6 (\3\:CKb \4\:CKb) resistor r=208.814 c=0
Rl4 (CKb \2\:CKb) resistor r=150.37 c=0
Rl5 (\2\:CKb \3\:CKb) resistor r=278.412 c=0
Rl16 (\7\:CKb \8\:CKb) resistor r=24.2328 c=0
Rl7 (\4\:CKb \5\:CKb) resistor r=24.2328 c=0
Rl17 (\7\:CKbb \8\:CKbb) resistor r=53.0848 c=0
Rl14 (\5\:CKbb \6\:CKbb) resistor r=46.8456 c=0
Rl8 (\3\:CKbb \4\:CKbb) resistor r=68.4636 c=0
Rl3 (CKbb \2\:CKbb) resistor r=49.2328 c=0
Rl11 (n20 \2\:n20) resistor r=104.649 c=0
Rl13 (\2\:n20 \4\:n20) resistor r=37.3411 c=0
Rl12 (\2\:n20 \3\:n20) resistor r=1.8551 c=0
Rl10 (\2\:mout \3\:mout) resistor r=25.8439 c=0
Rl9 (mout \2\:mout) resistor r=101.923 c=0
Rl21 (n30 \2\:n30) resistor r=87.2302 c=0
Rl22 (\2\:n30 \3\:n30) resistor r=29.5379 c=0
Rl35 (\13\:qbint \12\:qbint) resistor r=134.181 c=0
Rl36 (\14\:qbint \13\:qbint) resistor r=29.5379 c=0
Rl20 (\2\:qbint \4\:qbint) resistor r=43.9449 c=0
Rl19 (\2\:qbint \3\:qbint) resistor r=99.7141 c=0
Rl18 (\2\:qbint qbint) resistor r=11.5001 c=0
Rz6 (\2\:Q \1\:Q) resistor r=75 c=0
Rz16 (\1\:VDD \3\:VDD) resistor r=6.25 c=0
Rz17 (\8\:VDD \3\:VDD) resistor r=6.25 c=0
Rz7 (\5\:QN \4\:QN) resistor r=75 c=0
Rz13 (\14\:VSS \13\:VSS) resistor r=75 c=0
Rz14 (\16\:VSS \15\:VSS) resistor r=75 c=0
Rz15 (\18\:VSS \17\:VSS) resistor r=75 c=0
Rz5 (\13\:CKb \14\:CKb) resistor r=75 c=0
Rz3 (\18\:CKbb \19\:CKbb) resistor r=75 c=0
Rz1 (\9\:n20 \10\:n20) resistor r=75 c=0
Rz2 (\4\:mout \5\:mout) resistor r=75 c=0
Rz4 (\7\:n30 \8\:n30) resistor r=75 c=0
Rz8 (\19\:qbint \18\:qbint) resistor r=75 c=0
Rz9 (\12\:qint \11\:qint) resistor r=75 c=0
Ry6 (\4\:Q \3\:Q) resistor r=20.6667 c=0
Ry15 (\16\:VDD \15\:VDD) resistor r=62 c=0
Ry16 (\18\:VDD \17\:VDD) resistor r=62 c=0
Ry17 (\20\:VDD \19\:VDD) resistor r=62 c=0
Ry7 (\2\:QN \1\:QN) resistor r=20.6667 c=0
Ry10 (\1\:VSS \3\:VSS) resistor r=5.1667 c=0
Ry11 (\7\:VSS \3\:VSS) resistor r=5.1667 c=0
Ry5 (\9\:CKb \10\:CKb) resistor r=62 c=0
Ry3 (\13\:CKbb \14\:CKbb) resistor r=62 c=0
Ry1 (\7\:n20 \8\:n20) resistor r=62 c=0
Ry2 (\8\:mout \9\:mout) resistor r=62 c=0
Ry4 (\4\:n30 \5\:n30) resistor r=62 c=0
Ry8 (\25\:qbint \24\:qbint) resistor r=62 c=0
Ry9 (\8\:qint \7\:qint) resistor r=62 c=0
Rx11 (\2\:CK \4\:CK) resistor r=45 c=0
Rx1 (\2\:D \4\:D) resistor r=45 c=0
Rx9 (\8\:CKb \11\:CKb) resistor r=45 c=0
Rx10 (\5\:CKb \12\:CKb) resistor r=45 c=0
Rx4 (\4\:CKbb \9\:CKbb) resistor r=45 c=0
Rx5 (\6\:CKbb \15\:CKbb) resistor r=45 c=0
Rx6 (\8\:CKbb \16\:CKbb) resistor r=45 c=0
Rx7 (\2\:CKbb \17\:CKbb) resistor r=45 c=0
Rx2 (\3\:n20 \5\:n20) resistor r=45 c=0
Rx3 (\2\:mout \7\:mout) resistor r=45 c=0
Rx8 (\2\:n30 \9\:n30) resistor r=45 c=0
Rx13 (\20\:qbint \14\:qbint) resistor r=45 c=0
Rx15 (\23\:qbint qbint) resistor r=45 c=0
Rx16 (\10\:qint qint) resistor r=45 c=0
mn21 (\18\:CKbb \2\:CKb \17\:VSS VSS) g45n1svt w=(1.45e-07) l=4.5e-08 \
        nf=1 as=3.118e-14 ad=2.03e-14 ps=7.2e-07 pd=5.7e-07 nrd=1.16667 \
        nrs=1.16667 sa=1.4e-07 sb=2e-06 sd=160n sca=23.279 scb=0.0230742 \
        scc=0.00267719 m=(1)
mn25 (n21 \3\:D \17\:VSS VSS) g45n1svt w=(1.45e-07) l=4.5e-08 nf=1 \
        as=3.118e-14 ad=8.7e-15 ps=7.2e-07 pd=4.1e-07 nrd=1.16667 \
        nrs=1.16667 sa=4e-07 sb=1.94e-06 sd=160n sca=23.279 scb=0.0230742 \
        scc=0.00267719 m=(1)
mn26 (\9\:n20 \3\:CKb n21 VSS) g45n1svt w=(1.45e-07) l=4.5e-08 nf=1 \
        as=8.7e-15 ad=4.132e-14 ps=4.1e-07 pd=8.6e-07 nrd=1.16667 \
        nrs=1.16667 sa=5.05e-07 sb=1.835e-06 sd=160n sca=23.279 \
        scb=0.0230742 scc=0.00267719 m=(1)
mn36 (\9\:n20 \3\:CKbb n25 VSS) g45n1svt w=(1.45e-07) l=4.5e-08 nf=1 \
        as=1.16e-14 ad=4.132e-14 ps=4.5e-07 pd=8.6e-07 nrd=1.16667 \
        nrs=1.16667 sa=8.35e-07 sb=1.505e-06 sd=160n sca=23.279 \
        scb=0.0230742 scc=0.00267719 m=(1)
mn35 (n25 mout \15\:VSS VSS) g45n1svt w=(1.45e-07) l=4.5e-08 nf=1 \
        as=5.19e-14 ad=1.16e-14 ps=1.6e-06 pd=4.5e-07 nrd=1.16667 \
        nrs=1.16667 sa=9.6e-07 sb=1.38e-06 sd=160n sca=23.279 \
        scb=0.0230742 scc=0.00267719 m=(1)
mn30 (\4\:mout \4\:n20 \15\:VSS VSS) g45n1svt w=(1.45e-07) l=4.5e-08 \
        nf=1 as=5.19e-14 ad=3.915e-14 ps=1.6e-06 pd=8.3e-07 nrd=1.16667 \
        nrs=1.16667 sa=1.155e-06 sb=1.185e-06 sd=160n sca=23.279 \
        scb=0.0230742 scc=0.00267719 m=(1)
mn40 (\7\:n30 \5\:CKbb \4\:mout VSS) g45n1svt w=(1.45e-07) l=4.5e-08 nf=1 \
        as=3.915e-14 ad=2.755e-14 ps=8.3e-07 pd=6.7e-07 nrd=1.16667 \
        nrs=1.16667 sa=1.47e-06 sb=8.7e-07 sd=160n sca=23.279 \
        scb=0.0230742 scc=0.00267719 m=(1)
mn51 (\7\:n30 \6\:CKb n35 VSS) g45n1svt w=(1.45e-07) l=4.5e-08 nf=1 \
        as=2.682e-14 ad=2.755e-14 ps=6.6e-07 pd=6.7e-07 nrd=1.16667 \
        nrs=1.16667 sa=1.705e-06 sb=6.35e-07 sd=160n sca=23.279 \
        scb=0.0230742 scc=0.00267719 m=(1)
mn50 (n35 \3\:qbint \13\:VSS VSS) g45n1svt w=(1.45e-07) l=4.5e-08 nf=1 \
        as=4.03e-14 ad=2.682e-14 ps=8.5e-07 pd=6.6e-07 nrd=1.16667 \
        nrs=1.16667 sa=1.935e-06 sb=4.05e-07 sd=160n sca=23.279 \
        scb=0.0230742 scc=0.00267719 m=(1)
mn20 (\13\:CKb \3\:CK \1\:VSS VSS) g45n1svt w=(1.45e-07) l=4.5e-08 nf=1 \
        as=7.89e-14 ad=2.465e-14 ps=1.88e-06 pd=6.3e-07 nrd=1.16667 \
        nrs=1.16667 sa=1.7e-07 sb=1.715e-06 sd=160n sca=21.4614 \
        scb=0.0218523 scc=0.00230065 m=(1)
mn56 (\11\:qint \13\:qbint \1\:VSS VSS) g45n1svt w=(1.45e-07) l=4.5e-08 \
        nf=1 as=6.49e-14 ad=3.263e-14 ps=1.09e-06 pd=7.4e-07 nrd=1.16667 \
        nrs=1.16667 sa=1.66e-06 sb=2.25e-07 sd=160n sca=21.4614 \
        scb=0.0218523 scc=0.00230065 m=(1)
mn45 (\18\:qbint \3\:n30 \13\:VSS VSS) g45n1svt w=(2.05e-07) l=4.5e-08 \
        nf=1 as=4.03e-14 ad=2.87e-14 ps=8.5e-07 pd=6.9e-07 nrd=1.16667 \
        nrs=1.16667 sa=1.45561e-06 sb=1.4e-07 sd=160n sca=19.867 \
        scb=0.0198061 scc=0.00201945 m=(1)
mn55 (\1\:Q \5\:qbint \1\:VSS VSS) g45n1svt w=(2.6e-07) l=4.5e-08 nf=1 \
        as=9.575e-14 ad=4.68e-14 ps=1.8e-06 pd=8.8e-07 nrd=1.16667 \
        nrs=1.16667 sa=3.31442e-07 sb=1.21519e-06 sd=160n sca=16.3874 \
        scb=0.0162972 scc=0.00139495 m=(2)
mn57_1__rcx (\4\:QN qint \1\:VSS VSS) g45n1svt w=(2.6e-07) l=4.5e-08 \
        nf=1 as=8.875e-14 ad=5.46e-14 ps=1.405e-06 pd=9.4e-07 nrd=1.16667 \
        nrs=1.16667 sa=8.91442e-07 sb=6.55192e-07 sd=160n sca=16.3874 \
        scb=0.0162972 scc=0.00139495 m=(2)
mp45 (\24\:qbint n30 \15\:VDD VDD) g45p1svt w=(3.1e-07) l=4.5e-08 nf=1 \
        as=9.65e-14 ad=4.34e-14 ps=1.64e-06 pd=9e-07 nrd=1.16667 \
        nrs=1.16667 sa=1.43355e-06 sb=1.4e-07 sd=160n sca=13.6224 \
        scb=0.0125368 scc=0.000630866 m=(1)
mp55 (\3\:Q \5\:qbint \1\:VDD VDD) g45p1svt w=(3.9e-07) l=4.5e-08 nf=1 \
        as=1.0105e-13 ad=7.02e-14 ps=1.37e-06 pd=1.14e-06 nrd=1.16667 \
        nrs=1.16667 sa=3.46731e-07 sb=1.03455e-06 sd=160n sca=30.5009 \
        scb=0.0202006 scc=0.00336097 m=(2)
mp57_1__rcx (\1\:QN qint \1\:VDD VDD) g45p1svt w=(3.9e-07) l=4.5e-08 \
        nf=1 as=8.922e-14 ad=6.24e-14 ps=1.26e-06 pd=1.1e-06 nrd=1.16667 \
        nrs=1.16667 sa=9.06731e-07 sb=4.74551e-07 sd=160n sca=30.5009 \
        scb=0.0202006 scc=0.00336097 m=(2)
ends DFFX2
// End of subcircuit definition.
