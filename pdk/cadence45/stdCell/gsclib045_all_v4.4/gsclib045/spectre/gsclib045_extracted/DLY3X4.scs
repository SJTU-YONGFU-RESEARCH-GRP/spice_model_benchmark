// Generated for: spectre (May  1 08:10:13 2013 )
// Library name: gsclib045
// Cell name: DLY3X4
// View name: extracted

simulator lang=spectre

subckt DLY3X4 A VDD VSS Y
mp2 (\9\:n1 \1\:VSS n8 VDD) g45p1svt w=(2.15e-07) l=4.5e-08 nf=1 \
        as=2.902e-14 ad=3.01e-14 ps=7e-07 pd=7.1e-07 nrd=1.16667 \
        nrs=1.16667 sa=1.4e-07 sb=8.8e-07 sd=160n sca=23.8898 \
        scb=0.0257238 scc=0.00168255 m=(1)
mp1 (n8 \2\:n0 \35\:VDD VDD) g45p1svt w=(2.15e-07) l=4.5e-08 nf=1 \
        as=3.44e-14 ad=2.902e-14 ps=7.5e-07 pd=7e-07 nrd=1.16667 \
        nrs=1.16667 sa=3.2e-07 sb=7e-07 sd=160n sca=20.5436 scb=0.0200303 \
        scc=0.00154452 m=(1)
mp3 (n10 \4\:n1 \35\:VDD VDD) g45p1svt w=(2.15e-07) l=4.5e-08 nf=1 \
        as=3.44e-14 ad=6.665e-14 ps=7.5e-07 pd=1.05e-06 nrd=1.16667 \
        nrs=1.16667 sa=5.25e-07 sb=4.95e-07 sd=160n sca=19.1751 \
        scb=0.0185424 scc=0.00153893 m=(1)
mp4 (\8\:n2 \3\:VSS n10 VDD) g45p1svt w=(2.15e-07) l=4.5e-08 nf=1 \
        as=6.665e-14 ad=3.01e-14 ps=1.05e-06 pd=7.1e-07 nrd=1.16667 \
        nrs=1.16667 sa=8.8e-07 sb=1.4e-07 sd=160n sca=18.4975 \
        scb=0.0182651 scc=0.0015388 m=(1)
mp0 (\6\:n0 \4\:A \33\:VDD VDD) g45p1svt w=(2.15e-07) l=4.5e-08 nf=1 \
        as=3.44e-14 ad=3.01e-14 ps=7.5e-07 pd=7.1e-07 nrd=1.16667 \
        nrs=1.16667 sa=1.4e-07 sb=6.32326e-07 sd=160n sca=15.6338 \
        scb=0.015455 scc=0.000959319 m=(1)
mp5 (n12 n2 \33\:VDD VDD) g45p1svt w=(2.15e-07) l=4.5e-08 nf=1 \
        as=3.44e-14 ad=5.59e-14 ps=7.5e-07 pd=9.5e-07 nrd=1.16667 \
        nrs=1.16667 sa=3.45e-07 sb=4.27326e-07 sd=160n sca=15.6338 \
        scb=0.015455 scc=0.000959319 m=(1)
mp6 (\8\:n3 \5\:VSS n12 VDD) g45p1svt w=(2.15e-07) l=4.5e-08 nf=1 \
        as=5.59e-14 ad=2.63e-14 ps=9.5e-07 pd=7.1e-07 nrd=1.16667 \
        nrs=1.16667 sa=6.5e-07 sb=1.22326e-07 sd=160n sca=15.6338 \
        scb=0.015455 scc=0.000959319 m=(1)
mp7 (n14 n3 \15\:VDD VDD) g45p1svt w=(2.15e-07) l=4.5e-08 nf=1 \
        as=9.167e-14 ad=1.29e-14 ps=1.47e-06 pd=5.5e-07 nrd=1.16667 \
        nrs=1.16667 sa=1.10686e-06 sb=2.45e-07 sd=160n sca=22.8495 \
        scb=0.0214046 scc=0.00242442 m=(1)
mp8 (\7\:n4 \8\:VSS n14 VDD) g45p1svt w=(2.15e-07) l=4.5e-08 nf=1 \
        as=1.29e-14 ad=3.01e-14 ps=5.5e-07 pd=7.1e-07 nrd=1.16667 \
        nrs=1.16667 sa=1.21186e-06 sb=1.4e-07 sd=160n sca=22.8495 \
        scb=0.0214046 scc=0.00242442 m=(1)
mp9 (n16 n4 \22\:VDD VDD) g45p1svt w=(2.15e-07) l=4.5e-08 nf=1 \
        as=1.0415e-13 ad=1.29e-14 ps=1.56e-06 pd=5.5e-07 nrd=1.16667 \
        nrs=1.16667 sa=5.75e-07 sb=2.45e-07 sd=160n sca=17.1405 \
        scb=0.0165101 scc=0.000961221 m=(1)
mp10 (\7\:n5 \10\:VSS n16 VDD) g45p1svt w=(2.15e-07) l=4.5e-08 nf=1 \
        as=1.29e-14 ad=3.01e-14 ps=5.5e-07 pd=7.1e-07 nrd=1.16667 \
        nrs=1.16667 sa=6.8e-07 sb=1.4e-07 sd=160n sca=18.2098 \
        scb=0.0180238 scc=0.000972287 m=(1)
C1 (Y VSS) capacitor c=3.25246e-16
C2 (A VSS) capacitor c=4.46454e-17
C3 (VDD VSS) capacitor c=2.68081e-16
C4 (n1 VSS) capacitor c=9.15724e-17
C5 (n0 VSS) capacitor c=3.87798e-17
C6 (n9 VSS) capacitor c=7.26019e-19
C7 (n2 VSS) capacitor c=6.02824e-17
C8 (n11 VSS) capacitor c=1.08923e-18
C9 (n3 VSS) capacitor c=7.61519e-17
C10 (n6 VSS) capacitor c=2.37615e-16
C11 (n13 VSS) capacitor c=4.89877e-18
C12 (n4 VSS) capacitor c=9.96547e-17
C13 (n5 VSS) capacitor c=4.88244e-17
C14 (n15 VSS) capacitor c=1.91808e-19
C15 (n8 VSS) capacitor c=3.4105e-18
C16 (n10 VSS) capacitor c=1.46957e-18
C17 (n12 VSS) capacitor c=2.47056e-18
C18 (\3\:n5 VSS) capacitor c=5.16677e-17
C19 (\4\:A VSS) capacitor c=3.84771e-17
C20 (\4\:n1 VSS) capacitor c=4.01437e-17
C21 (\2\:n0 VSS) capacitor c=1.16124e-16
C22 (\9\:VDD VSS) capacitor c=4.55286e-17
C23 (\2\:n4 VSS) capacitor c=5.44927e-17
C24 (\7\:VDD VSS) capacitor c=4.78561e-17
C25 (\2\:n3 VSS) capacitor c=2.27426e-17
C26 (\5\:VDD VSS) capacitor c=5.85805e-17
C27 (\2\:n2 VSS) capacitor c=5.59928e-17
C28 (\3\:A VSS) capacitor c=3.38833e-17
C29 (\3\:VDD VSS) capacitor c=5.85448e-17
C30 (\3\:n0 VSS) capacitor c=1.00136e-16
C31 (\1\:VDD VSS) capacitor c=5.80815e-17
C32 (\10\:VDD VSS) capacitor c=4.91631e-17
C33 (\3\:n4 VSS) capacitor c=3.2509e-17
C34 (\4\:n5 VSS) capacitor c=3.29996e-17
C35 (\8\:VDD VSS) capacitor c=4.89942e-17
C36 (\3\:n3 VSS) capacitor c=2.03316e-17
C37 (\9\:n6 VSS) capacitor c=1.6592e-17
C38 (\6\:VDD VSS) capacitor c=4.64086e-17
C39 (\3\:n2 VSS) capacitor c=2.9458e-17
C40 (\1\:A VSS) capacitor c=2.36839e-17
C41 (\4\:VDD VSS) capacitor c=4.27378e-17
C42 (\3\:n1 VSS) capacitor c=2.75374e-17
C43 (\2\:VDD VSS) capacitor c=4.38253e-17
C44 (\7\:n5 VSS) capacitor c=9.82696e-17
C45 (\22\:VDD VSS) capacitor c=4.41016e-17
C46 (\16\:n6 VSS) capacitor c=1.5094e-16
C47 (\7\:n4 VSS) capacitor c=1.02001e-16
C48 (\8\:n3 VSS) capacitor c=5.90933e-17
C49 (\33\:VDD VSS) capacitor c=4.20954e-17
C50 (\6\:n0 VSS) capacitor c=1.07742e-16
C51 (\8\:n2 VSS) capacitor c=8.35695e-17
C52 (\35\:VDD VSS) capacitor c=7.75224e-17
C53 (\9\:n1 VSS) capacitor c=1.82376e-17
C54 (\11\:VDD VSS) capacitor c=7.18785e-17
C55 (\5\:n5 VSS) capacitor c=8.76659e-17
C56 (\18\:n6 VSS) capacitor c=1.03643e-16
C57 (\5\:n4 VSS) capacitor c=2.0265e-16
C58 (\6\:n3 VSS) capacitor c=2.93234e-17
C59 (\4\:n0 VSS) capacitor c=7.2857e-17
C60 (\6\:n2 VSS) capacitor c=4.30493e-17
C61 (\7\:n1 VSS) capacitor c=6.3303e-17
C62 (\2\:n1 VSS) capacitor c=4.66308e-17
C63 (\2\:A VSS) capacitor c=1.84648e-17
C64 (\2\:n5 VSS) capacitor c=2.80062e-17
C65 (\5\:n1 VSS) capacitor c=7.28546e-17
C66 (\6\:n1 VSS) capacitor c=6.38784e-17
C67 (\8\:n0 VSS) capacitor c=7.04176e-17
C68 (\5\:A VSS) capacitor c=6.84446e-17
C69 (\4\:n2 VSS) capacitor c=5.56967e-17
C70 (\5\:n2 VSS) capacitor c=8.86311e-17
C71 (\4\:n3 VSS) capacitor c=2.11623e-16
C72 (\5\:n3 VSS) capacitor c=1.93297e-16
C73 (\15\:n6 VSS) capacitor c=1.25744e-16
C74 (\4\:n4 VSS) capacitor c=1.45032e-16
C75 (\9\:n5 VSS) capacitor c=6.14717e-17
C76 (\13\:VDD VSS) capacitor c=1.57295e-17
C77 (\15\:VDD VSS) capacitor c=2.169e-16
C78 (\18\:VDD VSS) capacitor c=6.74666e-18
C79 (\19\:VDD VSS) capacitor c=1.13333e-17
C80 (\21\:VDD VSS) capacitor c=1.78814e-17
C81 (\24\:VDD VSS) capacitor c=8.65947e-17
C82 (\25\:VDD VSS) capacitor c=1.88106e-17
C83 (\32\:VDD VSS) capacitor c=4.80291e-17
C84 (\37\:VDD VSS) capacitor c=7.70258e-17
C85 (\38\:VDD VSS) capacitor c=7.03383e-17
C86 (\39\:VDD VSS) capacitor c=7.89878e-17
Rk25 (\12\:VSS \13\:VSS) resistor r=0.06753 c=0
Rk26 (\13\:VSS \14\:VSS) resistor r=0.1902 c=0
Rk27 (\14\:VSS \15\:VSS) resistor r=0.3934 c=0
Rk28 (\15\:VSS \16\:VSS) resistor r=0.04997 c=0
Rk29 (\16\:VSS \17\:VSS) resistor r=0.1403 c=0
Rk32 (\17\:VSS \20\:VSS) resistor r=0.0874 c=0
Rk33 (\20\:VSS \21\:VSS) resistor r=0.1793 c=0
Rk34 (\21\:VSS \22\:VSS) resistor r=0.207 c=0
Rk35 (\22\:VSS \23\:VSS) resistor r=0.1603 c=0
Rk36 (\23\:VSS \24\:VSS) resistor r=0.07987 c=0
Rk38 (\25\:VSS VSS) resistor r=0.09236 c=0
Rk37 (\24\:VSS \25\:VSS) resistor r=0.2178 c=0
Rk39 (\13\:VSS \26\:VSS) resistor r=0.6834 c=0
Rk40 (\14\:VSS \28\:VSS) resistor r=0.237 c=0
Rk41 (\15\:VSS \29\:VSS) resistor r=0.6114 c=0
Rk45 (\20\:VSS \36\:VSS) resistor r=0.5823 c=0
Rk46 (\21\:VSS \38\:VSS) resistor r=0.04332 c=0
Rk47 (\23\:VSS \39\:VSS) resistor r=0.7478 c=0
Rk48 (\24\:VSS \41\:VSS) resistor r=0.2622 c=0
Rk49 (\25\:VSS \42\:VSS) resistor r=0.5645 c=0
Rk6 (\5\:A A) resistor r=0.07297 c=0
Rk50 (\12\:VDD \13\:VDD) resistor r=0.356 c=0
Rk51 (\13\:VDD \14\:VDD) resistor r=0.3459 c=0
Rk52 (\14\:VDD \15\:VDD) resistor r=0.208 c=0
Rk55 (\15\:VDD \18\:VDD) resistor r=0.2479 c=0
Rk56 (\18\:VDD \19\:VDD) resistor r=0.1075 c=0
Rk57 (\19\:VDD \20\:VDD) resistor r=0.2281 c=0
Rk59 (\21\:VDD VDD) resistor r=0.288 c=0
Rk58 (\20\:VDD \21\:VDD) resistor r=0.2632 c=0
Rk60 (\13\:VDD \23\:VDD) resistor r=0.2927 c=0
Rk61 (\23\:VDD \24\:VDD) resistor r=0.3931 c=0
Rk62 (\24\:VDD \25\:VDD) resistor r=0.06622 c=0
Rk66 (\18\:VDD \32\:VDD) resistor r=0.5025 c=0
Rk67 (\19\:VDD \34\:VDD) resistor r=0.3918 c=0
Rk68 (\21\:VDD \36\:VDD) resistor r=0.3521 c=0
Rk69 (\36\:VDD \37\:VDD) resistor r=0.4008 c=0
Rk70 (\37\:VDD \38\:VDD) resistor r=0.3206 c=0
Rk71 (\24\:VDD \39\:VDD) resistor r=0.3785 c=0
Rk1 (\5\:n1 \6\:n1) resistor r=0.3436 c=0
Rk2 (\6\:n1 \8\:n1) resistor r=0.4134 c=0
Rk3 (\6\:n1 \10\:n1) resistor r=0.02292 c=0
Rk4 (\5\:n0 \7\:n0) resistor r=0.3899 c=0
Rk5 (\7\:n0 \8\:n0) resistor r=0.6089 c=0
Rk7 (\4\:n2 \5\:n2) resistor r=0.4021 c=0
Rk8 (\5\:n2 \7\:n2) resistor r=0.1355 c=0
Rk9 (\5\:n2 \9\:n2) resistor r=0.517 c=0
Rk16 (\4\:n3 \5\:n3) resistor r=1.5123 c=0
Rk17 (\5\:n3 \7\:n3) resistor r=0.06035 c=0
Rk18 (\5\:n3 \9\:n3) resistor r=0.3849 c=0
Rk19 (\15\:n6 \17\:n6) resistor r=0.9667 c=0
Rk20 (\17\:n6 \19\:n6) resistor r=0.4137 c=0
Rk21 (\4\:n4 \6\:n4) resistor r=1.0255 c=0
Rk22 (\6\:n4 \8\:n4) resistor r=0.5622 c=0
Rk23 (\6\:n5 \8\:n5) resistor r=0.689 c=0
Rk24 (\8\:n5 \9\:n5) resistor r=0.3794 c=0
Rl40 (\9\:VSS \10\:VSS) resistor r=90.3618 c=0
Rl32 (\7\:VSS \8\:VSS) resistor r=57.6695 c=0
Rl16 (\6\:VSS \5\:VSS) resistor r=71.8456 c=0
Rl9 (\4\:VSS \3\:VSS) resistor r=24.2328 c=0
Rl1 (\2\:VSS \1\:VSS) resistor r=66.0234 c=0
Rl12 (\2\:A \4\:A) resistor r=97.7911 c=0
Rl11 (\2\:A \3\:A) resistor r=34.3295 c=0
Rl10 (\1\:A \2\:A) resistor r=1.2713 c=0
Rl39 (\10\:VDD \9\:VDD) resistor r=95.1508 c=0
Rl33 (\8\:VDD \7\:VDD) resistor r=189.898 c=0
Rl15 (\6\:VDD \5\:VDD) resistor r=87.6944 c=0
Rl8 (\4\:VDD \3\:VDD) resistor r=87.6944 c=0
Rl2 (\2\:VDD \1\:VDD) resistor r=47.3097 c=0
Rl5 (\2\:n1 \4\:n1) resistor r=34.3295 c=0
Rl3 (n1 \2\:n1) resistor r=180.049 c=0
Rl4 (\2\:n1 \3\:n1) resistor r=2.0166 c=0
Rl7 (\2\:n0 \3\:n0) resistor r=222.643 c=0
Rl6 (n0 \2\:n0) resistor r=189.898 c=0
Rl13 (n2 \2\:n2) resistor r=140.385 c=0
Rl14 (\2\:n2 \3\:n2) resistor r=24.2328 c=0
Rl30 (n3 \2\:n3) resistor r=153.846 c=0
Rl31 (\2\:n3 \3\:n3) resistor r=24.2328 c=0
Rl24 (n6 \9\:n6) resistor r=10.3526 c=0
Rl37 (n4 \2\:n4) resistor r=216.534 c=0
Rl38 (\2\:n4 \3\:n4) resistor r=24.2328 c=0
Rl35 (\2\:n5 \3\:n5) resistor r=90.3625 c=0
Rl34 (n5 \2\:n5) resistor r=90.0661 c=0
Rl36 (\2\:n5 \4\:n5) resistor r=34.5407 c=0
Rz10 (\28\:VSS \27\:VSS) resistor r=75 c=0
Rz14 (\38\:VSS \37\:VSS) resistor r=75 c=0
Rz15 (\41\:VSS \40\:VSS) resistor r=75 c=0
Rz16 (\12\:VDD \11\:VDD) resistor r=37.5 c=0
Rz17 (\14\:VDD \11\:VDD) resistor r=6.25 c=0
Rz18 (\20\:VDD \11\:VDD) resistor r=6.25 c=0
Rz1 (\7\:n1 \8\:n1) resistor r=75 c=0
Rz2 (\4\:n0 \5\:n0) resistor r=75 c=0
Rz3 (\6\:n2 \7\:n2) resistor r=75 c=0
Rz6 (\6\:n3 \7\:n3) resistor r=75 c=0
Rz7 (\19\:n6 \18\:n6) resistor r=75 c=0
Rz8 (\5\:n4 \6\:n4) resistor r=75 c=0
Rz9 (\5\:n5 \6\:n5) resistor r=75 c=0
Ry10 (\12\:VSS \11\:VSS) resistor r=31 c=0
Ry11 (\16\:VSS \11\:VSS) resistor r=5.1667 c=0
Ry12 (\22\:VSS \11\:VSS) resistor r=5.1667 c=0
Ry13 (\23\:VDD \22\:VDD) resistor r=62 c=0
Ry17 (\34\:VDD \33\:VDD) resistor r=62 c=0
Ry18 (\36\:VDD \35\:VDD) resistor r=62 c=0
Ry1 (\9\:n1 \10\:n1) resistor r=62 c=0
Ry2 (\6\:n0 \7\:n0) resistor r=62 c=0
Ry3 (\8\:n2 \9\:n2) resistor r=62 c=0
Ry6 (\8\:n3 \9\:n3) resistor r=62 c=0
Ry7 (\17\:n6 \16\:n6) resistor r=20.6667 c=0
Ry8 (\7\:n4 \8\:n4) resistor r=62 c=0
Ry9 (\7\:n5 \8\:n5) resistor r=62 c=0
Rx9 (\26\:VSS \9\:VSS) resistor r=45 c=0
Rx10 (\29\:VSS \7\:VSS) resistor r=45 c=0
Rx11 (\36\:VSS \6\:VSS) resistor r=45 c=0
Rx12 (\39\:VSS \4\:VSS) resistor r=45 c=0
Rx13 (\42\:VSS \2\:VSS) resistor r=45 c=0
Rx3 (\1\:A \5\:A) resistor r=45 c=0
Rx14 (\25\:VDD \8\:VDD) resistor r=45 c=0
Rx15 (\32\:VDD \6\:VDD) resistor r=45 c=0
Rx16 (\37\:VDD \4\:VDD) resistor r=45 c=0
Rx17 (\38\:VDD \2\:VDD) resistor r=45 c=0
Rx18 (\39\:VDD \10\:VDD) resistor r=45 c=0
Rx1 (\3\:n1 \5\:n1) resistor r=45 c=0
Rx2 (n0 \8\:n0) resistor r=45 c=0
Rx4 (\3\:n2 \4\:n2) resistor r=45 c=0
Rx5 (\3\:n3 \4\:n3) resistor r=45 c=0
Rx6 (\15\:n6 \9\:n6) resistor r=45 c=0
Rx7 (\3\:n4 \4\:n4) resistor r=45 c=0
Rx8 (\4\:n5 \9\:n5) resistor r=45 c=0
mn2 (\7\:n1 \1\:VDD n7 VSS) g45n1svt w=(1.45e-07) l=4.5e-08 nf=1 \
        as=8.7e-15 ad=6.163e-14 ps=4.1e-07 pd=1.14e-06 nrd=1.16667 \
        nrs=1.16667 sa=4.25e-07 sb=5.65e-07 sd=160n sca=8.55924 \
        scb=0.0065649 scc=0.000116351 m=(1)
mn1 (n7 \3\:n0 \40\:VSS VSS) g45n1svt w=(1.45e-07) l=4.5e-08 nf=1 \
        as=2.32e-14 ad=8.7e-15 ps=6.1e-07 pd=4.1e-07 nrd=1.16667 \
        nrs=1.16667 sa=5.3e-07 sb=4.6e-07 sd=160n sca=8.55924 \
        scb=0.0065649 scc=0.000116351 m=(1)
mn3 (n9 n1 \40\:VSS VSS) g45n1svt w=(1.45e-07) l=4.5e-08 nf=1 \
        as=2.32e-14 ad=8.7e-15 ps=6.1e-07 pd=4.1e-07 nrd=1.16667 \
        nrs=1.16667 sa=7.35e-07 sb=2.55e-07 sd=160n sca=8.55924 \
        scb=0.0065649 scc=0.000116351 m=(1)
mn4 (\6\:n2 \3\:VDD n9 VSS) g45n1svt w=(1.45e-07) l=4.5e-08 nf=1 \
        as=8.7e-15 ad=2.175e-14 ps=4.1e-07 pd=5.9e-07 nrd=1.16667 \
        nrs=1.16667 sa=8.4e-07 sb=1.5e-07 sd=160n sca=8.55924 \
        scb=0.0065649 scc=0.000116351 m=(1)
mn0 (\4\:n0 \3\:A \37\:VSS VSS) g45n1svt w=(1.45e-07) l=4.5e-08 nf=1 \
        as=5.335e-14 ad=2.465e-14 ps=1.62e-06 pd=6.3e-07 nrd=1.16667 \
        nrs=1.16667 sa=1.7e-07 sb=6.2e-07 sd=160n sca=23.279 scb=0.0230742 \
        scc=0.00267719 m=(1)
mn5 (n11 \2\:n2 \37\:VSS VSS) g45n1svt w=(1.45e-07) l=4.5e-08 nf=1 \
        as=5.335e-14 ad=1.957e-14 ps=1.62e-06 pd=5.6e-07 nrd=1.16667 \
        nrs=1.16667 sa=3.75e-07 sb=4.15e-07 sd=160n sca=23.279 \
        scb=0.0230742 scc=0.00267719 m=(1)
mn6 (\6\:n3 \5\:VDD n11 VSS) g45n1svt w=(1.45e-07) l=4.5e-08 nf=1 \
        as=1.957e-14 ad=3.407e-14 ps=5.6e-07 pd=7.6e-07 nrd=1.16667 \
        nrs=1.16667 sa=5.55e-07 sb=2.35e-07 sd=160n sca=23.279 \
        scb=0.0230742 scc=0.00267719 m=(1)
mn7 (n13 \2\:n3 \17\:VSS VSS) g45n1svt w=(1.45e-07) l=4.5e-08 nf=1 \
        as=6.297e-14 ad=3.48e-14 ps=1.23e-06 pd=7.7e-07 nrd=1.16667 \
        nrs=1.16667 sa=1.175e-06 sb=4.25e-07 sd=160n sca=12.5912 \
        scb=0.0129007 scc=0.000589158 m=(1)
mn8 (\5\:n4 \7\:VDD n13 VSS) g45n1svt w=(1.45e-07) l=4.5e-08 nf=1 \
        as=3.48e-14 ad=2.03e-14 ps=7.7e-07 pd=5.7e-07 nrd=1.16667 \
        nrs=1.16667 sa=1.46e-06 sb=1.4e-07 sd=160n sca=12.5912 \
        scb=0.0129007 scc=0.000589158 m=(1)
mn9 (n15 \2\:n4 \27\:VSS VSS) g45n1svt w=(1.45e-07) l=4.5e-08 nf=1 \
        as=4.63e-14 ad=1.957e-14 ps=1e-06 pd=5.6e-07 nrd=1.16667 \
        nrs=1.16667 sa=6e-07 sb=4.55e-07 sd=160n sca=8.15925 \
        scb=0.00587019 scc=8.94977e-05 m=(1)
mn10 (\5\:n5 \9\:VDD n15 VSS) g45n1svt w=(1.45e-07) l=4.5e-08 nf=1 \
        as=1.957e-14 ad=3.988e-14 ps=5.6e-07 pd=8.4e-07 nrd=1.16667 \
        nrs=1.16667 sa=7.8e-07 sb=2.75e-07 sd=160n sca=8.15925 \
        scb=0.00587019 scc=8.94977e-05 m=(1)
mn11 (\18\:n6 n5 \27\:VSS VSS) g45n1svt w=(2.6e-07) l=4.5e-08 nf=1 \
        as=4.63e-14 ad=8.19e-14 ps=1e-06 pd=1.15e-06 nrd=1.16667 \
        nrs=1.16667 sa=3.15e-07 sb=4.56923e-07 sd=160n sca=10.5507 \
        scb=0.0097116 scc=0.000384728 m=(1)
mn12_1__rcx (Y n6 \17\:VSS VSS) g45n1svt w=(2.6e-07) l=4.5e-08 nf=1 \
        as=7.069e-14 ad=4.16e-14 ps=1.3975e-06 pd=8.4e-07 nrd=1.16667 \
        nrs=1.16667 sa=1.22115e-07 sb=1.17933e-06 sd=160n sca=10.3222 \
        scb=0.00938145 scc=0.000353946 m=(4)
mp11 (\16\:n6 \3\:n5 \22\:VDD VDD) g45p1svt w=(3.9e-07) l=4.5e-08 nf=1 \
        as=1.0415e-13 ad=5.46e-14 ps=1.56e-06 pd=1.06e-06 nrd=1.16667 \
        nrs=1.16667 sa=1.4e-07 sb=4.26923e-07 sd=160n sca=24.4353 \
        scb=0.0186618 scc=0.00260099 m=(1)
mp12_1__rcx (Y n6 \15\:VDD VDD) g45p1svt w=(3.9e-07) l=4.5e-08 nf=1 \
        as=6.507e-14 ad=6.24e-14 ps=1.1825e-06 pd=1.1e-06 nrd=1.16667 \
        nrs=1.16667 sa=1.12308e-07 sb=1.00994e-06 sd=160n sca=30.5009 \
        scb=0.0202006 scc=0.00336097 m=(4)
ends DLY3X4
// End of subcircuit definition.
