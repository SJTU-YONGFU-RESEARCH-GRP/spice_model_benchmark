// Generated for: spectre (May  1 08:11:49 2013 )
// Library name: gsclib045
// Cell name: LSHL_ISONH_X1_TO_ON
// View name: extracted

simulator lang=spectre

subckt LSHL_ISONH_X1_TO_ON A ISOn VDD VSS Y
mp0 (\9\:n0 \1\:A \6\:VDD VDD) g45p1svt w=(2.15e-07) l=4.5e-08 nf=1 \
        as=3.01e-14 ad=3.01e-14 ps=7.1e-07 pd=7.1e-07 nrd=1.16667 \
        nrs=1.16667 sa=1.4e-07 sb=1.4e-07 sd=160n sca=10.5181 \
        scb=0.00745996 scc=7.37045e-05 m=(1)
C1 (Y VSS) capacitor c=1.89698e-17
C2 (VDD VSS) capacitor c=1.40348e-16
C3 (A VSS) capacitor c=1.57667e-17
C4 (ISOn VSS) capacitor c=2.91659e-17
C5 (gatedVSS VSS) capacitor c=2.04666e-16
C6 (n0 VSS) capacitor c=5.16608e-17
C7 (\1\:ISOn VSS) capacitor c=6.21582e-17
C8 (\1\:A VSS) capacitor c=5.40091e-17
C9 (\4\:n0 VSS) capacitor c=2.79834e-17
C10 (\4\:A VSS) capacitor c=3.94291e-17
C11 (\3\:n0 VSS) capacitor c=3.3312e-17
C12 (\3\:A VSS) capacitor c=4.91436e-17
C13 (\6\:Y VSS) capacitor c=4.68581e-17
C14 (\1\:VDD VSS) capacitor c=1.01618e-16
C15 (\2\:Y VSS) capacitor c=1.2565e-16
C16 (\9\:n0 VSS) capacitor c=9.88542e-17
C17 (\6\:VDD VSS) capacitor c=3.5252e-17
C18 (\4\:Y VSS) capacitor c=5.1764e-17
C19 (\7\:gatedVSS VSS) capacitor c=3.8092e-17
C20 (\7\:n0 VSS) capacitor c=6.73693e-17
C21 (\2\:ISOn VSS) capacitor c=1.32272e-16
C22 (\6\:A VSS) capacitor c=5.76845e-18
C23 (\8\:A VSS) capacitor c=9.40504e-18
C24 (\6\:ISOn VSS) capacitor c=2.68466e-17
C25 (\5\:n0 VSS) capacitor c=5.70548e-17
C26 (\6\:n0 VSS) capacitor c=1.47618e-16
C27 (\1\:Y VSS) capacitor c=3.65655e-17
C28 (\4\:VDD VSS) capacitor c=2.77976e-17
C29 (\5\:VDD VSS) capacitor c=2.71154e-18
Rk13 (Y \1\:Y) resistor r=0.05047 c=0
Rk14 (\1\:Y \3\:Y) resistor r=0.5068 c=0
Rk15 (Y \5\:Y) resistor r=0.3148 c=0
Rk16 (\1\:Y \7\:Y) resistor r=0.2272 c=0
Rk21 (\2\:VSS VSS) resistor r=0.2983 c=0
Rk17 (\2\:VDD \4\:VDD) resistor r=0.5647 c=0
Rk19 (\5\:VDD VDD) resistor r=0.02961 c=0
Rk18 (\4\:VDD \5\:VDD) resistor r=0.09748 c=0
Rk20 (\5\:VDD \7\:VDD) resistor r=0.2536 c=0
Rk1 (\5\:A A) resistor r=0.0022 c=0
Rk2 (A \6\:A) resistor r=0.0022 c=0
Rk3 (\5\:A \6\:A) resistor r=0.03643 c=0
Rk5 (\6\:A \8\:A) resistor r=0.02537 c=0
Rk4 (\7\:A \8\:A) resistor r=0.0022 c=0
Rk6 (\6\:ISOn ISOn) resistor r=0.02942 c=0
Rk9 (gatedVSS \8\:gatedVSS) resistor r=0.08868 c=0
Rk10 (\5\:n0 \6\:n0) resistor r=0.3065 c=0
Rk11 (\6\:n0 \8\:n0) resistor r=0.7115 c=0
Rk12 (\6\:n0 \10\:n0) resistor r=0.4982 c=0
Rl1 (\1\:A \2\:A) resistor r=191.323 c=0
Rl3 (\2\:A \4\:A) resistor r=167.633 c=0
Rl2 (\2\:A \3\:A) resistor r=5.8309 c=0
Rl4 (\2\:ISOn \1\:ISOn) resistor r=119.395 c=0
Rl8 (n0 \2\:n0) resistor r=120.442 c=0
Rl10 (\2\:n0 \4\:n0) resistor r=47.7469 c=0
Rl9 (\2\:n0 \3\:n0) resistor r=0.6051 c=0
Rz6 (\4\:Y \5\:Y) resistor r=37.5 c=0
Rz8 (\2\:VSS \1\:VSS) resistor r=75 c=0
Rz2 (gatedVSS \3\:gatedVSS) resistor r=37.5 c=0
Rz4 (\8\:gatedVSS \7\:gatedVSS) resistor r=75 c=0
Rz5 (\7\:n0 \8\:n0) resistor r=75 c=0
Ry2 (\2\:Y \3\:Y) resistor r=20.6667 c=0
Ry3 (\6\:Y \7\:Y) resistor r=20.6667 c=0
Ry4 (\1\:VDD \2\:VDD) resistor r=20.6667 c=0
Ry5 (\6\:VDD \7\:VDD) resistor r=62 c=0
Ry1 (\9\:n0 \10\:n0) resistor r=62 c=0
Rx1 (\3\:A \7\:A) resistor r=45 c=0
Rx2 (\6\:ISOn \2\:ISOn) resistor r=45 c=0
Rx3 (\3\:n0 \5\:n0) resistor r=45 c=0
mn0 (\7\:gatedVSS \4\:A \7\:n0 VSS) g45n1svt w=(1.45e-07) l=4.5e-08 nf=1 \
        as=2.03e-14 ad=2.03e-14 ps=5.7e-07 pd=5.7e-07 nrd=1.16667 \
        nrs=1.16667 sa=1.4e-07 sb=1.4e-07 sd=160n sca=11.1906 \
        scb=0.0108717 scc=0.000387468 m=(1)
NM0 (\4\:Y \4\:n0 \3\:gatedVSS VSS) g45n1svt w=(2.6e-07) l=4.5e-08 nf=1 \
        as=3.64e-14 ad=3.64e-14 ps=8e-07 pd=8e-07 nrd=1.16667 nrs=1.16667 \
        sa=1.4e-07 sb=1.4e-07 sd=160n sca=9.32128 scb=0.00786794 \
        scc=0.000232361 m=(1)
NM3 (gatedVSS \2\:ISOn \1\:VSS VSS) g45n1svt w=(2.6e-07) l=4.5e-08 nf=1 \
        as=3.64e-14 ad=4.16e-14 ps=8e-07 pd=8.4e-07 nrd=1.16667 \
        nrs=1.16667 sa=1.4e-07 sb=3.45e-07 sd=160n sca=9.32128 \
        scb=0.00786794 scc=0.000232361 m=(2)
PM0 (\6\:Y n0 \1\:VDD VDD) g45p1svt w=(3.9e-07) l=4.5e-08 nf=1 \
        as=5.46e-14 ad=6.24e-14 ps=1.06e-06 pd=1.1e-06 nrd=1.16667 \
        nrs=1.16667 sa=3.45e-07 sb=1.4e-07 sd=160n sca=18.1342 \
        scb=0.0186365 scc=0.000647246 m=(1)
PM4 (\2\:Y \1\:ISOn \1\:VDD VDD) g45p1svt w=(3.9e-07) l=4.5e-08 nf=1 \
        as=6.24e-14 ad=5.46e-14 ps=1.1e-06 pd=1.06e-06 nrd=1.16667 \
        nrs=1.16667 sa=1.4e-07 sb=3.45e-07 sd=160n sca=14.6556 \
        scb=0.0128209 scc=0.000518831 m=(1)
ends LSHL_ISONH_X1_TO_ON
// End of subcircuit definition.
