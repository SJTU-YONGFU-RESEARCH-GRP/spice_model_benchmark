// Generated for: spectre (May  1 08:11:56 2013 )
// Library name: gsclib045
// Cell name: LSLH_ISOH_X1_TO_ON
// View name: extracted

simulator lang=spectre

subckt LSLH_ISOH_X1_TO_ON A ExtVDD ISO VDD VSS Y
PM2 (\7\:Ab \9\:A \4\:ExtVDD ExtVDD) g45p1svt w=(2.15e-07) l=4.5e-08 \
        nf=1 as=3.01e-14 ad=3.01e-14 ps=7.1e-07 pd=7.1e-07 nrd=1.16667 \
        nrs=1.16667 sa=1.4e-07 sb=1.4e-07 sd=160n sca=26.6894 scb=0.032469 \
        scc=0.00166949 m=(1)
PM0 (\11\:Ybint \4\:Yint \13\:VDD VDD) g45p1svt w=(2.15e-07) l=4.5e-08 \
        nf=1 as=3.01e-14 ad=3.01e-14 ps=7.1e-07 pd=7.1e-07 nrd=1.16667 \
        nrs=1.16667 sa=1.4e-07 sb=1.4e-07 sd=160n sca=23.0829 \
        scb=0.0252371 scc=0.00197374 m=(1)
PM5 (\16\:ison \1\:ISO \11\:VDD VDD) g45p1svt w=(2.15e-07) l=4.5e-08 \
        nf=1 as=3.01e-14 ad=3.01e-14 ps=7.1e-07 pd=7.1e-07 nrd=1.16667 \
        nrs=1.16667 sa=1.4e-07 sb=1.4e-07 sd=160n sca=9.3087 \
        scb=0.00624818 scc=6.7825e-05 m=(1)
PM1 (\11\:Yint Ybint \3\:VDD VDD) g45p1svt w=(2.15e-07) l=4.5e-08 nf=1 \
        as=3.01e-14 ad=3.01e-14 ps=7.1e-07 pd=7.1e-07 nrd=1.16667 \
        nrs=1.16667 sa=1.4e-07 sb=1.4e-07 sd=160n sca=7.11886 \
        scb=0.00384538 scc=3.76076e-05 m=(1)
C1 (ExtVDD VSS) capacitor c=6.63823e-17
C2 (VDD VSS) capacitor c=4.14811e-16
C3 (A VSS) capacitor c=1.99528e-17
C4 (ISO VSS) capacitor c=3.21703e-17
C5 (Y VSS) capacitor c=2.95105e-17
C6 (Yint VSS) capacitor c=3.70622e-17
C7 (Ab VSS) capacitor c=1.55271e-16
C8 (ison VSS) capacitor c=3.88998e-17
C9 (Ybint VSS) capacitor c=3.02148e-17
C10 (GatedVSS VSS) capacitor c=3.45876e-17
C11 (\6\:Ybint VSS) capacitor c=2.92527e-17
C12 (\1\:ISO VSS) capacitor c=2.53671e-17
C13 (\4\:Yint VSS) capacitor c=2.74063e-17
C14 (\9\:A VSS) capacitor c=4.92695e-17
C15 (\3\:Ybint VSS) capacitor c=2.54544e-17
C16 (\1\:A VSS) capacitor c=2.09495e-16
C17 (\4\:ISO VSS) capacitor c=5.78774e-17
C18 (\10\:A VSS) capacitor c=2.43985e-17
C19 (\5\:Ybint VSS) capacitor c=7.83673e-18
C20 (\2\:Y VSS) capacitor c=3.32218e-17
C21 (\1\:Y VSS) capacitor c=3.15728e-17
C22 (\2\:Ybint VSS) capacitor c=2.33337e-17
C23 (\11\:ison VSS) capacitor c=3.18547e-17
C24 (\6\:ison VSS) capacitor c=1.90128e-17
C25 (\3\:ISO VSS) capacitor c=5.32864e-17
C26 (\3\:Yint VSS) capacitor c=2.4391e-17
C27 (\2\:GatedVSS VSS) capacitor c=2.99406e-17
C28 (\4\:Ab VSS) capacitor c=6.12182e-17
C29 (\6\:A VSS) capacitor c=2.15167e-17
C30 (\6\:Y VSS) capacitor c=7.5736e-17
C31 (\1\:VDD VSS) capacitor c=9.06586e-17
C32 (\3\:Y VSS) capacitor c=4.56495e-17
C33 (\9\:VDD VSS) capacitor c=8.48334e-17
C34 (\3\:VDD VSS) capacitor c=5.17946e-17
C35 (\11\:Yint VSS) capacitor c=5.05319e-17
C36 (\16\:ison VSS) capacitor c=3.87127e-17
C37 (\11\:VDD VSS) capacitor c=4.72376e-17
C38 (\11\:Ybint VSS) capacitor c=8.50373e-17
C39 (\13\:VDD VSS) capacitor c=5.22012e-17
C40 (\7\:Ab VSS) capacitor c=8.57294e-17
C41 (\4\:ExtVDD VSS) capacitor c=3.51371e-17
C42 (\9\:Y VSS) capacitor c=3.88677e-17
C43 (\9\:GatedVSS VSS) capacitor c=9.86365e-17
C44 (\3\:GatedVSS VSS) capacitor c=3.33978e-16
C45 (\5\:Yint VSS) capacitor c=1.89063e-16
C46 (\13\:ison VSS) capacitor c=5.13933e-17
C47 (\10\:Ab VSS) capacitor c=6.32027e-17
C48 (\15\:GatedVSS VSS) capacitor c=1.09031e-16
C49 (ExtVDD VSS) capacitor c=3.05403e-17
C50 (VDD VSS) capacitor c=4.43533e-17
C51 (\2\:Yint VSS) capacitor c=2.51725e-17
C52 (\4\:A VSS) capacitor c=1.65128e-16
C53 (\5\:A VSS) capacitor c=2.24741e-17
C54 (\2\:ison VSS) capacitor c=1.47857e-16
C55 (\4\:Ybint VSS) capacitor c=8.75889e-18
C56 (\11\:A VSS) capacitor c=3.50815e-17
C57 (\3\:ExtVDD VSS) capacitor c=1.931e-17
C58 (\9\:Ab VSS) capacitor c=1.05248e-16
C59 (\8\:Yint VSS) capacitor c=3.85409e-17
C60 (\6\:ISO VSS) capacitor c=8.19401e-18
C61 (\8\:ISO VSS) capacitor c=2.55429e-17
C62 (\12\:ison VSS) capacitor c=5.839e-17
C63 (\13\:Yint VSS) capacitor c=3.31608e-17
C64 (\15\:ison VSS) capacitor c=4.81914e-17
C65 (\6\:GatedVSS VSS) capacitor c=8.12322e-17
C66 (\5\:Y VSS) capacitor c=4.68188e-17
C67 (\11\:GatedVSS VSS) capacitor c=4.06274e-16
C68 (\14\:GatedVSS VSS) capacitor c=1.87228e-16
C69 (\23\:GatedVSS VSS) capacitor c=1.03859e-16
C70 (\7\:Ybint VSS) capacitor c=5.30374e-17
C71 (\8\:Ybint VSS) capacitor c=1.74674e-16
C72 (\10\:Ybint VSS) capacitor c=6.22085e-17
C73 (\8\:Y VSS) capacitor c=6.68769e-17
C74 (\5\:VDD VSS) capacitor c=1.16858e-16
C75 (\7\:VDD VSS) capacitor c=2.8334e-17
C76 (\8\:VDD VSS) capacitor c=1.673e-17
Rk4 (\3\:ExtVDD ExtVDD) resistor r=0.02416 c=0
Rk3 (ExtVDD \3\:ExtVDD) resistor r=0.03424 c=0
Rk5 (\3\:ExtVDD \5\:ExtVDD) resistor r=0.2891 c=0
Rk54 (VDD VDD) resistor r=0.3051 c=0
Rk49 (\2\:VDD \4\:VDD) resistor r=0.5807 c=0
Rk50 (\4\:VDD \5\:VDD) resistor r=0.2409 c=0
Rk51 (\5\:VDD \7\:VDD) resistor r=0.2187 c=0
Rk53 (\8\:VDD VDD) resistor r=0.1845 c=0
Rk52 (\7\:VDD \8\:VDD) resistor r=0.03916 c=0
Rk55 (\5\:VDD \10\:VDD) resistor r=0.562 c=0
Rk56 (\8\:VDD \12\:VDD) resistor r=0.2568 c=0
Rk57 (VDD \14\:VDD) resistor r=0.2861 c=0
Rk1 (\11\:A A) resistor r=0.02681 c=0
Rk11 (\5\:ISO ISO) resistor r=0.004142 c=0
Rk12 (ISO \6\:ISO) resistor r=0.004142 c=0
Rk13 (\5\:ISO \6\:ISO) resistor r=0.007378 c=0
Rk15 (\6\:ISO \8\:ISO) resistor r=0.02927 c=0
Rk14 (\7\:ISO \8\:ISO) resistor r=0.004142 c=0
Rk45 (VSS VSS) resistor r=0.3173 c=0
Rk44 (\1\:VSS VSS) resistor r=0.2996 c=0
Rk59 (VSS VSS) resistor r=0.2779 c=0
Rk46 (VSS \7\:VSS) resistor r=0.07649 c=0
Rk58 (\13\:VSS VSS) resistor r=0.59 c=0
Rk60 (VSS \14\:VSS) resistor r=0.1158 c=0
Rk22 (\4\:Y \5\:Y) resistor r=0.2698 c=0
Rk38 (Y \7\:Y) resistor r=0.2113 c=0
Rk39 (\7\:Y \8\:Y) resistor r=0.519 c=0
Rk40 (Y \10\:Y) resistor r=0.2219 c=0
Rk9 (\5\:Yint \8\:Yint) resistor r=0.2013 c=0
Rk17 (\12\:Yint \13\:Yint) resistor r=0.2047 c=0
Rk6 (\8\:Ab \9\:Ab) resistor r=0.6836 c=0
Rk7 (\9\:Ab \11\:Ab) resistor r=0.4474 c=0
Rk16 (\12\:ison \14\:ison) resistor r=0.3822 c=0
Rk18 (\15\:ison \17\:ison) resistor r=0.2458 c=0
Rk32 (\7\:Ybint \8\:Ybint) resistor r=0.3016 c=0
Rk34 (\8\:Ybint \10\:Ybint) resistor r=0.152 c=0
Rk35 (\10\:Ybint \12\:Ybint) resistor r=0.5783 c=0
Rk20 (\3\:GatedVSS \6\:GatedVSS) resistor r=1.1462 c=0
Rk23 (\10\:GatedVSS \11\:GatedVSS) resistor r=0.6487 c=0
Rk26 (\11\:GatedVSS \14\:GatedVSS) resistor r=0.3563 c=0
Rk27 (\14\:GatedVSS \16\:GatedVSS) resistor r=0.7661 c=0
Rk31 (\14\:GatedVSS \23\:GatedVSS) resistor r=0.8124 c=0
Rl21 (\4\:A \9\:A) resistor r=239.672 c=0
Rl16 (\4\:A \1\:A) resistor r=494.483 c=0
Rl22 (\5\:A \10\:A) resistor r=59.022 c=0
Rl18 (\5\:A \6\:A) resistor r=46.4864 c=0
Rl17 (\5\:A \4\:A) resistor r=192.732 c=0
Rl2 (\1\:ISO \2\:ISO) resistor r=56.5719 c=0
Rl4 (\2\:ISO \4\:ISO) resistor r=193.396 c=0
Rl3 (\2\:ISO \3\:ISO) resistor r=0.6051 c=0
Rl33 (\1\:Y \2\:Y) resistor r=105.578 c=0
Rl12 (\2\:Yint \4\:Yint) resistor r=41.7694 c=0
Rl10 (\2\:Yint Yint) resistor r=148.662 c=0
Rl11 (\2\:Yint \3\:Yint) resistor r=34.5546 c=0
Rl7 (Ab \4\:Ab) resistor r=178.013 c=0
Rl23 (\2\:ison ison) resistor r=105.555 c=0
Rl32 (\2\:ison \11\:ison) resistor r=115.398 c=0
Rl27 (\2\:ison \6\:ison) resistor r=4.4574 c=0
Rl13 (\2\:Ybint Ybint) resistor r=58.6635 c=0
Rl36 (\4\:Ybint \6\:Ybint) resistor r=53.5603 c=0
Rl34 (\4\:Ybint \3\:Ybint) resistor r=53.5603 c=0
Rl35 (\4\:Ybint \5\:Ybint) resistor r=2.0166 c=0
Rl1 (\2\:GatedVSS GatedVSS) resistor r=171.167 c=0
Rz15 (\9\:Y \10\:Y) resistor r=37.5 c=0
Rz2 (\11\:Ab \10\:Ab) resistor r=75 c=0
Rz5 (\14\:ison \13\:ison) resistor r=75 c=0
Rz8 (\10\:GatedVSS \9\:GatedVSS) resistor r=37.5 c=0
Rz9 (\16\:GatedVSS \15\:GatedVSS) resistor r=75 c=0
Ry1 (\4\:ExtVDD \5\:ExtVDD) resistor r=62 c=0
Ry10 (\1\:VDD \2\:VDD) resistor r=20.6667 c=0
Ry11 (\3\:VDD \4\:VDD) resistor r=62 c=0
Ry12 (\9\:VDD \10\:VDD) resistor r=20.6667 c=0
Ry13 (\11\:VDD \12\:VDD) resistor r=62 c=0
Ry14 (\13\:VDD \14\:VDD) resistor r=62 c=0
Ry8 (\1\:VSS \3\:VSS) resistor r=7.75 c=0
Ry9 (\7\:VSS \3\:VSS) resistor r=5.1667 c=0
Ry15 (\13\:VSS \12\:VSS) resistor r=7.75 c=0
Ry16 (\14\:VSS \12\:VSS) resistor r=5.1667 c=0
Ry5 (\3\:Y \4\:Y) resistor r=20.6667 c=0
Ry7 (\6\:Y \7\:Y) resistor r=20.6667 c=0
Ry3 (\12\:Yint \11\:Yint) resistor r=62 c=0
Ry2 (\8\:Ab \7\:Ab) resistor r=62 c=0
Ry4 (\17\:ison \16\:ison) resistor r=62 c=0
Ry6 (\12\:Ybint \11\:Ybint) resistor r=62 c=0
Rx1 (\11\:A \6\:A) resistor r=45 c=0
Rx4 (\3\:ISO \7\:ISO) resistor r=45 c=0
Rx9 (\2\:Y \5\:Y) resistor r=45 c=0
Rx13 (\1\:Y \8\:Y) resistor r=45 c=0
Rx3 (\8\:Yint \3\:Yint) resistor r=45 c=0
Rx6 (\13\:Yint Yint) resistor r=45 c=0
Rx2 (\9\:Ab \4\:Ab) resistor r=45 c=0
Rx5 (\12\:ison \6\:ison) resistor r=45 c=0
Rx7 (\15\:ison \11\:ison) resistor r=45 c=0
Rx11 (\7\:Ybint \5\:Ybint) resistor r=45 c=0
Rx12 (\10\:Ybint \2\:Ybint) resistor r=45 c=0
Rx8 (\6\:GatedVSS \2\:GatedVSS) resistor r=45 c=0
Rx10 (\23\:GatedVSS GatedVSS) resistor r=45 c=0
NM2 (\15\:GatedVSS \10\:A \10\:Ab VSS) g45n1svt w=(1.45e-07) l=4.5e-08 \
        nf=1 as=2.03e-14 ad=2.03e-14 ps=5.7e-07 pd=5.7e-07 nrd=1.16667 \
        nrs=1.16667 sa=1.4e-07 sb=1.4e-07 sd=160n sca=12.9138 \
        scb=0.0133404 scc=0.000640143 m=(1)
NM4 (\1\:VSS \4\:ISO \13\:ison VSS) g45n1svt w=(1.45e-07) l=4.5e-08 nf=1 \
        as=4.365e-14 ad=2.03e-14 ps=9e-07 pd=5.7e-07 nrd=1.16667 \
        nrs=1.16667 sa=1.4e-07 sb=9.9e-07 sd=160n sca=8.42104 \
        scb=0.00632542 scc=0.000106623 m=(1)
mn0 (\9\:Y \3\:Ybint \9\:GatedVSS VSS) g45n1svt w=(2.6e-07) l=4.5e-08 \
        nf=1 as=3.64e-14 ad=3.64e-14 ps=8e-07 pd=8e-07 nrd=1.16667 \
        nrs=1.16667 sa=1.4e-07 sb=1.4e-07 sd=160n sca=15.3338 \
        scb=0.0153436 scc=0.00119435 m=(1)
NM1_1__rcx (\5\:Yint Ab \11\:GatedVSS VSS) g45n1svt w=(2.6e-07) l=4.5e-08 \
        nf=1 as=4.16e-14 ad=3.987e-14 ps=8.4e-07 pd=8.2667e-07 nrd=1.16667 \
        nrs=1.16667 sa=5.5e-07 sb=7.55e-07 sd=160n sca=15.3338 \
        scb=0.0153436 scc=0.00119435 m=(3)
NM0_1__rcx (\8\:Ybint \1\:A \11\:GatedVSS VSS) g45n1svt w=(2.6e-07) \
        l=4.5e-08 nf=1 as=3.987e-14 ad=4.16e-14 ps=8.2667e-07 pd=8.4e-07 \
        nrd=1.16667 nrs=1.16667 sa=7.55e-07 sb=5.5e-07 sd=160n sca=15.3338 \
        scb=0.0153436 scc=0.00119435 m=(3)
NM3_1__rcx (\3\:GatedVSS \2\:ison \1\:VSS VSS) g45n1svt w=(2.6e-07) \
        l=4.5e-08 nf=1 as=4.16e-14 ad=4.081e-14 ps=8.4e-07 pd=8.45e-07 \
        nrd=1.16667 nrs=1.16667 sa=2.71058e-07 sb=7.55e-07 sd=160n \
        sca=9.14564 scb=0.00759168 scc=0.000213449 m=(4)
PM4 (\3\:Y ison \9\:VDD VDD) g45p1svt w=(3.9e-07) l=4.5e-08 nf=1 \
        as=5.46e-14 ad=5.46e-14 ps=1.06e-06 pd=1.06e-06 nrd=1.16667 \
        nrs=1.16667 sa=1.4e-07 sb=1.4e-07 sd=160n sca=17.3671 \
        scb=0.0152308 scc=0.00148042 m=(1)
mp0 (\6\:Y \6\:Ybint \1\:VDD VDD) g45p1svt w=(3.9e-07) l=4.5e-08 nf=1 \
        as=5.46e-14 ad=5.46e-14 ps=1.06e-06 pd=1.06e-06 nrd=1.16667 \
        nrs=1.16667 sa=1.4e-07 sb=1.4e-07 sd=160n sca=29.3799 \
        scb=0.0313151 scc=0.00276721 m=(1)
ends LSLH_ISOH_X1_TO_ON
// End of subcircuit definition.
