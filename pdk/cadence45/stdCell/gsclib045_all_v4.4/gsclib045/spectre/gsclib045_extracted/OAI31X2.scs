// Generated for: spectre (May  1 08:17:27 2013 )
// Library name: gsclib045
// Cell name: OAI31X2
// View name: extracted

simulator lang=spectre

subckt OAI31X2 A0 A1 A2 B0 VDD VSS Y
mp0_1__rcx (2 \1\:A0 \9\:VDD VDD) g45p1svt w=(3.9e-07) l=4.5e-08 nf=1 \
        as=5.46e-14 ad=2.34e-14 ps=1.06e-06 pd=9e-07 nrd=1.16667 \
        nrs=1.16667 sa=1.4e-07 sb=1.505e-06 sd=160n sca=15.7135 \
        scb=0.0146768 scc=0.000444335 m=(1)
mp1_1__rcx (2 \1\:A1 4 VDD) g45p1svt w=(3.9e-07) l=4.5e-08 nf=1 \
        as=1.0335e-13 ad=2.34e-14 ps=1.31e-06 pd=9e-07 nrd=1.16667 \
        nrs=1.16667 sa=2.45e-07 sb=1.4e-06 sd=160n sca=14.3102 \
        scb=0.0124442 scc=0.000417178 m=(1)
mp2_1__rcx (\6\:Y \5\:A2 4 VDD) g45p1svt w=(3.9e-07) l=4.5e-08 nf=1 \
        as=1.0335e-13 ad=6.24e-14 ps=1.31e-06 pd=1.1e-06 nrd=1.16667 \
        nrs=1.16667 sa=5.55e-07 sb=1.09e-06 sd=160n sca=12.6509 \
        scb=0.0108992 scc=0.000412427 m=(1)
mp2 (\6\:Y \1\:A2 6 VDD) g45p1svt w=(3.9e-07) l=4.5e-08 nf=1 as=4.485e-14 \
        ad=6.24e-14 ps=1.01e-06 pd=1.1e-06 nrd=1.16667 nrs=1.16667 \
        sa=7.6e-07 sb=8.85e-07 sd=160n sca=12.3656 scb=0.0108222 \
        scc=0.000412413 m=(1)
mp1 (6 \4\:A1 7 VDD) g45p1svt w=(3.9e-07) l=4.5e-08 nf=1 as=5.07e-14 \
        ad=4.485e-14 ps=1.04e-06 pd=1.01e-06 nrd=1.16667 nrs=1.16667 \
        sa=9.2e-07 sb=7.25e-07 sd=160n sca=12.3656 scb=0.0108222 \
        scc=0.000412413 m=(1)
mp0 (7 \6\:A0 \1\:VDD VDD) g45p1svt w=(3.9e-07) l=4.5e-08 nf=1 \
        as=6.24e-14 ad=5.07e-14 ps=1.1e-06 pd=1.04e-06 nrd=1.16667 \
        nrs=1.16667 sa=1.095e-06 sb=5.5e-07 sd=160n sca=12.6936 \
        scb=0.0109155 scc=0.000412431 m=(1)
mp3_1__rcx (\4\:Y \3\:B0 \1\:VDD VDD) g45p1svt w=(3.9e-07) l=4.5e-08 \
        nf=1 as=5.85e-14 ad=6.24e-14 ps=1.08e-06 pd=1.1e-06 nrd=1.16667 \
        nrs=1.16667 sa=1.3e-06 sb=3.45e-07 sd=160n sca=13.5897 \
        scb=0.0115632 scc=0.000413321 m=(2)
C1 (A0 VSS) capacitor c=4.83815e-16
C2 (VDD VSS) capacitor c=1.03847e-16
C3 (A1 VSS) capacitor c=1.47342e-17
C4 (B0 VSS) capacitor c=6.98954e-17
C5 (Y VSS) capacitor c=1.68087e-17
C6 (A2 VSS) capacitor c=5.87288e-17
C7 (n0 VSS) capacitor c=2.98568e-16
C8 (2 VSS) capacitor c=9.07463e-20
C9 (4 VSS) capacitor c=9.96283e-20
C10 (6 VSS) capacitor c=4.04974e-18
C11 (7 VSS) capacitor c=4.86917e-18
C12 (\6\:A0 VSS) capacitor c=6.42477e-17
C13 (\4\:A1 VSS) capacitor c=7.08329e-17
C14 (\1\:A2 VSS) capacitor c=3.5653e-17
C15 (\5\:A2 VSS) capacitor c=2.98127e-17
C16 (\1\:A1 VSS) capacitor c=7.89405e-17
C17 (\1\:A0 VSS) capacitor c=8.10425e-17
C18 (\1\:B0 VSS) capacitor c=6.8658e-17
C19 (\2\:A2 VSS) capacitor c=3.06313e-17
C20 (\2\:A1 VSS) capacitor c=3.50224e-16
C21 (\1\:VDD VSS) capacitor c=1.12561e-16
C22 (\4\:Y VSS) capacitor c=9.73737e-17
C23 (\6\:Y VSS) capacitor c=6.63777e-17
C24 (\9\:VDD VSS) capacitor c=2.79916e-17
C25 (\1\:Y VSS) capacitor c=7.42012e-17
C26 (\3\:A2 VSS) capacitor c=1.06586e-16
C27 (\3\:B0 VSS) capacitor c=7.62188e-17
C28 (\7\:A2 VSS) capacitor c=6.53026e-17
C29 (\3\:Y VSS) capacitor c=6.93534e-17
C30 (\7\:B0 VSS) capacitor c=2.79612e-17
C31 (\5\:VDD VSS) capacitor c=2.73107e-17
C32 (\6\:VDD VSS) capacitor c=1.3573e-17
Rk19 (\1\:VDD \5\:VDD) resistor r=0.1748 c=0
Rk21 (\6\:VDD VDD) resistor r=0.1096 c=0
Rk20 (\5\:VDD \6\:VDD) resistor r=0.3899 c=0
Rk23 (\6\:VDD \10\:VDD) resistor r=0.291 c=0
Rk3 (\2\:A1 A1) resistor r=0.02427 c=0
Rk24 (VSS \1\:VSS) resistor r=0.1321 c=0
Rk27 (\1\:VSS \6\:VSS) resistor r=0.1015 c=0
Rk13 (\7\:B0 B0) resistor r=0.05078 c=0
Rk9 (\3\:Y Y) resistor r=0.01229 c=0
Rk7 (\2\:Y \3\:Y) resistor r=0.5074 c=0
Rk8 (\3\:Y \5\:Y) resistor r=0.02358 c=0
Rk10 (\5\:Y \7\:Y) resistor r=0.5598 c=0
Rk4 (A2 \7\:A2) resistor r=0.02393 c=0
Rl13 (A0 \6\:A0) resistor r=101.06 c=0
Rl1 (A0 \1\:A0) resistor r=111.004 c=0
Rl10 (\2\:A1 \4\:A1) resistor r=87.2302 c=0
Rl3 (\2\:A1 \1\:A1) resistor r=87.2302 c=0
Rl15 (\3\:B0 \1\:B0) resistor r=69.0037 c=0
Rl5 (\2\:A2 \1\:A2) resistor r=21.9779 c=0
Rl8 (\2\:A2 \5\:A2) resistor r=77.1158 c=0
Rl6 (\3\:A2 \2\:A2) resistor r=58.1371 c=0
Rz9 (\6\:VSS \5\:VSS) resistor r=75 c=0
Rz1 (\2\:Y \1\:Y) resistor r=75 c=0
Ry5 (\10\:VDD \9\:VDD) resistor r=20.6667 c=0
Ry1 (\5\:Y \4\:Y) resistor r=20.6667 c=0
Ry2 (\7\:Y \6\:Y) resistor r=62 c=0
Rx6 (\7\:B0 \1\:B0) resistor r=45 c=0
Rx3 (\7\:A2 \2\:A2) resistor r=45 c=0
mn3_1__rcx (\1\:Y \1\:B0 n0 VSS) g45n1svt w=(2.6e-07) l=4.5e-08 nf=1 \
        as=4.42e-14 ad=4.16e-14 ps=8.6e-07 pd=8.4e-07 nrd=1.16667 \
        nrs=1.16667 sa=1.59e-06 sb=3.45e-07 sd=160n sca=14.8545 \
        scb=0.0148797 scc=0.00110433 m=(2)
mn2 (n0 \3\:A2 \5\:VSS VSS) g45n1svt w=(2.6e-07) l=4.5e-08 nf=1 \
        as=9.26e-14 ad=4.16e-14 ps=1.55e-06 pd=8.4e-07 nrd=1.16667 \
        nrs=1.16667 sa=6.1e-07 sb=1.325e-06 sd=160n sca=14.8545 \
        scb=0.0148797 scc=0.00110433 m=(2)
mn0_1__rcx (n0 A0 \1\:VSS VSS) g45n1svt w=(2.6e-07) l=4.5e-08 nf=1 \
        as=9.26e-14 ad=4.42e-14 ps=1.55e-06 pd=8.6e-07 nrd=1.16667 \
        nrs=1.16667 sa=1.4e-07 sb=1.795e-06 sd=160n sca=14.8545 \
        scb=0.0148797 scc=0.00110433 m=(2)
mn1 (n0 \2\:A1 \1\:VSS VSS) g45n1svt w=(2.6e-07) l=4.5e-08 nf=1 \
        as=9.26e-14 ad=4.16e-14 ps=1.55e-06 pd=8.4e-07 nrd=1.16667 \
        nrs=1.16667 sa=4.05e-07 sb=1.53e-06 sd=160n sca=14.8545 \
        scb=0.0148797 scc=0.00110433 m=(2)
ends OAI31X2
// End of subcircuit definition.
