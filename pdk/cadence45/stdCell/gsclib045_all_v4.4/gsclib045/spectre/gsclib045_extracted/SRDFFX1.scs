// Generated for: spectre (May  1 08:12:50 2013 )
// Library name: gsclib045
// Cell name: SRDFFX1
// View name: extracted

simulator lang=spectre

subckt SRDFFX1 CK D ExtVDD Q QN RT SE SI VDD VSS
PM3 (\15\:n35g \4\:RTb net234 ExtVDD) g45p1svt w=(2.15e-07) l=4.5e-08 \
        nf=1 as=3.01e-14 ad=1.29e-14 ps=7.1e-07 pd=5.5e-07 nrd=1.16667 \
        nrs=1.16667 sa=8.7e-07 sb=1.4e-07 sd=160n sca=25.2796 \
        scb=0.0259458 scc=0.00265434 m=(1)
mp11 (n1 \4\:D \19\:VDD VDD) g45p1svt w=(2.15e-07) l=4.5e-08 nf=1 \
        as=1.362e-13 ad=1.29e-14 ps=2.93e-06 pd=5.5e-07 nrd=1.16667 \
        nrs=1.16667 sa=1.7e-07 sb=7.6e-07 sd=160n sca=15.238 scb=0.0153511 \
        scc=0.00103803 m=(1)
mp21 (\17\:CKbb \4\:CKb \19\:VDD VDD) g45p1svt w=(2.15e-07) l=4.5e-08 \
        nf=1 as=1.362e-13 ad=3.01e-14 ps=2.93e-06 pd=7.1e-07 nrd=1.16667 \
        nrs=1.16667 sa=1.4e-07 sb=3.45e-07 sd=160n sca=15.2549 \
        scb=0.0153595 scc=0.00103804 m=(1)
mp35 (n7 mout \17\:VDD VDD) g45p1svt w=(2.15e-07) l=4.5e-08 nf=1 \
        as=1.29e-14 ad=3.44e-14 ps=5.5e-07 pd=7.5e-07 nrd=1.16667 \
        nrs=1.16667 sa=2.45e-07 sb=3.45e-07 sd=160n sca=6.42122 \
        scb=0.00257522 scc=1.4095e-05 m=(1)
mp10 (\8\:SEb \3\:SE \14\:VDD VDD) g45p1svt w=(2.15e-07) l=4.5e-08 nf=1 \
        as=3.44e-14 ad=3.01e-14 ps=7.5e-07 pd=7.1e-07 nrd=1.16667 \
        nrs=1.16667 sa=7.9e-07 sb=1.4e-07 sd=160n sca=34.2363 \
        scb=0.0392303 scc=0.00368484 m=(1)
mp14 (\3\:Db SEb n3 VDD) g45p1svt w=(2.15e-07) l=4.5e-08 nf=1 as=1.29e-14 \
        ad=3.44e-14 ps=5.5e-07 pd=7.5e-07 nrd=1.16667 nrs=1.16667 \
        sa=4.8e-07 sb=4.5e-07 sd=160n sca=17.3611 scb=0.0177712 \
        scc=0.00105096 m=(1)
mp56 (\9\:net573 \13\:qbint \12\:VDD VDD) g45p1svt w=(2.15e-07) \
        l=4.5e-08 nf=1 as=3.01e-14 ad=6.535e-14 ps=7.1e-07 pd=1.16e-06 \
        nrd=1.16667 nrs=1.16667 sa=3.75e-07 sb=1.4e-07 sd=160n sca=18.0318 \
        scb=0.0190355 scc=0.000934132 m=(1)
mp20 (\17\:CKb \4\:CK \19\:VDD VDD) g45p1svt w=(2.15e-07) l=4.5e-08 nf=1 \
        as=3.01e-14 ad=1.362e-13 ps=7.1e-07 pd=2.93e-06 nrd=1.16667 \
        nrs=1.16667 sa=3.45e-07 sb=1.4e-07 sd=160n sca=14.7851 \
        scb=0.0152025 scc=0.00103799 m=(1)
mp32 (\14\:mout \3\:n20 \17\:VDD VDD) g45p1svt w=(2.15e-07) l=4.5e-08 \
        nf=1 as=3.01e-14 ad=3.44e-14 ps=7.1e-07 pd=7.5e-07 nrd=1.16667 \
        nrs=1.16667 sa=4.5e-07 sb=1.4e-07 sd=160n sca=6.07861 \
        scb=0.00247604 scc=1.40748e-05 m=(1)
mp25 (\9\:n20 \3\:CKbb \5\:Db VDD) g45p1svt w=(2.15e-07) l=4.5e-08 nf=1 \
        as=3.01e-14 ad=3.01e-14 ps=7.1e-07 pd=7.1e-07 nrd=1.16667 \
        nrs=1.16667 sa=1.4e-07 sb=1.4e-07 sd=160n sca=20.3407 scb=0.022946 \
        scc=0.00119484 m=(1)
mp36 (\12\:n20 \8\:CKb n7 VDD) g45p1svt w=(2.15e-07) l=4.5e-08 nf=1 \
        as=1.29e-14 ad=3.01e-14 ps=5.5e-07 pd=7.1e-07 nrd=1.16667 \
        nrs=1.16667 sa=1.4e-07 sb=4.5e-07 sd=160n sca=6.79882 \
        scb=0.00278203 scc=1.42286e-05 m=(1)
mp12 (\3\:Db \4\:SE n1 VDD) g45p1svt w=(2.15e-07) l=4.5e-08 nf=1 \
        as=1.29e-14 ad=3.44e-14 ps=5.5e-07 pd=7.5e-07 nrd=1.16667 \
        nrs=1.16667 sa=2.75e-07 sb=6.55e-07 sd=160n sca=15.6684 \
        scb=0.0156302 scc=0.00103829 m=(1)
mp13 (n3 \3\:SI \14\:VDD VDD) g45p1svt w=(2.15e-07) l=4.5e-08 nf=1 \
        as=3.44e-14 ad=1.29e-14 ps=7.5e-07 pd=5.5e-07 nrd=1.16667 \
        nrs=1.16667 sa=5.85e-07 sb=3.45e-07 sd=160n sca=19.3151 \
        scb=0.0211393 scc=0.00112289 m=(1)
mp40 (\4\:n35 \7\:CKb \5\:mout VDD) g45p1svt w=(2.15e-07) l=4.5e-08 nf=1 \
        as=3.01e-14 ad=3.01e-14 ps=7.1e-07 pd=7.1e-07 nrd=1.16667 \
        nrs=1.16667 sa=1.4e-07 sb=1.4e-07 sd=160n sca=25.5298 \
        scb=0.0265038 scc=0.00266093 m=(1)
PM0 (\6\:n35g \5\:RT \9\:n35 ExtVDD) g45p1svt w=(2.15e-07) l=4.5e-08 nf=1 \
        as=3.01e-14 ad=3.01e-14 ps=7.1e-07 pd=7.1e-07 nrd=1.16667 \
        nrs=1.16667 sa=1.4e-07 sb=1.4e-07 sd=160n sca=26.0836 \
        scb=0.0271848 scc=0.00267095 m=(1)
mp45 (\17\:qbint \3\:n35g \1\:ExtVDD ExtVDD) g45p1svt w=(2.15e-07) \
        l=4.5e-08 nf=1 as=3.5882e-13 ad=3.01e-14 ps=3.6e-06 pd=7.1e-07 \
        nrd=1.16667 nrs=1.16667 sa=1.4e-07 sb=8.7e-07 sd=160n sca=25.2796 \
        scb=0.0259458 scc=0.00265434 m=(1)
PM2 (net234 \4\:qbint \1\:ExtVDD ExtVDD) g45p1svt w=(2.15e-07) l=4.5e-08 \
        nf=1 as=3.5882e-13 ad=1.29e-14 ps=3.6e-06 pd=5.5e-07 nrd=1.16667 \
        nrs=1.16667 sa=7.65e-07 sb=2.45e-07 sd=160n sca=14.5295 \
        scb=0.0144143 scc=0.000486924 m=(1)
PM1 (\6\:RTb \6\:RT \1\:ExtVDD ExtVDD) g45p1svt w=(2.15e-07) l=4.5e-08 \
        nf=1 as=3.5882e-13 ad=3.01e-14 ps=3.6e-06 pd=7.1e-07 nrd=1.16667 \
        nrs=1.16667 sa=3.3e-07 sb=1.4e-07 sd=160n sca=24.3731 \
        scb=0.0258873 scc=0.00229004 m=(1)
mp53 (\14\:n35 \11\:CKbb \3\:net0110 VDD) g45p1svt w=(2.15e-07) l=4.5e-08 \
        nf=1 as=3.01e-14 ad=3.01e-14 ps=7.1e-07 pd=7.1e-07 nrd=1.16667 \
        nrs=1.16667 sa=1.4e-07 sb=1.4e-07 sd=160n sca=28.3325 \
        scb=0.0311878 scc=0.00281308 m=(1)
mp52 (net0110 \11\:qbint \10\:VDD VDD) g45p1svt w=(2.15e-07) l=4.5e-08 \
        nf=1 as=3.01e-14 ad=3.01e-14 ps=7.1e-07 pd=7.1e-07 nrd=1.16667 \
        nrs=1.16667 sa=1.4e-07 sb=1.4e-07 sd=160n sca=11.272 \
        scb=0.00858882 scc=0.000167946 m=(1)
C1 (RT VSS) capacitor c=3.679e-17
C2 (QN VSS) capacitor c=1.96714e-17
C3 (SI VSS) capacitor c=8.74653e-17
C4 (VDD VSS) capacitor c=7.00114e-16
C5 (ExtVDD VSS) capacitor c=2.09184e-16
C6 (SE VSS) capacitor c=3.97634e-17
C7 (CK VSS) capacitor c=7.89151e-17
C8 (Q VSS) capacitor c=6.15951e-17
C9 (D VSS) capacitor c=7.44742e-17
C10 (n20 VSS) capacitor c=3.84704e-17
C11 (CKbb VSS) capacitor c=3.32569e-17
C12 (mout VSS) capacitor c=5.38931e-17
C13 (CKb VSS) capacitor c=4.89466e-17
C14 (SEb VSS) capacitor c=7.78865e-17
C15 (n35g VSS) capacitor c=1.81021e-17
C16 (qbint VSS) capacitor c=4.50779e-17
C17 (RTb VSS) capacitor c=5.18628e-17
C18 (net573 VSS) capacitor c=2.24911e-17
C19 (n35 VSS) capacitor c=1.46024e-16
C20 (Db VSS) capacitor c=9.76601e-17
C21 (net0110 VSS) capacitor c=6.33951e-17
C22 (n1 VSS) capacitor c=1.02126e-18
C23 (\7\:qbint VSS) capacitor c=3.38232e-17
C24 (\11\:qbint VSS) capacitor c=8.45214e-17
C25 (\13\:qbint VSS) capacitor c=4.43633e-17
C26 (\3\:net573 VSS) capacitor c=5.88836e-17
C27 (\11\:CKbb VSS) capacitor c=5.18173e-17
C28 (\4\:RTb VSS) capacitor c=9.92332e-17
C29 (\6\:RT VSS) capacitor c=2.31933e-17
C30 (\4\:qbint VSS) capacitor c=5.43131e-17
C31 (\3\:n35g VSS) capacitor c=5.40715e-17
C32 (\5\:RT VSS) capacitor c=6.00536e-17
C33 (\3\:SE VSS) capacitor c=7.80206e-17
C34 (\7\:CKb VSS) capacitor c=2.75917e-17
C35 (\3\:SI VSS) capacitor c=9.50348e-17
C36 (\4\:SE VSS) capacitor c=1.24272e-16
C37 (\4\:D VSS) capacitor c=7.27734e-17
C38 (\3\:n20 VSS) capacitor c=4.52142e-17
C39 (\4\:CK VSS) capacitor c=6.00857e-17
C40 (\4\:CKb VSS) capacitor c=5.08616e-17
C41 (\8\:CKb VSS) capacitor c=8.27548e-17
C42 (\3\:CKbb VSS) capacitor c=3.17181e-17
C43 (\6\:qbint VSS) capacitor c=3.71857e-17
C44 (\14\:qbint VSS) capacitor c=4.6354e-17
C45 (\12\:qbint VSS) capacitor c=8.77329e-17
C46 (\4\:net573 VSS) capacitor c=3.6802e-17
C47 (\11\:CKb VSS) capacitor c=2.34338e-16
C48 (\8\:RT VSS) capacitor c=1.22497e-16
C49 (\2\:RT VSS) capacitor c=6.25904e-17
C50 (\5\:qbint VSS) capacitor c=3.89021e-17
C51 (\5\:n35g VSS) capacitor c=3.28693e-17
C52 (\2\:RTb VSS) capacitor c=4.95171e-17
C53 (\5\:SE VSS) capacitor c=5.77321e-17
C54 (\5\:CKbb VSS) capacitor c=2.4685e-17
C55 (\1\:SI VSS) capacitor c=4.91758e-17
C56 (\6\:SE VSS) capacitor c=8.73973e-17
C57 (\3\:SEb VSS) capacitor c=6.67349e-17
C58 (\1\:D VSS) capacitor c=4.94494e-17
C59 (\6\:n20 VSS) capacitor c=6.57695e-17
C60 (\1\:CK VSS) capacitor c=2.90039e-17
C61 (\3\:mout VSS) capacitor c=5.02141e-17
C62 (\9\:CKb VSS) capacitor c=3.70413e-17
C63 (\10\:CKbb VSS) capacitor c=4.86151e-17
C64 (\6\:CKb VSS) capacitor c=5.30031e-17
C65 (\10\:qbint VSS) capacitor c=8.43212e-17
C66 (\12\:CKbb VSS) capacitor c=3.98788e-17
C67 (\7\:RT VSS) capacitor c=1.45437e-16
C68 (\9\:CKbb VSS) capacitor c=1.565e-16
C69 (\3\:RT VSS) capacitor c=3.28591e-17
C70 (\1\:RT VSS) capacitor c=5.27006e-17
C71 (\3\:RTb VSS) capacitor c=7.63738e-17
C72 (\3\:qbint VSS) capacitor c=4.46336e-17
C73 (\2\:n35 VSS) capacitor c=1.8951e-16
C74 (\4\:n35g VSS) capacitor c=6.68101e-17
C75 (\12\:CKb VSS) capacitor c=2.21992e-16
C76 (\3\:n35 VSS) capacitor c=7.65242e-17
C77 (\1\:SE VSS) capacitor c=2.46698e-17
C78 (\2\:SI VSS) capacitor c=7.76792e-17
C79 (\2\:SEb VSS) capacitor c=7.84258e-17
C80 (\3\:D VSS) capacitor c=1.51381e-17
C81 (\3\:CK VSS) capacitor c=2.32661e-17
C82 (\2\:mout VSS) capacitor c=3.81772e-17
C83 (\4\:mout VSS) capacitor c=3.84117e-17
C84 (\10\:CKb VSS) capacitor c=2.33818e-17
C85 (\5\:n20 VSS) capacitor c=3.76424e-17
C86 (\4\:CKbb VSS) capacitor c=6.37001e-17
C87 (\8\:CKbb VSS) capacitor c=2.5911e-17
C88 (\2\:n20 VSS) capacitor c=3.96919e-17
C89 (\1\:VDD VSS) capacitor c=4.94273e-17
C90 (\3\:Q VSS) capacitor c=7.26656e-17
C91 (\10\:VDD VSS) capacitor c=5.41941e-17
C92 (\9\:net573 VSS) capacitor c=5.55911e-17
C93 (\12\:VDD VSS) capacitor c=7.9225e-17
C94 (\3\:net0110 VSS) capacitor c=8.53747e-17
C95 (\4\:QN VSS) capacitor c=6.82659e-17
C96 (\14\:n35 VSS) capacitor c=5.23647e-17
C97 (\15\:n35g VSS) capacitor c=5.61023e-17
C98 (\6\:RTb VSS) capacitor c=7.41279e-17
C99 (\1\:ExtVDD VSS) capacitor c=2.78122e-16
C100 (\9\:n35 VSS) capacitor c=6.23225e-17
C101 (\17\:qbint VSS) capacitor c=6.84219e-17
C102 (\6\:n35g VSS) capacitor c=9.32134e-17
C103 (\8\:SEb VSS) capacitor c=5.07541e-17
C104 (\4\:n35 VSS) capacitor c=6.41956e-17
C105 (\14\:VDD VSS) capacitor c=6.08819e-17
C106 (\5\:mout VSS) capacitor c=6.55202e-17
C107 (\3\:Db VSS) capacitor c=1.94245e-16
C108 (\19\:VDD VSS) capacitor c=3.46031e-17
C109 (\14\:mout VSS) capacitor c=4.55422e-17
C110 (\17\:CKb VSS) capacitor c=2.99352e-17
C111 (\17\:VDD VSS) capacitor c=4.82692e-17
C112 (\17\:CKbb VSS) capacitor c=7.27498e-17
C113 (\12\:n20 VSS) capacitor c=6.84476e-17
C114 (\5\:Db VSS) capacitor c=2.22036e-16
C115 (\9\:n20 VSS) capacitor c=6.35189e-17
C116 (\1\:Q VSS) capacitor c=6.53309e-17
C117 (\5\:net573 VSS) capacitor c=4.31214e-17
C118 (\1\:QN VSS) capacitor c=3.92132e-17
C119 (\17\:n35 VSS) capacitor c=3.68453e-17
C120 (\11\:n35g VSS) capacitor c=2.97017e-17
C121 (\10\:RTb VSS) capacitor c=5.82842e-17
C122 (\12\:n35 VSS) capacitor c=6.36959e-17
C123 (\19\:qbint VSS) capacitor c=2.43616e-17
C124 (\9\:n35g VSS) capacitor c=8.09004e-17
C125 (\4\:SEb VSS) capacitor c=3.94972e-17
C126 (\7\:n35 VSS) capacitor c=4.1687e-17
C127 (\10\:mout VSS) capacitor c=2.32181e-17
C128 (\12\:mout VSS) capacitor c=2.6199e-17
C129 (\13\:CKb VSS) capacitor c=5.69554e-17
C130 (\15\:CKbb VSS) capacitor c=9.10195e-17
C131 (\16\:n20 VSS) capacitor c=8.20271e-17
C132 (\7\:Db VSS) capacitor c=7.83888e-17
C133 (\7\:n20 VSS) capacitor c=5.89357e-17
C134 (\2\:CKbb VSS) capacitor c=6.47949e-17
C135 (\2\:CK VSS) capacitor c=3.8013e-17
C136 (\4\:n20 VSS) capacitor c=5.45698e-17
C137 (\2\:D VSS) capacitor c=3.57762e-17
C138 (\2\:SE VSS) capacitor c=2.57832e-17
C139 (\2\:CKb VSS) capacitor c=1.55652e-16
C140 (\3\:CKb VSS) capacitor c=9.21235e-17
C141 (\5\:CKb VSS) capacitor c=5.86579e-17
C142 (VDD VSS) capacitor c=2.29308e-16
C143 (\2\:n35g VSS) capacitor c=2.90834e-17
C144 (\4\:RT VSS) capacitor c=3.9139e-17
C145 (\2\:qbint VSS) capacitor c=4.15774e-17
C146 (\6\:CKbb VSS) capacitor c=1.29663e-16
C147 (\7\:CKbb VSS) capacitor c=7.26084e-17
C148 (\2\:net573 VSS) capacitor c=1.52113e-17
C149 (\11\:n20 VSS) capacitor c=4.46092e-17
C150 (\13\:CKbb VSS) capacitor c=9.82481e-17
C151 (\14\:CKbb VSS) capacitor c=9.64029e-17
C152 (\8\:qbint VSS) capacitor c=4.66721e-17
C153 (\9\:qbint VSS) capacitor c=6.80871e-17
C154 (\14\:n20 VSS) capacitor c=5.21129e-17
C155 (\15\:n20 VSS) capacitor c=8.75652e-17
C156 (\19\:CKbb VSS) capacitor c=4.38515e-17
C157 (\15\:CKb VSS) capacitor c=6.01166e-17
C158 (\16\:CKb VSS) capacitor c=4.39203e-17
C159 (\7\:mout VSS) capacitor c=8.38253e-17
C160 (\8\:mout VSS) capacitor c=5.83055e-17
C161 (\9\:mout VSS) capacitor c=5.28786e-17
C162 (\16\:mout VSS) capacitor c=4.43233e-17
C163 (\7\:SE VSS) capacitor c=5.27458e-17
C164 (\6\:SEb VSS) capacitor c=8.40187e-17
C165 (\7\:SEb VSS) capacitor c=6.96745e-17
C166 (\6\:n35 VSS) capacitor c=7.6197e-17
C167 (\19\:CKb VSS) capacitor c=3.81838e-17
C168 (\20\:CKb VSS) capacitor c=4.18264e-17
C169 (\8\:n35g VSS) capacitor c=3.40483e-17
C170 (\11\:n35 VSS) capacitor c=7.39472e-17
C171 (\15\:qbint VSS) capacitor c=8.77521e-17
C172 (\16\:qbint VSS) capacitor c=1.12148e-16
C173 (\13\:n35g VSS) capacitor c=1.03969e-16
C174 (\14\:n35g VSS) capacitor c=1.16319e-16
C175 (\5\:RTb VSS) capacitor c=4.89909e-17
C176 (\8\:RTb VSS) capacitor c=1.01908e-16
C177 (\9\:RTb VSS) capacitor c=9.17306e-17
C178 (\20\:CKbb VSS) capacitor c=9.29688e-17
C179 (\21\:CKbb VSS) capacitor c=9.58748e-17
C180 (\21\:qbint VSS) capacitor c=2.38855e-17
C181 (\22\:qbint VSS) capacitor c=2.98542e-17
C182 (\9\:RT VSS) capacitor c=1.03959e-16
C183 (\10\:RT VSS) capacitor c=1.18651e-16
C184 (\11\:RT VSS) capacitor c=5.89446e-17
C185 (\3\:QN VSS) capacitor c=3.19271e-17
C186 (\16\:n35 VSS) capacitor c=3.71585e-17
C187 (\7\:net573 VSS) capacitor c=5.74857e-17
C188 (\8\:net573 VSS) capacitor c=3.4514e-17
C189 (\3\:VDD VSS) capacitor c=4.53222e-17
C190 (\5\:VDD VSS) capacitor c=9.30322e-18
C191 (\6\:VDD VSS) capacitor c=1.35048e-16
C192 (\7\:VDD VSS) capacitor c=7.72485e-17
C193 (\9\:VDD VSS) capacitor c=3.80669e-17
C194 (\16\:VDD VSS) capacitor c=5.92488e-17
Rk53 (RT \9\:RT) resistor r=0.1932 c=0
Rk54 (\9\:RT \10\:RT) resistor r=0.6407 c=0
Rk55 (RT \11\:RT) resistor r=0.006609 c=0
Rk57 (\3\:QN QN) resistor r=0.02948 c=0
Rk56 (\2\:QN \3\:QN) resistor r=0.1988 c=0
Rk58 (\3\:QN \5\:QN) resistor r=0.3451 c=0
Rk83 (\2\:VDD \3\:VDD) resistor r=0.5761 c=0
Rk84 (\3\:VDD \5\:VDD) resistor r=0.06676 c=0
Rk86 (\6\:VDD VDD) resistor r=1.0026 c=0
Rk85 (\5\:VDD \6\:VDD) resistor r=0.05188 c=0
Rk87 (VDD \7\:VDD) resistor r=0.5195 c=0
Rk88 (\7\:VDD \9\:VDD) resistor r=0.3401 c=0
Rk89 (\3\:VDD \11\:VDD) resistor r=0.3013 c=0
Rk90 (\6\:VDD \13\:VDD) resistor r=0.3741 c=0
Rk91 (\7\:VDD \15\:VDD) resistor r=0.3661 c=0
Rk95 (\16\:VDD VDD) resistor r=0.1955 c=0
Rk92 (\9\:VDD \16\:VDD) resistor r=0.1709 c=0
Rk93 (\16\:VDD \18\:VDD) resistor r=0.2069 c=0
Rk94 (\9\:VDD \20\:VDD) resistor r=0.2389 c=0
Rk38 (ExtVDD ExtVDD) resistor r=0.002061 c=0
Rk36 (\2\:ExtVDD ExtVDD) resistor r=0.02215 c=0
Rk39 (ExtVDD \5\:ExtVDD) resistor r=0.02014 c=0
Rk40 (ExtVDD \6\:ExtVDD) resistor r=0.1496 c=0
Rk25 (SE \7\:SE) resistor r=0.0432 c=0
Rk65 (\2\:Q Q) resistor r=0.2973 c=0
Rk66 (Q \4\:Q) resistor r=0.2044 c=0
Rk67 (\2\:VSS \4\:VSS) resistor r=0.4109 c=0
Rk68 (\4\:VSS \5\:VSS) resistor r=0.1883 c=0
Rk69 (\5\:VSS \6\:VSS) resistor r=0.6716 c=0
Rk70 (\6\:VSS \7\:VSS) resistor r=0.03204 c=0
Rk72 (\8\:VSS VSS) resistor r=0.1211 c=0
Rk71 (\7\:VSS \8\:VSS) resistor r=0.1759 c=0
Rk73 (VSS \9\:VSS) resistor r=0.5208 c=0
Rk74 (\9\:VSS \10\:VSS) resistor r=0.3071 c=0
Rk76 (\11\:VSS VSS) resistor r=0.1213 c=0
Rk75 (\10\:VSS \11\:VSS) resistor r=0.06428 c=0
Rk77 (VSS \13\:VSS) resistor r=0.3119 c=0
Rk78 (\5\:VSS \15\:VSS) resistor r=0.2667 c=0
Rk79 (\6\:VSS \17\:VSS) resistor r=0.1891 c=0
Rk80 (\8\:VSS \19\:VSS) resistor r=0.1942 c=0
Rk81 (\9\:VSS \21\:VSS) resistor r=0.2532 c=0
Rk82 (\10\:VSS \23\:VSS) resistor r=0.2488 c=0
Rk96 (\25\:VSS \26\:VSS) resistor r=0.1362 c=0
Rk97 (\26\:VSS \27\:VSS) resistor r=0.6768 c=0
Rk99 (\28\:VSS VSS) resistor r=0.2973 c=0
Rk98 (\27\:VSS \28\:VSS) resistor r=0.07916 c=0
Rk101 (\29\:VSS VSS) resistor r=0.1213 c=0
Rk100 (VSS \29\:VSS) resistor r=0.8929 c=0
Rk102 (VSS \31\:VSS) resistor r=0.2968 c=0
Rk103 (\26\:VSS \33\:VSS) resistor r=0.2348 c=0
Rk104 (\27\:VSS \35\:VSS) resistor r=0.2434 c=0
Rk1 (\8\:n20 \10\:n20) resistor r=0.543 c=0
Rk2 (\10\:n20 \11\:n20) resistor r=0.2541 c=0
Rk4 (\13\:n20 \14\:n20) resistor r=0.3402 c=0
Rk5 (\13\:n20 \15\:n20) resistor r=0.2662 c=0
Rk6 (\15\:n20 \17\:n20) resistor r=0.4595 c=0
Rk3 (\13\:CKbb \14\:CKbb) resistor r=0.7511 c=0
Rk7 (\16\:CKbb \18\:CKbb) resistor r=0.5321 c=0
Rk8 (\18\:CKbb \19\:CKbb) resistor r=0.142 c=0
Rk51 (\20\:CKbb \21\:CKbb) resistor r=0.7115 c=0
Rk17 (\6\:mout \7\:mout) resistor r=0.602 c=0
Rk18 (\7\:mout \8\:mout) resistor r=0.5259 c=0
Rk19 (\8\:mout \9\:mout) resistor r=0.1904 c=0
Rk20 (\7\:mout \11\:mout) resistor r=0.1278 c=0
Rk21 (\8\:mout \13\:mout) resistor r=0.1169 c=0
Rk22 (\8\:mout \15\:mout) resistor r=0.5475 c=0
Rk23 (\9\:mout \16\:mout) resistor r=0.3936 c=0
Rk10 (\14\:CKb \15\:CKb) resistor r=0.3167 c=0
Rk11 (\15\:CKb \16\:CKb) resistor r=0.1578 c=0
Rk12 (\15\:CKb \18\:CKb) resistor r=0.1865 c=0
Rk31 (\19\:CKb \20\:CKb) resistor r=0.3714 c=0
Rk26 (\5\:SEb \6\:SEb) resistor r=0.2161 c=0
Rk27 (\6\:SEb \7\:SEb) resistor r=0.3544 c=0
Rk28 (\6\:SEb \9\:SEb) resistor r=0.3096 c=0
Rk32 (\7\:n35g \8\:n35g) resistor r=0.2733 c=0
Rk33 (\7\:n35g \10\:n35g) resistor r=0.6914 c=0
Rk44 (\12\:n35g \13\:n35g) resistor r=0.2429 c=0
Rk45 (\13\:n35g \14\:n35g) resistor r=0.5654 c=0
Rk46 (\13\:n35g \16\:n35g) resistor r=0.4319 c=0
Rk41 (\15\:qbint \16\:qbint) resistor r=0.4944 c=0
Rk42 (\16\:qbint \18\:qbint) resistor r=0.567 c=0
Rk43 (\16\:qbint \20\:qbint) resistor r=0.1463 c=0
Rk52 (\21\:qbint \22\:qbint) resistor r=0.2118 c=0
Rk47 (\5\:RTb \7\:RTb) resistor r=0.2162 c=0
Rk48 (\7\:RTb \8\:RTb) resistor r=0.4165 c=0
Rk49 (\8\:RTb \9\:RTb) resistor r=0.6885 c=0
Rk50 (\8\:RTb \11\:RTb) resistor r=0.3065 c=0
Rk61 (\6\:net573 \7\:net573) resistor r=0.2307 c=0
Rk62 (\7\:net573 \8\:net573) resistor r=0.1648 c=0
Rk63 (\7\:net573 \10\:net573) resistor r=0.2901 c=0
Rk29 (\5\:n35 \6\:n35) resistor r=0.4097 c=0
Rk30 (\6\:n35 \8\:n35) resistor r=0.2903 c=0
Rk34 (\10\:n35 \11\:n35) resistor r=0.4009 c=0
Rk35 (\11\:n35 \13\:n35) resistor r=0.3298 c=0
Rk59 (\15\:n35 \16\:n35) resistor r=0.3037 c=0
Rk60 (\16\:n35 \18\:n35) resistor r=0.2671 c=0
Rk14 (\2\:Db \4\:Db) resistor r=0.6363 c=0
Rk15 (\4\:Db \6\:Db) resistor r=1.42 c=0
Rk16 (\6\:Db \8\:Db) resistor r=0.5649 c=0
Rk64 (\2\:net0110 \4\:net0110) resistor r=0.6451 c=0
Rl53 (\7\:RT \8\:RT) resistor r=651.902 c=0
Rl40 (\1\:RT \2\:RT) resistor r=169.515 c=0
Rl43 (\4\:RT \6\:RT) resistor r=21.372 c=0
Rl42 (\4\:RT \5\:RT) resistor r=264.027 c=0
Rl41 (\3\:RT \4\:RT) resistor r=96.114 c=0
Rl19 (\2\:SI \3\:SI) resistor r=155.002 c=0
Rl18 (\1\:SI \2\:SI) resistor r=24.2328 c=0
Rl22 (\3\:SE \4\:SE) resistor r=294.192 c=0
Rl24 (\5\:SE \6\:SE) resistor r=241.873 c=0
Rl21 (\2\:SE \3\:SE) resistor r=49.6369 c=0
Rl23 (\2\:SE \5\:SE) resistor r=147.714 c=0
Rl20 (\1\:SE \2\:SE) resistor r=0.767 c=0
Rl9 (\2\:CK \4\:CK) resistor r=147.791 c=0
Rl7 (\1\:CK \2\:CK) resistor r=63.1757 c=0
Rl8 (\2\:CK \3\:CK) resistor r=2.0166 c=0
Rl15 (\2\:D \4\:D) resistor r=115.099 c=0
Rl13 (\1\:D \2\:D) resistor r=84.3295 c=0
Rl14 (\2\:D \3\:D) resistor r=5.1123 c=0
Rl1 (n20 \2\:n20) resistor r=123.512 c=0
Rl10 (\3\:n20 \4\:n20) resistor r=100.163 c=0
Rl12 (\4\:n20 \6\:n20) resistor r=179.184 c=0
Rl11 (\4\:n20 \5\:n20) resistor r=123.391 c=0
Rl56 (\11\:CKbb \12\:CKbb) resistor r=163.284 c=0
Rl3 (\2\:CKbb \3\:CKbb) resistor r=68.4981 c=0
Rl2 (CKbb \2\:CKbb) resistor r=50.7843 c=0
Rl4 (\2\:CKbb \4\:CKbb) resistor r=262.732 c=0
Rl48 (\5\:CKbb \6\:CKbb) resistor r=66.1349 c=0
Rl51 (\6\:CKbb \9\:CKbb) resistor r=762.322 c=0
Rl52 (\7\:CKbb \10\:CKbb) resistor r=60.7265 c=0
Rl50 (\7\:CKbb \8\:CKbb) resistor r=81.3209 c=0
Rl49 (\6\:CKbb \7\:CKbb) resistor r=462.851 c=0
Rl5 (mout \2\:mout) resistor r=24.2328 c=0
Rl6 (\3\:mout \4\:mout) resistor r=24.2328 c=0
Rl57 (\11\:CKb \12\:CKb) resistor r=870.726 c=0
Rl30 (\2\:CKb \7\:CKb) resistor r=127.816 c=0
Rl25 (CKb \2\:CKb) resistor r=349.798 c=0
Rl27 (\3\:CKb \4\:CKb) resistor r=103.952 c=0
Rl31 (\3\:CKb \8\:CKb) resistor r=147.793 c=0
Rl26 (\2\:CKb \3\:CKb) resistor r=431.465 c=0
Rl28 (\4\:CKb \5\:CKb) resistor r=74.8465 c=0
Rl32 (\5\:CKb \9\:CKb) resistor r=132.539 c=0
Rl29 (\5\:CKb \6\:CKb) resistor r=266.239 c=0
Rl33 (\5\:CKb \10\:CKb) resistor r=4.3228 c=0
Rl16 (SEb \2\:SEb) resistor r=101.718 c=0
Rl17 (\2\:SEb \3\:SEb) resistor r=132.669 c=0
Rl36 (\3\:n35g \4\:n35g) resistor r=265.853 c=0
Rl35 (\2\:n35g \3\:n35g) resistor r=181.74 c=0
Rl37 (\2\:n35g \5\:n35g) resistor r=94.1963 c=0
Rl34 (n35g \2\:n35g) resistor r=2.4834 c=0
Rl61 (\6\:qbint \7\:qbint) resistor r=149.805 c=0
Rl68 (\13\:qbint \14\:qbint) resistor r=189.403 c=0
Rl66 (\11\:qbint \12\:qbint) resistor r=337.984 c=0
Rl47 (\3\:qbint \5\:qbint) resistor r=35.3072 c=0
Rl46 (\2\:qbint \4\:qbint) resistor r=70.093 c=0
Rl44 (qbint \2\:qbint) resistor r=112.732 c=0
Rl45 (\2\:qbint \3\:qbint) resistor r=152.601 c=0
Rl62 (\7\:qbint \8\:qbint) resistor r=99.804 c=0
Rl65 (\8\:qbint \11\:qbint) resistor r=200.917 c=0
Rl67 (\9\:qbint \13\:qbint) resistor r=95.4293 c=0
Rl64 (\9\:qbint \10\:qbint) resistor r=387.298 c=0
Rl63 (\8\:qbint \9\:qbint) resistor r=104.193 c=0
Rl39 (\3\:RTb \4\:RTb) resistor r=239.402 c=0
Rl38 (RTb \2\:RTb) resistor r=112.412 c=0
Rl59 (\2\:net573 \3\:net573) resistor r=67.5354 c=0
Rl60 (\2\:net573 \4\:net573) resistor r=64.1263 c=0
Rl58 (net573 \2\:net573) resistor r=3.1216 c=0
Rl54 (n35 \2\:n35) resistor r=508.667 c=0
Rl55 (\2\:n35 \3\:n35) resistor r=334.803 c=0
Rz17 (\1\:QN \2\:QN) resistor r=37.5 c=0
Rz20 (\1\:Q \2\:Q) resistor r=37.5 c=0
Rz21 (\1\:VSS \2\:VSS) resistor r=37.5 c=0
Rz22 (\12\:VSS \13\:VSS) resistor r=75 c=0
Rz23 (\14\:VSS \15\:VSS) resistor r=37.5 c=0
Rz24 (\16\:VSS \17\:VSS) resistor r=75 c=0
Rz25 (\18\:VSS \19\:VSS) resistor r=75 c=0
Rz26 (\20\:VSS \21\:VSS) resistor r=75 c=0
Rz27 (\22\:VSS \23\:VSS) resistor r=75 c=0
Rz30 (\30\:VSS \31\:VSS) resistor r=75 c=0
Rz31 (\32\:VSS \33\:VSS) resistor r=75 c=0
Rz32 (\34\:VSS \35\:VSS) resistor r=75 c=0
Rz1 (\7\:n20 \8\:n20) resistor r=75 c=0
Rz2 (\16\:n20 \17\:n20) resistor r=75 c=0
Rz3 (\15\:CKbb \16\:CKbb) resistor r=75 c=0
Rz7 (\10\:mout \11\:mout) resistor r=75 c=0
Rz8 (\12\:mout \13\:mout) resistor r=75 c=0
Rz4 (\13\:CKb \14\:CKb) resistor r=75 c=0
Rz9 (\4\:SEb \5\:SEb) resistor r=75 c=0
Rz11 (\9\:n35g \10\:n35g) resistor r=75 c=0
Rz15 (\11\:n35g \12\:n35g) resistor r=75 c=0
Rz14 (\19\:qbint \20\:qbint) resistor r=75 c=0
Rz16 (\10\:RTb \11\:RTb) resistor r=75 c=0
Rz19 (\5\:net573 \6\:net573) resistor r=75 c=0
Rz10 (\7\:n35 \8\:n35) resistor r=75 c=0
Rz12 (\12\:n35 \13\:n35) resistor r=75 c=0
Rz18 (\17\:n35 \18\:n35) resistor r=75 c=0
Rz5 (Db \2\:Db) resistor r=75 c=0
Rz6 (\7\:Db \8\:Db) resistor r=75 c=0
Ry19 (\4\:QN \5\:QN) resistor r=20.6667 c=0
Ry28 (\1\:VDD \2\:VDD) resistor r=20.6667 c=0
Ry29 (\10\:VDD \11\:VDD) resistor r=62 c=0
Ry30 (\12\:VDD \13\:VDD) resistor r=20.6667 c=0
Ry31 (\14\:VDD \15\:VDD) resistor r=62 c=0
Ry32 (\17\:VDD \18\:VDD) resistor r=62 c=0
Ry33 (\19\:VDD \20\:VDD) resistor r=62 c=0
Ry13 (\1\:ExtVDD \2\:ExtVDD) resistor r=62 c=0
Ry14 (\1\:ExtVDD \5\:ExtVDD) resistor r=62 c=0
Ry15 (\1\:ExtVDD \6\:ExtVDD) resistor r=62 c=0
Ry24 (\3\:Q \4\:Q) resistor r=20.6667 c=0
Ry25 (\3\:VSS \4\:VSS) resistor r=10.3333 c=0
Ry26 (\3\:VSS \7\:VSS) resistor r=5.1667 c=0
Ry27 (\3\:VSS \11\:VSS) resistor r=5.1667 c=0
Ry34 (\24\:VSS \25\:VSS) resistor r=10.3333 c=0
Ry35 (\24\:VSS \28\:VSS) resistor r=5.1667 c=0
Ry36 (\24\:VSS \29\:VSS) resistor r=5.1667 c=0
Ry1 (\9\:n20 \10\:n20) resistor r=62 c=0
Ry2 (\12\:n20 \13\:n20) resistor r=62 c=0
Ry3 (\17\:CKbb \18\:CKbb) resistor r=62 c=0
Ry7 (\5\:mout \6\:mout) resistor r=62 c=0
Ry8 (\14\:mout \15\:mout) resistor r=62 c=0
Ry4 (\17\:CKb \18\:CKb) resistor r=62 c=0
Ry9 (\8\:SEb \9\:SEb) resistor r=62 c=0
Ry11 (\6\:n35g \7\:n35g) resistor r=62 c=0
Ry17 (\15\:n35g \16\:n35g) resistor r=62 c=0
Ry16 (\17\:qbint \18\:qbint) resistor r=62 c=0
Ry18 (\6\:RTb \7\:RTb) resistor r=62 c=0
Ry21 (\9\:net573 \10\:net573) resistor r=62 c=0
Ry10 (\4\:n35 \5\:n35) resistor r=62 c=0
Ry12 (\9\:n35 \10\:n35) resistor r=62 c=0
Ry20 (\14\:n35 \15\:n35) resistor r=62 c=0
Ry5 (\3\:Db \4\:Db) resistor r=62 c=0
Ry6 (\5\:Db \6\:Db) resistor r=62 c=0
Ry22 (net0110 \2\:net0110) resistor r=62 c=0
Ry23 (\3\:net0110 \4\:net0110) resistor r=62 c=0
Rx28 (\3\:RT \9\:RT) resistor r=45 c=0
Rx29 (\1\:RT \10\:RT) resistor r=45 c=0
Rx30 (\7\:RT \11\:RT) resistor r=45 c=0
Rx12 (\2\:SI SI) resistor r=45 c=0
Rx13 (\1\:SE \7\:SE) resistor r=45 c=0
Rx7 (\3\:CK CK) resistor r=45 c=0
Rx9 (\3\:D D) resistor r=45 c=0
Rx1 (n20 \11\:n20) resistor r=45 c=0
Rx4 (\2\:n20 \14\:n20) resistor r=45 c=0
Rx5 (\5\:n20 \15\:n20) resistor r=45 c=0
Rx2 (\4\:CKbb \13\:CKbb) resistor r=45 c=0
Rx3 (\8\:CKbb \14\:CKbb) resistor r=45 c=0
Rx6 (CKbb \19\:CKbb) resistor r=45 c=0
Rx24 (\12\:CKbb \20\:CKbb) resistor r=45 c=0
Rx25 (\9\:CKbb \21\:CKbb) resistor r=45 c=0
Rx10 (\4\:mout \9\:mout) resistor r=45 c=0
Rx11 (\2\:mout \16\:mout) resistor r=45 c=0
Rx8 (\10\:CKb \16\:CKb) resistor r=45 c=0
Rx16 (CKb \19\:CKb) resistor r=45 c=0
Rx17 (\12\:CKb \20\:CKb) resistor r=45 c=0
Rx14 (\2\:SEb \7\:SEb) resistor r=45 c=0
Rx18 (\4\:n35g \8\:n35g) resistor r=45 c=0
Rx21 (n35g \14\:n35g) resistor r=45 c=0
Rx20 (\3\:qbint \15\:qbint) resistor r=45 c=0
Rx26 (\10\:qbint \21\:qbint) resistor r=45 c=0
Rx27 (qbint \22\:qbint) resistor r=45 c=0
Rx22 (\3\:RTb \5\:RTb) resistor r=45 c=0
Rx23 (RTb \9\:RTb) resistor r=45 c=0
Rx32 (net573 \8\:net573) resistor r=45 c=0
Rx15 (\3\:n35 \6\:n35) resistor r=45 c=0
Rx19 (\2\:n35 \11\:n35) resistor r=45 c=0
Rx31 (n35 \16\:n35) resistor r=45 c=0
mn35 (n6 \3\:mout \30\:VSS VSS) g45n1svt w=(1.45e-07) l=4.5e-08 nf=1 \
        as=2.32e-14 ad=8.7e-15 ps=6.1e-07 pd=4.1e-07 nrd=1.16667 \
        nrs=1.16667 sa=2.45e-07 sb=3.45e-07 sd=160n sca=8.42104 \
        scb=0.00632542 scc=0.000106623 m=(1)
mn12 (Db \3\:SEb n0 VSS) g45n1svt w=(1.45e-07) l=4.5e-08 nf=1 as=2.32e-14 \
        ad=8.7e-15 ps=6.1e-07 pd=4.1e-07 nrd=1.16667 nrs=1.16667 \
        sa=2.45e-07 sb=6.55e-07 sd=160n sca=8.85152 scb=0.00706865 \
        scc=0.000138481 m=(1)
mn14 (Db \6\:SE n2 VSS) g45n1svt w=(1.45e-07) l=4.5e-08 nf=1 as=8.7e-15 \
        ad=2.32e-14 ps=4.1e-07 pd=6.1e-07 nrd=1.16667 nrs=1.16667 \
        sa=4.5e-07 sb=4.5e-07 sd=160n sca=8.85152 scb=0.00706865 \
        scc=0.000138481 m=(1)
mn56 (\5\:net573 \14\:qbint \14\:VSS VSS) g45n1svt w=(1.45e-07) \
        l=4.5e-08 nf=1 as=2.03e-14 ad=4.365e-14 ps=5.7e-07 pd=9e-07 \
        nrd=1.16667 nrs=1.16667 sa=3.75e-07 sb=1.4e-07 sd=160n sca=9.33388 \
        scb=0.00788941 scc=0.00017958 m=(1)
mn21 (\15\:CKbb \9\:CKb \12\:VSS VSS) g45n1svt w=(1.45e-07) l=4.5e-08 \
        nf=1 as=2.32e-14 ad=2.03e-14 ps=6.1e-07 pd=5.7e-07 nrd=1.16667 \
        nrs=1.16667 sa=1.4e-07 sb=3.45e-07 sd=160n sca=8.0352 \
        scb=0.00565402 scc=8.19771e-05 m=(1)
mn13 (n2 \1\:SI \20\:VSS VSS) g45n1svt w=(1.45e-07) l=4.5e-08 nf=1 \
        as=2.32e-14 ad=8.7e-15 ps=6.1e-07 pd=4.1e-07 nrd=1.16667 \
        nrs=1.16667 sa=5.55e-07 sb=3.45e-07 sd=160n sca=8.85152 \
        scb=0.00706865 scc=0.000138481 m=(1)
mn10 (\4\:SEb \5\:SE \20\:VSS VSS) g45n1svt w=(1.45e-07) l=4.5e-08 nf=1 \
        as=2.32e-14 ad=2.03e-14 ps=6.1e-07 pd=5.7e-07 nrd=1.16667 \
        nrs=1.16667 sa=7.6e-07 sb=1.4e-07 sd=160n sca=8.85152 \
        scb=0.00706865 scc=0.000138481 m=(1)
mn25 (\7\:Db \6\:CKb \7\:n20 VSS) g45n1svt w=(1.45e-07) l=4.5e-08 nf=1 \
        as=2.03e-14 ad=2.03e-14 ps=5.7e-07 pd=5.7e-07 nrd=1.16667 \
        nrs=1.16667 sa=1.4e-07 sb=1.4e-07 sd=160n sca=8.0352 \
        scb=0.00565402 scc=8.19771e-05 m=(1)
mn36 (\16\:n20 \10\:CKbb n6 VSS) g45n1svt w=(1.45e-07) l=4.5e-08 nf=1 \
        as=8.7e-15 ad=2.03e-14 ps=4.1e-07 pd=5.7e-07 nrd=1.16667 \
        nrs=1.16667 sa=1.4e-07 sb=4.5e-07 sd=160n sca=8.42104 \
        scb=0.00632542 scc=0.000106623 m=(1)
mn20 (\13\:CKb \1\:CK \12\:VSS VSS) g45n1svt w=(1.45e-07) l=4.5e-08 nf=1 \
        as=2.32e-14 ad=2.03e-14 ps=6.1e-07 pd=5.7e-07 nrd=1.16667 \
        nrs=1.16667 sa=3.45e-07 sb=1.4e-07 sd=160n sca=8.0352 \
        scb=0.00565402 scc=8.19771e-05 m=(1)
mn32 (\12\:mout \6\:n20 \30\:VSS VSS) g45n1svt w=(1.45e-07) l=4.5e-08 \
        nf=1 as=2.32e-14 ad=2.03e-14 ps=6.1e-07 pd=5.7e-07 nrd=1.16667 \
        nrs=1.16667 sa=4.5e-07 sb=1.4e-07 sd=160n sca=8.42104 \
        scb=0.00632542 scc=0.000106623 m=(1)
mn11 (n0 \1\:D \22\:VSS VSS) g45n1svt w=(1.45e-07) l=4.5e-08 nf=1 \
        as=2.03e-14 ad=8.7e-15 ps=5.7e-07 pd=4.1e-07 nrd=1.16667 \
        nrs=1.16667 sa=1.4e-07 sb=7.6e-07 sd=160n sca=8.85152 \
        scb=0.00706865 scc=0.000138481 m=(1)
mn40 (\7\:n35 \5\:CKbb \10\:mout VSS) g45n1svt w=(1.45e-07) l=4.5e-08 \
        nf=1 as=2.03e-14 ad=2.03e-14 ps=5.7e-07 pd=5.7e-07 nrd=1.16667 \
        nrs=1.16667 sa=1.4e-07 sb=1.4e-07 sd=160n sca=8.42104 \
        scb=0.00632542 scc=0.000106623 m=(1)
NM0 (\9\:n35g \2\:RTb \12\:n35 VSS) g45n1svt w=(1.45e-07) l=4.5e-08 nf=1 \
        as=2.03e-14 ad=2.03e-14 ps=5.7e-07 pd=5.7e-07 nrd=1.16667 \
        nrs=1.16667 sa=1.4e-07 sb=1.4e-07 sd=160n sca=8.42104 \
        scb=0.00632542 scc=0.000106623 m=(1)
mn45 (\19\:qbint \5\:n35g \18\:VSS VSS) g45n1svt w=(1.45e-07) l=4.5e-08 \
        nf=1 as=2.03e-14 ad=2.03e-14 ps=5.7e-07 pd=5.7e-07 nrd=1.16667 \
        nrs=1.16667 sa=1.4e-07 sb=1.4e-07 sd=160n sca=9.33388 \
        scb=0.00788941 scc=0.00017958 m=(1)
NM3 (net0134 \5\:qbint \16\:VSS VSS) g45n1svt w=(1.45e-07) l=4.5e-08 \
        nf=1 as=2.03e-14 ad=8.7e-15 ps=5.7e-07 pd=4.1e-07 nrd=1.16667 \
        nrs=1.16667 sa=1.4e-07 sb=2.45e-07 sd=160n sca=9.33388 \
        scb=0.00788941 scc=0.00017958 m=(1)
NM1 (\10\:RTb \2\:RT \34\:VSS VSS) g45n1svt w=(1.45e-07) l=4.5e-08 nf=1 \
        as=2.03e-14 ad=2.03e-14 ps=5.7e-07 pd=5.7e-07 nrd=1.16667 \
        nrs=1.16667 sa=1.4e-07 sb=1.4e-07 sd=160n sca=8.42104 \
        scb=0.00632542 scc=0.000106623 m=(1)
NM2 (\11\:n35g \8\:RT net0134 VSS) g45n1svt w=(1.45e-07) l=4.5e-08 nf=1 \
        as=8.7e-15 ad=2.03e-14 ps=4.1e-07 pd=5.7e-07 nrd=1.16667 \
        nrs=1.16667 sa=2.45e-07 sb=1.4e-07 sd=160n sca=9.33388 \
        scb=0.00788941 scc=0.00017958 m=(1)
mn53 (\17\:n35 \11\:CKb net0118 VSS) g45n1svt w=(1.45e-07) l=4.5e-08 nf=1 \
        as=8.7e-15 ad=2.03e-14 ps=4.1e-07 pd=5.7e-07 nrd=1.16667 \
        nrs=1.16667 sa=1.4e-07 sb=2.45e-07 sd=160n sca=8.42104 \
        scb=0.00632542 scc=0.000106623 m=(1)
mn52 (net0118 \12\:qbint \32\:VSS VSS) g45n1svt w=(1.45e-07) l=4.5e-08 \
        nf=1 as=2.03e-14 ad=8.7e-15 ps=5.7e-07 pd=4.1e-07 nrd=1.16667 \
        nrs=1.16667 sa=2.45e-07 sb=1.4e-07 sd=160n sca=8.42104 \
        scb=0.00632542 scc=0.000106623 m=(1)
mn57 (\1\:QN \4\:net573 \14\:VSS VSS) g45n1svt w=(2.6e-07) l=4.5e-08 \
        nf=1 as=4.365e-14 ad=3.64e-14 ps=9e-07 pd=8e-07 nrd=1.16667 \
        nrs=1.16667 sa=1.4e-07 sb=2.71058e-07 sd=160n sca=9.69565 \
        scb=0.00844644 scc=0.000275168 m=(1)
mn55 (\1\:Q \6\:qbint \1\:VSS VSS) g45n1svt w=(2.6e-07) l=4.5e-08 nf=1 \
        as=3.64e-14 ad=3.64e-14 ps=8e-07 pd=8e-07 nrd=1.16667 nrs=1.16667 \
        sa=1.4e-07 sb=1.4e-07 sd=160n sca=9.50447 scb=0.0081528 \
        scc=0.00025289 m=(1)
mp57 (\4\:QN \3\:net573 \12\:VDD VDD) g45p1svt w=(3.9e-07) l=4.5e-08 \
        nf=1 as=5.46e-14 ad=6.535e-14 ps=1.06e-06 pd=1.16e-06 nrd=1.16667 \
        nrs=1.16667 sa=1.4e-07 sb=2.69551e-07 sd=160n sca=38.4244 \
        scb=0.0401517 scc=0.00462137 m=(1)
mp55 (\3\:Q \7\:qbint \1\:VDD VDD) g45p1svt w=(3.9e-07) l=4.5e-08 nf=1 \
        as=5.46e-14 ad=5.46e-14 ps=1.06e-06 pd=1.06e-06 nrd=1.16667 \
        nrs=1.16667 sa=1.4e-07 sb=1.4e-07 sd=160n sca=20.1111 \
        scb=0.0190466 scc=0.00152507 m=(1)
ends SRDFFX1
// End of subcircuit definition.
