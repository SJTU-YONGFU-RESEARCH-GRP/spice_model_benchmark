// Generated for: spectre (May  1 08:16:21 2013 )
// Library name: gsclib045
// Cell name: NOR3X6
// View name: extracted

simulator lang=spectre

subckt NOR3X6 A B C VDD VSS Y
mp0_1__rcx (2 \1\:A \1\:VDD VDD) g45p1svt w=(3.9e-07) l=4.5e-08 nf=1 \
        as=5.46e-14 ad=2.34e-14 ps=1.06e-06 pd=9e-07 nrd=1.16667 \
        nrs=1.16667 sa=1.4e-07 sb=2e-06 sd=160n sca=16.7415 scb=0.0157405 \
        scc=0.000674193 m=(1)
mp1_1__rcx (2 \1\:B 8 VDD) g45p1svt w=(3.9e-07) l=4.5e-08 nf=1 \
        as=1.482e-13 ad=2.34e-14 ps=1.54e-06 pd=9e-07 nrd=1.16667 \
        nrs=1.16667 sa=2.45e-07 sb=2e-06 sd=160n sca=15.4152 scb=0.0136728 \
        scc=0.00065148 m=(1)
mp2_1__rcx (\13\:Y \7\:C 8 VDD) g45p1svt w=(3.9e-07) l=4.5e-08 nf=1 \
        as=1.482e-13 ad=6.24e-14 ps=1.54e-06 pd=1.1e-06 nrd=1.16667 \
        nrs=1.16667 sa=6.7e-07 sb=2e-06 sd=160n sca=13.5671 scb=0.012183 \
        scc=0.000647513 m=(1)
mp2_2__rcx (\13\:Y \1\:C 3 VDD) g45p1svt w=(3.9e-07) l=4.5e-08 nf=1 \
        as=2.34e-14 ad=6.24e-14 ps=9e-07 pd=1.1e-06 nrd=1.16667 \
        nrs=1.16667 sa=8.75e-07 sb=2e-06 sd=160n sca=13.5671 scb=0.012183 \
        scc=0.000647513 m=(1)
mp1_2__rcx (3 \4\:B 11 VDD) g45p1svt w=(3.9e-07) l=4.5e-08 nf=1 \
        as=6.24e-14 ad=2.34e-14 ps=1.1e-06 pd=9e-07 nrd=1.16667 \
        nrs=1.16667 sa=9.8e-07 sb=2e-06 sd=160n sca=13.5671 scb=0.012183 \
        scc=0.000647513 m=(1)
mp0_2__rcx (11 \9\:A \7\:VDD VDD) g45p1svt w=(3.9e-07) l=4.5e-08 nf=1 \
        as=6.24e-14 ad=6.24e-14 ps=1.1e-06 pd=1.1e-06 nrd=1.16667 \
        nrs=1.16667 sa=1.185e-06 sb=2e-06 sd=160n sca=13.5671 scb=0.012183 \
        scc=0.000647513 m=(1)
mp0_3__rcx (12 \8\:A \7\:VDD VDD) g45p1svt w=(3.9e-07) l=4.5e-08 nf=1 \
        as=6.24e-14 ad=8.58e-14 ps=1.1e-06 pd=1.22e-06 nrd=1.16667 \
        nrs=1.16667 sa=1.39e-06 sb=2e-06 sd=160n sca=13.5671 scb=0.012183 \
        scc=0.000647513 m=(1)
mp1_3__rcx (12 \7\:B 9 VDD) g45p1svt w=(3.9e-07) l=4.5e-08 nf=1 \
        as=1.482e-13 ad=8.58e-14 ps=1.54e-06 pd=1.22e-06 nrd=1.16667 \
        nrs=1.16667 sa=1.655e-06 sb=2e-06 sd=160n sca=13.5671 scb=0.012183 \
        scc=0.000647513 m=(1)
mp2_3__rcx (\11\:Y \14\:C 9 VDD) g45p1svt w=(3.9e-07) l=4.5e-08 nf=1 \
        as=1.482e-13 ad=6.24e-14 ps=1.54e-06 pd=1.1e-06 nrd=1.16667 \
        nrs=1.16667 sa=2e-06 sb=1.675e-06 sd=160n sca=13.5671 scb=0.012183 \
        scc=0.000647513 m=(1)
mp2_4__rcx (\11\:Y \8\:C 4 VDD) g45p1svt w=(3.9e-07) l=4.5e-08 nf=1 \
        as=2.34e-14 ad=6.24e-14 ps=9e-07 pd=1.1e-06 nrd=1.16667 \
        nrs=1.16667 sa=2e-06 sb=1.47e-06 sd=160n sca=13.5671 scb=0.012183 \
        scc=0.000647513 m=(1)
mp1_4__rcx (4 \10\:B 13 VDD) g45p1svt w=(3.9e-07) l=4.5e-08 nf=1 \
        as=8.19e-14 ad=2.34e-14 ps=1.2e-06 pd=9e-07 nrd=1.16667 \
        nrs=1.16667 sa=2e-06 sb=1.365e-06 sd=160n sca=13.5671 scb=0.012183 \
        scc=0.000647513 m=(1)
mp0_4__rcx (13 \15\:A \10\:VDD VDD) g45p1svt w=(3.9e-07) l=4.5e-08 nf=1 \
        as=6.24e-14 ad=8.19e-14 ps=1.1e-06 pd=1.2e-06 nrd=1.16667 \
        nrs=1.16667 sa=2e-06 sb=1.11e-06 sd=160n sca=13.5671 scb=0.012183 \
        scc=0.000647513 m=(1)
mp0_5__rcx (14 \14\:A \10\:VDD VDD) g45p1svt w=(3.9e-07) l=4.5e-08 nf=1 \
        as=6.24e-14 ad=6.63e-14 ps=1.1e-06 pd=1.12e-06 nrd=1.16667 \
        nrs=1.16667 sa=2e-06 sb=9.05e-07 sd=160n sca=13.5671 scb=0.012183 \
        scc=0.000647513 m=(1)
mp1_5__rcx (14 \13\:B 5 VDD) g45p1svt w=(3.9e-07) l=4.5e-08 nf=1 \
        as=2.34e-14 ad=6.63e-14 ps=9e-07 pd=1.12e-06 nrd=1.16667 \
        nrs=1.16667 sa=2e-06 sb=6.9e-07 sd=160n sca=13.8386 scb=0.012255 \
        scc=0.000647525 m=(1)
mp2_5__rcx (\9\:Y \17\:C 5 VDD) g45p1svt w=(3.9e-07) l=4.5e-08 nf=1 \
        as=2.34e-14 ad=6.24e-14 ps=9e-07 pd=1.1e-06 nrd=1.16667 \
        nrs=1.16667 sa=2e-06 sb=5.85e-07 sd=160n sca=14.1837 scb=0.0124217 \
        scc=0.000647608 m=(1)
mp2 (\9\:Y \15\:C 6 VDD) g45p1svt w=(3.9e-07) l=4.5e-08 nf=1 as=2.34e-14 \
        ad=6.24e-14 ps=9e-07 pd=1.1e-06 nrd=1.16667 nrs=1.16667 sa=2e-06 \
        sb=3.8e-07 sd=160n sca=15.4628 scb=0.0137376 scc=0.00065186 m=(1)
mp1 (6 \16\:B 15 VDD) g45p1svt w=(3.9e-07) l=4.5e-08 nf=1 as=3.51e-14 \
        ad=2.34e-14 ps=9.6e-07 pd=9e-07 nrd=1.16667 nrs=1.16667 sa=2e-06 \
        sb=2.75e-07 sd=160n sca=16.8269 scb=0.0158863 scc=0.000676698 \
        m=(1)
mp0 (15 \16\:A \13\:VDD VDD) g45p1svt w=(3.9e-07) l=4.5e-08 nf=1 \
        as=5.46e-14 ad=3.51e-14 ps=1.06e-06 pd=9.6e-07 nrd=1.16667 \
        nrs=1.16667 sa=2e-06 sb=1.4e-07 sd=160n sca=20.691 scb=0.0225653 \
        scc=0.00096071 m=(1)
C1 (C VSS) capacitor c=8.84588e-16
C2 (A VSS) capacitor c=1.92788e-17
C3 (Y VSS) capacitor c=1.16545e-16
C4 (VDD VSS) capacitor c=2.4221e-16
C5 (B VSS) capacitor c=6.35708e-17
C6 (2 VSS) capacitor c=1.56659e-18
C7 (8 VSS) capacitor c=1.13351e-17
C8 (3 VSS) capacitor c=2.44041e-18
C9 (11 VSS) capacitor c=7.46017e-18
C10 (12 VSS) capacitor c=9.69343e-18
C11 (9 VSS) capacitor c=1.84473e-17
C12 (4 VSS) capacitor c=2.44041e-18
C13 (13 VSS) capacitor c=8.81225e-18
C14 (14 VSS) capacitor c=7.9355e-18
C15 (5 VSS) capacitor c=2.44041e-18
C16 (6 VSS) capacitor c=2.37923e-18
C17 (15 VSS) capacitor c=3.57883e-18
C18 (\16\:A VSS) capacitor c=5.38206e-17
C19 (\16\:B VSS) capacitor c=1.0103e-16
C20 (\15\:C VSS) capacitor c=5.90069e-17
C21 (\17\:C VSS) capacitor c=7.64751e-17
C22 (\13\:B VSS) capacitor c=7.64549e-17
C23 (\14\:A VSS) capacitor c=2.8914e-17
C24 (\15\:A VSS) capacitor c=2.28843e-17
C25 (\10\:B VSS) capacitor c=8.1298e-17
C26 (\8\:C VSS) capacitor c=7.95296e-17
C27 (\14\:C VSS) capacitor c=2.77121e-17
C28 (\7\:B VSS) capacitor c=3.65204e-17
C29 (\8\:A VSS) capacitor c=2.41083e-17
C30 (\9\:A VSS) capacitor c=2.87504e-17
C31 (\4\:B VSS) capacitor c=7.78642e-17
C32 (\1\:C VSS) capacitor c=7.27932e-17
C33 (\7\:C VSS) capacitor c=2.72622e-17
C34 (\1\:B VSS) capacitor c=6.85128e-17
C35 (\1\:A VSS) capacitor c=6.33091e-17
C36 (\17\:A VSS) capacitor c=4.04018e-17
C37 (\17\:B VSS) capacitor c=6.29641e-17
C38 (\2\:B VSS) capacitor c=1.20991e-15
C39 (\2\:A VSS) capacitor c=1.08689e-15
C40 (\13\:VDD VSS) capacitor c=4.42617e-17
C41 (\9\:Y VSS) capacitor c=1.54748e-16
C42 (\10\:VDD VSS) capacitor c=3.6975e-17
C43 (\11\:Y VSS) capacitor c=2.17116e-16
C44 (\7\:VDD VSS) capacitor c=3.88275e-17
C45 (\13\:Y VSS) capacitor c=1.52801e-16
C46 (\1\:VDD VSS) capacitor c=3.32061e-17
C47 (\4\:VDD VSS) capacitor c=5.41813e-17
C48 (\1\:Y VSS) capacitor c=6.36279e-16
C49 (\16\:C VSS) capacitor c=3.29189e-17
C50 (\18\:B VSS) capacitor c=2.61388e-17
C51 (\20\:A VSS) capacitor c=1.57455e-16
C52 (\3\:VDD VSS) capacitor c=1.52036e-17
C53 (\6\:VDD VSS) capacitor c=2.88196e-17
C54 (\9\:VDD VSS) capacitor c=3.30491e-17
Rk15 (\2\:A A) resistor r=0.03773 c=0
Rk11 (\2\:A \20\:A) resistor r=0.9952 c=0
Rk19 (\1\:Y Y) resistor r=0.6777 c=0
Rk20 (Y \10\:Y) resistor r=0.464 c=0
Rk21 (\10\:Y \12\:Y) resistor r=0.8066 c=0
Rk22 (\12\:Y \14\:Y) resistor r=1.0442 c=0
Rk28 (\3\:VDD VDD) resistor r=0.1149 c=0
Rk27 (\2\:VDD \3\:VDD) resistor r=0.2677 c=0
Rk29 (\3\:VDD \5\:VDD) resistor r=0.4362 c=0
Rk30 (\5\:VDD \6\:VDD) resistor r=0.1754 c=0
Rk31 (\6\:VDD \8\:VDD) resistor r=0.2196 c=0
Rk32 (\6\:VDD \9\:VDD) resistor r=0.7319 c=0
Rk33 (\9\:VDD \11\:VDD) resistor r=0.2196 c=0
Rk34 (\9\:VDD \12\:VDD) resistor r=0.1453 c=0
Rk35 (\12\:VDD \14\:VDD) resistor r=0.5655 c=0
Rk37 (\1\:VSS VSS) resistor r=0.06476 c=0
Rk5 (B \2\:B) resistor r=0.2915 c=0
Rk4 (\18\:B B) resistor r=0.08133 c=0
Rl20 (C \8\:C) resistor r=159.593 c=0
Rl25 (C \14\:C) resistor r=101.605 c=0
Rl5 (C \1\:C) resistor r=119.762 c=0
Rl10 (C \7\:C) resistor r=103.431 c=0
Rl37 (C \16\:C) resistor r=70.5495 c=0
Rl35 (\16\:C \15\:C) resistor r=44.2087 c=0
Rl36 (\16\:C \17\:C) resistor r=88.4394 c=0
Rl41 (\17\:A \16\:A) resistor r=62.2302 c=0
Rl31 (\2\:A \14\:A) resistor r=49.5589 c=0
Rl32 (\2\:A \15\:A) resistor r=24.2328 c=0
Rl16 (\2\:A \8\:A) resistor r=24.2328 c=0
Rl17 (\2\:A \9\:A) resistor r=47.3105 c=0
Rl1 (\2\:A \1\:A) resistor r=44.208 c=0
Rl40 (\17\:B \16\:B) resistor r=74.2328 c=0
Rl33 (\2\:B \13\:B) resistor r=44.9225 c=0
Rl26 (\2\:B \10\:B) resistor r=75.6918 c=0
Rl18 (\2\:B \7\:B) resistor r=53.0211 c=0
Rl11 (\2\:B \4\:B) resistor r=44.9225 c=0
Rl3 (\2\:B \1\:B) resistor r=44.9225 c=0
Rz9 (\4\:VDD \5\:VDD) resistor r=6.25 c=0
Rz10 (\4\:VDD \12\:VDD) resistor r=8.3333 c=0
Ry1 (\10\:Y \9\:Y) resistor r=62 c=0
Ry2 (\12\:Y \11\:Y) resistor r=62 c=0
Ry3 (\14\:Y \13\:Y) resistor r=62 c=0
Ry4 (\1\:VDD \2\:VDD) resistor r=31 c=0
Ry5 (\7\:VDD \8\:VDD) resistor r=62 c=0
Ry6 (\10\:VDD \11\:VDD) resistor r=62 c=0
Ry7 (\13\:VDD \14\:VDD) resistor r=62 c=0
Rx11 (\20\:A \17\:A) resistor r=45 c=0
Rx4 (\18\:B \17\:B) resistor r=45 c=0
mn0_1__rcx (\1\:Y \2\:A \1\:VSS VSS) g45n1svt w=(3.1e-07) l=4.5e-08 nf=1 \
        as=8.388e-14 ad=4.96e-14 ps=1.372e-06 pd=9.4e-07 nrd=1.16667 \
        nrs=1.16667 sa=1.4e-07 sb=2e-06 sd=160n sca=11.5366 scb=0.0108681 \
        scc=0.000577396 m=(5)
mn1_1__rcx (\1\:Y \2\:B \1\:VSS VSS) g45n1svt w=(3.1e-07) l=4.5e-08 nf=1 \
        as=9.4e-14 ad=4.96e-14 ps=1.49e-06 pd=9.4e-07 nrd=1.16667 \
        nrs=1.16667 sa=3.45e-07 sb=2e-06 sd=160n sca=11.5366 scb=0.0108681 \
        scc=0.000577396 m=(5)
mn2_1__rcx (\1\:Y C \1\:VSS VSS) g45n1svt w=(3.1e-07) l=4.5e-08 nf=1 \
        as=9.4e-14 ad=4.836e-14 ps=1.49e-06 pd=9.32e-07 nrd=1.16667 \
        nrs=1.16667 sa=6.1e-07 sb=2e-06 sd=160n sca=11.5366 scb=0.0108681 \
        scc=0.000577396 m=(5)
ends NOR3X6
// End of subcircuit definition.
