// Generated for: spectre (May  1 08:16:36 2013 )
// Library name: gsclib045
// Cell name: NOR4X4
// View name: extracted

simulator lang=spectre

subckt NOR4X4 A B C D VDD VSS Y
mp0_1__rcx (n0 A \4\:VDD VDD) g45p1svt w=(3.9e-07) l=4.5e-08 nf=1 \
        as=6.24e-14 ad=6.094e-14 ps=1.1e-06 pd=1.0925e-06 nrd=1.16667 \
        nrs=1.16667 sa=1.4e-07 sb=1.58e-06 sd=160n sca=22.8747 \
        scb=0.0261588 scc=0.00121841 m=(4)
mp2_1__rcx (n2 C n1 VDD) g45p1svt w=(3.9e-07) l=4.5e-08 nf=1 as=6.24e-14 \
        ad=6.045e-14 ps=1.1e-06 pd=1.09e-06 nrd=1.16667 nrs=1.16667 \
        sa=1.4e-07 sb=1.575e-06 sd=160n sca=13.5671 scb=0.012183 \
        scc=0.000647513 m=(4)
mp1_1__rcx (\4\:n1 B n0 VDD) g45p1svt w=(3.9e-07) l=4.5e-08 nf=1 \
        as=6.094e-14 ad=6.24e-14 ps=1.0925e-06 pd=1.1e-06 nrd=1.16667 \
        nrs=1.16667 sa=9.65e-07 sb=7.55e-07 sd=160n sca=12.0739 \
        scb=0.0104574 scc=0.000357242 m=(4)
mp3_1__rcx (\18\:Y \1\:D n2 VDD) g45p1svt w=(3.9e-07) l=4.5e-08 nf=1 \
        as=6.045e-14 ad=6.24e-14 ps=1.09e-06 pd=1.1e-06 nrd=1.16667 \
        nrs=1.16667 sa=9.6e-07 sb=7.55e-07 sd=160n sca=13.7486 \
        scb=0.0122257 scc=0.000647518 m=(4)
C1 (B VSS) capacitor c=4.47078e-16
C2 (D VSS) capacitor c=5.06074e-17
C3 (A VSS) capacitor c=3.7172e-16
C4 (Y VSS) capacitor c=2.35513e-16
C5 (VDD VSS) capacitor c=2.54359e-16
C6 (C VSS) capacitor c=3.80046e-16
C7 (n0 VSS) capacitor c=3.93183e-16
C8 (n1 VSS) capacitor c=1.75486e-16
C9 (n2 VSS) capacitor c=3.66458e-16
C10 (\1\:D VSS) capacitor c=3.2326e-16
C11 (\18\:Y VSS) capacitor c=3.42784e-16
C12 (\4\:n1 VSS) capacitor c=1.49442e-16
C13 (\1\:VDD VSS) capacitor c=1.61809e-16
C14 (\1\:Y VSS) capacitor c=1.05491e-16
C15 (\5\:Y VSS) capacitor c=1.20479e-16
C16 (\9\:Y VSS) capacitor c=1.07659e-16
C17 (\14\:Y VSS) capacitor c=7.95268e-17
C18 (\13\:Y VSS) capacitor c=2.8979e-17
C19 (\4\:VDD VSS) capacitor c=1.15657e-16
Rk49 (\1\:VSS VSS) resistor r=0.1575 c=0
Rk19 (\1\:D D) resistor r=0.1482 c=0
Rk29 (Y \18\:Y) resistor r=1.6043 c=0
Rk21 (\1\:Y \5\:Y) resistor r=0.281 c=0
Rk23 (\5\:Y \9\:Y) resistor r=0.2729 c=0
Rk28 (\13\:Y Y) resistor r=0.136 c=0
Rk25 (\9\:Y \13\:Y) resistor r=0.2413 c=0
Rk26 (\13\:Y \14\:Y) resistor r=0.05874 c=0
Rk53 (\2\:VDD \3\:VDD) resistor r=0.9527 c=0
Rk56 (\4\:VDD VDD) resistor r=0.1023 c=0
Rk54 (\3\:VDD \4\:VDD) resistor r=0.243 c=0
Rk15 (n1 \4\:n1) resistor r=0.4695 c=0
Rz18 (\2\:VDD \1\:VDD) resistor r=10.7143 c=0
Rz19 (\3\:VDD \1\:VDD) resistor r=6.25 c=0
mn3_1__rcx (\1\:Y \1\:D \1\:VSS VSS) g45n1svt w=(2.6e-07) l=4.5e-08 nf=1 \
        as=4.03e-14 ad=4.16e-14 ps=8.3e-07 pd=8.4e-07 nrd=1.16667 \
        nrs=1.16667 sa=2e-06 sb=7.55e-07 sd=160n sca=14.8545 scb=0.0148797 \
        scc=0.00110433 m=(4)
mn2_1__rcx (\5\:Y C \1\:VSS VSS) g45n1svt w=(2.6e-07) l=4.5e-08 nf=1 \
        as=4.16e-14 ad=4.16e-14 ps=8.4e-07 pd=8.4e-07 nrd=1.16667 \
        nrs=1.16667 sa=1.78e-06 sb=1.575e-06 sd=160n sca=14.8545 \
        scb=0.0148797 scc=0.00110433 m=(4)
mn1_1__rcx (\9\:Y B \1\:VSS VSS) g45n1svt w=(2.6e-07) l=4.5e-08 nf=1 \
        as=4.16e-14 ad=4.16e-14 ps=8.4e-07 pd=8.4e-07 nrd=1.16667 \
        nrs=1.16667 sa=9.6e-07 sb=2e-06 sd=160n sca=14.8545 scb=0.0148797 \
        scc=0.00110433 m=(4)
mn0_1__rcx (\14\:Y A \1\:VSS VSS) g45n1svt w=(2.6e-07) l=4.5e-08 nf=1 \
        as=4.03e-14 ad=4.16e-14 ps=8.3e-07 pd=8.4e-07 nrd=1.16667 \
        nrs=1.16667 sa=1.4e-07 sb=2e-06 sd=160n sca=14.8545 scb=0.0148797 \
        scc=0.00110433 m=(4)
ends NOR4X4
// End of subcircuit definition.
