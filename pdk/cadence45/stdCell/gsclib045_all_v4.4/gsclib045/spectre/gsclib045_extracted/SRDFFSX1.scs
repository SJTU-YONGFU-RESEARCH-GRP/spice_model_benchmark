// Generated for: spectre (May  1 08:12:49 2013 )
// Library name: gsclib045
// Cell name: SRDFFSX1
// View name: extracted

simulator lang=spectre

subckt SRDFFSX1 CK D ExtVDD Q QN RT SE SI SN VDD VSS
PM3 (\15\:n35g \4\:RTb net234 ExtVDD) g45p1svt w=(2.15e-07) l=4.5e-08 \
        nf=1 as=3.01e-14 ad=1.29e-14 ps=7.1e-07 pd=5.5e-07 nrd=1.16667 \
        nrs=1.16667 sa=8.7e-07 sb=1.4e-07 sd=160n sca=25.2796 \
        scb=0.0259458 scc=0.00265434 m=(1)
mp11 (n1 \4\:D \25\:VDD VDD) g45p1svt w=(2.15e-07) l=4.5e-08 nf=1 \
        as=1.362e-13 ad=1.29e-14 ps=2.93e-06 pd=5.5e-07 nrd=1.16667 \
        nrs=1.16667 sa=1.7e-07 sb=7.6e-07 sd=160n sca=15.238 scb=0.0153511 \
        scc=0.00103803 m=(1)
mp52 (n11 \11\:qbint \14\:VDD VDD) g45p1svt w=(2.15e-07) l=4.5e-08 nf=1 \
        as=3.44e-14 ad=3.01e-14 ps=7.5e-07 pd=7.1e-07 nrd=1.16667 \
        nrs=1.16667 sa=1.4e-07 sb=3.45e-07 sd=160n sca=11.272 \
        scb=0.00858882 scc=0.000167946 m=(1)
mp21 (\17\:CKbb \4\:CKb \25\:VDD VDD) g45p1svt w=(2.15e-07) l=4.5e-08 \
        nf=1 as=1.362e-13 ad=3.01e-14 ps=2.93e-06 pd=7.1e-07 nrd=1.16667 \
        nrs=1.16667 sa=1.4e-07 sb=3.45e-07 sd=160n sca=15.2549 \
        scb=0.0153595 scc=0.00103804 m=(1)
mp20 (\17\:CKb \4\:CK \25\:VDD VDD) g45p1svt w=(2.15e-07) l=4.5e-08 nf=1 \
        as=3.01e-14 ad=1.362e-13 ps=7.1e-07 pd=2.93e-06 nrd=1.16667 \
        nrs=1.16667 sa=3.45e-07 sb=1.4e-07 sd=160n sca=14.7851 \
        scb=0.0152025 scc=0.00103799 m=(1)
mp10 (\8\:SEb \3\:SE \18\:VDD VDD) g45p1svt w=(2.15e-07) l=4.5e-08 nf=1 \
        as=3.44e-14 ad=3.01e-14 ps=7.5e-07 pd=7.1e-07 nrd=1.16667 \
        nrs=1.16667 sa=7.9e-07 sb=1.4e-07 sd=160n sca=34.2363 \
        scb=0.0392303 scc=0.00368484 m=(1)
mp14 (\3\:Db SEb n3 VDD) g45p1svt w=(2.15e-07) l=4.5e-08 nf=1 as=1.29e-14 \
        ad=3.44e-14 ps=5.5e-07 pd=7.5e-07 nrd=1.16667 nrs=1.16667 \
        sa=4.8e-07 sb=4.5e-07 sd=160n sca=17.3611 scb=0.0177712 \
        scc=0.00105096 m=(1)
mp56 (\9\:net573 \13\:qbint \16\:VDD VDD) g45p1svt w=(2.15e-07) \
        l=4.5e-08 nf=1 as=3.01e-14 ad=6.535e-14 ps=7.1e-07 pd=1.16e-06 \
        nrd=1.16667 nrs=1.16667 sa=3.75e-07 sb=1.4e-07 sd=160n sca=18.0318 \
        scb=0.0190355 scc=0.000934132 m=(1)
mp35 (n7 mout \23\:VDD VDD) g45p1svt w=(2.15e-07) l=4.5e-08 nf=1 \
        as=1.29e-14 ad=3.44e-14 ps=5.5e-07 pd=7.5e-07 nrd=1.16667 \
        nrs=1.16667 sa=2.45e-07 sb=3.45e-07 sd=160n sca=6.42122 \
        scb=0.00257522 scc=1.4095e-05 m=(1)
mp25 (\10\:n20 \3\:CKbb \5\:Db VDD) g45p1svt w=(2.15e-07) l=4.5e-08 nf=1 \
        as=3.01e-14 ad=3.01e-14 ps=7.1e-07 pd=7.1e-07 nrd=1.16667 \
        nrs=1.16667 sa=1.4e-07 sb=1.4e-07 sd=160n sca=20.3407 scb=0.022946 \
        scc=0.00119484 m=(1)
mp36 (\13\:n20 \8\:CKb n7 VDD) g45p1svt w=(2.15e-07) l=4.5e-08 nf=1 \
        as=1.29e-14 ad=3.01e-14 ps=5.5e-07 pd=7.1e-07 nrd=1.16667 \
        nrs=1.16667 sa=1.4e-07 sb=4.5e-07 sd=160n sca=6.79882 \
        scb=0.00278203 scc=1.42286e-05 m=(1)
mp30 (\16\:mout \1\:SN \23\:VDD VDD) g45p1svt w=(2.15e-07) l=4.5e-08 \
        nf=1 as=3.44e-14 ad=3.01e-14 ps=7.5e-07 pd=7.1e-07 nrd=1.16667 \
        nrs=1.16667 sa=4.5e-07 sb=1.4e-07 sd=160n sca=6.07861 \
        scb=0.00247604 scc=1.40748e-05 m=(1)
mp32 (\19\:mout \3\:n20 \20\:VDD VDD) g45p1svt w=(2.15e-07) l=4.5e-08 \
        nf=1 as=3.01e-14 ad=3.01e-14 ps=7.1e-07 pd=7.1e-07 nrd=1.16667 \
        nrs=1.16667 sa=1.4e-07 sb=1.4e-07 sd=160n sca=6.79882 \
        scb=0.00278203 scc=1.42286e-05 m=(1)
mp12 (\3\:Db \4\:SE n1 VDD) g45p1svt w=(2.15e-07) l=4.5e-08 nf=1 \
        as=1.29e-14 ad=3.44e-14 ps=5.5e-07 pd=7.5e-07 nrd=1.16667 \
        nrs=1.16667 sa=2.75e-07 sb=6.55e-07 sd=160n sca=15.6684 \
        scb=0.0156302 scc=0.00103829 m=(1)
mp13 (n3 \3\:SI \18\:VDD VDD) g45p1svt w=(2.15e-07) l=4.5e-08 nf=1 \
        as=3.44e-14 ad=1.29e-14 ps=7.5e-07 pd=5.5e-07 nrd=1.16667 \
        nrs=1.16667 sa=5.85e-07 sb=3.45e-07 sd=160n sca=19.3151 \
        scb=0.0211393 scc=0.00112289 m=(1)
mp40 (\4\:n35 \7\:CKb \5\:mout VDD) g45p1svt w=(2.15e-07) l=4.5e-08 nf=1 \
        as=3.01e-14 ad=3.01e-14 ps=7.1e-07 pd=7.1e-07 nrd=1.16667 \
        nrs=1.16667 sa=1.4e-07 sb=1.4e-07 sd=160n sca=25.5298 \
        scb=0.0265038 scc=0.00266093 m=(1)
PM0 (\6\:n35g \5\:RT \9\:n35 ExtVDD) g45p1svt w=(2.15e-07) l=4.5e-08 nf=1 \
        as=3.01e-14 ad=3.01e-14 ps=7.1e-07 pd=7.1e-07 nrd=1.16667 \
        nrs=1.16667 sa=1.4e-07 sb=1.4e-07 sd=160n sca=26.0836 \
        scb=0.0271848 scc=0.00267095 m=(1)
mp45 (\17\:qbint \3\:n35g \1\:ExtVDD ExtVDD) g45p1svt w=(2.15e-07) \
        l=4.5e-08 nf=1 as=3.5882e-13 ad=3.01e-14 ps=3.6e-06 pd=7.1e-07 \
        nrd=1.16667 nrs=1.16667 sa=1.4e-07 sb=8.7e-07 sd=160n sca=25.2796 \
        scb=0.0259458 scc=0.00265434 m=(1)
PM2 (net234 \4\:qbint \1\:ExtVDD ExtVDD) g45p1svt w=(2.15e-07) l=4.5e-08 \
        nf=1 as=3.5882e-13 ad=1.29e-14 ps=3.6e-06 pd=5.5e-07 nrd=1.16667 \
        nrs=1.16667 sa=7.65e-07 sb=2.45e-07 sd=160n sca=14.5295 \
        scb=0.0144143 scc=0.000486924 m=(1)
PM1 (\6\:RTb \6\:RT \1\:ExtVDD ExtVDD) g45p1svt w=(2.15e-07) l=4.5e-08 \
        nf=1 as=3.5882e-13 ad=3.01e-14 ps=3.6e-06 pd=7.1e-07 nrd=1.16667 \
        nrs=1.16667 sa=3.3e-07 sb=1.4e-07 sd=160n sca=24.3731 \
        scb=0.0258873 scc=0.00229004 m=(1)
mp53 (\14\:n35 \11\:CKbb \3\:n11 VDD) g45p1svt w=(2.15e-07) l=4.5e-08 \
        nf=1 as=3.01e-14 ad=3.01e-14 ps=7.1e-07 pd=7.1e-07 nrd=1.16667 \
        nrs=1.16667 sa=1.4e-07 sb=1.4e-07 sd=160n sca=28.3325 \
        scb=0.0311878 scc=0.00281308 m=(1)
mp50 (n11 \7\:SN \12\:VDD VDD) g45p1svt w=(2.15e-07) l=4.5e-08 nf=1 \
        as=3.01e-14 ad=3.44e-14 ps=7.1e-07 pd=7.5e-07 nrd=1.16667 \
        nrs=1.16667 sa=3.45e-07 sb=1.4e-07 sd=160n sca=12.4133 \
        scb=0.0108228 scc=0.00019293 m=(1)
C1 (Q VSS) capacitor c=5.87853e-17
C2 (D VSS) capacitor c=7.4302e-17
C3 (QN VSS) capacitor c=1.89004e-17
C4 (RT VSS) capacitor c=6.47056e-17
C5 (SI VSS) capacitor c=8.72799e-17
C6 (CK VSS) capacitor c=7.39135e-17
C7 (SN VSS) capacitor c=5.15768e-17
C8 (VDD VSS) capacitor c=7.17297e-16
C9 (ExtVDD VSS) capacitor c=2.17804e-16
C10 (SE VSS) capacitor c=9.25557e-17
C11 (n20 VSS) capacitor c=3.84704e-17
C12 (CKbb VSS) capacitor c=2.98966e-17
C13 (mout VSS) capacitor c=5.41849e-17
C14 (CKb VSS) capacitor c=5.11416e-17
C15 (SEb VSS) capacitor c=7.78913e-17
C16 (n35g VSS) capacitor c=1.81021e-17
C17 (qbint VSS) capacitor c=4.50779e-17
C18 (RTb VSS) capacitor c=5.18542e-17
C19 (net573 VSS) capacitor c=2.24911e-17
C20 (n35 VSS) capacitor c=1.72987e-16
C21 (Db VSS) capacitor c=9.74662e-17
C22 (n11 VSS) capacitor c=8.02955e-17
C23 (n1 VSS) capacitor c=1.02126e-18
C24 (\7\:qbint VSS) capacitor c=3.27466e-17
C25 (\7\:SN VSS) capacitor c=8.63122e-17
C26 (\11\:qbint VSS) capacitor c=1.07655e-16
C27 (\13\:qbint VSS) capacitor c=4.44846e-17
C28 (\3\:net573 VSS) capacitor c=5.88814e-17
C29 (\11\:CKbb VSS) capacitor c=4.66897e-17
C30 (\4\:RTb VSS) capacitor c=9.92332e-17
C31 (\6\:RT VSS) capacitor c=2.32835e-17
C32 (\4\:qbint VSS) capacitor c=5.43131e-17
C33 (\3\:n35g VSS) capacitor c=5.38326e-17
C34 (\5\:RT VSS) capacitor c=6.6308e-17
C35 (\3\:SE VSS) capacitor c=7.79257e-17
C36 (\7\:CKb VSS) capacitor c=3.24234e-17
C37 (\3\:SI VSS) capacitor c=9.50348e-17
C38 (\4\:SE VSS) capacitor c=1.23974e-16
C39 (\3\:n20 VSS) capacitor c=2.47551e-17
C40 (\4\:D VSS) capacitor c=7.21093e-17
C41 (\1\:SN VSS) capacitor c=3.03251e-17
C42 (\4\:CK VSS) capacitor c=6.00607e-17
C43 (\4\:CKb VSS) capacitor c=4.76066e-17
C44 (\8\:CKb VSS) capacitor c=8.37379e-17
C45 (\3\:CKbb VSS) capacitor c=3.14545e-17
C46 (\6\:qbint VSS) capacitor c=3.83393e-17
C47 (\14\:qbint VSS) capacitor c=4.68866e-17
C48 (\8\:SN VSS) capacitor c=1.46664e-16
C49 (\12\:qbint VSS) capacitor c=1.49248e-16
C50 (\4\:net573 VSS) capacitor c=3.67878e-17
C51 (\11\:CKb VSS) capacitor c=2.54305e-16
C52 (\8\:RT VSS) capacitor c=1.22491e-16
C53 (\2\:RT VSS) capacitor c=6.24848e-17
C54 (\5\:qbint VSS) capacitor c=3.89021e-17
C55 (\5\:n35g VSS) capacitor c=3.28693e-17
C56 (\2\:RTb VSS) capacitor c=4.94565e-17
C57 (\5\:SE VSS) capacitor c=5.77321e-17
C58 (\5\:CKbb VSS) capacitor c=2.73683e-17
C59 (\1\:SI VSS) capacitor c=4.91758e-17
C60 (\6\:SE VSS) capacitor c=8.73973e-17
C61 (\3\:SEb VSS) capacitor c=6.67349e-17
C62 (\1\:D VSS) capacitor c=4.94494e-17
C63 (\6\:n20 VSS) capacitor c=8.26456e-17
C64 (\6\:SN VSS) capacitor c=7.08369e-17
C65 (\1\:CK VSS) capacitor c=2.90039e-17
C66 (\3\:mout VSS) capacitor c=4.47936e-17
C67 (\9\:CKb VSS) capacitor c=3.70074e-17
C68 (\10\:CKbb VSS) capacitor c=4.84288e-17
C69 (\6\:CKb VSS) capacitor c=5.24812e-17
C70 (\10\:qbint VSS) capacitor c=8.4428e-17
C71 (\12\:CKbb VSS) capacitor c=5.14028e-17
C72 (\3\:SN VSS) capacitor c=2.85605e-16
C73 (\9\:SN VSS) capacitor c=6.35566e-17
C74 (\7\:RT VSS) capacitor c=1.45806e-16
C75 (\9\:CKbb VSS) capacitor c=1.68353e-16
C76 (\3\:RT VSS) capacitor c=3.9325e-17
C77 (\1\:RT VSS) capacitor c=5.31338e-17
C78 (\3\:RTb VSS) capacitor c=7.6116e-17
C79 (\3\:qbint VSS) capacitor c=4.462e-17
C80 (\2\:n35 VSS) capacitor c=2.52702e-16
C81 (\4\:n35g VSS) capacitor c=6.7148e-17
C82 (\12\:CKb VSS) capacitor c=2.19285e-16
C83 (\3\:n35 VSS) capacitor c=1.15906e-16
C84 (\1\:SE VSS) capacitor c=2.46698e-17
C85 (\2\:SI VSS) capacitor c=7.76828e-17
C86 (\2\:SEb VSS) capacitor c=7.84512e-17
C87 (\7\:n20 VSS) capacitor c=4.84514e-17
C88 (\4\:n20 VSS) capacitor c=7.40254e-17
C89 (\3\:D VSS) capacitor c=1.51283e-17
C90 (\2\:SN VSS) capacitor c=4.21305e-17
C91 (\5\:SN VSS) capacitor c=2.67168e-17
C92 (\3\:CK VSS) capacitor c=2.32661e-17
C93 (\2\:mout VSS) capacitor c=4.67116e-17
C94 (\4\:mout VSS) capacitor c=2.88546e-17
C95 (\10\:CKb VSS) capacitor c=2.33818e-17
C96 (\5\:n20 VSS) capacitor c=7.9592e-17
C97 (\4\:CKbb VSS) capacitor c=6.37226e-17
C98 (\8\:CKbb VSS) capacitor c=2.56994e-17
C99 (\2\:n20 VSS) capacitor c=3.96715e-17
C100 (\1\:VDD VSS) capacitor c=4.32884e-17
C101 (\12\:VDD VSS) capacitor c=2.78026e-17
C102 (\3\:Q VSS) capacitor c=7.96329e-17
C103 (\14\:VDD VSS) capacitor c=5.2844e-17
C104 (\9\:net573 VSS) capacitor c=5.54253e-17
C105 (\16\:VDD VSS) capacitor c=7.90333e-17
C106 (\3\:n11 VSS) capacitor c=8.51682e-17
C107 (\4\:QN VSS) capacitor c=6.87212e-17
C108 (\14\:n35 VSS) capacitor c=5.2074e-17
C109 (\15\:n35g VSS) capacitor c=5.60093e-17
C110 (\6\:RTb VSS) capacitor c=7.36169e-17
C111 (\1\:ExtVDD VSS) capacitor c=2.77552e-16
C112 (\9\:n35 VSS) capacitor c=6.21166e-17
C113 (\17\:qbint VSS) capacitor c=6.81257e-17
C114 (\6\:n35g VSS) capacitor c=9.39138e-17
C115 (\8\:SEb VSS) capacitor c=5.05376e-17
C116 (\4\:n35 VSS) capacitor c=6.28963e-17
C117 (\18\:VDD VSS) capacitor c=6.09284e-17
C118 (\5\:mout VSS) capacitor c=8.77411e-17
C119 (\3\:Db VSS) capacitor c=1.94493e-16
C120 (\20\:VDD VSS) capacitor c=5.05613e-17
C121 (\19\:mout VSS) capacitor c=3.95307e-17
C122 (\25\:VDD VSS) capacitor c=3.45561e-17
C123 (\16\:mout VSS) capacitor c=4.39515e-17
C124 (\17\:CKb VSS) capacitor c=2.98728e-17
C125 (\23\:VDD VSS) capacitor c=4.82504e-17
C126 (\17\:CKbb VSS) capacitor c=6.81543e-17
C127 (\13\:n20 VSS) capacitor c=6.13605e-17
C128 (\5\:Db VSS) capacitor c=2.29311e-16
C129 (\10\:n20 VSS) capacitor c=6.35107e-17
C130 (\1\:Q VSS) capacitor c=5.31752e-17
C131 (\5\:net573 VSS) capacitor c=4.3056e-17
C132 (\1\:QN VSS) capacitor c=3.95078e-17
C133 (\17\:n35 VSS) capacitor c=3.92206e-17
C134 (\11\:n35g VSS) capacitor c=2.9646e-17
C135 (\10\:RTb VSS) capacitor c=5.81576e-17
C136 (\12\:n35 VSS) capacitor c=6.35105e-17
C137 (\19\:qbint VSS) capacitor c=2.4312e-17
C138 (\9\:n35g VSS) capacitor c=8.0334e-17
C139 (\4\:SEb VSS) capacitor c=3.94217e-17
C140 (\7\:n35 VSS) capacitor c=4.08987e-17
C141 (\11\:mout VSS) capacitor c=2.18955e-17
C142 (\13\:mout VSS) capacitor c=1.77476e-17
C143 (\13\:CKb VSS) capacitor c=5.68222e-17
C144 (\15\:CKbb VSS) capacitor c=8.66755e-17
C145 (\17\:n20 VSS) capacitor c=8.68117e-17
C146 (\7\:Db VSS) capacitor c=7.82032e-17
C147 (\8\:n20 VSS) capacitor c=5.8828e-17
C148 (\2\:CKbb VSS) capacitor c=6.33996e-17
C149 (\2\:CK VSS) capacitor c=3.8013e-17
C150 (\2\:D VSS) capacitor c=3.58121e-17
C151 (\2\:SE VSS) capacitor c=2.57832e-17
C152 (\2\:CKb VSS) capacitor c=1.48985e-16
C153 (\3\:CKb VSS) capacitor c=8.85899e-17
C154 (\5\:CKb VSS) capacitor c=5.80277e-17
C155 (VDD VSS) capacitor c=2.29178e-16
C156 (\2\:n35g VSS) capacitor c=2.91019e-17
C157 (\4\:RT VSS) capacitor c=4.7642e-17
C158 (\2\:qbint VSS) capacitor c=4.15774e-17
C159 (\6\:CKbb VSS) capacitor c=1.27934e-16
C160 (\7\:CKbb VSS) capacitor c=7.26369e-17
C161 (\4\:SN VSS) capacitor c=2.51245e-16
C162 (\2\:net573 VSS) capacitor c=1.51896e-17
C163 (\12\:n20 VSS) capacitor c=4.43791e-17
C164 (\13\:CKbb VSS) capacitor c=9.88207e-17
C165 (\14\:CKbb VSS) capacitor c=9.60827e-17
C166 (\15\:n20 VSS) capacitor c=5.22113e-17
C167 (\16\:n20 VSS) capacitor c=9.14603e-17
C168 (\8\:qbint VSS) capacitor c=4.57168e-17
C169 (\9\:qbint VSS) capacitor c=6.76551e-17
C170 (\19\:CKbb VSS) capacitor c=5.17371e-17
C171 (\15\:CKb VSS) capacitor c=6.0013e-17
C172 (\16\:CKb VSS) capacitor c=3.80438e-17
C173 (\10\:SN VSS) capacitor c=3.93457e-17
C174 (\11\:SN VSS) capacitor c=4.31594e-17
C175 (\19\:n20 VSS) capacitor c=6.66198e-17
C176 (\20\:n20 VSS) capacitor c=7.56057e-17
C177 (\7\:mout VSS) capacitor c=8.24009e-17
C178 (\8\:mout VSS) capacitor c=4.31019e-17
C179 (\9\:mout VSS) capacitor c=1.00429e-16
C180 (\10\:mout VSS) capacitor c=8.7307e-17
C181 (\15\:mout VSS) capacitor c=6.70667e-17
C182 (\18\:mout VSS) capacitor c=7.17743e-17
C183 (\6\:SEb VSS) capacitor c=8.40138e-17
C184 (\7\:SEb VSS) capacitor c=6.95776e-17
C185 (\6\:n35 VSS) capacitor c=7.78696e-17
C186 (\19\:CKb VSS) capacitor c=3.90919e-17
C187 (\20\:CKb VSS) capacitor c=4.22696e-17
C188 (\8\:n35g VSS) capacitor c=3.45465e-17
C189 (\11\:n35 VSS) capacitor c=7.49352e-17
C190 (\15\:qbint VSS) capacitor c=8.75716e-17
C191 (\16\:qbint VSS) capacitor c=1.1192e-16
C192 (\13\:n35g VSS) capacitor c=1.03642e-16
C193 (\14\:n35g VSS) capacitor c=1.16086e-16
C194 (\5\:RTb VSS) capacitor c=4.89587e-17
C195 (\8\:RTb VSS) capacitor c=9.92419e-17
C196 (\9\:RTb VSS) capacitor c=9.13939e-17
C197 (\10\:RT VSS) capacitor c=1.0922e-16
C198 (\11\:RT VSS) capacitor c=1.17967e-16
C199 (\12\:SN VSS) capacitor c=8.29034e-17
C200 (\13\:SN VSS) capacitor c=7.84331e-17
C201 (\20\:CKbb VSS) capacitor c=1.30668e-16
C202 (\21\:CKbb VSS) capacitor c=1.34155e-16
C203 (\21\:qbint VSS) capacitor c=2.4137e-17
C204 (\22\:qbint VSS) capacitor c=2.98079e-17
C205 (\3\:QN VSS) capacitor c=3.1402e-17
C206 (\16\:n35 VSS) capacitor c=4.54193e-17
C207 (\7\:net573 VSS) capacitor c=5.41305e-17
C208 (\8\:net573 VSS) capacitor c=3.4576e-17
C209 (\3\:VDD VSS) capacitor c=2.70854e-17
C210 (\4\:VDD VSS) capacitor c=2.57013e-17
C211 (\6\:VDD VSS) capacitor c=9.09693e-18
C212 (\7\:VDD VSS) capacitor c=1.23384e-16
C213 (\8\:VDD VSS) capacitor c=7.08961e-17
C214 (\9\:VDD VSS) capacitor c=2.52741e-17
C215 (\11\:VDD VSS) capacitor c=4.70941e-17
C216 (\22\:VDD VSS) capacitor c=6.00935e-17
Rk72 (\2\:Q Q) resistor r=0.1675 c=0
Rk73 (Q \4\:Q) resistor r=0.332 c=0
Rk64 (\3\:QN QN) resistor r=0.03624 c=0
Rk63 (\2\:QN \3\:QN) resistor r=0.1939 c=0
Rk65 (\3\:QN \5\:QN) resistor r=0.3451 c=0
Rk74 (\2\:VSS \4\:VSS) resistor r=0.4123 c=0
Rk75 (\4\:VSS \5\:VSS) resistor r=0.1887 c=0
Rk76 (\5\:VSS \6\:VSS) resistor r=0.6733 c=0
Rk77 (\6\:VSS \7\:VSS) resistor r=0.03212 c=0
Rk79 (\8\:VSS VSS) resistor r=0.1214 c=0
Rk78 (\7\:VSS \8\:VSS) resistor r=0.1763 c=0
Rk80 (VSS \9\:VSS) resistor r=0.5221 c=0
Rk81 (\9\:VSS \10\:VSS) resistor r=0.3079 c=0
Rk83 (\11\:VSS VSS) resistor r=0.1216 c=0
Rk82 (\10\:VSS \11\:VSS) resistor r=0.06444 c=0
Rk84 (VSS \13\:VSS) resistor r=0.313 c=0
Rk85 (\5\:VSS \15\:VSS) resistor r=0.2678 c=0
Rk86 (\6\:VSS \17\:VSS) resistor r=0.19 c=0
Rk87 (\8\:VSS \19\:VSS) resistor r=0.1951 c=0
Rk88 (\9\:VSS \21\:VSS) resistor r=0.2543 c=0
Rk89 (\10\:VSS \23\:VSS) resistor r=0.2499 c=0
Rk107 (\25\:VSS \26\:VSS) resistor r=0.08184 c=0
Rk108 (\26\:VSS \27\:VSS) resistor r=0.7333 c=0
Rk110 (\28\:VSS VSS) resistor r=0.2981 c=0
Rk109 (\27\:VSS \28\:VSS) resistor r=0.07935 c=0
Rk112 (\29\:VSS VSS) resistor r=0.1216 c=0
Rk111 (VSS \29\:VSS) resistor r=0.8951 c=0
Rk113 (VSS \31\:VSS) resistor r=0.3043 c=0
Rk114 (\26\:VSS \33\:VSS) resistor r=0.2357 c=0
Rk115 (\27\:VSS \35\:VSS) resistor r=0.2445 c=0
Rk116 (\31\:VSS \36\:VSS) resistor r=0.1028 c=0
Rk58 (RT \10\:RT) resistor r=0.1993 c=0
Rk59 (\10\:RT \11\:RT) resistor r=0.6488 c=0
Rk13 (SN \10\:SN) resistor r=0.0106 c=0
Rk14 (\10\:SN \11\:SN) resistor r=0.3153 c=0
Rk60 (\12\:SN \13\:SN) resistor r=0.538 c=0
Rk90 (\2\:VDD \3\:VDD) resistor r=0.3819 c=0
Rk91 (\3\:VDD \4\:VDD) resistor r=0.1963 c=0
Rk92 (\4\:VDD \6\:VDD) resistor r=0.06692 c=0
Rk94 (\7\:VDD VDD) resistor r=1.0051 c=0
Rk93 (\6\:VDD \7\:VDD) resistor r=0.05201 c=0
Rk95 (VDD \8\:VDD) resistor r=0.5208 c=0
Rk96 (\8\:VDD \9\:VDD) resistor r=0.1711 c=0
Rk97 (\9\:VDD \11\:VDD) resistor r=0.1695 c=0
Rk98 (\3\:VDD \13\:VDD) resistor r=0.32 c=0
Rk99 (\4\:VDD \15\:VDD) resistor r=0.3026 c=0
Rk100 (\7\:VDD \17\:VDD) resistor r=0.3757 c=0
Rk101 (\8\:VDD \19\:VDD) resistor r=0.3677 c=0
Rk102 (\9\:VDD \21\:VDD) resistor r=0.2078 c=0
Rk106 (\22\:VDD VDD) resistor r=0.1959 c=0
Rk103 (\11\:VDD \22\:VDD) resistor r=0.1713 c=0
Rk104 (\22\:VDD \24\:VDD) resistor r=0.2078 c=0
Rk105 (\11\:VDD \26\:VDD) resistor r=0.2399 c=0
Rk44 (ExtVDD ExtVDD) resistor r=0.002066 c=0
Rk42 (\2\:ExtVDD ExtVDD) resistor r=0.02219 c=0
Rk45 (ExtVDD \5\:ExtVDD) resistor r=0.02018 c=0
Rk46 (ExtVDD \6\:ExtVDD) resistor r=0.1499 c=0
Rk1 (\9\:n20 \11\:n20) resistor r=0.5452 c=0
Rk2 (\11\:n20 \12\:n20) resistor r=0.2551 c=0
Rk4 (\14\:n20 \15\:n20) resistor r=0.3416 c=0
Rk5 (\14\:n20 \16\:n20) resistor r=0.2303 c=0
Rk6 (\16\:n20 \18\:n20) resistor r=0.4984 c=0
Rk19 (\19\:n20 \20\:n20) resistor r=0.4375 c=0
Rk3 (\13\:CKbb \14\:CKbb) resistor r=0.7542 c=0
Rk7 (\16\:CKbb \18\:CKbb) resistor r=0.532 c=0
Rk8 (\18\:CKbb \19\:CKbb) resistor r=0.2044 c=0
Rk61 (\20\:CKbb \21\:CKbb) resistor r=0.8279 c=0
Rk20 (\6\:mout \7\:mout) resistor r=0.6045 c=0
Rk21 (\7\:mout \8\:mout) resistor r=0.3058 c=0
Rk22 (\8\:mout \9\:mout) resistor r=0.1684 c=0
Rk23 (\9\:mout \10\:mout) resistor r=0.3479 c=0
Rk24 (\7\:mout \12\:mout) resistor r=0.1284 c=0
Rk25 (\8\:mout \14\:mout) resistor r=0.09239 c=0
Rk26 (\9\:mout \15\:mout) resistor r=0.5264 c=0
Rk27 (\15\:mout \17\:mout) resistor r=0.0449 c=0
Rk28 (\10\:mout \18\:mout) resistor r=0.4268 c=0
Rk29 (\15\:mout \20\:mout) resistor r=0.03469 c=0
Rk10 (\14\:CKb \15\:CKb) resistor r=0.318 c=0
Rk11 (\15\:CKb \16\:CKb) resistor r=0.1585 c=0
Rk12 (\15\:CKb \18\:CKb) resistor r=0.1872 c=0
Rk37 (\19\:CKb \20\:CKb) resistor r=0.3729 c=0
Rk32 (\5\:SEb \6\:SEb) resistor r=0.217 c=0
Rk33 (\6\:SEb \7\:SEb) resistor r=0.3559 c=0
Rk34 (\6\:SEb \9\:SEb) resistor r=0.3109 c=0
Rk38 (\7\:n35g \8\:n35g) resistor r=0.2744 c=0
Rk39 (\7\:n35g \10\:n35g) resistor r=0.6943 c=0
Rk50 (\12\:n35g \13\:n35g) resistor r=0.2439 c=0
Rk51 (\13\:n35g \14\:n35g) resistor r=0.5678 c=0
Rk52 (\13\:n35g \16\:n35g) resistor r=0.4337 c=0
Rk47 (\15\:qbint \16\:qbint) resistor r=0.4966 c=0
Rk48 (\16\:qbint \18\:qbint) resistor r=0.5694 c=0
Rk49 (\16\:qbint \20\:qbint) resistor r=0.1469 c=0
Rk62 (\21\:qbint \22\:qbint) resistor r=0.2126 c=0
Rk53 (\5\:RTb \7\:RTb) resistor r=0.2171 c=0
Rk54 (\7\:RTb \8\:RTb) resistor r=0.4182 c=0
Rk55 (\8\:RTb \9\:RTb) resistor r=0.6914 c=0
Rk56 (\8\:RTb \11\:RTb) resistor r=0.3078 c=0
Rk68 (\6\:net573 \7\:net573) resistor r=0.2375 c=0
Rk69 (\7\:net573 \8\:net573) resistor r=0.1656 c=0
Rk70 (\7\:net573 \10\:net573) resistor r=0.2849 c=0
Rk35 (\5\:n35 \6\:n35) resistor r=0.4114 c=0
Rk36 (\6\:n35 \8\:n35) resistor r=0.2915 c=0
Rk40 (\10\:n35 \11\:n35) resistor r=0.4026 c=0
Rk41 (\11\:n35 \13\:n35) resistor r=0.3312 c=0
Rk66 (\15\:n35 \16\:n35) resistor r=0.305 c=0
Rk67 (\16\:n35 \18\:n35) resistor r=0.2683 c=0
Rk16 (\2\:Db \4\:Db) resistor r=0.6389 c=0
Rk17 (\4\:Db \6\:Db) resistor r=1.4324 c=0
Rk18 (\6\:Db \8\:Db) resistor r=0.5673 c=0
Rk71 (\2\:n11 \4\:n11) resistor r=0.6555 c=0
Rl13 (\2\:D \4\:D) resistor r=115.099 c=0
Rl11 (\1\:D \2\:D) resistor r=84.3295 c=0
Rl12 (\2\:D \3\:D) resistor r=5.1123 c=0
Rl54 (\7\:RT \8\:RT) resistor r=651.902 c=0
Rl41 (\1\:RT \2\:RT) resistor r=169.515 c=0
Rl44 (\4\:RT \6\:RT) resistor r=21.372 c=0
Rl43 (\4\:RT \5\:RT) resistor r=264.027 c=0
Rl42 (\3\:RT \4\:RT) resistor r=96.114 c=0
Rl20 (\2\:SI \3\:SI) resistor r=155.002 c=0
Rl19 (\1\:SI \2\:SI) resistor r=24.2328 c=0
Rl9 (\2\:CK \4\:CK) resistor r=147.791 c=0
Rl7 (\1\:CK \2\:CK) resistor r=63.1757 c=0
Rl8 (\2\:CK \3\:CK) resistor r=2.0166 c=0
Rl65 (\7\:SN \8\:SN) resistor r=367.487 c=0
Rl66 (\8\:SN \9\:SN) resistor r=284.764 c=0
Rl10 (\1\:SN \2\:SN) resistor r=24.2328 c=0
Rl57 (\4\:SN \6\:SN) resistor r=115.884 c=0
Rl55 (\3\:SN \4\:SN) resistor r=1092.88 c=0
Rl56 (\4\:SN \5\:SN) resistor r=66.1252 c=0
Rl23 (\3\:SE \4\:SE) resistor r=294.192 c=0
Rl25 (\5\:SE \6\:SE) resistor r=241.873 c=0
Rl22 (\2\:SE \3\:SE) resistor r=49.6369 c=0
Rl24 (\2\:SE \5\:SE) resistor r=147.714 c=0
Rl21 (\1\:SE \2\:SE) resistor r=0.767 c=0
Rl16 (\6\:n20 \7\:n20) resistor r=136.213 c=0
Rl14 (\3\:n20 \4\:n20) resistor r=24.848 c=0
Rl15 (\4\:n20 \5\:n20) resistor r=281.721 c=0
Rl1 (n20 \2\:n20) resistor r=123.512 c=0
Rl60 (\11\:CKbb \12\:CKbb) resistor r=166.412 c=0
Rl3 (\2\:CKbb \3\:CKbb) resistor r=68.4981 c=0
Rl2 (CKbb \2\:CKbb) resistor r=38.8525 c=0
Rl4 (\2\:CKbb \4\:CKbb) resistor r=262.732 c=0
Rl49 (\5\:CKbb \6\:CKbb) resistor r=66.1349 c=0
Rl52 (\6\:CKbb \9\:CKbb) resistor r=762.322 c=0
Rl53 (\7\:CKbb \10\:CKbb) resistor r=60.7265 c=0
Rl51 (\7\:CKbb \8\:CKbb) resistor r=81.3209 c=0
Rl50 (\6\:CKbb \7\:CKbb) resistor r=462.851 c=0
Rl5 (mout \2\:mout) resistor r=24.2328 c=0
Rl6 (\3\:mout \4\:mout) resistor r=24.2328 c=0
Rl61 (\11\:CKb \12\:CKb) resistor r=870.726 c=0
Rl31 (\2\:CKb \7\:CKb) resistor r=127.816 c=0
Rl26 (CKb \2\:CKb) resistor r=349.798 c=0
Rl28 (\3\:CKb \4\:CKb) resistor r=103.952 c=0
Rl32 (\3\:CKb \8\:CKb) resistor r=147.793 c=0
Rl27 (\2\:CKb \3\:CKb) resistor r=431.465 c=0
Rl29 (\4\:CKb \5\:CKb) resistor r=74.8465 c=0
Rl33 (\5\:CKb \9\:CKb) resistor r=132.539 c=0
Rl30 (\5\:CKb \6\:CKb) resistor r=266.282 c=0
Rl34 (\5\:CKb \10\:CKb) resistor r=4.3228 c=0
Rl17 (SEb \2\:SEb) resistor r=101.718 c=0
Rl18 (\2\:SEb \3\:SEb) resistor r=132.669 c=0
Rl37 (\3\:n35g \4\:n35g) resistor r=265.853 c=0
Rl36 (\2\:n35g \3\:n35g) resistor r=181.74 c=0
Rl38 (\2\:n35g \5\:n35g) resistor r=94.1963 c=0
Rl35 (n35g \2\:n35g) resistor r=2.4834 c=0
Rl67 (\6\:qbint \7\:qbint) resistor r=149.805 c=0
Rl74 (\13\:qbint \14\:qbint) resistor r=189.403 c=0
Rl72 (\11\:qbint \12\:qbint) resistor r=343.448 c=0
Rl48 (\3\:qbint \5\:qbint) resistor r=35.3072 c=0
Rl47 (\2\:qbint \4\:qbint) resistor r=70.093 c=0
Rl45 (qbint \2\:qbint) resistor r=112.732 c=0
Rl46 (\2\:qbint \3\:qbint) resistor r=152.601 c=0
Rl68 (\7\:qbint \8\:qbint) resistor r=99.804 c=0
Rl71 (\8\:qbint \11\:qbint) resistor r=200.917 c=0
Rl73 (\9\:qbint \13\:qbint) resistor r=95.4293 c=0
Rl70 (\9\:qbint \10\:qbint) resistor r=387.298 c=0
Rl69 (\8\:qbint \9\:qbint) resistor r=104.193 c=0
Rl40 (\3\:RTb \4\:RTb) resistor r=239.402 c=0
Rl39 (RTb \2\:RTb) resistor r=112.412 c=0
Rl63 (\2\:net573 \3\:net573) resistor r=67.5354 c=0
Rl64 (\2\:net573 \4\:net573) resistor r=64.1263 c=0
Rl62 (net573 \2\:net573) resistor r=3.1216 c=0
Rl58 (n35 \2\:n35) resistor r=508.667 c=0
Rl59 (\2\:n35 \3\:n35) resistor r=334.803 c=0
Rz20 (\1\:Q \2\:Q) resistor r=37.5 c=0
Rz17 (\1\:QN \2\:QN) resistor r=37.5 c=0
Rz21 (\1\:VSS \2\:VSS) resistor r=37.5 c=0
Rz22 (\12\:VSS \13\:VSS) resistor r=75 c=0
Rz23 (\14\:VSS \15\:VSS) resistor r=37.5 c=0
Rz24 (\16\:VSS \17\:VSS) resistor r=75 c=0
Rz25 (\18\:VSS \19\:VSS) resistor r=75 c=0
Rz26 (\20\:VSS \21\:VSS) resistor r=75 c=0
Rz27 (\22\:VSS \23\:VSS) resistor r=75 c=0
Rz30 (\30\:VSS \31\:VSS) resistor r=75 c=0
Rz31 (\32\:VSS \33\:VSS) resistor r=75 c=0
Rz32 (\34\:VSS \35\:VSS) resistor r=75 c=0
Rz33 (\30\:VSS \36\:VSS) resistor r=75 c=0
Rz1 (\8\:n20 \9\:n20) resistor r=75 c=0
Rz2 (\17\:n20 \18\:n20) resistor r=75 c=0
Rz3 (\15\:CKbb \16\:CKbb) resistor r=75 c=0
Rz7 (\11\:mout \12\:mout) resistor r=75 c=0
Rz8 (\13\:mout \14\:mout) resistor r=75 c=0
Rz4 (\13\:CKb \14\:CKb) resistor r=75 c=0
Rz9 (\4\:SEb \5\:SEb) resistor r=75 c=0
Rz11 (\9\:n35g \10\:n35g) resistor r=75 c=0
Rz15 (\11\:n35g \12\:n35g) resistor r=75 c=0
Rz14 (\19\:qbint \20\:qbint) resistor r=75 c=0
Rz16 (\10\:RTb \11\:RTb) resistor r=75 c=0
Rz19 (\5\:net573 \6\:net573) resistor r=75 c=0
Rz10 (\7\:n35 \8\:n35) resistor r=75 c=0
Rz12 (\12\:n35 \13\:n35) resistor r=75 c=0
Rz18 (\17\:n35 \18\:n35) resistor r=75 c=0
Rz5 (Db \2\:Db) resistor r=75 c=0
Rz6 (\7\:Db \8\:Db) resistor r=75 c=0
Ry25 (\3\:Q \4\:Q) resistor r=20.6667 c=0
Ry20 (\4\:QN \5\:QN) resistor r=20.6667 c=0
Ry26 (\3\:VSS \4\:VSS) resistor r=10.3333 c=0
Ry27 (\3\:VSS \7\:VSS) resistor r=5.1667 c=0
Ry28 (\3\:VSS \11\:VSS) resistor r=5.1667 c=0
Ry37 (\24\:VSS \25\:VSS) resistor r=10.3333 c=0
Ry38 (\24\:VSS \28\:VSS) resistor r=5.1667 c=0
Ry39 (\24\:VSS \29\:VSS) resistor r=5.1667 c=0
Ry29 (\1\:VDD \2\:VDD) resistor r=20.6667 c=0
Ry30 (\12\:VDD \13\:VDD) resistor r=62 c=0
Ry31 (\14\:VDD \15\:VDD) resistor r=62 c=0
Ry32 (\16\:VDD \17\:VDD) resistor r=20.6667 c=0
Ry33 (\18\:VDD \19\:VDD) resistor r=62 c=0
Ry34 (\20\:VDD \21\:VDD) resistor r=62 c=0
Ry35 (\23\:VDD \24\:VDD) resistor r=62 c=0
Ry36 (\25\:VDD \26\:VDD) resistor r=62 c=0
Ry14 (\1\:ExtVDD \2\:ExtVDD) resistor r=62 c=0
Ry15 (\1\:ExtVDD \5\:ExtVDD) resistor r=62 c=0
Ry16 (\1\:ExtVDD \6\:ExtVDD) resistor r=62 c=0
Ry1 (\10\:n20 \11\:n20) resistor r=62 c=0
Ry2 (\13\:n20 \14\:n20) resistor r=62 c=0
Ry3 (\17\:CKbb \18\:CKbb) resistor r=62 c=0
Ry7 (\5\:mout \6\:mout) resistor r=62 c=0
Ry8 (\16\:mout \17\:mout) resistor r=62 c=0
Ry9 (\19\:mout \20\:mout) resistor r=62 c=0
Ry4 (\17\:CKb \18\:CKb) resistor r=62 c=0
Ry10 (\8\:SEb \9\:SEb) resistor r=62 c=0
Ry12 (\6\:n35g \7\:n35g) resistor r=62 c=0
Ry18 (\15\:n35g \16\:n35g) resistor r=62 c=0
Ry17 (\17\:qbint \18\:qbint) resistor r=62 c=0
Ry19 (\6\:RTb \7\:RTb) resistor r=62 c=0
Ry22 (\9\:net573 \10\:net573) resistor r=62 c=0
Ry11 (\4\:n35 \5\:n35) resistor r=62 c=0
Ry13 (\9\:n35 \10\:n35) resistor r=62 c=0
Ry21 (\14\:n35 \15\:n35) resistor r=62 c=0
Ry5 (\3\:Db \4\:Db) resistor r=62 c=0
Ry6 (\5\:Db \6\:Db) resistor r=62 c=0
Ry23 (n11 \2\:n11) resistor r=62 c=0
Ry24 (\3\:n11 \4\:n11) resistor r=62 c=0
Rx11 (\3\:D D) resistor r=45 c=0
Rx28 (\7\:RT RT) resistor r=45 c=0
Rx29 (\3\:RT \10\:RT) resistor r=45 c=0
Rx30 (\1\:RT \11\:RT) resistor r=45 c=0
Rx16 (\2\:SI SI) resistor r=45 c=0
Rx7 (\3\:CK CK) resistor r=45 c=0
Rx9 (\5\:SN \10\:SN) resistor r=45 c=0
Rx10 (\2\:SN \11\:SN) resistor r=45 c=0
Rx31 (\3\:SN \12\:SN) resistor r=45 c=0
Rx32 (\9\:SN \13\:SN) resistor r=45 c=0
Rx17 (\1\:SE SE) resistor r=45 c=0
Rx1 (n20 \12\:n20) resistor r=45 c=0
Rx4 (\2\:n20 \15\:n20) resistor r=45 c=0
Rx5 (\5\:n20 \16\:n20) resistor r=45 c=0
Rx12 (\7\:n20 \19\:n20) resistor r=45 c=0
Rx13 (\4\:n20 \20\:n20) resistor r=45 c=0
Rx2 (\4\:CKbb \13\:CKbb) resistor r=45 c=0
Rx3 (\8\:CKbb \14\:CKbb) resistor r=45 c=0
Rx6 (CKbb \19\:CKbb) resistor r=45 c=0
Rx33 (\12\:CKbb \20\:CKbb) resistor r=45 c=0
Rx34 (\9\:CKbb \21\:CKbb) resistor r=45 c=0
Rx14 (\4\:mout \10\:mout) resistor r=45 c=0
Rx15 (\2\:mout \18\:mout) resistor r=45 c=0
Rx8 (\10\:CKb \16\:CKb) resistor r=45 c=0
Rx20 (CKb \19\:CKb) resistor r=45 c=0
Rx21 (\12\:CKb \20\:CKb) resistor r=45 c=0
Rx18 (\2\:SEb \7\:SEb) resistor r=45 c=0
Rx22 (\4\:n35g \8\:n35g) resistor r=45 c=0
Rx25 (n35g \14\:n35g) resistor r=45 c=0
Rx24 (\3\:qbint \15\:qbint) resistor r=45 c=0
Rx35 (\10\:qbint \21\:qbint) resistor r=45 c=0
Rx36 (qbint \22\:qbint) resistor r=45 c=0
Rx26 (\3\:RTb \5\:RTb) resistor r=45 c=0
Rx27 (RTb \9\:RTb) resistor r=45 c=0
Rx38 (net573 \8\:net573) resistor r=45 c=0
Rx19 (\3\:n35 \6\:n35) resistor r=45 c=0
Rx23 (\2\:n35 \11\:n35) resistor r=45 c=0
Rx37 (n35 \16\:n35) resistor r=45 c=0
mn30 (net0119 \6\:SN \30\:VSS VSS) g45n1svt w=(1.45e-07) l=4.5e-08 nf=1 \
        as=8.7e-15 ad=6.307e-14 ps=4.1e-07 pd=1.16e-06 nrd=1.16667 \
        nrs=1.16667 sa=7.25e-07 sb=2.45e-07 sd=160n sca=8.42104 \
        scb=0.00632542 scc=0.000106623 m=(1)
mn12 (Db \3\:SEb n0 VSS) g45n1svt w=(1.45e-07) l=4.5e-08 nf=1 as=2.32e-14 \
        ad=8.7e-15 ps=6.1e-07 pd=4.1e-07 nrd=1.16667 nrs=1.16667 \
        sa=2.45e-07 sb=6.55e-07 sd=160n sca=8.85152 scb=0.00706865 \
        scc=0.000138481 m=(1)
mn14 (Db \6\:SE n2 VSS) g45n1svt w=(1.45e-07) l=4.5e-08 nf=1 as=8.7e-15 \
        ad=2.32e-14 ps=4.1e-07 pd=6.1e-07 nrd=1.16667 nrs=1.16667 \
        sa=4.5e-07 sb=4.5e-07 sd=160n sca=8.85152 scb=0.00706865 \
        scc=0.000138481 m=(1)
mn56 (\5\:net573 \14\:qbint \14\:VSS VSS) g45n1svt w=(1.45e-07) \
        l=4.5e-08 nf=1 as=2.03e-14 ad=4.365e-14 ps=5.7e-07 pd=9e-07 \
        nrd=1.16667 nrs=1.16667 sa=3.75e-07 sb=1.4e-07 sd=160n sca=9.33388 \
        scb=0.00788941 scc=0.00017958 m=(1)
mn20 (\13\:CKb \1\:CK \12\:VSS VSS) g45n1svt w=(1.45e-07) l=4.5e-08 nf=1 \
        as=2.03e-14 ad=2.32e-14 ps=5.7e-07 pd=6.1e-07 nrd=1.16667 \
        nrs=1.16667 sa=3.45e-07 sb=1.4e-07 sd=160n sca=8.0352 \
        scb=0.00565402 scc=8.19771e-05 m=(1)
mn21 (\15\:CKbb \9\:CKb \12\:VSS VSS) g45n1svt w=(1.45e-07) l=4.5e-08 \
        nf=1 as=2.32e-14 ad=2.03e-14 ps=6.1e-07 pd=5.7e-07 nrd=1.16667 \
        nrs=1.16667 sa=1.4e-07 sb=3.45e-07 sd=160n sca=8.0352 \
        scb=0.00565402 scc=8.19771e-05 m=(1)
mn13 (n2 \1\:SI \20\:VSS VSS) g45n1svt w=(1.45e-07) l=4.5e-08 nf=1 \
        as=2.32e-14 ad=8.7e-15 ps=6.1e-07 pd=4.1e-07 nrd=1.16667 \
        nrs=1.16667 sa=5.55e-07 sb=3.45e-07 sd=160n sca=8.85152 \
        scb=0.00706865 scc=0.000138481 m=(1)
mn52 (net0118 \12\:qbint net0116 VSS) g45n1svt w=(1.45e-07) l=4.5e-08 \
        nf=1 as=8.7e-15 ad=8.7e-15 ps=4.1e-07 pd=4.1e-07 nrd=1.16667 \
        nrs=1.16667 sa=2.45e-07 sb=2.45e-07 sd=160n sca=8.42104 \
        scb=0.00632542 scc=0.000106623 m=(1)
mn10 (\4\:SEb \5\:SE \20\:VSS VSS) g45n1svt w=(1.45e-07) l=4.5e-08 nf=1 \
        as=2.32e-14 ad=2.03e-14 ps=6.1e-07 pd=5.7e-07 nrd=1.16667 \
        nrs=1.16667 sa=7.6e-07 sb=1.4e-07 sd=160n sca=8.85152 \
        scb=0.00706865 scc=0.000138481 m=(1)
mn25 (\7\:Db \6\:CKb \8\:n20 VSS) g45n1svt w=(1.45e-07) l=4.5e-08 nf=1 \
        as=2.03e-14 ad=2.03e-14 ps=5.7e-07 pd=5.7e-07 nrd=1.16667 \
        nrs=1.16667 sa=1.4e-07 sb=1.4e-07 sd=160n sca=8.0352 \
        scb=0.00565402 scc=8.19771e-05 m=(1)
mn36 (\17\:n20 \10\:CKbb n6 VSS) g45n1svt w=(1.45e-07) l=4.5e-08 nf=1 \
        as=8.7e-15 ad=2.03e-14 ps=4.1e-07 pd=5.7e-07 nrd=1.16667 \
        nrs=1.16667 sa=1.4e-07 sb=8.3e-07 sd=160n sca=8.42104 \
        scb=0.00632542 scc=0.000106623 m=(1)
mn35 (n6 \3\:mout \30\:VSS VSS) g45n1svt w=(1.45e-07) l=4.5e-08 nf=1 \
        as=6.307e-14 ad=8.7e-15 ps=1.16e-06 pd=4.1e-07 nrd=1.16667 \
        nrs=1.16667 sa=2.45e-07 sb=7.25e-07 sd=160n sca=8.42104 \
        scb=0.00632542 scc=0.000106623 m=(1)
mn32 (\13\:mout \6\:n20 net0119 VSS) g45n1svt w=(1.45e-07) l=4.5e-08 nf=1 \
        as=8.7e-15 ad=2.03e-14 ps=4.1e-07 pd=5.7e-07 nrd=1.16667 \
        nrs=1.16667 sa=8.3e-07 sb=1.4e-07 sd=160n sca=8.42104 \
        scb=0.00632542 scc=0.000106623 m=(1)
mn11 (n0 \1\:D \22\:VSS VSS) g45n1svt w=(1.45e-07) l=4.5e-08 nf=1 \
        as=2.03e-14 ad=8.7e-15 ps=5.7e-07 pd=4.1e-07 nrd=1.16667 \
        nrs=1.16667 sa=1.4e-07 sb=7.6e-07 sd=160n sca=8.85152 \
        scb=0.00706865 scc=0.000138481 m=(1)
mn40 (\7\:n35 \5\:CKbb \11\:mout VSS) g45n1svt w=(1.45e-07) l=4.5e-08 \
        nf=1 as=2.03e-14 ad=2.03e-14 ps=5.7e-07 pd=5.7e-07 nrd=1.16667 \
        nrs=1.16667 sa=1.4e-07 sb=1.4e-07 sd=160n sca=8.42104 \
        scb=0.00632542 scc=0.000106623 m=(1)
NM0 (\9\:n35g \2\:RTb \12\:n35 VSS) g45n1svt w=(1.45e-07) l=4.5e-08 nf=1 \
        as=2.03e-14 ad=2.03e-14 ps=5.7e-07 pd=5.7e-07 nrd=1.16667 \
        nrs=1.16667 sa=1.4e-07 sb=1.4e-07 sd=160n sca=8.42104 \
        scb=0.00632542 scc=0.000106623 m=(1)
mn45 (\19\:qbint \5\:n35g \18\:VSS VSS) g45n1svt w=(1.45e-07) l=4.5e-08 \
        nf=1 as=2.03e-14 ad=2.03e-14 ps=5.7e-07 pd=5.7e-07 nrd=1.16667 \
        nrs=1.16667 sa=1.4e-07 sb=1.4e-07 sd=160n sca=9.33388 \
        scb=0.00788941 scc=0.00017958 m=(1)
NM3 (net0134 \5\:qbint \16\:VSS VSS) g45n1svt w=(1.45e-07) l=4.5e-08 \
        nf=1 as=2.03e-14 ad=8.7e-15 ps=5.7e-07 pd=4.1e-07 nrd=1.16667 \
        nrs=1.16667 sa=1.4e-07 sb=2.45e-07 sd=160n sca=9.33388 \
        scb=0.00788941 scc=0.00017958 m=(1)
NM1 (\10\:RTb \2\:RT \34\:VSS VSS) g45n1svt w=(1.45e-07) l=4.5e-08 nf=1 \
        as=2.03e-14 ad=2.03e-14 ps=5.7e-07 pd=5.7e-07 nrd=1.16667 \
        nrs=1.16667 sa=1.4e-07 sb=1.4e-07 sd=160n sca=8.42104 \
        scb=0.00632542 scc=0.000106623 m=(1)
NM2 (\11\:n35g \8\:RT net0134 VSS) g45n1svt w=(1.45e-07) l=4.5e-08 nf=1 \
        as=8.7e-15 ad=2.03e-14 ps=4.1e-07 pd=5.7e-07 nrd=1.16667 \
        nrs=1.16667 sa=2.45e-07 sb=1.4e-07 sd=160n sca=9.33388 \
        scb=0.00788941 scc=0.00017958 m=(1)
mn53 (\17\:n35 \11\:CKb net0118 VSS) g45n1svt w=(1.45e-07) l=4.5e-08 nf=1 \
        as=8.7e-15 ad=2.03e-14 ps=4.1e-07 pd=5.7e-07 nrd=1.16667 \
        nrs=1.16667 sa=1.4e-07 sb=3.5e-07 sd=160n sca=8.42104 \
        scb=0.00632542 scc=0.000106623 m=(1)
mn50 (net0116 \8\:SN \32\:VSS VSS) g45n1svt w=(1.45e-07) l=4.5e-08 nf=1 \
        as=2.03e-14 ad=8.7e-15 ps=5.7e-07 pd=4.1e-07 nrd=1.16667 \
        nrs=1.16667 sa=3.5e-07 sb=1.4e-07 sd=160n sca=8.42104 \
        scb=0.00632542 scc=0.000106623 m=(1)
mn57 (\1\:QN \4\:net573 \14\:VSS VSS) g45n1svt w=(2.6e-07) l=4.5e-08 \
        nf=1 as=4.365e-14 ad=3.64e-14 ps=9e-07 pd=8e-07 nrd=1.16667 \
        nrs=1.16667 sa=1.4e-07 sb=2.71058e-07 sd=160n sca=9.69565 \
        scb=0.00844644 scc=0.000275168 m=(1)
mn55 (\1\:Q \6\:qbint \1\:VSS VSS) g45n1svt w=(2.6e-07) l=4.5e-08 nf=1 \
        as=3.64e-14 ad=3.64e-14 ps=8e-07 pd=8e-07 nrd=1.16667 nrs=1.16667 \
        sa=1.4e-07 sb=1.4e-07 sd=160n sca=9.50447 scb=0.0081528 \
        scc=0.00025289 m=(1)
mp57 (\4\:QN \3\:net573 \16\:VDD VDD) g45p1svt w=(3.9e-07) l=4.5e-08 \
        nf=1 as=5.46e-14 ad=6.535e-14 ps=1.06e-06 pd=1.16e-06 nrd=1.16667 \
        nrs=1.16667 sa=1.4e-07 sb=2.69551e-07 sd=160n sca=38.4244 \
        scb=0.0401517 scc=0.00462137 m=(1)
mp55 (\3\:Q \7\:qbint \1\:VDD VDD) g45p1svt w=(3.9e-07) l=4.5e-08 nf=1 \
        as=5.46e-14 ad=5.46e-14 ps=1.06e-06 pd=1.06e-06 nrd=1.16667 \
        nrs=1.16667 sa=1.4e-07 sb=1.4e-07 sd=160n sca=20.1111 \
        scb=0.0190466 scc=0.00152507 m=(1)
ends SRDFFSX1
// End of subcircuit definition.
