// Generated for: spectre (May  1 08:14:30 2013 )
// Library name: gsclib045
// Cell name: SMDFFHQX4
// View name: extracted

simulator lang=spectre

subckt SMDFFHQX4 CK D0 D1 Q S0 SE SI VDD VSS
mp20 (\15\:CKb \3\:CK \9\:VDD VDD) g45p1svt w=(2.15e-07) l=4.5e-08 nf=1 \
        as=8.72e-14 ad=3.01e-14 ps=1.92e-06 pd=7.1e-07 nrd=1.16667 \
        nrs=1.16667 sa=1.4e-07 sb=2e-06 sd=160n sca=34.5903 scb=0.0376512 \
        scc=0.00347075 m=(1)
mp21 (\8\:CKbb \10\:CKb \16\:VDD VDD) g45p1svt w=(2.15e-07) l=4.5e-08 \
        nf=1 as=6.05e-14 ad=2.95e-14 ps=1.18e-06 pd=7.1e-07 nrd=1.16667 \
        nrs=1.16667 sa=1.37209e-07 sb=8.1e-07 sd=160n sca=10.718 \
        scb=0.00841932 scc=0.00013813 m=(1)
mp10 (\5\:SEb \1\:SE \14\:VDD VDD) g45p1svt w=(2.15e-07) l=4.5e-08 nf=1 \
        as=6.535e-14 ad=3.01e-14 ps=1.16e-06 pd=7.1e-07 nrd=1.16667 \
        nrs=1.16667 sa=1.4e-07 sb=1.325e-06 sd=160n sca=12.1244 \
        scb=0.0107968 scc=0.000332109 m=(1)
mp0 (\6\:S0b \7\:S0 \1\:VDD VDD) g45p1svt w=(2.15e-07) l=4.5e-08 nf=1 \
        as=9.868e-14 ad=3.01e-14 ps=1.47e-06 pd=7.1e-07 nrd=1.16667 \
        nrs=1.16667 sa=1.325e-06 sb=1.4e-07 sd=160n sca=14.7678 \
        scb=0.0134734 scc=0.000346306 m=(1)
C1 (D0 VSS) capacitor c=8.4305e-17
C2 (S0 VSS) capacitor c=3.98419e-17
C3 (VDD VSS) capacitor c=3.93868e-16
C4 (SE VSS) capacitor c=2.83917e-17
C5 (D1 VSS) capacitor c=5.07083e-17
C6 (Q VSS) capacitor c=4.12922e-17
C7 (SI VSS) capacitor c=3.90095e-17
C8 (CKb VSS) capacitor c=4.71953e-17
C9 (qbint VSS) capacitor c=2.69316e-16
C10 (n30 VSS) capacitor c=9.66857e-17
C11 (net482 VSS) capacitor c=3.02224e-18
C12 (mout VSS) capacitor c=6.02531e-17
C13 (CKbb VSS) capacitor c=1.84214e-17
C14 (n20 VSS) capacitor c=3.83656e-17
C15 (net474 VSS) capacitor c=5.97186e-19
C16 (dbp VSS) capacitor c=8.57815e-17
C17 (db VSS) capacitor c=1.01157e-16
C18 (SEb VSS) capacitor c=5.70484e-17
C19 (net498 VSS) capacitor c=1.87259e-18
C20 (S0b VSS) capacitor c=4.61717e-17
C21 (net409 VSS) capacitor c=6.03734e-18
C22 (net393 VSS) capacitor c=4.05178e-18
C23 (net417 VSS) capacitor c=1.8729e-18
C24 (net425 VSS) capacitor c=2.9009e-18
C25 (net429 VSS) capacitor c=3.79054e-18
C26 (\7\:S0 VSS) capacitor c=4.11388e-17
C27 (\3\:D1 VSS) capacitor c=6.68921e-17
C28 (\2\:S0 VSS) capacitor c=5.83927e-17
C29 (\4\:D0 VSS) capacitor c=9.03014e-17
C30 (\1\:SE VSS) capacitor c=3.60126e-17
C31 (\6\:SE VSS) capacitor c=4.08294e-17
C32 (\2\:SEb VSS) capacitor c=7.09121e-17
C33 (\4\:SI VSS) capacitor c=8.20385e-17
C34 (\10\:CKb VSS) capacitor c=5.15616e-17
C35 (\6\:CKbb VSS) capacitor c=3.86058e-17
C36 (\8\:CKb VSS) capacitor c=3.5583e-17
C37 (\3\:CKb VSS) capacitor c=2.77591e-17
C38 (\3\:CKbb VSS) capacitor c=8.75919e-17
C39 (\15\:qbint VSS) capacitor c=7.68134e-17
C40 (\3\:CK VSS) capacitor c=3.28008e-17
C41 (\5\:S0 VSS) capacitor c=2.76145e-17
C42 (\1\:D1 VSS) capacitor c=7.70469e-17
C43 (\3\:S0 VSS) capacitor c=6.59156e-17
C44 (\3\:S0b VSS) capacitor c=1.05779e-16
C45 (\1\:D0 VSS) capacitor c=7.68348e-17
C46 (\5\:SE VSS) capacitor c=3.57394e-17
C47 (\3\:SEb VSS) capacitor c=3.98139e-17
C48 (\4\:SE VSS) capacitor c=6.60349e-17
C49 (\1\:SI VSS) capacitor c=5.20067e-17
C50 (\5\:CKb VSS) capacitor c=3.43903e-17
C51 (\11\:CKb VSS) capacitor c=2.39276e-17
C52 (\4\:CKbb VSS) capacitor c=5.99885e-17
C53 (\3\:mout VSS) capacitor c=5.74149e-17
C54 (\3\:n20 VSS) capacitor c=4.14012e-17
C55 (\17\:qbint VSS) capacitor c=4.53897e-17
C56 (\1\:CK VSS) capacitor c=3.25114e-17
C57 (\6\:S0 VSS) capacitor c=3.96509e-17
C58 (\2\:D1 VSS) capacitor c=6.90765e-17
C59 (\4\:S0 VSS) capacitor c=5.58939e-17
C60 (\2\:S0b VSS) capacitor c=6.755e-17
C61 (\1\:S0 VSS) capacitor c=5.137e-17
C62 (\3\:D0 VSS) capacitor c=2.23536e-17
C63 (\2\:SE VSS) capacitor c=6.25496e-17
C64 (\4\:SEb VSS) capacitor c=4.04017e-17
C65 (\3\:SI VSS) capacitor c=2.94381e-17
C66 (\7\:CKbb VSS) capacitor c=4.29432e-17
C67 (\9\:CKb VSS) capacitor c=2.54076e-17
C68 (\5\:CKbb VSS) capacitor c=3.83846e-17
C69 (\2\:mout VSS) capacitor c=4.63691e-17
C70 (\2\:n20 VSS) capacitor c=3.16935e-17
C71 (\2\:CKbb VSS) capacitor c=3.90012e-17
C72 (\4\:CKb VSS) capacitor c=4.14337e-17
C73 (\2\:CKb VSS) capacitor c=4.55208e-17
C74 (\16\:qbint VSS) capacitor c=6.12636e-17
C75 (\8\:n30 VSS) capacitor c=1.73809e-17
C76 (\2\:CK VSS) capacitor c=3.01836e-17
C77 (\6\:S0b VSS) capacitor c=1.00549e-16
C78 (\1\:VDD VSS) capacitor c=3.4972e-17
C79 (\7\:db VSS) capacitor c=7.05163e-17
C80 (\14\:VDD VSS) capacitor c=5.12389e-17
C81 (\5\:SEb VSS) capacitor c=1.14309e-16
C82 (\5\:db VSS) capacitor c=4.10848e-17
C83 (\4\:dbp VSS) capacitor c=7.3246e-17
C84 (\16\:VDD VSS) capacitor c=3.53654e-17
C85 (\8\:CKbb VSS) capacitor c=7.82384e-17
C86 (\6\:dbp VSS) capacitor c=1.04023e-16
C87 (\4\:n20 VSS) capacitor c=5.50849e-17
C88 (\18\:VDD VSS) capacitor c=3.4417e-17
C89 (\4\:mout VSS) capacitor c=6.45284e-17
C90 (\12\:n30 VSS) capacitor c=9.9605e-17
C91 (\23\:qbint VSS) capacitor c=5.04574e-17
C92 (\1\:Q VSS) capacitor c=1.66415e-16
C93 (\15\:CKb VSS) capacitor c=1.63142e-16
C94 (\3\:VDD VSS) capacitor c=8.31076e-17
C95 (\4\:S0b VSS) capacitor c=5.63507e-17
C96 (\10\:SEb VSS) capacitor c=7.75788e-17
C97 (\9\:db VSS) capacitor c=7.33422e-17
C98 (\14\:CKbb VSS) capacitor c=5.18258e-17
C99 (\8\:dbp VSS) capacitor c=6.78784e-17
C100 (\8\:n20 VSS) capacitor c=6.88192e-17
C101 (\7\:mout VSS) capacitor c=4.71059e-17
C102 (\9\:n30 VSS) capacitor c=8.21486e-17
C103 (\21\:qbint VSS) capacitor c=4.63875e-17
C104 (\17\:CKb VSS) capacitor c=5.37404e-17
C105 (\3\:n30 VSS) capacitor c=8.27576e-17
C106 (\6\:CKb VSS) capacitor c=6.27173e-17
C107 (\7\:CKb VSS) capacitor c=6.50411e-17
C108 (\2\:SI VSS) capacitor c=3.52505e-17
C109 (\3\:SE VSS) capacitor c=6.88315e-17
C110 (\4\:CK VSS) capacitor c=1.15782e-16
C111 (\2\:D0 VSS) capacitor c=3.33971e-17
C112 (\18\:qbint VSS) capacitor c=6.70777e-17
C113 (\19\:qbint VSS) capacitor c=4.70226e-17
C114 (\20\:qbint VSS) capacitor c=3.24242e-17
C115 (\11\:n30 VSS) capacitor c=9.25318e-17
C116 (\6\:mout VSS) capacitor c=5.04064e-17
C117 (\9\:mout VSS) capacitor c=5.40428e-17
C118 (\12\:CKb VSS) capacitor c=5.53756e-17
C119 (\13\:CKb VSS) capacitor c=1.00864e-16
C120 (\14\:CKb VSS) capacitor c=2.12188e-16
C121 (\19\:CKb VSS) capacitor c=9.23072e-17
C122 (\20\:CKb VSS) capacitor c=8.14951e-17
C123 (\6\:n20 VSS) capacitor c=7.03398e-17
C124 (\7\:n20 VSS) capacitor c=7.94573e-17
C125 (\10\:CKbb VSS) capacitor c=1.18052e-16
C126 (\11\:CKbb VSS) capacitor c=7.28359e-17
C127 (\12\:CKbb VSS) capacitor c=1.00444e-16
C128 (\13\:CKbb VSS) capacitor c=1.04237e-16
C129 (\16\:CKbb VSS) capacitor c=6.03866e-17
C130 (\5\:SI VSS) capacitor c=7.68359e-17
C131 (\3\:dbp VSS) capacitor c=8.96947e-17
C132 (\7\:SEb VSS) capacitor c=7.98565e-17
C133 (\8\:SEb VSS) capacitor c=3.84398e-17
C134 (\9\:SEb VSS) capacitor c=8.52978e-17
C135 (\7\:SE VSS) capacitor c=8.30422e-17
C136 (\5\:D0 VSS) capacitor c=6.3367e-17
C137 (\3\:db VSS) capacitor c=1.49195e-16
C138 (\4\:db VSS) capacitor c=8.27359e-17
C139 (\4\:D1 VSS) capacitor c=7.51233e-17
C140 (\8\:S0 VSS) capacitor c=7.86524e-17
C141 (\9\:S0 VSS) capacitor c=6.05573e-17
C142 (\10\:S0 VSS) capacitor c=2.79591e-17
C143 (\8\:S0b VSS) capacitor c=9.40556e-17
C144 (\5\:VDD VSS) capacitor c=3.64467e-17
C145 (\6\:VDD VSS) capacitor c=3.20666e-17
C146 (\8\:VDD VSS) capacitor c=3.10702e-17
C147 (\9\:VDD VSS) capacitor c=1.75042e-16
Rk46 (\5\:D0 D0) resistor r=0.02098 c=0
Rk1 (\4\:CK CK) resistor r=0.002997 c=0
Rk54 (\9\:S0 S0) resistor r=0.2875 c=0
Rk53 (\8\:S0 \9\:S0) resistor r=0.3841 c=0
Rk55 (S0 \10\:S0) resistor r=0.03339 c=0
Rk58 (\2\:VSS \4\:VSS) resistor r=0.4302 c=0
Rk59 (\4\:VSS \5\:VSS) resistor r=0.2655 c=0
Rk60 (\5\:VSS \6\:VSS) resistor r=0.5786 c=0
Rk61 (\6\:VSS \7\:VSS) resistor r=0.258 c=0
Rk62 (\7\:VSS \8\:VSS) resistor r=0.3523 c=0
Rk71 (\9\:VSS VSS) resistor r=0.1123 c=0
Rk63 (\8\:VSS \9\:VSS) resistor r=0.6554 c=0
Rk65 (\5\:VSS \12\:VSS) resistor r=0.1804 c=0
Rk66 (\6\:VSS \14\:VSS) resistor r=0.2695 c=0
Rk67 (\8\:VSS \16\:VSS) resistor r=0.04328 c=0
Rk75 (\2\:VDD \4\:VDD) resistor r=0.2979 c=0
Rk76 (\4\:VDD \5\:VDD) resistor r=0.2605 c=0
Rk77 (\5\:VDD \6\:VDD) resistor r=0.6187 c=0
Rk78 (\6\:VDD \7\:VDD) resistor r=0.2229 c=0
Rk79 (\7\:VDD \8\:VDD) resistor r=0.3683 c=0
Rk85 (\9\:VDD VDD) resistor r=0.1324 c=0
Rk80 (\8\:VDD \9\:VDD) resistor r=0.5611 c=0
Rk86 (\5\:VDD \15\:VDD) resistor r=0.2216 c=0
Rk87 (\6\:VDD \17\:VDD) resistor r=0.2532 c=0
Rk88 (\8\:VDD \19\:VDD) resistor r=0.202 c=0
Rk43 (\7\:SE SE) resistor r=0.005993 c=0
Rk52 (D1 \4\:D1) resistor r=0.05461 c=0
Rk6 (\1\:Q Q) resistor r=0.02432 c=0
Rk31 (SI \5\:SI) resistor r=0.07572 c=0
Rk16 (\12\:CKb \13\:CKb) resistor r=0.3022 c=0
Rk17 (\13\:CKb \14\:CKb) resistor r=0.3617 c=0
Rk18 (\14\:CKb \16\:CKb) resistor r=1.3338 c=0
Rk19 (\16\:CKb \18\:CKb) resistor r=0.37 c=0
Rk20 (\13\:CKb \19\:CKb) resistor r=0.6893 c=0
Rk21 (\14\:CKb \20\:CKb) resistor r=0.3534 c=0
Rk7 (\18\:qbint \19\:qbint) resistor r=0.3865 c=0
Rk8 (\19\:qbint \20\:qbint) resistor r=0.1927 c=0
Rk9 (\19\:qbint \22\:qbint) resistor r=0.2468 c=0
Rk10 (\19\:qbint \24\:qbint) resistor r=0.2692 c=0
Rk11 (\10\:n30 \11\:n30) resistor r=0.4714 c=0
Rk12 (\10\:n30 \13\:n30) resistor r=0.4786 c=0
Rk13 (\5\:mout \6\:mout) resistor r=0.2474 c=0
Rk14 (\6\:mout \8\:mout) resistor r=0.1649 c=0
Rk15 (\6\:mout \9\:mout) resistor r=0.2462 c=0
Rk25 (\9\:CKbb \10\:CKbb) resistor r=0.5271 c=0
Rk26 (\10\:CKbb \11\:CKbb) resistor r=0.3528 c=0
Rk27 (\11\:CKbb \12\:CKbb) resistor r=0.2851 c=0
Rk28 (\12\:CKbb \13\:CKbb) resistor r=0.846 c=0
Rk29 (\11\:CKbb \15\:CKbb) resistor r=0.2718 c=0
Rk30 (\12\:CKbb \16\:CKbb) resistor r=0.2303 c=0
Rk22 (\5\:n20 \6\:n20) resistor r=0.149 c=0
Rk23 (\6\:n20 \7\:n20) resistor r=0.3933 c=0
Rk24 (\6\:n20 \9\:n20) resistor r=0.303 c=0
Rk32 (\2\:dbp \3\:dbp) resistor r=0.5263 c=0
Rk33 (\3\:dbp \5\:dbp) resistor r=0.1258 c=0
Rk34 (\3\:dbp \7\:dbp) resistor r=0.4271 c=0
Rk35 (\7\:dbp \9\:dbp) resistor r=0.3601 c=0
Rk36 (\5\:dbp \10\:dbp) resistor r=0.1627 c=0
Rk47 (\2\:db \3\:db) resistor r=0.7325 c=0
Rk48 (\3\:db \4\:db) resistor r=0.4829 c=0
Rk49 (\4\:db \6\:db) resistor r=0.07934 c=0
Rk50 (\3\:db \8\:db) resistor r=0.2634 c=0
Rk51 (\4\:db \10\:db) resistor r=0.356 c=0
Rk37 (\6\:SEb \7\:SEb) resistor r=0.6934 c=0
Rk38 (\7\:SEb \8\:SEb) resistor r=0.12 c=0
Rk39 (\7\:SEb \9\:SEb) resistor r=0.1527 c=0
Rk40 (\9\:SEb \11\:SEb) resistor r=0.5886 c=0
Rk56 (\5\:S0b \7\:S0b) resistor r=0.6043 c=0
Rk57 (\7\:S0b \8\:S0b) resistor r=0.6029 c=0
Rl53 (\2\:D0 \4\:D0) resistor r=159.077 c=0
Rl51 (\1\:D0 \2\:D0) resistor r=126.433 c=0
Rl52 (\2\:D0 \3\:D0) resistor r=6.4284 c=0
Rl2 (\2\:CK \3\:CK) resistor r=34.9443 c=0
Rl1 (\1\:CK \2\:CK) resistor r=62.9757 c=0
Rl61 (\6\:S0 \7\:S0) resistor r=135.714 c=0
Rl60 (\5\:S0 \6\:S0) resistor r=69.2308 c=0
Rl57 (\3\:S0 \4\:S0) resistor r=55.0021 c=0
Rl54 (\1\:S0 \2\:S0) resistor r=59.5926 c=0
Rl46 (\1\:SE \2\:SE) resistor r=80.0021 c=0
Rl49 (\2\:SE \5\:SE) resistor r=164.617 c=0
Rl50 (\3\:SE \6\:SE) resistor r=35.772 c=0
Rl48 (\3\:SE \4\:SE) resistor r=127.645 c=0
Rl47 (\2\:SE \3\:SE) resistor r=199.477 c=0
Rl59 (\2\:D1 \3\:D1) resistor r=111.516 c=0
Rl58 (\1\:D1 \2\:D1) resistor r=113.257 c=0
Rl43 (\2\:SI \4\:SI) resistor r=41.1873 c=0
Rl41 (\1\:SI \2\:SI) resistor r=85.265 c=0
Rl42 (\2\:SI \3\:SI) resistor r=8.3025 c=0
Rl38 (\8\:CKb \9\:CKb) resistor r=24.2328 c=0
Rl26 (\3\:CKb \4\:CKb) resistor r=31.6893 c=0
Rl25 (CKb \2\:CKb) resistor r=33.3841 c=0
Rl39 (\6\:CKb \10\:CKb) resistor r=165.066 c=0
Rl35 (\5\:CKb \6\:CKb) resistor r=88.4394 c=0
Rl37 (\7\:CKb \8\:CKb) resistor r=139.928 c=0
Rl40 (\7\:CKb \11\:CKb) resistor r=30.4507 c=0
Rl36 (\6\:CKb \7\:CKb) resistor r=192.698 c=0
Rl23 (\16\:qbint \15\:qbint) resistor r=123.334 c=0
Rl24 (\16\:qbint \17\:qbint) resistor r=33.3841 c=0
Rl17 (\3\:n30 n30) resistor r=44.9718 c=0
Rl22 (\3\:n30 \8\:n30) resistor r=4.6885 c=0
Rl31 (mout \2\:mout) resistor r=79.9442 c=0
Rl32 (\2\:mout \3\:mout) resistor r=26.098 c=0
Rl34 (\6\:CKbb \7\:CKbb) resistor r=33.3841 c=0
Rl33 (\4\:CKbb \5\:CKbb) resistor r=33.3841 c=0
Rl28 (\2\:CKbb \3\:CKbb) resistor r=191.862 c=0
Rl27 (CKbb \2\:CKbb) resistor r=24.2328 c=0
Rl29 (n20 \2\:n20) resistor r=29.5379 c=0
Rl30 (\2\:n20 \3\:n20) resistor r=83.3841 c=0
Rl45 (\3\:SEb \4\:SEb) resistor r=29.5379 c=0
Rl44 (SEb \2\:SEb) resistor r=39.4 c=0
Rl55 (S0b \2\:S0b) resistor r=24.2328 c=0
Rl56 (\2\:S0b \3\:S0b) resistor r=179.675 c=0
Rz15 (\2\:VSS \1\:VSS) resistor r=75 c=0
Rz16 (\12\:VSS \11\:VSS) resistor r=75 c=0
Rz17 (\14\:VSS \13\:VSS) resistor r=75 c=0
Rz18 (\16\:VSS \15\:VSS) resistor r=75 c=0
Rz23 (\4\:VDD \3\:VDD) resistor r=7.5 c=0
Rz24 (\7\:VDD \3\:VDD) resistor r=6.25 c=0
Rz25 (\9\:VDD \3\:VDD) resistor r=6.25 c=0
Rz6 (\17\:CKb \18\:CKb) resistor r=75 c=0
Rz3 (\22\:qbint \21\:qbint) resistor r=75 c=0
Rz4 (\10\:n30 \9\:n30) resistor r=75 c=0
Rz5 (\7\:mout \8\:mout) resistor r=75 c=0
Rz8 (\14\:CKbb \15\:CKbb) resistor r=75 c=0
Rz7 (\8\:n20 \9\:n20) resistor r=75 c=0
Rz9 (dbp \2\:dbp) resistor r=75 c=0
Rz10 (\8\:dbp \9\:dbp) resistor r=75 c=0
Rz12 (db \2\:db) resistor r=75 c=0
Rz13 (\9\:db \10\:db) resistor r=75 c=0
Rz11 (\10\:SEb \11\:SEb) resistor r=75 c=0
Rz14 (\4\:S0b \5\:S0b) resistor r=75 c=0
Ry16 (\4\:VSS \3\:VSS) resistor r=6.2 c=0
Ry17 (\7\:VSS \3\:VSS) resistor r=5.1667 c=0
Ry18 (\9\:VSS \3\:VSS) resistor r=5.1667 c=0
Ry19 (\2\:VDD \1\:VDD) resistor r=62 c=0
Ry20 (\15\:VDD \14\:VDD) resistor r=31 c=0
Ry21 (\17\:VDD \16\:VDD) resistor r=62 c=0
Ry22 (\19\:VDD \18\:VDD) resistor r=62 c=0
Ry6 (\15\:CKb \16\:CKb) resistor r=62 c=0
Ry3 (\24\:qbint \23\:qbint) resistor r=62 c=0
Ry4 (\13\:n30 \12\:n30) resistor r=62 c=0
Ry5 (\4\:mout \5\:mout) resistor r=62 c=0
Ry8 (\8\:CKbb \9\:CKbb) resistor r=62 c=0
Ry7 (\4\:n20 \5\:n20) resistor r=31 c=0
Ry9 (\4\:dbp \5\:dbp) resistor r=62 c=0
Ry10 (\6\:dbp \7\:dbp) resistor r=62 c=0
Ry11 (\4\:dbp \10\:dbp) resistor r=62 c=0
Ry13 (\5\:db \6\:db) resistor r=62 c=0
Ry14 (\7\:db \8\:db) resistor r=20.6667 c=0
Ry12 (\5\:SEb \6\:SEb) resistor r=62 c=0
Ry15 (\6\:S0b \7\:S0b) resistor r=62 c=0
Rx17 (\3\:D0 \5\:D0) resistor r=45 c=0
Rx1 (\2\:CK \4\:CK) resistor r=45 c=0
Rx19 (\1\:S0 \8\:S0) resistor r=45 c=0
Rx20 (\4\:S0 \9\:S0) resistor r=45 c=0
Rx21 (\6\:S0 \10\:S0) resistor r=45 c=0
Rx16 (\2\:SE \7\:SE) resistor r=45 c=0
Rx18 (\2\:D1 \4\:D1) resistor r=45 c=0
Rx13 (\3\:SI \5\:SI) resistor r=45 c=0
Rx6 (\4\:CKb \12\:CKb) resistor r=45 c=0
Rx7 (\9\:CKb \19\:CKb) resistor r=45 c=0
Rx8 (\2\:CKb \20\:CKb) resistor r=45 c=0
Rx2 (\18\:qbint \16\:qbint) resistor r=45 c=0
Rx3 (\20\:qbint qbint) resistor r=45 c=0
Rx4 (\11\:n30 \8\:n30) resistor r=45 c=0
Rx5 (\2\:mout \9\:mout) resistor r=45 c=0
Rx10 (\7\:CKbb \10\:CKbb) resistor r=45 c=0
Rx11 (\2\:CKbb \13\:CKbb) resistor r=45 c=0
Rx12 (\5\:CKbb \16\:CKbb) resistor r=45 c=0
Rx9 (\2\:n20 \7\:n20) resistor r=45 c=0
Rx14 (SEb \8\:SEb) resistor r=45 c=0
Rx15 (\4\:SEb \9\:SEb) resistor r=45 c=0
Rx22 (\2\:S0b \8\:S0b) resistor r=45 c=0
mn20 (\17\:CKb \1\:CK \9\:VSS VSS) g45n1svt w=(1.45e-07) l=4.5e-08 nf=1 \
        as=5.74e-14 ad=2.465e-14 ps=1.59e-06 pd=6.3e-07 nrd=1.16667 \
        nrs=1.16667 sa=1.7e-07 sb=1.58655e-06 sd=160n sca=22.3376 \
        scb=0.0224607 scc=0.00248252 m=(1)
mn21 (\14\:CKbb \5\:CKb \13\:VSS VSS) g45n1svt w=(1.45e-07) l=4.5e-08 \
        nf=1 as=3.47e-14 ad=2.03e-14 ps=8.4e-07 pd=5.7e-07 nrd=1.16667 \
        nrs=1.16667 sa=1.4e-07 sb=8.45e-07 sd=160n sca=9.87692 \
        scb=0.0087933 scc=0.000232488 m=(1)
mn10 (\10\:SEb \5\:SE \11\:VSS VSS) g45n1svt w=(1.45e-07) l=4.5e-08 nf=1 \
        as=7.53e-14 ad=2.03e-14 ps=1.4e-06 pd=5.7e-07 nrd=1.16667 \
        nrs=1.16667 sa=1.4e-07 sb=1.08483e-06 sd=160n sca=6.67224 \
        scb=0.00331168 scc=2.36561e-05 m=(1)
mn0 (\4\:S0b \5\:S0 \1\:VSS VSS) g45n1svt w=(1.45e-07) l=4.5e-08 nf=1 \
        as=5.427e-14 ad=2.465e-14 ps=1.11e-06 pd=6.3e-07 nrd=1.16667 \
        nrs=1.16667 sa=9.63621e-07 sb=1.7e-07 sd=160n sca=9.33388 \
        scb=0.00788941 scc=0.00017958 m=(1)
mn12 (net490 \1\:SI \13\:VSS VSS) g45n1svt w=(2.6e-07) l=4.5e-08 nf=1 \
        as=3.47e-14 ad=3.51e-14 ps=8.4e-07 pd=7.9e-07 nrd=1.16667 \
        nrs=1.16667 sa=2.36635e-07 sb=6.4e-07 sd=160n sca=13.5771 \
        scb=0.0135427 scc=0.000870653 m=(1)
mn13 (dbp \4\:SE net490 VSS) g45n1svt w=(2.6e-07) l=4.5e-08 nf=1 \
        as=3.51e-14 ad=4.94e-14 ps=7.9e-07 pd=9e-07 nrd=1.16667 \
        nrs=1.16667 sa=4.16635e-07 sb=4.6e-07 sd=160n sca=13.5771 \
        scb=0.0135427 scc=0.000870653 m=(1)
mn11 (\9\:db \3\:SEb dbp VSS) g45n1svt w=(2.6e-07) l=4.5e-08 nf=1 \
        as=4.94e-14 ad=5.85e-14 ps=9e-07 pd=9.7e-07 nrd=1.16667 \
        nrs=1.16667 sa=6.51635e-07 sb=2.25e-07 sd=160n sca=13.5771 \
        scb=0.0135427 scc=0.000870653 m=(1)
mn1 (net498 \1\:D0 \11\:VSS VSS) g45n1svt w=(2.6e-07) l=4.5e-08 nf=1 \
        as=7.53e-14 ad=1.56e-14 ps=1.4e-06 pd=6.4e-07 nrd=1.16667 \
        nrs=1.16667 sa=3.92788e-07 sb=7.43654e-07 sd=160n sca=7.96722 \
        scb=0.00567143 scc=0.000107411 m=(1)
mn2 (db \3\:S0b net498 VSS) g45n1svt w=(2.6e-07) l=4.5e-08 nf=1 \
        as=1.56e-14 ad=4.16e-14 ps=6.4e-07 pd=8.4e-07 nrd=1.16667 \
        nrs=1.16667 sa=4.97788e-07 sb=6.38654e-07 sd=160n sca=7.96722 \
        scb=0.00567143 scc=0.000107411 m=(1)
mn4 (db \3\:S0 net510 VSS) g45n1svt w=(2.6e-07) l=4.5e-08 nf=1 \
        as=1.56e-14 ad=4.16e-14 ps=6.4e-07 pd=8.4e-07 nrd=1.16667 \
        nrs=1.16667 sa=7.02788e-07 sb=4.33654e-07 sd=160n sca=7.96722 \
        scb=0.00567143 scc=0.000107411 m=(1)
mn3 (net510 \1\:D1 \1\:VSS VSS) g45n1svt w=(2.6e-07) l=4.5e-08 nf=1 \
        as=5.427e-14 ad=1.56e-14 ps=1.11e-06 pd=6.4e-07 nrd=1.16667 \
        nrs=1.16667 sa=8.07788e-07 sb=3.28654e-07 sd=160n sca=7.96722 \
        scb=0.00567143 scc=0.000107411 m=(1)
mn55_1__rcx (\1\:Q qbint \9\:VSS VSS) g45n1svt w=(2.6e-07) l=4.5e-08 \
        nf=1 as=4.473e-14 ad=4.16e-14 ps=1.0275e-06 pd=8.4e-07 nrd=1.16667 \
        nrs=1.16667 sa=2.47788e-07 sb=1.72817e-06 sd=160n sca=16.9678 \
        scb=0.0167861 scc=0.00150639 m=(4)
mn50 (net482 \17\:qbint \9\:VSS VSS) g45n1svt w=(2.05e-07) l=4.5e-08 \
        nf=1 as=5.53e-14 ad=2.358e-14 ps=1.02e-06 pd=6.4e-07 nrd=1.16667 \
        nrs=1.16667 sa=1.50634e-06 sb=2e-06 sd=160n sca=13.4389 \
        scb=0.0137383 scc=0.000784938 m=(1)
mn51 (\9\:n30 CKb net482 VSS) g45n1svt w=(2.05e-07) l=4.5e-08 nf=1 \
        as=2.358e-14 ad=8.61e-14 ps=6.4e-07 pd=1.25e-06 nrd=1.16667 \
        nrs=1.16667 sa=1.66634e-06 sb=1.84e-06 sd=160n sca=13.4389 \
        scb=0.0137383 scc=0.000784938 m=(1)
mn40 (\7\:mout CKbb \9\:n30 VSS) g45n1svt w=(2.05e-07) l=4.5e-08 nf=1 \
        as=8.61e-14 ad=7.073e-14 ps=1.25e-06 pd=1.1e-06 nrd=1.16667 \
        nrs=1.16667 sa=2e-06 sb=1.375e-06 sd=160n sca=13.4389 \
        scb=0.0137383 scc=0.000784938 m=(1)
mn30 (\7\:mout \3\:n20 \15\:VSS VSS) g45n1svt w=(2.05e-07) l=4.5e-08 \
        nf=1 as=8.29e-14 ad=7.073e-14 ps=1.48e-06 pd=1.1e-06 nrd=1.16667 \
        nrs=1.16667 sa=2e-06 sb=9.85e-07 sd=160n sca=13.4389 scb=0.0137383 \
        scc=0.000784938 m=(1)
mn35 (net474 \3\:mout \15\:VSS VSS) g45n1svt w=(2.05e-07) l=4.5e-08 nf=1 \
        as=8.29e-14 ad=1.23e-14 ps=1.48e-06 pd=5.3e-07 nrd=1.16667 \
        nrs=1.16667 sa=2e-06 sb=7.2e-07 sd=160n sca=13.4389 scb=0.0137383 \
        scc=0.000784938 m=(1)
mn36 (\8\:n20 \4\:CKbb net474 VSS) g45n1svt w=(2.05e-07) l=4.5e-08 nf=1 \
        as=1.23e-14 ad=5.228e-14 ps=5.3e-07 pd=9.2e-07 nrd=1.16667 \
        nrs=1.16667 sa=2e-06 sb=6.15e-07 sd=160n sca=13.4389 scb=0.0137383 \
        scc=0.000784938 m=(1)
mn25 (\8\:dbp \11\:CKb \8\:n20 VSS) g45n1svt w=(2.05e-07) l=4.5e-08 nf=1 \
        as=5.228e-14 ad=6.458e-14 ps=9.2e-07 pd=1.04e-06 nrd=1.16667 \
        nrs=1.16667 sa=2e-06 sb=3.15e-07 sd=160n sca=13.4389 scb=0.0137383 \
        scc=0.000784938 m=(1)
mn45 (\21\:qbint \3\:n30 \9\:VSS VSS) g45n1svt w=(2.05e-07) l=4.5e-08 \
        nf=1 as=4.68e-14 ad=3.28e-14 ps=9.3e-07 pd=7.3e-07 nrd=1.16667 \
        nrs=1.16667 sa=1.03634e-06 sb=2e-06 sd=160n sca=13.4389 \
        scb=0.0137383 scc=0.000784938 m=(2)
mp12 (net417 \4\:SI \16\:VDD VDD) g45p1svt w=(3.9e-07) l=4.5e-08 nf=1 \
        as=6.05e-14 ad=2.34e-14 ps=1.18e-06 pd=9e-07 nrd=1.16667 \
        nrs=1.16667 sa=2.55577e-07 sb=5.65e-07 sd=160n sca=16.7336 \
        scb=0.0149207 scc=0.00128056 m=(1)
mp13 (\4\:dbp \2\:SEb net417 VDD) g45p1svt w=(3.9e-07) l=4.5e-08 nf=1 \
        as=2.34e-14 ad=7.41e-14 ps=9e-07 pd=1.16e-06 nrd=1.16667 \
        nrs=1.16667 sa=3.60577e-07 sb=4.6e-07 sd=160n sca=16.7336 \
        scb=0.0149207 scc=0.00128056 m=(1)
mp11 (\4\:dbp \6\:SE \5\:db VDD) g45p1svt w=(3.9e-07) l=4.5e-08 nf=1 \
        as=8.775e-14 ad=7.41e-14 ps=1.23e-06 pd=1.16e-06 nrd=1.16667 \
        nrs=1.16667 sa=5.95577e-07 sb=2.25e-07 sd=160n sca=16.7336 \
        scb=0.0149207 scc=0.00128056 m=(1)
mp1 (net425 \4\:D0 \14\:VDD VDD) g45p1svt w=(3.9e-07) l=4.5e-08 nf=1 \
        as=6.535e-14 ad=4.29e-14 ps=1.16e-06 pd=1e-06 nrd=1.16667 \
        nrs=1.16667 sa=2.69551e-07 sb=9.15e-07 sd=160n sca=11.3866 \
        scb=0.00953811 scc=0.000231855 m=(1)
mp2 (\7\:db \2\:S0 net425 VDD) g45p1svt w=(3.9e-07) l=4.5e-08 nf=1 \
        as=4.29e-14 ad=7.02e-14 ps=1e-06 pd=1.14e-06 nrd=1.16667 \
        nrs=1.16667 sa=4.24551e-07 sb=7.6e-07 sd=160n sca=11.3866 \
        scb=0.00953811 scc=0.000231855 m=(1)
mp4 (\7\:db S0b net429 VDD) g45p1svt w=(3.9e-07) l=4.5e-08 nf=1 \
        as=5.265e-14 ad=7.02e-14 ps=1.05e-06 pd=1.14e-06 nrd=1.16667 \
        nrs=1.16667 sa=6.49551e-07 sb=5.35e-07 sd=160n sca=11.3866 \
        scb=0.00953811 scc=0.000231855 m=(1)
mp3 (net429 \3\:D1 \1\:VDD VDD) g45p1svt w=(3.9e-07) l=4.5e-08 nf=1 \
        as=9.868e-14 ad=5.265e-14 ps=1.47e-06 pd=1.05e-06 nrd=1.16667 \
        nrs=1.16667 sa=8.29551e-07 sb=3.55e-07 sd=160n sca=11.6183 \
        scb=0.00959647 scc=0.000231864 m=(1)
mp55_1__rcx (\1\:Q qbint \9\:VDD VDD) g45p1svt w=(3.9e-07) l=4.5e-08 \
        nf=1 as=9.235e-14 ad=6.24e-14 ps=1.515e-06 pd=1.1e-06 nrd=1.16667 \
        nrs=1.16667 sa=2.68141e-07 sb=1.76308e-06 sd=160n sca=20.0514 \
        scb=0.0177139 scc=0.00149226 m=(4)
mp50 (net409 \15\:qbint \9\:VDD VDD) g45p1svt w=(3.1e-07) l=4.5e-08 nf=1 \
        as=8.74e-14 ad=3.875e-14 ps=1.38e-06 pd=8.7e-07 nrd=1.16667 \
        nrs=1.16667 sa=1.72153e-06 sb=1.73339e-06 sd=160n sca=19.8394 \
        scb=0.0179302 scc=0.00185493 m=(1)
mp51 (\12\:n30 \3\:CKbb net409 VDD) g45p1svt w=(3.1e-07) l=4.5e-08 nf=1 \
        as=3.875e-14 ad=4.96e-14 ps=8.7e-07 pd=9.4e-07 nrd=1.16667 \
        nrs=1.16667 sa=1.89153e-06 sb=1.56339e-06 sd=160n sca=19.8394 \
        scb=0.0179302 scc=0.00185493 m=(1)
mp40 (\12\:n30 \3\:CKb \4\:mout VDD) g45p1svt w=(3.1e-07) l=4.5e-08 nf=1 \
        as=1.3485e-13 ad=4.96e-14 ps=1.49e-06 pd=9.4e-07 nrd=1.16667 \
        nrs=1.16667 sa=1.96476e-06 sb=1.35839e-06 sd=160n sca=19.8394 \
        scb=0.0179302 scc=0.00185493 m=(1)
mp30 (\4\:mout n20 \18\:VDD VDD) g45p1svt w=(3.1e-07) l=4.5e-08 nf=1 \
        as=8.74e-14 ad=1.3485e-13 ps=1.38e-06 pd=1.49e-06 nrd=1.16667 \
        nrs=1.16667 sa=2e-06 sb=8.78387e-07 sd=160n sca=19.8394 \
        scb=0.0179302 scc=0.00185493 m=(1)
mp35 (net393 mout \18\:VDD VDD) g45p1svt w=(3.1e-07) l=4.5e-08 nf=1 \
        as=8.74e-14 ad=5.735e-14 ps=1.38e-06 pd=9.9e-07 nrd=1.16667 \
        nrs=1.16667 sa=2e-06 sb=6.13387e-07 sd=160n sca=19.8394 \
        scb=0.0179302 scc=0.00185493 m=(1)
mp36 (\4\:n20 \8\:CKb net393 VDD) g45p1svt w=(3.1e-07) l=4.5e-08 nf=1 \
        as=5.735e-14 ad=5.89e-14 ps=9.9e-07 pd=1e-06 nrd=1.16667 \
        nrs=1.16667 sa=2e-06 sb=3.83387e-07 sd=160n sca=19.8394 \
        scb=0.0179302 scc=0.00185493 m=(1)
mp25 (\4\:n20 \6\:CKbb \6\:dbp VDD) g45p1svt w=(3.1e-07) l=4.5e-08 nf=1 \
        as=4.6e-14 ad=5.89e-14 ps=1.07e-06 pd=1e-06 nrd=1.16667 \
        nrs=1.16667 sa=2e-06 sb=1.48387e-07 sd=160n sca=19.8394 \
        scb=0.0179302 scc=0.00185493 m=(1)
mp45_1__rcx (\23\:qbint n30 \9\:VDD VDD) g45p1svt w=(3.1e-07) l=4.5e-08 \
        nf=1 as=8.94e-14 ad=4.96e-14 ps=1.38e-06 pd=9.4e-07 nrd=1.16667 \
        nrs=1.16667 sa=1.25153e-06 sb=2e-06 sd=160n sca=19.8394 \
        scb=0.0179302 scc=0.00185493 m=(2)
ends SMDFFHQX4
// End of subcircuit definition.
