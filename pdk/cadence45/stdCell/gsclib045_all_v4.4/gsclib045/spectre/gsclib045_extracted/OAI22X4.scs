// Generated for: spectre (May  1 08:17:13 2013 )
// Library name: gsclib045
// Cell name: OAI22X4
// View name: extracted

simulator lang=spectre

subckt OAI22X4 A0 A1 B0 B1 VDD VSS Y
mp0_1__rcx (4 \1\:A0 \15\:VDD VDD) g45p1svt w=(3.9e-07) l=4.5e-08 nf=1 \
        as=5.46e-14 ad=2.34e-14 ps=1.06e-06 pd=9e-07 nrd=1.16667 \
        nrs=1.16667 sa=1.4e-07 sb=2e-06 sd=160n sca=19.2882 scb=0.0164375 \
        scc=0.00159648 m=(1)
mp1_1__rcx (\15\:Y \5\:A1 4 VDD) g45p1svt w=(3.9e-07) l=4.5e-08 nf=1 \
        as=2.34e-14 ad=6.24e-14 ps=9e-07 pd=1.1e-06 nrd=1.16667 \
        nrs=1.16667 sa=2.45e-07 sb=2e-06 sd=160n sca=18.8494 scb=0.0161462 \
        scc=0.00159619 m=(1)
mp1_2__rcx (\15\:Y \1\:A1 3 VDD) g45p1svt w=(3.9e-07) l=4.5e-08 nf=1 \
        as=2.34e-14 ad=6.24e-14 ps=9e-07 pd=1.1e-06 nrd=1.16667 \
        nrs=1.16667 sa=4.5e-07 sb=2e-06 sd=160n sca=18.3796 scb=0.0159892 \
        scc=0.00159615 m=(1)
mp0_2__rcx (3 \6\:A0 \12\:VDD VDD) g45p1svt w=(3.9e-07) l=4.5e-08 nf=1 \
        as=6.24e-14 ad=2.34e-14 ps=1.1e-06 pd=9e-07 nrd=1.16667 \
        nrs=1.16667 sa=5.55e-07 sb=2e-06 sd=160n sca=18.3796 scb=0.0159892 \
        scc=0.00159615 m=(1)
mp0_3__rcx (9 \4\:A0 \12\:VDD VDD) g45p1svt w=(3.9e-07) l=4.5e-08 nf=1 \
        as=6.24e-14 ad=4.875e-14 ps=1.1e-06 pd=1.03e-06 nrd=1.16667 \
        nrs=1.16667 sa=7.6e-07 sb=2e-06 sd=160n sca=18.3796 scb=0.0159892 \
        scc=0.00159615 m=(1)
mp1_3__rcx (\11\:Y \11\:A1 9 VDD) g45p1svt w=(3.9e-07) l=4.5e-08 nf=1 \
        as=4.875e-14 ad=6.24e-14 ps=1.03e-06 pd=1.1e-06 nrd=1.16667 \
        nrs=1.16667 sa=9.3e-07 sb=1.94e-06 sd=160n sca=18.3796 \
        scb=0.0159892 scc=0.00159615 m=(1)
mp1 (\11\:Y \7\:A1 11 VDD) g45p1svt w=(3.9e-07) l=4.5e-08 nf=1 \
        as=3.12e-14 ad=6.24e-14 ps=9.4e-07 pd=1.1e-06 nrd=1.16667 \
        nrs=1.16667 sa=1.135e-06 sb=1.735e-06 sd=160n sca=18.3796 \
        scb=0.0159892 scc=0.00159615 m=(1)
mp0 (11 \11\:A0 \10\:VDD VDD) g45p1svt w=(3.9e-07) l=4.5e-08 nf=1 \
        as=1.4115e-13 ad=3.12e-14 ps=1.67e-06 pd=9.4e-07 nrd=1.16667 \
        nrs=1.16667 sa=1.26e-06 sb=1.61e-06 sd=160n sca=18.3796 \
        scb=0.0159892 scc=0.00159615 m=(1)
mp2_1__rcx (10 \1\:B0 \10\:VDD VDD) g45p1svt w=(3.9e-07) l=4.5e-08 nf=1 \
        as=1.4115e-13 ad=4.875e-14 ps=1.67e-06 pd=1.03e-06 nrd=1.16667 \
        nrs=1.16667 sa=1.63e-06 sb=1.24e-06 sd=160n sca=18.3796 \
        scb=0.0159892 scc=0.00159615 m=(1)
mp3_1__rcx (\18\:Y \4\:B1 10 VDD) g45p1svt w=(3.9e-07) l=4.5e-08 nf=1 \
        as=4.875e-14 ad=6.24e-14 ps=1.03e-06 pd=1.1e-06 nrd=1.16667 \
        nrs=1.16667 sa=1.8e-06 sb=1.07e-06 sd=160n sca=18.3796 \
        scb=0.0159892 scc=0.00159615 m=(1)
mp3_2__rcx (\18\:Y \6\:B1 5 VDD) g45p1svt w=(3.9e-07) l=4.5e-08 nf=1 \
        as=2.34e-14 ad=6.24e-14 ps=9e-07 pd=1.1e-06 nrd=1.16667 \
        nrs=1.16667 sa=2e-06 sb=8.65e-07 sd=160n sca=18.3796 scb=0.0159892 \
        scc=0.00159615 m=(1)
mp2_2__rcx (5 \8\:B0 \8\:VDD VDD) g45p1svt w=(3.9e-07) l=4.5e-08 nf=1 \
        as=6.24e-14 ad=2.34e-14 ps=1.1e-06 pd=9e-07 nrd=1.16667 \
        nrs=1.16667 sa=2e-06 sb=7.6e-07 sd=160n sca=18.3796 scb=0.0159892 \
        scc=0.00159615 m=(1)
mp2_3__rcx (7 \10\:B0 \8\:VDD VDD) g45p1svt w=(3.9e-07) l=4.5e-08 nf=1 \
        as=6.24e-14 ad=2.34e-14 ps=1.1e-06 pd=9e-07 nrd=1.16667 \
        nrs=1.16667 sa=2e-06 sb=5.55e-07 sd=160n sca=18.3986 scb=0.0159927 \
        scc=0.00159615 m=(1)
mp3_3__rcx (\21\:Y \10\:B1 7 VDD) g45p1svt w=(3.9e-07) l=4.5e-08 nf=1 \
        as=2.34e-14 ad=6.24e-14 ps=9e-07 pd=1.1e-06 nrd=1.16667 \
        nrs=1.16667 sa=2e-06 sb=4.5e-07 sd=160n sca=18.6377 scb=0.0160565 \
        scc=0.00159616 m=(1)
mp3 (\21\:Y \12\:B1 6 VDD) g45p1svt w=(3.9e-07) l=4.5e-08 nf=1 \
        as=2.34e-14 ad=6.24e-14 ps=9e-07 pd=1.1e-06 nrd=1.16667 \
        nrs=1.16667 sa=2e-06 sb=2.45e-07 sd=160n sca=19.4511 scb=0.0165805 \
        scc=0.00159672 m=(1)
mp2 (6 \13\:B0 \1\:VDD VDD) g45p1svt w=(3.9e-07) l=4.5e-08 nf=1 \
        as=5.46e-14 ad=2.34e-14 ps=1.06e-06 pd=9e-07 nrd=1.16667 \
        nrs=1.16667 sa=2e-06 sb=1.4e-07 sd=160n sca=20.2277 scb=0.017479 \
        scc=0.00160012 m=(1)
C1 (B0 VSS) capacitor c=3.04103e-17
C2 (A1 VSS) capacitor c=4.62009e-16
C3 (VDD VSS) capacitor c=1.26649e-16
C4 (B1 VSS) capacitor c=4.33013e-16
C5 (A0 VSS) capacitor c=5.29906e-16
C6 (Y VSS) capacitor c=1.53126e-17
C7 (net102 VSS) capacitor c=5.8827e-16
C8 (3 VSS) capacitor c=2.0348e-18
C9 (9 VSS) capacitor c=3.88442e-18
C10 (11 VSS) capacitor c=2.32514e-18
C11 (10 VSS) capacitor c=3.90746e-18
C12 (5 VSS) capacitor c=2.02598e-18
C13 (7 VSS) capacitor c=2.19172e-18
C14 (\13\:B0 VSS) capacitor c=1.08431e-16
C15 (\12\:B1 VSS) capacitor c=5.98972e-17
C16 (\10\:B1 VSS) capacitor c=7.77661e-17
C17 (\10\:B0 VSS) capacitor c=6.87409e-17
C18 (\8\:B0 VSS) capacitor c=7.36754e-17
C19 (\6\:B1 VSS) capacitor c=5.87884e-17
C20 (\4\:B1 VSS) capacitor c=4.78602e-17
C21 (\1\:B0 VSS) capacitor c=6.06639e-17
C22 (\11\:A0 VSS) capacitor c=7.45608e-17
C23 (\7\:A1 VSS) capacitor c=6.72281e-17
C24 (\11\:A1 VSS) capacitor c=3.69054e-17
C25 (\4\:A0 VSS) capacitor c=5.5047e-17
C26 (\6\:A0 VSS) capacitor c=7.00635e-17
C27 (\1\:A1 VSS) capacitor c=7.73929e-17
C28 (\5\:A1 VSS) capacitor c=5.85745e-17
C29 (\1\:A0 VSS) capacitor c=1.17408e-16
C30 (\2\:B0 VSS) capacitor c=5.53054e-16
C31 (\1\:VDD VSS) capacitor c=4.00654e-17
C32 (\21\:Y VSS) capacitor c=9.15797e-17
C33 (\8\:VDD VSS) capacitor c=4.10705e-17
C34 (\18\:Y VSS) capacitor c=6.00071e-17
C35 (\10\:VDD VSS) capacitor c=2.91231e-17
C36 (\11\:Y VSS) capacitor c=2.73227e-17
C37 (\12\:VDD VSS) capacitor c=4.52814e-17
C38 (\15\:Y VSS) capacitor c=4.53906e-17
C39 (\15\:VDD VSS) capacitor c=3.85062e-17
C40 (\3\:VDD VSS) capacitor c=4.92342e-17
C41 (\1\:Y VSS) capacitor c=4.28144e-16
C42 (\7\:B0 VSS) capacitor c=3.85329e-17
C43 (\9\:Y VSS) capacitor c=5.7766e-17
C44 (\10\:Y VSS) capacitor c=5.65883e-17
C45 (\13\:Y VSS) capacitor c=2.23053e-17
C46 (\14\:Y VSS) capacitor c=4.92764e-17
C47 (\5\:VDD VSS) capacitor c=2.10937e-17
C48 (\6\:VDD VSS) capacitor c=2.30746e-17
C49 (\14\:VDD VSS) capacitor c=1.39022e-17
Rk25 (\2\:B0 B0) resistor r=0.08407 c=0
Rk34 (\2\:VDD \4\:VDD) resistor r=0.4848 c=0
Rk35 (\4\:VDD \5\:VDD) resistor r=0.1925 c=0
Rk36 (\5\:VDD \6\:VDD) resistor r=0.41 c=0
Rk37 (\6\:VDD \7\:VDD) resistor r=0.3476 c=0
Rk38 (\5\:VDD \9\:VDD) resistor r=0.2572 c=0
Rk39 (\6\:VDD \11\:VDD) resistor r=0.1778 c=0
Rk40 (\7\:VDD \13\:VDD) resistor r=0.3031 c=0
Rk43 (\14\:VDD VDD) resistor r=0.2348 c=0
Rk41 (\7\:VDD \14\:VDD) resistor r=0.3157 c=0
Rk42 (\14\:VDD \16\:VDD) resistor r=0.351 c=0
Rk11 (\1\:Y \9\:Y) resistor r=0.6175 c=0
Rk12 (\9\:Y \10\:Y) resistor r=0.2661 c=0
Rk13 (\10\:Y \12\:Y) resistor r=0.05031 c=0
Rk15 (\13\:Y Y) resistor r=0.03891 c=0
Rk14 (\9\:Y \13\:Y) resistor r=0.1352 c=0
Rk16 (\10\:Y \14\:Y) resistor r=0.4505 c=0
Rk17 (\14\:Y \16\:Y) resistor r=0.05702 c=0
Rk18 (\10\:Y \17\:Y) resistor r=0.1099 c=0
Rk19 (\13\:Y \19\:Y) resistor r=0.2419 c=0
Rk20 (\14\:Y \20\:Y) resistor r=0.1166 c=0
Rk21 (\19\:Y \22\:Y) resistor r=0.4349 c=0
Rk49 (\3\:VSS VSS) resistor r=0.1022 c=0
Rk44 (\2\:VSS \3\:VSS) resistor r=0.693 c=0
Rl38 (\2\:B0 \13\:B0) resistor r=163.4 c=0
Rl19 (\2\:B0 \1\:B0) resistor r=91.0764 c=0
Rl31 (\7\:B0 \10\:B0) resistor r=85.0356 c=0
Rl29 (\7\:B0 \8\:B0) resistor r=123.107 c=0
Rl28 (\7\:B0 \2\:B0) resistor r=3.8223 c=0
Rl12 (A1 \7\:A1) resistor r=106.514 c=0
Rl15 (A1 \11\:A1) resistor r=25.3108 c=0
Rl3 (A1 \1\:A1) resistor r=82.6695 c=0
Rl6 (A1 \5\:A1) resistor r=24.7951 c=0
Rl36 (B1 \12\:B1) resistor r=27.0846 c=0
Rl34 (B1 \10\:B1) resistor r=76.8424 c=0
Rl25 (B1 \6\:B1) resistor r=27.0846 c=0
Rl23 (B1 \4\:B1) resistor r=76.8424 c=0
Rl18 (A0 \11\:A0) resistor r=93.4636 c=0
Rl8 (A0 \4\:A0) resistor r=141.129 c=0
Rl9 (A0 \6\:A0) resistor r=94.5244 c=0
Rl1 (A0 \1\:A0) resistor r=237.546 c=0
Rz14 (\3\:VDD \4\:VDD) resistor r=10.7143 c=0
Rz15 (\3\:VDD \7\:VDD) resistor r=6.25 c=0
Ry7 (\1\:VDD \2\:VDD) resistor r=20.6667 c=0
Ry8 (\8\:VDD \9\:VDD) resistor r=62 c=0
Ry9 (\10\:VDD \11\:VDD) resistor r=62 c=0
Ry10 (\12\:VDD \13\:VDD) resistor r=62 c=0
Ry11 (\15\:VDD \16\:VDD) resistor r=20.6667 c=0
Ry1 (\12\:Y \11\:Y) resistor r=62 c=0
Ry2 (\16\:Y \15\:Y) resistor r=62 c=0
Ry3 (\17\:Y \11\:Y) resistor r=62 c=0
Ry4 (\19\:Y \18\:Y) resistor r=62 c=0
Ry5 (\20\:Y \15\:Y) resistor r=62 c=0
Ry6 (\22\:Y \21\:Y) resistor r=20.6667 c=0
Ry12 (\2\:VSS \1\:VSS) resistor r=8.8571 c=0
Ry13 (\3\:VSS \1\:VSS) resistor r=5.1667 c=0
mn0_1__rcx (net102 A0 \3\:VSS VSS) g45n1svt w=(2.6e-07) l=4.5e-08 nf=1 \
        as=8.06e-14 ad=4.55e-14 ps=1.35e-06 pd=8.7e-07 nrd=1.16667 \
        nrs=1.16667 sa=1.4e-07 sb=2e-06 sd=160n sca=9.14564 scb=0.00759168 \
        scc=0.000213449 m=(4)
mn1_1__rcx (net102 A1 \3\:VSS VSS) g45n1svt w=(2.6e-07) l=4.5e-08 nf=1 \
        as=8.06e-14 ad=4.16e-14 ps=1.35e-06 pd=8.4e-07 nrd=1.16667 \
        nrs=1.16667 sa=4.05e-07 sb=2e-06 sd=160n sca=9.14564 \
        scb=0.00759168 scc=0.000213449 m=(4)
mn2_1__rcx (\1\:Y \2\:B0 net102 VSS) g45n1svt w=(2.6e-07) l=4.5e-08 nf=1 \
        as=4.55e-14 ad=4.16e-14 ps=8.7e-07 pd=8.4e-07 nrd=1.16667 \
        nrs=1.16667 sa=2e-06 sb=1.575e-06 sd=160n sca=9.14564 \
        scb=0.00759168 scc=0.000213449 m=(4)
mn3_1__rcx (\1\:Y B1 net102 VSS) g45n1svt w=(2.6e-07) l=4.5e-08 nf=1 \
        as=4.16e-14 ad=4.16e-14 ps=8.4e-07 pd=8.4e-07 nrd=1.16667 \
        nrs=1.16667 sa=2e-06 sb=1.37e-06 sd=160n sca=9.14564 \
        scb=0.00759168 scc=0.000213449 m=(4)
ends OAI22X4
// End of subcircuit definition.
