// Generated for: spectre (May  1 08:11:44 2013 )
// Library name: gsclib045
// Cell name: LSHL_ISOH_X1_TO_ON
// View name: extracted

simulator lang=spectre

subckt LSHL_ISOH_X1_TO_ON A ISO VDD VSS Y
PM1 (\9\:ison \1\:ISO \5\:VDD VDD) g45p1svt w=(2.15e-07) l=4.5e-08 nf=1 \
        as=3.01e-14 ad=3.44e-14 ps=7.1e-07 pd=7.5e-07 nrd=1.16667 \
        nrs=1.16667 sa=1.4e-07 sb=3.45e-07 sd=160n sca=10.1453 \
        scb=0.00734814 scc=7.36798e-05 m=(1)
mp0 (\9\:n0 \1\:A \5\:VDD VDD) g45p1svt w=(2.15e-07) l=4.5e-08 nf=1 \
        as=3.01e-14 ad=3.44e-14 ps=7.1e-07 pd=7.5e-07 nrd=1.16667 \
        nrs=1.16667 sa=3.45e-07 sb=1.4e-07 sd=160n sca=10.1453 \
        scb=0.00734814 scc=7.36798e-05 m=(1)
C1 (VDD VSS) capacitor c=2.1607e-16
C2 (ISO VSS) capacitor c=5.22825e-17
C3 (A VSS) capacitor c=2.96784e-17
C4 (ison VSS) capacitor c=6.74978e-17
C5 (gatedVSS VSS) capacitor c=2.40034e-16
C6 (n0 VSS) capacitor c=5.33784e-17
C7 (\1\:A VSS) capacitor c=5.67746e-17
C8 (\1\:ISO VSS) capacitor c=8.54435e-17
C9 (\4\:n0 VSS) capacitor c=2.67568e-17
C10 (\4\:A VSS) capacitor c=3.50053e-17
C11 (\3\:ISO VSS) capacitor c=3.87065e-17
C12 (\3\:n0 VSS) capacitor c=4.55043e-17
C13 (\4\:ison VSS) capacitor c=1.74466e-17
C14 (\3\:A VSS) capacitor c=1.77336e-17
C15 (\2\:ISO VSS) capacitor c=6.03457e-17
C16 (\6\:Y VSS) capacitor c=5.88422e-17
C17 (\1\:VDD VSS) capacitor c=1.12352e-16
C18 (\4\:Y VSS) capacitor c=1.34041e-16
C19 (\9\:n0 VSS) capacitor c=1.02156e-16
C20 (\5\:VDD VSS) capacitor c=5.54623e-17
C21 (\9\:ison VSS) capacitor c=1.06456e-16
C22 (\1\:Y VSS) capacitor c=4.89539e-17
C23 (\7\:gatedVSS VSS) capacitor c=5.62063e-17
C24 (\7\:n0 VSS) capacitor c=1.30819e-16
C25 (\7\:ison VSS) capacitor c=1.51266e-16
C26 (\2\:A VSS) capacitor c=6.53048e-17
C27 (\2\:ison VSS) capacitor c=1.13554e-16
C28 (\5\:A VSS) capacitor c=3.64218e-17
C29 (\6\:ison VSS) capacitor c=1.18177e-16
C30 (\5\:n0 VSS) capacitor c=6.27429e-17
C31 (\6\:n0 VSS) capacitor c=1.4979e-16
C32 (\3\:Y VSS) capacitor c=6.7253e-17
Rk21 (\4\:VDD VDD) resistor r=0.02528 c=0
Rk20 (\2\:VDD \4\:VDD) resistor r=0.6482 c=0
Rk22 (VDD \6\:VDD) resistor r=0.3553 c=0
Rk1 (ISO \4\:ISO) resistor r=0.003448 c=0
Rk23 (\2\:VSS VSS) resistor r=0.3014 c=0
Rk24 (VSS \4\:VSS) resistor r=0.07815 c=0
Rk25 (\4\:VSS \6\:VSS) resistor r=0.7751 c=0
Rk16 (\2\:Y \3\:Y) resistor r=0.3039 c=0
Rk17 (\3\:Y \5\:Y) resistor r=0.5546 c=0
Rk19 (\7\:Y Y) resistor r=0.004839 c=0
Rk18 (\3\:Y \7\:Y) resistor r=0.1783 c=0
Rk5 (\5\:A A) resistor r=0.008783 c=0
Rk4 (\5\:A \6\:A) resistor r=0.005175 c=0
Rk8 (\6\:ison \8\:ison) resistor r=0.6624 c=0
Rk9 (\8\:ison \10\:ison) resistor r=0.9061 c=0
Rk12 (gatedVSS \8\:gatedVSS) resistor r=0.09023 c=0
Rk13 (\5\:n0 \6\:n0) resistor r=0.3375 c=0
Rk14 (\6\:n0 \8\:n0) resistor r=0.6842 c=0
Rk15 (\6\:n0 \10\:n0) resistor r=0.531 c=0
Rl1 (\1\:ISO \2\:ISO) resistor r=264.957 c=0
Rl2 (\2\:ISO \3\:ISO) resistor r=171.342 c=0
Rl3 (\1\:A \2\:A) resistor r=248.037 c=0
Rl5 (\2\:A \4\:A) resistor r=117.068 c=0
Rl4 (\2\:A \3\:A) resistor r=1.2666 c=0
Rl6 (\2\:ison ison) resistor r=208.445 c=0
Rl8 (\4\:ison \2\:ison) resistor r=77.0076 c=0
Rl10 (n0 \2\:n0) resistor r=125.556 c=0
Rl12 (\2\:n0 \4\:n0) resistor r=41.9777 c=0
Rl11 (\2\:n0 \3\:n0) resistor r=0.6051 c=0
Rz9 (\2\:VSS \1\:VSS) resistor r=75 c=0
Rz10 (\6\:VSS \5\:VSS) resistor r=75 c=0
Rz7 (\1\:Y \2\:Y) resistor r=37.5 c=0
Rz1 (\8\:ison \7\:ison) resistor r=75 c=0
Rz3 (gatedVSS \3\:gatedVSS) resistor r=37.5 c=0
Rz5 (\8\:gatedVSS \7\:gatedVSS) resistor r=75 c=0
Rz6 (\7\:n0 \8\:n0) resistor r=75 c=0
Ry5 (\1\:VDD \2\:VDD) resistor r=20.6667 c=0
Ry6 (\5\:VDD \6\:VDD) resistor r=62 c=0
Ry3 (\4\:Y \5\:Y) resistor r=20.6667 c=0
Ry4 (\6\:Y \7\:Y) resistor r=20.6667 c=0
Ry1 (\10\:ison \9\:ison) resistor r=62 c=0
Ry2 (\9\:n0 \10\:n0) resistor r=62 c=0
Rx1 (\2\:ISO \4\:ISO) resistor r=45 c=0
Rx2 (\3\:A \6\:A) resistor r=45 c=0
Rx3 (\6\:ison \4\:ison) resistor r=45 c=0
Rx4 (\3\:n0 \5\:n0) resistor r=45 c=0
mn0 (\7\:gatedVSS \4\:A \7\:n0 VSS) g45n1svt w=(1.45e-07) l=4.5e-08 nf=1 \
        as=2.03e-14 ad=2.03e-14 ps=5.7e-07 pd=5.7e-07 nrd=1.16667 \
        nrs=1.16667 sa=1.4e-07 sb=1.4e-07 sd=160n sca=11.1906 \
        scb=0.0108717 scc=0.000387468 m=(1)
NM1 (\5\:VSS \3\:ISO \7\:ison VSS) g45n1svt w=(1.45e-07) l=4.5e-08 nf=1 \
        as=2.03e-14 ad=2.03e-14 ps=5.7e-07 pd=5.7e-07 nrd=1.16667 \
        nrs=1.16667 sa=1.4e-07 sb=1.4e-07 sd=160n sca=11.1906 \
        scb=0.0108717 scc=0.000387468 m=(1)
NM0 (\1\:Y \4\:n0 \3\:gatedVSS VSS) g45n1svt w=(2.6e-07) l=4.5e-08 nf=1 \
        as=3.64e-14 ad=3.64e-14 ps=8e-07 pd=8e-07 nrd=1.16667 nrs=1.16667 \
        sa=1.4e-07 sb=1.4e-07 sd=160n sca=9.32128 scb=0.00786794 \
        scc=0.000232361 m=(1)
NM3 (gatedVSS \2\:ison \1\:VSS VSS) g45n1svt w=(2.6e-07) l=4.5e-08 nf=1 \
        as=3.64e-14 ad=4.16e-14 ps=8e-07 pd=8.4e-07 nrd=1.16667 \
        nrs=1.16667 sa=1.4e-07 sb=3.45e-07 sd=160n sca=9.32128 \
        scb=0.00786794 scc=0.000232361 m=(2)
PM0 (\6\:Y n0 \1\:VDD VDD) g45p1svt w=(3.9e-07) l=4.5e-08 nf=1 \
        as=5.46e-14 ad=6.24e-14 ps=1.06e-06 pd=1.1e-06 nrd=1.16667 \
        nrs=1.16667 sa=3.45e-07 sb=1.4e-07 sd=160n sca=17.0626 \
        scb=0.016739 scc=0.000580643 m=(1)
PM4 (\4\:Y ison \1\:VDD VDD) g45p1svt w=(3.9e-07) l=4.5e-08 nf=1 \
        as=6.24e-14 ad=5.46e-14 ps=1.1e-06 pd=1.06e-06 nrd=1.16667 \
        nrs=1.16667 sa=1.4e-07 sb=3.45e-07 sd=160n sca=14.3303 \
        scb=0.0124199 scc=0.00051711 m=(1)
ends LSHL_ISOH_X1_TO_ON
// End of subcircuit definition.
