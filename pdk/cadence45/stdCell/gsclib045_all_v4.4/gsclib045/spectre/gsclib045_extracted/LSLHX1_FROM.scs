// Generated for: spectre (May  1 08:11:52 2013 )
// Library name: gsclib045
// Cell name: LSLHX1_FROM
// View name: extracted

simulator lang=spectre

subckt LSLHX1_FROM A ExtVDD VDD VSS Y
PM2 (\9\:Ab \8\:A \3\:VDD VDD) g45p1svt w=(2.15e-07) l=4.5e-08 nf=1 \
        as=3.01e-14 ad=3.01e-14 ps=7.1e-07 pd=7.1e-07 nrd=1.16667 \
        nrs=1.16667 sa=1.4e-07 sb=1.4e-07 sd=160n sca=22.1186 \
        scb=0.0256747 scc=0.000846596 m=(1)
PM0 (\15\:Ybint \4\:Yint \6\:ExtVDD ExtVDD) g45p1svt w=(2.15e-07) \
        l=4.5e-08 nf=1 as=3.01e-14 ad=3.01e-14 ps=7.1e-07 pd=7.1e-07 \
        nrd=1.16667 nrs=1.16667 sa=1.4e-07 sb=1.4e-07 sd=160n sca=22.4693 \
        scb=0.0242319 scc=0.00195457 m=(1)
PM1 (\11\:Yint Ybint \4\:ExtVDD ExtVDD) g45p1svt w=(2.15e-07) l=4.5e-08 \
        nf=1 as=3.01e-14 ad=3.01e-14 ps=7.1e-07 pd=7.1e-07 nrd=1.16667 \
        nrs=1.16667 sa=1.4e-07 sb=1.4e-07 sd=160n sca=6.51475 \
        scb=0.00284195 scc=1.84335e-05 m=(1)
C1 (ExtVDD VSS) capacitor c=2.34231e-16
C2 (A VSS) capacitor c=4.03589e-17
C3 (Y VSS) capacitor c=7.29803e-17
C4 (VDD VSS) capacitor c=8.3941e-17
C5 (Yint VSS) capacitor c=3.22671e-17
C6 (Ab VSS) capacitor c=1.73986e-16
C7 (Ybint VSS) capacitor c=2.71508e-17
C8 (\6\:Ybint VSS) capacitor c=5.18774e-17
C9 (\4\:Yint VSS) capacitor c=2.63292e-17
C10 (\8\:A VSS) capacitor c=4.07374e-17
C11 (\3\:Ybint VSS) capacitor c=2.39332e-17
C12 (\1\:A VSS) capacitor c=2.26218e-16
C13 (\9\:A VSS) capacitor c=2.96624e-17
C14 (\5\:Ybint VSS) capacitor c=7.97083e-18
C15 (\2\:Ybint VSS) capacitor c=2.44523e-17
C16 (\3\:Yint VSS) capacitor c=2.12283e-17
C17 (\4\:Ab VSS) capacitor c=7.92137e-17
C18 (\5\:A VSS) capacitor c=1.69129e-17
C19 (\3\:Y VSS) capacitor c=3.55351e-17
C20 (\1\:ExtVDD VSS) capacitor c=6.17592e-17
C21 (\4\:ExtVDD VSS) capacitor c=1.1854e-16
C22 (\11\:Yint VSS) capacitor c=6.3912e-17
C23 (\15\:Ybint VSS) capacitor c=8.80672e-17
C24 (\6\:ExtVDD VSS) capacitor c=1.23113e-16
C25 (\9\:Ab VSS) capacitor c=5.44083e-17
C26 (\3\:VDD VSS) capacitor c=3.6737e-17
C27 (\1\:Y VSS) capacitor c=6.28916e-17
C28 (\5\:Yint VSS) capacitor c=1.66597e-16
C29 (\11\:Ab VSS) capacitor c=2.73755e-17
C30 (VDD VSS) capacitor c=3.13684e-16
C31 (\2\:Yint VSS) capacitor c=1.72691e-17
C32 (\4\:A VSS) capacitor c=1.55154e-16
C33 (\4\:Ybint VSS) capacitor c=1.92564e-17
C34 (\11\:A VSS) capacitor c=1.78584e-17
C35 (\7\:Ab VSS) capacitor c=5.97788e-18
C36 (\8\:Ab VSS) capacitor c=5.96956e-17
C37 (\8\:Yint VSS) capacitor c=4.05672e-17
C38 (\13\:Yint VSS) capacitor c=5.50301e-17
C39 (\3\:ExtVDD VSS) capacitor c=1.5477e-17
C40 (\9\:ExtVDD VSS) capacitor c=6.81811e-17
C41 (\7\:Ybint VSS) capacitor c=4.44954e-17
C42 (\8\:Ybint VSS) capacitor c=1.96083e-16
C43 (\10\:Ybint VSS) capacitor c=9.26014e-17
C44 (\2\:VDD VSS) capacitor c=1.34307e-17
Rk18 (ExtVDD ExtVDD) resistor r=0.003774 c=0
Rk13 (\2\:ExtVDD \3\:ExtVDD) resistor r=0.2431 c=0
Rk14 (\3\:ExtVDD \5\:ExtVDD) resistor r=0.2622 c=0
Rk15 (\5\:ExtVDD \7\:ExtVDD) resistor r=0.9734 c=0
Rk17 (\9\:ExtVDD ExtVDD) resistor r=0.001887 c=0
Rk16 (\3\:ExtVDD \9\:ExtVDD) resistor r=0.1693 c=0
Rk31 (\3\:VSS VSS) resistor r=0.2902 c=0
Rk30 (\2\:VSS \3\:VSS) resistor r=0.09668 c=0
Rk36 (\7\:VSS VSS) resistor r=0.1765 c=0
Rk35 (VSS \7\:VSS) resistor r=0.1839 c=0
Rk37 (VSS \9\:VSS) resistor r=0.5026 c=0
Rk38 (\3\:VSS \11\:VSS) resistor r=0.2229 c=0
Rk42 (\19\:VSS VSS) resistor r=0.7263 c=0
Rk44 (\20\:VSS VSS) resistor r=0.2153 c=0
Rk43 (VSS \20\:VSS) resistor r=0.2424 c=0
Rk1 (A \10\:A) resistor r=0.0081 c=0
Rk3 (\11\:A A) resistor r=0.005137 c=0
Rk2 (\10\:A \11\:A) resistor r=0.00399 c=0
Rk25 (\2\:Y Y) resistor r=0.4125 c=0
Rk26 (Y \4\:Y) resistor r=0.1581 c=0
Rk27 (VDD VDD) resistor r=0.5764 c=0
Rk28 (VDD \2\:VDD) resistor r=0.1867 c=0
Rk29 (\2\:VDD \4\:VDD) resistor r=0.3398 c=0
Rk10 (\5\:Yint \8\:Yint) resistor r=0.2587 c=0
Rk12 (\12\:Yint \13\:Yint) resistor r=0.2911 c=0
Rk6 (\7\:Ab \8\:Ab) resistor r=0.04171 c=0
Rk7 (\8\:Ab \10\:Ab) resistor r=0.4593 c=0
Rk8 (\8\:Ab \12\:Ab) resistor r=0.1377 c=0
Rk19 (\7\:Ybint \8\:Ybint) resistor r=0.2657 c=0
Rk21 (\8\:Ybint \10\:Ybint) resistor r=0.1966 c=0
Rk24 (\10\:Ybint \16\:Ybint) resistor r=0.5862 c=0
Rl16 (\4\:A \8\:A) resistor r=163.948 c=0
Rl12 (\4\:A \1\:A) resistor r=621.773 c=0
Rl17 (\4\:A \9\:A) resistor r=83.8346 c=0
Rl13 (\4\:A \5\:A) resistor r=9.0434 c=0
Rl8 (\2\:Yint \4\:Yint) resistor r=41.7694 c=0
Rl6 (\2\:Yint Yint) resistor r=105.33 c=0
Rl7 (\2\:Yint \3\:Yint) resistor r=34.5546 c=0
Rl3 (Ab \4\:Ab) resistor r=297.331 c=0
Rl9 (\2\:Ybint Ybint) resistor r=72.3229 c=0
Rl20 (\4\:Ybint \6\:Ybint) resistor r=154.48 c=0
Rl18 (\4\:Ybint \3\:Ybint) resistor r=49.0088 c=0
Rl19 (\4\:Ybint \5\:Ybint) resistor r=3.5166 c=0
Rz9 (\9\:VSS \8\:VSS) resistor r=75 c=0
Rz10 (\11\:VSS \10\:VSS) resistor r=37.5 c=0
Rz7 (\1\:Y \2\:Y) resistor r=37.5 c=0
Rz1 (\12\:Ab \11\:Ab) resistor r=75 c=0
Ry3 (\1\:ExtVDD \2\:ExtVDD) resistor r=20.6667 c=0
Ry4 (\4\:ExtVDD \5\:ExtVDD) resistor r=62 c=0
Ry5 (\6\:ExtVDD \7\:ExtVDD) resistor r=62 c=0
Ry9 (\2\:VSS \1\:VSS) resistor r=7.75 c=0
Ry10 (\7\:VSS \1\:VSS) resistor r=5.1667 c=0
Ry11 (\19\:VSS \18\:VSS) resistor r=7.75 c=0
Ry12 (\20\:VSS \18\:VSS) resistor r=5.1667 c=0
Ry7 (\3\:Y \4\:Y) resistor r=20.6667 c=0
Ry8 (\3\:VDD \4\:VDD) resistor r=62 c=0
Ry2 (\12\:Yint \11\:Yint) resistor r=62 c=0
Ry1 (\10\:Ab \9\:Ab) resistor r=62 c=0
Ry6 (\16\:Ybint \15\:Ybint) resistor r=62 c=0
Rx1 (\10\:A \5\:A) resistor r=45 c=0
Rx3 (\8\:Yint \3\:Yint) resistor r=45 c=0
Rx4 (\13\:Yint Yint) resistor r=45 c=0
Rx2 (\7\:Ab \4\:Ab) resistor r=45 c=0
Rx5 (\7\:Ybint \5\:Ybint) resistor r=45 c=0
Rx6 (\10\:Ybint \2\:Ybint) resistor r=45 c=0
NM2 (\8\:VSS \9\:A \11\:Ab VSS) g45n1svt w=(1.45e-07) l=4.5e-08 nf=1 \
        as=2.03e-14 ad=2.03e-14 ps=5.7e-07 pd=5.7e-07 nrd=1.16667 \
        nrs=1.16667 sa=1.4e-07 sb=1.4e-07 sd=160n sca=7.79977 \
        scb=0.00524357 scc=6.87485e-05 m=(1)
mn0 (\1\:Y \3\:Ybint \10\:VSS VSS) g45n1svt w=(2.6e-07) l=4.5e-08 nf=1 \
        as=3.64e-14 ad=3.64e-14 ps=8e-07 pd=8e-07 nrd=1.16667 nrs=1.16667 \
        sa=1.4e-07 sb=1.4e-07 sd=160n sca=11.8713 scb=0.0115056 \
        scc=0.000581193 m=(1)
NM1 (\5\:Yint Ab VSS VSS) g45n1svt w=(2.6e-07) l=4.5e-08 nf=1 \
        as=4.16e-14 ad=3.987e-14 ps=8.4e-07 pd=8.2667e-07 nrd=1.16667 \
        nrs=1.16667 sa=5.5e-07 sb=7.55e-07 sd=160n sca=11.8713 \
        scb=0.0115056 scc=0.000581193 m=(3)
NM0 (\8\:Ybint \1\:A VSS VSS) g45n1svt w=(2.6e-07) l=4.5e-08 nf=1 \
        as=3.987e-14 ad=4.16e-14 ps=8.2667e-07 pd=8.4e-07 nrd=1.16667 \
        nrs=1.16667 sa=7.55e-07 sb=5.5e-07 sd=160n sca=11.8713 \
        scb=0.0115056 scc=0.000581193 m=(3)
mp0 (\3\:Y \6\:Ybint \1\:ExtVDD ExtVDD) g45p1svt w=(3.9e-07) l=4.5e-08 \
        nf=1 as=5.46e-14 ad=5.46e-14 ps=1.06e-06 pd=1.06e-06 nrd=1.16667 \
        nrs=1.16667 sa=1.4e-07 sb=1.4e-07 sd=160n sca=25.8656 \
        scb=0.0273401 scc=0.00268966 m=(1)
ends LSLHX1_FROM
// End of subcircuit definition.
