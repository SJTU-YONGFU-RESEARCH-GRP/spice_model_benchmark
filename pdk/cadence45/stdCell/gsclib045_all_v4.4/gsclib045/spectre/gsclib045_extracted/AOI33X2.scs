// Generated for: spectre (May  1 08:09:05 2013 )
// Library name: gsclib045
// Cell name: AOI33X2
// View name: extracted

simulator lang=spectre

subckt AOI33X2 A0 A1 A2 B0 B1 B2 VDD VSS Y
mp3_1__rcx (\7\:Y B0 net124 VDD) g45p1svt w=(3.9e-07) l=4.5e-08 nf=1 \
        as=8.58e-14 ad=6.338e-14 ps=1.22e-06 pd=1.105e-06 nrd=1.16667 \
        nrs=1.16667 sa=1.555e-06 sb=1.2e-06 sd=160n sca=12.3656 \
        scb=0.0108222 scc=0.000412413 m=(2)
mp4_1__rcx (\7\:Y \1\:B1 net124 VDD) g45p1svt w=(3.9e-07) l=4.5e-08 nf=1 \
        as=6.825e-14 ad=6.338e-14 ps=1.13e-06 pd=1.105e-06 nrd=1.16667 \
        nrs=1.16667 sa=1.765e-06 sb=9.9e-07 sd=160n sca=12.3656 \
        scb=0.0108222 scc=0.000412413 m=(2)
mp0_1__rcx (net124 A0 \4\:VDD VDD) g45p1svt w=(3.9e-07) l=4.5e-08 nf=1 \
        as=7.117e-14 ad=8.58e-14 ps=1.145e-06 pd=1.22e-06 nrd=1.16667 \
        nrs=1.16667 sa=1.4e-07 sb=2e-06 sd=160n sca=22.0413 scb=0.02503 \
        scc=0.00108348 m=(2)
mp1_1__rcx (net124 \1\:A1 \4\:VDD VDD) g45p1svt w=(3.9e-07) l=4.5e-08 \
        nf=1 as=7.117e-14 ad=6.24e-14 ps=1.145e-06 pd=1.1e-06 nrd=1.16667 \
        nrs=1.16667 sa=3.45e-07 sb=2e-06 sd=160n sca=15.2233 scb=0.013848 \
        scc=0.000431029 m=(2)
mp5 (\9\:Y \1\:B2 net124 VDD) g45p1svt w=(3.9e-07) l=4.5e-08 nf=1 \
        as=6.825e-14 ad=6.24e-14 ps=1.13e-06 pd=1.1e-06 nrd=1.16667 \
        nrs=1.16667 sa=1.98e-06 sb=7.75e-07 sd=160n sca=12.4666 \
        scb=0.0108434 scc=0.000412415 m=(2)
mp2 (net124 \3\:A2 \9\:VDD VDD) g45p1svt w=(3.9e-07) l=4.5e-08 nf=1 \
        as=6.24e-14 ad=6.24e-14 ps=1.1e-06 pd=1.1e-06 nrd=1.16667 \
        nrs=1.16667 sa=5.5e-07 sb=2e-06 sd=160n sca=13.3531 scb=0.0113375 \
        scc=0.000412845 m=(2)
C1 (A1 VSS) capacitor c=2.4193e-17
C2 (B1 VSS) capacitor c=3.18617e-17
C3 (Y VSS) capacitor c=7.05497e-17
C4 (A2 VSS) capacitor c=6.83954e-17
C5 (B2 VSS) capacitor c=7.38366e-17
C6 (B0 VSS) capacitor c=4.59137e-16
C7 (A0 VSS) capacitor c=4.43097e-16
C8 (VDD VSS) capacitor c=1.67163e-16
C9 (11 VSS) capacitor c=2.6935e-18
C10 (12 VSS) capacitor c=6.8412e-18
C11 (13 VSS) capacitor c=2.64226e-18
C12 (14 VSS) capacitor c=1.19232e-17
C13 (15 VSS) capacitor c=7.18522e-18
C14 (16 VSS) capacitor c=4.78439e-18
C15 (17 VSS) capacitor c=7.31257e-18
C16 (18 VSS) capacitor c=3.44348e-18
C17 (net124 VSS) capacitor c=4.91436e-16
C18 (\1\:B2 VSS) capacitor c=1.12102e-16
C19 (\1\:B1 VSS) capacitor c=4.0687e-16
C20 (\1\:A1 VSS) capacitor c=3.86595e-16
C21 (\6\:B0 VSS) capacitor c=4.08944e-17
C22 (\6\:B1 VSS) capacitor c=4.9799e-17
C23 (\6\:B2 VSS) capacitor c=3.0376e-17
C24 (\4\:B2 VSS) capacitor c=3.12555e-17
C25 (\3\:B1 VSS) capacitor c=4.42022e-17
C26 (\3\:B0 VSS) capacitor c=3.6312e-17
C27 (\6\:A0 VSS) capacitor c=3.05001e-17
C28 (\6\:A1 VSS) capacitor c=5.45001e-17
C29 (\1\:A2 VSS) capacitor c=4.74494e-17
C30 (\4\:A2 VSS) capacitor c=3.12455e-17
C31 (\3\:A1 VSS) capacitor c=5.69811e-17
C32 (\1\:A0 VSS) capacitor c=4.9292e-17
C33 (\3\:A2 VSS) capacitor c=1.22086e-16
C34 (\9\:Y VSS) capacitor c=9.54817e-17
C35 (\7\:Y VSS) capacitor c=1.34629e-16
C36 (\9\:VDD VSS) capacitor c=4.75609e-17
C37 (\1\:VDD VSS) capacitor c=7.91028e-17
C38 (\1\:Y VSS) capacitor c=7.44635e-17
C39 (\4\:Y VSS) capacitor c=8.28809e-17
C40 (\2\:A2 VSS) capacitor c=2.44836e-17
C41 (\3\:B2 VSS) capacitor c=2.58196e-17
C42 (\7\:A2 VSS) capacitor c=4.9309e-17
C43 (\7\:B2 VSS) capacitor c=6.00427e-17
C44 (\3\:Y VSS) capacitor c=1.31257e-16
C45 (\4\:VDD VSS) capacitor c=1.25083e-16
Rk2 (\1\:A1 A1) resistor r=0.09952 c=0
Rk9 (B1 \1\:B1) resistor r=0.08385 c=0
Rk11 (\2\:Y \3\:Y) resistor r=0.4463 c=0
Rk12 (\3\:Y \5\:Y) resistor r=0.5299 c=0
Rk14 (\6\:Y Y) resistor r=0.02126 c=0
Rk15 (\6\:Y \7\:Y) resistor r=0.1544 c=0
Rk13 (\3\:Y \6\:Y) resistor r=0.4542 c=0
Rk26 (\2\:VSS \3\:VSS) resistor r=0.04327 c=0
Rk27 (\3\:VSS \5\:VSS) resistor r=0.6254 c=0
Rk28 (\3\:VSS \6\:VSS) resistor r=0.1242 c=0
Rk30 (\7\:VSS VSS) resistor r=0.0572 c=0
Rk29 (\6\:VSS \7\:VSS) resistor r=0.4935 c=0
Rk31 (\5\:VSS \9\:VSS) resistor r=0.2623 c=0
Rk32 (\7\:VSS \11\:VSS) resistor r=0.2184 c=0
Rk5 (\7\:A2 A2) resistor r=0.005542 c=0
Rk8 (\7\:B2 B2) resistor r=0.02105 c=0
Rk33 (\2\:VDD \3\:VDD) resistor r=0.7518 c=0
Rk37 (\4\:VDD VDD) resistor r=0.1098 c=0
Rk34 (\3\:VDD \4\:VDD) resistor r=0.02988 c=0
Rk39 (\4\:VDD \10\:VDD) resistor r=0.202 c=0
Rl11 (\1\:A1 \6\:A1) resistor r=29.9442 c=0
Rl4 (\1\:A1 \3\:A1) resistor r=33.3841 c=0
Rl24 (\1\:B1 \6\:B1) resistor r=44.9225 c=0
Rl17 (\1\:B1 \3\:B1) resistor r=33.3841 c=0
Rl5 (\2\:A2 \1\:A2) resistor r=32.7557 c=0
Rl7 (\2\:A2 \4\:A2) resistor r=82.1768 c=0
Rl6 (\2\:A2 \3\:A2) resistor r=24.6542 c=0
Rl19 (\3\:B2 \1\:B2) resistor r=24.6542 c=0
Rl22 (\3\:B2 \6\:B2) resistor r=82.1768 c=0
Rl20 (\3\:B2 \4\:B2) resistor r=32.7557 c=0
Rl26 (B0 \6\:B0) resistor r=24.7951 c=0
Rl15 (B0 \3\:B0) resistor r=29.5379 c=0
Rl13 (A0 \6\:A0) resistor r=29.5379 c=0
Rl1 (A0 \1\:A0) resistor r=29.8412 c=0
Rz1 (\2\:Y \1\:Y) resistor r=75 c=0
Rz2 (\5\:Y \4\:Y) resistor r=75 c=0
Rz3 (\1\:VSS \2\:VSS) resistor r=75 c=0
Rz4 (\8\:VSS \9\:VSS) resistor r=75 c=0
Rz5 (\10\:VSS \11\:VSS) resistor r=75 c=0
Rz6 (\2\:VDD \1\:VDD) resistor r=25 c=0
Rz7 (\3\:VDD \1\:VDD) resistor r=6.25 c=0
Ry2 (\7\:Y \9\:Y) resistor r=62 c=0
Ry11 (\4\:VSS \5\:VSS) resistor r=20.6667 c=0
Ry12 (\4\:VSS \6\:VSS) resistor r=5.1667 c=0
Ry14 (\10\:VDD \9\:VDD) resistor r=62 c=0
Rx3 (\7\:A2 \3\:A2) resistor r=45 c=0
Rx6 (\7\:B2 \1\:B2) resistor r=45 c=0
mn0_1__rcx (11 \1\:A0 \10\:VSS VSS) g45n1svt w=(2.6e-07) l=4.5e-08 nf=1 \
        as=3.64e-14 ad=1.56e-14 ps=8e-07 pd=6.4e-07 nrd=1.16667 \
        nrs=1.16667 sa=1.4e-07 sb=2e-06 sd=160n sca=10.3222 scb=0.00938145 \
        scc=0.000353946 m=(1)
mn1_1__rcx (11 \3\:A1 12 VSS) g45n1svt w=(2.6e-07) l=4.5e-08 nf=1 \
        as=5.59e-14 ad=1.56e-14 ps=9.5e-07 pd=6.4e-07 nrd=1.16667 \
        nrs=1.16667 sa=2.45e-07 sb=2e-06 sd=160n sca=10.3222 \
        scb=0.00938145 scc=0.000353946 m=(1)
mn2_1__rcx (\4\:Y \4\:A2 12 VSS) g45n1svt w=(2.6e-07) l=4.5e-08 nf=1 \
        as=5.59e-14 ad=4.16e-14 ps=9.5e-07 pd=8.4e-07 nrd=1.16667 \
        nrs=1.16667 sa=5.05e-07 sb=2e-06 sd=160n sca=10.3222 \
        scb=0.00938145 scc=0.000353946 m=(1)
mn2 (\4\:Y \1\:A2 13 VSS) g45n1svt w=(2.6e-07) l=4.5e-08 nf=1 as=1.56e-14 \
        ad=4.16e-14 ps=6.4e-07 pd=8.4e-07 nrd=1.16667 nrs=1.16667 \
        sa=7.1e-07 sb=1.865e-06 sd=160n sca=10.3222 scb=0.00938145 \
        scc=0.000353946 m=(1)
mn1 (13 \6\:A1 14 VSS) g45n1svt w=(2.6e-07) l=4.5e-08 nf=1 as=6.5e-14 \
        ad=1.56e-14 ps=1.02e-06 pd=6.4e-07 nrd=1.16667 nrs=1.16667 \
        sa=8.15e-07 sb=1.76e-06 sd=160n sca=10.3222 scb=0.00938145 \
        scc=0.000353946 m=(1)
mn0 (14 \6\:A0 \1\:VSS VSS) g45n1svt w=(2.6e-07) l=4.5e-08 nf=1 \
        as=1.05e-13 ad=6.5e-14 ps=1.57e-06 pd=1.02e-06 nrd=1.16667 \
        nrs=1.16667 sa=1.11e-06 sb=1.465e-06 sd=160n sca=10.3222 \
        scb=0.00938145 scc=0.000353946 m=(1)
mn3_1__rcx (15 \3\:B0 \1\:VSS VSS) g45n1svt w=(2.6e-07) l=4.5e-08 nf=1 \
        as=1.05e-13 ad=4.29e-14 ps=1.57e-06 pd=8.5e-07 nrd=1.16667 \
        nrs=1.16667 sa=1.455e-06 sb=1.12e-06 sd=160n sca=10.3222 \
        scb=0.00938145 scc=0.000353946 m=(1)
mn4_1__rcx (15 \3\:B1 16 VSS) g45n1svt w=(2.6e-07) l=4.5e-08 nf=1 \
        as=2.99e-14 ad=4.29e-14 ps=7.5e-07 pd=8.5e-07 nrd=1.16667 \
        nrs=1.16667 sa=1.665e-06 sb=9.1e-07 sd=160n sca=10.3222 \
        scb=0.00938145 scc=0.000353946 m=(1)
mn5_1__rcx (\1\:Y \4\:B2 16 VSS) g45n1svt w=(2.6e-07) l=4.5e-08 nf=1 \
        as=2.99e-14 ad=4.16e-14 ps=7.5e-07 pd=8.4e-07 nrd=1.16667 \
        nrs=1.16667 sa=1.825e-06 sb=7.5e-07 sd=160n sca=10.3222 \
        scb=0.00938145 scc=0.000353946 m=(1)
mn5 (\1\:Y \6\:B2 17 VSS) g45n1svt w=(2.6e-07) l=4.5e-08 nf=1 as=6.11e-14 \
        ad=4.16e-14 ps=9.9e-07 pd=8.4e-07 nrd=1.16667 nrs=1.16667 sa=2e-06 \
        sb=5.45e-07 sd=160n sca=10.3222 scb=0.00938145 scc=0.000353946 \
        m=(1)
mn4 (17 \6\:B1 18 VSS) g45n1svt w=(2.6e-07) l=4.5e-08 nf=1 as=2.08e-14 \
        ad=6.11e-14 ps=6.8e-07 pd=9.9e-07 nrd=1.16667 nrs=1.16667 sa=2e-06 \
        sb=2.65e-07 sd=160n sca=10.3222 scb=0.00938145 scc=0.000353946 \
        m=(1)
mn3 (18 \6\:B0 \8\:VSS VSS) g45n1svt w=(2.6e-07) l=4.5e-08 nf=1 \
        as=3.64e-14 ad=2.08e-14 ps=8e-07 pd=6.8e-07 nrd=1.16667 \
        nrs=1.16667 sa=2e-06 sb=1.4e-07 sd=160n sca=10.3222 scb=0.00938145 \
        scc=0.000353946 m=(1)
ends AOI33X2
// End of subcircuit definition.
