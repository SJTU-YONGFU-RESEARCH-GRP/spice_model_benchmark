// Generated for: spectre (May  1 08:12:11 2013 )
// Library name: gsclib045
// Cell name: RDFFNSRQX1
// View name: extracted

simulator lang=spectre

subckt RDFFNSRQX1 CKN D ExtVDD Q RN RT SN VDD VSS
mp20 (\21\:CKNb \4\:CKN \23\:VDD VDD) g45p1svt w=(2.15e-07) l=4.5e-08 \
        nf=1 as=3.01e-14 ad=3.44e-14 ps=7.1e-07 pd=7.5e-07 nrd=1.16667 \
        nrs=1.16667 sa=3.45e-07 sb=1.4e-07 sd=160n sca=14.7851 \
        scb=0.0152025 scc=0.00103799 m=(1)
mp21 (\13\:CKNbb \5\:CKNb \23\:VDD VDD) g45p1svt w=(2.15e-07) l=4.5e-08 \
        nf=1 as=3.44e-14 ad=3.01e-14 ps=7.5e-07 pd=7.1e-07 nrd=1.16667 \
        nrs=1.16667 sa=1.4e-07 sb=3.45e-07 sd=160n sca=14.7851 \
        scb=0.0152025 scc=0.00103799 m=(1)
mp25 (n22 \3\:D \13\:VDD VDD) g45p1svt w=(2.15e-07) l=4.5e-08 nf=1 \
        as=3.01e-14 ad=1.29e-14 ps=7.1e-07 pd=5.5e-07 nrd=1.16667 \
        nrs=1.16667 sa=1.4e-07 sb=2.45e-07 sd=160n sca=20.3407 \
        scb=0.022946 scc=0.00119484 m=(1)
mp26 (\16\:n20 \3\:CKNb n22 VDD) g45p1svt w=(2.15e-07) l=4.5e-08 nf=1 \
        as=1.29e-14 ad=3.01e-14 ps=5.5e-07 pd=7.1e-07 nrd=1.16667 \
        nrs=1.16667 sa=2.45e-07 sb=1.4e-07 sd=160n sca=17.8768 \
        scb=0.0186195 scc=0.00106238 m=(1)
mp36 (\8\:n20 \4\:CKNbb n31 VDD) g45p1svt w=(2.15e-07) l=4.5e-08 nf=1 \
        as=1.29e-14 ad=3.01e-14 ps=5.5e-07 pd=7.1e-07 nrd=1.16667 \
        nrs=1.16667 sa=1.4e-07 sb=4.5e-07 sd=160n sca=6.79882 \
        scb=0.00278203 scc=1.42286e-05 m=(1)
mp35 (n31 mout \25\:VDD VDD) g45p1svt w=(2.15e-07) l=4.5e-08 nf=1 \
        as=3.44e-14 ad=1.29e-14 ps=7.5e-07 pd=5.5e-07 nrd=1.16667 \
        nrs=1.16667 sa=2.45e-07 sb=3.45e-07 sd=160n sca=6.42122 \
        scb=0.00257522 scc=1.4095e-05 m=(1)
mp30 (\16\:mout \1\:SN \25\:VDD VDD) g45p1svt w=(2.15e-07) l=4.5e-08 \
        nf=1 as=3.44e-14 ad=3.01e-14 ps=7.5e-07 pd=7.1e-07 nrd=1.16667 \
        nrs=1.16667 sa=4.5e-07 sb=1.4e-07 sd=160n sca=6.07861 \
        scb=0.00247604 scc=1.40748e-05 m=(1)
mp32 (\19\:mout \3\:n20 net402 VDD) g45p1svt w=(2.15e-07) l=4.5e-08 nf=1 \
        as=1.29e-14 ad=3.01e-14 ps=5.5e-07 pd=7.1e-07 nrd=1.16667 \
        nrs=1.16667 sa=1.4e-07 sb=2.45e-07 sd=160n sca=6.79882 \
        scb=0.00278203 scc=1.42286e-05 m=(1)
mp31 (net402 \7\:RNb \19\:VDD VDD) g45p1svt w=(2.15e-07) l=4.5e-08 nf=1 \
        as=3.01e-14 ad=1.29e-14 ps=7.1e-07 pd=5.5e-07 nrd=1.16667 \
        nrs=1.16667 sa=2.45e-07 sb=1.4e-07 sd=160n sca=7.36861 \
        scb=0.00328614 scc=1.51674e-05 m=(1)
mp22 (\13\:RNb \4\:RN \21\:VDD VDD) g45p1svt w=(2.15e-07) l=4.5e-08 nf=1 \
        as=3.01e-14 ad=3.01e-14 ps=7.1e-07 pd=7.1e-07 nrd=1.16667 \
        nrs=1.16667 sa=1.4e-07 sb=1.4e-07 sd=160n sca=15.0221 scb=0.014826 \
        scc=0.000817388 m=(1)
mp40 (\4\:n35 \5\:CKNbb \5\:mout VDD) g45p1svt w=(2.15e-07) l=4.5e-08 \
        nf=1 as=3.01e-14 ad=3.01e-14 ps=7.1e-07 pd=7.1e-07 nrd=1.16667 \
        nrs=1.16667 sa=1.4e-07 sb=1.4e-07 sd=160n sca=25.5298 \
        scb=0.0265038 scc=0.00266093 m=(1)
PM0 (\6\:n35g \5\:RT \9\:n35 ExtVDD) g45p1svt w=(2.15e-07) l=4.5e-08 nf=1 \
        as=3.01e-14 ad=3.01e-14 ps=7.1e-07 pd=7.1e-07 nrd=1.16667 \
        nrs=1.16667 sa=1.4e-07 sb=1.4e-07 sd=160n sca=26.0836 \
        scb=0.0271848 scc=0.00267095 m=(1)
PM1 (\14\:qbint \3\:n35g \1\:ExtVDD ExtVDD) g45p1svt w=(2.15e-07) \
        l=4.5e-08 nf=1 as=3.5882e-13 ad=3.01e-14 ps=3.6e-06 pd=7.1e-07 \
        nrd=1.16667 nrs=1.16667 sa=1.4e-07 sb=8.7e-07 sd=160n sca=25.2796 \
        scb=0.0259458 scc=0.00265434 m=(1)
PM2 (net205 \4\:qbint \1\:ExtVDD ExtVDD) g45p1svt w=(2.15e-07) l=4.5e-08 \
        nf=1 as=3.5882e-13 ad=1.29e-14 ps=3.6e-06 pd=5.5e-07 nrd=1.16667 \
        nrs=1.16667 sa=7.65e-07 sb=2.45e-07 sd=160n sca=14.5295 \
        scb=0.0144143 scc=0.000486924 m=(1)
mp45 (\6\:RTb \6\:RT \1\:ExtVDD ExtVDD) g45p1svt w=(2.15e-07) l=4.5e-08 \
        nf=1 as=3.5882e-13 ad=3.01e-14 ps=3.6e-06 pd=7.1e-07 nrd=1.16667 \
        nrs=1.16667 sa=3.3e-07 sb=1.4e-07 sd=160n sca=24.3731 \
        scb=0.0258873 scc=0.00229004 m=(1)
PM3 (\15\:n35g \4\:RTb net205 ExtVDD) g45p1svt w=(2.15e-07) l=4.5e-08 \
        nf=1 as=1.29e-14 ad=3.01e-14 ps=5.5e-07 pd=7.1e-07 nrd=1.16667 \
        nrs=1.16667 sa=8.7e-07 sb=1.4e-07 sd=160n sca=25.2796 \
        scb=0.0259458 scc=0.00265434 m=(1)
mp53 (\14\:n35 \13\:CKNb \3\:n41 VDD) g45p1svt w=(2.15e-07) l=4.5e-08 \
        nf=1 as=3.01e-14 ad=3.01e-14 ps=7.1e-07 pd=7.1e-07 nrd=1.16667 \
        nrs=1.16667 sa=1.4e-07 sb=1.4e-07 sd=160n sca=28.3325 \
        scb=0.0311878 scc=0.00281308 m=(1)
mp51 (n43 \4\:RNb \17\:VDD VDD) g45p1svt w=(2.15e-07) l=4.5e-08 nf=1 \
        as=3.01e-14 ad=1.29e-14 ps=7.1e-07 pd=5.5e-07 nrd=1.16667 \
        nrs=1.16667 sa=1.4e-07 sb=4.5e-07 sd=160n sca=11.272 \
        scb=0.00858882 scc=0.000167946 m=(1)
mp52 (n41 \10\:qbint n43 VDD) g45p1svt w=(2.15e-07) l=4.5e-08 nf=1 \
        as=1.29e-14 ad=3.44e-14 ps=5.5e-07 pd=7.5e-07 nrd=1.16667 \
        nrs=1.16667 sa=2.45e-07 sb=3.45e-07 sd=160n sca=11.4972 \
        scb=0.00902054 scc=0.000170728 m=(1)
mp50 (n41 \7\:SN \1\:VDD VDD) g45p1svt w=(2.15e-07) l=4.5e-08 nf=1 \
        as=3.01e-14 ad=3.44e-14 ps=7.1e-07 pd=7.5e-07 nrd=1.16667 \
        nrs=1.16667 sa=4.5e-07 sb=1.4e-07 sd=160n sca=14.6968 \
        scb=0.0152164 scc=0.000337347 m=(1)
C1 (RN VSS) capacitor c=3.49439e-17
C2 (RT VSS) capacitor c=4.05224e-17
C3 (SN VSS) capacitor c=4.12252e-17
C4 (D VSS) capacitor c=4.53043e-17
C5 (VDD VSS) capacitor c=6.76778e-16
C6 (Q VSS) capacitor c=3.67286e-17
C7 (CKN VSS) capacitor c=3.85167e-17
C8 (ExtVDD VSS) capacitor c=1.93965e-16
C9 (CKNb VSS) capacitor c=4.77715e-17
C10 (mout VSS) capacitor c=5.37899e-17
C11 (n20 VSS) capacitor c=8.3384e-17
C12 (RNb VSS) capacitor c=3.88111e-17
C13 (CKNbb VSS) capacitor c=5.23616e-17
C14 (n35g VSS) capacitor c=1.81021e-17
C15 (qbint VSS) capacitor c=4.5129e-17
C16 (RTb VSS) capacitor c=5.18542e-17
C17 (n35 VSS) capacitor c=1.72095e-16
C18 (n41 VSS) capacitor c=8.4668e-17
C19 (n42 VSS) capacitor c=7.9641e-17
C20 (n40 VSS) capacitor c=8.4714e-17
C21 (net426 VSS) capacitor c=8.72419e-17
C22 (\7\:SN VSS) capacitor c=7.07664e-17
C23 (\7\:qbint VSS) capacitor c=3.86494e-17
C24 (\10\:qbint VSS) capacitor c=1.41875e-16
C25 (\4\:RNb VSS) capacitor c=3.14159e-16
C26 (\13\:CKNb VSS) capacitor c=5.93608e-17
C27 (\4\:RTb VSS) capacitor c=9.90503e-17
C28 (\6\:RT VSS) capacitor c=2.27886e-17
C29 (\4\:qbint VSS) capacitor c=5.41936e-17
C30 (\3\:n35g VSS) capacitor c=6.31299e-17
C31 (\5\:RT VSS) capacitor c=8.5787e-17
C32 (\5\:CKNbb VSS) capacitor c=1.17104e-16
C33 (\4\:RN VSS) capacitor c=3.25002e-17
C34 (\7\:RNb VSS) capacitor c=6.93875e-17
C35 (\3\:n20 VSS) capacitor c=4.64244e-17
C36 (\4\:CKN VSS) capacitor c=5.56484e-17
C37 (\1\:SN VSS) capacitor c=2.99249e-17
C38 (\5\:CKNb VSS) capacitor c=3.12642e-17
C39 (\4\:CKNbb VSS) capacitor c=8.70164e-17
C40 (\3\:CKNb VSS) capacitor c=1.65173e-16
C41 (\3\:D VSS) capacitor c=5.60323e-17
C42 (\8\:SN VSS) capacitor c=1.342e-16
C43 (\6\:qbint VSS) capacitor c=4.18446e-17
C44 (\11\:qbint VSS) capacitor c=8.09839e-17
C45 (\3\:RNb VSS) capacitor c=6.84518e-17
C46 (\7\:CKNbb VSS) capacitor c=2.24387e-16
C47 (\8\:RT VSS) capacitor c=1.22307e-16
C48 (\2\:RT VSS) capacitor c=6.24665e-17
C49 (\5\:qbint VSS) capacitor c=3.87746e-17
C50 (\5\:n35g VSS) capacitor c=2.76477e-17
C51 (\2\:RTb VSS) capacitor c=4.95977e-17
C52 (\7\:CKNb VSS) capacitor c=3.28382e-17
C53 (\1\:RN VSS) capacitor c=3.57238e-17
C54 (\6\:n20 VSS) capacitor c=6.17351e-17
C55 (\6\:SN VSS) capacitor c=4.7386e-17
C56 (\1\:CKN VSS) capacitor c=2.85199e-17
C57 (\3\:mout VSS) capacitor c=4.58549e-17
C58 (\12\:CKNb VSS) capacitor c=4.97927e-17
C59 (\2\:CKNbb VSS) capacitor c=8.19093e-17
C60 (\1\:D VSS) capacitor c=6.60532e-17
C61 (\9\:qbint VSS) capacitor c=9.32195e-17
C62 (\14\:CKNb VSS) capacitor c=8.1803e-17
C63 (\3\:SN VSS) capacitor c=3.75458e-16
C64 (\9\:SN VSS) capacitor c=9.19241e-17
C65 (\7\:RT VSS) capacitor c=1.5907e-16
C66 (\11\:CKNb VSS) capacitor c=1.67893e-16
C67 (\3\:RTb VSS) capacitor c=7.95914e-17
C68 (\3\:RT VSS) capacitor c=5.60515e-17
C69 (\1\:RT VSS) capacitor c=5.31416e-17
C70 (\3\:qbint VSS) capacitor c=4.40973e-17
C71 (\2\:n35 VSS) capacitor c=2.52666e-16
C72 (\4\:n35g VSS) capacitor c=7.14509e-17
C73 (\6\:CKNbb VSS) capacitor c=5.38762e-17
C74 (\8\:CKNbb VSS) capacitor c=2.18316e-16
C75 (\3\:n35 VSS) capacitor c=1.15997e-16
C76 (\2\:RNb VSS) capacitor c=3.49956e-17
C77 (\9\:RNb VSS) capacitor c=1.06902e-17
C78 (\8\:RNb VSS) capacitor c=8.82523e-17
C79 (\7\:n20 VSS) capacitor c=5.42065e-17
C80 (\3\:RN VSS) capacitor c=5.04616e-17
C81 (\4\:n20 VSS) capacitor c=9.47513e-17
C82 (\3\:CKN VSS) capacitor c=2.32639e-17
C83 (\2\:SN VSS) capacitor c=4.19192e-17
C84 (\5\:SN VSS) capacitor c=2.03023e-17
C85 (\6\:CKNb VSS) capacitor c=2.2872e-17
C86 (\3\:CKNbb VSS) capacitor c=1.23769e-16
C87 (\2\:mout VSS) capacitor c=4.70867e-17
C88 (\4\:mout VSS) capacitor c=3.16305e-17
C89 (\5\:n20 VSS) capacitor c=7.72297e-17
C90 (\2\:n20 VSS) capacitor c=7.16658e-17
C91 (\4\:CKNb VSS) capacitor c=8.29647e-17
C92 (\10\:CKNb VSS) capacitor c=3.21371e-17
C93 (\2\:D VSS) capacitor c=5.32683e-17
C94 (\1\:VDD VSS) capacitor c=3.00372e-17
C95 (\15\:VDD VSS) capacitor c=4.73411e-17
C96 (\3\:Q VSS) capacitor c=5.31824e-17
C97 (\17\:VDD VSS) capacitor c=4.97525e-17
C98 (\3\:n41 VSS) capacitor c=9.86843e-17
C99 (\14\:n35 VSS) capacitor c=5.32074e-17
C100 (\15\:n35g VSS) capacitor c=5.75592e-17
C101 (\6\:RTb VSS) capacitor c=7.31692e-17
C102 (\1\:ExtVDD VSS) capacitor c=2.78332e-16
C103 (\9\:n35 VSS) capacitor c=6.17939e-17
C104 (\14\:qbint VSS) capacitor c=6.71048e-17
C105 (\6\:n35g VSS) capacitor c=9.14819e-17
C106 (\4\:n35 VSS) capacitor c=6.9148e-17
C107 (\5\:mout VSS) capacitor c=1.2787e-16
C108 (\13\:RNb VSS) capacitor c=2.66676e-17
C109 (\19\:VDD VSS) capacitor c=4.32936e-17
C110 (\21\:VDD VSS) capacitor c=5.18481e-17
C111 (\19\:mout VSS) capacitor c=3.6725e-17
C112 (\21\:CKNb VSS) capacitor c=4.71204e-17
C113 (\16\:mout VSS) capacitor c=4.35465e-17
C114 (\23\:VDD VSS) capacitor c=6.44006e-17
C115 (\25\:VDD VSS) capacitor c=4.92715e-17
C116 (\13\:CKNbb VSS) capacitor c=5.20149e-17
C117 (\8\:n20 VSS) capacitor c=4.10985e-17
C118 (\16\:n20 VSS) capacitor c=6.43097e-17
C119 (\13\:VDD VSS) capacitor c=4.45717e-17
C120 (\1\:Q VSS) capacitor c=3.75243e-17
C121 (\3\:n42 VSS) capacitor c=8.11087e-17
C122 (\3\:n40 VSS) capacitor c=7.8716e-17
C123 (\17\:n35 VSS) capacitor c=4.83257e-17
C124 (\11\:n35g VSS) capacitor c=2.62819e-17
C125 (\10\:RTb VSS) capacitor c=5.82842e-17
C126 (\12\:n35 VSS) capacitor c=6.35994e-17
C127 (\16\:qbint VSS) capacitor c=2.27723e-17
C128 (\9\:n35g VSS) capacitor c=8.02839e-17
C129 (\7\:n35 VSS) capacitor c=4.90555e-17
C130 (\11\:mout VSS) capacitor c=3.72589e-17
C131 (\10\:RNb VSS) capacitor c=4.13569e-17
C132 (\13\:mout VSS) capacitor c=3.83153e-17
C133 (\3\:net426 VSS) capacitor c=1.00658e-16
C134 (\17\:CKNb VSS) capacitor c=6.02557e-17
C135 (\9\:CKNbb VSS) capacitor c=3.47244e-17
C136 (\12\:n20 VSS) capacitor c=6.63607e-17
C137 (\14\:n20 VSS) capacitor c=5.8713e-17
C138 (\2\:CKNb VSS) capacitor c=7.22134e-17
C139 (\2\:CKN VSS) capacitor c=3.4518e-17
C140 (VDD VSS) capacitor c=2.40791e-16
C141 (\2\:n35g VSS) capacitor c=3.35493e-17
C142 (ExtVDD VSS) capacitor c=3.93333e-17
C143 (\4\:RT VSS) capacitor c=7.57031e-17
C144 (\2\:qbint VSS) capacitor c=4.13898e-17
C145 (\8\:CKNb VSS) capacitor c=1.373e-16
C146 (\9\:CKNb VSS) capacitor c=7.7833e-17
C147 (\4\:SN VSS) capacitor c=3.39868e-16
C148 (\5\:RNb VSS) capacitor c=5.22866e-16
C149 (\6\:RNb VSS) capacitor c=1.20805e-16
C150 (\15\:CKNb VSS) capacitor c=6.36827e-17
C151 (\16\:CKNb VSS) capacitor c=7.35128e-17
C152 (\8\:qbint VSS) capacitor c=1.07542e-16
C153 (\10\:n20 VSS) capacitor c=2.98554e-17
C154 (\11\:n20 VSS) capacitor c=6.92235e-17
C155 (\18\:n20 VSS) capacitor c=3.71535e-17
C156 (\12\:CKNbb VSS) capacitor c=7.80767e-17
C157 (\15\:CKNbb VSS) capacitor c=5.06155e-17
C158 (\10\:SN VSS) capacitor c=4.02291e-17
C159 (\11\:SN VSS) capacitor c=4.48545e-17
C160 (\5\:CKN VSS) capacitor c=5.83031e-18
C161 (\6\:CKN VSS) capacitor c=3.37627e-17
C162 (\19\:CKNb VSS) capacitor c=6.51813e-17
C163 (\20\:CKNb VSS) capacitor c=4.74519e-17
C164 (\5\:RN VSS) capacitor c=3.68928e-17
C165 (\19\:n20 VSS) capacitor c=8.20287e-17
C166 (\20\:n20 VSS) capacitor c=7.97179e-17
C167 (\12\:RNb VSS) capacitor c=5.58496e-17
C168 (\15\:RNb VSS) capacitor c=7.17668e-17
C169 (\16\:RNb VSS) capacitor c=8.30407e-17
C170 (\7\:mout VSS) capacitor c=1.56448e-16
C171 (\8\:mout VSS) capacitor c=5.30172e-17
C172 (\9\:mout VSS) capacitor c=1.07075e-16
C173 (\10\:mout VSS) capacitor c=8.52178e-17
C174 (\15\:mout VSS) capacitor c=6.17414e-17
C175 (\18\:mout VSS) capacitor c=7.29672e-17
C176 (\6\:n35 VSS) capacitor c=1.07027e-16
C177 (\16\:CKNbb VSS) capacitor c=3.95005e-17
C178 (\17\:CKNbb VSS) capacitor c=4.14738e-17
C179 (\8\:n35g VSS) capacitor c=3.22942e-17
C180 (\11\:n35 VSS) capacitor c=7.56753e-17
C181 (\12\:qbint VSS) capacitor c=8.78238e-17
C182 (\13\:qbint VSS) capacitor c=1.08917e-16
C183 (\13\:n35g VSS) capacitor c=1.01787e-16
C184 (\14\:n35g VSS) capacitor c=1.16156e-16
C185 (\5\:RTb VSS) capacitor c=4.68869e-17
C186 (\8\:RTb VSS) capacitor c=1.00504e-16
C187 (\9\:RTb VSS) capacitor c=9.16754e-17
C188 (\12\:SN VSS) capacitor c=8.28002e-17
C189 (\13\:SN VSS) capacitor c=8.05138e-17
C190 (\23\:CKNb VSS) capacitor c=1.33275e-16
C191 (\24\:CKNb VSS) capacitor c=1.34072e-16
C192 (\18\:qbint VSS) capacitor c=1.9284e-17
C193 (\19\:qbint VSS) capacitor c=2.9848e-17
C194 (\9\:RT VSS) capacitor c=5.10577e-17
C195 (\10\:RT VSS) capacitor c=1.05897e-16
C196 (\11\:RT VSS) capacitor c=1.18223e-16
C197 (\16\:n35 VSS) capacitor c=4.78259e-17
C198 (\3\:VDD VSS) capacitor c=3.25349e-17
C199 (\4\:VDD VSS) capacitor c=2.80348e-17
C200 (\6\:VDD VSS) capacitor c=1.23155e-16
C201 (\7\:VDD VSS) capacitor c=6.07873e-17
C202 (\8\:VDD VSS) capacitor c=2.35705e-17
C203 (\10\:VDD VSS) capacitor c=2.5853e-17
C204 (\11\:VDD VSS) capacitor c=2.99371e-17
C205 (\12\:VDD VSS) capacitor c=3.38301e-17
Rk21 (\5\:RN RN) resistor r=0.03815 c=0
Rk62 (RT \9\:RT) resistor r=0.06666 c=0
Rk63 (\9\:RT \10\:RT) resistor r=0.2241 c=0
Rk64 (\10\:RT \11\:RT) resistor r=0.6461 c=0
Rk12 (SN \10\:SN) resistor r=0.01187 c=0
Rk13 (\10\:SN \11\:SN) resistor r=0.3244 c=0
Rk59 (\12\:SN \13\:SN) resistor r=0.5357 c=0
Rk2 (\4\:D D) resistor r=0.006855 c=0
Rk80 (\2\:VDD \3\:VDD) resistor r=0.3366 c=0
Rk81 (\3\:VDD \4\:VDD) resistor r=0.2178 c=0
Rk83 (\6\:VDD VDD) resistor r=1.0549 c=0
Rk82 (\4\:VDD \6\:VDD) resistor r=0.06676 c=0
Rk84 (VDD \7\:VDD) resistor r=0.6386 c=0
Rk85 (\7\:VDD \8\:VDD) resistor r=0.08888 c=0
Rk86 (\8\:VDD \10\:VDD) resistor r=0.1312 c=0
Rk87 (\10\:VDD \11\:VDD) resistor r=0.08907 c=0
Rk89 (\12\:VDD VDD) resistor r=0.1955 c=0
Rk88 (\11\:VDD \12\:VDD) resistor r=0.08144 c=0
Rk90 (VDD \14\:VDD) resistor r=0.5113 c=0
Rk91 (\3\:VDD \16\:VDD) resistor r=0.3564 c=0
Rk92 (\4\:VDD \18\:VDD) resistor r=0.2927 c=0
Rk93 (\7\:VDD \20\:VDD) resistor r=0.2015 c=0
Rk94 (\8\:VDD \22\:VDD) resistor r=0.359 c=0
Rk95 (\11\:VDD \24\:VDD) resistor r=0.4032 c=0
Rk96 (\12\:VDD \26\:VDD) resistor r=0.2069 c=0
Rk68 (\2\:Q Q) resistor r=0.1703 c=0
Rk69 (Q \4\:Q) resistor r=0.2987 c=0
Rk72 (\2\:VSS \4\:VSS) resistor r=0.4654 c=0
Rk73 (\4\:VSS \5\:VSS) resistor r=0.8135 c=0
Rk75 (\6\:VSS VSS) resistor r=0.2973 c=0
Rk74 (\5\:VSS \6\:VSS) resistor r=0.07916 c=0
Rk77 (\7\:VSS VSS) resistor r=0.1213 c=0
Rk76 (VSS \7\:VSS) resistor r=0.8929 c=0
Rk78 (\5\:VSS \9\:VSS) resistor r=0.2434 c=0
Rk79 (VSS \11\:VSS) resistor r=0.3081 c=0
Rk97 (\13\:VSS \15\:VSS) resistor r=0.4109 c=0
Rk98 (\15\:VSS \16\:VSS) resistor r=0.8603 c=0
Rk99 (\16\:VSS \17\:VSS) resistor r=0.03204 c=0
Rk101 (\18\:VSS VSS) resistor r=0.1211 c=0
Rk100 (\17\:VSS \18\:VSS) resistor r=0.1759 c=0
Rk102 (VSS \19\:VSS) resistor r=0.7291 c=0
Rk104 (\20\:VSS VSS) resistor r=0.01959 c=0
Rk103 (\19\:VSS \20\:VSS) resistor r=0.1635 c=0
Rk105 (VSS \21\:VSS) resistor r=0.03725 c=0
Rk106 (\21\:VSS \23\:VSS) resistor r=0.6579 c=0
Rk107 (\16\:VSS \25\:VSS) resistor r=0.1891 c=0
Rk108 (\18\:VSS \27\:VSS) resistor r=0.1942 c=0
Rk109 (\19\:VSS \29\:VSS) resistor r=0.2359 c=0
Rk110 (\21\:VSS \31\:VSS) resistor r=0.2364 c=0
Rk14 (CKN \5\:CKN) resistor r=0.002227 c=0
Rk17 (\5\:CKN \6\:CKN) resistor r=0.01545 c=0
Rk16 (\6\:CKN \7\:CKN) resistor r=0.00544 c=0
Rk46 (ExtVDD ExtVDD) resistor r=0.002061 c=0
Rk44 (\2\:ExtVDD ExtVDD) resistor r=0.02215 c=0
Rk47 (ExtVDD \5\:ExtVDD) resistor r=0.02014 c=0
Rk48 (ExtVDD \6\:ExtVDD) resistor r=0.1056 c=0
Rk1 (\15\:CKNb \16\:CKNb) resistor r=0.6841 c=0
Rk18 (\18\:CKNb \19\:CKNb) resistor r=0.3405 c=0
Rk19 (\19\:CKNb \20\:CKNb) resistor r=0.1632 c=0
Rk20 (\19\:CKNb \22\:CKNb) resistor r=0.2066 c=0
Rk60 (\23\:CKNb \24\:CKNb) resistor r=0.8226 c=0
Rk27 (\6\:mout \7\:mout) resistor r=0.7619 c=0
Rk28 (\7\:mout \8\:mout) resistor r=0.3523 c=0
Rk29 (\8\:mout \9\:mout) resistor r=0.1709 c=0
Rk30 (\9\:mout \10\:mout) resistor r=0.3404 c=0
Rk31 (\7\:mout \12\:mout) resistor r=0.1231 c=0
Rk32 (\8\:mout \14\:mout) resistor r=0.09956 c=0
Rk33 (\9\:mout \15\:mout) resistor r=0.5241 c=0
Rk34 (\15\:mout \17\:mout) resistor r=0.04481 c=0
Rk35 (\10\:mout \18\:mout) resistor r=0.425 c=0
Rk36 (\15\:mout \20\:mout) resistor r=0.03462 c=0
Rk3 (\9\:n20 \10\:n20) resistor r=0.2067 c=0
Rk4 (\9\:n20 \11\:n20) resistor r=0.2104 c=0
Rk5 (\11\:n20 \13\:n20) resistor r=0.4456 c=0
Rk6 (\15\:n20 \17\:n20) resistor r=0.4887 c=0
Rk7 (\17\:n20 \18\:n20) resistor r=0.1577 c=0
Rk22 (\19\:n20 \20\:n20) resistor r=0.4615 c=0
Rk24 (\11\:RNb \12\:RNb) resistor r=0.3447 c=0
Rk25 (\12\:RNb \14\:RNb) resistor r=0.1482 c=0
Rk26 (\15\:RNb \16\:RNb) resistor r=0.3465 c=0
Rk8 (\10\:CKNbb \11\:CKNbb) resistor r=0.2129 c=0
Rk9 (\11\:CKNbb \12\:CKNbb) resistor r=0.01514 c=0
Rk10 (\11\:CKNbb \14\:CKNbb) resistor r=0.3382 c=0
Rk11 (\14\:CKNbb \15\:CKNbb) resistor r=0.2715 c=0
Rk39 (\16\:CKNbb \17\:CKNbb) resistor r=0.3681 c=0
Rk40 (\7\:n35g \8\:n35g) resistor r=0.2407 c=0
Rk41 (\7\:n35g \10\:n35g) resistor r=0.6914 c=0
Rk52 (\12\:n35g \13\:n35g) resistor r=0.2429 c=0
Rk53 (\13\:n35g \14\:n35g) resistor r=0.5654 c=0
Rk54 (\13\:n35g \16\:n35g) resistor r=0.4319 c=0
Rk49 (\12\:qbint \13\:qbint) resistor r=0.4944 c=0
Rk50 (\13\:qbint \15\:qbint) resistor r=0.567 c=0
Rk51 (\13\:qbint \17\:qbint) resistor r=0.1463 c=0
Rk61 (\18\:qbint \19\:qbint) resistor r=0.2118 c=0
Rk55 (\5\:RTb \7\:RTb) resistor r=0.2224 c=0
Rk56 (\7\:RTb \8\:RTb) resistor r=0.4165 c=0
Rk57 (\8\:RTb \9\:RTb) resistor r=0.6885 c=0
Rk58 (\8\:RTb \11\:RTb) resistor r=0.3065 c=0
Rk37 (\5\:n35 \6\:n35) resistor r=0.4289 c=0
Rk38 (\6\:n35 \8\:n35) resistor r=0.3027 c=0
Rk42 (\10\:n35 \11\:n35) resistor r=0.4009 c=0
Rk43 (\11\:n35 \13\:n35) resistor r=0.3298 c=0
Rk65 (\15\:n35 \16\:n35) resistor r=0.3037 c=0
Rk66 (\16\:n35 \18\:n35) resistor r=0.2874 c=0
Rk70 (\2\:n41 \4\:n41) resistor r=0.7136 c=0
Rk71 (\2\:n42 \4\:n42) resistor r=0.5301 c=0
Rk67 (\2\:n40 \4\:n40) resistor r=0.6255 c=0
Rk23 (\2\:net426 \4\:net426) resistor r=0.5521 c=0
Rl20 (\2\:RN \4\:RN) resistor r=63.1757 c=0
Rl18 (\1\:RN \2\:RN) resistor r=153.56 c=0
Rl19 (\2\:RN \3\:RN) resistor r=0.5166 c=0
Rl45 (\7\:RT \8\:RT) resistor r=651.902 c=0
Rl31 (\1\:RT \2\:RT) resistor r=169.515 c=0
Rl34 (\4\:RT \6\:RT) resistor r=21.372 c=0
Rl33 (\4\:RT \5\:RT) resistor r=264.027 c=0
Rl32 (\3\:RT \4\:RT) resistor r=96.114 c=0
Rl64 (\7\:SN \8\:SN) resistor r=237.735 c=0
Rl65 (\8\:SN \9\:SN) resistor r=491.014 c=0
Rl12 (\1\:SN \2\:SN) resistor r=24.2328 c=0
Rl48 (\4\:SN \6\:SN) resistor r=95.229 c=0
Rl46 (\3\:SN \4\:SN) resistor r=1129.61 c=0
Rl47 (\4\:SN \5\:SN) resistor r=14.5488 c=0
Rl2 (\2\:D \3\:D) resistor r=41.5405 c=0
Rl1 (\1\:D \2\:D) resistor r=137.096 c=0
Rl15 (\2\:CKN \4\:CKN) resistor r=147.791 c=0
Rl13 (\1\:CKN \2\:CKN) resistor r=63.1757 c=0
Rl14 (\2\:CKN \3\:CKN) resistor r=2.0166 c=0
Rl51 (\13\:CKNb \14\:CKNb) resistor r=166.412 c=0
Rl9 (\3\:CKNb \4\:CKNb) resistor r=349.426 c=0
Rl10 (\2\:CKNb \5\:CKNb) resistor r=59.4618 c=0
Rl8 (\2\:CKNb \3\:CKNb) resistor r=237.282 c=0
Rl7 (CKNb \2\:CKNb) resistor r=147.923 c=0
Rl11 (\2\:CKNb \6\:CKNb) resistor r=4.3228 c=0
Rl40 (\7\:CKNb \8\:CKNb) resistor r=66.1349 c=0
Rl43 (\8\:CKNb \11\:CKNb) resistor r=762.322 c=0
Rl44 (\9\:CKNb \12\:CKNb) resistor r=66.8717 c=0
Rl42 (\9\:CKNb \10\:CKNb) resistor r=132.647 c=0
Rl41 (\8\:CKNb \9\:CKNb) resistor r=465.929 c=0
Rl5 (mout \2\:mout) resistor r=24.2328 c=0
Rl6 (\3\:mout \4\:mout) resistor r=24.2328 c=0
Rl21 (\6\:n20 \7\:n20) resistor r=136.213 c=0
Rl16 (\3\:n20 \4\:n20) resistor r=24.848 c=0
Rl17 (\4\:n20 \5\:n20) resistor r=281.721 c=0
Rl3 (n20 \2\:n20) resistor r=205.495 c=0
Rl53 (\3\:RNb \4\:RNb) resistor r=234.8 c=0
Rl22 (RNb \2\:RNb) resistor r=62.7075 c=0
Rl54 (\4\:RNb \5\:RNb) resistor r=1125.6 c=0
Rl57 (\5\:RNb \8\:RNb) resistor r=775.703 c=0
Rl56 (\6\:RNb \7\:RNb) resistor r=142.538 c=0
Rl58 (\6\:RNb \9\:RNb) resistor r=2.7666 c=0
Rl55 (\5\:RNb \6\:RNb) resistor r=283.029 c=0
Rl25 (\5\:CKNbb \6\:CKNbb) resistor r=163.736 c=0
Rl52 (\7\:CKNbb \8\:CKNbb) resistor r=870.726 c=0
Rl24 (\3\:CKNbb \5\:CKNbb) resistor r=528.767 c=0
Rl23 (\3\:CKNbb \4\:CKNbb) resistor r=188.95 c=0
Rl4 (CKNbb \2\:CKNbb) resistor r=183.837 c=0
Rl28 (\3\:n35g \4\:n35g) resistor r=250.512 c=0
Rl27 (\2\:n35g \3\:n35g) resistor r=181.74 c=0
Rl29 (\2\:n35g \5\:n35g) resistor r=94.1963 c=0
Rl26 (n35g \2\:n35g) resistor r=2.4834 c=0
Rl59 (\6\:qbint \7\:qbint) resistor r=149.805 c=0
Rl63 (\10\:qbint \11\:qbint) resistor r=237.758 c=0
Rl39 (\3\:qbint \5\:qbint) resistor r=35.3072 c=0
Rl38 (\2\:qbint \4\:qbint) resistor r=70.093 c=0
Rl36 (qbint \2\:qbint) resistor r=112.732 c=0
Rl37 (\2\:qbint \3\:qbint) resistor r=152.601 c=0
Rl60 (\7\:qbint \8\:qbint) resistor r=99.804 c=0
Rl62 (\8\:qbint \10\:qbint) resistor r=180.657 c=0
Rl61 (\8\:qbint \9\:qbint) resistor r=494.685 c=0
Rl35 (\3\:RTb \4\:RTb) resistor r=242.811 c=0
Rl30 (RTb \2\:RTb) resistor r=112.412 c=0
Rl49 (n35 \2\:n35) resistor r=508.667 c=0
Rl50 (\2\:n35 \3\:n35) resistor r=334.803 c=0
Rz20 (\1\:Q \2\:Q) resistor r=37.5 c=0
Rz23 (\1\:VSS \2\:VSS) resistor r=75 c=0
Rz24 (\8\:VSS \9\:VSS) resistor r=75 c=0
Rz25 (\10\:VSS \11\:VSS) resistor r=37.5 c=0
Rz28 (\12\:VSS \13\:VSS) resistor r=37.5 c=0
Rz29 (\22\:VSS \23\:VSS) resistor r=75 c=0
Rz30 (\24\:VSS \25\:VSS) resistor r=75 c=0
Rz31 (\26\:VSS \27\:VSS) resistor r=75 c=0
Rz32 (\28\:VSS \29\:VSS) resistor r=75 c=0
Rz33 (\30\:VSS \31\:VSS) resistor r=75 c=0
Rz4 (\17\:CKNb \18\:CKNb) resistor r=75 c=0
Rz8 (\11\:mout \12\:mout) resistor r=75 c=0
Rz9 (\13\:mout \14\:mout) resistor r=75 c=0
Rz1 (\12\:n20 \13\:n20) resistor r=75 c=0
Rz2 (\14\:n20 \15\:n20) resistor r=75 c=0
Rz7 (\10\:RNb \11\:RNb) resistor r=75 c=0
Rz3 (\9\:CKNbb \10\:CKNbb) resistor r=75 c=0
Rz11 (\9\:n35g \10\:n35g) resistor r=75 c=0
Rz15 (\11\:n35g \12\:n35g) resistor r=75 c=0
Rz14 (\16\:qbint \17\:qbint) resistor r=75 c=0
Rz16 (\10\:RTb \11\:RTb) resistor r=75 c=0
Rz10 (\7\:n35 \8\:n35) resistor r=75 c=0
Rz12 (\12\:n35 \13\:n35) resistor r=75 c=0
Rz17 (\17\:n35 \18\:n35) resistor r=75 c=0
Rz21 (n42 \2\:n42) resistor r=75 c=0
Rz22 (\3\:n42 \4\:n42) resistor r=75 c=0
Rz18 (n40 \2\:n40) resistor r=75 c=0
Rz19 (\3\:n40 \4\:n40) resistor r=75 c=0
Rz5 (net426 \2\:net426) resistor r=75 c=0
Rz6 (\3\:net426 \4\:net426) resistor r=75 c=0
Ry25 (\1\:VDD \2\:VDD) resistor r=62 c=0
Ry26 (\13\:VDD \14\:VDD) resistor r=62 c=0
Ry27 (\15\:VDD \16\:VDD) resistor r=20.6667 c=0
Ry28 (\17\:VDD \18\:VDD) resistor r=62 c=0
Ry29 (\19\:VDD \20\:VDD) resistor r=62 c=0
Ry30 (\21\:VDD \22\:VDD) resistor r=62 c=0
Ry31 (\23\:VDD \24\:VDD) resistor r=62 c=0
Ry32 (\25\:VDD \26\:VDD) resistor r=62 c=0
Ry19 (\3\:Q \4\:Q) resistor r=20.6667 c=0
Ry22 (\3\:VSS \4\:VSS) resistor r=10.3333 c=0
Ry23 (\3\:VSS \6\:VSS) resistor r=5.1667 c=0
Ry24 (\3\:VSS \7\:VSS) resistor r=5.1667 c=0
Ry33 (\14\:VSS \15\:VSS) resistor r=10.3333 c=0
Ry34 (\14\:VSS \17\:VSS) resistor r=5.1667 c=0
Ry35 (\14\:VSS \20\:VSS) resistor r=5.1667 c=0
Ry12 (\1\:ExtVDD \2\:ExtVDD) resistor r=62 c=0
Ry13 (\1\:ExtVDD \5\:ExtVDD) resistor r=62 c=0
Ry14 (\1\:ExtVDD \6\:ExtVDD) resistor r=62 c=0
Ry4 (\21\:CKNb \22\:CKNb) resistor r=62 c=0
Ry6 (\5\:mout \6\:mout) resistor r=62 c=0
Ry7 (\16\:mout \17\:mout) resistor r=62 c=0
Ry8 (\19\:mout \20\:mout) resistor r=62 c=0
Ry1 (\8\:n20 \9\:n20) resistor r=62 c=0
Ry2 (\16\:n20 \17\:n20) resistor r=62 c=0
Ry5 (\13\:RNb \14\:RNb) resistor r=62 c=0
Ry3 (\13\:CKNbb \14\:CKNbb) resistor r=62 c=0
Ry10 (\6\:n35g \7\:n35g) resistor r=62 c=0
Ry16 (\15\:n35g \16\:n35g) resistor r=62 c=0
Ry15 (\14\:qbint \15\:qbint) resistor r=62 c=0
Ry17 (\6\:RTb \7\:RTb) resistor r=62 c=0
Ry9 (\4\:n35 \5\:n35) resistor r=62 c=0
Ry11 (\9\:n35 \10\:n35) resistor r=62 c=0
Ry18 (\14\:n35 \15\:n35) resistor r=62 c=0
Ry20 (n41 \2\:n41) resistor r=62 c=0
Ry21 (\3\:n41 \4\:n41) resistor r=62 c=0
Rx13 (\3\:RN \5\:RN) resistor r=45 c=0
Rx36 (\7\:RT \9\:RT) resistor r=45 c=0
Rx37 (\3\:RT \10\:RT) resistor r=45 c=0
Rx38 (\1\:RT \11\:RT) resistor r=45 c=0
Rx9 (\5\:SN \10\:SN) resistor r=45 c=0
Rx10 (\2\:SN \11\:SN) resistor r=45 c=0
Rx30 (\3\:SN \12\:SN) resistor r=45 c=0
Rx31 (\9\:SN \13\:SN) resistor r=45 c=0
Rx3 (\2\:D \4\:D) resistor r=45 c=0
Rx11 (\3\:CKN \7\:CKN) resistor r=45 c=0
Rx1 (\4\:CKNb \15\:CKNb) resistor r=45 c=0
Rx2 (\10\:CKNb \16\:CKNb) resistor r=45 c=0
Rx12 (\6\:CKNb \20\:CKNb) resistor r=45 c=0
Rx32 (\14\:CKNb \23\:CKNb) resistor r=45 c=0
Rx33 (\11\:CKNb \24\:CKNb) resistor r=45 c=0
Rx19 (\4\:mout \10\:mout) resistor r=45 c=0
Rx20 (\2\:mout \18\:mout) resistor r=45 c=0
Rx4 (\2\:n20 \10\:n20) resistor r=45 c=0
Rx5 (\5\:n20 \11\:n20) resistor r=45 c=0
Rx6 (n20 \18\:n20) resistor r=45 c=0
Rx14 (\7\:n20 \19\:n20) resistor r=45 c=0
Rx15 (\4\:n20 \20\:n20) resistor r=45 c=0
Rx16 (\8\:RNb \12\:RNb) resistor r=45 c=0
Rx17 (\9\:RNb \15\:RNb) resistor r=45 c=0
Rx18 (\2\:RNb \16\:RNb) resistor r=45 c=0
Rx7 (CKNbb \12\:CKNbb) resistor r=45 c=0
Rx8 (\3\:CKNbb \15\:CKNbb) resistor r=45 c=0
Rx22 (\6\:CKNbb \16\:CKNbb) resistor r=45 c=0
Rx23 (\8\:CKNbb \17\:CKNbb) resistor r=45 c=0
Rx24 (\4\:n35g \8\:n35g) resistor r=45 c=0
Rx27 (n35g \14\:n35g) resistor r=45 c=0
Rx26 (\3\:qbint \12\:qbint) resistor r=45 c=0
Rx34 (\9\:qbint \18\:qbint) resistor r=45 c=0
Rx35 (qbint \19\:qbint) resistor r=45 c=0
Rx28 (\3\:RTb \5\:RTb) resistor r=45 c=0
Rx29 (RTb \9\:RTb) resistor r=45 c=0
Rx21 (\3\:n35 \6\:n35) resistor r=45 c=0
Rx25 (\2\:n35 \11\:n35) resistor r=45 c=0
Rx39 (n35 \16\:n35) resistor r=45 c=0
mn26 (\14\:n20 \2\:CKNbb n21 VSS) g45n1svt w=(1.45e-07) l=4.5e-08 nf=1 \
        as=8.7e-15 ad=2.03e-14 ps=4.1e-07 pd=5.7e-07 nrd=1.16667 \
        nrs=1.16667 sa=2.45e-07 sb=1.4e-07 sd=160n sca=8.0352 \
        scb=0.00565402 scc=8.19771e-05 m=(1)
mn25 (n21 \1\:D \22\:VSS VSS) g45n1svt w=(1.45e-07) l=4.5e-08 nf=1 \
        as=2.03e-14 ad=8.7e-15 ps=5.7e-07 pd=4.1e-07 nrd=1.16667 \
        nrs=1.16667 sa=2.45e-07 sb=1.4e-07 sd=160n sca=8.0352 \
        scb=0.00565402 scc=8.19771e-05 m=(1)
mn32 (\13\:mout \6\:n20 \3\:net426 VSS) g45n1svt w=(1.45e-07) l=4.5e-08 \
        nf=1 as=2.03e-14 ad=2.32e-14 ps=5.7e-07 pd=6.1e-07 nrd=1.16667 \
        nrs=1.16667 sa=8.3e-07 sb=1.4e-07 sd=160n sca=8.42104 \
        scb=0.00632542 scc=0.000106623 m=(1)
mn52 (n40 \11\:qbint n42 VSS) g45n1svt w=(1.45e-07) l=4.5e-08 nf=1 \
        as=2.32e-14 ad=2.32e-14 ps=6.1e-07 pd=6.1e-07 nrd=1.16667 \
        nrs=1.16667 sa=3.45e-07 sb=3.45e-07 sd=160n sca=8.42104 \
        scb=0.00632542 scc=0.000106623 m=(1)
mn30 (\3\:net426 \6\:SN \10\:VSS VSS) g45n1svt w=(1.45e-07) l=4.5e-08 \
        nf=1 as=2.32e-14 ad=4.858e-14 ps=6.1e-07 pd=9.6e-07 nrd=1.16667 \
        nrs=1.16667 sa=6.25e-07 sb=3.45e-07 sd=160n sca=8.42104 \
        scb=0.00632542 scc=0.000106623 m=(1)
mn51 (n40 \3\:RNb \3\:n42 VSS) g45n1svt w=(1.45e-07) l=4.5e-08 nf=1 \
        as=2.32e-14 ad=2.03e-14 ps=6.1e-07 pd=5.7e-07 nrd=1.16667 \
        nrs=1.16667 sa=1.4e-07 sb=5.5e-07 sd=160n sca=8.42104 \
        scb=0.00632542 scc=0.000106623 m=(1)
mn50 (n42 \8\:SN \1\:VSS VSS) g45n1svt w=(1.45e-07) l=4.5e-08 nf=1 \
        as=2.03e-14 ad=2.32e-14 ps=5.7e-07 pd=6.1e-07 nrd=1.16667 \
        nrs=1.16667 sa=5.5e-07 sb=1.4e-07 sd=160n sca=8.42104 \
        scb=0.00632542 scc=0.000106623 m=(1)
mn36 (\12\:n20 \12\:CKNb n30 VSS) g45n1svt w=(1.45e-07) l=4.5e-08 nf=1 \
        as=8.7e-15 ad=2.03e-14 ps=4.1e-07 pd=5.7e-07 nrd=1.16667 \
        nrs=1.16667 sa=1.4e-07 sb=8.3e-07 sd=160n sca=8.42104 \
        scb=0.00632542 scc=0.000106623 m=(1)
mn35 (n30 \3\:mout \10\:VSS VSS) g45n1svt w=(1.45e-07) l=4.5e-08 nf=1 \
        as=4.858e-14 ad=8.7e-15 ps=9.6e-07 pd=4.1e-07 nrd=1.16667 \
        nrs=1.16667 sa=2.45e-07 sb=7.25e-07 sd=160n sca=8.42104 \
        scb=0.00632542 scc=0.000106623 m=(1)
mn21 (\9\:CKNbb CKNb \30\:VSS VSS) g45n1svt w=(1.45e-07) l=4.5e-08 nf=1 \
        as=2.32e-14 ad=2.03e-14 ps=6.1e-07 pd=5.7e-07 nrd=1.16667 \
        nrs=1.16667 sa=1.4e-07 sb=3.45e-07 sd=160n sca=8.0352 \
        scb=0.00565402 scc=8.19771e-05 m=(1)
mn20 (\17\:CKNb \1\:CKN \30\:VSS VSS) g45n1svt w=(1.45e-07) l=4.5e-08 \
        nf=1 as=2.32e-14 ad=2.03e-14 ps=6.1e-07 pd=5.7e-07 nrd=1.16667 \
        nrs=1.16667 sa=3.45e-07 sb=1.4e-07 sd=160n sca=8.0352 \
        scb=0.00565402 scc=8.19771e-05 m=(1)
mn22 (\10\:RNb \1\:RN \28\:VSS VSS) g45n1svt w=(1.45e-07) l=4.5e-08 nf=1 \
        as=2.03e-14 ad=2.03e-14 ps=5.7e-07 pd=5.7e-07 nrd=1.16667 \
        nrs=1.16667 sa=1.4e-07 sb=1.4e-07 sd=160n sca=8.0352 \
        scb=0.00565402 scc=8.19771e-05 m=(1)
mn31 (\11\:mout RNb net426 VSS) g45n1svt w=(1.45e-07) l=4.5e-08 nf=1 \
        as=2.03e-14 ad=2.32e-14 ps=5.7e-07 pd=6.1e-07 nrd=1.16667 \
        nrs=1.16667 sa=1.4e-07 sb=3.45e-07 sd=160n sca=8.42104 \
        scb=0.00632542 scc=0.000106623 m=(1)
mn40 (\7\:n35 \7\:CKNb \11\:mout VSS) g45n1svt w=(1.45e-07) l=4.5e-08 \
        nf=1 as=2.32e-14 ad=2.03e-14 ps=6.1e-07 pd=5.7e-07 nrd=1.16667 \
        nrs=1.16667 sa=3.45e-07 sb=1.4e-07 sd=160n sca=8.42104 \
        scb=0.00632542 scc=0.000106623 m=(1)
NM0 (\9\:n35g \2\:RTb \12\:n35 VSS) g45n1svt w=(1.45e-07) l=4.5e-08 nf=1 \
        as=2.03e-14 ad=2.03e-14 ps=5.7e-07 pd=5.7e-07 nrd=1.16667 \
        nrs=1.16667 sa=1.4e-07 sb=1.4e-07 sd=160n sca=8.42104 \
        scb=0.00632542 scc=0.000106623 m=(1)
NM1 (\16\:qbint \5\:n35g \26\:VSS VSS) g45n1svt w=(1.45e-07) l=4.5e-08 \
        nf=1 as=2.03e-14 ad=2.03e-14 ps=5.7e-07 pd=5.7e-07 nrd=1.16667 \
        nrs=1.16667 sa=1.4e-07 sb=1.4e-07 sd=160n sca=9.33388 \
        scb=0.00788941 scc=0.00017958 m=(1)
NM3 (net0121 \5\:qbint \24\:VSS VSS) g45n1svt w=(1.45e-07) l=4.5e-08 \
        nf=1 as=2.03e-14 ad=8.7e-15 ps=5.7e-07 pd=4.1e-07 nrd=1.16667 \
        nrs=1.16667 sa=1.4e-07 sb=2.45e-07 sd=160n sca=9.33388 \
        scb=0.00788941 scc=0.00017958 m=(1)
mn45 (\10\:RTb \2\:RT \8\:VSS VSS) g45n1svt w=(1.45e-07) l=4.5e-08 nf=1 \
        as=2.03e-14 ad=2.03e-14 ps=5.7e-07 pd=5.7e-07 nrd=1.16667 \
        nrs=1.16667 sa=1.4e-07 sb=1.4e-07 sd=160n sca=8.42104 \
        scb=0.00632542 scc=0.000106623 m=(1)
NM2 (\11\:n35g \8\:RT net0121 VSS) g45n1svt w=(1.45e-07) l=4.5e-08 nf=1 \
        as=8.7e-15 ad=2.03e-14 ps=4.1e-07 pd=5.7e-07 nrd=1.16667 \
        nrs=1.16667 sa=2.45e-07 sb=1.4e-07 sd=160n sca=9.33388 \
        scb=0.00788941 scc=0.00017958 m=(1)
mn53 (\17\:n35 \7\:CKNbb \3\:n40 VSS) g45n1svt w=(1.45e-07) l=4.5e-08 \
        nf=1 as=2.03e-14 ad=2.03e-14 ps=5.7e-07 pd=5.7e-07 nrd=1.16667 \
        nrs=1.16667 sa=1.4e-07 sb=1.4e-07 sd=160n sca=8.42104 \
        scb=0.00632542 scc=0.000106623 m=(1)
mn55 (\1\:Q \6\:qbint \12\:VSS VSS) g45n1svt w=(2.6e-07) l=4.5e-08 nf=1 \
        as=3.64e-14 ad=3.64e-14 ps=8e-07 pd=8e-07 nrd=1.16667 nrs=1.16667 \
        sa=1.4e-07 sb=1.4e-07 sd=160n sca=9.50447 scb=0.0081528 \
        scc=0.00025289 m=(1)
mp55 (\3\:Q \7\:qbint \15\:VDD VDD) g45p1svt w=(3.9e-07) l=4.5e-08 nf=1 \
        as=5.46e-14 ad=5.46e-14 ps=1.06e-06 pd=1.06e-06 nrd=1.16667 \
        nrs=1.16667 sa=1.4e-07 sb=1.4e-07 sd=160n sca=20.1111 \
        scb=0.0190466 scc=0.00152507 m=(1)
ends RDFFNSRQX1
// End of subcircuit definition.
