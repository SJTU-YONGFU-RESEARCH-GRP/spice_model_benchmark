// Generated for: spectre (May  1 08:12:16 2013 )
// Library name: gsclib045
// Cell name: RDFFQX1
// View name: extracted

simulator lang=spectre

subckt RDFFQX1 CK D ExtVDD Q RT VDD VSS
mp21 (\17\:CKbb \3\:CKb \11\:VDD VDD) g45p1svt w=(2.15e-07) l=4.5e-08 \
        nf=1 as=3.44e-14 ad=3.01e-14 ps=7.5e-07 pd=7.1e-07 nrd=1.16667 \
        nrs=1.16667 sa=1.4e-07 sb=3.45e-07 sd=160n sca=17.4028 \
        scb=0.0174739 scc=0.00112966 m=(1)
PM3 (\15\:n35g \4\:RTb net205 ExtVDD) g45p1svt w=(2.15e-07) l=4.5e-08 \
        nf=1 as=3.01e-14 ad=1.29e-14 ps=7.1e-07 pd=5.5e-07 nrd=1.16667 \
        nrs=1.16667 sa=8.7e-07 sb=1.4e-07 sd=160n sca=25.3956 \
        scb=0.0259635 scc=0.00265434 m=(1)
mp32 (\5\:mout \3\:n20 \13\:VDD VDD) g45p1svt w=(2.15e-07) l=4.5e-08 \
        nf=1 as=3.44e-14 ad=3.44e-14 ps=7.5e-07 pd=7.5e-07 nrd=1.16667 \
        nrs=1.16667 sa=4.5e-07 sb=3.45e-07 sd=160n sca=13.3227 \
        scb=0.0128692 scc=0.00026948 m=(1)
mp35 (n31 mout \13\:VDD VDD) g45p1svt w=(2.15e-07) l=4.5e-08 nf=1 \
        as=1.29e-14 ad=3.44e-14 ps=5.5e-07 pd=7.5e-07 nrd=1.16667 \
        nrs=1.16667 sa=2.45e-07 sb=5.5e-07 sd=160n sca=11.0561 \
        scb=0.00895352 scc=0.000216286 m=(1)
mp25 (n22 \4\:D \15\:VDD VDD) g45p1svt w=(2.15e-07) l=4.5e-08 nf=1 \
        as=3.01e-14 ad=1.29e-14 ps=7.1e-07 pd=5.5e-07 nrd=1.16667 \
        nrs=1.16667 sa=1.4e-07 sb=2.45e-07 sd=160n sca=20.8003 \
        scb=0.0234283 scc=0.00128079 m=(1)
mp26 (\9\:n20 \2\:CKbb n22 VDD) g45p1svt w=(2.15e-07) l=4.5e-08 nf=1 \
        as=1.29e-14 ad=3.01e-14 ps=5.5e-07 pd=7.1e-07 nrd=1.16667 \
        nrs=1.16667 sa=2.45e-07 sb=1.4e-07 sd=160n sca=18.3364 \
        scb=0.0191018 scc=0.00114833 m=(1)
mp36 (\13\:n20 \10\:CKb n31 VDD) g45p1svt w=(2.15e-07) l=4.5e-08 nf=1 \
        as=1.29e-14 ad=3.01e-14 ps=5.5e-07 pd=7.1e-07 nrd=1.16667 \
        nrs=1.16667 sa=1.4e-07 sb=6.55e-07 sd=160n sca=10.8258 \
        scb=0.00859528 scc=0.000215268 m=(1)
mp20 (\13\:CKb \4\:CK \11\:VDD VDD) g45p1svt w=(2.15e-07) l=4.5e-08 nf=1 \
        as=3.44e-14 ad=3.01e-14 ps=7.5e-07 pd=7.1e-07 nrd=1.16667 \
        nrs=1.16667 sa=3.45e-07 sb=1.4e-07 sd=160n sca=21.5211 \
        scb=0.0246647 scc=0.00134591 m=(1)
mp40 (\4\:n35 \7\:CKb \5\:mout VDD) g45p1svt w=(2.15e-07) l=4.5e-08 nf=1 \
        as=3.44e-14 ad=3.01e-14 ps=7.5e-07 pd=7.1e-07 nrd=1.16667 \
        nrs=1.16667 sa=6.55e-07 sb=1.4e-07 sd=160n sca=24.8876 \
        scb=0.0288072 scc=0.00200347 m=(1)
PM0 (\6\:n35g \6\:RT \10\:n35 ExtVDD) g45p1svt w=(2.15e-07) l=4.5e-08 \
        nf=1 as=3.01e-14 ad=3.01e-14 ps=7.1e-07 pd=7.1e-07 nrd=1.16667 \
        nrs=1.16667 sa=1.4e-07 sb=1.4e-07 sd=160n sca=35.8476 \
        scb=0.0407387 scc=0.00396292 m=(1)
PM1 (\14\:qbint \3\:n35g \1\:ExtVDD ExtVDD) g45p1svt w=(2.15e-07) \
        l=4.5e-08 nf=1 as=3.3457e-13 ad=3.01e-14 ps=3.53e-06 pd=7.1e-07 \
        nrd=1.16667 nrs=1.16667 sa=1.4e-07 sb=8.7e-07 sd=160n sca=25.3956 \
        scb=0.0259635 scc=0.00265434 m=(1)
PM2 (net205 \4\:qbint \1\:ExtVDD ExtVDD) g45p1svt w=(2.15e-07) l=4.5e-08 \
        nf=1 as=3.3457e-13 ad=1.29e-14 ps=3.53e-06 pd=5.5e-07 nrd=1.16667 \
        nrs=1.16667 sa=7.65e-07 sb=2.45e-07 sd=160n sca=14.6455 \
        scb=0.014432 scc=0.000486925 m=(1)
mp45 (\6\:RTb \8\:RT \1\:ExtVDD ExtVDD) g45p1svt w=(2.15e-07) l=4.5e-08 \
        nf=1 as=3.3457e-13 ad=3.01e-14 ps=3.53e-06 pd=7.1e-07 nrd=1.16667 \
        nrs=1.16667 sa=3.1e-07 sb=1.4e-07 sd=160n sca=34.1371 \
        scb=0.0394413 scc=0.00358201 m=(1)
mp53 (\15\:n35 \10\:CKbb net084 VDD) g45p1svt w=(2.15e-07) l=4.5e-08 nf=1 \
        as=1.29e-14 ad=3.01e-14 ps=5.5e-07 pd=7.1e-07 nrd=1.16667 \
        nrs=1.16667 sa=1.4e-07 sb=2.45e-07 sd=160n sca=30.754 scb=0.0335 \
        scc=0.00281233 m=(1)
mp52 (net084 \10\:qbint \9\:VDD VDD) g45p1svt w=(2.15e-07) l=4.5e-08 \
        nf=1 as=3.01e-14 ad=1.29e-14 ps=7.1e-07 pd=5.5e-07 nrd=1.16667 \
        nrs=1.16667 sa=2.45e-07 sb=1.4e-07 sd=160n sca=21.6675 \
        scb=0.0252286 scc=0.000716813 m=(1)
C1 (RT VSS) capacitor c=1.92688e-17
C2 (ExtVDD VSS) capacitor c=1.37701e-16
C3 (D VSS) capacitor c=2.57747e-17
C4 (VDD VSS) capacitor c=4.08236e-16
C5 (Q VSS) capacitor c=3.45485e-17
C6 (CK VSS) capacitor c=4.6892e-17
C7 (CKbb VSS) capacitor c=4.89121e-17
C8 (n20 VSS) capacitor c=4.56602e-17
C9 (mout VSS) capacitor c=5.68895e-17
C10 (n35 VSS) capacitor c=1.47271e-16
C11 (CKb VSS) capacitor c=3.42444e-16
C12 (n35g VSS) capacitor c=1.80661e-17
C13 (qbint VSS) capacitor c=4.78499e-17
C14 (RTb VSS) capacitor c=4.12161e-17
C15 (\9\:qbint VSS) capacitor c=2.81233e-17
C16 (\10\:qbint VSS) capacitor c=2.00346e-16
C17 (\10\:CKbb VSS) capacitor c=8.74558e-17
C18 (\4\:RTb VSS) capacitor c=9.88135e-17
C19 (\8\:RT VSS) capacitor c=2.27269e-17
C20 (\4\:qbint VSS) capacitor c=6.90125e-17
C21 (\3\:n35g VSS) capacitor c=5.05413e-17
C22 (\6\:RT VSS) capacitor c=7.80017e-17
C23 (\7\:CKb VSS) capacitor c=3.01367e-17
C24 (\4\:CK VSS) capacitor c=3.41971e-17
C25 (\3\:n20 VSS) capacitor c=5.79369e-17
C26 (\3\:CKb VSS) capacitor c=6.07083e-17
C27 (\10\:CKb VSS) capacitor c=9.57038e-17
C28 (\2\:CKbb VSS) capacitor c=1.21193e-16
C29 (\4\:D VSS) capacitor c=6.96161e-17
C30 (\6\:qbint VSS) capacitor c=3.1529e-17
C31 (\11\:qbint VSS) capacitor c=9.13617e-17
C32 (\7\:RT VSS) capacitor c=1.68343e-16
C33 (\1\:RT VSS) capacitor c=4.50932e-17
C34 (\5\:qbint VSS) capacitor c=3.9152e-17
C35 (\5\:n35g VSS) capacitor c=2.85177e-17
C36 (\8\:CKbb VSS) capacitor c=3.16073e-17
C37 (\1\:CK VSS) capacitor c=3.971e-17
C38 (\6\:n20 VSS) capacitor c=5.17415e-17
C39 (\8\:CKb VSS) capacitor c=2.42413e-17
C40 (\3\:mout VSS) capacitor c=4.9379e-17
C41 (\9\:CKbb VSS) capacitor c=5.01995e-17
C42 (\5\:CKb VSS) capacitor c=8.51978e-17
C43 (\1\:D VSS) capacitor c=4.707e-17
C44 (\11\:CKbb VSS) capacitor c=5.67016e-17
C45 (\4\:CKbb VSS) capacitor c=1.28363e-16
C46 (\8\:qbint VSS) capacitor c=1.09113e-16
C47 (\3\:RT VSS) capacitor c=1.70748e-16
C48 (\3\:RTb VSS) capacitor c=7.33589e-17
C49 (\4\:RT VSS) capacitor c=4.32576e-17
C50 (\2\:RT VSS) capacitor c=3.90818e-17
C51 (\3\:qbint VSS) capacitor c=3.57682e-17
C52 (\2\:RTb VSS) capacitor c=4.01219e-17
C53 (\2\:n35 VSS) capacitor c=1.66076e-16
C54 (\4\:n35g VSS) capacitor c=6.78973e-17
C55 (\3\:n35 VSS) capacitor c=4.37431e-17
C56 (\3\:CK VSS) capacitor c=2.69531e-17
C57 (\9\:CKb VSS) capacitor c=8.5521e-17
C58 (\2\:mout VSS) capacitor c=3.87963e-17
C59 (\4\:mout VSS) capacitor c=4.04131e-17
C60 (\5\:n20 VSS) capacitor c=4.33784e-17
C61 (\2\:n20 VSS) capacitor c=4.14223e-17
C62 (\3\:CKbb VSS) capacitor c=6.13871e-17
C63 (\7\:CKbb VSS) capacitor c=3.0207e-17
C64 (\3\:D VSS) capacitor c=1.71535e-17
C65 (\1\:VDD VSS) capacitor c=4.43926e-17
C66 (\9\:VDD VSS) capacitor c=2.50787e-17
C67 (\3\:Q VSS) capacitor c=6.15191e-17
C68 (\15\:n35 VSS) capacitor c=4.31544e-17
C69 (\15\:n35g VSS) capacitor c=4.75925e-17
C70 (\6\:RTb VSS) capacitor c=6.01515e-17
C71 (\1\:ExtVDD VSS) capacitor c=2.90415e-16
C72 (\10\:n35 VSS) capacitor c=5.12721e-17
C73 (\14\:qbint VSS) capacitor c=6.79862e-17
C74 (\6\:n35g VSS) capacitor c=8.81482e-17
C75 (\4\:n35 VSS) capacitor c=4.01866e-17
C76 (\13\:CKb VSS) capacitor c=5.98893e-17
C77 (\5\:mout VSS) capacitor c=5.94841e-17
C78 (\11\:VDD VSS) capacitor c=6.79366e-17
C79 (\13\:VDD VSS) capacitor c=5.96603e-17
C80 (\17\:CKbb VSS) capacitor c=4.41313e-17
C81 (\13\:n20 VSS) capacitor c=4.60065e-17
C82 (\9\:n20 VSS) capacitor c=8.35255e-17
C83 (\15\:VDD VSS) capacitor c=4.32319e-17
C84 (\1\:Q VSS) capacitor c=4.12195e-17
C85 (\18\:n35 VSS) capacitor c=6.03244e-17
C86 (\11\:n35g VSS) capacitor c=2.9641e-17
C87 (\10\:RTb VSS) capacitor c=5.97e-17
C88 (\13\:n35 VSS) capacitor c=5.57681e-17
C89 (\16\:qbint VSS) capacitor c=2.38621e-17
C90 (\9\:n35g VSS) capacitor c=7.6489e-17
C91 (\7\:n35 VSS) capacitor c=4.49493e-17
C92 (\15\:CKb VSS) capacitor c=3.65918e-17
C93 (\10\:mout VSS) capacitor c=5.23912e-17
C94 (\14\:CKbb VSS) capacitor c=4.92834e-17
C95 (\16\:n20 VSS) capacitor c=4.36734e-17
C96 (\7\:n20 VSS) capacitor c=7.65062e-17
C97 (\2\:D VSS) capacitor c=4.23424e-17
C98 (\4\:n20 VSS) capacitor c=4.75933e-17
C99 (\2\:CK VSS) capacitor c=3.35822e-17
C100 (VDD VSS) capacitor c=2.43461e-16
C101 (\2\:n35g VSS) capacitor c=3.01463e-17
C102 (ExtVDD VSS) capacitor c=3.94468e-17
C103 (\2\:qbint VSS) capacitor c=4.10902e-17
C104 (\5\:RT VSS) capacitor c=5.36934e-17
C105 (\5\:CKbb VSS) capacitor c=1.09619e-16
C106 (\6\:CKbb VSS) capacitor c=4.22437e-17
C107 (\2\:CKb VSS) capacitor c=2.61166e-16
C108 (\6\:CKb VSS) capacitor c=4.13326e-17
C109 (\7\:qbint VSS) capacitor c=2.78147e-17
C110 (\12\:CKbb VSS) capacitor c=9.81888e-17
C111 (\13\:CKbb VSS) capacitor c=8.51911e-17
C112 (\5\:D VSS) capacitor c=2.79953e-17
C113 (\11\:n20 VSS) capacitor c=3.70015e-17
C114 (\12\:n20 VSS) capacitor c=5.21744e-17
C115 (\15\:n20 VSS) capacitor c=5.33201e-17
C116 (\16\:CKbb VSS) capacitor c=8.01632e-17
C117 (\7\:mout VSS) capacitor c=4.31792e-17
C118 (\8\:mout VSS) capacitor c=2.73751e-17
C119 (\9\:mout VSS) capacitor c=2.48777e-17
C120 (\12\:mout VSS) capacitor c=2.40532e-17
C121 (\5\:CK VSS) capacitor c=4.63936e-17
C122 (\11\:CKb VSS) capacitor c=5.14744e-17
C123 (\12\:CKb VSS) capacitor c=4.37672e-17
C124 (\6\:n35 VSS) capacitor c=6.86936e-17
C125 (\9\:n35 VSS) capacitor c=6.22108e-17
C126 (\8\:n35g VSS) capacitor c=3.33312e-17
C127 (\12\:n35 VSS) capacitor c=6.03283e-17
C128 (\12\:qbint VSS) capacitor c=8.88092e-17
C129 (\13\:qbint VSS) capacitor c=1.11075e-16
C130 (\13\:n35g VSS) capacitor c=1.14642e-16
C131 (\14\:n35g VSS) capacitor c=1.16642e-16
C132 (\9\:RT VSS) capacitor c=6.33111e-17
C133 (\10\:RT VSS) capacitor c=6.13838e-17
C134 (\5\:RTb VSS) capacitor c=3.75961e-17
C135 (\8\:RTb VSS) capacitor c=1.11197e-16
C136 (\9\:RTb VSS) capacitor c=6.95648e-17
C137 (\11\:RT VSS) capacitor c=3.16423e-17
C138 (\18\:qbint VSS) capacitor c=1.86559e-17
C139 (\19\:qbint VSS) capacitor c=3.0903e-17
C140 (\19\:CKbb VSS) capacitor c=1.10832e-16
C141 (\20\:CKbb VSS) capacitor c=9.68986e-17
C142 (\17\:n35 VSS) capacitor c=6.16616e-17
C143 (\3\:VDD VSS) capacitor c=1.15313e-17
C144 (\5\:VDD VSS) capacitor c=1.08994e-16
C145 (\6\:VDD VSS) capacitor c=7.14434e-17
C146 (\8\:VDD VSS) capacitor c=2.9524e-17
Rk41 (\9\:RT \10\:RT) resistor r=0.4442 c=0
Rk46 (RT \11\:RT) resistor r=0.02248 c=0
Rk31 (ExtVDD ExtVDD) resistor r=0.002057 c=0
Rk29 (\2\:ExtVDD ExtVDD) resistor r=0.0221 c=0
Rk32 (ExtVDD \5\:ExtVDD) resistor r=0.0201 c=0
Rk33 (ExtVDD \6\:ExtVDD) resistor r=0.1054 c=0
Rk34 (\7\:ExtVDD \8\:ExtVDD) resistor r=0.02871 c=0
Rk2 (D \5\:D) resistor r=0.02028 c=0
Rk64 (\2\:VDD \3\:VDD) resistor r=0.4133 c=0
Rk66 (\5\:VDD VDD) resistor r=0.9273 c=0
Rk65 (\3\:VDD \5\:VDD) resistor r=0.0725 c=0
Rk67 (VDD \6\:VDD) resistor r=0.6382 c=0
Rk72 (\8\:VDD VDD) resistor r=0.1829 c=0
Rk68 (\6\:VDD \8\:VDD) resistor r=0.05483 c=0
Rk69 (\3\:VDD \10\:VDD) resistor r=0.2931 c=0
Rk70 (\6\:VDD \12\:VDD) resistor r=0.3821 c=0
Rk71 (\8\:VDD \14\:VDD) resistor r=0.3525 c=0
Rk73 (VDD \16\:VDD) resistor r=0.5155 c=0
Rk51 (\2\:Q Q) resistor r=0.1608 c=0
Rk52 (Q \4\:Q) resistor r=0.3215 c=0
Rk53 (\2\:VSS \4\:VSS) resistor r=0.6737 c=0
Rk54 (\4\:VSS \5\:VSS) resistor r=0.309 c=0
Rk56 (\6\:VSS VSS) resistor r=0.075 c=0
Rk55 (\5\:VSS \6\:VSS) resistor r=0.2074 c=0
Rk57 (VSS \7\:VSS) resistor r=0.5457 c=0
Rk59 (\8\:VSS VSS) resistor r=0.02182 c=0
Rk58 (\7\:VSS \8\:VSS) resistor r=0.0938 c=0
Rk60 (VSS \10\:VSS) resistor r=0.5942 c=0
Rk61 (\5\:VSS \12\:VSS) resistor r=0.1854 c=0
Rk62 (\6\:VSS \14\:VSS) resistor r=0.1905 c=0
Rk63 (\8\:VSS \16\:VSS) resistor r=0.2366 c=0
Rk74 (\18\:VSS \20\:VSS) resistor r=0.6516 c=0
Rk76 (\21\:VSS VSS) resistor r=0.331 c=0
Rk75 (\20\:VSS \21\:VSS) resistor r=0.262 c=0
Rk78 (\22\:VSS VSS) resistor r=0.119 c=0
Rk77 (VSS \22\:VSS) resistor r=0.5444 c=0
Rk79 (VSS \24\:VSS) resistor r=0.2756 c=0
Rk80 (\21\:VSS \26\:VSS) resistor r=0.3501 c=0
Rk16 (\5\:CK CK) resistor r=0.006226 c=0
Rk15 (\5\:CK \6\:CK) resistor r=0.005454 c=0
Rk1 (\12\:CKbb \13\:CKbb) resistor r=0.8336 c=0
Rk8 (\15\:CKbb \16\:CKbb) resistor r=0.3151 c=0
Rk9 (\16\:CKbb \18\:CKbb) resistor r=0.1858 c=0
Rk48 (\19\:CKbb \20\:CKbb) resistor r=0.8499 c=0
Rk3 (\8\:n20 \10\:n20) resistor r=0.4919 c=0
Rk4 (\10\:n20 \11\:n20) resistor r=0.3007 c=0
Rk5 (\12\:n20 \14\:n20) resistor r=0.2757 c=0
Rk6 (\14\:n20 \15\:n20) resistor r=0.2392 c=0
Rk7 (\12\:n20 \17\:n20) resistor r=0.2333 c=0
Rk10 (\6\:mout \7\:mout) resistor r=0.3049 c=0
Rk11 (\7\:mout \8\:mout) resistor r=0.1492 c=0
Rk12 (\8\:mout \9\:mout) resistor r=0.1241 c=0
Rk13 (\7\:mout \11\:mout) resistor r=0.2733 c=0
Rk14 (\8\:mout \12\:mout) resistor r=0.1307 c=0
Rk22 (\5\:n35 \6\:n35) resistor r=0.2864 c=0
Rk23 (\6\:n35 \8\:n35) resistor r=0.272 c=0
Rk24 (\6\:n35 \9\:n35) resistor r=0.567 c=0
Rk27 (\11\:n35 \12\:n35) resistor r=0.2719 c=0
Rk28 (\12\:n35 \14\:n35) resistor r=0.3269 c=0
Rk49 (\16\:n35 \17\:n35) resistor r=0.17 c=0
Rk50 (\17\:n35 \19\:n35) resistor r=0.4264 c=0
Rk19 (\11\:CKb \12\:CKb) resistor r=0.2082 c=0
Rk20 (\12\:CKb \14\:CKb) resistor r=0.3121 c=0
Rk21 (\12\:CKb \16\:CKb) resistor r=0.1956 c=0
Rk25 (\7\:n35g \8\:n35g) resistor r=0.2289 c=0
Rk26 (\7\:n35g \10\:n35g) resistor r=0.6049 c=0
Rk38 (\12\:n35g \13\:n35g) resistor r=0.2424 c=0
Rk39 (\13\:n35g \14\:n35g) resistor r=0.5641 c=0
Rk40 (\13\:n35g \16\:n35g) resistor r=0.4309 c=0
Rk35 (\12\:qbint \13\:qbint) resistor r=0.4933 c=0
Rk36 (\13\:qbint \15\:qbint) resistor r=0.5658 c=0
Rk37 (\13\:qbint \17\:qbint) resistor r=0.1459 c=0
Rk47 (\18\:qbint \19\:qbint) resistor r=0.2113 c=0
Rk42 (\5\:RTb \7\:RTb) resistor r=0.226 c=0
Rk43 (\7\:RTb \8\:RTb) resistor r=0.2727 c=0
Rk44 (\8\:RTb \9\:RTb) resistor r=0.669 c=0
Rk45 (\8\:RTb \11\:RTb) resistor r=0.3325 c=0
Rl29 (\3\:RT \7\:RT) resistor r=709.9 c=0
Rl26 (\3\:RT \4\:RT) resistor r=72.2057 c=0
Rl20 (\1\:RT \2\:RT) resistor r=125.877 c=0
Rl30 (\5\:RT \8\:RT) resistor r=30.9873 c=0
Rl28 (\5\:RT \6\:RT) resistor r=273.765 c=0
Rl27 (\4\:RT \5\:RT) resistor r=78.204 c=0
Rl3 (\2\:D \4\:D) resistor r=132.406 c=0
Rl1 (\1\:D \2\:D) resistor r=78.5603 c=0
Rl2 (\2\:D \3\:D) resistor r=5.1123 c=0
Rl14 (\2\:CK \4\:CK) resistor r=70.868 c=0
Rl12 (\1\:CK \2\:CK) resistor r=140.099 c=0
Rl13 (\2\:CK \3\:CK) resistor r=2.0166 c=0
Rl38 (\10\:CKbb \11\:CKbb) resistor r=115.79 c=0
Rl5 (CKbb \2\:CKbb) resistor r=147.837 c=0
Rl6 (\2\:CKbb \3\:CKbb) resistor r=246.721 c=0
Rl34 (\5\:CKbb \8\:CKbb) resistor r=64.1356 c=0
Rl31 (\4\:CKbb \5\:CKbb) resistor r=862.964 c=0
Rl35 (\6\:CKbb \9\:CKbb) resistor r=64.1356 c=0
Rl33 (\6\:CKbb \7\:CKbb) resistor r=113.909 c=0
Rl32 (\5\:CKbb \6\:CKbb) resistor r=172.374 c=0
Rl4 (n20 \2\:n20) resistor r=112.885 c=0
Rl9 (\3\:n20 \4\:n20) resistor r=103.572 c=0
Rl11 (\4\:n20 \6\:n20) resistor r=96.5354 c=0
Rl10 (\4\:n20 \5\:n20) resistor r=121.254 c=0
Rl7 (mout \2\:mout) resistor r=24.2328 c=0
Rl8 (\3\:mout \4\:mout) resistor r=24.2328 c=0
Rl36 (n35 \2\:n35) resistor r=499.328 c=0
Rl37 (\2\:n35 \3\:n35) resistor r=104.689 c=0
Rl40 (\2\:CKb \3\:CKb) resistor r=214.27 c=0
Rl39 (CKb \2\:CKb) resistor r=1441.22 c=0
Rl41 (\3\:CKb \4\:CKb) resistor r=134.462 c=0
Rl45 (\4\:CKb \8\:CKb) resistor r=72.9234 c=0
Rl42 (\4\:CKb \5\:CKb) resistor r=222.576 c=0
Rl46 (\4\:CKb \9\:CKb) resistor r=3.6978 c=0
Rl44 (\6\:CKb \7\:CKb) resistor r=66.684 c=0
Rl47 (\6\:CKb \10\:CKb) resistor r=229.379 c=0
Rl43 (\2\:CKb \6\:CKb) resistor r=112.483 c=0
Rl17 (\3\:n35g \4\:n35g) resistor r=241.174 c=0
Rl16 (\2\:n35g \3\:n35g) resistor r=181.74 c=0
Rl18 (\2\:n35g \5\:n35g) resistor r=94.1963 c=0
Rl15 (n35g \2\:n35g) resistor r=2.4834 c=0
Rl52 (\10\:qbint \11\:qbint) resistor r=235.906 c=0
Rl51 (\8\:qbint \10\:qbint) resistor r=601.135 c=0
Rl25 (\3\:qbint \5\:qbint) resistor r=35.3072 c=0
Rl24 (\2\:qbint \4\:qbint) resistor r=148.502 c=0
Rl22 (qbint \2\:qbint) resistor r=112.732 c=0
Rl23 (\2\:qbint \3\:qbint) resistor r=74.1915 c=0
Rl50 (\7\:qbint \9\:qbint) resistor r=68.607 c=0
Rl48 (\6\:qbint \7\:qbint) resistor r=78.0039 c=0
Rl49 (\7\:qbint \8\:qbint) resistor r=166.462 c=0
Rl21 (\3\:RTb \4\:RTb) resistor r=242.199 c=0
Rl19 (RTb \2\:RTb) resistor r=124.312 c=0
Rz14 (\1\:Q \2\:Q) resistor r=37.5 c=0
Rz15 (\1\:VSS \2\:VSS) resistor r=37.5 c=0
Rz16 (\9\:VSS \10\:VSS) resistor r=75 c=0
Rz17 (\11\:VSS \12\:VSS) resistor r=75 c=0
Rz18 (\13\:VSS \14\:VSS) resistor r=75 c=0
Rz19 (\15\:VSS \16\:VSS) resistor r=75 c=0
Rz22 (\17\:VSS \18\:VSS) resistor r=75 c=0
Rz23 (\23\:VSS \24\:VSS) resistor r=75 c=0
Rz24 (\25\:VSS \26\:VSS) resistor r=75 c=0
Rz3 (\14\:CKbb \15\:CKbb) resistor r=75 c=0
Rz1 (\7\:n20 \8\:n20) resistor r=75 c=0
Rz2 (\16\:n20 \17\:n20) resistor r=75 c=0
Rz4 (\10\:mout \11\:mout) resistor r=75 c=0
Rz6 (\7\:n35 \8\:n35) resistor r=75 c=0
Rz8 (\13\:n35 \14\:n35) resistor r=75 c=0
Rz13 (\18\:n35 \19\:n35) resistor r=75 c=0
Rz5 (\15\:CKb \16\:CKb) resistor r=75 c=0
Rz7 (\9\:n35g \10\:n35g) resistor r=75 c=0
Rz11 (\11\:n35g \12\:n35g) resistor r=75 c=0
Rz10 (\16\:qbint \17\:qbint) resistor r=75 c=0
Rz12 (\10\:RTb \11\:RTb) resistor r=75 c=0
Ry9 (\1\:ExtVDD \2\:ExtVDD) resistor r=62 c=0
Ry10 (\1\:ExtVDD \5\:ExtVDD) resistor r=62 c=0
Ry11 (\1\:ExtVDD \6\:ExtVDD) resistor r=62 c=0
Ry12 (\1\:ExtVDD \7\:ExtVDD) resistor r=62 c=0
Ry13 (\1\:ExtVDD \8\:ExtVDD) resistor r=62 c=0
Ry21 (\1\:VDD \2\:VDD) resistor r=20.6667 c=0
Ry22 (\9\:VDD \10\:VDD) resistor r=62 c=0
Ry23 (\11\:VDD \12\:VDD) resistor r=62 c=0
Ry24 (\13\:VDD \14\:VDD) resistor r=62 c=0
Ry25 (\15\:VDD \16\:VDD) resistor r=62 c=0
Ry18 (\3\:Q \4\:Q) resistor r=20.6667 c=0
Ry19 (\3\:VSS \4\:VSS) resistor r=5.6364 c=0
Ry20 (\3\:VSS \7\:VSS) resistor r=5.1667 c=0
Ry26 (\19\:VSS \20\:VSS) resistor r=5.6364 c=0
Ry27 (\19\:VSS \22\:VSS) resistor r=5.1667 c=0
Ry3 (\17\:CKbb \18\:CKbb) resistor r=62 c=0
Ry1 (\9\:n20 \10\:n20) resistor r=62 c=0
Ry2 (\13\:n20 \14\:n20) resistor r=62 c=0
Ry4 (\5\:mout \6\:mout) resistor r=62 c=0
Ry6 (\4\:n35 \5\:n35) resistor r=62 c=0
Ry8 (\10\:n35 \11\:n35) resistor r=62 c=0
Ry17 (\15\:n35 \16\:n35) resistor r=62 c=0
Ry5 (\13\:CKb \14\:CKb) resistor r=62 c=0
Ry7 (\6\:n35g \7\:n35g) resistor r=62 c=0
Ry15 (\15\:n35g \16\:n35g) resistor r=62 c=0
Ry14 (\14\:qbint \15\:qbint) resistor r=62 c=0
Ry16 (\6\:RTb \7\:RTb) resistor r=62 c=0
Rx17 (\4\:RT \9\:RT) resistor r=45 c=0
Rx18 (\2\:RT \10\:RT) resistor r=45 c=0
Rx21 (\3\:RT \11\:RT) resistor r=45 c=0
Rx3 (\3\:D \5\:D) resistor r=45 c=0
Rx10 (\3\:CK \6\:CK) resistor r=45 c=0
Rx1 (\3\:CKbb \12\:CKbb) resistor r=45 c=0
Rx2 (\7\:CKbb \13\:CKbb) resistor r=45 c=0
Rx7 (CKbb \16\:CKbb) resistor r=45 c=0
Rx24 (\11\:CKbb \19\:CKbb) resistor r=45 c=0
Rx25 (\4\:CKbb \20\:CKbb) resistor r=45 c=0
Rx4 (\2\:n20 \11\:n20) resistor r=45 c=0
Rx5 (\5\:n20 \12\:n20) resistor r=45 c=0
Rx6 (n20 \15\:n20) resistor r=45 c=0
Rx8 (\4\:mout \9\:mout) resistor r=45 c=0
Rx9 (\2\:mout \12\:mout) resistor r=45 c=0
Rx12 (\3\:n35 \9\:n35) resistor r=45 c=0
Rx14 (\2\:n35 \12\:n35) resistor r=45 c=0
Rx26 (n35 \17\:n35) resistor r=45 c=0
Rx11 (\9\:CKb \11\:CKb) resistor r=45 c=0
Rx13 (\4\:n35g \8\:n35g) resistor r=45 c=0
Rx16 (n35g \14\:n35g) resistor r=45 c=0
Rx15 (\3\:qbint \12\:qbint) resistor r=45 c=0
Rx22 (\8\:qbint \18\:qbint) resistor r=45 c=0
Rx23 (qbint \19\:qbint) resistor r=45 c=0
Rx19 (\3\:RTb \5\:RTb) resistor r=45 c=0
Rx20 (\2\:RTb \9\:RTb) resistor r=45 c=0
mn21 (\14\:CKbb \8\:CKb \15\:VSS VSS) g45n1svt w=(1.45e-07) l=4.5e-08 \
        nf=1 as=2.32e-14 ad=2.03e-14 ps=6.1e-07 pd=5.7e-07 nrd=1.16667 \
        nrs=1.16667 sa=1.4e-07 sb=3.45e-07 sd=160n sca=7.91544 \
        scb=0.00544522 scc=7.50774e-05 m=(1)
mn35 (n30 \3\:mout \23\:VSS VSS) g45n1svt w=(1.45e-07) l=4.5e-08 nf=1 \
        as=2.32e-14 ad=8.7e-15 ps=6.1e-07 pd=4.1e-07 nrd=1.16667 \
        nrs=1.16667 sa=2.45e-07 sb=5.5e-07 sd=160n sca=11.4452 \
        scb=0.0112553 scc=0.00042156 m=(1)
mn20 (\15\:CKb \1\:CK \15\:VSS VSS) g45n1svt w=(1.45e-07) l=4.5e-08 nf=1 \
        as=2.03e-14 ad=2.32e-14 ps=5.7e-07 pd=6.1e-07 nrd=1.16667 \
        nrs=1.16667 sa=3.45e-07 sb=1.4e-07 sd=160n sca=7.91544 \
        scb=0.00544522 scc=7.50774e-05 m=(1)
mn32 (\10\:mout \6\:n20 \23\:VSS VSS) g45n1svt w=(1.45e-07) l=4.5e-08 \
        nf=1 as=2.32e-14 ad=2.32e-14 ps=6.1e-07 pd=6.1e-07 nrd=1.16667 \
        nrs=1.16667 sa=4.5e-07 sb=3.45e-07 sd=160n sca=11.4452 \
        scb=0.0112553 scc=0.00042156 m=(1)
mn26 (\7\:n20 \5\:CKb n21 VSS) g45n1svt w=(1.45e-07) l=4.5e-08 nf=1 \
        as=2.03e-14 ad=8.7e-15 ps=5.7e-07 pd=4.1e-07 nrd=1.16667 \
        nrs=1.16667 sa=2.45e-07 sb=1.4e-07 sd=160n sca=7.91544 \
        scb=0.00544522 scc=7.50774e-05 m=(1)
mn25 (n21 \1\:D \9\:VSS VSS) g45n1svt w=(1.45e-07) l=4.5e-08 nf=1 \
        as=8.7e-15 ad=2.03e-14 ps=4.1e-07 pd=5.7e-07 nrd=1.16667 \
        nrs=1.16667 sa=2.45e-07 sb=1.4e-07 sd=160n sca=7.91544 \
        scb=0.00544522 scc=7.50774e-05 m=(1)
mn40 (\7\:n35 \8\:CKbb \10\:mout VSS) g45n1svt w=(1.45e-07) l=4.5e-08 \
        nf=1 as=2.03e-14 ad=2.32e-14 ps=5.7e-07 pd=6.1e-07 nrd=1.16667 \
        nrs=1.16667 sa=6.55e-07 sb=1.4e-07 sd=160n sca=11.4452 \
        scb=0.0112553 scc=0.00042156 m=(1)
mn36 (\16\:n20 \9\:CKbb n30 VSS) g45n1svt w=(1.45e-07) l=4.5e-08 nf=1 \
        as=8.7e-15 ad=2.03e-14 ps=4.1e-07 pd=5.7e-07 nrd=1.16667 \
        nrs=1.16667 sa=1.4e-07 sb=6.55e-07 sd=160n sca=11.4452 \
        scb=0.0112553 scc=0.00042156 m=(1)
NM0 (\9\:n35g RTb \13\:n35 VSS) g45n1svt w=(1.45e-07) l=4.5e-08 nf=1 \
        as=2.03e-14 ad=2.03e-14 ps=5.7e-07 pd=5.7e-07 nrd=1.16667 \
        nrs=1.16667 sa=1.4e-07 sb=1.4e-07 sd=160n sca=6.59604 \
        scb=0.00318587 scc=2.16275e-05 m=(1)
NM1 (\16\:qbint \5\:n35g \13\:VSS VSS) g45n1svt w=(1.45e-07) l=4.5e-08 \
        nf=1 as=2.03e-14 ad=2.03e-14 ps=5.7e-07 pd=5.7e-07 nrd=1.16667 \
        nrs=1.16667 sa=1.4e-07 sb=1.4e-07 sd=160n sca=9.33388 \
        scb=0.00788941 scc=0.00017958 m=(1)
NM3 (net0121 \5\:qbint \11\:VSS VSS) g45n1svt w=(1.45e-07) l=4.5e-08 \
        nf=1 as=2.03e-14 ad=8.7e-15 ps=5.7e-07 pd=4.1e-07 nrd=1.16667 \
        nrs=1.16667 sa=1.4e-07 sb=2.45e-07 sd=160n sca=9.33388 \
        scb=0.00788941 scc=0.00017958 m=(1)
mn45 (\10\:RTb \1\:RT \25\:VSS VSS) g45n1svt w=(1.45e-07) l=4.5e-08 nf=1 \
        as=2.03e-14 ad=2.03e-14 ps=5.7e-07 pd=5.7e-07 nrd=1.16667 \
        nrs=1.16667 sa=1.4e-07 sb=1.4e-07 sd=160n sca=6.59604 \
        scb=0.00318587 scc=2.16275e-05 m=(1)
NM2 (\11\:n35g \7\:RT net0121 VSS) g45n1svt w=(1.45e-07) l=4.5e-08 nf=1 \
        as=8.7e-15 ad=2.03e-14 ps=4.1e-07 pd=5.7e-07 nrd=1.16667 \
        nrs=1.16667 sa=2.45e-07 sb=1.4e-07 sd=160n sca=9.33388 \
        scb=0.00788941 scc=0.00017958 m=(1)
mn53 (\18\:n35 CKb net095 VSS) g45n1svt w=(1.45e-07) l=4.5e-08 nf=1 \
        as=8.7e-15 ad=2.03e-14 ps=4.1e-07 pd=5.7e-07 nrd=1.16667 \
        nrs=1.16667 sa=1.4e-07 sb=2.45e-07 sd=160n sca=8.55924 \
        scb=0.0065649 scc=0.000116351 m=(1)
mn52 (net095 \11\:qbint \17\:VSS VSS) g45n1svt w=(1.45e-07) l=4.5e-08 \
        nf=1 as=2.03e-14 ad=8.7e-15 ps=5.7e-07 pd=4.1e-07 nrd=1.16667 \
        nrs=1.16667 sa=2.45e-07 sb=1.4e-07 sd=160n sca=8.55924 \
        scb=0.0065649 scc=0.000116351 m=(1)
mn55 (\1\:Q \6\:qbint \1\:VSS VSS) g45n1svt w=(2.6e-07) l=4.5e-08 nf=1 \
        as=3.64e-14 ad=3.64e-14 ps=8e-07 pd=8e-07 nrd=1.16667 nrs=1.16667 \
        sa=1.4e-07 sb=1.4e-07 sd=160n sca=9.32128 scb=0.00786794 \
        scc=0.000232361 m=(1)
mp55 (\3\:Q \9\:qbint \1\:VDD VDD) g45p1svt w=(3.9e-07) l=4.5e-08 nf=1 \
        as=5.46e-14 ad=5.46e-14 ps=1.06e-06 pd=1.06e-06 nrd=1.16667 \
        nrs=1.16667 sa=1.4e-07 sb=1.4e-07 sd=160n sca=29.5335 \
        scb=0.0330001 scc=0.00212514 m=(1)
ends RDFFQX1
// End of subcircuit definition.
