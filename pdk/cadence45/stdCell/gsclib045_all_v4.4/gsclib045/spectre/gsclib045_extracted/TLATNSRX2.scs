// Generated for: spectre (May  1 08:18:19 2013 )
// Library name: gsclib045
// Cell name: TLATNSRX2
// View name: extracted

simulator lang=spectre

subckt TLATNSRX2 D GN Q QN RN SN VDD VSS
mp3 (\4\:GNb GNbb \25\:VDD VDD) g45p1svt w=(2.15e-07) l=4.5e-08 nf=1 \
        as=3.44e-14 ad=3.01e-14 ps=7.5e-07 pd=7.1e-07 nrd=1.16667 \
        nrs=1.16667 sa=1.4e-07 sb=9e-07 sd=160n sca=15.0072 scb=0.0138831 \
        scc=0.00018176 m=(1)
mp5 (net313 \1\:D \25\:VDD VDD) g45p1svt w=(2.15e-07) l=4.5e-08 nf=1 \
        as=3.44e-14 ad=6.558e-14 ps=7.5e-07 pd=1.04e-06 nrd=1.16667 \
        nrs=1.16667 sa=3.45e-07 sb=6.95e-07 sd=160n sca=11.8374 \
        scb=0.00867489 scc=8.30219e-05 m=(1)
mp6 (\6\:n5 \4\:GNbb net313 VDD) g45p1svt w=(2.15e-07) l=4.5e-08 nf=1 \
        as=6.558e-14 ad=3.44e-14 ps=1.04e-06 pd=7.5e-07 nrd=1.16667 \
        nrs=1.16667 sa=6.95e-07 sb=3.45e-07 sd=160n sca=10.3113 \
        scb=0.00749421 scc=8.05171e-05 m=(1)
mp17 (\6\:n5 GNb \3\:net270 VDD) g45p1svt w=(2.15e-07) l=4.5e-08 nf=1 \
        as=3.01e-14 ad=3.44e-14 ps=7.1e-07 pd=7.5e-07 nrd=1.16667 \
        nrs=1.16667 sa=9e-07 sb=1.4e-07 sd=160n sca=10.2104 scb=0.00747301 \
        scc=8.05149e-05 m=(1)
mp16 (net270 qint \23\:VDD VDD) g45p1svt w=(2.15e-07) l=4.5e-08 nf=1 \
        as=5.465e-14 ad=3.44e-14 ps=1.76e-06 pd=7.5e-07 nrd=1.16667 \
        nrs=1.16667 sa=1e-07 sb=2e-06 sd=160n sca=35.2411 scb=0.0263265 \
        scc=0.00456529 m=(1)
mp15 (net270 \5\:RN \21\:VDD VDD) g45p1svt w=(2.15e-07) l=4.5e-08 nf=1 \
        as=6.54e-14 ad=3.44e-14 ps=1.86e-06 pd=7.5e-07 nrd=1.16667 \
        nrs=1.16667 sa=3.05e-07 sb=2e-06 sd=160n sca=35.2411 scb=0.0263265 \
        scc=0.00456529 m=(1)
mp1 (\12\:GNbb \1\:RN \21\:VDD VDD) g45p1svt w=(2.15e-07) l=4.5e-08 nf=1 \
        as=6.54e-14 ad=3.44e-14 ps=1.86e-06 pd=7.5e-07 nrd=1.16667 \
        nrs=1.16667 sa=5e-07 sb=2e-06 sd=160n sca=35.2411 scb=0.0263265 \
        scc=0.00456529 m=(1)
mp2 (\12\:GNbb \2\:GNbp \19\:VDD VDD) g45p1svt w=(2.15e-07) l=4.5e-08 \
        nf=1 as=1.06e-13 ad=3.44e-14 ps=2.41e-06 pd=7.5e-07 nrd=1.16667 \
        nrs=1.16667 sa=7.05e-07 sb=2e-06 sd=160n sca=35.2411 scb=0.0263265 \
        scc=0.00456529 m=(1)
mp0 (\4\:GNbp \1\:GN \1\:VDD VDD) g45p1svt w=(2.15e-07) l=4.5e-08 nf=1 \
        as=9.025e-14 ad=3.01e-14 ps=1.44e-06 pd=7.1e-07 nrd=1.16667 \
        nrs=1.16667 sa=2e-06 sb=1.4e-07 sd=160n sca=40.4761 scb=0.0335098 \
        scc=0.004697 m=(1)
C1 (QN VSS) capacitor c=2.5621e-17
C2 (GN VSS) capacitor c=7.65342e-17
C3 (VDD VSS) capacitor c=2.96686e-16
C4 (SN VSS) capacitor c=8.09166e-17
C5 (Q VSS) capacitor c=4.10643e-17
C6 (GNbb VSS) capacitor c=5.28057e-17
C7 (GNb VSS) capacitor c=7.09392e-17
C8 (n5 VSS) capacitor c=6.44128e-17
C9 (net354 VSS) capacitor c=1.07233e-18
C10 (net350 VSS) capacitor c=6.0807e-19
C11 (qint VSS) capacitor c=5.57515e-17
C12 (net326 VSS) capacitor c=6.47048e-19
C13 (GNbp VSS) capacitor c=2.56125e-17
C14 (net342 VSS) capacitor c=1.46331e-18
C15 (qbint VSS) capacitor c=1.55603e-16
C16 (net270 VSS) capacitor c=5.80807e-17
C17 (\1\:GN VSS) capacitor c=2.02057e-17
C18 (\4\:qint VSS) capacitor c=1.28996e-16
C19 (\1\:SN VSS) capacitor c=3.92915e-17
C20 (\4\:n5 VSS) capacitor c=4.2719e-17
C21 (\2\:GNbp VSS) capacitor c=6.71288e-17
C22 (\1\:RN VSS) capacitor c=3.65212e-17
C23 (\5\:RN VSS) capacitor c=2.84066e-17
C24 (\4\:GNbb VSS) capacitor c=4.04415e-17
C25 (\1\:D VSS) capacitor c=4.57463e-17
C26 (\4\:GN VSS) capacitor c=2.78357e-17
C27 (\3\:SN VSS) capacitor c=6.11234e-17
C28 (\3\:GNbp VSS) capacitor c=6.59159e-17
C29 (\6\:RN VSS) capacitor c=4.7301e-17
C30 (\4\:RN VSS) capacitor c=4.42989e-17
C31 (\2\:qint VSS) capacitor c=4.94166e-17
C32 (\6\:GNbb VSS) capacitor c=3.5902e-17
C33 (\3\:GNb VSS) capacitor c=2.89387e-17
C34 (\3\:D VSS) capacitor c=3.71733e-17
C35 (\3\:GNbb VSS) capacitor c=2.4371e-17
C36 (\3\:GN VSS) capacitor c=2.73773e-17
C37 (\2\:SN VSS) capacitor c=4.11587e-17
C38 (\3\:n5 VSS) capacitor c=2.06579e-17
C39 (\2\:RN VSS) capacitor c=2.18171e-17
C40 (\3\:qint VSS) capacitor c=3.02069e-17
C41 (\7\:GNbb VSS) capacitor c=2.32907e-17
C42 (\5\:GNbb VSS) capacitor c=5.32967e-17
C43 (\2\:GNb VSS) capacitor c=7.52681e-17
C44 (\2\:D VSS) capacitor c=5.85229e-17
C45 (\2\:GNbb VSS) capacitor c=5.18463e-17
C46 (\4\:GNbp VSS) capacitor c=2.29415e-16
C47 (\1\:VDD VSS) capacitor c=1.66344e-16
C48 (\3\:Q VSS) capacitor c=6.01976e-17
C49 (\11\:qbint VSS) capacitor c=3.45017e-17
C50 (\1\:QN VSS) capacitor c=5.77692e-17
C51 (\19\:VDD VSS) capacitor c=1.99158e-17
C52 (\23\:qint VSS) capacitor c=6.346e-17
C53 (\12\:GNbb VSS) capacitor c=5.57085e-17
C54 (\21\:VDD VSS) capacitor c=1.61165e-17
C55 (\23\:VDD VSS) capacitor c=2.58506e-17
C56 (\3\:net270 VSS) capacitor c=8.80405e-17
C57 (\6\:n5 VSS) capacitor c=2.19192e-16
C58 (\25\:VDD VSS) capacitor c=3.12337e-17
C59 (\4\:GNb VSS) capacitor c=1.33829e-17
C60 (\4\:VDD VSS) capacitor c=4.39573e-17
C61 (\7\:GNbp VSS) capacitor c=3.23379e-17
C62 (\1\:Q VSS) capacitor c=1.68535e-17
C63 (\9\:qbint VSS) capacitor c=1.96579e-17
C64 (\3\:QN VSS) capacitor c=2.15381e-17
C65 (\20\:qint VSS) capacitor c=7.89083e-17
C66 (\8\:GNbb VSS) capacitor c=2.56424e-17
C67 (\8\:n5 VSS) capacitor c=1.09083e-16
C68 (\7\:GNb VSS) capacitor c=6.9634e-17
C69 (\3\:RN VSS) capacitor c=2.36685e-17
C70 (\2\:n5 VSS) capacitor c=2.76859e-17
C71 (\8\:qint VSS) capacitor c=1.30152e-16
C72 (\4\:D VSS) capacitor c=4.07696e-17
C73 (\6\:D VSS) capacitor c=5.82761e-17
C74 (\6\:GNb VSS) capacitor c=9.54521e-17
C75 (\9\:GNb VSS) capacitor c=9.60926e-17
C76 (\7\:RN VSS) capacitor c=1.24133e-16
C77 (\10\:GNbb VSS) capacitor c=9.13352e-17
C78 (\11\:GNbb VSS) capacitor c=1.33147e-16
C79 (\14\:GNbb VSS) capacitor c=1.17921e-16
C80 (\15\:GNbb VSS) capacitor c=8.3387e-17
C81 (\16\:GNbb VSS) capacitor c=4.83693e-17
C82 (\5\:n5 VSS) capacitor c=1.9445e-16
C83 (\4\:SN VSS) capacitor c=2.98336e-17
C84 (\18\:qint VSS) capacitor c=6.24223e-17
C85 (\19\:qint VSS) capacitor c=6.04501e-17
C86 (\22\:qint VSS) capacitor c=1.14692e-16
C87 (\7\:qbint VSS) capacitor c=2.94022e-17
C88 (\8\:qbint VSS) capacitor c=2.75097e-17
C89 (\5\:GN VSS) capacitor c=5.23929e-17
C90 (\6\:GNbp VSS) capacitor c=2.52794e-16
C91 (\8\:VDD VSS) capacitor c=1.97875e-17
C92 (\9\:VDD VSS) capacitor c=2.64114e-17
C93 (\10\:VDD VSS) capacitor c=1.29247e-17
C94 (\12\:VDD VSS) capacitor c=2.02919e-17
Rk8 (\7\:RN RN) resistor r=0.02928 c=0
Rk55 (\1\:VSS \8\:VSS) resistor r=0.5284 c=0
Rk56 (\8\:VSS \9\:VSS) resistor r=0.303 c=0
Rk58 (\10\:VSS VSS) resistor r=0.1399 c=0
Rk57 (\9\:VSS \10\:VSS) resistor r=0.4108 c=0
Rk62 (\8\:VSS \18\:VSS) resistor r=0.122 c=0
Rk63 (\10\:VSS \20\:VSS) resistor r=0.287 c=0
Rk24 (QN \2\:QN) resistor r=0.194 c=0
Rk25 (QN \4\:QN) resistor r=0.0569 c=0
Rk1 (\4\:D \5\:D) resistor r=0.002943 c=0
Rk2 (D \6\:D) resistor r=0.002825 c=0
Rk3 (\4\:D \6\:D) resistor r=0.01545 c=0
Rk31 (\5\:GN GN) resistor r=0.01957 c=0
Rk38 (\1\:VDD \8\:VDD) resistor r=0.1099 c=0
Rk39 (\8\:VDD \9\:VDD) resistor r=0.3379 c=0
Rk40 (\9\:VDD \10\:VDD) resistor r=0.1992 c=0
Rk41 (\10\:VDD \11\:VDD) resistor r=0.1668 c=0
Rk43 (\12\:VDD VDD) resistor r=0.18 c=0
Rk42 (\11\:VDD \12\:VDD) resistor r=0.3707 c=0
Rk47 (\8\:VDD \20\:VDD) resistor r=0.07937 c=0
Rk48 (\9\:VDD \22\:VDD) resistor r=0.07346 c=0
Rk49 (\10\:VDD \24\:VDD) resistor r=0.04327 c=0
Rk50 (\12\:VDD \26\:VDD) resistor r=0.223 c=0
Rk19 (\4\:SN SN) resistor r=0.02695 c=0
Rk29 (Q \2\:Q) resistor r=0.03074 c=0
Rk30 (Q \4\:Q) resistor r=0.189 c=0
Rk9 (\9\:GNbb \10\:GNbb) resistor r=0.2005 c=0
Rk10 (\10\:GNbb \11\:GNbb) resistor r=0.549 c=0
Rk11 (\10\:GNbb \13\:GNbb) resistor r=0.2021 c=0
Rk12 (\11\:GNbb \14\:GNbb) resistor r=0.7169 c=0
Rk13 (\14\:GNbb \15\:GNbb) resistor r=0.4251 c=0
Rk14 (\14\:GNbb \16\:GNbb) resistor r=0.2083 c=0
Rk4 (\5\:GNb \6\:GNb) resistor r=0.04758 c=0
Rk5 (\6\:GNb \8\:GNb) resistor r=0.5623 c=0
Rk6 (\6\:GNb \9\:GNb) resistor r=0.6156 c=0
Rk15 (\5\:n5 \7\:n5) resistor r=1.3953 c=0
Rk16 (\7\:n5 \9\:n5) resistor r=0.6286 c=0
Rk20 (\18\:qint \19\:qint) resistor r=0.37 c=0
Rk21 (\19\:qint \21\:qint) resistor r=0.1351 c=0
Rk22 (\21\:qint \22\:qint) resistor r=0.8444 c=0
Rk23 (\19\:qint \24\:qint) resistor r=0.2567 c=0
Rk32 (\5\:GNbp \6\:GNbp) resistor r=1.9338 c=0
Rk33 (\5\:GNbp \8\:GNbp) resistor r=0.2905 c=0
Rk26 (\7\:qbint \8\:qbint) resistor r=0.176 c=0
Rk27 (\8\:qbint \10\:qbint) resistor r=0.1474 c=0
Rk28 (\8\:qbint \12\:qbint) resistor r=0.1055 c=0
Rk7 (\2\:net270 \4\:net270) resistor r=0.3525 c=0
Rl11 (\1\:RN \2\:RN) resistor r=71.4298 c=0
Rl14 (\2\:RN \5\:RN) resistor r=24.2328 c=0
Rl15 (\3\:RN \6\:RN) resistor r=90.3625 c=0
Rl13 (\3\:RN \4\:RN) resistor r=65.3625 c=0
Rl12 (\2\:RN \3\:RN) resistor r=45.0682 c=0
Rl3 (\1\:D \2\:D) resistor r=130.002 c=0
Rl4 (\2\:D \3\:D) resistor r=87.6944 c=0
Rl41 (\1\:GN \2\:GN) resistor r=49.7185 c=0
Rl43 (\2\:GN \4\:GN) resistor r=65.1031 c=0
Rl42 (\2\:GN \3\:GN) resistor r=3.3229 c=0
Rl21 (\1\:SN \2\:SN) resistor r=29.5379 c=0
Rl22 (\2\:SN \3\:SN) resistor r=56.461 c=0
Rl8 (\6\:GNbb \7\:GNbb) resistor r=29.5379 c=0
Rl5 (\4\:GNbb \5\:GNbb) resistor r=106.02 c=0
Rl1 (GNbb \2\:GNbb) resistor r=188.462 c=0
Rl2 (\2\:GNbb \3\:GNbb) resistor r=32.8815 c=0
Rl6 (GNb \2\:GNb) resistor r=279.579 c=0
Rl7 (\2\:GNb \3\:GNb) resistor r=76.1559 c=0
Rl20 (\2\:n5 \4\:n5) resistor r=23.7402 c=0
Rl18 (n5 \2\:n5) resistor r=111.847 c=0
Rl19 (\2\:n5 \3\:n5) resistor r=5.1011 c=0
Rl9 (\2\:qint qint) resistor r=142.308 c=0
Rl10 (\3\:qint \2\:qint) resistor r=24.2328 c=0
Rl26 (\8\:qint \4\:qint) resistor r=72.3971 c=0
Rl17 (\2\:GNbp \3\:GNbp) resistor r=170.72 c=0
Rl16 (GNbp \2\:GNbp) resistor r=81.461 c=0
Rz15 (\18\:VSS \17\:VSS) resistor r=75 c=0
Rz16 (\20\:VSS \19\:VSS) resistor r=75 c=0
Rz5 (\4\:QN \3\:QN) resistor r=75 c=0
Rz9 (\1\:VDD \4\:VDD) resistor r=6.25 c=0
Rz10 (\11\:VDD \4\:VDD) resistor r=6.25 c=0
Rz7 (\2\:Q \1\:Q) resistor r=75 c=0
Rz2 (\8\:GNbb \9\:GNbb) resistor r=75 c=0
Rz1 (\7\:GNb \8\:GNb) resistor r=75 c=0
Rz3 (\8\:n5 \9\:n5) resistor r=75 c=0
Rz4 (\21\:qint \20\:qint) resistor r=75 c=0
Rz8 (\7\:GNbp \8\:GNbp) resistor r=75 c=0
Rz6 (\10\:qbint \9\:qbint) resistor r=75 c=0
Ry19 (\1\:VSS \4\:VSS) resistor r=5.1667 c=0
Ry20 (\9\:VSS \4\:VSS) resistor r=5.1667 c=0
Ry7 (\2\:QN \1\:QN) resistor r=62 c=0
Ry15 (\20\:VDD \19\:VDD) resistor r=62 c=0
Ry16 (\22\:VDD \21\:VDD) resistor r=62 c=0
Ry17 (\24\:VDD \23\:VDD) resistor r=62 c=0
Ry18 (\26\:VDD \25\:VDD) resistor r=62 c=0
Ry9 (\4\:Q \3\:Q) resistor r=62 c=0
Ry4 (\12\:GNbb \13\:GNbb) resistor r=62 c=0
Ry1 (\4\:GNb \5\:GNb) resistor r=62 c=0
Ry5 (\6\:n5 \7\:n5) resistor r=62 c=0
Ry6 (\24\:qint \23\:qint) resistor r=62 c=0
Ry10 (\4\:GNbp \5\:GNbp) resistor r=62 c=0
Ry8 (\12\:qbint \11\:qbint) resistor r=62 c=0
Ry2 (net270 \2\:net270) resistor r=62 c=0
Ry3 (\3\:net270 \4\:net270) resistor r=62 c=0
Rx3 (\2\:RN \7\:RN) resistor r=45 c=0
Rx1 (\2\:D \5\:D) resistor r=45 c=0
Rx12 (\3\:GN \5\:GN) resistor r=45 c=0
Rx8 (\2\:SN \4\:SN) resistor r=45 c=0
Rx4 (\7\:GNbb \11\:GNbb) resistor r=45 c=0
Rx5 (\2\:GNbb \15\:GNbb) resistor r=45 c=0
Rx6 (\5\:GNbb \16\:GNbb) resistor r=45 c=0
Rx2 (\2\:GNb \9\:GNb) resistor r=45 c=0
Rx7 (\3\:n5 \5\:n5) resistor r=45 c=0
Rx9 (\18\:qint \8\:qint) resistor r=45 c=0
Rx10 (\22\:qint \3\:qint) resistor r=45 c=0
Rx13 (GNbp \6\:GNbp) resistor r=45 c=0
Rx11 (\7\:qbint qbint) resistor r=45 c=0
mn3 (\7\:GNb \3\:GNbb \19\:VSS VSS) g45n1svt w=(1.45e-07) l=4.5e-08 nf=1 \
        as=3.045e-14 ad=2.03e-14 ps=7.1e-07 pd=5.7e-07 nrd=1.16667 \
        nrs=1.16667 sa=1.4e-07 sb=1.915e-06 sd=160n sca=11.7118 \
        scb=0.0116498 scc=0.000458536 m=(1)
mn5 (net366 \3\:D \19\:VSS VSS) g45n1svt w=(1.45e-07) l=4.5e-08 nf=1 \
        as=3.045e-14 ad=2.9e-14 ps=7.1e-07 pd=6.9e-07 nrd=1.16667 \
        nrs=1.16667 sa=3.95e-07 sb=1.66e-06 sd=160n sca=11.7118 \
        scb=0.0116498 scc=0.000458536 m=(1)
mn6 (\8\:n5 \3\:GNb net366 VSS) g45n1svt w=(1.45e-07) l=4.5e-08 nf=1 \
        as=2.9e-14 ad=6.235e-14 ps=6.9e-07 pd=1.15e-06 nrd=1.16667 \
        nrs=1.16667 sa=6.4e-07 sb=1.415e-06 sd=160n sca=11.7118 \
        scb=0.0116498 scc=0.000458536 m=(1)
mn17 (\8\:n5 \6\:GNbb net354 VSS) g45n1svt w=(1.45e-07) l=4.5e-08 nf=1 \
        as=3.915e-14 ad=6.235e-14 ps=8.3e-07 pd=1.15e-06 nrd=1.16667 \
        nrs=1.16667 sa=1.115e-06 sb=9.4e-07 sd=160n sca=11.7118 \
        scb=0.0116498 scc=0.000458536 m=(1)
mn16 (net354 \2\:qint net350 VSS) g45n1svt w=(1.45e-07) l=4.5e-08 nf=1 \
        as=8.7e-15 ad=3.915e-14 ps=4.1e-07 pd=8.3e-07 nrd=1.16667 \
        nrs=1.16667 sa=1.43e-06 sb=6.25e-07 sd=160n sca=11.7118 \
        scb=0.0116498 scc=0.000458536 m=(1)
mn15 (net350 \4\:RN \17\:VSS VSS) g45n1svt w=(1.45e-07) l=4.5e-08 nf=1 \
        as=6.13e-14 ad=8.7e-15 ps=1.22e-06 pd=4.1e-07 nrd=1.16667 \
        nrs=1.16667 sa=1.535e-06 sb=5.2e-07 sd=160n sca=11.7118 \
        scb=0.0116498 scc=0.000458536 m=(1)
mn1 (net326 \6\:RN \17\:VSS VSS) g45n1svt w=(1.45e-07) l=4.5e-08 nf=1 \
        as=6.13e-14 ad=1.015e-14 ps=1.22e-06 pd=4.3e-07 nrd=1.16667 \
        nrs=1.16667 sa=1.8e-06 sb=2.55e-07 sd=160n sca=11.7118 \
        scb=0.0116498 scc=0.000458536 m=(1)
mn2 (\8\:GNbb \3\:GNbp net326 VSS) g45n1svt w=(1.45e-07) l=4.5e-08 nf=1 \
        as=1.015e-14 ad=2.03e-14 ps=4.3e-07 pd=5.7e-07 nrd=1.16667 \
        nrs=1.16667 sa=1.915e-06 sb=1.4e-07 sd=160n sca=11.7118 \
        scb=0.0116498 scc=0.000458536 m=(1)
mn0 (\7\:GNbp \4\:GN \1\:VSS VSS) g45n1svt w=(1.45e-07) l=4.5e-08 nf=1 \
        as=5.597e-14 ad=2.32e-14 ps=1.07e-06 pd=6.1e-07 nrd=1.16667 \
        nrs=1.16667 sa=2e-06 sb=1.6e-07 sd=160n sca=18.4982 scb=0.0194884 \
        scc=0.00168796 m=(1)
mn11 (\20\:qint n5 net342 VSS) g45n1svt w=(2.05e-07) l=4.5e-08 nf=1 \
        as=1.23e-14 ad=2.87e-14 ps=5.3e-07 pd=6.9e-07 nrd=1.16667 \
        nrs=1.16667 sa=1.4e-07 sb=1.90634e-06 sd=160n sca=16.0682 \
        scb=0.0166045 scc=0.00126927 m=(1)
mn10 (net342 \3\:SN \1\:VSS VSS) g45n1svt w=(2.05e-07) l=4.5e-08 nf=1 \
        as=5.587e-14 ad=1.23e-14 ps=9.9e-07 pd=5.3e-07 nrd=1.16667 \
        nrs=1.16667 sa=2.45e-07 sb=1.81549e-06 sd=160n sca=16.0682 \
        scb=0.0166045 scc=0.00126927 m=(1)
mn20_1__rcx (\9\:qbint \4\:qint \1\:VSS VSS) g45n1svt w=(2.6e-07) \
        l=4.5e-08 nf=1 as=5.07e-14 ad=5.07e-14 ps=9.1e-07 pd=9.1e-07 \
        nrd=1.16667 nrs=1.16667 sa=8.78558e-07 sb=1.04962e-06 sd=160n \
        sca=14.4034 scb=0.0144248 scc=0.00102063 m=(2)
mn22_1__rcx (\3\:QN \8\:qint \1\:VSS VSS) g45n1svt w=(2.6e-07) l=4.5e-08 \
        nf=1 as=4.874e-14 ad=4.81e-14 ps=9.15e-07 pd=8.9e-07 nrd=1.16667 \
        nrs=1.16667 sa=4.43558e-07 sb=1.48462e-06 sd=160n sca=14.4034 \
        scb=0.0144248 scc=0.00102063 m=(2)
mn21_1__rcx (\1\:Q qbint \1\:VSS VSS) g45n1svt w=(2.6e-07) l=4.5e-08 \
        nf=1 as=5.789e-14 ad=4.16e-14 ps=1.025e-06 pd=8.4e-07 nrd=1.16667 \
        nrs=1.16667 sa=1.39356e-06 sb=5.34615e-07 sd=160n sca=14.4034 \
        scb=0.0144248 scc=0.00102063 m=(2)
mp11 (\23\:qint \4\:n5 \19\:VDD VDD) g45p1svt w=(3.1e-07) l=4.5e-08 nf=1 \
        as=1.06e-13 ad=6.51e-14 ps=2.41e-06 pd=1.04e-06 nrd=1.16667 \
        nrs=1.16667 sa=6.75645e-07 sb=1.98008e-06 sd=160n sca=28.1356 \
        scb=0.0216057 scc=0.00325451 m=(1)
mp10 (\23\:qint \1\:SN \1\:VDD VDD) g45p1svt w=(3.1e-07) l=4.5e-08 nf=1 \
        as=1.0525e-13 ad=6.51e-14 ps=2.03e-06 pd=1.04e-06 nrd=1.16667 \
        nrs=1.16667 sa=9.30645e-07 sb=1.84298e-06 sd=160n sca=28.1356 \
        scb=0.0216057 scc=0.00325451 m=(1)
mp21 (\3\:Q qbint \1\:VDD VDD) g45p1svt w=(3.9e-07) l=4.5e-08 nf=1 \
        as=9.477e-14 ad=9.165e-14 ps=1.42e-06 pd=1.25e-06 nrd=1.16667 \
        nrs=1.16667 sa=1.70404e-06 sb=5.79551e-07 sd=160n sca=24.5929 \
        scb=0.0186977 scc=0.00260099 m=(2)
mp20_1__rcx (\11\:qbint \4\:qint \1\:VDD VDD) g45p1svt w=(3.9e-07) \
        l=4.5e-08 nf=1 as=9.735e-14 ad=6.24e-14 ps=1.39e-06 pd=1.1e-06 \
        nrd=1.16667 nrs=1.16667 sa=1.45282e-06 sb=1.05955e-06 sd=160n \
        sca=24.4353 scb=0.0186618 scc=0.00260099 m=(2)
mp22 (\1\:QN \8\:qint \1\:VDD VDD) g45p1svt w=(3.9e-07) l=4.5e-08 nf=1 \
        as=1.0033e-13 ad=6.24e-14 ps=1.705e-06 pd=1.1e-06 nrd=1.16667 \
        nrs=1.16667 sa=9.82821e-07 sb=1.52955e-06 sd=160n sca=24.4353 \
        scb=0.0186618 scc=0.00260099 m=(2)
ends TLATNSRX2
// End of subcircuit definition.
