// Generated for: spectre (May  1 08:13:13 2013 )
// Library name: gsclib045
// Cell name: SPDFF2RX1
// View name: extracted

simulator lang=spectre

subckt SPDFF2RX1 CK D1 D2 Q1 Q1N Q2 Q2N RN SE SI1 SI2 VDD VSS VSS VDD
PM19 (\3\:Q2N qint_2 \1\:VDD VDD) g45p1svt w=(3.9e-07) l=4.5e-08 nf=1 \
        as=5.46e-14 ad=9.843e-14 ps=1.06e-06 pd=1.97e-06 nrd=1.16667 \
        nrs=1.16667 sa=1.4e-07 sb=2.49744e-07 sd=160n sca=41.7168 \
        scb=0.0364245 scc=0.00429626 m=(1)
PM17 (\1\:Q2 \10\:qbint_2 \23\:VDD VDD) g45p1svt w=(3.9e-07) l=4.5e-08 \
        nf=1 as=8.385e-14 ad=1.4115e-13 ps=1.59e-06 pd=2.12e-06 \
        nrd=1.16667 nrs=1.16667 sa=1.4e-07 sb=1.17795e-06 sd=160n \
        sca=30.6824 scb=0.0202434 scc=0.00336098 m=(1)
mp57 (\3\:Q1N \4\:qint \49\:VDD VDD) g45p1svt w=(3.9e-07) l=4.5e-08 nf=1 \
        as=5.46e-14 ad=9.842e-14 ps=1.06e-06 pd=1.97e-06 nrd=1.16667 \
        nrs=1.16667 sa=1.4e-07 sb=2.49744e-07 sd=160n sca=41.7168 \
        scb=0.0364245 scc=0.00429626 m=(1)
mp55 (\3\:Q1 qbint \47\:VDD VDD) g45p1svt w=(3.9e-07) l=4.5e-08 nf=1 \
        as=8.385e-14 ad=1.4115e-13 ps=1.59e-06 pd=2.12e-06 nrd=1.16667 \
        nrs=1.16667 sa=1.4e-07 sb=1.17795e-06 sd=160n sca=30.6824 \
        scb=0.0202434 scc=0.00336098 m=(1)
C1 (VDD VSS) capacitor c=9.02071e-16
C2 (SE VSS) capacitor c=2.71758e-17
C3 (RN VSS) capacitor c=3.54719e-17
C4 (Q1N VSS) capacitor c=1.93123e-17
C5 (Q1 VSS) capacitor c=5.49642e-17
C6 (D1 VSS) capacitor c=2.01214e-17
C7 (Q2N VSS) capacitor c=1.93545e-17
C8 (Q2 VSS) capacitor c=5.4444e-17
C9 (D2 VSS) capacitor c=2.07156e-17
C10 (CK VSS) capacitor c=4.60785e-17
C11 (Ckbb VSS) capacitor c=2.20379e-17
C12 (CKb VSS) capacitor c=3.43291e-17
C13 (Db VSS) capacitor c=5.02186e-17
C14 (qint VSS) capacitor c=2.28104e-17
C15 (n8 VSS) capacitor c=1.80574e-18
C16 (n6 VSS) capacitor c=6.69684e-17
C17 (SEb VSS) capacitor c=4.29388e-17
C18 (qbint VSS) capacitor c=4.50607e-17
C19 (n20 VSS) capacitor c=2.55522e-17
C20 (n30 VSS) capacitor c=3.62459e-17
C21 (mout VSS) capacitor c=5.23006e-17
C22 (n2 VSS) capacitor c=3.96884e-18
C23 (n4 VSS) capacitor c=1.50187e-18
C24 (n9 VSS) capacitor c=5.88253e-19
C25 (n11 VSS) capacitor c=3.08511e-18
C26 (n5 VSS) capacitor c=2.3104e-19
C27 (n1 VSS) capacitor c=2.88673e-18
C28 (Db_2 VSS) capacitor c=1.02121e-16
C29 (qint_2 VSS) capacitor c=5.13179e-17
C30 (n8_2 VSS) capacitor c=1.80578e-18
C31 (n6_2 VSS) capacitor c=7.4595e-17
C32 (SEb_2 VSS) capacitor c=5.68096e-17
C33 (qbint_2 VSS) capacitor c=4.73237e-17
C34 (n20_2 VSS) capacitor c=4.67187e-17
C35 (n30_2 VSS) capacitor c=4.67885e-17
C36 (mout_2 VSS) capacitor c=5.25797e-17
C37 (n2_2 VSS) capacitor c=3.95036e-18
C38 (n4_2 VSS) capacitor c=1.50247e-18
C39 (n9_2 VSS) capacitor c=5.52712e-19
C40 (n11_2 VSS) capacitor c=3.08511e-18
C41 (n5_2 VSS) capacitor c=2.3104e-19
C42 (n1_2 VSS) capacitor c=2.88673e-18
C43 (\4\:qbint_2 VSS) capacitor c=3.79654e-17
C44 (\10\:qbint_2 VSS) capacitor c=4.54449e-17
C45 (\13\:RN VSS) capacitor c=3.04484e-17
C46 (\12\:Ckbb VSS) capacitor c=7.65173e-17
C47 (\15\:CKb VSS) capacitor c=2.87148e-17
C48 (\9\:RN VSS) capacitor c=6.5104e-17
C49 (\13\:CKb VSS) capacitor c=3.75016e-17
C50 (\8\:Ckbb VSS) capacitor c=9.09069e-17
C51 (\1\:D2 VSS) capacitor c=4.76438e-17
C52 (\13\:SE VSS) capacitor c=4.13386e-17
C53 (\3\:SEb_2 VSS) capacitor c=4.27899e-17
C54 (\3\:SI2 VSS) capacitor c=8.33648e-17
C55 (\8\:SE VSS) capacitor c=4.63984e-17
C56 (\1\:CK VSS) capacitor c=3.97193e-17
C57 (\11\:CKb VSS) capacitor c=3.4982e-17
C58 (\5\:SE VSS) capacitor c=4.42336e-17
C59 (\3\:SI1 VSS) capacitor c=8.19498e-17
C60 (\1\:SE VSS) capacitor c=4.09455e-17
C61 (\1\:D1 VSS) capacitor c=4.65702e-17
C62 (\6\:Ckbb VSS) capacitor c=9.02271e-17
C63 (\6\:CKb VSS) capacitor c=3.66746e-17
C64 (\6\:RN VSS) capacitor c=6.54428e-17
C65 (\4\:n20 VSS) capacitor c=4.61486e-17
C66 (\3\:CKb VSS) capacitor c=2.85052e-17
C67 (\3\:Ckbb VSS) capacitor c=7.66783e-17
C68 (\8\:qbint VSS) capacitor c=4.82946e-17
C69 (\3\:RN VSS) capacitor c=3.05845e-17
C70 (\3\:n30 VSS) capacitor c=4.54106e-17
C71 (\7\:qbint VSS) capacitor c=3.74468e-17
C72 (\4\:qint VSS) capacitor c=5.02517e-17
C73 (\4\:qint_2 VSS) capacitor c=3.98003e-17
C74 (\8\:qbint_2 VSS) capacitor c=3.5269e-17
C75 (\9\:qbint_2 VSS) capacitor c=3.12857e-17
C76 (\3\:n30_2 VSS) capacitor c=3.69005e-17
C77 (\11\:RN VSS) capacitor c=4.43684e-17
C78 (\3\:qbint_2 VSS) capacitor c=3.89788e-17
C79 (\17\:CKb VSS) capacitor c=3.408e-17
C80 (\13\:Ckbb VSS) capacitor c=6.02139e-17
C81 (\4\:n20_2 VSS) capacitor c=4.02749e-17
C82 (\10\:RN VSS) capacitor c=8.26827e-17
C83 (\3\:mout_2 VSS) capacitor c=4.93331e-17
C84 (\10\:Ckbb VSS) capacitor c=5.79088e-17
C85 (\12\:CKb VSS) capacitor c=5.7991e-17
C86 (\3\:D2 VSS) capacitor c=4.06457e-17
C87 (\11\:SE VSS) capacitor c=4.33001e-17
C88 (\1\:SI2 VSS) capacitor c=5.68102e-17
C89 (\10\:SE VSS) capacitor c=4.0503e-17
C90 (\3\:CK VSS) capacitor c=4.14933e-17
C91 (\10\:CKb VSS) capacitor c=3.06741e-17
C92 (\7\:SE VSS) capacitor c=4.03782e-17
C93 (\1\:SI1 VSS) capacitor c=5.48548e-17
C94 (\3\:SE VSS) capacitor c=4.33001e-17
C95 (\3\:SEb VSS) capacitor c=5.71879e-17
C96 (\3\:D1 VSS) capacitor c=4.06724e-17
C97 (\7\:CKb VSS) capacitor c=5.81134e-17
C98 (\4\:Ckbb VSS) capacitor c=5.79329e-17
C99 (\3\:mout VSS) capacitor c=4.93391e-17
C100 (\5\:RN VSS) capacitor c=8.25598e-17
C101 (\3\:n20 VSS) capacitor c=3.9835e-17
C102 (\2\:Ckbb VSS) capacitor c=6.03046e-17
C103 (\10\:qbint VSS) capacitor c=3.89788e-17
C104 (\1\:RN VSS) capacitor c=4.41774e-17
C105 (\5\:qbint VSS) capacitor c=3.10294e-17
C106 (\4\:qbint VSS) capacitor c=3.52782e-17
C107 (\3\:qint VSS) capacitor c=3.97237e-17
C108 (\3\:qint_2 VSS) capacitor c=2.26452e-17
C109 (\7\:qbint_2 VSS) capacitor c=2.50119e-17
C110 (\2\:n30_2 VSS) capacitor c=4.3584e-17
C111 (\14\:RN VSS) capacitor c=3.13443e-17
C112 (\12\:RN VSS) capacitor c=1.37873e-16
C113 (\2\:qbint_2 VSS) capacitor c=4.34767e-17
C114 (\18\:CKb VSS) capacitor c=5.05399e-17
C115 (\14\:Ckbb VSS) capacitor c=2.20571e-17
C116 (\16\:CKb VSS) capacitor c=3.93206e-17
C117 (\3\:n20_2 VSS) capacitor c=2.51537e-17
C118 (\8\:RN VSS) capacitor c=2.95257e-17
C119 (\2\:mout_2 VSS) capacitor c=4.88216e-17
C120 (\11\:Ckbb VSS) capacitor c=2.1772e-17
C121 (\14\:CKb VSS) capacitor c=4.08654e-17
C122 (\9\:Ckbb VSS) capacitor c=4.46127e-17
C123 (\2\:D2 VSS) capacitor c=3.6553e-17
C124 (\14\:SE VSS) capacitor c=5.0586e-17
C125 (\2\:SEb_2 VSS) capacitor c=7.66847e-17
C126 (\12\:SE VSS) capacitor c=5.01789e-17
C127 (\2\:SI2 VSS) capacitor c=4.89202e-17
C128 (\9\:SE VSS) capacitor c=2.58441e-17
C129 (\2\:CK VSS) capacitor c=3.26581e-17
C130 (\8\:CKb VSS) capacitor c=2.08504e-17
C131 (\6\:SE VSS) capacitor c=2.66574e-17
C132 (\2\:SI1 VSS) capacitor c=4.89409e-17
C133 (\4\:SE VSS) capacitor c=5.02371e-17
C134 (\2\:SEb VSS) capacitor c=7.59001e-17
C135 (\2\:SE VSS) capacitor c=5.05765e-17
C136 (\2\:D1 VSS) capacitor c=3.65361e-17
C137 (\7\:Ckbb VSS) capacitor c=4.45378e-17
C138 (\5\:CKb VSS) capacitor c=4.08432e-17
C139 (\5\:Ckbb VSS) capacitor c=2.1772e-17
C140 (\2\:mout VSS) capacitor c=4.88184e-17
C141 (\7\:RN VSS) capacitor c=2.96489e-17
C142 (\4\:CKb VSS) capacitor c=3.98233e-17
C143 (\2\:CKb VSS) capacitor c=5.05454e-17
C144 (\9\:qbint VSS) capacitor c=4.34926e-17
C145 (\2\:RN VSS) capacitor c=1.37944e-16
C146 (\4\:RN VSS) capacitor c=3.13054e-17
C147 (\2\:n30 VSS) capacitor c=4.36322e-17
C148 (\3\:Q2N VSS) capacitor c=6.90746e-17
C149 (\1\:VDD VSS) capacitor c=3.54955e-17
C150 (\9\:qint_2 VSS) capacitor c=3.17828e-17
C151 (\1\:Q2 VSS) capacitor c=6.16371e-17
C152 (\23\:VDD VSS) capacitor c=2.46467e-17
C153 (\13\:qbint_2 VSS) capacitor c=1.24381e-16
C154 (\25\:VDD VSS) capacitor c=2.60349e-17
C155 (\4\:n30_2 VSS) capacitor c=8.565e-17
C156 (\4\:mout_2 VSS) capacitor c=5.58902e-17
C157 (\27\:VDD VSS) capacitor c=1.92728e-17
C158 (\29\:VDD VSS) capacitor c=2.15646e-17
C159 (\3\:n6_2 VSS) capacitor c=6.72001e-17
C160 (\7\:n20_2 VSS) capacitor c=6.84785e-17
C161 (\4\:Db_2 VSS) capacitor c=8.96735e-17
C162 (\31\:VDD VSS) capacitor c=1.93779e-17
C163 (\6\:Db_2 VSS) capacitor c=5.02548e-17
C164 (\33\:VDD VSS) capacitor c=2.4514e-17
C165 (\5\:SEb_2 VSS) capacitor c=1.07963e-16
C166 (\32\:CKb VSS) capacitor c=3.56648e-17
C167 (\35\:VDD VSS) capacitor c=1.73098e-17
C168 (\17\:Ckbb VSS) capacitor c=1.187e-16
C169 (\6\:SEb VSS) capacitor c=1.08338e-16
C170 (\37\:VDD VSS) capacitor c=2.41324e-17
C171 (\39\:VDD VSS) capacitor c=1.93791e-17
C172 (\4\:Db VSS) capacitor c=8.91209e-17
C173 (\5\:n20 VSS) capacitor c=6.86505e-17
C174 (\41\:VDD VSS) capacitor c=2.14555e-17
C175 (\3\:n6 VSS) capacitor c=7.53754e-17
C176 (\43\:VDD VSS) capacitor c=1.94301e-17
C177 (\8\:mout VSS) capacitor c=5.58106e-17
C178 (\4\:n30 VSS) capacitor c=8.57349e-17
C179 (\45\:VDD VSS) capacitor c=2.60092e-17
C180 (\12\:qbint VSS) capacitor c=1.24029e-16
C181 (\47\:VDD VSS) capacitor c=2.46042e-17
C182 (\3\:Q1 VSS) capacitor c=6.13477e-17
C183 (\5\:qint VSS) capacitor c=3.28002e-17
C184 (\49\:VDD VSS) capacitor c=2.03117e-17
C185 (\3\:Q1N VSS) capacitor c=6.90694e-17
C186 (\3\:VDD VSS) capacitor c=8.37657e-17
C187 (\1\:Q2N VSS) capacitor c=3.11914e-17
C188 (\7\:qint_2 VSS) capacitor c=3.33391e-17
C189 (\3\:Q2 VSS) capacitor c=3.66938e-17
C190 (\16\:qbint_2 VSS) capacitor c=4.64575e-17
C191 (\6\:n30_2 VSS) capacitor c=1.40848e-16
C192 (\8\:mout_2 VSS) capacitor c=2.99275e-17
C193 (\9\:n20_2 VSS) capacitor c=4.63673e-17
C194 (\8\:Db_2 VSS) capacitor c=7.30619e-17
C195 (\7\:SEb_2 VSS) capacitor c=7.84545e-17
C196 (\29\:CKb VSS) capacitor c=5.71647e-17
C197 (\15\:Ckbb VSS) capacitor c=5.36013e-16
C198 (\4\:SEb VSS) capacitor c=7.93173e-17
C199 (\6\:Db VSS) capacitor c=1.02356e-16
C200 (\8\:Db VSS) capacitor c=7.33177e-17
C201 (\9\:n20 VSS) capacitor c=4.63855e-17
C202 (\6\:mout VSS) capacitor c=2.99539e-17
C203 (\6\:n30 VSS) capacitor c=1.42341e-16
C204 (\16\:qbint VSS) capacitor c=4.63783e-17
C205 (\1\:Q1 VSS) capacitor c=3.61388e-17
C206 (\9\:qint VSS) capacitor c=3.3341e-17
C207 (\1\:Q1N VSS) capacitor c=3.11914e-17
C208 (\2\:qint VSS) capacitor c=7.48686e-18
C209 (\2\:qbint VSS) capacitor c=2.51475e-17
C210 (\3\:qbint VSS) capacitor c=3.82094e-17
C211 (\2\:n20 VSS) capacitor c=2.37037e-17
C212 (\9\:CKb VSS) capacitor c=1.35609e-17
C213 (\7\:qint VSS) capacitor c=3.66181e-17
C214 (\8\:qint VSS) capacitor c=2.41783e-17
C215 (\11\:qbint VSS) capacitor c=9.56896e-17
C216 (\14\:qbint VSS) capacitor c=4.87196e-17
C217 (\15\:qbint VSS) capacitor c=2.06706e-17
C218 (\8\:n30 VSS) capacitor c=1.32679e-16
C219 (\4\:mout VSS) capacitor c=7.81825e-17
C220 (\5\:mout VSS) capacitor c=7.29173e-17
C221 (\7\:n20 VSS) capacitor c=9.93508e-17
C222 (\8\:n20 VSS) capacitor c=1.0267e-16
C223 (\2\:n20_2 VSS) capacitor c=2.31147e-17
C224 (\4\:D1 VSS) capacitor c=5.22623e-17
C225 (\3\:Db VSS) capacitor c=1.03859e-16
C226 (\4\:SI1 VSS) capacitor c=3.03601e-17
C227 (\6\:SI1 VSS) capacitor c=4.21091e-17
C228 (\8\:SEb VSS) capacitor c=9.2243e-17
C229 (\5\:qbint_2 VSS) capacitor c=3.74914e-17
C230 (\5\:CK VSS) capacitor c=4.91349e-17
C231 (\2\:qint_2 VSS) capacitor c=7.57237e-18
C232 (\4\:SI2 VSS) capacitor c=4.23153e-17
C233 (\5\:SI2 VSS) capacitor c=3.02383e-17
C234 (\4\:SEb_2 VSS) capacitor c=9.20617e-17
C235 (\4\:D2 VSS) capacitor c=5.22724e-17
C236 (\3\:Db_2 VSS) capacitor c=1.04652e-16
C237 (\5\:n20_2 VSS) capacitor c=1.0264e-16
C238 (\6\:n20_2 VSS) capacitor c=9.99378e-17
C239 (\6\:mout_2 VSS) capacitor c=7.30139e-17
C240 (\7\:mout_2 VSS) capacitor c=7.82979e-17
C241 (\8\:n30_2 VSS) capacitor c=1.32992e-16
C242 (\11\:qbint_2 VSS) capacitor c=2.07013e-17
C243 (\12\:qbint_2 VSS) capacitor c=4.87469e-17
C244 (\15\:qbint_2 VSS) capacitor c=9.57939e-17
C245 (\5\:qint_2 VSS) capacitor c=2.41278e-17
C246 (\6\:qint_2 VSS) capacitor c=3.63894e-17
C247 (\19\:CKb VSS) capacitor c=1.12001e-16
C248 (\20\:CKb VSS) capacitor c=6.55717e-16
C249 (\21\:CKb VSS) capacitor c=3.97172e-16
C250 (\22\:CKb VSS) capacitor c=4.80862e-16
C251 (\23\:CKb VSS) capacitor c=3.8269e-16
C252 (\24\:CKb VSS) capacitor c=6.55929e-16
C253 (\25\:CKb VSS) capacitor c=1.12143e-16
C254 (\26\:CKb VSS) capacitor c=7.15436e-17
C255 (\27\:CKb VSS) capacitor c=3.64179e-17
C256 (\28\:CKb VSS) capacitor c=1.07134e-16
C257 (\31\:CKb VSS) capacitor c=7.24681e-17
C258 (\15\:RN VSS) capacitor c=4.40218e-16
C259 (\16\:RN VSS) capacitor c=4.09551e-16
C260 (\17\:RN VSS) capacitor c=5.87529e-16
C261 (\18\:RN VSS) capacitor c=4.48783e-16
C262 (\19\:RN VSS) capacitor c=4.40672e-16
C263 (\15\:SE VSS) capacitor c=5.51509e-17
C264 (\16\:SE VSS) capacitor c=1.09945e-15
C265 (\17\:SE VSS) capacitor c=2.32487e-16
C266 (\18\:SE VSS) capacitor c=2.47655e-16
C267 (\19\:SE VSS) capacitor c=1.10047e-15
C268 (\20\:SE VSS) capacitor c=5.50702e-17
C269 (\21\:SE VSS) capacitor c=8.53934e-17
C270 (\22\:SE VSS) capacitor c=5.77444e-17
C271 (\19\:Ckbb VSS) capacitor c=6.09537e-16
C272 (\20\:Ckbb VSS) capacitor c=1.58024e-16
C273 (\21\:Ckbb VSS) capacitor c=3.21209e-16
C274 (\23\:Ckbb VSS) capacitor c=2.34438e-16
C275 (\24\:Ckbb VSS) capacitor c=1.57961e-16
C276 (\25\:Ckbb VSS) capacitor c=6.09653e-16
C277 (\5\:VDD VSS) capacitor c=1.45107e-17
C278 (\6\:VDD VSS) capacitor c=2.32062e-17
C279 (\8\:VDD VSS) capacitor c=4.87412e-18
C280 (\9\:VDD VSS) capacitor c=2.04716e-17
C281 (\10\:VDD VSS) capacitor c=3.01551e-17
C282 (\11\:VDD VSS) capacitor c=2.06302e-17
C283 (\13\:VDD VSS) capacitor c=3.12147e-17
C284 (\14\:VDD VSS) capacitor c=3.30338e-17
C285 (\15\:VDD VSS) capacitor c=1.40569e-17
C286 (\17\:VDD VSS) capacitor c=1.7363e-17
C287 (\18\:VDD VSS) capacitor c=1.99435e-17
C288 (\19\:VDD VSS) capacitor c=2.13471e-17
C289 (\21\:VDD VSS) capacitor c=1.10548e-17
C290 (\22\:VDD VSS) capacitor c=1.22141e-17
Rk129 (\2\:VSS \4\:VSS) resistor r=0.1692 c=0
Rk130 (\4\:VSS \5\:VSS) resistor r=0.1849 c=0
Rk131 (\5\:VSS \6\:VSS) resistor r=0.3162 c=0
Rk132 (\6\:VSS \7\:VSS) resistor r=0.4117 c=0
Rk133 (\7\:VSS \8\:VSS) resistor r=0.1033 c=0
Rk134 (\8\:VSS \9\:VSS) resistor r=0.5608 c=0
Rk135 (\9\:VSS \10\:VSS) resistor r=0.413 c=0
Rk136 (\10\:VSS \11\:VSS) resistor r=0.139 c=0
Rk137 (\11\:VSS \12\:VSS) resistor r=0.3109 c=0
Rk138 (\12\:VSS \13\:VSS) resistor r=0.4372 c=0
Rk139 (\13\:VSS \14\:VSS) resistor r=0.413 c=0
Rk140 (\14\:VSS \15\:VSS) resistor r=0.0549 c=0
Rk141 (\15\:VSS \16\:VSS) resistor r=0.5059 c=0
Rk142 (\16\:VSS \17\:VSS) resistor r=0.515 c=0
Rk143 (\17\:VSS \18\:VSS) resistor r=0.1976 c=0
Rk144 (\18\:VSS \19\:VSS) resistor r=0.1186 c=0
Rk146 (\20\:VSS VSS) resistor r=0.1311 c=0
Rk145 (\19\:VSS \20\:VSS) resistor r=0.306 c=0
Rk147 (\5\:VSS \22\:VSS) resistor r=0.04428 c=0
Rk148 (\6\:VSS \24\:VSS) resistor r=0.04428 c=0
Rk149 (\8\:VSS \26\:VSS) resistor r=0.04428 c=0
Rk150 (\9\:VSS \28\:VSS) resistor r=0.04428 c=0
Rk151 (\10\:VSS \30\:VSS) resistor r=0.04428 c=0
Rk152 (\12\:VSS \32\:VSS) resistor r=0.04234 c=0
Rk153 (\13\:VSS \34\:VSS) resistor r=0.04428 c=0
Rk154 (\14\:VSS \36\:VSS) resistor r=0.04428 c=0
Rk155 (\16\:VSS \38\:VSS) resistor r=0.04428 c=0
Rk156 (\17\:VSS \40\:VSS) resistor r=0.04428 c=0
Rk157 (\19\:VSS \42\:VSS) resistor r=0.04428 c=0
Rk158 (\20\:VSS \44\:VSS) resistor r=0.04428 c=0
Rk95 (\2\:VDD \4\:VDD) resistor r=0.1692 c=0
Rk96 (\4\:VDD \5\:VDD) resistor r=0.2103 c=0
Rk97 (\5\:VDD \6\:VDD) resistor r=0.2907 c=0
Rk98 (\6\:VDD \7\:VDD) resistor r=0.4117 c=0
Rk99 (\7\:VDD \8\:VDD) resistor r=0.05235 c=0
Rk100 (\8\:VDD \9\:VDD) resistor r=0.1761 c=0
Rk101 (\9\:VDD \10\:VDD) resistor r=0.4462 c=0
Rk102 (\10\:VDD \11\:VDD) resistor r=0.4003 c=0
Rk103 (\11\:VDD \12\:VDD) resistor r=0.139 c=0
Rk104 (\12\:VDD \13\:VDD) resistor r=0.3097 c=0
Rk105 (\13\:VDD \14\:VDD) resistor r=0.4385 c=0
Rk106 (\14\:VDD \15\:VDD) resistor r=0.4003 c=0
Rk107 (\15\:VDD \16\:VDD) resistor r=0.06764 c=0
Rk108 (\16\:VDD \17\:VDD) resistor r=0.3785 c=0
Rk109 (\17\:VDD \18\:VDD) resistor r=0.1761 c=0
Rk110 (\18\:VDD \19\:VDD) resistor r=0.464 c=0
Rk111 (\19\:VDD \20\:VDD) resistor r=0.1976 c=0
Rk112 (\20\:VDD \21\:VDD) resistor r=0.09312 c=0
Rk114 (\22\:VDD VDD) resistor r=0.1311 c=0
Rk113 (\21\:VDD \22\:VDD) resistor r=0.3315 c=0
Rk115 (\5\:VDD \24\:VDD) resistor r=0.04428 c=0
Rk116 (\6\:VDD \26\:VDD) resistor r=0.04428 c=0
Rk117 (\8\:VDD \28\:VDD) resistor r=0.04428 c=0
Rk118 (\9\:VDD \30\:VDD) resistor r=0.04428 c=0
Rk119 (\10\:VDD \32\:VDD) resistor r=0.04428 c=0
Rk120 (\11\:VDD \34\:VDD) resistor r=0.04428 c=0
Rk121 (\13\:VDD \36\:VDD) resistor r=0.04428 c=0
Rk122 (\14\:VDD \38\:VDD) resistor r=0.04428 c=0
Rk123 (\15\:VDD \40\:VDD) resistor r=0.04428 c=0
Rk124 (\17\:VDD \42\:VDD) resistor r=0.04428 c=0
Rk125 (\18\:VDD \44\:VDD) resistor r=0.04428 c=0
Rk126 (\19\:VDD \46\:VDD) resistor r=0.04428 c=0
Rk127 (\21\:VDD \48\:VDD) resistor r=0.04428 c=0
Rk128 (\22\:VDD \50\:VDD) resistor r=0.04428 c=0
Rk79 (\15\:SE \16\:SE) resistor r=0.2693 c=0
Rk80 (\16\:SE \17\:SE) resistor r=0.6104 c=0
Rk81 (\17\:SE \18\:SE) resistor r=1.2826 c=0
Rk82 (\18\:SE \19\:SE) resistor r=0.7282 c=0
Rk83 (\19\:SE \20\:SE) resistor r=0.2693 c=0
Rk84 (\17\:SE \21\:SE) resistor r=0.2357 c=0
Rk86 (\22\:SE SE) resistor r=0.03339 c=0
Rk85 (\18\:SE \22\:SE) resistor r=0.2357 c=0
Rk74 (\15\:RN \16\:RN) resistor r=1.3244 c=0
Rk78 (\17\:RN RN) resistor r=0.01692 c=0
Rk75 (\16\:RN \17\:RN) resistor r=2.5573 c=0
Rk76 (\17\:RN \18\:RN) resistor r=2.9145 c=0
Rk77 (\18\:RN \19\:RN) resistor r=1.3244 c=0
Rk1 (Q1N \2\:Q1N) resistor r=0.03697 c=0
Rk2 (Q1N \4\:Q1N) resistor r=0.2019 c=0
Rk7 (\4\:Q1 Q1) resistor r=0.01569 c=0
Rk6 (\2\:Q1 \4\:Q1) resistor r=0.2754 c=0
Rk21 (\4\:D1 D1) resistor r=0.01784 c=0
Rk26 (\4\:SI1 \5\:SI1) resistor r=0.007782 c=0
Rk27 (SI1 \6\:SI1) resistor r=0.007782 c=0
Rk28 (\4\:SI1 \6\:SI1) resistor r=0.03341 c=0
Rk93 (Q2N \2\:Q2N) resistor r=0.03697 c=0
Rk94 (Q2N \4\:Q2N) resistor r=0.2019 c=0
Rk57 (Q2 \2\:Q2) resistor r=0.01601 c=0
Rk58 (\2\:Q2 \4\:Q2) resistor r=0.2754 c=0
Rk39 (\4\:D2 D2) resistor r=0.01763 c=0
Rk34 (SI2 \4\:SI2) resistor r=0.007782 c=0
Rk36 (\4\:SI2 \5\:SI2) resistor r=0.03299 c=0
Rk35 (\5\:SI2 \6\:SI2) resistor r=0.007782 c=0
Rk33 (CK \5\:CK) resistor r=0.01189 c=0
Rk32 (\4\:CK \5\:CK) resistor r=0.004283 c=0
Rk31 (\16\:Ckbb \18\:Ckbb) resistor r=0.3117 c=0
Rk87 (\19\:Ckbb \20\:Ckbb) resistor r=0.8175 c=0
Rk88 (\20\:Ckbb \21\:Ckbb) resistor r=0.4931 c=0
Rk89 (\21\:Ckbb \22\:Ckbb) resistor r=2.1531 c=0
Rk90 (\22\:Ckbb \23\:Ckbb) resistor r=1.51 c=0
Rk91 (\23\:Ckbb \24\:Ckbb) resistor r=0.4931 c=0
Rk92 (\24\:Ckbb \25\:Ckbb) resistor r=0.8175 c=0
Rk62 (\19\:CKb \20\:CKb) resistor r=0.6853 c=0
Rk63 (\20\:CKb \21\:CKb) resistor r=1.0064 c=0
Rk64 (\21\:CKb \22\:CKb) resistor r=2.0396 c=0
Rk65 (\22\:CKb \23\:CKb) resistor r=1.9091 c=0
Rk66 (\23\:CKb \24\:CKb) resistor r=1.0064 c=0
Rk67 (\24\:CKb \25\:CKb) resistor r=0.7764 c=0
Rk68 (\20\:CKb \26\:CKb) resistor r=0.2841 c=0
Rk69 (\22\:CKb \27\:CKb) resistor r=0.1135 c=0
Rk70 (\27\:CKb \28\:CKb) resistor r=0.2158 c=0
Rk71 (\28\:CKb \30\:CKb) resistor r=0.2758 c=0
Rk72 (\24\:CKb \31\:CKb) resistor r=0.2841 c=0
Rk73 (\27\:CKb \33\:CKb) resistor r=0.202 c=0
Rk22 (\2\:Db \3\:Db) resistor r=0.2084 c=0
Rk23 (\3\:Db \5\:Db) resistor r=0.3022 c=0
Rk24 (\3\:Db \7\:Db) resistor r=0.559 c=0
Rk25 (\5\:Db \9\:Db) resistor r=0.4427 c=0
Rk3 (\6\:qint \7\:qint) resistor r=0.1049 c=0
Rk4 (\7\:qint \8\:qint) resistor r=0.1212 c=0
Rk5 (\7\:qint \10\:qint) resistor r=0.1254 c=0
Rk17 (\2\:n6 \4\:n6) resistor r=0.222 c=0
Rk29 (\5\:SEb \7\:SEb) resistor r=0.4177 c=0
Rk30 (\7\:SEb \8\:SEb) resistor r=0.5473 c=0
Rk8 (\11\:qbint \13\:qbint) resistor r=0.5653 c=0
Rk9 (\13\:qbint \14\:qbint) resistor r=0.3414 c=0
Rk10 (\14\:qbint \15\:qbint) resistor r=0.1588 c=0
Rk11 (\14\:qbint \17\:qbint) resistor r=0.206 c=0
Rk18 (\6\:n20 \7\:n20) resistor r=0.269 c=0
Rk19 (\7\:n20 \8\:n20) resistor r=0.5797 c=0
Rk20 (\7\:n20 \10\:n20) resistor r=0.1946 c=0
Rk12 (\5\:n30 \7\:n30) resistor r=0.3718 c=0
Rk13 (\7\:n30 \8\:n30) resistor r=0.5769 c=0
Rk14 (\4\:mout \5\:mout) resistor r=0.4556 c=0
Rk15 (\5\:mout \7\:mout) resistor r=0.1207 c=0
Rk16 (\5\:mout \9\:mout) resistor r=0.2146 c=0
Rk40 (\2\:Db_2 \3\:Db_2) resistor r=0.6063 c=0
Rk41 (\3\:Db_2 \5\:Db_2) resistor r=0.3022 c=0
Rk42 (\3\:Db_2 \7\:Db_2) resistor r=0.2084 c=0
Rk43 (\5\:Db_2 \9\:Db_2) resistor r=0.4427 c=0
Rk59 (\5\:qint_2 \6\:qint_2) resistor r=0.1212 c=0
Rk60 (\6\:qint_2 \8\:qint_2) resistor r=0.1254 c=0
Rk61 (\6\:qint_2 \10\:qint_2) resistor r=0.1049 c=0
Rk44 (\2\:n6_2 \4\:n6_2) resistor r=0.222 c=0
Rk37 (\4\:SEb_2 \6\:SEb_2) resistor r=0.5488 c=0
Rk38 (\6\:SEb_2 \8\:SEb_2) resistor r=0.4152 c=0
Rk53 (\11\:qbint_2 \12\:qbint_2) resistor r=0.1588 c=0
Rk54 (\12\:qbint_2 \14\:qbint_2) resistor r=0.3414 c=0
Rk55 (\14\:qbint_2 \15\:qbint_2) resistor r=0.5649 c=0
Rk56 (\12\:qbint_2 \17\:qbint_2) resistor r=0.2017 c=0
Rk45 (\5\:n20_2 \6\:n20_2) resistor r=0.5797 c=0
Rk46 (\6\:n20_2 \8\:n20_2) resistor r=0.2666 c=0
Rk47 (\6\:n20_2 \10\:n20_2) resistor r=0.1946 c=0
Rk51 (\5\:n30_2 \7\:n30_2) resistor r=0.3726 c=0
Rk52 (\7\:n30_2 \8\:n30_2) resistor r=0.5799 c=0
Rk48 (\5\:mout_2 \6\:mout_2) resistor r=0.2448 c=0
Rk49 (\6\:mout_2 \7\:mout_2) resistor r=0.4556 c=0
Rk50 (\6\:mout_2 \9\:mout_2) resistor r=0.1207 c=0
Rl54 (\13\:SE \14\:SE) resistor r=52.6149 c=0
Rl51 (\11\:SE \12\:SE) resistor r=33.3841 c=0
Rl47 (\8\:SE \9\:SE) resistor r=54.5379 c=0
Rl48 (\9\:SE \10\:SE) resistor r=41.0764 c=0
Rl40 (\5\:SE \6\:SE) resistor r=54.5379 c=0
Rl41 (\6\:SE \7\:SE) resistor r=41.0764 c=0
Rl37 (\3\:SE \4\:SE) resistor r=33.3841 c=0
Rl34 (\1\:SE \2\:SE) resistor r=52.6149 c=0
Rl64 (\9\:RN \10\:RN) resistor r=147.643 c=0
Rl24 (\5\:RN \6\:RN) resistor r=147.643 c=0
Rl76 (\13\:RN \14\:RN) resistor r=52.6149 c=0
Rl75 (\12\:RN \13\:RN) resistor r=51.1559 c=0
Rl74 (\11\:RN \12\:RN) resistor r=47.3097 c=0
Rl63 (\8\:RN \9\:RN) resistor r=52.6149 c=0
Rl25 (\6\:RN \7\:RN) resistor r=52.6149 c=0
Rl13 (\2\:RN \3\:RN) resistor r=51.1559 c=0
Rl12 (\1\:RN \2\:RN) resistor r=47.3097 c=0
Rl14 (\3\:RN \4\:RN) resistor r=52.6149 c=0
Rl32 (\1\:D1 \2\:D1) resistor r=91.5405 c=0
Rl33 (\2\:D1 \3\:D1) resistor r=35.7713 c=0
Rl39 (\2\:SI1 \3\:SI1) resistor r=89.1533 c=0
Rl38 (\1\:SI1 \2\:SI1) resistor r=41.0764 c=0
Rl55 (\1\:D2 \2\:D2) resistor r=91.5405 c=0
Rl56 (\2\:D2 \3\:D2) resistor r=35.7713 c=0
Rl50 (\2\:SI2 \3\:SI2) resistor r=89.1533 c=0
Rl49 (\1\:SI2 \2\:SI2) resistor r=41.0764 c=0
Rl45 (\1\:CK \2\:CK) resistor r=24.2328 c=0
Rl46 (\2\:CK \3\:CK) resistor r=58.8482 c=0
Rl69 (\12\:Ckbb \13\:Ckbb) resistor r=183.747 c=0
Rl19 (\2\:Ckbb \3\:Ckbb) resistor r=183.747 c=0
Rl70 (\13\:Ckbb \14\:Ckbb) resistor r=62.6944 c=0
Rl60 (\10\:Ckbb \11\:Ckbb) resistor r=62.6944 c=0
Rl57 (\8\:Ckbb \9\:Ckbb) resistor r=230.67 c=0
Rl31 (\6\:Ckbb \7\:Ckbb) resistor r=230.67 c=0
Rl28 (\4\:Ckbb \5\:Ckbb) resistor r=62.6944 c=0
Rl18 (Ckbb \2\:Ckbb) resistor r=62.6944 c=0
Rl58 (\12\:CKb \13\:CKb) resistor r=109.983 c=0
Rl30 (\6\:CKb \7\:CKb) resistor r=109.983 c=0
Rl71 (\17\:CKb \18\:CKb) resistor r=31.9251 c=0
Rl68 (\15\:CKb \16\:CKb) resistor r=24.2328 c=0
Rl59 (\13\:CKb \14\:CKb) resistor r=32.9066 c=0
Rl29 (\5\:CKb \6\:CKb) resistor r=33.8727 c=0
Rl20 (\3\:CKb \4\:CKb) resistor r=24.2328 c=0
Rl17 (CKb \2\:CKb) resistor r=31.9251 c=0
Rl44 (\9\:CKb \11\:CKb) resistor r=64.2642 c=0
Rl43 (\9\:CKb \10\:CKb) resistor r=37.3411 c=0
Rl42 (\8\:CKb \9\:CKb) resistor r=1.2334 c=0
Rl3 (\2\:qint \4\:qint) resistor r=38.1757 c=0
Rl2 (\2\:qint \3\:qint) resistor r=45.868 c=0
Rl1 (qint \2\:qint) resistor r=5.915 c=0
Rl35 (SEb \2\:SEb) resistor r=26.9231 c=0
Rl36 (\2\:SEb \3\:SEb) resistor r=148.376 c=0
Rl15 (\8\:qbint \9\:qbint) resistor r=62.2302 c=0
Rl16 (\9\:qbint \10\:qbint) resistor r=39.1533 c=0
Rl4 (qbint \2\:qbint) resistor r=41.3231 c=0
Rl7 (\2\:qbint \5\:qbint) resistor r=49.0154 c=0
Rl8 (\2\:qbint \6\:qbint) resistor r=5.6723 c=0
Rl9 (\3\:qbint \7\:qbint) resistor r=30.0028 c=0
Rl6 (\3\:qbint \4\:qbint) resistor r=58.8489 c=0
Rl5 (\2\:qbint \3\:qbint) resistor r=145.337 c=0
Rl23 (\2\:n20 \4\:n20) resistor r=36.2526 c=0
Rl22 (\2\:n20 \3\:n20) resistor r=82.4064 c=0
Rl21 (n20 \2\:n20) resistor r=2.7713 c=0
Rl11 (\2\:n30 \3\:n30) resistor r=58.4254 c=0
Rl10 (n30 \2\:n30) resistor r=49.9532 c=0
Rl26 (mout \2\:mout) resistor r=72.3097 c=0
Rl27 (\2\:mout \3\:mout) resistor r=26.1559 c=0
Rl85 (qint_2 \2\:qint_2) resistor r=38.1757 c=0
Rl87 (\2\:qint_2 \4\:qint_2) resistor r=45.868 c=0
Rl86 (\2\:qint_2 \3\:qint_2) resistor r=5.9102 c=0
Rl53 (\2\:SEb_2 \3\:SEb_2) resistor r=26.3736 c=0
Rl52 (SEb_2 \2\:SEb_2) resistor r=147.512 c=0
Rl72 (qbint_2 \2\:qbint_2) resistor r=62.2302 c=0
Rl73 (\2\:qbint_2 \3\:qbint_2) resistor r=39.1533 c=0
Rl79 (\4\:qbint_2 \5\:qbint_2) resistor r=30.0028 c=0
Rl82 (\5\:qbint_2 \8\:qbint_2) resistor r=58.8489 c=0
Rl84 (\6\:qbint_2 \10\:qbint_2) resistor r=41.3231 c=0
Rl83 (\6\:qbint_2 \9\:qbint_2) resistor r=49.0154 c=0
Rl81 (\6\:qbint_2 \7\:qbint_2) resistor r=5.6723 c=0
Rl80 (\5\:qbint_2 \6\:qbint_2) resistor r=145.337 c=0
Rl65 (n20_2 \2\:n20_2) resistor r=36.2526 c=0
Rl67 (\2\:n20_2 \4\:n20_2) resistor r=82.4064 c=0
Rl66 (\2\:n20_2 \3\:n20_2) resistor r=2.7666 c=0
Rl77 (n30_2 \2\:n30_2) resistor r=57.5621 c=0
Rl78 (\2\:n30_2 \3\:n30_2) resistor r=49.8142 c=0
Rl61 (mout_2 \2\:mout_2) resistor r=72.3097 c=0
Rl62 (\2\:mout_2 \3\:mout_2) resistor r=26.1559 c=0
Rz29 (\1\:VSS \2\:VSS) resistor r=75 c=0
Rz30 (\21\:VSS \22\:VSS) resistor r=75 c=0
Rz31 (\23\:VSS \24\:VSS) resistor r=75 c=0
Rz32 (\25\:VSS \26\:VSS) resistor r=75 c=0
Rz33 (\27\:VSS \28\:VSS) resistor r=75 c=0
Rz34 (\29\:VSS \30\:VSS) resistor r=75 c=0
Rz35 (\31\:VSS \32\:VSS) resistor r=75 c=0
Rz36 (\33\:VSS \34\:VSS) resistor r=75 c=0
Rz37 (\35\:VSS \36\:VSS) resistor r=75 c=0
Rz38 (\37\:VSS \38\:VSS) resistor r=75 c=0
Rz39 (\39\:VSS \40\:VSS) resistor r=75 c=0
Rz40 (\41\:VSS \42\:VSS) resistor r=75 c=0
Rz41 (\43\:VSS \44\:VSS) resistor r=75 c=0
Rz24 (\3\:VDD \4\:VDD) resistor r=12.5 c=0
Rz25 (\3\:VDD \7\:VDD) resistor r=6.25 c=0
Rz26 (\3\:VDD \12\:VDD) resistor r=6.25 c=0
Rz27 (\3\:VDD \16\:VDD) resistor r=6.25 c=0
Rz28 (\3\:VDD \20\:VDD) resistor r=6.25 c=0
Rz1 (\1\:Q1N \2\:Q1N) resistor r=75 c=0
Rz3 (\1\:Q1 \2\:Q1) resistor r=75 c=0
Rz23 (\1\:Q2N \2\:Q2N) resistor r=75 c=0
Rz19 (\3\:Q2 \4\:Q2) resistor r=75 c=0
Rz11 (\15\:Ckbb \16\:Ckbb) resistor r=75 c=0
Rz22 (\15\:Ckbb \22\:Ckbb) resistor r=37.5 c=0
Rz21 (\29\:CKb \30\:CKb) resistor r=75 c=0
Rz8 (\6\:Db \7\:Db) resistor r=75 c=0
Rz9 (\8\:Db \9\:Db) resistor r=75 c=0
Rz2 (\9\:qint \10\:qint) resistor r=75 c=0
Rz10 (\4\:SEb \5\:SEb) resistor r=75 c=0
Rz4 (\16\:qbint \17\:qbint) resistor r=75 c=0
Rz7 (\9\:n20 \10\:n20) resistor r=75 c=0
Rz5 (\6\:n30 \7\:n30) resistor r=75 c=0
Rz6 (\6\:mout \7\:mout) resistor r=75 c=0
Rz13 (Db_2 \2\:Db_2) resistor r=75 c=0
Rz14 (\8\:Db_2 \9\:Db_2) resistor r=75 c=0
Rz20 (\7\:qint_2 \8\:qint_2) resistor r=75 c=0
Rz12 (\7\:SEb_2 \8\:SEb_2) resistor r=75 c=0
Rz18 (\16\:qbint_2 \17\:qbint_2) resistor r=75 c=0
Rz15 (\9\:n20_2 \10\:n20_2) resistor r=75 c=0
Rz17 (\6\:n30_2 \7\:n30_2) resistor r=75 c=0
Rz16 (\8\:mout_2 \9\:mout_2) resistor r=75 c=0
Ry42 (\3\:VSS \4\:VSS) resistor r=10.3333 c=0
Ry43 (\3\:VSS \7\:VSS) resistor r=5.1667 c=0
Ry44 (\3\:VSS \11\:VSS) resistor r=5.1667 c=0
Ry45 (\3\:VSS \15\:VSS) resistor r=5.1667 c=0
Ry46 (\3\:VSS \18\:VSS) resistor r=5.1667 c=0
Ry27 (\1\:VDD \2\:VDD) resistor r=62 c=0
Ry28 (\23\:VDD \24\:VDD) resistor r=62 c=0
Ry29 (\25\:VDD \26\:VDD) resistor r=62 c=0
Ry30 (\27\:VDD \28\:VDD) resistor r=62 c=0
Ry31 (\29\:VDD \30\:VDD) resistor r=62 c=0
Ry32 (\31\:VDD \32\:VDD) resistor r=62 c=0
Ry33 (\33\:VDD \34\:VDD) resistor r=62 c=0
Ry34 (\35\:VDD \36\:VDD) resistor r=62 c=0
Ry35 (\37\:VDD \38\:VDD) resistor r=62 c=0
Ry36 (\39\:VDD \40\:VDD) resistor r=62 c=0
Ry37 (\41\:VDD \42\:VDD) resistor r=62 c=0
Ry38 (\43\:VDD \44\:VDD) resistor r=62 c=0
Ry39 (\45\:VDD \46\:VDD) resistor r=62 c=0
Ry40 (\47\:VDD \48\:VDD) resistor r=62 c=0
Ry41 (\49\:VDD \50\:VDD) resistor r=62 c=0
Ry1 (\3\:Q1N \4\:Q1N) resistor r=31 c=0
Ry3 (\3\:Q1 \4\:Q1) resistor r=31 c=0
Ry26 (\3\:Q2N \4\:Q2N) resistor r=31 c=0
Ry23 (\1\:Q2 \2\:Q2) resistor r=31 c=0
Ry13 (\17\:Ckbb \18\:Ckbb) resistor r=62 c=0
Ry25 (\32\:CKb \33\:CKb) resistor r=62 c=0
Ry10 (Db \2\:Db) resistor r=62 c=0
Ry11 (\4\:Db \5\:Db) resistor r=62 c=0
Ry2 (\5\:qint \6\:qint) resistor r=62 c=0
Ry7 (n6 \2\:n6) resistor r=62 c=0
Ry8 (\3\:n6 \4\:n6) resistor r=62 c=0
Ry12 (\6\:SEb \7\:SEb) resistor r=62 c=0
Ry4 (\12\:qbint \13\:qbint) resistor r=62 c=0
Ry9 (\5\:n20 \6\:n20) resistor r=62 c=0
Ry5 (\4\:n30 \5\:n30) resistor r=62 c=0
Ry6 (\8\:mout \9\:mout) resistor r=62 c=0
Ry15 (\4\:Db_2 \5\:Db_2) resistor r=62 c=0
Ry16 (\6\:Db_2 \7\:Db_2) resistor r=62 c=0
Ry24 (\9\:qint_2 \10\:qint_2) resistor r=62 c=0
Ry17 (n6_2 \2\:n6_2) resistor r=62 c=0
Ry18 (\3\:n6_2 \4\:n6_2) resistor r=62 c=0
Ry14 (\5\:SEb_2 \6\:SEb_2) resistor r=62 c=0
Ry22 (\13\:qbint_2 \14\:qbint_2) resistor r=62 c=0
Ry19 (\7\:n20_2 \8\:n20_2) resistor r=62 c=0
Ry21 (\4\:n30_2 \5\:n30_2) resistor r=62 c=0
Ry20 (\4\:mout_2 \5\:mout_2) resistor r=62 c=0
Rx31 (\14\:SE \15\:SE) resistor r=45 c=0
Rx32 (\12\:SE \16\:SE) resistor r=45 c=0
Rx33 (\4\:SE \19\:SE) resistor r=45 c=0
Rx34 (\2\:SE \20\:SE) resistor r=45 c=0
Rx35 (\9\:SE \21\:SE) resistor r=45 c=0
Rx36 (\6\:SE \22\:SE) resistor r=45 c=0
Rx27 (\14\:RN \15\:RN) resistor r=45 c=0
Rx28 (\8\:RN \16\:RN) resistor r=45 c=0
Rx29 (\7\:RN \18\:RN) resistor r=45 c=0
Rx30 (\4\:RN \19\:RN) resistor r=45 c=0
Rx7 (\2\:D1 \4\:D1) resistor r=45 c=0
Rx8 (\2\:SI1 \5\:SI1) resistor r=45 c=0
Rx13 (\2\:D2 \4\:D2) resistor r=45 c=0
Rx11 (\2\:SI2 \6\:SI2) resistor r=45 c=0
Rx10 (\2\:CK \4\:CK) resistor r=45 c=0
Rx37 (\14\:Ckbb \19\:Ckbb) resistor r=45 c=0
Rx38 (\11\:Ckbb \20\:Ckbb) resistor r=45 c=0
Rx39 (\9\:Ckbb \21\:Ckbb) resistor r=45 c=0
Rx40 (\7\:Ckbb \23\:Ckbb) resistor r=45 c=0
Rx41 (\5\:Ckbb \24\:Ckbb) resistor r=45 c=0
Rx42 (Ckbb \25\:Ckbb) resistor r=45 c=0
Rx20 (\18\:CKb \19\:CKb) resistor r=45 c=0
Rx21 (\14\:CKb \21\:CKb) resistor r=45 c=0
Rx22 (\5\:CKb \23\:CKb) resistor r=45 c=0
Rx23 (\2\:CKb \25\:CKb) resistor r=45 c=0
Rx24 (\16\:CKb \26\:CKb) resistor r=45 c=0
Rx25 (\8\:CKb \28\:CKb) resistor r=45 c=0
Rx26 (\4\:CKb \31\:CKb) resistor r=45 c=0
Rx1 (qint \8\:qint) resistor r=45 c=0
Rx9 (\2\:SEb \8\:SEb) resistor r=45 c=0
Rx2 (\9\:qbint \11\:qbint) resistor r=45 c=0
Rx3 (\6\:qbint \15\:qbint) resistor r=45 c=0
Rx6 (n20 \8\:n20) resistor r=45 c=0
Rx4 (\2\:n30 \8\:n30) resistor r=45 c=0
Rx5 (\2\:mout \4\:mout) resistor r=45 c=0
Rx19 (\3\:qint_2 \5\:qint_2) resistor r=45 c=0
Rx12 (\2\:SEb_2 \4\:SEb_2) resistor r=45 c=0
Rx17 (\7\:qbint_2 \11\:qbint_2) resistor r=45 c=0
Rx18 (\2\:qbint_2 \15\:qbint_2) resistor r=45 c=0
Rx14 (\3\:n20_2 \5\:n20_2) resistor r=45 c=0
Rx16 (\2\:n30_2 \8\:n30_2) resistor r=45 c=0
Rx15 (\2\:mout_2 \7\:mout_2) resistor r=45 c=0
NM19 (\1\:Q2N \4\:qint_2 \1\:VSS VSS) g45n1svt w=(2.6e-07) l=4.5e-08 \
        nf=1 as=3.64e-14 ad=7.48e-14 ps=8e-07 pd=1.6e-06 nrd=1.16667 \
        nrs=1.16667 sa=1.4e-07 sb=2.66058e-07 sd=160n sca=17.5885 \
        scb=0.0172826 scc=0.00162584 m=(1)
NM17 (\3\:Q2 \9\:qbint_2 \21\:VSS VSS) g45n1svt w=(2.6e-07) l=4.5e-08 \
        nf=1 as=3.64e-14 ad=6.97e-14 ps=8e-07 pd=1.5e-06 nrd=1.16667 \
        nrs=1.16667 sa=1.4e-07 sb=1.4e-07 sd=160n sca=17.5885 \
        scb=0.0172826 scc=0.00162584 m=(1)
mn57 (\1\:Q1N \3\:qint \43\:VSS VSS) g45n1svt w=(2.6e-07) l=4.5e-08 nf=1 \
        as=3.64e-14 ad=7.48e-14 ps=8e-07 pd=1.6e-06 nrd=1.16667 \
        nrs=1.16667 sa=1.4e-07 sb=2.66058e-07 sd=160n sca=17.5885 \
        scb=0.0172826 scc=0.00162584 m=(1)
mn55 (\1\:Q1 \5\:qbint \41\:VSS VSS) g45n1svt w=(2.6e-07) l=4.5e-08 nf=1 \
        as=3.64e-14 ad=6.97e-14 ps=8e-07 pd=1.5e-06 nrd=1.16667 \
        nrs=1.16667 sa=1.4e-07 sb=1.4e-07 sd=160n sca=17.5885 \
        scb=0.0172826 scc=0.00162584 m=(1)
mn21 (\15\:Ckbb \10\:CKb \31\:VSS VSS) g45n1svt w=(1.45e-07) l=4.5e-08 \
        nf=1 as=9.708e-14 ad=6.752e-14 ps=1.51e-06 pd=1.56e-06 nrd=1.16667 \
        nrs=1.16667 sa=2.3e-07 sb=3.6e-07 sd=160n sca=19.8813 \
        scb=0.0206549 scc=0.00197265 m=(1)
mn20 (\29\:CKb \3\:CK \31\:VSS VSS) g45n1svt w=(1.45e-07) l=4.5e-08 nf=1 \
        as=2.03e-14 ad=6.752e-14 ps=5.7e-07 pd=1.56e-06 nrd=1.16667 \
        nrs=1.16667 sa=4.5e-07 sb=1.4e-07 sd=160n sca=19.8813 \
        scb=0.0206549 scc=0.00197265 m=(1)
NM18 (\7\:qint_2 \8\:qbint_2 \1\:VSS VSS) g45n1svt w=(1.45e-07) \
        l=4.5e-08 nf=1 as=2.03e-14 ad=7.48e-14 ps=5.7e-07 pd=1.6e-06 \
        nrd=1.16667 nrs=1.16667 sa=3.7e-07 sb=1.4e-07 sd=160n sca=23.279 \
        scb=0.0230742 scc=0.00267719 m=(1)
NM13 (\16\:qbint_2 \3\:n30_2 n9_2 VSS) g45n1svt w=(1.45e-07) l=4.5e-08 \
        nf=1 as=1.45e-14 ad=2.392e-14 ps=4.9e-07 pd=6.2e-07 nrd=1.16667 \
        nrs=1.16667 sa=2e-06 sb=1.65e-07 sd=160n sca=15.7071 scb=0.0167369 \
        scc=0.00113434 m=(1)
NM14 (n9_2 \11\:RN \23\:VSS VSS) g45n1svt w=(1.45e-07) l=4.5e-08 nf=1 \
        as=1.45e-14 ad=7.75e-14 ps=4.9e-07 pd=1.49e-06 nrd=1.16667 \
        nrs=1.16667 sa=3.1e-07 sb=1.91e-06 sd=160n sca=15.7071 \
        scb=0.0167369 scc=0.00113434 m=(1)
NM15 (n11_2 \3\:qbint_2 \23\:VSS VSS) g45n1svt w=(1.45e-07) l=4.5e-08 \
        nf=1 as=1.957e-14 ad=7.75e-14 ps=5.6e-07 pd=1.49e-06 nrd=1.16667 \
        nrs=1.16667 sa=5.75e-07 sb=1.645e-06 sd=160n sca=15.7071 \
        scb=0.0167369 scc=0.00113434 m=(1)
NM16 (\6\:n30_2 \17\:CKb n11_2 VSS) g45n1svt w=(1.45e-07) l=4.5e-08 nf=1 \
        as=2.9e-14 ad=1.957e-14 ps=6.9e-07 pd=5.6e-07 nrd=1.16667 \
        nrs=1.16667 sa=7.55e-07 sb=1.465e-06 sd=160n sca=15.7071 \
        scb=0.0167369 scc=0.00113434 m=(1)
NM12 (\8\:mout_2 \13\:Ckbb \6\:n30_2 VSS) g45n1svt w=(1.45e-07) l=4.5e-08 \
        nf=1 as=3.335e-14 ad=2.9e-14 ps=7.5e-07 pd=6.9e-07 nrd=1.16667 \
        nrs=1.16667 sa=1e-06 sb=1.22e-06 sd=160n sca=15.7071 scb=0.0167369 \
        scc=0.00113434 m=(1)
NM8 (\8\:mout_2 \4\:n20_2 \25\:VSS VSS) g45n1svt w=(1.45e-07) l=4.5e-08 \
        nf=1 as=8.475e-14 ad=3.335e-14 ps=1.59e-06 pd=7.5e-07 nrd=1.16667 \
        nrs=1.16667 sa=9.45e-07 sb=1.275e-06 sd=160n sca=15.7071 \
        scb=0.0167369 scc=0.00113434 m=(1)
NM10 (n7_2 \10\:RN \25\:VSS VSS) g45n1svt w=(1.45e-07) l=4.5e-08 nf=1 \
        as=8.7e-15 ad=8.475e-14 ps=4.1e-07 pd=1.59e-06 nrd=1.16667 \
        nrs=1.16667 sa=1.59e-06 sb=6.3e-07 sd=160n sca=15.7071 \
        scb=0.0167369 scc=0.00113434 m=(1)
NM11 (n5_2 \3\:mout_2 n7_2 VSS) g45n1svt w=(1.45e-07) l=4.5e-08 nf=1 \
        as=1.957e-14 ad=8.7e-15 ps=5.6e-07 pd=4.1e-07 nrd=1.16667 \
        nrs=1.16667 sa=1.695e-06 sb=5.25e-07 sd=160n sca=15.7071 \
        scb=0.0167369 scc=0.00113434 m=(1)
NM9 (\9\:n20_2 \10\:Ckbb n5_2 VSS) g45n1svt w=(1.45e-07) l=4.5e-08 nf=1 \
        as=2.32e-14 ad=1.957e-14 ps=6.1e-07 pd=5.6e-07 nrd=1.16667 \
        nrs=1.16667 sa=1.875e-06 sb=3.45e-07 sd=160n sca=15.7071 \
        scb=0.0167369 scc=0.00113434 m=(1)
NM7 (\8\:Db_2 \12\:CKb \9\:n20_2 VSS) g45n1svt w=(1.45e-07) l=4.5e-08 \
        nf=1 as=2.03e-14 ad=2.32e-14 ps=5.7e-07 pd=6.1e-07 nrd=1.16667 \
        nrs=1.16667 sa=2e-06 sb=1.4e-07 sd=160n sca=15.7071 scb=0.0167369 \
        scc=0.00113434 m=(1)
NM1 (n1_2 \3\:D2 \27\:VSS VSS) g45n1svt w=(1.45e-07) l=4.5e-08 nf=1 \
        as=5.027e-14 ad=2.03e-14 ps=1.33e-06 pd=5.7e-07 nrd=1.16667 \
        nrs=1.16667 sa=8.86379e-07 sb=1.25e-07 sd=160n sca=12.9138 \
        scb=0.0133404 scc=0.000640143 m=(1)
NM2 (Db_2 SEb_2 n1_2 VSS) g45n1svt w=(1.45e-07) l=4.5e-08 nf=1 \
        as=2.03e-14 ad=3.77e-14 ps=5.7e-07 pd=8.1e-07 nrd=1.16667 \
        nrs=1.16667 sa=7.01379e-07 sb=3.1e-07 sd=160n sca=12.9138 \
        scb=0.0133404 scc=0.000640143 m=(1)
NM3 (Db_2 \11\:SE n3_2 VSS) g45n1svt w=(1.45e-07) l=4.5e-08 nf=1 \
        as=8.7e-15 ad=3.77e-14 ps=4.1e-07 pd=8.1e-07 nrd=1.16667 \
        nrs=1.16667 sa=3.96379e-07 sb=6.15e-07 sd=160n sca=12.9138 \
        scb=0.0133404 scc=0.000640143 m=(1)
NM4 (n3_2 \1\:SI2 \29\:VSS VSS) g45n1svt w=(1.45e-07) l=4.5e-08 nf=1 \
        as=8.7e-15 ad=7.87e-14 ps=4.1e-07 pd=1.6e-06 nrd=1.16667 \
        nrs=1.16667 sa=7.2e-07 sb=2.91379e-07 sd=160n sca=12.9138 \
        scb=0.0133404 scc=0.000640143 m=(1)
NM0 (\7\:SEb_2 \10\:SE \29\:VSS VSS) g45n1svt w=(1.45e-07) l=4.5e-08 \
        nf=1 as=3.262e-14 ad=7.87e-14 ps=7.4e-07 pd=1.6e-06 nrd=1.16667 \
        nrs=1.16667 sa=4.41897e-07 sb=2.25e-07 sd=160n sca=23.279 \
        scb=0.0230742 scc=0.00267719 m=(1)
mn56 (\9\:qint \4\:qbint \43\:VSS VSS) g45n1svt w=(1.45e-07) l=4.5e-08 \
        nf=1 as=2.03e-14 ad=7.48e-14 ps=5.7e-07 pd=1.6e-06 nrd=1.16667 \
        nrs=1.16667 sa=3.7e-07 sb=1.4e-07 sd=160n sca=23.279 scb=0.0230742 \
        scc=0.00267719 m=(1)
mn46 (\16\:qbint n30 n9 VSS) g45n1svt w=(1.45e-07) l=4.5e-08 nf=1 \
        as=1.45e-14 ad=2.392e-14 ps=4.9e-07 pd=6.2e-07 nrd=1.16667 \
        nrs=1.16667 sa=2e-06 sb=1.65e-07 sd=160n sca=15.7071 scb=0.0167369 \
        scc=0.00113434 m=(1)
mn45 (n9 \1\:RN \39\:VSS VSS) g45n1svt w=(1.45e-07) l=4.5e-08 nf=1 \
        as=1.45e-14 ad=7.75e-14 ps=4.9e-07 pd=1.49e-06 nrd=1.16667 \
        nrs=1.16667 sa=3.1e-07 sb=1.91e-06 sd=160n sca=15.7071 \
        scb=0.0167369 scc=0.00113434 m=(1)
mn50 (n11 \10\:qbint \39\:VSS VSS) g45n1svt w=(1.45e-07) l=4.5e-08 nf=1 \
        as=1.957e-14 ad=7.75e-14 ps=5.6e-07 pd=1.49e-06 nrd=1.16667 \
        nrs=1.16667 sa=5.75e-07 sb=1.645e-06 sd=160n sca=15.7071 \
        scb=0.0167369 scc=0.00113434 m=(1)
mn51 (\6\:n30 CKb n11 VSS) g45n1svt w=(1.45e-07) l=4.5e-08 nf=1 \
        as=2.9e-14 ad=1.957e-14 ps=6.9e-07 pd=5.6e-07 nrd=1.16667 \
        nrs=1.16667 sa=7.55e-07 sb=1.465e-06 sd=160n sca=15.7071 \
        scb=0.0167369 scc=0.00113434 m=(1)
mn40 (\6\:mout \2\:Ckbb \6\:n30 VSS) g45n1svt w=(1.45e-07) l=4.5e-08 nf=1 \
        as=3.335e-14 ad=2.9e-14 ps=7.5e-07 pd=6.9e-07 nrd=1.16667 \
        nrs=1.16667 sa=1e-06 sb=1.22e-06 sd=160n sca=15.7071 scb=0.0167369 \
        scc=0.00113434 m=(1)
mn30 (\6\:mout \3\:n20 \37\:VSS VSS) g45n1svt w=(1.45e-07) l=4.5e-08 \
        nf=1 as=8.475e-14 ad=3.335e-14 ps=1.59e-06 pd=7.5e-07 nrd=1.16667 \
        nrs=1.16667 sa=9.45e-07 sb=1.275e-06 sd=160n sca=15.7071 \
        scb=0.0167369 scc=0.00113434 m=(1)
mn35 (n7 \5\:RN \37\:VSS VSS) g45n1svt w=(1.45e-07) l=4.5e-08 nf=1 \
        as=8.7e-15 ad=8.475e-14 ps=4.1e-07 pd=1.59e-06 nrd=1.16667 \
        nrs=1.16667 sa=1.59e-06 sb=6.3e-07 sd=160n sca=15.7071 \
        scb=0.0167369 scc=0.00113434 m=(1)
mn36 (n5 \3\:mout n7 VSS) g45n1svt w=(1.45e-07) l=4.5e-08 nf=1 \
        as=1.957e-14 ad=8.7e-15 ps=5.6e-07 pd=4.1e-07 nrd=1.16667 \
        nrs=1.16667 sa=1.695e-06 sb=5.25e-07 sd=160n sca=15.7071 \
        scb=0.0167369 scc=0.00113434 m=(1)
mn37 (\9\:n20 \4\:Ckbb n5 VSS) g45n1svt w=(1.45e-07) l=4.5e-08 nf=1 \
        as=2.32e-14 ad=1.957e-14 ps=6.1e-07 pd=5.6e-07 nrd=1.16667 \
        nrs=1.16667 sa=1.875e-06 sb=3.45e-07 sd=160n sca=15.7071 \
        scb=0.0167369 scc=0.00113434 m=(1)
mn25 (\8\:Db \7\:CKb \9\:n20 VSS) g45n1svt w=(1.45e-07) l=4.5e-08 nf=1 \
        as=2.03e-14 ad=2.32e-14 ps=5.7e-07 pd=6.1e-07 nrd=1.16667 \
        nrs=1.16667 sa=2e-06 sb=1.4e-07 sd=160n sca=15.7071 scb=0.0167369 \
        scc=0.00113434 m=(1)
mn11 (n1 \3\:D1 \35\:VSS VSS) g45n1svt w=(1.45e-07) l=4.5e-08 nf=1 \
        as=5.027e-14 ad=2.03e-14 ps=1.33e-06 pd=5.7e-07 nrd=1.16667 \
        nrs=1.16667 sa=8.86379e-07 sb=1.25e-07 sd=160n sca=12.9138 \
        scb=0.0133404 scc=0.000640143 m=(1)
mn12 (\6\:Db \3\:SEb n1 VSS) g45n1svt w=(1.45e-07) l=4.5e-08 nf=1 \
        as=2.03e-14 ad=3.77e-14 ps=5.7e-07 pd=8.1e-07 nrd=1.16667 \
        nrs=1.16667 sa=7.01379e-07 sb=3.1e-07 sd=160n sca=12.9138 \
        scb=0.0133404 scc=0.000640143 m=(1)
mn14 (\6\:Db \3\:SE n3 VSS) g45n1svt w=(1.45e-07) l=4.5e-08 nf=1 \
        as=8.7e-15 ad=3.77e-14 ps=4.1e-07 pd=8.1e-07 nrd=1.16667 \
        nrs=1.16667 sa=3.96379e-07 sb=6.15e-07 sd=160n sca=12.9138 \
        scb=0.0133404 scc=0.000640143 m=(1)
mn13 (n3 \1\:SI1 \33\:VSS VSS) g45n1svt w=(1.45e-07) l=4.5e-08 nf=1 \
        as=8.7e-15 ad=7.87e-14 ps=4.1e-07 pd=1.6e-06 nrd=1.16667 \
        nrs=1.16667 sa=7.2e-07 sb=2.91379e-07 sd=160n sca=12.9138 \
        scb=0.0133404 scc=0.000640143 m=(1)
mn10 (\4\:SEb \7\:SE \33\:VSS VSS) g45n1svt w=(1.45e-07) l=4.5e-08 nf=1 \
        as=3.262e-14 ad=7.87e-14 ps=7.4e-07 pd=1.6e-06 nrd=1.16667 \
        nrs=1.16667 sa=4.41897e-07 sb=2.25e-07 sd=160n sca=23.279 \
        scb=0.0230742 scc=0.00267719 m=(1)
mp21 (\17\:Ckbb \11\:CKb \35\:VDD VDD) g45p1svt w=(2.15e-07) l=4.5e-08 \
        nf=1 as=3.01e-14 ad=8.732e-14 ps=7.1e-07 pd=1.85e-06 nrd=1.16667 \
        nrs=1.16667 sa=1.4e-07 sb=3.6e-07 sd=160n sca=31.508 scb=0.0252524 \
        scc=0.00399199 m=(1)
mp20 (\32\:CKb \1\:CK \35\:VDD VDD) g45p1svt w=(2.15e-07) l=4.5e-08 nf=1 \
        as=3.01e-14 ad=8.732e-14 ps=7.1e-07 pd=1.85e-06 nrd=1.16667 \
        nrs=1.16667 sa=3.6e-07 sb=1.4e-07 sd=160n sca=31.508 scb=0.0252524 \
        scc=0.00399199 m=(1)
PM18 (\9\:qint_2 \4\:qbint_2 \1\:VDD VDD) g45p1svt w=(2.15e-07) \
        l=4.5e-08 nf=1 as=9.843e-14 ad=3.01e-14 ps=1.97e-06 pd=7.1e-07 \
        nrd=1.16667 nrs=1.16667 sa=1.4e-07 sb=3.7e-07 sd=160n sca=48.5748 \
        scb=0.0312356 scc=0.00590118 m=(1)
PM14 (\13\:qbint_2 n30_2 \23\:VDD VDD) g45p1svt w=(2.15e-07) l=4.5e-08 \
        nf=1 as=1.4115e-13 ad=3.44e-14 ps=2.12e-06 pd=7.5e-07 nrd=1.16667 \
        nrs=1.16667 sa=1.69e-06 sb=5.15e-07 sd=160n sca=29.9075 \
        scb=0.0247057 scc=0.00372713 m=(1)
PM13 (\13\:qbint_2 \13\:RN \25\:VDD VDD) g45p1svt w=(2.15e-07) l=4.5e-08 \
        nf=1 as=3.44e-14 ad=1.049e-13 ps=7.5e-07 pd=1.83e-06 nrd=1.16667 \
        nrs=1.16667 sa=7.2e-07 sb=1.485e-06 sd=160n sca=29.9075 \
        scb=0.0247057 scc=0.00372713 m=(1)
PM15 (n8_2 qbint_2 \25\:VDD VDD) g45p1svt w=(2.15e-07) l=4.5e-08 nf=1 \
        as=3.01e-14 ad=1.049e-13 ps=7.1e-07 pd=1.83e-06 nrd=1.16667 \
        nrs=1.16667 sa=9.85e-07 sb=1.22e-06 sd=160n sca=29.9075 \
        scb=0.0247057 scc=0.00372713 m=(1)
PM16 (\4\:n30_2 \12\:Ckbb n8_2 VDD) g45p1svt w=(2.15e-07) l=4.5e-08 nf=1 \
        as=3.01e-14 ad=5.375e-14 ps=7.1e-07 pd=9.3e-07 nrd=1.16667 \
        nrs=1.16667 sa=1.035e-06 sb=1.17e-06 sd=160n sca=29.9075 \
        scb=0.0247057 scc=0.00372713 m=(1)
PM12 (\4\:n30_2 \15\:CKb \4\:mout_2 VDD) g45p1svt w=(2.15e-07) l=4.5e-08 \
        nf=1 as=3.762e-14 ad=5.375e-14 ps=7.8e-07 pd=9.3e-07 nrd=1.16667 \
        nrs=1.16667 sa=7.4e-07 sb=1.465e-06 sd=160n sca=29.9075 \
        scb=0.0247057 scc=0.00372713 m=(1)
PM8 (\4\:mout_2 n20_2 \27\:VDD VDD) g45p1svt w=(2.15e-07) l=4.5e-08 nf=1 \
        as=8.415e-14 ad=3.762e-14 ps=1.83e-06 pd=7.8e-07 nrd=1.16667 \
        nrs=1.16667 sa=5.2e-07 sb=1.685e-06 sd=160n sca=29.9075 \
        scb=0.0247057 scc=0.00372713 m=(1)
PM9 (n6_2 \9\:RN \27\:VDD VDD) g45p1svt w=(2.15e-07) l=4.5e-08 nf=1 \
        as=8.415e-14 ad=3.44e-14 ps=1.83e-06 pd=7.5e-07 nrd=1.16667 \
        nrs=1.16667 sa=3.05e-07 sb=1.9e-06 sd=160n sca=29.9075 \
        scb=0.0247057 scc=0.00372713 m=(1)
PM11 (n6_2 mout_2 \29\:VDD VDD) g45p1svt w=(2.15e-07) l=4.5e-08 nf=1 \
        as=3.44e-14 ad=6.29e-14 ps=7.5e-07 pd=1.83e-06 nrd=1.16667 \
        nrs=1.16667 sa=2e-06 sb=1e-07 sd=160n sca=29.9075 scb=0.0247057 \
        scc=0.00372713 m=(1)
PM10 (\7\:n20_2 \13\:CKb \3\:n6_2 VDD) g45p1svt w=(2.15e-07) l=4.5e-08 \
        nf=1 as=3.44e-14 ad=3.01e-14 ps=7.5e-07 pd=7.1e-07 nrd=1.16667 \
        nrs=1.16667 sa=1.4e-07 sb=3.31977e-07 sd=160n sca=45.7906 \
        scb=0.0283307 scc=0.00588417 m=(1)
PM7 (\7\:n20_2 \8\:Ckbb \4\:Db_2 VDD) g45p1svt w=(2.15e-07) l=4.5e-08 \
        nf=1 as=2.73e-14 ad=3.44e-14 ps=7.1e-07 pd=7.5e-07 nrd=1.16667 \
        nrs=1.16667 sa=1.26977e-07 sb=3.45e-07 sd=160n sca=45.7906 \
        scb=0.0283307 scc=0.00588417 m=(1)
PM1 (n2_2 \1\:D2 \31\:VDD VDD) g45p1svt w=(2.15e-07) l=4.5e-08 nf=1 \
        as=7.005e-14 ad=3.87e-14 ps=1.71e-06 pd=7.9e-07 nrd=1.16667 \
        nrs=1.16667 sa=1e-06 sb=1.10465e-07 sd=160n sca=21.1782 \
        scb=0.0203295 scc=0.00208843 m=(1)
PM2 (\6\:Db_2 \13\:SE n2_2 VDD) g45p1svt w=(2.15e-07) l=4.5e-08 nf=1 \
        as=3.87e-14 ad=3.44e-14 ps=7.9e-07 pd=7.5e-07 nrd=1.16667 \
        nrs=1.16667 sa=7.75e-07 sb=3.35465e-07 sd=160n sca=21.1782 \
        scb=0.0203295 scc=0.00208843 m=(1)
PM4 (\6\:Db_2 \3\:SEb_2 n4_2 VDD) g45p1svt w=(2.15e-07) l=4.5e-08 nf=1 \
        as=2.58e-14 ad=3.44e-14 ps=6.7e-07 pd=7.5e-07 nrd=1.16667 \
        nrs=1.16667 sa=5.7e-07 sb=5.40465e-07 sd=160n sca=21.1782 \
        scb=0.0203295 scc=0.00208843 m=(1)
PM3 (n4_2 \3\:SI2 \33\:VDD VDD) g45p1svt w=(2.15e-07) l=4.5e-08 nf=1 \
        as=2.58e-14 ad=1.001e-13 ps=6.7e-07 pd=1.75e-06 nrd=1.16667 \
        nrs=1.16667 sa=7.05465e-07 sb=4.05e-07 sd=160n sca=21.1782 \
        scb=0.0203295 scc=0.00208843 m=(1)
PM0 (\5\:SEb_2 \8\:SE \33\:VDD VDD) g45p1svt w=(2.15e-07) l=4.5e-08 nf=1 \
        as=3.01e-14 ad=1.001e-13 ps=7.1e-07 pd=1.75e-06 nrd=1.16667 \
        nrs=1.16667 sa=9.70465e-07 sb=1.4e-07 sd=160n sca=21.1782 \
        scb=0.0203295 scc=0.00208843 m=(1)
mp56 (\5\:qint \7\:qbint \49\:VDD VDD) g45p1svt w=(2.15e-07) l=4.5e-08 \
        nf=1 as=9.842e-14 ad=3.01e-14 ps=1.97e-06 pd=7.1e-07 nrd=1.16667 \
        nrs=1.16667 sa=1.4e-07 sb=3.7e-07 sd=160n sca=48.5748 \
        scb=0.0312356 scc=0.00590118 m=(1)
mp46 (\12\:qbint \3\:n30 \47\:VDD VDD) g45p1svt w=(2.15e-07) l=4.5e-08 \
        nf=1 as=1.4115e-13 ad=3.44e-14 ps=2.12e-06 pd=7.5e-07 nrd=1.16667 \
        nrs=1.16667 sa=1.69e-06 sb=5.15e-07 sd=160n sca=29.9075 \
        scb=0.0247057 scc=0.00372713 m=(1)
mp45 (\12\:qbint \3\:RN \45\:VDD VDD) g45p1svt w=(2.15e-07) l=4.5e-08 \
        nf=1 as=3.44e-14 ad=1.049e-13 ps=7.5e-07 pd=1.83e-06 nrd=1.16667 \
        nrs=1.16667 sa=7.2e-07 sb=1.485e-06 sd=160n sca=29.9075 \
        scb=0.0247057 scc=0.00372713 m=(1)
mp50 (n8 \8\:qbint \45\:VDD VDD) g45p1svt w=(2.15e-07) l=4.5e-08 nf=1 \
        as=3.01e-14 ad=1.049e-13 ps=7.1e-07 pd=1.83e-06 nrd=1.16667 \
        nrs=1.16667 sa=9.85e-07 sb=1.22e-06 sd=160n sca=29.9075 \
        scb=0.0247057 scc=0.00372713 m=(1)
mp51 (\4\:n30 \3\:Ckbb n8 VDD) g45p1svt w=(2.15e-07) l=4.5e-08 nf=1 \
        as=3.01e-14 ad=5.375e-14 ps=7.1e-07 pd=9.3e-07 nrd=1.16667 \
        nrs=1.16667 sa=1.035e-06 sb=1.17e-06 sd=160n sca=29.9075 \
        scb=0.0247057 scc=0.00372713 m=(1)
mp40 (\4\:n30 \3\:CKb \8\:mout VDD) g45p1svt w=(2.15e-07) l=4.5e-08 nf=1 \
        as=3.762e-14 ad=5.375e-14 ps=7.8e-07 pd=9.3e-07 nrd=1.16667 \
        nrs=1.16667 sa=7.4e-07 sb=1.465e-06 sd=160n sca=29.9075 \
        scb=0.0247057 scc=0.00372713 m=(1)
mp30 (\8\:mout \4\:n20 \43\:VDD VDD) g45p1svt w=(2.15e-07) l=4.5e-08 \
        nf=1 as=8.415e-14 ad=3.762e-14 ps=1.83e-06 pd=7.8e-07 nrd=1.16667 \
        nrs=1.16667 sa=5.2e-07 sb=1.685e-06 sd=160n sca=29.9075 \
        scb=0.0247057 scc=0.00372713 m=(1)
mp35 (\3\:n6 \6\:RN \43\:VDD VDD) g45p1svt w=(2.15e-07) l=4.5e-08 nf=1 \
        as=8.415e-14 ad=3.44e-14 ps=1.83e-06 pd=7.5e-07 nrd=1.16667 \
        nrs=1.16667 sa=3.05e-07 sb=1.9e-06 sd=160n sca=29.9075 \
        scb=0.0247057 scc=0.00372713 m=(1)
mp36 (\3\:n6 mout \41\:VDD VDD) g45p1svt w=(2.15e-07) l=4.5e-08 nf=1 \
        as=3.44e-14 ad=6.29e-14 ps=7.5e-07 pd=1.83e-06 nrd=1.16667 \
        nrs=1.16667 sa=2e-06 sb=1e-07 sd=160n sca=29.9075 scb=0.0247057 \
        scc=0.00372713 m=(1)
mp37 (\5\:n20 \6\:CKb n6 VDD) g45p1svt w=(2.15e-07) l=4.5e-08 nf=1 \
        as=3.44e-14 ad=3.01e-14 ps=7.5e-07 pd=7.1e-07 nrd=1.16667 \
        nrs=1.16667 sa=1.4e-07 sb=3.31977e-07 sd=160n sca=45.7906 \
        scb=0.0283307 scc=0.00588417 m=(1)
mp25 (\5\:n20 \6\:Ckbb \4\:Db VDD) g45p1svt w=(2.15e-07) l=4.5e-08 nf=1 \
        as=2.73e-14 ad=3.44e-14 ps=7.1e-07 pd=7.5e-07 nrd=1.16667 \
        nrs=1.16667 sa=1.26977e-07 sb=3.45e-07 sd=160n sca=45.7906 \
        scb=0.0283307 scc=0.00588417 m=(1)
mp11 (n2 \1\:D1 \39\:VDD VDD) g45p1svt w=(2.15e-07) l=4.5e-08 nf=1 \
        as=7.005e-14 ad=3.87e-14 ps=1.71e-06 pd=7.9e-07 nrd=1.16667 \
        nrs=1.16667 sa=1e-06 sb=1.10465e-07 sd=160n sca=21.1782 \
        scb=0.0203295 scc=0.00208843 m=(1)
mp12 (Db \1\:SE n2 VDD) g45p1svt w=(2.15e-07) l=4.5e-08 nf=1 as=3.87e-14 \
        ad=3.44e-14 ps=7.9e-07 pd=7.5e-07 nrd=1.16667 nrs=1.16667 \
        sa=7.75e-07 sb=3.35465e-07 sd=160n sca=21.1782 scb=0.0203295 \
        scc=0.00208843 m=(1)
mp14 (Db SEb n4 VDD) g45p1svt w=(2.15e-07) l=4.5e-08 nf=1 as=2.58e-14 \
        ad=3.44e-14 ps=6.7e-07 pd=7.5e-07 nrd=1.16667 nrs=1.16667 \
        sa=5.7e-07 sb=5.40465e-07 sd=160n sca=21.1782 scb=0.0203295 \
        scc=0.00208843 m=(1)
mp13 (n4 \3\:SI1 \37\:VDD VDD) g45p1svt w=(2.15e-07) l=4.5e-08 nf=1 \
        as=2.58e-14 ad=1.001e-13 ps=6.7e-07 pd=1.75e-06 nrd=1.16667 \
        nrs=1.16667 sa=7.05465e-07 sb=4.05e-07 sd=160n sca=21.1782 \
        scb=0.0203295 scc=0.00208843 m=(1)
mp10 (\6\:SEb \5\:SE \37\:VDD VDD) g45p1svt w=(2.15e-07) l=4.5e-08 nf=1 \
        as=3.01e-14 ad=1.001e-13 ps=7.1e-07 pd=1.75e-06 nrd=1.16667 \
        nrs=1.16667 sa=9.70465e-07 sb=1.4e-07 sd=160n sca=21.1782 \
        scb=0.0203295 scc=0.00208843 m=(1)
ends SPDFF2RX1
// End of subcircuit definition.
