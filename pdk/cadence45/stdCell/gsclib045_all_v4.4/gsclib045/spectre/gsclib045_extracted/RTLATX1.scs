// Generated for: spectre (May  1 08:12:29 2013 )
// Library name: gsclib045
// Cell name: RTLATX1
// View name: extracted

simulator lang=spectre

subckt RTLATX1 D ExtVDD G Q QN RT VDD VSS
mp5 (net220 \3\:D \16\:VDD VDD) g45p1svt w=(2.15e-07) l=4.5e-08 nf=1 \
        as=1.29e-14 ad=3.44e-14 ps=5.5e-07 pd=7.5e-07 nrd=1.16667 \
        nrs=1.16667 sa=3.45e-07 sb=2.45e-07 sd=160n sca=19.7192 \
        scb=0.0218524 scc=0.000619363 m=(1)
mp1 (\8\:Gbb \3\:Gb \16\:VDD VDD) g45p1svt w=(2.15e-07) l=4.5e-08 nf=1 \
        as=3.44e-14 ad=3.01e-14 ps=7.5e-07 pd=7.1e-07 nrd=1.16667 \
        nrs=1.16667 sa=1.4e-07 sb=4.5e-07 sd=160n sca=21.2798 \
        scb=0.0239423 scc=0.000923328 m=(1)
mp0 (\15\:Gb \1\:G \13\:VDD VDD) g45p1svt w=(2.15e-07) l=4.5e-08 nf=1 \
        as=3.01e-14 ad=3.01e-14 ps=7.1e-07 pd=7.1e-07 nrd=1.16667 \
        nrs=1.16667 sa=1.4e-07 sb=1.4e-07 sd=160n sca=22.6619 \
        scb=0.0252789 scc=0.00128716 m=(1)
mp6 (\5\:n0 \4\:Gb net220 VDD) g45p1svt w=(2.15e-07) l=4.5e-08 nf=1 \
        as=1.29e-14 ad=3.01e-14 ps=5.5e-07 pd=7.1e-07 nrd=1.16667 \
        nrs=1.16667 sa=4.5e-07 sb=1.4e-07 sd=160n sca=29.5047 \
        scb=0.0315778 scc=0.00276782 m=(1)
PM0 (\7\:n0g \7\:RT \9\:n0 ExtVDD) g45p1svt w=(2.15e-07) l=4.5e-08 nf=1 \
        as=3.01e-14 ad=3.01e-14 ps=7.1e-07 pd=7.1e-07 nrd=1.16667 \
        nrs=1.16667 sa=1.4e-07 sb=1.4e-07 sd=160n sca=29.8246 scb=0.033558 \
        scc=0.00297535 m=(1)
mp11 (\17\:Qint \4\:n0g \10\:ExtVDD ExtVDD) g45p1svt w=(2.15e-07) \
        l=4.5e-08 nf=1 as=3.01e-14 ad=3.01e-14 ps=7.1e-07 pd=7.1e-07 \
        nrd=1.16667 nrs=1.16667 sa=1.4e-07 sb=1.4e-07 sd=160n sca=12.1365 \
        scb=0.0108856 scc=0.000154611 m=(1)
mp45 (\7\:RTb \5\:RT \3\:ExtVDD ExtVDD) g45p1svt w=(2.15e-07) l=4.5e-08 \
        nf=1 as=3.01e-14 ad=3.01e-14 ps=7.1e-07 pd=7.1e-07 nrd=1.16667 \
        nrs=1.16667 sa=1.4e-07 sb=1.4e-07 sd=160n sca=13.1336 scb=0.011983 \
        scc=0.00033933 m=(1)
PM2 (net145 \12\:Qint \6\:ExtVDD ExtVDD) g45p1svt w=(2.15e-07) l=4.5e-08 \
        nf=1 as=3.01e-14 ad=1.29e-14 ps=7.1e-07 pd=5.5e-07 nrd=1.16667 \
        nrs=1.16667 sa=1.4e-07 sb=2.45e-07 sd=160n sca=15.9786 \
        scb=0.0173297 scc=0.000549121 m=(1)
PM3 (\11\:n0g \3\:RTb net145 ExtVDD) g45p1svt w=(2.15e-07) l=4.5e-08 nf=1 \
        as=1.29e-14 ad=3.01e-14 ps=5.5e-07 pd=7.1e-07 nrd=1.16667 \
        nrs=1.16667 sa=2.45e-07 sb=1.4e-07 sd=160n sca=27.0191 \
        scb=0.0289692 scc=0.00271657 m=(1)
mp16 (net095 \4\:Gbb net212 VDD) g45p1svt w=(2.15e-07) l=4.5e-08 nf=1 \
        as=1.29e-14 ad=3.01e-14 ps=5.5e-07 pd=7.1e-07 nrd=1.16667 \
        nrs=1.16667 sa=1.4e-07 sb=2.45e-07 sd=160n sca=11.6742 \
        scb=0.00884358 scc=0.00012544 m=(1)
mp15 (net212 \2\:Qint \1\:VDD VDD) g45p1svt w=(2.15e-07) l=4.5e-08 nf=1 \
        as=3.01e-14 ad=1.29e-14 ps=7.1e-07 pd=5.5e-07 nrd=1.16667 \
        nrs=1.16667 sa=2.45e-07 sb=1.4e-07 sd=160n sca=12.7038 \
        scb=0.0109783 scc=0.00016343 m=(1)
C1 (RT VSS) capacitor c=2.61387e-17
C2 (QN VSS) capacitor c=3.77754e-17
C3 (VDD VSS) capacitor c=2.75455e-16
C4 (ExtVDD VSS) capacitor c=2.75089e-16
C5 (Q VSS) capacitor c=4.9626e-17
C6 (D VSS) capacitor c=5.59028e-17
C7 (Gb VSS) capacitor c=5.41702e-17
C8 (Gbb VSS) capacitor c=1.21753e-16
C9 (Qbint VSS) capacitor c=3.00348e-17
C10 (n0 VSS) capacitor c=6.47987e-17
C11 (Qint VSS) capacitor c=8.12939e-17
C12 (n0g VSS) capacitor c=4.73884e-17
C13 (RTb VSS) capacitor c=4.21035e-17
C14 (net095 VSS) capacitor c=4.50439e-17
C15 (\4\:Qbint VSS) capacitor c=3.8933e-17
C16 (\2\:Qint VSS) capacitor c=1.1609e-16
C17 (\4\:Gbb VSS) capacitor c=1.15216e-16
C18 (\3\:Qint VSS) capacitor c=6.29363e-17
C19 (\10\:Qint VSS) capacitor c=2.28005e-17
C20 (\3\:RTb VSS) capacitor c=9.30377e-17
C21 (\12\:Qint VSS) capacitor c=6.6295e-17
C22 (\5\:RT VSS) capacitor c=5.28764e-17
C23 (\4\:n0g VSS) capacitor c=9.37464e-17
C24 (\7\:RT VSS) capacitor c=3.47138e-17
C25 (\4\:Gb VSS) capacitor c=5.88761e-17
C26 (\1\:G VSS) capacitor c=3.78016e-17
C27 (\3\:D VSS) capacitor c=7.36283e-17
C28 (\3\:Gb VSS) capacitor c=7.65507e-17
C29 (\8\:Gb VSS) capacitor c=1.12378e-16
C30 (\9\:Qint VSS) capacitor c=2.62182e-17
C31 (\11\:Qint VSS) capacitor c=2.49102e-17
C32 (\13\:Qint VSS) capacitor c=5.79159e-17
C33 (\9\:RT VSS) capacitor c=9.33417e-17
C34 (\1\:RT VSS) capacitor c=4.9922e-17
C35 (\3\:n0g VSS) capacitor c=2.34422e-17
C36 (\2\:RTb VSS) capacitor c=4.7536e-17
C37 (\3\:Gbb VSS) capacitor c=4.2823e-17
C38 (\1\:D VSS) capacitor c=7.07926e-17
C39 (\3\:G VSS) capacitor c=4.26845e-17
C40 (\5\:Gb VSS) capacitor c=6.12922e-17
C41 (\3\:Qbint VSS) capacitor c=2.77551e-17
C42 (\5\:Gbb VSS) capacitor c=7.18908e-17
C43 (\9\:Gb VSS) capacitor c=5.88556e-17
C44 (\8\:RT VSS) capacitor c=6.09055e-17
C45 (\4\:RTb VSS) capacitor c=7.8294e-17
C46 (\5\:RTb VSS) capacitor c=4.61984e-17
C47 (\6\:RT VSS) capacitor c=5.62345e-17
C48 (\2\:ExtVDD VSS) capacitor c=5.36393e-17
C49 (\1\:ExtVDD VSS) capacitor c=4.85819e-17
C50 (\5\:n0g VSS) capacitor c=1.01425e-16
C51 (\6\:Gb VSS) capacitor c=1.03458e-16
C52 (\8\:Qint VSS) capacitor c=7.80029e-17
C53 (\4\:RT VSS) capacitor c=3.41171e-17
C54 (\2\:n0 VSS) capacitor c=8.0185e-17
C55 (\7\:Gb VSS) capacitor c=4.75479e-17
C56 (\2\:Gbb VSS) capacitor c=1.0809e-16
C57 (\2\:D VSS) capacitor c=5.64169e-17
C58 (\2\:G VSS) capacitor c=4.89896e-17
C59 (\3\:Q VSS) capacitor c=5.42768e-17
C60 (\9\:VDD VSS) capacitor c=7.21267e-17
C61 (\1\:VDD VSS) capacitor c=2.27562e-17
C62 (\7\:Qbint VSS) capacitor c=8.16158e-17
C63 (\11\:VDD VSS) capacitor c=8.74983e-17
C64 (\1\:QN VSS) capacitor c=6.44243e-17
C65 (\11\:n0g VSS) capacitor c=1.19645e-16
C66 (\6\:ExtVDD VSS) capacitor c=6.47286e-17
C67 (\7\:RTb VSS) capacitor c=3.89701e-17
C68 (\3\:ExtVDD VSS) capacitor c=4.00298e-17
C69 (\10\:ExtVDD VSS) capacitor c=6.2815e-17
C70 (\17\:Qint VSS) capacitor c=4.89896e-17
C71 (\7\:n0g VSS) capacitor c=7.40167e-17
C72 (\9\:n0 VSS) capacitor c=1.0991e-16
C73 (\5\:n0 VSS) capacitor c=2.63642e-17
C74 (\15\:Gb VSS) capacitor c=3.32971e-17
C75 (\13\:VDD VSS) capacitor c=3.63886e-17
C76 (\16\:VDD VSS) capacitor c=5.22232e-17
C77 (\8\:Gbb VSS) capacitor c=5.09661e-17
C78 (\1\:Q VSS) capacitor c=2.93217e-17
C79 (\9\:Qbint VSS) capacitor c=5.58419e-17
C80 (\3\:net095 VSS) capacitor c=4.49401e-17
C81 (\3\:QN VSS) capacitor c=4.68919e-17
C82 (\12\:RTb VSS) capacitor c=2.26454e-17
C83 (\15\:n0g VSS) capacitor c=1.89833e-17
C84 (\14\:Qint VSS) capacitor c=3.90578e-17
C85 (\9\:n0g VSS) capacitor c=8.89525e-17
C86 (\12\:n0 VSS) capacitor c=6.18656e-17
C87 (\7\:n0 VSS) capacitor c=6.87194e-17
C88 (\13\:Gb VSS) capacitor c=4.50314e-17
C89 (\10\:Gbb VSS) capacitor c=2.54951e-17
C90 (\2\:Gb VSS) capacitor c=7.83131e-17
C91 (ExtVDD VSS) capacitor c=3.85206e-17
C92 (VDD VSS) capacitor c=3.4637e-16
C93 (\2\:n0g VSS) capacitor c=4.75407e-17
C94 (\2\:RT VSS) capacitor c=6.11578e-17
C95 (\3\:RT VSS) capacitor c=5.5761e-17
C96 (\4\:Qint VSS) capacitor c=2.4764e-17
C97 (\5\:Qint VSS) capacitor c=4.98633e-17
C98 (\6\:Qint VSS) capacitor c=6.53775e-17
C99 (\7\:Qint VSS) capacitor c=4.10981e-17
C100 (\2\:Qbint VSS) capacitor c=2.21289e-17
C101 (\4\:G VSS) capacitor c=3.45237e-17
C102 (\5\:G VSS) capacitor c=3.63272e-18
C103 (\6\:G VSS) capacitor c=3.04226e-17
C104 (\6\:Gbb VSS) capacitor c=5.36329e-17
C105 (\7\:Gbb VSS) capacitor c=5.79338e-17
C106 (\10\:Gb VSS) capacitor c=1.31732e-17
C107 (\11\:Gb VSS) capacitor c=3.37647e-17
C108 (\12\:Gb VSS) capacitor c=4.19735e-17
C109 (\17\:Gb VSS) capacitor c=6.40745e-18
C110 (\3\:n0 VSS) capacitor c=2.52061e-17
C111 (\4\:n0 VSS) capacitor c=5.67574e-17
C112 (\13\:RT VSS) capacitor c=2.31102e-17
C113 (\11\:n0 VSS) capacitor c=5.36566e-17
C114 (\16\:Qint VSS) capacitor c=6.03967e-17
C115 (\6\:n0g VSS) capacitor c=2.48841e-17
C116 (\5\:ExtVDD VSS) capacitor c=5.42328e-17
C117 (\12\:ExtVDD VSS) capacitor c=2.95385e-17
C118 (\6\:RTb VSS) capacitor c=2.30693e-17
C119 (\9\:RTb VSS) capacitor c=3.91242e-17
C120 (\10\:RTb VSS) capacitor c=6.06984e-17
C121 (\11\:RTb VSS) capacitor c=6.24997e-17
C122 (\13\:n0g VSS) capacitor c=9.90514e-17
C123 (\14\:n0g VSS) capacitor c=2.87856e-17
C124 (\14\:RT VSS) capacitor c=1.29591e-16
C125 (\15\:RT VSS) capacitor c=1.30662e-16
C126 (\18\:Gb VSS) capacitor c=7.87232e-17
C127 (\19\:Gb VSS) capacitor c=1.21864e-16
C128 (\12\:Gbb VSS) capacitor c=1.84973e-16
C129 (\13\:Gbb VSS) capacitor c=2.43357e-16
C130 (\5\:Qbint VSS) capacitor c=2.93834e-17
C131 (\3\:VDD VSS) capacitor c=3.71204e-17
C132 (\5\:VDD VSS) capacitor c=2.16902e-17
C133 (\6\:VDD VSS) capacitor c=8.72087e-17
C134 (\15\:VDD VSS) capacitor c=1.19853e-16
Rk18 (\10\:RT RT) resistor r=0.003536 c=0
Rk19 (\11\:RT RT) resistor r=0.002122 c=0
Rk20 (\10\:RT \11\:RT) resistor r=0.01898 c=0
Rk22 (\11\:RT \13\:RT) resistor r=0.02088 c=0
Rk21 (\12\:RT \13\:RT) resistor r=0.003536 c=0
Rk42 (\14\:RT \15\:RT) resistor r=1.0351 c=0
Rk46 (QN \4\:QN) resistor r=0.09302 c=0
Rk45 (\2\:QN \4\:QN) resistor r=0.5711 c=0
Rk53 (\2\:VDD \3\:VDD) resistor r=0.2736 c=0
Rk54 (\3\:VDD \5\:VDD) resistor r=0.1877 c=0
Rk56 (\6\:VDD VDD) resistor r=0.8217 c=0
Rk55 (\5\:VDD \6\:VDD) resistor r=0.03919 c=0
Rk57 (VDD \8\:VDD) resistor r=0.9799 c=0
Rk58 (\3\:VDD \10\:VDD) resistor r=0.4167 c=0
Rk59 (\6\:VDD \12\:VDD) resistor r=0.3716 c=0
Rk60 (\8\:VDD \14\:VDD) resistor r=0.3183 c=0
Rk62 (\15\:VDD VDD) resistor r=0.05125 c=0
Rk61 (\8\:VDD \15\:VDD) resistor r=0.05451 c=0
Rk63 (\15\:VDD \17\:VDD) resistor r=0.2832 c=0
Rk64 (\2\:VSS \3\:VSS) resistor r=0.1278 c=0
Rk66 (\4\:VSS VSS) resistor r=0.5417 c=0
Rk65 (\3\:VSS \4\:VSS) resistor r=0.5118 c=0
Rk68 (\5\:VSS VSS) resistor r=0.1844 c=0
Rk67 (VSS \5\:VSS) resistor r=0.6404 c=0
Rk69 (VSS \7\:VSS) resistor r=0.5061 c=0
Rk70 (\3\:VSS \9\:VSS) resistor r=0.2882 c=0
Rk71 (VSS \11\:VSS) resistor r=0.3032 c=0
Rk72 (\13\:VSS \14\:VSS) resistor r=0.1303 c=0
Rk73 (\14\:VSS \15\:VSS) resistor r=0.2285 c=0
Rk74 (\15\:VSS \16\:VSS) resistor r=0.2804 c=0
Rk76 (\17\:VSS VSS) resistor r=0.2088 c=0
Rk75 (\16\:VSS \17\:VSS) resistor r=0.3321 c=0
Rk77 (VSS \18\:VSS) resistor r=0.2708 c=0
Rk79 (\19\:VSS VSS) resistor r=0.3793 c=0
Rk78 (\18\:VSS \19\:VSS) resistor r=0.369 c=0
Rk80 (VSS \21\:VSS) resistor r=0.283 c=0
Rk81 (\14\:VSS \23\:VSS) resistor r=0.2458 c=0
Rk82 (\15\:VSS \25\:VSS) resistor r=0.2575 c=0
Rk83 (\17\:VSS \27\:VSS) resistor r=0.2753 c=0
Rk84 (\18\:VSS \29\:VSS) resistor r=0.2415 c=0
Rk1 (\4\:G G) resistor r=0.007228 c=0
Rk2 (G \5\:G) resistor r=0.007038 c=0
Rk3 (\4\:G \5\:G) resistor r=0.004546 c=0
Rk5 (\5\:G \6\:G) resistor r=0.007576 c=0
Rk4 (\6\:G \7\:G) resistor r=0.005136 c=0
Rk31 (ExtVDD ExtVDD) resistor r=0.001963 c=0
Rk29 (\4\:ExtVDD \5\:ExtVDD) resistor r=0.2255 c=0
Rk30 (\7\:ExtVDD ExtVDD) resistor r=0.1352 c=0
Rk33 (ExtVDD \11\:ExtVDD) resistor r=0.1516 c=0
Rk34 (\11\:ExtVDD \12\:ExtVDD) resistor r=0.2295 c=0
Rk51 (\2\:Q Q) resistor r=0.2143 c=0
Rk52 (Q \4\:Q) resistor r=0.3507 c=0
Rk10 (\10\:Gb \11\:Gb) resistor r=0.156 c=0
Rk11 (\11\:Gb \12\:Gb) resistor r=0.2411 c=0
Rk12 (\12\:Gb \14\:Gb) resistor r=0.2401 c=0
Rk13 (\11\:Gb \16\:Gb) resistor r=0.1464 c=0
Rk14 (\12\:Gb \17\:Gb) resistor r=0.1139 c=0
Rk43 (\18\:Gb \19\:Gb) resistor r=0.7236 c=0
Rk7 (\6\:Gbb \7\:Gbb) resistor r=0.2873 c=0
Rk8 (\7\:Gbb \9\:Gbb) resistor r=0.4402 c=0
Rk9 (\7\:Gbb \11\:Gbb) resistor r=0.168 c=0
Rk44 (\12\:Gbb \13\:Gbb) resistor r=1.605 c=0
Rk48 (\5\:Qbint \6\:Qbint) resistor r=0.02326 c=0
Rk49 (\6\:Qbint \8\:Qbint) resistor r=0.3083 c=0
Rk50 (\6\:Qbint \10\:Qbint) resistor r=0.2047 c=0
Rk15 (\3\:n0 \4\:n0) resistor r=0.3083 c=0
Rk16 (\4\:n0 \6\:n0) resistor r=0.1986 c=0
Rk17 (\4\:n0 \8\:n0) resistor r=0.4678 c=0
Rk23 (\10\:n0 \11\:n0) resistor r=0.4878 c=0
Rk24 (\10\:n0 \13\:n0) resistor r=0.5665 c=0
Rk25 (\15\:Qint \16\:Qint) resistor r=0.2099 c=0
Rk26 (\16\:Qint \18\:Qint) resistor r=0.4287 c=0
Rk27 (\6\:n0g \8\:n0g) resistor r=0.1078 c=0
Rk28 (\8\:n0g \10\:n0g) resistor r=0.5632 c=0
Rk39 (\12\:n0g \13\:n0g) resistor r=0.7323 c=0
Rk40 (\13\:n0g \14\:n0g) resistor r=0.1057 c=0
Rk41 (\13\:n0g \16\:n0g) resistor r=0.08816 c=0
Rk35 (\6\:RTb \8\:RTb) resistor r=0.1317 c=0
Rk36 (\9\:RTb \10\:RTb) resistor r=0.1666 c=0
Rk37 (\10\:RTb \11\:RTb) resistor r=0.327 c=0
Rk38 (\10\:RTb \13\:RTb) resistor r=0.09304 c=0
Rk47 (\2\:net095 \4\:net095) resistor r=0.5082 c=0
Rl27 (\8\:RT \9\:RT) resistor r=350.785 c=0
Rl23 (\5\:RT \6\:RT) resistor r=204.389 c=0
Rl22 (\2\:RT \5\:RT) resistor r=26.665 c=0
Rl19 (\1\:RT \2\:RT) resistor r=182.259 c=0
Rl24 (\3\:RT \7\:RT) resistor r=21.372 c=0
Rl21 (\3\:RT \4\:RT) resistor r=104.717 c=0
Rl20 (\2\:RT \3\:RT) resistor r=218.989 c=0
Rl3 (\1\:G \2\:G) resistor r=88.3245 c=0
Rl4 (\2\:G \3\:G) resistor r=127.297 c=0
Rl14 (\1\:ExtVDD \2\:ExtVDD) resistor r=176.713 c=0
Rl2 (\2\:D \3\:D) resistor r=87.7202 c=0
Rl1 (\1\:D \2\:D) resistor r=133.743 c=0
Rl8 (\3\:Gb \5\:Gb) resistor r=249.542 c=0
Rl29 (\8\:Gb \9\:Gb) resistor r=447.998 c=0
Rl12 (\6\:Gb \7\:Gb) resistor r=435.371 c=0
Rl7 (\2\:Gb \4\:Gb) resistor r=64.1356 c=0
Rl6 (\2\:Gb \3\:Gb) resistor r=168.248 c=0
Rl5 (Gb \2\:Gb) resistor r=353.207 c=0
Rl28 (\4\:Gbb \5\:Gbb) resistor r=455.381 c=0
Rl11 (\2\:Gbb \3\:Gbb) resistor r=44.0258 c=0
Rl10 (Gbb \2\:Gbb) resistor r=706.37 c=0
Rl44 (\2\:Qbint \4\:Qbint) resistor r=93.3448 c=0
Rl42 (Qbint \2\:Qbint) resistor r=60.9354 c=0
Rl43 (\2\:Qbint \3\:Qbint) resistor r=83.7545 c=0
Rl9 (n0 \2\:n0) resistor r=331.394 c=0
Rl31 (\2\:Qint \3\:Qint) resistor r=322.396 c=0
Rl30 (Qint \2\:Qint) resistor r=215.233 c=0
Rl32 (\3\:Qint \4\:Qint) resistor r=60.9354 c=0
Rl37 (\4\:Qint \9\:Qint) resistor r=93.3448 c=0
Rl38 (\5\:Qint \10\:Qint) resistor r=59.4143 c=0
Rl39 (\5\:Qint \11\:Qint) resistor r=91.8237 c=0
Rl33 (\4\:Qint \5\:Qint) resistor r=59.826 c=0
Rl40 (\6\:Qint \12\:Qint) resistor r=101.868 c=0
Rl34 (\5\:Qint \6\:Qint) resistor r=412.667 c=0
Rl41 (\7\:Qint \13\:Qint) resistor r=67.7766 c=0
Rl36 (\7\:Qint \8\:Qint) resistor r=192.03 c=0
Rl35 (\6\:Qint \7\:Qint) resistor r=20.6699 c=0
Rl18 (\4\:n0g \5\:n0g) resistor r=317.727 c=0
Rl17 (\2\:n0g \4\:n0g) resistor r=191.281 c=0
Rl16 (\2\:n0g \3\:n0g) resistor r=38.4366 c=0
Rl15 (n0g \2\:n0g) resistor r=109.66 c=0
Rl25 (\3\:RTb \4\:RTb) resistor r=306.661 c=0
Rl26 (\4\:RTb \5\:RTb) resistor r=184.803 c=0
Rl13 (RTb \2\:RTb) resistor r=124.916 c=0
Rz10 (\3\:QN \4\:QN) resistor r=37.5 c=0
Rz16 (\6\:VSS \7\:VSS) resistor r=75 c=0
Rz17 (\8\:VSS \9\:VSS) resistor r=75 c=0
Rz18 (\10\:VSS \11\:VSS) resistor r=75 c=0
Rz19 (\20\:VSS \21\:VSS) resistor r=75 c=0
Rz20 (\22\:VSS \23\:VSS) resistor r=37.5 c=0
Rz21 (\24\:VSS \25\:VSS) resistor r=37.5 c=0
Rz22 (\26\:VSS \27\:VSS) resistor r=75 c=0
Rz23 (\28\:VSS \29\:VSS) resistor r=75 c=0
Rz13 (\1\:Q \2\:Q) resistor r=37.5 c=0
Rz2 (\13\:Gb \14\:Gb) resistor r=75 c=0
Rz1 (\10\:Gbb \11\:Gbb) resistor r=75 c=0
Rz12 (\9\:Qbint \10\:Qbint) resistor r=37.5 c=0
Rz3 (\7\:n0 \8\:n0) resistor r=75 c=0
Rz4 (\12\:n0 \13\:n0) resistor r=75 c=0
Rz5 (\14\:Qint \15\:Qint) resistor r=75 c=0
Rz6 (\9\:n0g \10\:n0g) resistor r=75 c=0
Rz9 (\15\:n0g \16\:n0g) resistor r=75 c=0
Rz8 (\12\:RTb \13\:RTb) resistor r=75 c=0
Rz11 (\3\:net095 \4\:net095) resistor r=75 c=0
Ry12 (\1\:QN \2\:QN) resistor r=20.6667 c=0
Ry16 (\1\:VDD \2\:VDD) resistor r=62 c=0
Ry17 (\9\:VDD \10\:VDD) resistor r=20.6667 c=0
Ry18 (\11\:VDD \12\:VDD) resistor r=20.6667 c=0
Ry19 (\13\:VDD \14\:VDD) resistor r=62 c=0
Ry20 (\16\:VDD \17\:VDD) resistor r=62 c=0
Ry21 (\1\:VSS \2\:VSS) resistor r=62 c=0
Ry22 (\1\:VSS \4\:VSS) resistor r=5.1667 c=0
Ry23 (\1\:VSS \5\:VSS) resistor r=5.1667 c=0
Ry24 (\12\:VSS \13\:VSS) resistor r=62 c=0
Ry25 (\12\:VSS \16\:VSS) resistor r=5.1667 c=0
Ry26 (\12\:VSS \19\:VSS) resistor r=5.1667 c=0
Ry7 (\3\:ExtVDD \4\:ExtVDD) resistor r=62 c=0
Ry8 (\6\:ExtVDD \7\:ExtVDD) resistor r=62 c=0
Ry9 (\10\:ExtVDD \11\:ExtVDD) resistor r=62 c=0
Ry15 (\3\:Q \4\:Q) resistor r=20.6667 c=0
Ry2 (\15\:Gb \16\:Gb) resistor r=62 c=0
Ry1 (\8\:Gbb \9\:Gbb) resistor r=62 c=0
Ry14 (\7\:Qbint \8\:Qbint) resistor r=20.6667 c=0
Ry3 (\5\:n0 \6\:n0) resistor r=62 c=0
Ry4 (\9\:n0 \10\:n0) resistor r=62 c=0
Ry5 (\17\:Qint \18\:Qint) resistor r=62 c=0
Ry6 (\7\:n0g \8\:n0g) resistor r=62 c=0
Ry11 (\11\:n0g \12\:n0g) resistor r=62 c=0
Ry10 (\7\:RTb \8\:RTb) resistor r=62 c=0
Ry13 (net095 \2\:net095) resistor r=62 c=0
Rx7 (\4\:RT \12\:RT) resistor r=45 c=0
Rx17 (\8\:RT \14\:RT) resistor r=45 c=0
Rx18 (\6\:RT \15\:RT) resistor r=45 c=0
Rx1 (\2\:G \7\:G) resistor r=45 c=0
Rx11 (\2\:ExtVDD \5\:ExtVDD) resistor r=45 c=0
Rx12 (\1\:ExtVDD \12\:ExtVDD) resistor r=45 c=0
Rx2 (\2\:D D) resistor r=45 c=0
Rx4 (Gb \10\:Gb) resistor r=45 c=0
Rx5 (\7\:Gb \17\:Gb) resistor r=45 c=0
Rx19 (\9\:Gb \18\:Gb) resistor r=45 c=0
Rx20 (\6\:Gb \19\:Gb) resistor r=45 c=0
Rx3 (\2\:Gbb \6\:Gbb) resistor r=45 c=0
Rx21 (\5\:Gbb \12\:Gbb) resistor r=45 c=0
Rx22 (Gbb \13\:Gbb) resistor r=45 c=0
Rx23 (\3\:Qbint \5\:Qbint) resistor r=45 c=0
Rx6 (n0 \3\:n0) resistor r=45 c=0
Rx8 (\2\:n0 \11\:n0) resistor r=45 c=0
Rx9 (\8\:Qint \16\:Qint) resistor r=45 c=0
Rx10 (\5\:n0g \6\:n0g) resistor r=45 c=0
Rx16 (n0g \14\:n0g) resistor r=45 c=0
Rx13 (\4\:RTb \6\:RTb) resistor r=45 c=0
Rx14 (\5\:RTb \9\:RTb) resistor r=45 c=0
Rx15 (RTb \11\:RTb) resistor r=45 c=0
mn5 (net257 \1\:D \20\:VSS VSS) g45n1svt w=(1.45e-07) l=4.5e-08 nf=1 \
        as=8.7e-15 ad=2.32e-14 ps=4.1e-07 pd=6.1e-07 nrd=1.16667 \
        nrs=1.16667 sa=3.45e-07 sb=2.45e-07 sd=160n sca=7.91544 \
        scb=0.00544522 scc=7.50774e-05 m=(1)
mn1 (\10\:Gbb \5\:Gb \20\:VSS VSS) g45n1svt w=(1.45e-07) l=4.5e-08 nf=1 \
        as=2.32e-14 ad=2.03e-14 ps=6.1e-07 pd=5.7e-07 nrd=1.16667 \
        nrs=1.16667 sa=1.4e-07 sb=4.5e-07 sd=160n sca=7.91544 \
        scb=0.00544522 scc=7.50774e-05 m=(1)
mn0 (\13\:Gb \3\:G \6\:VSS VSS) g45n1svt w=(1.45e-07) l=4.5e-08 nf=1 \
        as=2.03e-14 ad=2.03e-14 ps=5.7e-07 pd=5.7e-07 nrd=1.16667 \
        nrs=1.16667 sa=1.4e-07 sb=1.4e-07 sd=160n sca=9.33388 \
        scb=0.00788941 scc=0.00017958 m=(1)
mn6 (\7\:n0 \3\:Gbb net257 VSS) g45n1svt w=(1.45e-07) l=4.5e-08 nf=1 \
        as=8.7e-15 ad=2.03e-14 ps=4.1e-07 pd=5.7e-07 nrd=1.16667 \
        nrs=1.16667 sa=4.5e-07 sb=1.4e-07 sd=160n sca=7.91544 \
        scb=0.00544522 scc=7.50774e-05 m=(1)
NM0 (\9\:n0g \2\:RTb \12\:n0 VSS) g45n1svt w=(1.45e-07) l=4.5e-08 nf=1 \
        as=2.03e-14 ad=2.03e-14 ps=5.7e-07 pd=5.7e-07 nrd=1.16667 \
        nrs=1.16667 sa=1.4e-07 sb=1.4e-07 sd=160n sca=9.50767 \
        scb=0.00818119 scc=0.00019576 m=(1)
mn11 (\14\:Qint \3\:n0g \28\:VSS VSS) g45n1svt w=(1.45e-07) l=4.5e-08 \
        nf=1 as=2.03e-14 ad=2.03e-14 ps=5.7e-07 pd=5.7e-07 nrd=1.16667 \
        nrs=1.16667 sa=1.4e-07 sb=1.4e-07 sd=160n sca=12.9138 \
        scb=0.0133404 scc=0.000640143 m=(1)
mn45 (\12\:RTb \1\:RT \10\:VSS VSS) g45n1svt w=(1.45e-07) l=4.5e-08 nf=1 \
        as=2.03e-14 ad=2.03e-14 ps=5.7e-07 pd=5.7e-07 nrd=1.16667 \
        nrs=1.16667 sa=1.4e-07 sb=1.4e-07 sd=160n sca=9.16682 \
        scb=0.00760686 scc=0.000164708 m=(1)
NM2 (\15\:n0g \9\:RT net093 VSS) g45n1svt w=(1.45e-07) l=4.5e-08 nf=1 \
        as=8.7e-15 ad=2.03e-14 ps=4.1e-07 pd=5.7e-07 nrd=1.16667 \
        nrs=1.16667 sa=1.4e-07 sb=2.45e-07 sd=160n sca=18.4982 \
        scb=0.0194884 scc=0.00168796 m=(1)
NM3 (net093 \13\:Qint \26\:VSS VSS) g45n1svt w=(1.45e-07) l=4.5e-08 nf=1 \
        as=2.03e-14 ad=8.7e-15 ps=5.7e-07 pd=4.1e-07 nrd=1.16667 \
        nrs=1.16667 sa=2.45e-07 sb=1.4e-07 sd=160n sca=18.4982 \
        scb=0.0194884 scc=0.00168796 m=(1)
mn16 (\3\:net095 \8\:Gb net245 VSS) g45n1svt w=(1.45e-07) l=4.5e-08 nf=1 \
        as=8.7e-15 ad=2.03e-14 ps=4.1e-07 pd=5.7e-07 nrd=1.16667 \
        nrs=1.16667 sa=1.4e-07 sb=2.45e-07 sd=160n sca=11.4452 \
        scb=0.0112553 scc=0.00042156 m=(1)
mn15 (net245 Qint \8\:VSS VSS) g45n1svt w=(1.45e-07) l=4.5e-08 nf=1 \
        as=2.03e-14 ad=8.7e-15 ps=5.7e-07 pd=4.1e-07 nrd=1.16667 \
        nrs=1.16667 sa=2.45e-07 sb=1.4e-07 sd=160n sca=11.4452 \
        scb=0.0112553 scc=0.00042156 m=(1)
mn20 (\9\:Qbint \9\:Qint \24\:VSS VSS) g45n1svt w=(2.6e-07) l=4.5e-08 \
        nf=1 as=3.64e-14 ad=4.16e-14 ps=8e-07 pd=8.4e-07 nrd=1.16667 \
        nrs=1.16667 sa=3.45e-07 sb=1.4e-07 sd=160n sca=8.81533 \
        scb=0.00706435 scc=0.000179997 m=(1)
mn22 (\3\:QN \11\:Qint \24\:VSS VSS) g45n1svt w=(2.6e-07) l=4.5e-08 nf=1 \
        as=3.64e-14 ad=4.16e-14 ps=8e-07 pd=8.4e-07 nrd=1.16667 \
        nrs=1.16667 sa=1.4e-07 sb=3.45e-07 sd=160n sca=8.81533 \
        scb=0.00706435 scc=0.000179997 m=(1)
mn21 (\1\:Q Qbint \22\:VSS VSS) g45n1svt w=(2.6e-07) l=4.5e-08 nf=1 \
        as=3.64e-14 ad=3.64e-14 ps=8e-07 pd=8e-07 nrd=1.16667 nrs=1.16667 \
        sa=1.4e-07 sb=1.4e-07 sd=160n sca=8.81533 scb=0.00706435 \
        scc=0.000179997 m=(1)
mp20 (\7\:Qbint \3\:Qint \11\:VDD VDD) g45p1svt w=(3.9e-07) l=4.5e-08 \
        nf=1 as=5.46e-14 ad=6.24e-14 ps=1.06e-06 pd=1.1e-06 nrd=1.16667 \
        nrs=1.16667 sa=3.45e-07 sb=1.4e-07 sd=160n sca=19.8289 \
        scb=0.0178306 scc=0.00149679 m=(1)
mp22 (\1\:QN \10\:Qint \11\:VDD VDD) g45p1svt w=(3.9e-07) l=4.5e-08 nf=1 \
        as=5.46e-14 ad=6.24e-14 ps=1.06e-06 pd=1.1e-06 nrd=1.16667 \
        nrs=1.16667 sa=1.4e-07 sb=3.45e-07 sd=160n sca=25.6406 \
        scb=0.0282369 scc=0.00209661 m=(1)
mp21 (\3\:Q \4\:Qbint \9\:VDD VDD) g45p1svt w=(3.9e-07) l=4.5e-08 nf=1 \
        as=5.46e-14 ad=5.46e-14 ps=1.06e-06 pd=1.06e-06 nrd=1.16667 \
        nrs=1.16667 sa=1.4e-07 sb=1.4e-07 sd=160n sca=29.8529 \
        scb=0.0334882 scc=0.00288579 m=(1)
ends RTLATX1
// End of subcircuit definition.
