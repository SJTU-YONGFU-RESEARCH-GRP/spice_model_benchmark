// Generated for: spectre (May  1 08:12:04 2013 )
// Library name: gsclib045
// Cell name: PBUFX2
// View name: extracted

simulator lang=spectre

subckt PBUFX2 A ExtVDD VSS Y
mp0 (\10\:n0 \4\:A \6\:ExtVDD ExtVDD) g45p1svt w=(2.15e-07) l=4.5e-08 \
        nf=1 as=3.01e-14 ad=3.01e-14 ps=7.1e-07 pd=7.1e-07 nrd=1.16667 \
        nrs=1.16667 sa=1.4e-07 sb=1.4e-07 sd=160n sca=85.3128 \
        scb=0.0561754 scc=0.010057 m=(1)
C1 (VDD VSS) capacitor c=9.46041e-17
C2 (ExtVDD VSS) capacitor c=1.36774e-16
C3 (A VSS) capacitor c=2.55712e-17
C4 (Y VSS) capacitor c=3.83837e-17
C5 (n0 VSS) capacitor c=1.38276e-16
C6 (\4\:A VSS) capacitor c=3.44573e-17
C7 (\1\:A VSS) capacitor c=3.5036e-17
C8 (\4\:n0 VSS) capacitor c=1.02538e-17
C9 (\3\:A VSS) capacitor c=2.2335e-17
C10 (\1\:ExtVDD VSS) capacitor c=2.19193e-16
C11 (\2\:Y VSS) capacitor c=9.1676e-17
C12 (\6\:ExtVDD VSS) capacitor c=7.15525e-17
C13 (\10\:n0 VSS) capacitor c=5.38943e-17
C14 (\4\:Y VSS) capacitor c=5.46262e-17
C15 (\12\:n0 VSS) capacitor c=2.84535e-17
C16 (VDD VSS) capacitor c=2.06719e-16
C17 (\2\:A VSS) capacitor c=3.66276e-17
C18 (\7\:A VSS) capacitor c=3.38373e-17
C19 (\8\:n0 VSS) capacitor c=7.76001e-17
C20 (\9\:n0 VSS) capacitor c=1.14764e-16
C21 (\1\:Y VSS) capacitor c=2.98091e-17
Rk26 (VDD VDD) resistor r=0.371 c=0
Rk19 (\3\:VSS VSS) resistor r=0.09656 c=0
Rk17 (\2\:VSS \3\:VSS) resistor r=0.2859 c=0
Rk20 (VSS \5\:VSS) resistor r=0.09723 c=0
Rk22 (\6\:VSS VSS) resistor r=0.3245 c=0
Rk21 (\5\:VSS \6\:VSS) resistor r=0.1041 c=0
Rk25 (\6\:VSS \12\:VSS) resistor r=0.225 c=0
Rk27 (\14\:VSS VSS) resistor r=0.5817 c=0
Rk29 (\15\:VSS VSS) resistor r=0.4289 c=0
Rk28 (VSS \15\:VSS) resistor r=0.09723 c=0
Rk12 (\1\:ExtVDD ExtVDD) resistor r=0.5167 c=0
Rk13 (ExtVDD \5\:ExtVDD) resistor r=0.00107 c=0
Rk14 (\5\:ExtVDD ExtVDD) resistor r=0.008659 c=0
Rk15 (ExtVDD \7\:ExtVDD) resistor r=0.2114 c=0
Rk4 (A \7\:A) resistor r=0.009911 c=0
Rk3 (\6\:A \7\:A) resistor r=0.003288 c=0
Rk8 (Y \1\:Y) resistor r=0.02868 c=0
Rk9 (\1\:Y \3\:Y) resistor r=0.357 c=0
Rk10 (\1\:Y \5\:Y) resistor r=0.2057 c=0
Rk5 (\8\:n0 \9\:n0) resistor r=0.5643 c=0
Rk6 (\9\:n0 \11\:n0) resistor r=0.4369 c=0
Rk7 (\9\:n0 \13\:n0) resistor r=0.1974 c=0
Rl3 (\2\:A \4\:A) resistor r=103.572 c=0
Rl1 (\1\:A \2\:A) resistor r=147.89 c=0
Rl2 (\2\:A \3\:A) resistor r=83.7545 c=0
Rl6 (\4\:n0 n0) resistor r=5.8986 c=0
Rz6 (\12\:VSS \11\:VSS) resistor r=75 c=0
Rz2 (\5\:Y \4\:Y) resistor r=37.5 c=0
Rz1 (\13\:n0 \12\:n0) resistor r=75 c=0
Ry6 (\2\:VSS \1\:VSS) resistor r=31 c=0
Ry7 (\5\:VSS \1\:VSS) resistor r=5.1667 c=0
Ry8 (\14\:VSS \13\:VSS) resistor r=31 c=0
Ry9 (\15\:VSS \13\:VSS) resistor r=5.1667 c=0
Ry4 (\7\:ExtVDD \6\:ExtVDD) resistor r=62 c=0
Ry2 (\3\:Y \2\:Y) resistor r=20.6667 c=0
Ry1 (\11\:n0 \10\:n0) resistor r=62 c=0
Rx1 (\3\:A \6\:A) resistor r=45 c=0
Rx2 (\8\:n0 \4\:n0) resistor r=45 c=0
mn0 (\12\:n0 \1\:A \11\:VSS VSS) g45n1svt w=(1.45e-07) l=4.5e-08 nf=1 \
        as=2.03e-14 ad=2.03e-14 ps=5.7e-07 pd=5.7e-07 nrd=1.16667 \
        nrs=1.16667 sa=1.4e-07 sb=1.4e-07 sd=160n sca=11.7118 \
        scb=0.0116498 scc=0.000458536 m=(1)
mn1 (\4\:Y n0 \3\:VSS VSS) g45n1svt w=(2.6e-07) l=4.5e-08 nf=1 \
        as=3.64e-14 ad=4.16e-14 ps=8e-07 pd=8.4e-07 nrd=1.16667 \
        nrs=1.16667 sa=3.45e-07 sb=1.4e-07 sd=160n sca=13.5771 \
        scb=0.0135427 scc=0.000870653 m=(2)
mp1 (\2\:Y n0 \1\:ExtVDD ExtVDD) g45p1svt w=(3.9e-07) l=4.5e-08 nf=1 \
        as=6.24e-14 ad=5.46e-14 ps=1.1e-06 pd=1.06e-06 nrd=1.16667 \
        nrs=1.16667 sa=1.4e-07 sb=3.45e-07 sd=160n sca=39.1196 \
        scb=0.0322259 scc=0.0036825 m=(2)
ends PBUFX2
// End of subcircuit definition.
