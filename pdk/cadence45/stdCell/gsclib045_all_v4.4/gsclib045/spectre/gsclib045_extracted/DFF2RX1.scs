// Generated for: spectre (May  1 08:12:56 2013 )
// Library name: gsclib045
// Cell name: DFF2RX1
// View name: extracted

simulator lang=spectre

subckt DFF2RX1 CK D1 D2 Q1 Q1N Q2 Q2N RN VDD VSS
PM17 (\1\:Q2 \11\:qbint_2 \6\:VDD VDD) g45p1svt w=(3.9e-07) l=4.5e-08 \
        nf=1 as=1.13e-13 ad=5e-14 ps=2.1e-06 pd=1.06e-06 nrd=1.16667 \
        nrs=1.16667 sa=1.28205e-07 sb=1.05064e-06 sd=160n sca=30.8288 \
        scb=0.0202939 scc=0.00336099 m=(1)
PM19 (\3\:Q2N qint_2 \1\:VDD VDD) g45p1svt w=(3.9e-07) l=4.5e-08 nf=1 \
        as=7.55e-14 ad=4.92e-14 ps=1.9e-06 pd=1.06e-06 nrd=1.16667 \
        nrs=1.16667 sa=1.26154e-07 sb=2.19808e-07 sd=160n sca=44.1638 \
        scb=0.0392167 scc=0.00476734 m=(1)
mp55 (\1\:Q1 qbint \39\:VDD VDD) g45p1svt w=(3.9e-07) l=4.5e-08 nf=1 \
        as=1.13e-13 ad=5e-14 ps=2.1e-06 pd=1.06e-06 nrd=1.16667 \
        nrs=1.16667 sa=1.28205e-07 sb=1.05064e-06 sd=160n sca=30.8288 \
        scb=0.0202939 scc=0.00336099 m=(1)
mp57 (\3\:Q1N qint \41\:VDD VDD) g45p1svt w=(3.9e-07) l=4.5e-08 nf=1 \
        as=7.55e-14 ad=4.92e-14 ps=1.9e-06 pd=1.06e-06 nrd=1.16667 \
        nrs=1.16667 sa=1.26154e-07 sb=2.19808e-07 sd=160n sca=44.1638 \
        scb=0.0392167 scc=0.00476734 m=(1)
C1 (Q1N VSS) capacitor c=1.80425e-17
C2 (D1 VSS) capacitor c=3.06322e-17
C3 (Q2N VSS) capacitor c=1.79246e-17
C4 (VDD VSS) capacitor c=6.60218e-16
C5 (RN VSS) capacitor c=4.44702e-16
C6 (Q2 VSS) capacitor c=5.04614e-17
C7 (Q1 VSS) capacitor c=5.21276e-17
C8 (CK VSS) capacitor c=4.6396e-17
C9 (CKb VSS) capacitor c=1.0248e-16
C10 (Ckbb VSS) capacitor c=5.82948e-17
C11 (qint VSS) capacitor c=4.72136e-17
C12 (Db VSS) capacitor c=8.08668e-17
C13 (n20 VSS) capacitor c=4.70726e-17
C14 (n6 VSS) capacitor c=5.25394e-17
C15 (n30 VSS) capacitor c=4.07309e-17
C16 (qbint VSS) capacitor c=3.66511e-17
C17 (mout VSS) capacitor c=5.20517e-17
C18 (n8 VSS) capacitor c=8.35591e-19
C19 (n11 VSS) capacitor c=8.47661e-19
C20 (qint_2 VSS) capacitor c=4.72351e-17
C21 (Db_2 VSS) capacitor c=7.86582e-17
C22 (n20_2 VSS) capacitor c=4.82738e-17
C23 (n6_2 VSS) capacitor c=5.19243e-17
C24 (n30_2 VSS) capacitor c=4.80775e-17
C25 (qbint_2 VSS) capacitor c=2.83164e-17
C26 (mout_2 VSS) capacitor c=5.24431e-17
C27 (n8_2 VSS) capacitor c=8.2822e-19
C28 (n11_2 VSS) capacitor c=8.47661e-19
C29 (\5\:qbint_2 VSS) capacitor c=3.35588e-17
C30 (\11\:qbint_2 VSS) capacitor c=3.67092e-17
C31 (\10\:RN VSS) capacitor c=7.28914e-17
C32 (\4\:qbint_2 VSS) capacitor c=5.55854e-17
C33 (\15\:Ckbb VSS) capacitor c=5.61152e-17
C34 (\15\:CKb VSS) capacitor c=7.41081e-17
C35 (\8\:RN VSS) capacitor c=7.04199e-17
C36 (\11\:CKb VSS) capacitor c=4.32926e-17
C37 (\9\:Ckbb VSS) capacitor c=3.86994e-17
C38 (\1\:D2 VSS) capacitor c=3.98024e-17
C39 (\1\:CK VSS) capacitor c=4.17887e-17
C40 (\10\:CKb VSS) capacitor c=3.3164e-17
C41 (\1\:D1 VSS) capacitor c=3.87788e-17
C42 (\7\:Ckbb VSS) capacitor c=3.81148e-17
C43 (\4\:CKb VSS) capacitor c=4.35091e-17
C44 (\5\:RN VSS) capacitor c=7.05029e-17
C45 (\2\:CKb VSS) capacitor c=7.41868e-17
C46 (\2\:Ckbb VSS) capacitor c=5.65852e-17
C47 (\8\:qbint VSS) capacitor c=5.63897e-17
C48 (\1\:RN VSS) capacitor c=7.33724e-17
C49 (\3\:n30 VSS) capacitor c=4.66916e-17
C50 (\7\:qbint VSS) capacitor c=3.35283e-17
C51 (\3\:qint_2 VSS) capacitor c=4.16412e-17
C52 (\9\:qbint_2 VSS) capacitor c=3.06045e-17
C53 (\10\:qbint_2 VSS) capacitor c=2.97079e-17
C54 (\3\:n30_2 VSS) capacitor c=4.09095e-17
C55 (\11\:RN VSS) capacitor c=8.59365e-17
C56 (\3\:qbint_2 VSS) capacitor c=7.09277e-17
C57 (\14\:CKb VSS) capacitor c=1.02493e-16
C58 (\13\:Ckbb VSS) capacitor c=3.28474e-17
C59 (\3\:n20_2 VSS) capacitor c=4.9525e-17
C60 (\9\:RN VSS) capacitor c=8.32476e-17
C61 (\3\:mout_2 VSS) capacitor c=5.15496e-17
C62 (\11\:Ckbb VSS) capacitor c=3.74541e-17
C63 (\12\:CKb VSS) capacitor c=4.36597e-17
C64 (\3\:D2 VSS) capacitor c=2.39062e-17
C65 (\3\:CK VSS) capacitor c=4.2874e-17
C66 (\9\:CKb VSS) capacitor c=3.16246e-17
C67 (\3\:D1 VSS) capacitor c=2.15307e-17
C68 (\6\:CKb VSS) capacitor c=4.41211e-17
C69 (\5\:Ckbb VSS) capacitor c=3.74533e-17
C70 (\3\:mout VSS) capacitor c=5.15827e-17
C71 (\4\:RN VSS) capacitor c=8.31365e-17
C72 (\3\:n20 VSS) capacitor c=4.80166e-17
C73 (\3\:Ckbb VSS) capacitor c=3.26485e-17
C74 (\11\:qbint VSS) capacitor c=7.09286e-17
C75 (\3\:RN VSS) capacitor c=8.59319e-17
C76 (\5\:qbint VSS) capacitor c=2.96796e-17
C77 (\4\:qbint VSS) capacitor c=3.06347e-17
C78 (\3\:qint VSS) capacitor c=4.16412e-17
C79 (\2\:qint_2 VSS) capacitor c=3.02167e-17
C80 (\8\:qbint_2 VSS) capacitor c=2.30562e-17
C81 (\2\:n30_2 VSS) capacitor c=4.61175e-17
C82 (\12\:RN VSS) capacitor c=2.96573e-17
C83 (\16\:Ckbb VSS) capacitor c=5.94527e-17
C84 (\16\:CKb VSS) capacitor c=3.42526e-17
C85 (\14\:Ckbb VSS) capacitor c=2.47584e-17
C86 (\2\:n20_2 VSS) capacitor c=4.65923e-17
C87 (\7\:RN VSS) capacitor c=2.82586e-17
C88 (\2\:mout_2 VSS) capacitor c=4.56189e-17
C89 (\12\:Ckbb VSS) capacitor c=3.56466e-17
C90 (\13\:CKb VSS) capacitor c=2.90846e-17
C91 (\10\:Ckbb VSS) capacitor c=2.79425e-17
C92 (\2\:D2 VSS) capacitor c=2.94814e-17
C93 (\2\:CK VSS) capacitor c=3.38334e-17
C94 (\7\:CKb VSS) capacitor c=2.05344e-17
C95 (\2\:D1 VSS) capacitor c=2.97233e-17
C96 (\8\:Ckbb VSS) capacitor c=2.82544e-17
C97 (\5\:CKb VSS) capacitor c=2.90286e-17
C98 (\6\:Ckbb VSS) capacitor c=3.56504e-17
C99 (\2\:mout VSS) capacitor c=4.59934e-17
C100 (\6\:RN VSS) capacitor c=2.82712e-17
C101 (\2\:n20 VSS) capacitor c=4.77105e-17
C102 (\3\:CKb VSS) capacitor c=3.41835e-17
C103 (\4\:Ckbb VSS) capacitor c=2.47585e-17
C104 (\10\:qbint VSS) capacitor c=2.62194e-17
C105 (\2\:RN VSS) capacitor c=2.96276e-17
C106 (\2\:n30 VSS) capacitor c=4.61526e-17
C107 (\6\:qbint VSS) capacitor c=2.37256e-17
C108 (\2\:qint VSS) capacitor c=3.03243e-17
C109 (\3\:Q2N VSS) capacitor c=3.52483e-17
C110 (\1\:VDD VSS) capacitor c=8.02793e-18
C111 (\4\:qint_2 VSS) capacitor c=2.07779e-17
C112 (\1\:Q2 VSS) capacitor c=4.2384e-17
C113 (\6\:VDD VSS) capacitor c=9.63384e-18
C114 (\14\:qbint_2 VSS) capacitor c=6.57093e-17
C115 (\9\:VDD VSS) capacitor c=3.6274e-17
C116 (\4\:n30_2 VSS) capacitor c=8.0256e-17
C117 (\4\:mout_2 VSS) capacitor c=4.61926e-17
C118 (\13\:VDD VSS) capacitor c=3.13992e-17
C119 (\16\:VDD VSS) capacitor c=3.48782e-17
C120 (\3\:n6_2 VSS) capacitor c=5.26857e-17
C121 (\6\:n20_2 VSS) capacitor c=7.20471e-17
C122 (\19\:VDD VSS) capacitor c=3.26128e-17
C123 (\26\:CKb VSS) capacitor c=3.59556e-17
C124 (\22\:VDD VSS) capacitor c=3.70123e-17
C125 (\30\:Ckbb VSS) capacitor c=1.09843e-16
C126 (\26\:VDD VSS) capacitor c=3.20339e-17
C127 (\4\:n20 VSS) capacitor c=5.05599e-17
C128 (\29\:VDD VSS) capacitor c=3.48055e-17
C129 (\3\:n6 VSS) capacitor c=5.2135e-17
C130 (\32\:VDD VSS) capacitor c=3.13151e-17
C131 (\8\:mout VSS) capacitor c=4.53215e-17
C132 (\4\:n30 VSS) capacitor c=8.08108e-17
C133 (\35\:VDD VSS) capacitor c=3.63265e-17
C134 (\13\:qbint VSS) capacitor c=6.55923e-17
C135 (\39\:VDD VSS) capacitor c=9.83542e-18
C136 (\1\:Q1 VSS) capacitor c=4.23591e-17
C137 (\4\:qint VSS) capacitor c=2.0885e-17
C138 (\41\:VDD VSS) capacitor c=2.05378e-17
C139 (\3\:Q1N VSS) capacitor c=3.52298e-17
C140 (\3\:VDD VSS) capacitor c=5.76158e-17
C141 (\1\:Q2N VSS) capacitor c=1.93025e-17
C142 (\7\:qint_2 VSS) capacitor c=3.05524e-17
C143 (\3\:Q2 VSS) capacitor c=4.1579e-17
C144 (\17\:qbint_2 VSS) capacitor c=4.61774e-17
C145 (\7\:n30_2 VSS) capacitor c=7.16893e-17
C146 (\8\:mout_2 VSS) capacitor c=5.05896e-17
C147 (\8\:n20_2 VSS) capacitor c=3.37144e-17
C148 (\3\:Db_2 VSS) capacitor c=1.00496e-16
C149 (\24\:CKb VSS) capacitor c=5.22803e-17
C150 (\28\:Ckbb VSS) capacitor c=4.56889e-17
C151 (\3\:Db VSS) capacitor c=1.00099e-16
C152 (\8\:n20 VSS) capacitor c=3.37259e-17
C153 (\6\:mout VSS) capacitor c=5.05883e-17
C154 (\8\:n30 VSS) capacitor c=7.17991e-17
C155 (\17\:qbint VSS) capacitor c=4.6156e-17
C156 (\3\:Q1 VSS) capacitor c=4.15749e-17
C157 (\8\:qint VSS) capacitor c=3.0551e-17
C158 (\1\:Q1N VSS) capacitor c=1.93025e-17
C159 (\3\:qbint VSS) capacitor c=3.10009e-17
C160 (\9\:qbint VSS) capacitor c=3.81038e-17
C161 (\8\:CKb VSS) capacitor c=1.51165e-17
C162 (\6\:qint VSS) capacitor c=2.75556e-17
C163 (\7\:qint VSS) capacitor c=3.13695e-17
C164 (\12\:qbint VSS) capacitor c=5.51012e-17
C165 (\15\:qbint VSS) capacitor c=4.19828e-17
C166 (\16\:qbint VSS) capacitor c=2.57402e-17
C167 (\2\:qbint_2 VSS) capacitor c=3.91473e-17
C168 (\6\:n30 VSS) capacitor c=9.16795e-17
C169 (\7\:n30 VSS) capacitor c=5.44726e-17
C170 (\4\:mout VSS) capacitor c=6.46485e-17
C171 (\5\:mout VSS) capacitor c=8.81818e-17
C172 (\6\:qbint_2 VSS) capacitor c=3.09904e-17
C173 (\6\:n20 VSS) capacitor c=1.07092e-16
C174 (\7\:n20 VSS) capacitor c=9.51662e-17
C175 (\6\:D1 VSS) capacitor c=6.65247e-17
C176 (\5\:CK VSS) capacitor c=5.1311e-17
C177 (\4\:D2 VSS) capacitor c=3.06374e-17
C178 (\5\:D2 VSS) capacitor c=5.81282e-17
C179 (\4\:n20_2 VSS) capacitor c=9.51806e-17
C180 (\5\:n20_2 VSS) capacitor c=7.92306e-17
C181 (\6\:mout_2 VSS) capacitor c=8.83425e-17
C182 (\7\:mout_2 VSS) capacitor c=6.47626e-17
C183 (\17\:CKb VSS) capacitor c=2.60992e-16
C184 (\18\:CKb VSS) capacitor c=2.68462e-16
C185 (\19\:CKb VSS) capacitor c=1.98434e-16
C186 (\20\:CKb VSS) capacitor c=2.27067e-16
C187 (\21\:CKb VSS) capacitor c=2.60039e-16
C188 (\22\:CKb VSS) capacitor c=4.58611e-17
C189 (\23\:CKb VSS) capacitor c=1.01014e-16
C190 (\13\:RN VSS) capacitor c=1.60059e-16
C191 (\14\:RN VSS) capacitor c=4.29541e-16
C192 (\15\:RN VSS) capacitor c=2.27935e-16
C193 (\16\:RN VSS) capacitor c=1.60466e-16
C194 (\17\:Ckbb VSS) capacitor c=1.03165e-16
C195 (\18\:Ckbb VSS) capacitor c=2.65829e-16
C196 (\20\:Ckbb VSS) capacitor c=1.40014e-16
C197 (\21\:Ckbb VSS) capacitor c=1.35331e-16
C198 (\22\:Ckbb VSS) capacitor c=1.00317e-16
C199 (\24\:Ckbb VSS) capacitor c=2.65938e-16
C200 (\25\:Ckbb VSS) capacitor c=1.03213e-16
C201 (\26\:Ckbb VSS) capacitor c=9.74076e-17
C202 (\27\:Ckbb VSS) capacitor c=8.517e-17
C203 (\32\:Ckbb VSS) capacitor c=8.91565e-17
C204 (\33\:Ckbb VSS) capacitor c=9.73268e-17
C205 (\6\:n30_2 VSS) capacitor c=9.38664e-17
C206 (\9\:n30_2 VSS) capacitor c=5.47231e-17
C207 (\12\:qbint_2 VSS) capacitor c=2.57457e-17
C208 (\13\:qbint_2 VSS) capacitor c=4.20989e-17
C209 (\16\:qbint_2 VSS) capacitor c=5.68424e-17
C210 (\6\:qint_2 VSS) capacitor c=2.74969e-17
C211 (\9\:qint_2 VSS) capacitor c=3.04312e-17
C212 (\5\:VDD VSS) capacitor c=1.31561e-17
C213 (\8\:VDD VSS) capacitor c=2.9134e-17
C214 (\12\:VDD VSS) capacitor c=1.04052e-17
C215 (\15\:VDD VSS) capacitor c=3.5331e-17
C216 (\18\:VDD VSS) capacitor c=3.72205e-17
C217 (\21\:VDD VSS) capacitor c=1.5364e-17
C218 (\25\:VDD VSS) capacitor c=2.64805e-17
C219 (\28\:VDD VSS) capacitor c=3.49466e-17
C220 (\31\:VDD VSS) capacitor c=2.83959e-17
C221 (\34\:VDD VSS) capacitor c=2.26122e-17
C222 (\38\:VDD VSS) capacitor c=9.40141e-18
Rk1 (Q1N \2\:Q1N) resistor r=0.0736 c=0
Rk2 (Q1N \4\:Q1N) resistor r=0.2052 c=0
Rk23 (\4\:D1 D1) resistor r=0.005257 c=0
Rk25 (\4\:D1 \6\:D1) resistor r=0.02315 c=0
Rk24 (\5\:D1 \6\:D1) resistor r=0.005142 c=0
Rk77 (Q2N \2\:Q2N) resistor r=0.0736 c=0
Rk78 (Q2N \4\:Q2N) resistor r=0.2052 c=0
Rk79 (\2\:VDD \4\:VDD) resistor r=0.08431 c=0
Rk80 (\4\:VDD \5\:VDD) resistor r=0.2574 c=0
Rk81 (\5\:VDD \7\:VDD) resistor r=0.04336 c=0
Rk82 (\5\:VDD \8\:VDD) resistor r=0.2813 c=0
Rk83 (\8\:VDD \10\:VDD) resistor r=0.04336 c=0
Rk84 (\8\:VDD \11\:VDD) resistor r=0.2599 c=0
Rk85 (\11\:VDD \12\:VDD) resistor r=0.09172 c=0
Rk86 (\12\:VDD \14\:VDD) resistor r=0.04336 c=0
Rk87 (\12\:VDD \15\:VDD) resistor r=0.1972 c=0
Rk88 (\15\:VDD \17\:VDD) resistor r=0.04151 c=0
Rk89 (\15\:VDD \18\:VDD) resistor r=0.4557 c=0
Rk90 (\18\:VDD \20\:VDD) resistor r=0.04336 c=0
Rk93 (\21\:VDD VDD) resistor r=0.1442 c=0
Rk91 (\18\:VDD \21\:VDD) resistor r=0.2562 c=0
Rk92 (\21\:VDD \23\:VDD) resistor r=0.04336 c=0
Rk94 (VDD \24\:VDD) resistor r=0.05045 c=0
Rk95 (\24\:VDD \25\:VDD) resistor r=0.05156 c=0
Rk96 (\25\:VDD \27\:VDD) resistor r=0.04336 c=0
Rk97 (\25\:VDD \28\:VDD) resistor r=0.4557 c=0
Rk98 (\28\:VDD \30\:VDD) resistor r=0.04151 c=0
Rk99 (\28\:VDD \31\:VDD) resistor r=0.1972 c=0
Rk100 (\31\:VDD \33\:VDD) resistor r=0.04336 c=0
Rk101 (\31\:VDD \34\:VDD) resistor r=0.3516 c=0
Rk102 (\34\:VDD \36\:VDD) resistor r=0.04336 c=0
Rk103 (\34\:VDD \37\:VDD) resistor r=0.1394 c=0
Rk104 (\37\:VDD \38\:VDD) resistor r=0.1419 c=0
Rk105 (\38\:VDD \40\:VDD) resistor r=0.04336 c=0
Rk106 (\38\:VDD \42\:VDD) resistor r=0.3491 c=0
Rk48 (\14\:RN RN) resistor r=2.2469 c=0
Rk47 (\13\:RN \14\:RN) resistor r=0.9881 c=0
Rk49 (RN \15\:RN) resistor r=0.7016 c=0
Rk50 (\15\:RN \16\:RN) resistor r=0.9881 c=0
Rk28 (D2 \4\:D2) resistor r=0.005028 c=0
Rk30 (\4\:D2 \5\:D2) resistor r=0.02315 c=0
Rk29 (\5\:D2 \6\:D2) resistor r=0.005142 c=0
Rk72 (\2\:Q2 Q2) resistor r=0.265 c=0
Rk73 (Q2 \4\:Q2) resistor r=0.06922 c=0
Rk107 (\2\:VSS \4\:VSS) resistor r=0.08619 c=0
Rk108 (\4\:VSS \5\:VSS) resistor r=0.2423 c=0
Rk109 (\5\:VSS \6\:VSS) resistor r=0.2622 c=0
Rk110 (\6\:VSS \7\:VSS) resistor r=0.2935 c=0
Rk111 (\7\:VSS \8\:VSS) resistor r=0.1294 c=0
Rk112 (\8\:VSS \9\:VSS) resistor r=0.6163 c=0
Rk114 (\10\:VSS VSS) resistor r=0.1428 c=0
Rk113 (\9\:VSS \10\:VSS) resistor r=0.2586 c=0
Rk115 (VSS \11\:VSS) resistor r=0.05045 c=0
Rk116 (\11\:VSS \12\:VSS) resistor r=0.05273 c=0
Rk117 (\12\:VSS \13\:VSS) resistor r=0.6163 c=0
Rk118 (\13\:VSS \14\:VSS) resistor r=0.4229 c=0
Rk119 (\14\:VSS \15\:VSS) resistor r=0.1052 c=0
Rk120 (\15\:VSS \16\:VSS) resistor r=0.157 c=0
Rk121 (\16\:VSS \18\:VSS) resistor r=0.3229 c=0
Rk122 (\5\:VSS \20\:VSS) resistor r=0.04336 c=0
Rk123 (\6\:VSS \22\:VSS) resistor r=0.03692 c=0
Rk124 (\8\:VSS \24\:VSS) resistor r=0.04336 c=0
Rk125 (\9\:VSS \26\:VSS) resistor r=0.04151 c=0
Rk126 (\10\:VSS \28\:VSS) resistor r=0.04151 c=0
Rk127 (\12\:VSS \30\:VSS) resistor r=0.04151 c=0
Rk128 (\13\:VSS \32\:VSS) resistor r=0.04336 c=0
Rk129 (\14\:VSS \34\:VSS) resistor r=0.03692 c=0
Rk130 (\16\:VSS \36\:VSS) resistor r=0.04336 c=0
Rk6 (\2\:Q1 Q1) resistor r=0.2758 c=0
Rk7 (Q1 \4\:Q1) resistor r=0.06922 c=0
Rk27 (CK \5\:CK) resistor r=0.0118 c=0
Rk26 (\4\:CK \5\:CK) resistor r=0.004235 c=0
Rk39 (\17\:CKb \18\:CKb) resistor r=0.8581 c=0
Rk40 (\18\:CKb \19\:CKb) resistor r=0.9309 c=0
Rk41 (\19\:CKb \20\:CKb) resistor r=0.8169 c=0
Rk42 (\20\:CKb \21\:CKb) resistor r=0.8581 c=0
Rk43 (\19\:CKb \22\:CKb) resistor r=0.1965 c=0
Rk44 (\22\:CKb \23\:CKb) resistor r=0.2098 c=0
Rk45 (\23\:CKb \25\:CKb) resistor r=0.2714 c=0
Rk46 (\22\:CKb \27\:CKb) resistor r=0.174 c=0
Rk51 (\17\:Ckbb \18\:Ckbb) resistor r=0.6003 c=0
Rk52 (\18\:Ckbb \19\:Ckbb) resistor r=0.5553 c=0
Rk53 (\19\:Ckbb \20\:Ckbb) resistor r=0.3808 c=0
Rk54 (\20\:Ckbb \21\:Ckbb) resistor r=0.7782 c=0
Rk55 (\21\:Ckbb \22\:Ckbb) resistor r=0.4456 c=0
Rk56 (\22\:Ckbb \23\:Ckbb) resistor r=0.3808 c=0
Rk57 (\23\:Ckbb \24\:Ckbb) resistor r=0.5553 c=0
Rk58 (\24\:Ckbb \25\:Ckbb) resistor r=0.5988 c=0
Rk59 (\19\:Ckbb \26\:Ckbb) resistor r=0.02486 c=0
Rk60 (\20\:Ckbb \27\:Ckbb) resistor r=0.3737 c=0
Rk61 (\21\:Ckbb \29\:Ckbb) resistor r=0.1993 c=0
Rk62 (\29\:Ckbb \31\:Ckbb) resistor r=0.3042 c=0
Rk63 (\22\:Ckbb \32\:Ckbb) resistor r=0.3737 c=0
Rk64 (\23\:Ckbb \33\:Ckbb) resistor r=0.02486 c=0
Rk3 (\5\:qint \6\:qint) resistor r=0.1283 c=0
Rk4 (\6\:qint \7\:qint) resistor r=0.1476 c=0
Rk5 (\6\:qint \9\:qint) resistor r=0.1582 c=0
Rk22 (\2\:Db \4\:Db) resistor r=0.4744 c=0
Rk19 (\5\:n20 \6\:n20) resistor r=0.3259 c=0
Rk20 (\6\:n20 \7\:n20) resistor r=0.5091 c=0
Rk21 (\6\:n20 \9\:n20) resistor r=0.202 c=0
Rk18 (\2\:n6 \4\:n6) resistor r=0.3059 c=0
Rk12 (\5\:n30 \6\:n30) resistor r=0.4318 c=0
Rk13 (\6\:n30 \7\:n30) resistor r=0.28 c=0
Rk14 (\6\:n30 \9\:n30) resistor r=0.2544 c=0
Rk8 (\12\:qbint \14\:qbint) resistor r=0.3557 c=0
Rk9 (\14\:qbint \15\:qbint) resistor r=0.3517 c=0
Rk10 (\15\:qbint \16\:qbint) resistor r=0.0888 c=0
Rk11 (\15\:qbint \18\:qbint) resistor r=0.3219 c=0
Rk15 (\4\:mout \5\:mout) resistor r=0.3842 c=0
Rk16 (\5\:mout \7\:mout) resistor r=0.2078 c=0
Rk17 (\5\:mout \9\:mout) resistor r=0.2521 c=0
Rk74 (\5\:qint_2 \6\:qint_2) resistor r=0.1283 c=0
Rk75 (\6\:qint_2 \8\:qint_2) resistor r=0.1459 c=0
Rk76 (\6\:qint_2 \9\:qint_2) resistor r=0.1476 c=0
Rk31 (\2\:Db_2 \4\:Db_2) resistor r=0.4744 c=0
Rk33 (\4\:n20_2 \5\:n20_2) resistor r=0.5091 c=0
Rk34 (\5\:n20_2 \7\:n20_2) resistor r=0.3251 c=0
Rk35 (\5\:n20_2 \9\:n20_2) resistor r=0.202 c=0
Rk32 (\2\:n6_2 \4\:n6_2) resistor r=0.3059 c=0
Rk65 (\5\:n30_2 \6\:n30_2) resistor r=0.4318 c=0
Rk66 (\6\:n30_2 \8\:n30_2) resistor r=0.2522 c=0
Rk67 (\6\:n30_2 \9\:n30_2) resistor r=0.28 c=0
Rk68 (\12\:qbint_2 \13\:qbint_2) resistor r=0.0888 c=0
Rk69 (\13\:qbint_2 \15\:qbint_2) resistor r=0.3517 c=0
Rk70 (\15\:qbint_2 \16\:qbint_2) resistor r=0.3415 c=0
Rk71 (\13\:qbint_2 \18\:qbint_2) resistor r=0.3141 c=0
Rk36 (\5\:mout_2 \6\:mout_2) resistor r=0.2521 c=0
Rk37 (\6\:mout_2 \7\:mout_2) resistor r=0.3842 c=0
Rk38 (\6\:mout_2 \9\:mout_2) resistor r=0.2078 c=0
Rl30 (\1\:D1 \2\:D1) resistor r=70.7448 c=0
Rl31 (\2\:D1 \3\:D1) resistor r=40.6058 c=0
Rl56 (\10\:RN \11\:RN) resistor r=150 c=0
Rl46 (\8\:RN \9\:RN) resistor r=147.643 c=0
Rl22 (\4\:RN \5\:RN) resistor r=147.643 c=0
Rl12 (\1\:RN \3\:RN) resistor r=150 c=0
Rl57 (\10\:RN \12\:RN) resistor r=102.615 c=0
Rl45 (\7\:RN \8\:RN) resistor r=102.615 c=0
Rl23 (\5\:RN \6\:RN) resistor r=102.615 c=0
Rl11 (\1\:RN \2\:RN) resistor r=102.615 c=0
Rl37 (\1\:D2 \2\:D2) resistor r=70.7448 c=0
Rl38 (\2\:D2 \3\:D2) resistor r=40.6058 c=0
Rl35 (\1\:CK \2\:CK) resistor r=24.2328 c=0
Rl36 (\2\:CK \3\:CK) resistor r=58.8482 c=0
Rl51 (\14\:CKb \15\:CKb) resistor r=232.258 c=0
Rl40 (\11\:CKb \12\:CKb) resistor r=136.538 c=0
Rl28 (\4\:CKb \6\:CKb) resistor r=136.538 c=0
Rl18 (CKb \2\:CKb) resistor r=232.258 c=0
Rl52 (\15\:CKb \16\:CKb) resistor r=55.0021 c=0
Rl41 (\11\:CKb \13\:CKb) resistor r=55.0021 c=0
Rl27 (\4\:CKb \5\:CKb) resistor r=55.0021 c=0
Rl19 (\2\:CKb \3\:CKb) resistor r=55.0021 c=0
Rl34 (\8\:CKb \10\:CKb) resistor r=64.2642 c=0
Rl33 (\8\:CKb \9\:CKb) resistor r=37.3411 c=0
Rl32 (\7\:CKb \8\:CKb) resistor r=1.2334 c=0
Rl50 (\15\:Ckbb \16\:Ckbb) resistor r=32.9066 c=0
Rl49 (\13\:Ckbb \14\:Ckbb) resistor r=26.098 c=0
Rl42 (\11\:Ckbb \12\:Ckbb) resistor r=26.1559 c=0
Rl39 (\9\:Ckbb \10\:Ckbb) resistor r=40.3645 c=0
Rl29 (\7\:Ckbb \8\:Ckbb) resistor r=40.3645 c=0
Rl26 (\5\:Ckbb \6\:Ckbb) resistor r=26.1559 c=0
Rl17 (\3\:Ckbb \4\:Ckbb) resistor r=26.098 c=0
Rl16 (Ckbb \2\:Ckbb) resistor r=33.8727 c=0
Rl1 (qint \2\:qint) resistor r=24.2328 c=0
Rl2 (\2\:qint \3\:qint) resistor r=39.6174 c=0
Rl20 (n20 \2\:n20) resistor r=24.2328 c=0
Rl21 (\2\:n20 \3\:n20) resistor r=114.617 c=0
Rl10 (\2\:n30 \3\:n30) resistor r=95.3297 c=0
Rl9 (n30 \2\:n30) resistor r=31.1666 c=0
Rl3 (qbint \2\:qbint) resistor r=33.4373 c=0
Rl6 (\2\:qbint \5\:qbint) resistor r=48.8219 c=0
Rl7 (\2\:qbint \6\:qbint) resistor r=4.1351 c=0
Rl8 (\3\:qbint \7\:qbint) resistor r=37.6951 c=0
Rl5 (\3\:qbint \4\:qbint) resistor r=51.1566 c=0
Rl4 (\2\:qbint \3\:qbint) resistor r=154.087 c=0
Rl13 (\8\:qbint \9\:qbint) resistor r=37.3411 c=0
Rl15 (\9\:qbint \11\:qbint) resistor r=120.033 c=0
Rl14 (\9\:qbint \10\:qbint) resistor r=3.1183 c=0
Rl24 (mout \2\:mout) resistor r=83.8482 c=0
Rl25 (\2\:mout \3\:mout) resistor r=24.2328 c=0
Rl66 (qint_2 \2\:qint_2) resistor r=24.2328 c=0
Rl67 (\2\:qint_2 \3\:qint_2) resistor r=39.6174 c=0
Rl47 (n20_2 \2\:n20_2) resistor r=24.2328 c=0
Rl48 (\2\:n20_2 \3\:n20_2) resistor r=114.617 c=0
Rl58 (n30_2 \2\:n30_2) resistor r=96.1538 c=0
Rl59 (\2\:n30_2 \3\:n30_2) resistor r=32.1327 c=0
Rl55 (\2\:qbint_2 \4\:qbint_2) resistor r=37.3411 c=0
Rl54 (\2\:qbint_2 \3\:qbint_2) resistor r=120.033 c=0
Rl53 (qbint_2 \2\:qbint_2) resistor r=3.1216 c=0
Rl60 (\5\:qbint_2 \6\:qbint_2) resistor r=37.6951 c=0
Rl63 (\6\:qbint_2 \9\:qbint_2) resistor r=51.1566 c=0
Rl65 (\7\:qbint_2 \11\:qbint_2) resistor r=33.4373 c=0
Rl64 (\7\:qbint_2 \10\:qbint_2) resistor r=48.8219 c=0
Rl62 (\7\:qbint_2 \8\:qbint_2) resistor r=4.1351 c=0
Rl61 (\6\:qbint_2 \7\:qbint_2) resistor r=154.087 c=0
Rl43 (mout_2 \2\:mout_2) resistor r=83.8482 c=0
Rl44 (\2\:mout_2 \3\:mout_2) resistor r=24.2328 c=0
Rz1 (\1\:Q1N \2\:Q1N) resistor r=37.5 c=0
Rz18 (\1\:Q2N \2\:Q2N) resistor r=37.5 c=0
Rz19 (\3\:VDD \4\:VDD) resistor r=18.75 c=0
Rz20 (\3\:VDD \11\:VDD) resistor r=6.25 c=0
Rz21 (\3\:VDD \24\:VDD) resistor r=6.25 c=0
Rz22 (\3\:VDD \37\:VDD) resistor r=6.25 c=0
Rz16 (\3\:Q2 \4\:Q2) resistor r=37.5 c=0
Rz23 (\1\:VSS \2\:VSS) resistor r=75 c=0
Rz24 (\17\:VSS \18\:VSS) resistor r=75 c=0
Rz25 (\19\:VSS \20\:VSS) resistor r=75 c=0
Rz26 (\21\:VSS \22\:VSS) resistor r=75 c=0
Rz27 (\23\:VSS \24\:VSS) resistor r=75 c=0
Rz28 (\25\:VSS \26\:VSS) resistor r=75 c=0
Rz29 (\27\:VSS \28\:VSS) resistor r=75 c=0
Rz30 (\29\:VSS \30\:VSS) resistor r=75 c=0
Rz31 (\31\:VSS \32\:VSS) resistor r=75 c=0
Rz32 (\33\:VSS \34\:VSS) resistor r=75 c=0
Rz33 (\35\:VSS \36\:VSS) resistor r=75 c=0
Rz3 (\3\:Q1 \4\:Q1) resistor r=37.5 c=0
Rz12 (\24\:CKb \25\:CKb) resistor r=75 c=0
Rz13 (\28\:Ckbb \29\:Ckbb) resistor r=75 c=0
Rz2 (\8\:qint \9\:qint) resistor r=75 c=0
Rz8 (\3\:Db \4\:Db) resistor r=75 c=0
Rz7 (\8\:n20 \9\:n20) resistor r=75 c=0
Rz5 (\8\:n30 \9\:n30) resistor r=75 c=0
Rz4 (\17\:qbint \18\:qbint) resistor r=75 c=0
Rz6 (\6\:mout \7\:mout) resistor r=75 c=0
Rz17 (\7\:qint_2 \8\:qint_2) resistor r=75 c=0
Rz9 (\3\:Db_2 \4\:Db_2) resistor r=75 c=0
Rz10 (\8\:n20_2 \9\:n20_2) resistor r=75 c=0
Rz14 (\7\:n30_2 \8\:n30_2) resistor r=75 c=0
Rz15 (\17\:qbint_2 \18\:qbint_2) resistor r=75 c=0
Rz11 (\8\:mout_2 \9\:mout_2) resistor r=75 c=0
Ry1 (\3\:Q1N \4\:Q1N) resistor r=31 c=0
Ry22 (\3\:Q2N \4\:Q2N) resistor r=31 c=0
Ry23 (\1\:VDD \2\:VDD) resistor r=62 c=0
Ry24 (\6\:VDD \7\:VDD) resistor r=62 c=0
Ry25 (\9\:VDD \10\:VDD) resistor r=62 c=0
Ry26 (\13\:VDD \14\:VDD) resistor r=62 c=0
Ry27 (\16\:VDD \17\:VDD) resistor r=62 c=0
Ry28 (\19\:VDD \20\:VDD) resistor r=62 c=0
Ry29 (\22\:VDD \23\:VDD) resistor r=62 c=0
Ry30 (\26\:VDD \27\:VDD) resistor r=62 c=0
Ry31 (\29\:VDD \30\:VDD) resistor r=62 c=0
Ry32 (\32\:VDD \33\:VDD) resistor r=62 c=0
Ry33 (\35\:VDD \36\:VDD) resistor r=62 c=0
Ry34 (\39\:VDD \40\:VDD) resistor r=62 c=0
Ry35 (\41\:VDD \42\:VDD) resistor r=62 c=0
Ry20 (\1\:Q2 \2\:Q2) resistor r=31 c=0
Ry36 (\3\:VSS \4\:VSS) resistor r=15.5 c=0
Ry37 (\3\:VSS \7\:VSS) resistor r=5.1667 c=0
Ry38 (\3\:VSS \11\:VSS) resistor r=5.1667 c=0
Ry39 (\3\:VSS \15\:VSS) resistor r=5.1667 c=0
Ry3 (\1\:Q1 \2\:Q1) resistor r=31 c=0
Ry16 (\26\:CKb \27\:CKb) resistor r=62 c=0
Ry17 (\30\:Ckbb \31\:Ckbb) resistor r=62 c=0
Ry2 (\4\:qint \5\:qint) resistor r=62 c=0
Ry10 (Db \2\:Db) resistor r=62 c=0
Ry9 (\4\:n20 \5\:n20) resistor r=62 c=0
Ry7 (n6 \2\:n6) resistor r=62 c=0
Ry8 (\3\:n6 \4\:n6) resistor r=62 c=0
Ry5 (\4\:n30 \5\:n30) resistor r=62 c=0
Ry4 (\13\:qbint \14\:qbint) resistor r=62 c=0
Ry6 (\8\:mout \9\:mout) resistor r=62 c=0
Ry21 (\4\:qint_2 \5\:qint_2) resistor r=62 c=0
Ry11 (Db_2 \2\:Db_2) resistor r=62 c=0
Ry14 (\6\:n20_2 \7\:n20_2) resistor r=62 c=0
Ry12 (n6_2 \2\:n6_2) resistor r=62 c=0
Ry13 (\3\:n6_2 \4\:n6_2) resistor r=62 c=0
Ry18 (\4\:n30_2 \5\:n30_2) resistor r=62 c=0
Ry19 (\14\:qbint_2 \15\:qbint_2) resistor r=62 c=0
Ry15 (\4\:mout_2 \5\:mout_2) resistor r=62 c=0
Rx7 (\2\:D1 \5\:D1) resistor r=45 c=0
Rx17 (\12\:RN \13\:RN) resistor r=45 c=0
Rx18 (\7\:RN \14\:RN) resistor r=45 c=0
Rx19 (\6\:RN \15\:RN) resistor r=45 c=0
Rx20 (\2\:RN \16\:RN) resistor r=45 c=0
Rx9 (\2\:D2 \6\:D2) resistor r=45 c=0
Rx8 (\2\:CK \4\:CK) resistor r=45 c=0
Rx12 (\16\:CKb \17\:CKb) resistor r=45 c=0
Rx13 (\13\:CKb \18\:CKb) resistor r=45 c=0
Rx14 (\5\:CKb \20\:CKb) resistor r=45 c=0
Rx15 (\3\:CKb \21\:CKb) resistor r=45 c=0
Rx16 (\7\:CKb \23\:CKb) resistor r=45 c=0
Rx21 (\16\:Ckbb \17\:Ckbb) resistor r=45 c=0
Rx22 (\14\:Ckbb \18\:Ckbb) resistor r=45 c=0
Rx23 (\4\:Ckbb \24\:Ckbb) resistor r=45 c=0
Rx24 (Ckbb \25\:Ckbb) resistor r=45 c=0
Rx25 (\12\:Ckbb \26\:Ckbb) resistor r=45 c=0
Rx26 (\10\:Ckbb \27\:Ckbb) resistor r=45 c=0
Rx27 (\8\:Ckbb \32\:Ckbb) resistor r=45 c=0
Rx28 (\6\:Ckbb \33\:Ckbb) resistor r=45 c=0
Rx1 (\2\:qint \7\:qint) resistor r=45 c=0
Rx6 (\2\:n20 \7\:n20) resistor r=45 c=0
Rx4 (\2\:n30 \7\:n30) resistor r=45 c=0
Rx2 (\10\:qbint \12\:qbint) resistor r=45 c=0
Rx3 (\6\:qbint \16\:qbint) resistor r=45 c=0
Rx5 (\2\:mout \4\:mout) resistor r=45 c=0
Rx32 (\2\:qint_2 \9\:qint_2) resistor r=45 c=0
Rx10 (\2\:n20_2 \4\:n20_2) resistor r=45 c=0
Rx29 (\2\:n30_2 \9\:n30_2) resistor r=45 c=0
Rx30 (\8\:qbint_2 \12\:qbint_2) resistor r=45 c=0
Rx31 (qbint_2 \16\:qbint_2) resistor r=45 c=0
Rx11 (\2\:mout_2 \7\:mout_2) resistor r=45 c=0
NM17 (\3\:Q2 \10\:qbint_2 \19\:VSS VSS) g45n1svt w=(2.6e-07) l=4.5e-08 \
        nf=1 as=6.225e-14 ad=3.64e-14 ps=1.56e-06 pd=8e-07 nrd=1.16667 \
        nrs=1.16667 sa=1.4e-07 sb=1.08654e-07 sd=160n sca=17.5885 \
        scb=0.0172826 scc=0.00162584 m=(1)
NM19 (\1\:Q2N \3\:qint_2 \1\:VSS VSS) g45n1svt w=(2.6e-07) l=4.5e-08 \
        nf=1 as=6.065e-14 ad=3.64e-14 ps=1.65e-06 pd=8e-07 nrd=1.16667 \
        nrs=1.16667 sa=1.4e-07 sb=2.31058e-07 sd=160n sca=17.5885 \
        scb=0.0172826 scc=0.00162584 m=(1)
mn55 (\3\:Q1 \5\:qbint \35\:VSS VSS) g45n1svt w=(2.6e-07) l=4.5e-08 nf=1 \
        as=6.225e-14 ad=3.64e-14 ps=1.56e-06 pd=8e-07 nrd=1.16667 \
        nrs=1.16667 sa=1.4e-07 sb=1.08654e-07 sd=160n sca=17.5885 \
        scb=0.0172826 scc=0.00162584 m=(1)
mn57 (\1\:Q1N \3\:qint \17\:VSS VSS) g45n1svt w=(2.6e-07) l=4.5e-08 nf=1 \
        as=6.065e-14 ad=3.64e-14 ps=1.65e-06 pd=8e-07 nrd=1.16667 \
        nrs=1.16667 sa=1.4e-07 sb=2.31058e-07 sd=160n sca=17.5885 \
        scb=0.0172826 scc=0.00162584 m=(1)
NM1 (\3\:Db_2 \3\:D2 \25\:VSS VSS) g45n1svt w=(1.45e-07) l=4.5e-08 nf=1 \
        as=6.163e-14 ad=5.055e-14 ps=1.14e-06 pd=1.35e-06 nrd=1.16667 \
        nrs=1.16667 sa=1.15e-07 sb=1.54207e-06 sd=160n sca=13.6097 \
        scb=0.014254 scc=0.000755054 m=(1)
NM7 (\3\:Db_2 \12\:CKb \8\:n20_2 VSS) g45n1svt w=(1.45e-07) l=4.5e-08 \
        nf=1 as=6.163e-14 ad=2.9e-14 ps=1.14e-06 pd=6.9e-07 nrd=1.16667 \
        nrs=1.16667 sa=5.85e-07 sb=1.21552e-06 sd=160n sca=13.6097 \
        scb=0.014254 scc=0.000755054 m=(1)
NM9 (\8\:n20_2 \11\:Ckbb n5_2 VSS) g45n1svt w=(1.45e-07) l=4.5e-08 nf=1 \
        as=2.9e-14 ad=1.957e-14 ps=6.9e-07 pd=5.6e-07 nrd=1.16667 \
        nrs=1.16667 sa=8.3e-07 sb=9.70517e-07 sd=160n sca=13.6097 \
        scb=0.014254 scc=0.000755054 m=(1)
NM11 (n5_2 \3\:mout_2 n7_2 VSS) g45n1svt w=(1.45e-07) l=4.5e-08 nf=1 \
        as=1.957e-14 ad=1.232e-14 ps=5.6e-07 pd=4.6e-07 nrd=1.16667 \
        nrs=1.16667 sa=1.01e-06 sb=7.90517e-07 sd=160n sca=13.6097 \
        scb=0.014254 scc=0.000755054 m=(1)
NM10 (n7_2 \9\:RN \23\:VSS VSS) g45n1svt w=(1.45e-07) l=4.5e-08 nf=1 \
        as=7.322e-14 ad=1.233e-14 ps=1.45e-06 pd=4.6e-07 nrd=1.16667 \
        nrs=1.16667 sa=6.60517e-07 sb=1.14e-06 sd=160n sca=13.6097 \
        scb=0.014254 scc=0.000755054 m=(1)
NM8 (\8\:mout_2 \3\:n20_2 \23\:VSS VSS) g45n1svt w=(1.45e-07) l=4.5e-08 \
        nf=1 as=2.682e-14 ad=7.322e-14 ps=6.6e-07 pd=1.45e-06 nrd=1.16667 \
        nrs=1.16667 sa=7.28621e-07 sb=9.17931e-07 sd=160n sca=9.50767 \
        scb=0.00818119 scc=0.00019576 m=(1)
NM12 (\8\:mout_2 \13\:Ckbb \7\:n30_2 VSS) g45n1svt w=(1.45e-07) l=4.5e-08 \
        nf=1 as=2.755e-14 ad=2.682e-14 ps=6.7e-07 pd=6.6e-07 nrd=1.16667 \
        nrs=1.16667 sa=6.87931e-07 sb=9.58621e-07 sd=160n sca=9.50767 \
        scb=0.00818119 scc=0.00019576 m=(1)
NM16 (\7\:n30_2 \14\:CKb n11_2 VSS) g45n1svt w=(1.45e-07) l=4.5e-08 nf=1 \
        as=2.755e-14 ad=8.7e-15 ps=6.7e-07 pd=4.1e-07 nrd=1.16667 \
        nrs=1.16667 sa=1.19362e-06 sb=4.52931e-07 sd=160n sca=9.50767 \
        scb=0.00818119 scc=0.00019576 m=(1)
NM15 (n11_2 \3\:qbint_2 \21\:VSS VSS) g45n1svt w=(1.45e-07) l=4.5e-08 \
        nf=1 as=5.14e-14 ad=8.7e-15 ps=1.4e-06 pd=4.1e-07 nrd=1.16667 \
        nrs=1.16667 sa=3.47931e-07 sb=1.29862e-06 sd=160n sca=9.50767 \
        scb=0.00818119 scc=0.00019576 m=(1)
NM14 (n9_2 \11\:RN \21\:VSS VSS) g45n1svt w=(1.45e-07) l=4.5e-08 nf=1 \
        as=8.7e-15 ad=5.14e-14 ps=4.1e-07 pd=1.4e-06 nrd=1.16667 \
        nrs=1.16667 sa=1.16e-06 sb=2.5e-07 sd=160n sca=11.4452 \
        scb=0.0112553 scc=0.00042156 m=(1)
NM13 (\17\:qbint_2 \3\:n30_2 n9_2 VSS) g45n1svt w=(1.45e-07) l=4.5e-08 \
        nf=1 as=8.7e-15 ad=2.102e-14 ps=4.1e-07 pd=5.8e-07 nrd=1.16667 \
        nrs=1.16667 sa=1.45e-07 sb=1.21793e-06 sd=160n sca=11.4452 \
        scb=0.0112553 scc=0.00042156 m=(1)
NM18 (\7\:qint_2 \9\:qbint_2 \1\:VSS VSS) g45n1svt w=(1.45e-07) \
        l=4.5e-08 nf=1 as=2.03e-14 ad=6.065e-14 ps=5.7e-07 pd=1.65e-06 \
        nrd=1.16667 nrs=1.16667 sa=1.4e-07 sb=3.35e-07 sd=160n sca=23.279 \
        scb=0.0230742 scc=0.00267719 m=(1)
mn11 (\3\:Db \3\:D1 \29\:VSS VSS) g45n1svt w=(1.45e-07) l=4.5e-08 nf=1 \
        as=6.162e-14 ad=5.055e-14 ps=1.14e-06 pd=1.35e-06 nrd=1.16667 \
        nrs=1.16667 sa=1.15e-07 sb=1.54207e-06 sd=160n sca=13.6097 \
        scb=0.014254 scc=0.000755054 m=(1)
mn25 (\3\:Db \6\:CKb \8\:n20 VSS) g45n1svt w=(1.45e-07) l=4.5e-08 nf=1 \
        as=6.162e-14 ad=2.9e-14 ps=1.14e-06 pd=6.9e-07 nrd=1.16667 \
        nrs=1.16667 sa=5.85e-07 sb=1.21552e-06 sd=160n sca=13.6097 \
        scb=0.014254 scc=0.000755054 m=(1)
mn37 (\8\:n20 \5\:Ckbb n5 VSS) g45n1svt w=(1.45e-07) l=4.5e-08 nf=1 \
        as=2.9e-14 ad=1.957e-14 ps=6.9e-07 pd=5.6e-07 nrd=1.16667 \
        nrs=1.16667 sa=8.3e-07 sb=9.70517e-07 sd=160n sca=13.6097 \
        scb=0.014254 scc=0.000755054 m=(1)
mn36 (n5 \3\:mout n7 VSS) g45n1svt w=(1.45e-07) l=4.5e-08 nf=1 \
        as=1.957e-14 ad=1.232e-14 ps=5.6e-07 pd=4.6e-07 nrd=1.16667 \
        nrs=1.16667 sa=1.01e-06 sb=7.90517e-07 sd=160n sca=13.6097 \
        scb=0.014254 scc=0.000755054 m=(1)
mn35 (n7 \4\:RN \31\:VSS VSS) g45n1svt w=(1.45e-07) l=4.5e-08 nf=1 \
        as=7.322e-14 ad=1.232e-14 ps=1.45e-06 pd=4.6e-07 nrd=1.16667 \
        nrs=1.16667 sa=6.60517e-07 sb=1.14e-06 sd=160n sca=13.6097 \
        scb=0.014254 scc=0.000755054 m=(1)
mn30 (\6\:mout \3\:n20 \31\:VSS VSS) g45n1svt w=(1.45e-07) l=4.5e-08 \
        nf=1 as=2.682e-14 ad=7.322e-14 ps=6.6e-07 pd=1.45e-06 nrd=1.16667 \
        nrs=1.16667 sa=7.28621e-07 sb=9.17931e-07 sd=160n sca=9.50767 \
        scb=0.00818119 scc=0.00019576 m=(1)
mn40 (\6\:mout \3\:Ckbb \8\:n30 VSS) g45n1svt w=(1.45e-07) l=4.5e-08 nf=1 \
        as=2.755e-14 ad=2.682e-14 ps=6.7e-07 pd=6.6e-07 nrd=1.16667 \
        nrs=1.16667 sa=6.87931e-07 sb=9.58621e-07 sd=160n sca=9.50767 \
        scb=0.00818119 scc=0.00019576 m=(1)
mn51 (\8\:n30 CKb n11 VSS) g45n1svt w=(1.45e-07) l=4.5e-08 nf=1 \
        as=2.755e-14 ad=8.7e-15 ps=6.7e-07 pd=4.1e-07 nrd=1.16667 \
        nrs=1.16667 sa=1.19362e-06 sb=4.52931e-07 sd=160n sca=9.50767 \
        scb=0.00818119 scc=0.00019576 m=(1)
mn50 (n11 \11\:qbint \33\:VSS VSS) g45n1svt w=(1.45e-07) l=4.5e-08 nf=1 \
        as=5.14e-14 ad=8.7e-15 ps=1.4e-06 pd=4.1e-07 nrd=1.16667 \
        nrs=1.16667 sa=3.47931e-07 sb=1.29862e-06 sd=160n sca=9.50767 \
        scb=0.00818119 scc=0.00019576 m=(1)
mn45 (n9 \3\:RN \33\:VSS VSS) g45n1svt w=(1.45e-07) l=4.5e-08 nf=1 \
        as=8.7e-15 ad=5.14e-14 ps=4.1e-07 pd=1.4e-06 nrd=1.16667 \
        nrs=1.16667 sa=1.16e-06 sb=2.5e-07 sd=160n sca=11.4452 \
        scb=0.0112553 scc=0.00042156 m=(1)
mn46 (\17\:qbint n30 n9 VSS) g45n1svt w=(1.45e-07) l=4.5e-08 nf=1 \
        as=8.7e-15 ad=2.102e-14 ps=4.1e-07 pd=5.8e-07 nrd=1.16667 \
        nrs=1.16667 sa=1.45e-07 sb=1.21793e-06 sd=160n sca=11.4452 \
        scb=0.0112553 scc=0.00042156 m=(1)
mn56 (\8\:qint \4\:qbint \17\:VSS VSS) g45n1svt w=(1.45e-07) l=4.5e-08 \
        nf=1 as=2.03e-14 ad=6.065e-14 ps=5.7e-07 pd=1.65e-06 nrd=1.16667 \
        nrs=1.16667 sa=1.4e-07 sb=3.35e-07 sd=160n sca=23.279 \
        scb=0.0230742 scc=0.00267719 m=(1)
mn21 (\28\:Ckbb \9\:CKb \27\:VSS VSS) g45n1svt w=(1.45e-07) l=4.5e-08 \
        nf=1 as=2.03e-14 ad=6.752e-14 ps=5.7e-07 pd=1.56e-06 nrd=1.16667 \
        nrs=1.16667 sa=1.4e-07 sb=3.6e-07 sd=160n sca=19.8813 \
        scb=0.0206549 scc=0.00197265 m=(1)
mn20 (\24\:CKb \3\:CK \27\:VSS VSS) g45n1svt w=(1.45e-07) l=4.5e-08 nf=1 \
        as=2.03e-14 ad=6.752e-14 ps=5.7e-07 pd=1.56e-06 nrd=1.16667 \
        nrs=1.16667 sa=3.6e-07 sb=1.4e-07 sd=160n sca=19.8813 \
        scb=0.0206549 scc=0.00197265 m=(1)
PM1 (Db_2 \1\:D2 \19\:VDD VDD) g45p1svt w=(2.15e-07) l=4.5e-08 nf=1 \
        as=4.3e-14 ad=6.28e-14 ps=8.3e-07 pd=1.73e-06 nrd=1.16667 \
        nrs=1.16667 sa=1.15e-07 sb=6.25e-07 sd=160n sca=29.9075 \
        scb=0.0247057 scc=0.00372713 m=(1)
PM7 (\6\:n20_2 \9\:Ckbb Db_2 VDD) g45p1svt w=(2.15e-07) l=4.5e-08 nf=1 \
        as=4.3e-14 ad=3.87e-14 ps=8.3e-07 pd=7.9e-07 nrd=1.16667 \
        nrs=1.16667 sa=3.8e-07 sb=3.6e-07 sd=160n sca=29.9075 \
        scb=0.0247057 scc=0.00372713 m=(1)
PM10 (\6\:n20_2 \11\:CKb \3\:n6_2 VDD) g45p1svt w=(2.15e-07) l=4.5e-08 \
        nf=1 as=3.333e-14 ad=3.87e-14 ps=7.4e-07 pd=7.9e-07 nrd=1.16667 \
        nrs=1.16667 sa=1.55e-07 sb=5.85e-07 sd=160n sca=29.9075 \
        scb=0.0247057 scc=0.00372713 m=(1)
PM11 (n6_2 mout_2 \16\:VDD VDD) g45p1svt w=(2.15e-07) l=4.5e-08 nf=1 \
        as=5.488e-14 ad=3.44e-14 ps=1.74e-06 pd=7.5e-07 nrd=1.16667 \
        nrs=1.16667 sa=1.84e-06 sb=1e-07 sd=160n sca=29.9075 scb=0.0247057 \
        scc=0.00372713 m=(1)
PM9 (n6_2 \8\:RN \13\:VDD VDD) g45p1svt w=(2.15e-07) l=4.5e-08 nf=1 \
        as=6.5e-14 ad=3.44e-14 ps=1.83e-06 pd=7.5e-07 nrd=1.16667 \
        nrs=1.16667 sa=1.635e-06 sb=3.05e-07 sd=160n sca=29.9075 \
        scb=0.0247057 scc=0.00372713 m=(1)
PM8 (\4\:mout_2 n20_2 \13\:VDD VDD) g45p1svt w=(2.15e-07) l=4.5e-08 nf=1 \
        as=6.5e-14 ad=4.408e-14 ps=1.83e-06 pd=8.4e-07 nrd=1.16667 \
        nrs=1.16667 sa=1.44e-06 sb=5e-07 sd=160n sca=29.9075 scb=0.0247057 \
        scc=0.00372713 m=(1)
PM12 (\4\:n30_2 \15\:CKb \4\:mout_2 VDD) g45p1svt w=(2.15e-07) l=4.5e-08 \
        nf=1 as=3.44e-14 ad=4.408e-14 ps=7.5e-07 pd=8.4e-07 nrd=1.16667 \
        nrs=1.16667 sa=7.5e-07 sb=1.19e-06 sd=160n sca=29.9075 \
        scb=0.0247057 scc=0.00372713 m=(1)
PM16 (\4\:n30_2 \15\:Ckbb n8_2 VDD) g45p1svt w=(2.15e-07) l=4.5e-08 nf=1 \
        as=3.44e-14 ad=1.505e-14 ps=7.5e-07 pd=5.7e-07 nrd=1.16667 \
        nrs=1.16667 sa=9.55e-07 sb=9.85e-07 sd=160n sca=29.9075 \
        scb=0.0247057 scc=0.00372713 m=(1)
PM15 (n8_2 \4\:qbint_2 \9\:VDD VDD) g45p1svt w=(2.15e-07) l=4.5e-08 nf=1 \
        as=7.07e-14 ad=1.505e-14 ps=1.83e-06 pd=5.7e-07 nrd=1.16667 \
        nrs=1.16667 sa=8.7e-07 sb=1.07e-06 sd=160n sca=29.9075 \
        scb=0.0247057 scc=0.00372713 m=(1)
PM13 (\14\:qbint_2 \10\:RN \9\:VDD VDD) g45p1svt w=(2.15e-07) l=4.5e-08 \
        nf=1 as=7.07e-14 ad=3.44e-14 ps=1.83e-06 pd=7.5e-07 nrd=1.16667 \
        nrs=1.16667 sa=6.65e-07 sb=1.275e-06 sd=160n sca=29.9075 \
        scb=0.0247057 scc=0.00372713 m=(1)
PM14 (\14\:qbint_2 n30_2 \6\:VDD VDD) g45p1svt w=(2.15e-07) l=4.5e-08 \
        nf=1 as=3.44e-14 ad=1.13e-13 ps=7.5e-07 pd=2.1e-06 nrd=1.16667 \
        nrs=1.16667 sa=1.48e-06 sb=4.6e-07 sd=160n sca=29.9075 \
        scb=0.0247057 scc=0.00372713 m=(1)
PM18 (\4\:qint_2 \5\:qbint_2 \1\:VDD VDD) g45p1svt w=(2.15e-07) \
        l=4.5e-08 nf=1 as=7.55e-14 ad=2.63e-14 ps=1.9e-06 pd=7.1e-07 \
        nrd=1.16667 nrs=1.16667 sa=3.35e-07 sb=1.22326e-07 sd=160n \
        sca=49.623 scb=0.0330309 scc=0.00593405 m=(1)
mp11 (Db \1\:D1 \26\:VDD VDD) g45p1svt w=(2.15e-07) l=4.5e-08 nf=1 \
        as=4.3e-14 ad=6.28e-14 ps=8.3e-07 pd=1.73e-06 nrd=1.16667 \
        nrs=1.16667 sa=1.15e-07 sb=6.25e-07 sd=160n sca=29.9075 \
        scb=0.0247057 scc=0.00372713 m=(1)
mp25 (\4\:n20 \7\:Ckbb Db VDD) g45p1svt w=(2.15e-07) l=4.5e-08 nf=1 \
        as=4.3e-14 ad=3.87e-14 ps=8.3e-07 pd=7.9e-07 nrd=1.16667 \
        nrs=1.16667 sa=3.8e-07 sb=3.6e-07 sd=160n sca=29.9075 \
        scb=0.0247057 scc=0.00372713 m=(1)
mp37 (\4\:n20 \4\:CKb n6 VDD) g45p1svt w=(2.15e-07) l=4.5e-08 nf=1 \
        as=3.333e-14 ad=3.87e-14 ps=7.4e-07 pd=7.9e-07 nrd=1.16667 \
        nrs=1.16667 sa=1.55e-07 sb=5.85e-07 sd=160n sca=29.9075 \
        scb=0.0247057 scc=0.00372713 m=(1)
mp36 (\3\:n6 mout \29\:VDD VDD) g45p1svt w=(2.15e-07) l=4.5e-08 nf=1 \
        as=5.488e-14 ad=3.44e-14 ps=1.74e-06 pd=7.5e-07 nrd=1.16667 \
        nrs=1.16667 sa=1.84e-06 sb=1e-07 sd=160n sca=29.9075 scb=0.0247057 \
        scc=0.00372713 m=(1)
mp35 (\3\:n6 \5\:RN \32\:VDD VDD) g45p1svt w=(2.15e-07) l=4.5e-08 nf=1 \
        as=6.5e-14 ad=3.44e-14 ps=1.83e-06 pd=7.5e-07 nrd=1.16667 \
        nrs=1.16667 sa=1.635e-06 sb=3.05e-07 sd=160n sca=29.9075 \
        scb=0.0247057 scc=0.00372713 m=(1)
mp30 (\8\:mout n20 \32\:VDD VDD) g45p1svt w=(2.15e-07) l=4.5e-08 nf=1 \
        as=6.5e-14 ad=4.408e-14 ps=1.83e-06 pd=8.4e-07 nrd=1.16667 \
        nrs=1.16667 sa=1.44e-06 sb=5e-07 sd=160n sca=29.9075 scb=0.0247057 \
        scc=0.00372713 m=(1)
mp40 (\4\:n30 \2\:CKb \8\:mout VDD) g45p1svt w=(2.15e-07) l=4.5e-08 nf=1 \
        as=3.44e-14 ad=4.408e-14 ps=7.5e-07 pd=8.4e-07 nrd=1.16667 \
        nrs=1.16667 sa=7.5e-07 sb=1.19e-06 sd=160n sca=29.9075 \
        scb=0.0247057 scc=0.00372713 m=(1)
mp51 (\4\:n30 \2\:Ckbb n8 VDD) g45p1svt w=(2.15e-07) l=4.5e-08 nf=1 \
        as=3.44e-14 ad=1.505e-14 ps=7.5e-07 pd=5.7e-07 nrd=1.16667 \
        nrs=1.16667 sa=9.55e-07 sb=9.85e-07 sd=160n sca=29.9075 \
        scb=0.0247057 scc=0.00372713 m=(1)
mp50 (n8 \8\:qbint \35\:VDD VDD) g45p1svt w=(2.15e-07) l=4.5e-08 nf=1 \
        as=7.07e-14 ad=1.505e-14 ps=1.83e-06 pd=5.7e-07 nrd=1.16667 \
        nrs=1.16667 sa=8.7e-07 sb=1.07e-06 sd=160n sca=29.9075 \
        scb=0.0247057 scc=0.00372713 m=(1)
mp45 (\13\:qbint \1\:RN \35\:VDD VDD) g45p1svt w=(2.15e-07) l=4.5e-08 \
        nf=1 as=7.07e-14 ad=3.44e-14 ps=1.83e-06 pd=7.5e-07 nrd=1.16667 \
        nrs=1.16667 sa=6.65e-07 sb=1.275e-06 sd=160n sca=29.9075 \
        scb=0.0247057 scc=0.00372713 m=(1)
mp46 (\13\:qbint \3\:n30 \39\:VDD VDD) g45p1svt w=(2.15e-07) l=4.5e-08 \
        nf=1 as=3.44e-14 ad=1.13e-13 ps=7.5e-07 pd=2.1e-06 nrd=1.16667 \
        nrs=1.16667 sa=1.48e-06 sb=4.6e-07 sd=160n sca=29.9075 \
        scb=0.0247057 scc=0.00372713 m=(1)
mp56 (\4\:qint \7\:qbint \41\:VDD VDD) g45p1svt w=(2.15e-07) l=4.5e-08 \
        nf=1 as=7.55e-14 ad=2.63e-14 ps=1.9e-06 pd=7.1e-07 nrd=1.16667 \
        nrs=1.16667 sa=3.35e-07 sb=1.22326e-07 sd=160n sca=49.623 \
        scb=0.0330309 scc=0.00593405 m=(1)
mp21 (\30\:Ckbb \10\:CKb \22\:VDD VDD) g45p1svt w=(2.15e-07) l=4.5e-08 \
        nf=1 as=3.01e-14 ad=8.732e-14 ps=7.1e-07 pd=1.85e-06 nrd=1.16667 \
        nrs=1.16667 sa=1.4e-07 sb=3.6e-07 sd=160n sca=31.508 scb=0.0252524 \
        scc=0.00399199 m=(1)
mp20 (\26\:CKb \1\:CK \22\:VDD VDD) g45p1svt w=(2.15e-07) l=4.5e-08 nf=1 \
        as=3.01e-14 ad=8.732e-14 ps=7.1e-07 pd=1.85e-06 nrd=1.16667 \
        nrs=1.16667 sa=3.6e-07 sb=1.4e-07 sd=160n sca=31.508 scb=0.0252524 \
        scc=0.00399199 m=(1)
ends DFF2RX1
// End of subcircuit definition.
