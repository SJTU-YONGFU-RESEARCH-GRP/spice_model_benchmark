// Generated for: spectre (May  1 08:11:50 2013 )
// Library name: gsclib045
// Cell name: LSHL_ISONL_X1_FROM_OFF
// View name: extracted

simulator lang=spectre

subckt LSHL_ISONL_X1_FROM_OFF A ExtVDD ISOn VSS Y
PM2 (\12\:n0 \1\:ISOn \1\:ExtVDD ExtVDD) g45p1svt w=(2.15e-07) l=4.5e-08 \
        nf=1 as=6.535e-14 ad=3.01e-14 ps=1.16e-06 pd=7.1e-07 nrd=1.16667 \
        nrs=1.16667 sa=1.4e-07 sb=3.75e-07 sd=160n sca=9.96767 \
        scb=0.00673424 scc=5.74085e-05 m=(1)
mp0 (\10\:n0 \1\:A \3\:ExtVDD ExtVDD) g45p1svt w=(2.15e-07) l=4.5e-08 \
        nf=1 as=3.01e-14 ad=3.01e-14 ps=7.1e-07 pd=7.1e-07 nrd=1.16667 \
        nrs=1.16667 sa=1.4e-07 sb=1.4e-07 sd=160n sca=10.57 scb=0.00792753 \
        scc=9.23989e-05 m=(1)
C1 (Y VSS) capacitor c=3.58241e-17
C2 (A VSS) capacitor c=5.24764e-17
C3 (ExtVDD VSS) capacitor c=1.52752e-16
C4 (VDD VSS) capacitor c=8.41487e-17
C5 (ISOn VSS) capacitor c=4.41315e-17
C6 (n0 VSS) capacitor c=2.91768e-17
C7 (GatedVSS VSS) capacitor c=1.64269e-16
C8 (\4\:n0 VSS) capacitor c=5.52164e-17
C9 (\1\:ISOn VSS) capacitor c=4.34334e-17
C10 (\1\:A VSS) capacitor c=5.33451e-17
C11 (\4\:A VSS) capacitor c=3.06514e-17
C12 (\3\:n0 VSS) capacitor c=4.47136e-17
C13 (\2\:ISOn VSS) capacitor c=5.84438e-17
C14 (\3\:A VSS) capacitor c=1.3128e-17
C15 (\1\:Y VSS) capacitor c=5.50627e-17
C16 (\1\:ExtVDD VSS) capacitor c=1.51157e-16
C17 (\12\:n0 VSS) capacitor c=3.80091e-17
C18 (\10\:n0 VSS) capacitor c=3.6013e-17
C19 (\3\:ExtVDD VSS) capacitor c=9.22751e-17
C20 (\3\:Y VSS) capacitor c=5.5202e-17
C21 (\5\:GatedVSS VSS) capacitor c=3.88152e-17
C22 (\7\:n0 VSS) capacitor c=8.92353e-17
C23 (ExtVDD VSS) capacitor c=1.01226e-16
C24 (\2\:A VSS) capacitor c=4.27336e-17
C25 (VDD VSS) capacitor c=2.21487e-16
C26 (\3\:ISOn VSS) capacitor c=8.82775e-17
C27 (\7\:ISOn VSS) capacitor c=2.06408e-17
C28 (\5\:n0 VSS) capacitor c=5.61253e-17
C29 (\6\:n0 VSS) capacitor c=1.77101e-16
C30 (\9\:n0 VSS) capacitor c=4.22601e-17
Rk21 (\3\:VSS VSS) resistor r=0.1521 c=0
Rk20 (\2\:VSS \3\:VSS) resistor r=0.4284 c=0
Rk22 (VSS \4\:VSS) resistor r=0.06302 c=0
Rk24 (\5\:VSS VSS) resistor r=0.363 c=0
Rk23 (\4\:VSS \5\:VSS) resistor r=0.03371 c=0
Rk25 (\3\:VSS \7\:VSS) resistor r=0.2549 c=0
Rk26 (\4\:VSS \9\:VSS) resistor r=0.207 c=0
Rk28 (\11\:VSS VSS) resistor r=0.581 c=0
Rk30 (\12\:VSS VSS) resistor r=0.363 c=0
Rk29 (VSS \12\:VSS) resistor r=0.09711 c=0
Rk18 (Y \2\:Y) resistor r=0.2462 c=0
Rk19 (Y \4\:Y) resistor r=0.3025 c=0
Rk11 (ExtVDD ExtVDD) resistor r=0.001733 c=0
Rk10 (\4\:ExtVDD ExtVDD) resistor r=0.2675 c=0
Rk9 (\2\:ExtVDD \4\:ExtVDD) resistor r=0.8462 c=0
Rk27 (VDD VDD) resistor r=0.4044 c=0
Rk6 (\6\:ISOn ISOn) resistor r=0.002491 c=0
Rk8 (\6\:ISOn \7\:ISOn) resistor r=0.01792 c=0
Rk7 (\7\:ISOn \8\:ISOn) resistor r=0.004982 c=0
Rk13 (\5\:n0 \6\:n0) resistor r=0.2867 c=0
Rk14 (\6\:n0 \8\:n0) resistor r=0.7017 c=0
Rk15 (\6\:n0 \9\:n0) resistor r=0.3698 c=0
Rk16 (\9\:n0 \11\:n0) resistor r=0.02654 c=0
Rk17 (\9\:n0 \13\:n0) resistor r=0.03215 c=0
Rk4 (GatedVSS \6\:GatedVSS) resistor r=0.08648 c=0
Rl1 (\1\:A \2\:A) resistor r=248.037 c=0
Rl3 (\2\:A \4\:A) resistor r=117.068 c=0
Rl2 (\2\:A \3\:A) resistor r=1.2666 c=0
Rl4 (\2\:ISOn \1\:ISOn) resistor r=104.766 c=0
Rl5 (\3\:ISOn \2\:ISOn) resistor r=135.302 c=0
Rl10 (\2\:n0 \4\:n0) resistor r=120.442 c=0
Rl8 (n0 \2\:n0) resistor r=47.9771 c=0
Rl9 (\2\:n0 \3\:n0) resistor r=0.6051 c=0
Rz7 (\7\:VSS \6\:VSS) resistor r=37.5 c=0
Rz8 (\9\:VSS \8\:VSS) resistor r=75 c=0
Rz6 (\3\:Y \4\:Y) resistor r=37.5 c=0
Rz5 (\7\:n0 \8\:n0) resistor r=75 c=0
Rz3 (\6\:GatedVSS \5\:GatedVSS) resistor r=75 c=0
Ry6 (\2\:VSS \1\:VSS) resistor r=31 c=0
Ry7 (\5\:VSS \1\:VSS) resistor r=5.1667 c=0
Ry8 (\11\:VSS \10\:VSS) resistor r=31 c=0
Ry9 (\12\:VSS \10\:VSS) resistor r=5.1667 c=0
Ry5 (\1\:Y \2\:Y) resistor r=20.6667 c=0
Ry1 (\1\:ExtVDD \2\:ExtVDD) resistor r=20.6667 c=0
Ry2 (\3\:ExtVDD \4\:ExtVDD) resistor r=62 c=0
Ry3 (\10\:n0 \11\:n0) resistor r=62 c=0
Ry4 (\12\:n0 \13\:n0) resistor r=62 c=0
Rx1 (\3\:A A) resistor r=45 c=0
Rx2 (\8\:ISOn \2\:ISOn) resistor r=45 c=0
Rx3 (\3\:n0 \5\:n0) resistor r=45 c=0
mn0 (\5\:GatedVSS \4\:A \7\:n0 VSS) g45n1svt w=(1.45e-07) l=4.5e-08 nf=1 \
        as=2.03e-14 ad=2.03e-14 ps=5.7e-07 pd=5.7e-07 nrd=1.16667 \
        nrs=1.16667 sa=1.4e-07 sb=1.4e-07 sd=160n sca=5.4629 \
        scb=0.00240631 scc=0.000219187 m=(1)
NM0 (\3\:Y n0 \6\:VSS VSS) g45n1svt w=(2.6e-07) l=4.5e-08 nf=1 \
        as=3.64e-14 ad=3.64e-14 ps=8e-07 pd=8e-07 nrd=1.16667 nrs=1.16667 \
        sa=1.4e-07 sb=1.4e-07 sd=160n sca=15.3338 scb=0.0153436 \
        scc=0.00119435 m=(1)
NM3 (GatedVSS \3\:ISOn \8\:VSS VSS) g45n1svt w=(2.6e-07) l=4.5e-08 nf=1 \
        as=3.64e-14 ad=4.16e-14 ps=8e-07 pd=8.4e-07 nrd=1.16667 \
        nrs=1.16667 sa=1.4e-07 sb=3.45e-07 sd=160n sca=15.3338 \
        scb=0.0153436 scc=0.00119435 m=(2)
PM0 (\1\:Y \4\:n0 \1\:ExtVDD ExtVDD) g45p1svt w=(3.9e-07) l=4.5e-08 nf=1 \
        as=5.46e-14 ad=6.535e-14 ps=1.06e-06 pd=1.16e-06 nrd=1.16667 \
        nrs=1.16667 sa=2.69551e-07 sb=1.4e-07 sd=160n sca=26.6928 \
        scb=0.0286638 scc=0.00274044 m=(1)
ends LSHL_ISONL_X1_FROM_OFF
// End of subcircuit definition.
