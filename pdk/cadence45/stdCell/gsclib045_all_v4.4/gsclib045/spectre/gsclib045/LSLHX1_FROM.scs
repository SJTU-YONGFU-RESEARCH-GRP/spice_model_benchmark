// gsclib045/LSLHX1_FROM/schematic

simulator lang=spectre

subckt LSLHX1_FROM A Y VSS ExtVDD VDD
mn0 (Y Ybint VSS VSS) g45n1svt w=(260n) l=45n nf=1 m=(1)
NM2 (VSS A Ab VSS) g45n1svt w=(145n) l=45n nf=1 m=(1)
NM0 (Ybint A VSS VSS) g45n1svt w=(780n) l=45n nf=3 m=(1)
NM1 (Yint Ab VSS VSS) g45n1svt w=(780n) l=45n nf=3 m=(1)
PM0 (Ybint Yint ExtVDD ExtVDD) g45p1svt w=(215n) l=45n nf=1 m=(1)
PM1 (Yint Ybint ExtVDD ExtVDD) g45p1svt w=(215n) l=45n nf=1 m=(1)
mp0 (Y Ybint ExtVDD ExtVDD) g45p1svt w=(390n) l=45n nf=1 m=(1)
PM2 (Ab A VDD VDD) g45p1svt w=(215n) l=45n nf=1 m=(1)
ends LSLHX1_FROM
