// gsclib045/NAND3X8/schematic

simulator lang=spectre

subckt NAND3X8 A B C Y VDD VSS
mn1 (n0 B n1 VSS) g45n1svt w=(2.065u) l=45n nf=1 m=(1)
mn2 (Y C n0 VSS) g45n1svt w=(2.065u) l=45n nf=1 m=(1)
mn0 (n1 A VSS VSS) g45n1svt w=(2.065u) l=45n nf=1 m=(1)
mp0 (Y A VDD VDD) g45p1svt w=(3.115u) l=45n nf=1 m=(1)
mp1 (Y B VDD VDD) g45p1svt w=(3.115u) l=45n nf=1 m=(1)
mp2 (Y C VDD VDD) g45p1svt w=(3.115u) l=45n nf=1 m=(1)
ends NAND3X8
