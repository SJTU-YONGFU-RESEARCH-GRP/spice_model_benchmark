// gsclib045/ISOHLDX1_ON/schematic

simulator lang=spectre

subckt ISOHLDX1_ON D ISO Q VSS VDD
mn5 (net257 D VSS VSS) g45n1svt w=(145n) l=45n nf=1 m=(1)
mn6 (n0 GNb net257 VSS) g45n1svt w=(145n) l=45n nf=1 m=(1)
mn16 (n0 GNbb net245 VSS) g45n1svt w=(145n) l=45n nf=1 m=(1)
mn15 (net245 Qint VSS VSS) g45n1svt w=(145n) l=45n nf=1 m=(1)
mn21 (Q Qbint VSS VSS) g45n1svt w=(260n) l=45n nf=1 m=(1)
mn0 (GNb ISO VSS VSS) g45n1svt w=(145n) l=45n nf=1 m=(1)
mn1 (GNbb GNb VSS VSS) g45n1svt w=(145n) l=45n nf=1 m=(1)
mn10 (Qint n0 VSS VSS) g45n1svt w=(145n) l=45n nf=1 m=(1)
mn20 (Qbint Qint VSS VSS) g45n1svt w=(260n) l=45n nf=1 m=(1)
mp6 (n0 GNbb net220 VDD) g45p1svt w=(215n) l=45n nf=1 m=(1)
mp5 (net220 D VDD VDD) g45p1svt w=(215n) l=45n nf=1 m=(1)
mp16 (n0 GNb net212 VDD) g45p1svt w=(215n) l=45n nf=1 m=(1)
mp15 (net212 Qint VDD VDD) g45p1svt w=(215n) l=45n nf=1 m=(1)
mp21 (Q Qbint VDD VDD) g45p1svt w=(390n) l=45n nf=1 m=(1)
mp0 (GNb ISO VDD VDD) g45p1svt w=(215n) l=45n nf=1 m=(1)
mp1 (GNbb GNb VDD VDD) g45p1svt w=(215n) l=45n nf=1 m=(1)
mp10 (Qint n0 VDD VDD) g45p1svt w=(215n) l=45n nf=1 m=(1)
mp20 (Qbint Qint VDD VDD) g45p1svt w=(390n) l=45n nf=1 m=(1)
ends ISOHLDX1_ON
