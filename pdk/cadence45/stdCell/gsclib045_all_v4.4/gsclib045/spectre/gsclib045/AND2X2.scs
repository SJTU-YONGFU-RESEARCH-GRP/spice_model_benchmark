// gsclib045/AND2X2/schematic

simulator lang=spectre

subckt AND2X2 A B Y VDD VSS
mn2 (Y n0 VSS VSS) g45n1svt w=(520n) l=45n nf=1 m=(1)
mn0 (net73 A VSS VSS) g45n1svt w=(145n) l=45n nf=1 m=(1)
mn1 (n0 B net73 VSS) g45n1svt w=(145n) l=45n nf=1 m=(1)
mp1 (n0 B VDD VDD) g45p1svt w=(215n) l=45n nf=1 m=(1)
mp0 (n0 A VDD VDD) g45p1svt w=(215n) l=45n nf=1 m=(1)
mp2 (Y n0 VDD VDD) g45p1svt w=(780n) l=45n nf=1 m=(1)
ends AND2X2
