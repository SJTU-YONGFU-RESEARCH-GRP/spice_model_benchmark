// gsclib045/LSHL_ISONH_X1_TO_ON/schematic

simulator lang=spectre

subckt LSHL_ISONH_X1_TO_ON A ISOn Y VSS VDD
NM3 (gatedVSS ISOn VSS VSS) g45n1svt w=(520n) l=45n nf=2 m=(1)
NM0 (Y n0 gatedVSS VSS) g45n1svt w=(260n) l=45n nf=1 m=(1)
mn0 (gatedVSS A n0 VSS) g45n1svt w=(145n) l=45n nf=1 m=(1)
PM4 (Y ISOn VDD VDD) g45p1svt w=(390n) l=45n nf=1 m=(1)
PM0 (Y n0 VDD VDD) g45p1svt w=(390n) l=45n nf=1 m=(1)
mp0 (n0 A VDD VDD) g45p1svt w=(215n) l=45n nf=1 m=(1)
ends LSHL_ISONH_X1_TO_ON
