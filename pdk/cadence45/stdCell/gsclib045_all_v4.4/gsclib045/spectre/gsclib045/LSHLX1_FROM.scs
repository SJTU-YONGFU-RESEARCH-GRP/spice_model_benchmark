// gsclib045/LSHLX1_FROM/schematic

simulator lang=spectre

subckt LSHLX1_FROM A Y VSS VDD ExtVDD
NM0 (Y n0 VSS VSS) g45n1svt w=(260n) l=45n nf=1 m=(1)
mn0 (VSS A n0 VSS) g45n1svt w=(145n) l=45n nf=1 m=(1)
PM0 (Y n0 ExtVDD ExtVDD) g45p1svt w=(390n) l=45n nf=1 m=(1)
mp0 (n0 A ExtVDD ExtVDD) g45p1svt w=(215n) l=45n nf=1 m=(1)
ends LSHLX1_FROM
