// gsclib045/CLKBUFX3/schematic

simulator lang=spectre

subckt CLKBUFX3 A Y VDD VSS
mn1 (Y net44 VSS VSS) g45n1svt w=(780n) l=45n nf=1 m=(1)
mn0 (net44 A VSS VSS) g45n1svt w=(260n) l=45n nf=1 m=(1)
mp1 (Y net44 VDD VDD) g45p1svt w=(1.17u) l=45n nf=1 m=(1)
mp0 (net44 A VDD VDD) g45p1svt w=(390n) l=45n nf=1 m=(1)
ends CLKBUFX3
