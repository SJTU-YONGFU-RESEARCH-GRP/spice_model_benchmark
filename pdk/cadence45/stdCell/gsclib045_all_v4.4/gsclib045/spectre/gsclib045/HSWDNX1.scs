// gsclib045/HSWDNX1/schematic

simulator lang=spectre

subckt HSWDNX1 PSO1n PSO1n_out PSO2n PSO2n_out VSS ExtVDD VDD
PM5 (PSO2n_out n2 ExtVDD ExtVDD) g45p1svt w=(900n) l=45n nf=2 m=(1)
PM2 (n2 PSO2n ExtVDD ExtVDD) g45p1svt w=(450n) l=45n nf=1 m=(1)
PM1 (n1 PSO1n ExtVDD ExtVDD) g45p1svt w=(1.8u) l=45n nf=4 m=(1)
PM6 (PSO1n_out n1 ExtVDD ExtVDD) g45p1svt w=(900n) l=45n nf=2 m=(1)
NM3 (VSS n2 PSO2n_out VSS) g45n1svt w=(600n) l=45n nf=2 m=(1)
NM1 (VSS PSO2n n2 VSS) g45n1svt w=(300n) l=45n nf=1 m=(1)
NM0 (VSS PSO1n n1 VSS) g45n1svt w=(1.2u) l=45n nf=4 m=(1)
NM4 (VSS n1 PSO1n_out VSS) g45n1svt w=(600n) l=45n nf=2 m=(1)
PM3 (VDD n2 ExtVDD ExtVDD) g45p1hvt w=(450n) l=45n nf=1 m=(1)
PM0 (VDD n1 ExtVDD ExtVDD) g45p1hvt w=(1.8u) l=45n nf=4 m=(12)
ends HSWDNX1
