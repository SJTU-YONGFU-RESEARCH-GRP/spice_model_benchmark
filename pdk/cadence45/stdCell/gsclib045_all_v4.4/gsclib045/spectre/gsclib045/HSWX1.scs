// gsclib045/HSWX1/schematic

simulator lang=spectre

subckt HSWX1 PSO PSO_out VDD VSS ExtVDD
PM2 (pson PSO ExtVDD ExtVDD) g45p1svt w=(390n) l=45n nf=1 m=(1)
PM1 (PSO_out pson ExtVDD ExtVDD) g45p1svt w=(390n) l=45n nf=1 m=(1)
mp0 (n0 pson ExtVDD ExtVDD) g45p1svt w=(900n) l=45n nf=2 m=(1)
NM2 (VSS PSO pson VSS) g45n1svt w=(260n) l=45n nf=1 m=(1)
NM0 (VSS pson PSO_out VSS) g45n1svt w=(260n) l=45n nf=1 m=(1)
mn0 (VSS pson n0 VSS) g45n1svt w=(600n) l=45n nf=2 m=(1)
PM0 (VDD n0 ExtVDD ExtVDD) g45p1hvt w=(1.8u) l=45n nf=4 m=(20)
ends HSWX1
