// gsclib045/PBUFX2/schematic

simulator lang=spectre

subckt PBUFX2 A Y VSS ExtVDD VDD
mn1 (VSS n0 Y VSS) g45n1svt w=(520n) l=45n nf=1 m=(1)
mn0 (VSS A n0 VSS) g45n1svt w=(145n) l=45n nf=1 m=(1)
mp1 (Y n0 ExtVDD ExtVDD) g45p1svt w=(780n) l=45n nf=1 m=(1)
mp0 (n0 A ExtVDD ExtVDD) g45p1svt w=(215n) l=45n nf=1 m=(1)
ends PBUFX2
