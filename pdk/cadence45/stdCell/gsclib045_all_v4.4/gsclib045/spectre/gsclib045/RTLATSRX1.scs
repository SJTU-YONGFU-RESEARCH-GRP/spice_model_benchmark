// gsclib045/RTLATSRX1/schematic

simulator lang=spectre

subckt RTLATSRX1 D G Q QN RN RT SN VDD ExtVDD VSS
NM3 (net094 Qint VSS VSS) g45n1svt w=(145n) l=45n nf=1 m=(1)
NM2 (n5g RT net094 VSS) g45n1svt w=(145n) l=45n nf=1 m=(1)
NM0 (n5g RTb n5 VSS) g45n1svt w=(145n) l=45n nf=1 m=(1)
mn45 (RTb RT VSS VSS) g45n1svt w=(145n) l=45n nf=1 m=(1)
mn5 (net191 D VSS VSS) g45n1svt w=(145n) l=45n nf=1 m=(1)
mn6 (n5 Gbb net191 VSS) g45n1svt w=(145n) l=45n nf=1 m=(1)
mn10 (net183 SN VSS VSS) g45n1svt w=(145n) l=45n nf=1 m=(1)
mn11 (Qint n5g net183 VSS) g45n1svt w=(145n) l=45n nf=1 m=(1)
mn17 (n5 Gb net171 VSS) g45n1svt w=(145n) l=45n nf=1 m=(1)
mn16 (net171 Qint net167 VSS) g45n1svt w=(145n) l=45n nf=1 m=(1)
mn15 (net167 RN VSS VSS) g45n1svt w=(145n) l=45n nf=1 m=(1)
mn1 (Gb G net159 VSS) g45n1svt w=(145n) l=45n nf=1 m=(1)
mn0 (net159 RN VSS VSS) g45n1svt w=(145n) l=45n nf=1 m=(1)
mn22 (QN Qint VSS VSS) g45n1svt w=(260n) l=45n nf=1 m=(1)
mn21 (Q Qbint VSS VSS) g45n1svt w=(260n) l=45n nf=1 m=(1)
mn2 (Gbb Gb VSS VSS) g45n1svt w=(145n) l=45n nf=1 m=(1)
mn20 (Qbint Qint VSS VSS) g45n1svt w=(260n) l=45n nf=1 m=(1)
PM3 (n5g RTb net94 ExtVDD) g45p1svt w=(215n) l=45n nf=1 m=(1)
PM2 (net94 Qint ExtVDD ExtVDD) g45p1svt w=(215n) l=45n nf=1 m=(1)
PM0 (n5g RT n5 ExtVDD) g45p1svt w=(215n) l=45n nf=1 m=(1)
mp45 (RTb RT ExtVDD ExtVDD) g45p1svt w=(215n) l=45n nf=1 m=(1)
mp6 (n5 Gb net142 VDD) g45p1svt w=(215n) l=45n nf=1 m=(1)
mp5 (net142 D VDD VDD) g45p1svt w=(215n) l=45n nf=1 m=(1)
mp10 (Qint SN ExtVDD ExtVDD) g45p1svt w=(215n) l=45n nf=1 m=(1)
mp1 (Gb G VDD VDD) g45p1svt w=(215n) l=45n nf=1 m=(1)
mp22 (QN Qint VDD VDD) g45p1svt w=(390n) l=45n nf=1 m=(1)
mp21 (Q Qbint VDD VDD) g45p1svt w=(390n) l=45n nf=1 m=(1)
mp2 (Gbb Gb VDD VDD) g45p1svt w=(215n) l=45n nf=1 m=(1)
mp17 (n5 Gbb net103 VDD) g45p1svt w=(215n) l=45n nf=1 m=(1)
mp16 (net103 Qint VDD VDD) g45p1svt w=(215n) l=45n nf=1 m=(1)
mp15 (net103 RN VDD VDD) g45p1svt w=(215n) l=45n nf=1 m=(1)
mp0 (Gb RN VDD VDD) g45p1svt w=(215n) l=45n nf=1 m=(1)
mp20 (Qbint Qint VDD VDD) g45p1svt w=(390n) l=45n nf=1 m=(1)
mp11 (Qint n5g ExtVDD ExtVDD) g45p1svt w=(215n) l=45n nf=1 m=(1)
ends RTLATSRX1
