// Generated for: spectre (Sep 25 11:22:08 2014 )
// Library name: gsclib045
// Cell name: DECAP2
// View name: schematic

simulator lang=spectre

subckt DECAP2 VSS VDD
mn0 (VSS VDD VSS VSS) g45n1svt w=(255n) l=45n nf=1 as=35.7f ad=35.7f \
        ps=790n pd=790n nrd=549.02m nrs=549.02m sa=140n sb=140n sd=160n \
        sca=146.63643 scb=0.10305 scc=0.01802 m=(1)
mp0 (VDD VSS VDD VDD) g45p1svt w=(445n) l=45n nf=1 as=62.3f ad=62.3f \
        ps=1.17u pd=1.17u nrd=314.607m nrs=314.607m sa=140n sb=140n \
        sd=160n sca=106.82293 scb=0.08585 scc=0.01273 m=(1)
ends DECAP2
// End of subcircuit definition.
