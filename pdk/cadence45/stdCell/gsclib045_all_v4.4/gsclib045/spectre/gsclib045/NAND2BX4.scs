// gsclib045/NAND2BX4/schematic

simulator lang=spectre

subckt NAND2BX4 AN B Y VSS VDD
mn2 (Y B n1 VSS) g45n1svt w=(1.04u) l=45n nf=1 m=(1)
mn0 (n0 AN VSS VSS) g45n1svt w=(260n) l=45n nf=1 m=(1)
mn1 (n1 n0 VSS VSS) g45n1svt w=(1.04u) l=45n nf=1 m=(1)
mp1 (Y n0 VDD VDD) g45p1svt w=(1.56u) l=45n nf=1 m=(1)
mp2 (Y B VDD VDD) g45p1svt w=(1.56u) l=45n nf=1 m=(1)
mp0 (n0 AN VDD VDD) g45p1svt w=(390n) l=45n nf=1 m=(1)
ends NAND2BX4
