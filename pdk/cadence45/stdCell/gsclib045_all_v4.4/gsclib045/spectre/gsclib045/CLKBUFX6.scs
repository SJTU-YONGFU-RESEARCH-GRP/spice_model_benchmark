// gsclib045/CLKBUFX6/schematic

simulator lang=spectre

subckt CLKBUFX6 A Y VSS VDD
mn1 (Y net44 VSS VSS) g45n1svt w=(1.55u) l=45n nf=1 m=(1)
mn0 (net44 A VSS VSS) g45n1svt w=(520n) l=45n nf=1 m=(1)
mp1 (Y net44 VDD VDD) g45p1svt w=(2.35u) l=45n nf=1 m=(1)
mp0 (net44 A VDD VDD) g45p1svt w=(780n) l=45n nf=1 m=(1)
ends CLKBUFX6
