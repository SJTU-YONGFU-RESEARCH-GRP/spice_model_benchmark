// gsclib045/ISOLX1_ON/schematic

simulator lang=spectre

subckt ISOLX1_ON A ISO Y VDD VSS
NM1 (VSS ISO ison VSS) g45n1svt w=(145n) l=45n nf=1 m=(1)
mn2 (Y n0 VSS VSS) g45n1svt w=(260n) l=45n nf=1 m=(1)
mn0 (net127 ison VSS VSS) g45n1svt w=(145n) l=45n nf=1 m=(1)
mn1 (n0 A net127 VSS) g45n1svt w=(145n) l=45n nf=1 m=(1)
PM1 (ison ISO VDD VDD) g45p1svt w=(215n) l=45n nf=1 m=(1)
mp1 (n0 ison VDD VDD) g45p1svt w=(215n) l=45n nf=1 m=(1)
mp0 (n0 A VDD VDD) g45p1svt w=(215n) l=45n nf=1 m=(1)
mp2 (Y n0 VDD VDD) g45p1svt w=(390n) l=45n nf=1 m=(1)
ends ISOLX1_ON
