// gsclib045/HSWDX1/schematic

simulator lang=spectre

subckt HSWDX1 PSO1 PSO1_out PSO2 PSO2_out VDD ExtVDD VSS
PM5 (PSO2_out pso2n ExtVDD ExtVDD) g45p1svt w=(390n) l=45n nf=1 m=(1)
PM2 (n2 pso2n ExtVDD ExtVDD) g45p1svt w=(450n) l=45n nf=1 m=(1)
PM8 (pso1n PSO1 ExtVDD ExtVDD) g45p1svt w=(390n) l=45n nf=1 m=(1)
PM7 (pso2n PSO2 ExtVDD ExtVDD) g45p1svt w=(390n) l=45n nf=1 m=(1)
PM1 (n1 pso1n ExtVDD ExtVDD) g45p1svt w=(1.8u) l=45n nf=4 m=(1)
PM6 (PSO1_out pso1n ExtVDD ExtVDD) g45p1svt w=(390n) l=45n nf=1 m=(1)
NM5 (VSS PSO1 pso1n VSS) g45n1svt w=(260n) l=45n nf=1 m=(1)
NM3 (VSS pso2n PSO2_out VSS) g45n1svt w=(260n) l=45n nf=1 m=(1)
NM1 (VSS pso2n n2 VSS) g45n1svt w=(300n) l=45n nf=1 m=(1)
NM2 (VSS PSO2 pso2n VSS) g45n1svt w=(260n) l=45n nf=1 m=(1)
NM0 (VSS pso1n n1 VSS) g45n1svt w=(1.2u) l=45n nf=4 m=(1)
NM4 (VSS pso1n PSO1_out VSS) g45n1svt w=(260n) l=45n nf=1 m=(1)
PM3 (VDD n2 ExtVDD ExtVDD) g45p1hvt w=(450n) l=45n nf=1 m=(1)
PM0 (VDD n1 ExtVDD ExtVDD) g45p1hvt w=(1.8u) l=45n nf=4 m=(12)
ends HSWDX1
