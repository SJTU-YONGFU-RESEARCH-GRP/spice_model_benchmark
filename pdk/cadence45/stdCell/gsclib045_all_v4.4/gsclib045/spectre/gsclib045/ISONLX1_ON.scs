// gsclib045/ISONLX1_ON/schematic

simulator lang=spectre

subckt ISONLX1_ON A ISOn Y VDD VSS
mn2 (Y n0 VSS VSS) g45n1svt w=(260n) l=45n nf=1 m=(1)
mn0 (net127 ISOn VSS VSS) g45n1svt w=(145n) l=45n nf=1 m=(1)
mn1 (n0 A net127 VSS) g45n1svt w=(145n) l=45n nf=1 m=(1)
mp1 (n0 ISOn VDD VDD) g45p1svt w=(215n) l=45n nf=1 m=(1)
mp0 (n0 A VDD VDD) g45p1svt w=(215n) l=45n nf=1 m=(1)
mp2 (Y n0 VDD VDD) g45p1svt w=(390n) l=45n nf=1 m=(1)
ends ISONLX1_ON
