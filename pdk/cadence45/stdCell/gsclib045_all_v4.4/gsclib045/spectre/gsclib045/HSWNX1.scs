// gsclib045/HSWNX1/schematic

simulator lang=spectre

subckt HSWNX1 PSOn PSOn_out ExtVDD VSS VDD
PM1 (PSOn_out n0 ExtVDD ExtVDD) g45p1svt w=(1.8u) l=45n nf=4 m=(1)
mp0 (n0 PSOn ExtVDD ExtVDD) g45p1svt w=(900n) l=45n nf=2 m=(1)
NM0 (VSS n0 PSOn_out VSS) g45n1svt w=(1.2u) l=45n nf=4 m=(1)
mn0 (VSS PSOn n0 VSS) g45n1svt w=(600n) l=45n nf=2 m=(1)
PM0 (VDD n0 ExtVDD ExtVDD) g45p1hvt w=(1.8u) l=45n nf=4 m=(20)
ends HSWNX1
