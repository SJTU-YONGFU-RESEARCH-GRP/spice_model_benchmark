// gsclib045/RTLATX1/schematic

simulator lang=spectre

subckt RTLATX1 D G Q QN RT VSS VDD ExtVDD
NM3 (net093 Qint VSS VSS) g45n1svt w=(145n) l=45n nf=1 m=(1)
NM2 (n0g RT net093 VSS) g45n1svt w=(145n) l=45n nf=1 m=(1)
mn11 (Qint n0g VSS VSS) g45n1svt w=(145n) l=45n nf=1 m=(1)
NM0 (n0g RTb n0 VSS) g45n1svt w=(145n) l=45n nf=1 m=(1)
mn45 (RTb RT VSS VSS) g45n1svt w=(145n) l=45n nf=1 m=(1)
mn5 (net257 D VSS VSS) g45n1svt w=(145n) l=45n nf=1 m=(1)
mn6 (n0 Gbb net257 VSS) g45n1svt w=(145n) l=45n nf=1 m=(1)
mn16 (net095 Gb net245 VSS) g45n1svt w=(145n) l=45n nf=1 m=(1)
mn15 (net245 Qint VSS VSS) g45n1svt w=(145n) l=45n nf=1 m=(1)
mn22 (QN Qint VSS VSS) g45n1svt w=(260n) l=45n nf=1 m=(1)
mn21 (Q Qbint VSS VSS) g45n1svt w=(260n) l=45n nf=1 m=(1)
mn0 (Gb G VSS VSS) g45n1svt w=(145n) l=45n nf=1 m=(1)
mn20 (Qbint Qint VSS VSS) g45n1svt w=(260n) l=45n nf=1 m=(1)
mn1 (Gbb Gb VSS VSS) g45n1svt w=(145n) l=45n nf=1 m=(1)
PM3 (n0g RTb net145 ExtVDD) g45p1svt w=(215n) l=45n nf=1 m=(1)
PM2 (net145 Qint ExtVDD ExtVDD) g45p1svt w=(215n) l=45n nf=1 m=(1)
mp11 (Qint n0g ExtVDD ExtVDD) g45p1svt w=(215n) l=45n nf=1 m=(1)
PM0 (n0g RT n0 ExtVDD) g45p1svt w=(215n) l=45n nf=1 m=(1)
mp6 (n0 Gb net220 VDD) g45p1svt w=(215n) l=45n nf=1 m=(1)
mp5 (net220 D VDD VDD) g45p1svt w=(215n) l=45n nf=1 m=(1)
mp16 (net095 Gbb net212 VDD) g45p1svt w=(215n) l=45n nf=1 m=(1)
mp15 (net212 Qint VDD VDD) g45p1svt w=(215n) l=45n nf=1 m=(1)
mp22 (QN Qint VDD VDD) g45p1svt w=(390n) l=45n nf=1 m=(1)
mp21 (Q Qbint VDD VDD) g45p1svt w=(390n) l=45n nf=1 m=(1)
mp0 (Gb G VDD VDD) g45p1svt w=(215n) l=45n nf=1 m=(1)
mp1 (Gbb Gb VDD VDD) g45p1svt w=(215n) l=45n nf=1 m=(1)
mp45 (RTb RT ExtVDD ExtVDD) g45p1svt w=(215n) l=45n nf=1 m=(1)
mp20 (Qbint Qint VDD VDD) g45p1svt w=(390n) l=45n nf=1 m=(1)
ends RTLATX1
