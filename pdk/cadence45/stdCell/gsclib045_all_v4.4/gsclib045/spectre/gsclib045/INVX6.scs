// Generated for: spectre (Mar 20 14:08:29 2013 )
// Library name: gsclib045
// Cell name: INVX6
// View name: schematic

simulator lang=spectre

subckt INVX6 A Y VSS VDD
mp0 (Y A VDD VDD) g45p1svt w=(2.35u) l=45n nf=1 as=329f ad=329f ps=4.98u \
        pd=4.98u nrd=59.5745m nrs=59.5745m sa=140n sb=140n sd=160n \
        sca=54.64759 scb=0.05560 scc=0.00670 m=(1)
mn0 (Y A VSS VSS) g45n1svt w=(1.55u) l=45n nf=1 as=217f ad=217f ps=3.38u \
        pd=3.38u nrd=90.3226m nrs=90.3226m sa=140n sb=140n sd=160n \
        sca=61.52026 scb=0.05946 scc=0.00743 m=(1)
ends INVX6
// End of subcircuit definition.
