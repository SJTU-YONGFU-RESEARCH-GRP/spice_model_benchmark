// gsclib045/CLKBUFX8/schematic

simulator lang=spectre

subckt CLKBUFX8 A Y VSS VDD
mn1 (Y net44 VSS VSS) g45n1svt w=(2.065u) l=45n nf=1 m=(1)
mn0 (net44 A VSS VSS) g45n1svt w=(520n) l=45n nf=1 m=(1)
mp1 (Y net44 VDD VDD) g45p1svt w=(3.115u) l=45n nf=1 m=(1)
mp0 (net44 A VDD VDD) g45p1svt w=(780n) l=45n nf=1 m=(1)
ends CLKBUFX8
