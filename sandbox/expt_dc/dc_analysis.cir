* SPICE Model Verification - DC Analysis Testbench
* Based on CHECKLIST.md DC Analysis requirements
* ===================================================

* Simulator settings for accuracy and convergence
.option temp=27 tnom=27
.option gmin=1e-15
.option reltol=1e-8
.option abstol=1e-12
.option chgtol=1e-15
.option method=gear

* Include FreePDK45 model (use absolute path to fix model inclusion)
.inc ./models/ngspice-cmos/FreePDK45/nom.inc

* ===================================================
* 1. DC Operating Point Analysis
* ===================================================

* DC sweep - IV characteristics test circuit
Vds_iv drain_iv 0 DC 0
Vgs_iv gate_iv 0 DC 0
Vs_iv source_iv 0 DC 0
Vb_iv bulk_iv 0 DC 0

* MOSFET device under test - standard 45nm transistor
M1 drain_iv gate_iv source_iv bulk_iv NMOS_VTG L=0.045u W=10u

* Bias point analysis circuit
Vds_bias drain_bias 0 DC 0
Vgs_bias gate_bias 0 DC 0
Vs_bias source_bias 0 DC 0
Vb_bias bulk_bias 0 DC 0

* MOSFET device for bias point analysis
M3 drain_bias gate_bias source_bias bulk_bias NMOS_VTG L=0.045u W=10u

* ===================================================
* 2. Temperature Dependence
* ===================================================

* Temperature sweep test circuit (same as DC sweep circuit)
* Will use M1 for temperature sweep analysis

* ===================================================
* 3. Thermodynamic Analysis
* ===================================================

* Power and energy conservation test circuit
Vdd_therm vdd_therm 0 DC 1.2
Vgs_therm gate_therm 0 PULSE(0 1.2 1n 0.1n 0.1n 5n 10n)

* MOSFET for thermodynamic analysis
M_therm drain_therm gate_therm 0 0 NMOS_VTG L=0.045u W=10u
Rload drain_therm vdd_therm 1k

* ===================================================
* 4. Physical Properties (Monotonicity, Symmetries)
* ===================================================

* Physical properties test circuit (geometry sweep)
Vds_phys drain_phys 0 DC 0
Vgs_phys gate_phys 0 DC 0
Vs_phys source_phys 0 DC 0
Vb_phys bulk_phys 0 DC 0

* Control block
.control
set filetype=ascii
set wr_vecnames
set wr_singlescale
set wr_singleprecision
set wr_formatted

* Create output directory
shell mkdir -p ./output

* ===================================================
* 1. DC Operating Point Analysis
* ===================================================
echo "1. Starting DC Operating Point Analysis"

* Linear scale DC sweep (0V to 1.2V)
echo "Running linear scale I-V sweep"
dc Vds_iv 0 1.2 0.01 Vgs_iv 0 1.2 0.1
let id = i(Vds_iv)
let is = i(Vs_iv)
let ig = i(Vgs_iv)
let ib = i(Vb_iv)
let kcl = abs(id + is + ig + ib)
wrdata ./output/iv_linear.txt v(drain_iv) v(gate_iv) id is ib ig kcl

* Log scale DC sweep for sub-threshold analysis
echo "Running log scale I-V sweep"
dc Vgs_iv 0 1.2 0.01 Vds_iv 0.05 1.2 0.3
let id_log = log10(abs(i(Vds_iv)))
wrdata ./output/iv_log.txt v(gate_iv) v(drain_iv) id_log

* Multi-terminal DC analysis - KCL verification
echo "Running KCL verification"
dc Vds_iv 0 1.2 0.1 Vgs_iv 0 1.2 0.1
let id = i(Vds_iv)
let is = i(Vs_iv)
let ig = i(Vgs_iv)
let ib = i(Vb_iv)
let kcl_error = abs(id + is + ig + ib)
wrdata ./output/kcl_check.txt v(drain_iv) v(gate_iv) id is ib ig kcl_error

* Bias point analysis
echo "Running bias point analysis"

* Define bias points for analysis (need separate variables for each value)
let vds_0 = 0.0
let vds_1 = 0.2
let vds_2 = 0.4
let vds_3 = 0.6
let vds_4 = 0.8
let vds_5 = 1.0
let vds_6 = 1.2

let vgs_0 = 0.0
let vgs_1 = 0.2
let vgs_2 = 0.4
let vgs_3 = 0.6
let vgs_4 = 0.8
let vgs_5 = 1.0
let vgs_6 = 1.2

* Initialize output file
echo "Vds Vgs Id Gm Gds ro" > ./output/bias_point.txt

* Loop through bias points manually (ngspice doesn't support arrays well)
* First row - VDS = 0.0
alter Vds_bias = vds_0
alter Vgs_bias = vgs_0
op
let id_bias = op.i(vds_bias)
let gm = @m3[gm]
let gds = @m3[gds]
let ro = 1/gds
echo "$&vds_0 $&vgs_0 $&id_bias $&gm $&gds $&ro" >> ./output/bias_point.txt

alter Vgs_bias = vgs_1
op
let id_bias = op.i(vds_bias)
let gm = @m3[gm]
let gds = @m3[gds]
let ro = 1/gds
echo "$&vds_0 $&vgs_1 $&id_bias $&gm $&gds $&ro" >> ./output/bias_point.txt

alter Vgs_bias = vgs_6
op
let id_bias = op.i(vds_bias)
let gm = @m3[gm]
let gds = @m3[gds]
let ro = 1/gds
echo "$&vds_0 $&vgs_6 $&id_bias $&gm $&gds $&ro" >> ./output/bias_point.txt

* Last row - VDS = 1.2
alter Vds_bias = vds_6
alter Vgs_bias = vgs_0
op
let id_bias = op.i(vds_bias)
let gm = @m3[gm]
let gds = @m3[gds]
let ro = 1/gds
echo "$&vds_6 $&vgs_0 $&id_bias $&gm $&gds $&ro" >> ./output/bias_point.txt

alter Vgs_bias = vgs_6
op
let id_bias = op.i(vds_bias)
let gm = @m3[gm]
let gds = @m3[gds]
let ro = 1/gds
echo "$&vds_6 $&vgs_6 $&id_bias $&gm $&gds $&ro" >> ./output/bias_point.txt

* ===================================================
* 2. Temperature Dependence
* ===================================================
echo "2. Starting Temperature Dependence Analysis"

* Temperature sweep simulations
* For each temperature point
option temp=-40
echo "Running simulation at temperature: -40 °C"
dc Vds_iv 0 1.2 0.05 Vgs_iv 0.6 1.2 0.1
let id = i(Vds_iv)
let is = i(Vs_iv)
let ig = i(Vgs_iv)
let ib = i(Vb_iv)
let kcl = abs(id + is + ig + ib)
wrdata ./output/iv_temp_n40.txt v(drain_iv) v(gate_iv) id is ib ig kcl

option temp=0
echo "Running simulation at temperature: 0 °C"
dc Vds_iv 0 1.2 0.05 Vgs_iv 0.6 1.2 0.1
let id = i(Vds_iv)
let is = i(Vs_iv)
let ig = i(Vgs_iv)
let ib = i(Vb_iv)
let kcl = abs(id + is + ig + ib)
wrdata ./output/iv_temp_0.txt v(drain_iv) v(gate_iv) id is ib ig kcl

option temp=25
echo "Running simulation at temperature: 25 °C"
dc Vds_iv 0 1.2 0.05 Vgs_iv 0.6 1.2 0.1
let id = i(Vds_iv)
let is = i(Vs_iv)
let ig = i(Vgs_iv)
let ib = i(Vb_iv)
let kcl = abs(id + is + ig + ib)
wrdata ./output/iv_temp_25.txt v(drain_iv) v(gate_iv) id is ib ig kcl

option temp=50
echo "Running simulation at temperature: 50 °C"
dc Vds_iv 0 1.2 0.05 Vgs_iv 0.6 1.2 0.1
let id = i(Vds_iv)
let is = i(Vs_iv)
let ig = i(Vgs_iv)
let ib = i(Vb_iv)
let kcl = abs(id + is + ig + ib)
wrdata ./output/iv_temp_50.txt v(drain_iv) v(gate_iv) id is ib ig kcl

option temp=100
echo "Running simulation at temperature: 100 °C"
dc Vds_iv 0 1.2 0.05 Vgs_iv 0.6 1.2 0.1
let id = i(Vds_iv)
let is = i(Vs_iv)
let ig = i(Vgs_iv)
let ib = i(Vb_iv)
let kcl = abs(id + is + ig + ib)
wrdata ./output/iv_temp_100.txt v(drain_iv) v(gate_iv) id is ib ig kcl

option temp=150
echo "Running simulation at temperature: 150 °C"
dc Vds_iv 0 1.2 0.05 Vgs_iv 0.6 1.2 0.1
let id = i(Vds_iv)
let is = i(Vs_iv)
let ig = i(Vgs_iv)
let ib = i(Vb_iv)
let kcl = abs(id + is + ig + ib)
wrdata ./output/iv_temp_150.txt v(drain_iv) v(gate_iv) id is ib ig kcl

* Temperature coefficient calculation
* Create a file to hold the temperature data
echo "# Current measurements at different temperatures for coefficient calculation" > ./output/temp_current_data.txt
echo "Temperature Gate Drain Current" >> ./output/temp_current_data.txt

* Reference temperature point (25°C)
option temp=25
* Use fixed bias conditions for consistency
dc Vgs_iv 0.8 0.8 0.01 Vds_iv 1.0 1.0 0.01
* Get current measurement at 25°C
let id_25c = i(Vds_iv)
* Store in file
echo "25 0.8 1.0 $&id_25c" >> ./output/temp_current_data.txt

* High temperature point (125°C)
option temp=125
* Use same bias conditions
dc Vgs_iv 0.8 0.8 0.01 Vds_iv 1.0 1.0 0.01
* Get current measurement at 125°C
let id_125c = i(Vds_iv)
* Store in file
echo "125 0.8 1.0 $&id_125c" >> ./output/temp_current_data.txt

* Calculate temperature coefficient directly
let delta_id = id_125c - id_25c
let delta_temp = 100.0
let tc = delta_id / delta_temp
* Store in regular output files for backward compatibility
echo "Temperature coefficient: $&tc A/°C" > ./output/temp_coeff.txt
echo "$&tc" > ./output/temp_coeff_value.txt

* ===================================================
* 3. Thermodynamic Analysis
* ===================================================
echo "3. Starting Thermodynamic Analysis"

* Energy conservation verification
option temp=27
dc Vdd_therm 0 1.2 0.1 Vgs_therm 0 1.2 0.1
let id_therm = i(vdd_therm)
let power = v(vdd_therm) * id_therm
let efficiency = abs(v(drain_therm) * i(vdd_therm)) / (v(vdd_therm) * i(vdd_therm) + 1e-15)
wrdata ./output/power_analysis.txt v(vdd_therm) v(gate_therm) id_therm power efficiency

* Power temperature coefficient - Use a simpler direct approach
* First, clear the output files
echo "# Power calculation at 25C and 125C for temperature coefficient" > ./output/power_temp_data.txt
echo "Temperature Current Voltage Power" >> ./output/power_temp_data.txt

* Run operating point analysis at 25°C with fixed bias
option temp=25
* Set a known bias condition
alter Vdd_therm = 1.2
alter Vgs_therm = 1.2
* Use a simple DC sweep instead of op to ensure vector availability
dc Vgs_therm 1.2 1.2 0.1
* Calculate values directly
let i_25c = i(vdd_therm)
let v_25c = v(drain_therm)
let p_25c = abs(i_25c * v_25c)
* Output directly to file
echo "25 $&i_25c $&v_25c $&p_25c" >> ./output/power_temp_data.txt

* Repeat for 125°C temperature
option temp=125
* Use same bias point
dc Vgs_therm 1.2 1.2 0.1
* Calculate values directly
let i_125c = i(vdd_therm)
let v_125c = v(drain_therm)
let p_125c = abs(i_125c * v_125c)
* Output directly to file
echo "125 $&i_125c $&v_125c $&p_125c" >> ./output/power_temp_data.txt

* Calculate power temperature coefficient
let power_diff = p_125c - p_25c
let temp_diff = 100.0
let power_ratio = power_diff / (abs(p_25c) + 1e-12)
let p_tc = power_ratio / temp_diff
echo "# Power temperature coefficient" > ./output/power_temp_coeff.txt
echo "# Power at 25°C: $&p_25c W" >> ./output/power_temp_coeff.txt
echo "# Power at 125°C: $&p_125c W" >> ./output/power_temp_coeff.txt
echo "# Coefficient: $&p_tc /°C" >> ./output/power_temp_coeff.txt
echo "$&p_tc" > ./output/power_temp_coeff_value.txt

* ===================================================
* 4. Physical Properties
* ===================================================
echo "4. Checking Physical Properties"

* Monotonicity check
dc Vgs_phys 0 1.2 0.01
let id_mono = i(Vds_phys)
let diff_id = deriv(id_mono)
wrdata ./output/monotonicity.txt v(gate_phys) id_mono diff_id

* Check for physical symmetries
echo "Testing physical symmetries"

* Parameter sweep - vary geometry manually rather than with arrays
echo "W L Id Gm Gds" > ./output/param_sweep.txt

* Fix bias point
alter Vds_phys = 1.0
alter Vgs_phys = 0.8

* W=1.0, L=0.045
alter @m1[w] = 1.0
alter @m1[l] = 0.045u
op
let id_geom = op.i(vds_phys)
let gm_geom = @m1[gm]
let gds_geom = @m1[gds]
echo "1.0 0.045 $&id_geom $&gm_geom $&gds_geom" >> ./output/param_sweep.txt

* W=5.0, L=0.045
alter @m1[w] = 5.0
alter @m1[l] = 0.045u
op
let id_geom = op.i(vds_phys)
let gm_geom = @m1[gm]
let gds_geom = @m1[gds]
echo "5.0 0.045 $&id_geom $&gm_geom $&gds_geom" >> ./output/param_sweep.txt

* W=10.0, L=0.045
alter @m1[w] = 10.0
alter @m1[l] = 0.045u
op
let id_geom = op.i(vds_phys)
let gm_geom = @m1[gm]
let gds_geom = @m1[gds]
echo "10.0 0.045 $&id_geom $&gm_geom $&gds_geom" >> ./output/param_sweep.txt

* W=10.0, L=0.09
alter @m1[w] = 10.0
alter @m1[l] = 0.09u
op
let id_geom = op.i(vds_phys)
let gm_geom = @m1[gm]
let gds_geom = @m1[gds]
echo "10.0 0.09 $&id_geom $&gm_geom $&gds_geom" >> ./output/param_sweep.txt

* W=10.0, L=0.18
alter @m1[w] = 10.0
alter @m1[l] = 0.18u
op
let id_geom = op.i(vds_phys)
let gm_geom = @m1[gm]
let gds_geom = @m1[gds]
echo "10.0 0.18 $&id_geom $&gm_geom $&gds_geom" >> ./output/param_sweep.txt

* Terminal permutation tests
echo "Terminal permutation tests"

* Create the output file with header
echo "# Terminal symmetry test data" > ./output/terminal_symmetry.txt
echo "# Tests if swapping drain and source leads to the same behavior" >> ./output/terminal_symmetry.txt
echo "# Vgs id_normal id_reversed id_diff" >> ./output/terminal_symmetry.txt

* Fix width and length for consistent measurements
alter @m1[w] = 10.0
alter @m1[l] = 0.045u

* Loop through gate voltages and measure terminal symmetry
* Gate voltage = 0.2V
alter Vgs_phys = 0.2
* Forward bias (normal configuration)
alter Vds_phys = 0.1
dc Vgs_phys 0.2 0.2 1
let id_normal = i(vds_phys)
* Reverse bias (swapped drain/source)
alter Vds_phys = -0.1
dc Vgs_phys 0.2 0.2 1
let id_reversed = -i(vds_phys)
* Calculate and store difference
let id_diff = id_normal - id_reversed
echo "0.2 $&id_normal $&id_reversed $&id_diff" >> ./output/terminal_symmetry.txt

* Gate voltage = 0.4V
alter Vgs_phys = 0.4
* Forward bias
alter Vds_phys = 0.1
dc Vgs_phys 0.4 0.4 1
let id_normal = i(vds_phys)
* Reverse bias
alter Vds_phys = -0.1
dc Vgs_phys 0.4 0.4 1
let id_reversed = -i(vds_phys)
* Calculate and store difference
let id_diff = id_normal - id_reversed
echo "0.4 $&id_normal $&id_reversed $&id_diff" >> ./output/terminal_symmetry.txt

* Gate voltage = 0.6V
alter Vgs_phys = 0.6
* Forward bias
alter Vds_phys = 0.1
dc Vgs_phys 0.6 0.6 1
let id_normal = i(vds_phys)
* Reverse bias
alter Vds_phys = -0.1
dc Vgs_phys 0.6 0.6 1
let id_reversed = -i(vds_phys)
* Calculate and store difference
let id_diff = id_normal - id_reversed
echo "0.6 $&id_normal $&id_reversed $&id_diff" >> ./output/terminal_symmetry.txt

* Gate voltage = 0.8V
alter Vgs_phys = 0.8
* Forward bias
alter Vds_phys = 0.1
dc Vgs_phys 0.8 0.8 1
let id_normal = i(vds_phys)
* Reverse bias
alter Vds_phys = -0.1
dc Vgs_phys 0.8 0.8 1
let id_reversed = -i(vds_phys)
* Calculate and store difference
let id_diff = id_normal - id_reversed
echo "0.8 $&id_normal $&id_reversed $&id_diff" >> ./output/terminal_symmetry.txt

* Gate voltage = 1.0V
alter Vgs_phys = 1.0
* Forward bias
alter Vds_phys = 0.1
dc Vgs_phys 1.0 1.0 1
let id_normal = i(vds_phys)
* Reverse bias
alter Vds_phys = -0.1
dc Vgs_phys 1.0 1.0 1
let id_reversed = -i(vds_phys)
* Calculate and store difference
let id_diff = id_normal - id_reversed
echo "1.0 $&id_normal $&id_reversed $&id_diff" >> ./output/terminal_symmetry.txt

* Gate voltage = 1.2V
alter Vgs_phys = 1.2
* Forward bias
alter Vds_phys = 0.1
dc Vgs_phys 1.2 1.2 1
let id_normal = i(vds_phys)
* Reverse bias
alter Vds_phys = -0.1
dc Vgs_phys 1.2 1.2 1
let id_reversed = -i(vds_phys)
* Calculate and store difference
let id_diff = id_normal - id_reversed
echo "1.2 $&id_normal $&id_reversed $&id_diff" >> ./output/terminal_symmetry.txt

* Cross-derivative analysis - Fix implementation
* Testing the symmetry of cross-derivatives (e.g., dgm/dVds = dgds/dVgs)
echo "Vgs Vds dgm_dvds dgds_dvgs cross_diff" > ./output/cross_derivative.txt

* Ensure we use a stronger bias point to get meaningful transconductance
alter @m1[w] = 10.0
alter @m1[l] = 0.045u
alter Vds_phys = 0.5
alter Vgs_phys = 0.8
op
let gm1 = @m1[gm]
let gds1 = @m1[gds]
print gm1
print gds1

* Calculate dgm/dVds - Take a larger step for numerical stability
alter Vds_phys = 0.7
op
let gm2 = @m1[gm]
let dgm_dvds = (gm2 - gm1) / 0.2
print dgm_dvds

* Calculate dgds/dVgs
alter Vds_phys = 0.5
alter Vgs_phys = 1.0
op
let gds2 = @m1[gds]
let dgds_dvgs = (gds2 - gds1) / 0.2
print dgds_dvgs

* Calculate difference
let cross_diff = abs(dgm_dvds - dgds_dvgs)
print cross_diff
echo "0.8 0.5 $&dgm_dvds $&dgds_dvgs $&cross_diff" >> ./output/cross_derivative.txt

* Additional physical symmetry tests - Current symmetry with better implementation
echo "Vgs id_positive id_negative symmetry_error" > ./output/current_symmetry_sweep.txt

* Set up bias conditions - Use larger values for more reliable results
alter @m1[w] = 10.0
alter @m1[l] = 0.045u

* Perform the sweep for both positive and negative drain bias
* Generate a single data file with multiple gate voltages
echo "0.0 0.0 0.0 0.0" >> ./output/current_symmetry_sweep.txt

* VGS = 0.2V
alter Vds_phys = 0.5
alter Vgs_phys = 0.2
op
let id_pos = i(vds_phys)
alter Vds_phys = -0.5
op
let id_neg = -i(vds_phys)
let sym_err = abs((id_pos - id_neg)/(max(abs(id_pos), abs(id_neg)) + 1e-12)*100)
echo "0.2 $&id_pos $&id_neg $&sym_err" >> ./output/current_symmetry_sweep.txt

* VGS = 0.4V
alter Vds_phys = 0.5
alter Vgs_phys = 0.4
op
let id_pos = i(vds_phys)
alter Vds_phys = -0.5
op
let id_neg = -i(vds_phys)
let sym_err = abs((id_pos - id_neg)/(max(abs(id_pos), abs(id_neg)) + 1e-12)*100)
echo "0.4 $&id_pos $&id_neg $&sym_err" >> ./output/current_symmetry_sweep.txt

* VGS = 0.6V
alter Vds_phys = 0.5
alter Vgs_phys = 0.6
op
let id_pos = i(vds_phys)
alter Vds_phys = -0.5
op
let id_neg = -i(vds_phys)
let sym_err = abs((id_pos - id_neg)/(max(abs(id_pos), abs(id_neg)) + 1e-12)*100)
echo "0.6 $&id_pos $&id_neg $&sym_err" >> ./output/current_symmetry_sweep.txt

* VGS = 0.8V
alter Vds_phys = 0.5
alter Vgs_phys = 0.8
op
let id_pos = i(vds_phys)
alter Vds_phys = -0.5
op
let id_neg = -i(vds_phys)
let sym_err = abs((id_pos - id_neg)/(max(abs(id_pos), abs(id_neg)) + 1e-12)*100)
echo "0.8 $&id_pos $&id_neg $&sym_err" >> ./output/current_symmetry_sweep.txt

* VGS = 1.0V
alter Vds_phys = 0.5
alter Vgs_phys = 1.0
op
let id_pos = i(vds_phys)
alter Vds_phys = -0.5
op
let id_neg = -i(vds_phys)
let sym_err = abs((id_pos - id_neg)/(max(abs(id_pos), abs(id_neg)) + 1e-12)*100)
echo "1.0 $&id_pos $&id_neg $&sym_err" >> ./output/current_symmetry_sweep.txt

* VGS = 1.2V
alter Vds_phys = 0.5
alter Vgs_phys = 1.2
op
let id_pos = i(vds_phys)
alter Vds_phys = -0.5
op
let id_neg = -i(vds_phys)
let sym_err = abs((id_pos - id_neg)/(max(abs(id_pos), abs(id_neg)) + 1e-12)*100)
echo "1.2 $&id_pos $&id_neg $&sym_err" >> ./output/current_symmetry_sweep.txt

* Make sure we also create a proper current_symmetry.txt file
echo "Vgs id_normal id_positive id_negative symmetry_error" > ./output/current_symmetry.txt
echo "0.8 $&id_pos $&id_pos $&id_neg $&sym_err" >> ./output/current_symmetry.txt

* Complete simulation
echo "DC analysis testbench completed successfully"
quit
.endc

.end
