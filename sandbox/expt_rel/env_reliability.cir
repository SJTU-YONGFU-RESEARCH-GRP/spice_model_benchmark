* MOSFET Environmental and Reliability Analysis Simulation
.option temp=27 tnom=27
.option gmin=1e-15
.option reltol=1e-8
.option abstol=1e-12
.option chgtol=1e-15
.option method=gear
.option TEMPSCALE=1.0

* Include FreePDK45 model
* Make sure the path to the model file is correct
.inc ../models/ngspice-cmos/FreePDK45/nom.inc

* In case of path issues, you might need to use an absolute path like:
* .inc /home/yongfu/proj/spice_model_benchmark/models/ngspice-cmos/FreePDK45/nom.inc

* Temperature and Thermal Analysis Circuit
Vds_temp drain_temp 0 DC 1.0
Vgs_temp gate_temp 0 DC 1.0
Vs_temp source_temp 0 DC 0
Vb_temp bulk_temp 0 DC 0

* MOSFET device under test - standard 45nm transistor
M1 drain_temp gate_temp source_temp bulk_temp NMOS_VTG L=0.045u W=10u

* Process and Statistical Analysis Circuit
* Monte Carlo devices with different parameters
Vds_mc drain_mc 0 DC 1.0
Vgs_mc gate_mc 0 DC 1.0
Vs_mc source_mc 0 DC 0
Vb_mc bulk_mc 0 DC 0

* MOSFET device for Monte Carlo analysis
M2 drain_mc gate_mc source_mc bulk_mc NMOS_VTG L=0.045u W=10u

* Process corners - typical device
Vds_tt drain_tt 0 DC 1.0
Vgs_tt gate_tt 0 DC 1.0
Vs_tt source_tt 0 DC 0
Vb_tt bulk_tt 0 DC 0
M3 drain_tt gate_tt source_tt bulk_tt NMOS_VTG L=0.045u W=10u

* Reliability and Aging Analysis Circuit
* Transistor with aging effects
Vds_rel drain_rel 0 DC 1.0
Vgs_rel gate_rel 0 DC 1.0
Vs_rel source_rel 0 DC 0
Vb_rel bulk_rel 0 DC 0

* MOSFET device for reliability testing
M4 drain_rel gate_rel source_rel bulk_rel NMOS_VTG L=0.045u W=10u

* Control block
.control
set filetype=ascii
set wr_vecnames
set wr_singlescale
set wr_singleprecision
set wr_formatted

* =============================================
* Temperature and Thermal Analysis
* =============================================
echo "Starting Temperature and Thermal Analysis"

* Thermal Analysis Sweep
let temp_points = (-40 0 25 50 75 100 125 150)
let num_temp_points = length(temp_points)

* Prepare file for thermal analysis
echo "Vgs Vds Temperature Id Power" > ./thermal_analysis.txt

* Thermal sweep with multiple bias points
let vgs_values = (0.6 0.8 1.0 1.2)
let vds_values = (0.6 0.8 1.0 1.2)

let i = 0
while i < length(vgs_values)
    let j = 0
    while j < length(vds_values)
        * Set bias voltages
        alter Vgs_temp = vgs_values[i]
        alter Vds_temp = vds_values[j]

        * Sweep over temperatures
        let k = 0
        while k < num_temp_points
            * Set temperature
            option temp = temp_points[k]

            * Run operating point analysis
            op

            * Calculate and save current and power
            let id_temp = i(Vds_temp)
            let power_temp = id_temp * v(drain_temp)

            * Write data to file (Vgs, Vds, Temperature, Id, Power)
            echo "$&vgs_values[i] $&vds_values[j] $&temp_points[k] $&id_temp $&power_temp" >> ./thermal_analysis.txt

            let k = k + 1
        end
        let j = j + 1
    end
    let i = i + 1
end

* Frequency-dependent thermal analysis at room temperature
option temp = 27
alter Vgs_temp = 1.0
alter Vds_temp = 1.0

* AC analysis to estimate thermal frequency response
echo "Frequency Thermal_impedance" > ./thermal_freq.txt
ac dec 10 1 1G
let zth_max = 0
meas ac zth_max max mag(v(drain_temp)/i(Vds_temp)) from=1 to=1G
let f_thermal = 0
meas ac f_thermal find frequency when mag(v(drain_temp)/i(Vds_temp))=zth_max/sqrt(2) fall=1
let thermal_z = mag(v(drain_temp)/i(Vds_temp))
* Make sure the file is written with proper column headers
echo "frequency thermal_z" > ./thermal_freq_data.txt
write ./thermal_freq_data.txt frequency thermal_z

* =============================================
* Process and Statistical Analysis
* =============================================
echo "Starting Process and Statistical Analysis"

* Reset temperature to nominal
option temp = 27

* Process Corner Analysis
echo "Corner Vgs Vds Id Gm Rout" > ./process_corners.txt

* Define corners we need to simulate
* We'll use built-in .alter blocks to simulate different process corners

* Typical corner (TT) - already defined above
op
let id_tt = i(Vds_tt)
let gm_tt = @m3[gm]
let rout_tt = 1/(@m3[gds])
echo "TT 1.0 1.0 $&id_tt $&gm_tt $&rout_tt" >> ./process_corners.txt

* Fast corner (FF) - We'll simulate with decreased Vth and increased mobility
altermod @m3[vth0] = @m3[vth0] * 0.9
altermod @m3[kp] = @m3[kp] * 1.1
op
let id_ff = i(Vds_tt)
let gm_ff = @m3[gm]
let rout_ff = 1/(@m3[gds])
echo "FF 1.0 1.0 $&id_ff $&gm_ff $&rout_ff" >> ./process_corners.txt

* Slow corner (SS) - We'll simulate with increased Vth and decreased mobility
altermod @m3[vth0] = @m3[vth0] * 1.2
altermod @m3[kp] = @m3[kp] * 0.8
op
let id_ss = i(Vds_tt)
let gm_ss = @m3[gm]
let rout_ss = 1/(@m3[gds])
echo "SS 1.0 1.0 $&id_ss $&gm_ss $&rout_ss" >> ./process_corners.txt

* Reset model parameters to nominal
altermod @m3[vth0] = @m3[vth0]/1.2*0.9
altermod @m3[kp] = @m3[kp]/0.8*1.1

* Fast NMOS, Slow PMOS (FS) - Since we only have NMOS, simulate as fast NMOS
altermod @m3[vth0] = @m3[vth0] * 0.9
altermod @m3[kp] = @m3[kp] * 1.1
op
let id_fs = i(Vds_tt)
let gm_fs = @m3[gm]
let rout_fs = 1/(@m3[gds])
echo "FS 1.0 1.0 $&id_fs $&gm_fs $&rout_fs" >> ./process_corners.txt

* Slow NMOS, Fast PMOS (SF) - Since we only have NMOS, simulate as slow NMOS
altermod @m3[vth0] = @m3[vth0] * 1.2
altermod @m3[kp] = @m3[kp] * 0.8
op
let id_sf = i(Vds_tt)
let gm_sf = @m3[gm]
let rout_sf = 1/(@m3[gds])
echo "SF 1.0 1.0 $&id_sf $&gm_sf $&rout_sf" >> ./process_corners.txt

* Reset model parameters to nominal
altermod @m3[vth0] = @m3[vth0]/1.2*0.9
altermod @m3[kp] = @m3[kp]/0.8*1.1

* Monte Carlo Analysis
echo "Run Vgs Vds L W Vth Mobility Id Gm" > ./monte_carlo.txt

* Perform Monte Carlo analysis by varying parameters
* We'll simulate 50 runs with parameter variations
let mc_runs = 50
let run_num = 1

* Set nominal values
let nom_vth0 = @m2[vth0]
let nom_kp = @m2[kp]
let nom_l = 0.045e-6
let nom_w = 10e-6

* Define variability (percentage of nominal value)
let vth_var = 0.1  * nom_vth0  * 1
let kp_var  = 0.1  * nom_kp    * 1
let l_var   = 0.05 * nom_l     * 1
let w_var   = 0.05 * nom_w     * 1

* Randomize seed for random number generation
set rndseed = 123

while run_num <= mc_runs
    * Generate random variations with gaussian distribution
    let l_rand  = (gauss(0,1) * l_var) + nom_l
    let w_rand  = (gauss(0,1) * w_var) + nom_w
    let vth_rand = (gauss(0,1) * vth_var) + nom_vth0
    let kp_rand  = (gauss(0,1) * kp_var) + nom_kp

    * Apply random variations to device
    altermod @m2[l] = l_rand
    altermod @m2[w] = w_rand
    altermod @m2[vth0] = vth_rand
    altermod @m2[kp] = kp_rand

    * Run simulation
    op

    * Get results
    let id_mc = i(Vds_mc)
    let gm_mc = @m2[gm]

    * Write Monte Carlo data
    echo "$&run_num 1.0 1.0 $&l_rand $&w_rand $&vth_rand $&kp_rand $&id_mc $&gm_mc" >> ./monte_carlo.txt

    let run_num = run_num + 1
end

* =============================================
* Reliability and Aging Analysis
* =============================================
echo "Starting Reliability and Aging Analysis"

* Aging analysis - directly simulate discrete Vth shifts
echo "Vth_shift Vgs Vds Id Gm Rout" > ./aging_analysis.txt

* Nominal values
op
let nom_vth0 = 0.5  * Approximate nominal Vth for NMOS
let nom_id = i(Vds_rel)

* Define discrete Vth shifts to simulate
let vth_shift1 = 0.0
let vth_shift2 = 0.01
let vth_shift3 = 0.02
let vth_shift4 = 0.03
let vth_shift5 = 0.05
let vth_shift6 = 0.07
let vth_shift7 = 0.1
let vth_shift8 = 0.15

* Use parameter = x in .model NMOS NMOS level=1 vto=x to apply shifting

* Run simulation for each Vth shift
* No shift (0.0V)
op
let id_aged = i(Vds_rel)
let gm_aged = @m4[gm]
let rout_aged = 1/(@m4[gds])
echo "0.0 1.0 1.0 $&id_aged $&gm_aged $&rout_aged" >> ./aging_analysis.txt

* 0.01V Vth shift
altermod @m4[vth0] = 0.51
op
let id_aged = i(Vds_rel)
let gm_aged = @m4[gm]
let rout_aged = 1/(@m4[gds])
echo "0.01 1.0 1.0 $&id_aged $&gm_aged $&rout_aged" >> ./aging_analysis.txt

* 0.02V Vth shift
altermod @m4[vth0] = 0.52
op
let id_aged = i(Vds_rel)
let gm_aged = @m4[gm]
let rout_aged = 1/(@m4[gds])
echo "0.02 1.0 1.0 $&id_aged $&gm_aged $&rout_aged" >> ./aging_analysis.txt

* 0.03V Vth shift
altermod @m4[vth0] = 0.53
op
let id_aged = i(Vds_rel)
let gm_aged = @m4[gm]
let rout_aged = 1/(@m4[gds])
echo "0.03 1.0 1.0 $&id_aged $&gm_aged $&rout_aged" >> ./aging_analysis.txt

* 0.05V Vth shift
altermod @m4[vth0] = 0.55
op
let id_aged = i(Vds_rel)
let gm_aged = @m4[gm]
let rout_aged = 1/(@m4[gds])
echo "0.05 1.0 1.0 $&id_aged $&gm_aged $&rout_aged" >> ./aging_analysis.txt

* 0.07V Vth shift
altermod @m4[vth0] = 0.57
op
let id_aged = i(Vds_rel)
let gm_aged = @m4[gm]
let rout_aged = 1/(@m4[gds])
echo "0.07 1.0 1.0 $&id_aged $&gm_aged $&rout_aged" >> ./aging_analysis.txt

* 0.10V Vth shift
altermod @m4[vth0] = 0.60
op
let id_aged = i(Vds_rel)
let gm_aged = @m4[gm]
let rout_aged = 1/(@m4[gds])
echo "0.10 1.0 1.0 $&id_aged $&gm_aged $&rout_aged" >> ./aging_analysis.txt

* 0.15V Vth shift
altermod @m4[vth0] = 0.65
op
let id_aged = i(Vds_rel)
let gm_aged = @m4[gm]
let rout_aged = 1/(@m4[gds])
echo "0.15 1.0 1.0 $&id_aged $&gm_aged $&rout_aged" >> ./aging_analysis.txt

* Stress Test Simulation
echo "Stress_level Vgs Vds Temperature Stress_time Id_degradation" > ./stress_test.txt

* Simulate different stress levels
* Level 1 - Low stress
alter Vgs_rel = 1.0
alter Vds_rel = 1.0
option temp = 25
op
let id_fresh1 = i(Vds_rel)

* Apply degradation (simplified model)
altermod @m4[vth0] = 0.52  * 0.02V shift for 1000 hours
op
let id_stressed1 = i(Vds_rel)
let degradation1 = (id_fresh1 - id_stressed1)/id_fresh1 * 100
echo "1 1.0 1.0 25 1000 $&degradation1" >> ./stress_test.txt

* Level 2 - Medium stress
alter Vgs_rel = 1.1
alter Vds_rel = 1.1
option temp = 85
op
let id_fresh2 = i(Vds_rel)

* Apply degradation (simplified model)
altermod @m4[vth0] = 0.55  * 0.05V shift for 1000 hours
op
let id_stressed2 = i(Vds_rel)
let degradation2 = (id_fresh2 - id_stressed2)/id_fresh2 * 100
echo "2 1.1 1.1 85 1000 $&degradation2" >> ./stress_test.txt

* Level 3 - High stress
alter Vgs_rel = 1.2
alter Vds_rel = 1.2
option temp = 125
op
let id_fresh3 = i(Vds_rel)

* Apply degradation (simplified model)
altermod @m4[vth0] = 0.60  * 0.1V shift for 1000 hours
op
let id_stressed3 = i(Vds_rel)
let degradation3 = (id_fresh3 - id_stressed3)/id_fresh3 * 100
echo "3 1.2 1.2 125 1000 $&degradation3" >> ./stress_test.txt

echo "Environmental and Reliability Analysis Completed Successfully"
quit
.endc

.end
