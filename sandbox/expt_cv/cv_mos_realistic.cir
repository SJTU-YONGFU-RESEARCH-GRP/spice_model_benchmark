* MOSFET CV Analysis - Complete SPICE Simulation
* This simulation performs a comprehensive bias sweep with multiple AC analyses
* to generate complete CV characteristics including all MOS operation regions

* NOTE ON MULTIFREQUENCY DATA: In the current simulation, the capacitance values
* for different frequencies (10kHz, 100kHz, 1MHz) are identical. This is
* a limitation of the current simulation approach. The plotting script (plot_cv_curves.py)
* implements a physics-based model to show realistic frequency-dependent behavior.
* To get true frequency-dependent CV curves, a more detailed SPICE model with
* better trap and carrier dynamics modeling would be needed.

.option temp=27 tnom=27
.option gmin=1e-15
.option reltol=1e-8
.option abstol=1e-12
.option chgtol=1e-15
.option method=gear

* Include FreePDK45 model with appropriate parameters
.inc ../../models/FreePDK45/nom.inc

* Enhanced test circuit for capacitance measurements
* Use small signal AC analysis to extract capacitance components
* Configure for operation in different regions (accumulation, depletion, inversion)

* Gate voltage source with AC component for small-signal analysis
VG gate 0 DC 0 AC 1
* Drain bias at VDD (typical operation voltage)
VD drain 0 DC 1.2
* Source and bulk connections tied to ground
VS source 0 DC 0
VB bulk 0 DC 0

* MOSFET device under test - standard 45nm transistor
* Using parameters from the FreePDK45 model
M1 drain gate source bulk NMOS_VTG L=0.045u W=10u

.control
* Output format configuration
set filetype=ascii
set wr_vecnames=yes
set wr_singlescale=yes
set numdgt=10

* Create log file
echo "** MOSFET CV Characteristic Simulation **" > ./results/cv_sim.log

* Set up gate voltage sweep parameters
let vg_start = -0.8   ; Start accumulation region
let vg_stop = 1.201   ; End strong inversion (slightly > 1.2 to ensure inclusion)
let vg_step = 0.05    ; Small step size for smooth curve
let num_points = floor((vg_stop - vg_start)/vg_step) + 1
echo "Gate voltage sweep from $&vg_start V to $&vg_stop V, $&num_points points" >> ./results/cv_sim.log

* Create output file with header
echo "Vg Cgg_1kHz Cgg_10kHz Cgg_100kHz Cgg_1MHz Cgb_1MHz Cgs_1MHz Cgd_1MHz" > ./results/cv_full_data.txt

* Perform gate voltage sweep with measurements at each bias point
let vg_bias = vg_start
while vg_bias <= vg_stop
    * Set gate bias
    alter VG = vg_bias

    * Run AC analysis at multiple frequencies
    * 1kHz (low frequency response)
    ac lin 1 1k 1k
    let cgg_1k_vec = -imag(i(VG))/(2*3.14159*1e3)
    set cgg_1k = $&cgg_1k_vec

    * 10kHz
    ac lin 1 10k 10k
    let cgg_10k_vec = -imag(i(VG))/(2*3.14159*1e4)
    set cgg_10k = $&cgg_10k_vec

    * 100kHz
    ac lin 1 100k 100k
    let cgg_100k_vec = -imag(i(VG))/(2*3.14159*1e5)
    set cgg_100k = $&cgg_100k_vec

    * 1MHz (standard frequency for CV measurements)
    ac lin 1 1meg 1meg
    let cgg_1m_vec = -imag(i(VG))/(2*3.14159*1e6)
    set cgg_1m = $&cgg_1m_vec

    * Calculate individual capacitance components at 1MHz
    * These help identify the behavior in different regions
    let cgb_1m_vec = abs(imag(v(gate,bulk)/i(VG)))/(2*3.14159*1e6)
    set cgb_1m = $&cgb_1m_vec
    let cgs_1m_vec = abs(imag(v(gate,source)/i(VG)))/(2*3.14159*1e6)
    set cgs_1m = $&cgs_1m_vec
    let cgd_1m_vec = abs(imag(v(gate,drain)/i(VG)))/(2*3.14159*1e6)
    set cgd_1m = $&cgd_1m_vec

    * Print results
    echo "$&vg_bias $cgg_1k $cgg_10k $cgg_100k $cgg_1m $cgb_1m $cgs_1m $cgd_1m" >> ./results/cv_full_data.txt

    * Log progress
    echo "VG = $&vg_bias V: Cgg(1MHz) = $cgg_1m F" >> ./results/cv_sim.log

    * Increment gate voltage
    let vg_bias = vg_bias + vg_step
end

echo "CV simulation completed successfully" >> ./results/cv_sim.log
echo "CV simulation completed."
quit
.endc

.end
