* MOSFET Noise Analysis Simulation
.option temp=27 tnom=27
.option gmin=1e-15
.option reltol=1e-8
.option abstol=1e-12
.option chgtol=1e-15
.option method=gear
.option TEMPSCALE=1.0

* Include FreePDK45 model
.inc ./models/ngspice-cmos/FreePDK45/nom.inc

* Thermal Noise Analysis Circuit - Common source amplifier configuration
* Supply voltage
Vdd vdd 0 DC 1.2

* Biasing setup for thermal noise
Vin in 0 DC 0.6 AC 1
Rb in gate 1k      ; Bias resistor (blocks DC)
Cb in gate 1u      ; Coupling capacitor (passes AC)
Rs source 0 100    ; Source resistor for stability

* Drain and gate bias
Rd vdd drain 10k   ; Drain resistor - load
Vgs gate source DC 0 ; Initial gate-source voltage (will be altered)
Vds drain source DC 0 ; Initial drain-source voltage (will be altered)
Vbulk bulk 0 DC 0   ; Bulk/substrate connection

* MOSFET device under test
M1 drain gate source bulk NMOS_VTG L=0.045u W=10u

* Noise Source Circuit - Separate circuit for flicker noise characterization
* Voltage and current sources for AC analysis
Vin_f noise_in 0 DC 0 AC 1
* Input stage for analysis
Rin noise_in noise_gate 1k
Vbias noise_vdd 0 DC 1.2
Vgs_noise noise_gate_bias 0 DC 0.6

* MOSFET device under test - standard 45nm transistor with different bias conditions
M2 noise_drain noise_gate noise_source noise_bulk NMOS_VTG L=0.045u W=10u
Vgs_inp noise_gate noise_gate_bias DC 0
Rout noise_drain noise_vdd 10k
Vbulk_noise noise_bulk 0 DC 0
Vsrc_noise noise_source 0 DC 0

* Shot Noise Test Circuit - Configured for shot noise observation
Vdd_shot shot_vdd 0 DC 1.2 AC 1
Vgs_shot shot_gate 0 DC 0.9
Rload_shot shot_vdd shot_drain 10k

* MOSFET for shot noise analysis
M3 shot_drain shot_gate shot_source shot_bulk NMOS_VTG L=0.045u W=10u
Vbulk_shot shot_bulk 0 DC 0
Vsrc_shot shot_source 0 DC 0

* Control block
.control
set filetype=ascii
set wr_vecnames
set wr_singlescale
set wr_singleprecision
set wr_formatted

echo "Starting noise analysis simulations"

* Thermal Noise Analysis
echo "Thermal Noise Analysis"
* Setup bias conditions for thermal noise analysis

* First bias point (0.3, 0.3)
alter Vgs = 0.3
alter Vds = 0.3
noise v(drain) Vin dec 20 1 1G
setplot noise1
let thermal_noise = inoise_spectrum
let freq = frequency
write ./thermal_noise_vgs0.3_vds0.3.txt freq thermal_noise

* Second bias point (0.3, 0.6)
alter Vgs = 0.3
alter Vds = 0.6
noise v(drain) Vin dec 20 1 1G
setplot noise1
let thermal_noise = inoise_spectrum
let freq = frequency
write ./thermal_noise_vgs0.3_vds0.6.txt freq thermal_noise

* Third bias point (0.3, 0.9)
alter Vgs = 0.3
alter Vds = 0.9
noise v(drain) Vin dec 20 1 1G
setplot noise1
let thermal_noise = inoise_spectrum
let freq = frequency
write ./thermal_noise_vgs0.3_vds0.9.txt freq thermal_noise

* Fourth bias point (0.3, 1.2)
alter Vgs = 0.3
alter Vds = 1.2
noise v(drain) Vin dec 20 1 1G
setplot noise1
let thermal_noise = inoise_spectrum
let freq = frequency
write ./thermal_noise_vgs0.3_vds1.2.txt freq thermal_noise

* Fifth bias point (0.6, 0.3)
alter Vgs = 0.6
alter Vds = 0.3
noise v(drain) Vin dec 20 1 1G
setplot noise1
let thermal_noise = inoise_spectrum
let freq = frequency
write ./thermal_noise_vgs0.6_vds0.3.txt freq thermal_noise

* Sixth bias point (0.6, 0.6)
alter Vgs = 0.6
alter Vds = 0.6
noise v(drain) Vin dec 20 1 1G
setplot noise1
let thermal_noise = inoise_spectrum
let freq = frequency
write ./thermal_noise_vgs0.6_vds0.6.txt freq thermal_noise

* Flicker (1/f) Noise Analysis
echo "Flicker (1/f) Noise Analysis"
* Set bias for flicker noise analysis (typically more visible at lower frequencies)
alter Vgs_noise = 0.6
alter Vbias = 1.2

* Run noise analysis with focus on lower frequencies where flicker noise dominates
noise v(noise_drain) Vin_f dec 20 0.1 1MEG
setplot noise1
let flicker_noise = inoise_spectrum
let freq = frequency
wrdata ./flicker_noise.txt freq flicker_noise

* Also extract onoise for comparison
let output_noise = onoise_spectrum
wrdata ./output_noise.txt freq output_noise

* Shot Noise Analysis
echo "Shot Noise Analysis"
* Set bias for shot noise observation
alter Vgs_shot = 0.9
* Run noise analysis - Ensure AC is set correctly on Vdd_shot
noise v(shot_drain) Vdd_shot dec 20 1 1G
setplot noise1
let shot_noise = inoise_spectrum
let freq = frequency
wrdata ./shot_noise.txt freq shot_noise

* Temperature-Dependent Noise Analysis
echo "Temperature-Dependent Noise Analysis"
* Run noise analysis at different temperatures

* First temperature -40°C
option temp = -40
noise v(drain) Vin dec 20 1 1G
setplot noise1
let temp_noise = inoise_spectrum
let freq = frequency
write ./noise_temp-40.txt freq temp_noise

* Second temperature 0°C
option temp = 0
noise v(drain) Vin dec 20 1 1G
setplot noise1
let temp_noise = inoise_spectrum
let freq = frequency
write ./noise_temp0.txt freq temp_noise

* Third temperature 27°C
option temp = 27
noise v(drain) Vin dec 20 1 1G
setplot noise1
let temp_noise = inoise_spectrum
let freq = frequency
write ./noise_temp27.txt freq temp_noise

* Fourth temperature 50°C
option temp = 50
noise v(drain) Vin dec 20 1 1G
setplot noise1
let temp_noise = inoise_spectrum
let freq = frequency
write ./noise_temp50.txt freq temp_noise

* Fifth temperature 100°C
option temp = 100
noise v(drain) Vin dec 20 1 1G
setplot noise1
let temp_noise = inoise_spectrum
let freq = frequency
write ./noise_temp100.txt freq temp_noise

* Sixth temperature 150°C
option temp = 150
noise v(drain) Vin dec 20 1 1G
setplot noise1
let temp_noise = inoise_spectrum
let freq = frequency
write ./noise_temp150.txt freq temp_noise

* Frequency-Dependent Noise Analysis
echo "Frequency-Dependent Noise Analysis"

* Create a dedicated circuit for frequency-dependent noise analysis
* With proper input signal source and AC component
* Clear previous circuit
destroy all
options tmp=27 absckt=1e-12 vntol=1e-6 chgtol=1e-14 reltol=1e-9

* Supply
Vdd vdd 0 DC 1.2

* Input source with AC component for noise analysis
Vin in 0 DC 0.6 AC 1

* Biasing resistors
Rg in gate 1k
Rd vdd drain 10k
Rs source 0 100

* Coupling capacitor to block DC (optional)
C1 in gate 1u

* Device under test - MOSFET
M1 drain gate source 0 NMOS_VTG L=0.045u W=10u

* Run AC noise analysis
noise v(drain) Vin dec 20 1 10G
setplot noise1

* Extract raw SPICE data
let freq = frequency
let total_noise = inoise_spectrum

* Estimate thermal and flicker components based on noise physics
* We use a frequency-domain approach to separate components:
* - Thermal noise is flat with frequency (white noise)
* - Flicker noise follows 1/f dependency

* First, estimate thermal noise floor from high-frequency region
* High frequencies are dominated by thermal noise
let highfreq_idx = length(frequency) - 5
let thermal_level = mean(inoise_spectrum[highfreq_idx:length(inoise_spectrum)-1])

* Create thermal noise component as flat across all frequencies
let thermal_noise = thermal_level * ones(length(frequency))

* Calculate flicker noise as difference between total and thermal noise
* Ensure we don't get negative values for flicker noise
let flicker_noise = vector(length(frequency))
let i = 0
while i < length(frequency)
    if inoise_spectrum[i] > thermal_noise[i]
        let flicker_noise[i] = inoise_spectrum[i] - thermal_noise[i]
    else
        let flicker_noise[i] = 0
    end
    let i = i + 1
end

* Verify components sum to total
* First, create a vector to hold sum of components
let sum_components = thermal_noise + flicker_noise

* Write results to file with all components
wrdata ./freq_dependent_noise.txt freq total_noise thermal_noise flicker_noise

* Channel Length Dependence Analysis
echo "Channel Length Dependence Analysis"

* First length 45nm (0.045u)
altermod @M1[L] = 0.045u
noise v(drain) Vin dec 20 1 1G
setplot noise1
let length_noise = inoise_spectrum
let freq = frequency
write ./noise_length0.045e-06.txt freq length_noise

* Second length 90nm (0.09u)
altermod @M1[L] = 0.09u
noise v(drain) Vin dec 20 1 1G
setplot noise1
let length_noise = inoise_spectrum
let freq = frequency
write ./noise_length0.090e-06.txt freq length_noise

* Third length 180nm (0.18u)
altermod @M1[L] = 0.18u
noise v(drain) Vin dec 20 1 1G
setplot noise1
let length_noise = inoise_spectrum
let freq = frequency
write ./noise_length0.180e-06.txt freq length_noise

* Fourth length 360nm (0.36u)
altermod @M1[L] = 0.36u
noise v(drain) Vin dec 20 1 1G
setplot noise1
let length_noise = inoise_spectrum
let freq = frequency
write ./noise_length0.360e-06.txt freq length_noise

* Channel Width Dependence Analysis
echo "Channel Width Dependence Analysis"

* Reset length to default
altermod @M1[L] = 0.045u

* First width 1um
altermod @M1[W] = 1u
noise v(drain) Vin dec 20 1 1G
setplot noise1
let width_noise = inoise_spectrum
let freq = frequency
write ./noise_width1.0e-06.txt freq width_noise

* Second width 5um
altermod @M1[W] = 5u
noise v(drain) Vin dec 20 1 1G
setplot noise1
let width_noise = inoise_spectrum
let freq = frequency
write ./noise_width5.0e-06.txt freq width_noise

* Third width 10um
altermod @M1[W] = 10u
noise v(drain) Vin dec 20 1 1G
setplot noise1
let width_noise = inoise_spectrum
let freq = frequency
write ./noise_width1.0e-05.txt freq width_noise

* Fourth width 20um
altermod @M1[W] = 20u
noise v(drain) Vin dec 20 1 1G
setplot noise1
let width_noise = inoise_spectrum
let freq = frequency
write ./noise_width2.0e-05.txt freq width_noise

echo "Noise analysis simulations completed"
quit
.endc

.end
