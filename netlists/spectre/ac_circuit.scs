// MOSFET AC Analysis - Spectre version
// Replicates ngspice ac_circuit.cir
simulator lang=spectre

simulatorOptions options gmin=1e-15 reltol=1e-8 vabstol=1e-12 temp=27 tnom=27

simulator lang=spice
.inc ../../models/FreePDK45/nom.inc
simulator lang=spectre

// ============================================================
// CV Measurement Circuit (M1): gate AC=1, D/S/B AC=0
// ============================================================
M_cv (drain_1 gate_1 source_1 bulk_1) NMOS_VTG l=0.045u w=10u

VG (gate_1 0) vsource dc=0 ac=1
VD (drain_1 0) vsource dc=1.0 ac=0
VS (source_1 0) vsource dc=0 ac=0
VB (bulk_1 0) vsource dc=0 ac=0

// ============================================================
// S-parameter Test Circuit (M2): 50-ohm 2-port
// ============================================================
M_sp (drain_2 gate_2 0 0) NMOS_VTG l=0.045u w=10u
RG_sp (gate_2 gate_in2) resistor r=50
RD_sp (drain_2 drain_in2) resistor r=50
VGS_port (gate_in2 0) vsource dc=0.8 ac=1
VDS_port (drain_in2 0) vsource dc=1.0 ac=0

// ============================================================
// Charge Conservation Test Circuit (M3)
// ============================================================
M_cc (drain_3 gate_3 source_3 bulk_3) NMOS_VTG l=0.045u w=10u

VGQ (gate_3 0) vsource dc=0 type=pwl wave=[0 0 1n 0 1.01n 1.0 5n 1.0]
VDQ (drain_3 0) vsource dc=1.0
VSQ (source_3 0) vsource dc=0
VBQ (bulk_3 0) vsource dc=0

// ============================================================
// CV Analysis: sweep Vg DC bias, run AC at 4 frequencies
// ============================================================
sw_cv_1k sweep param=dc dev=VG start=-0.8 stop=1.2 step=0.05 {
    ac_cv_1k ac start=1k stop=1k lin=1
}
sw_cv_10k sweep param=dc dev=VG start=-0.8 stop=1.2 step=0.05 {
    ac_cv_10k ac start=10k stop=10k lin=1
}
sw_cv_100k sweep param=dc dev=VG start=-0.8 stop=1.2 step=0.05 {
    ac_cv_100k ac start=100k stop=100k lin=1
}
sw_cv_1m sweep param=dc dev=VG start=-0.8 stop=1.2 step=0.05 {
    ac_cv_1m ac start=1MEG stop=1MEG lin=1
}

// ============================================================
// Full 4x4 Capacitance Matrix at 1MHz
// Gate excitation (default: VG.ac=1, others=0) - already set
// ============================================================
sw_cmat_g sweep param=dc dev=VG start=-0.8 stop=1.2 step=0.05 {
    ac_cmat_g ac start=1MEG stop=1MEG lin=1
}

// Drain excitation: VG.ac=0, VD.ac=1
// Use alternate circuit with swapped AC sources
// We create copies with different AC excitation
M_cv_d (drain_1d gate_1d source_1d bulk_1d) NMOS_VTG l=0.045u w=10u
VG_d (gate_1d 0) vsource dc=0 ac=0
VD_d (drain_1d 0) vsource dc=1.0 ac=1
VS_d (source_1d 0) vsource dc=0 ac=0
VB_d (bulk_1d 0) vsource dc=0 ac=0
sw_cmat_d sweep param=dc dev=VG_d start=-0.8 stop=1.2 step=0.05 {
    ac_cmat_d ac start=1MEG stop=1MEG lin=1
}

// Source excitation
M_cv_s (drain_1s gate_1s source_1s bulk_1s) NMOS_VTG l=0.045u w=10u
VG_s (gate_1s 0) vsource dc=0 ac=0
VD_s (drain_1s 0) vsource dc=1.0 ac=0
VS_s (source_1s 0) vsource dc=0 ac=1
VB_s (bulk_1s 0) vsource dc=0 ac=0
sw_cmat_s sweep param=dc dev=VG_s start=-0.8 stop=1.2 step=0.05 {
    ac_cmat_s ac start=1MEG stop=1MEG lin=1
}

// Bulk excitation
M_cv_b (drain_1b gate_1b source_1b bulk_1b) NMOS_VTG l=0.045u w=10u
VG_b (gate_1b 0) vsource dc=0 ac=0
VD_b (drain_1b 0) vsource dc=1.0 ac=0
VS_b (source_1b 0) vsource dc=0 ac=0
VB_b (bulk_1b 0) vsource dc=0 ac=1
sw_cmat_b sweep param=dc dev=VG_b start=-0.8 stop=1.2 step=0.05 {
    ac_cmat_b ac start=1MEG stop=1MEG lin=1
}

// ============================================================
// S-Parameter Analysis (M2 circuit): direct SP analysis
// ============================================================
ac_sp ac start=1MEG stop=1G dec=10

// ============================================================
// Non-Quasi-Static Effects: AC at high frequencies (use M1)
// ============================================================
// Set M1 to saturation: VG=0.8V, VD=1.0V via sweep
sw_nqs sweep param=dc dev=VG values=[0.8] {
    ac_nqs ac start=10MEG stop=10G dec=10
}

// ============================================================
// Charge Conservation Test (Transient on M3)
// ============================================================
tran_cc tran start=0 stop=5n step=0.01n
