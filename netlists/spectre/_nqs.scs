simulator lang=spice
.option temp=27 tnom=27 gmin=1e-15
.inc ../../models/FreePDK45/nom.inc
Mnqs dnqs gnqs snqs bnqs NMOS_VTG L=0.045u W=10u
VGnqs gnqs 0 DC 0.8 AC 1
VDnqs dnqs 0 DC 1.0 AC 0
VSnqs snqs 0 DC 0 AC 0
VBnqs bnqs 0 DC 0 AC 0
.ac dec 4 10meg 10G
