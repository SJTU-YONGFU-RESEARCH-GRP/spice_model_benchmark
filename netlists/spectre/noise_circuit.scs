simulator lang=spice
.option temp=27 tnom=27 gmin=1e-15
.inc ../../models/FreePDK45/nom.inc
* Thermal bias Vgs=0.3 Vds=0.3
Vdd_n0 vdd_n0 0 DC 1.2
Vin_n0 in_n0 0 DC 0.3 AC 1
Rb_n0 in_n0 gate_n0 1k
Rd_n0 vdd_n0 drain_n0 10k
Rs_n0 source_n0 0 100
M_noise0 drain_n0 gate_n0 source_n0 0 NMOS_VTG L=0.045u W=10u
Vgs_n0 gate_n0 source_n0 DC 0.3
Vds_n0 drain_n0 source_n0 DC 0.3
* Thermal bias Vgs=0.3 Vds=0.6
Vdd_n1 vdd_n1 0 DC 1.2
Vin_n1 in_n1 0 DC 0.3 AC 1
Rb_n1 in_n1 gate_n1 1k
Rd_n1 vdd_n1 drain_n1 10k
Rs_n1 source_n1 0 100
M_noise1 drain_n1 gate_n1 source_n1 0 NMOS_VTG L=0.045u W=10u
Vgs_n1 gate_n1 source_n1 DC 0.3
Vds_n1 drain_n1 source_n1 DC 0.6
* Thermal bias Vgs=0.3 Vds=0.9
Vdd_n2 vdd_n2 0 DC 1.2
Vin_n2 in_n2 0 DC 0.3 AC 1
Rb_n2 in_n2 gate_n2 1k
Rd_n2 vdd_n2 drain_n2 10k
Rs_n2 source_n2 0 100
M_noise2 drain_n2 gate_n2 source_n2 0 NMOS_VTG L=0.045u W=10u
Vgs_n2 gate_n2 source_n2 DC 0.3
Vds_n2 drain_n2 source_n2 DC 0.9
* Thermal bias Vgs=0.3 Vds=1.2
Vdd_n3 vdd_n3 0 DC 1.2
Vin_n3 in_n3 0 DC 0.3 AC 1
Rb_n3 in_n3 gate_n3 1k
Rd_n3 vdd_n3 drain_n3 10k
Rs_n3 source_n3 0 100
M_noise3 drain_n3 gate_n3 source_n3 0 NMOS_VTG L=0.045u W=10u
Vgs_n3 gate_n3 source_n3 DC 0.3
Vds_n3 drain_n3 source_n3 DC 1.2
* Thermal bias Vgs=0.6 Vds=0.3
Vdd_n4 vdd_n4 0 DC 1.2
Vin_n4 in_n4 0 DC 0.6 AC 1
Rb_n4 in_n4 gate_n4 1k
Rd_n4 vdd_n4 drain_n4 10k
Rs_n4 source_n4 0 100
M_noise4 drain_n4 gate_n4 source_n4 0 NMOS_VTG L=0.045u W=10u
Vgs_n4 gate_n4 source_n4 DC 0.6
Vds_n4 drain_n4 source_n4 DC 0.3
* Thermal bias Vgs=0.6 Vds=0.6
Vdd_n5 vdd_n5 0 DC 1.2
Vin_n5 in_n5 0 DC 0.6 AC 1
Rb_n5 in_n5 gate_n5 1k
Rd_n5 vdd_n5 drain_n5 10k
Rs_n5 source_n5 0 100
M_noise5 drain_n5 gate_n5 source_n5 0 NMOS_VTG L=0.045u W=10u
Vgs_n5 gate_n5 source_n5 DC 0.6
Vds_n5 drain_n5 source_n5 DC 0.6
* Flicker noise
Vdd_fl flicker_vdd 0 DC 1.2
Vin_fl flicker_in 0 DC 0 AC 1
Rin_fl flicker_in flicker_gate 1k
Rout_fl flicker_drain flicker_vdd 10k
M_fl flicker_drain flicker_gate flicker_source 0 NMOS_VTG L=0.045u W=10u
Vgs_fl flicker_gate 0 DC 0.6
Vsrc_fl flicker_source 0 DC 0
* Shot noise
Vdd_sh shot_vdd 0 DC 1.2 AC 1
Vgs_sh shot_gate 0 DC 0.9
Rload_sh shot_vdd shot_drain 10k
M_sh shot_drain shot_gate shot_source 0 NMOS_VTG L=0.045u W=10u
Vsrc_sh shot_source 0 DC 0
.noise v(drain_n5) Vin_n5 dec 20 1 1G
