* MOSFET IV and CV Characteristics Simulation with Temperature Analysis
.option temp=27 tnom=27
.option gmin=1e-15
.option reltol=1e-8
.option abstol=1e-12
.option chgtol=1e-15
.option method=gear
.option TEMP=27
.option TNOM=27
.option TEMPSCALE=1.0

* Include FreePDK45 model
.inc ../models/ngspice-cmos/FreePDK45/nom.inc

* IV Characteristics Circuit
Vds_iv drain_iv 0 DC 0
Vgs_iv gate_iv 0 DC 0
Vs_iv source_iv 0 DC 0
Vb_iv bulk_iv 0 DC 0

* MOSFET device under test - standard 45nm transistor
M1 drain_iv gate_iv source_iv bulk_iv NMOS_VTG L=0.045u W=10u

* CV Characteristics Circuit - Enhanced for realistic operation in all regions
Vg_cv gate_cv 0 DC 0 AC 1
Vd_cv drain_cv 0 DC 1.0
Vs_cv source_cv 0 DC 0
Vb_cv bulk_cv 0 DC 0

* MOSFET device under test - standard 45nm transistor
M2 drain_cv gate_cv source_cv bulk_cv NMOS_VTG L=0.045u W=10u

* Bias Point Analysis Circuit
Vds_bias drain_bias 0 DC 0
Vgs_bias gate_bias 0 DC 0
Vs_bias source_bias 0 DC 0
Vb_bias bulk_bias 0 DC 0

* MOSFET device under test for bias point analysis
M3 drain_bias gate_bias source_bias bulk_bias NMOS_VTG L=0.045u W=10u

* Transient Analysis Circuits

* Large-Signal Transient Analysis Circuit
* Pulse input source for gate
Vgs_tran gate_tran 0 PULSE(0 1.2 0n 0.1n 0.1n 10n 20n)
Vds_tran drain_tran 0 DC 1.2
Vs_tran source_tran 0 DC 0
Vb_tran bulk_tran 0 DC 0

* Load capacitor to see switching behavior
Cload drain_tran 0 1f

* MOSFET device under test - standard 45nm transistor
M_tran drain_tran gate_tran source_tran bulk_tran NMOS_VTG L=0.045u W=10u

* Switching Simulation Circuit (inverter)
Vdd_inv vdd_inv 0 DC 1.2
Vin_inv in_inv 0 PULSE(0 1.2 0n 0.1n 0.1n 10n 20n)
M_inv_n out_inv in_inv 0 0 NMOS_VTG L=0.045u W=10u
M_inv_p out_inv in_inv vdd_inv vdd_inv PMOS_VTG L=0.045u W=20u
Cload_inv out_inv 0 1f

* Delay Effect Circuit - Chain of inverters
Vdd_delay vdd_delay 0 DC 1.2
Vin_delay in_delay 0 PULSE(0 1.2 0n 0.1n 0.1n 10n 20n)

* First inverter
M_d1_n mid1_delay in_delay 0 0 NMOS_VTG L=0.045u W=10u
M_d1_p mid1_delay in_delay vdd_delay vdd_delay PMOS_VTG L=0.045u W=20u
Cload_d1 mid1_delay 0 1f

* Second inverter
M_d2_n mid2_delay mid1_delay 0 0 NMOS_VTG L=0.045u W=10u
M_d2_p mid2_delay mid1_delay vdd_delay vdd_delay PMOS_VTG L=0.045u W=20u
Cload_d2 mid2_delay 0 1f

* Third inverter (output)
M_d3_n out_delay mid2_delay 0 0 NMOS_VTG L=0.045u W=10u
M_d3_p out_delay mid2_delay vdd_delay vdd_delay PMOS_VTG L=0.045u W=20u
Cload_d3 out_delay 0 1f

* Power Dissipation Circuit
Vdd_power vdd_power 0 DC 1.2
Vin_power in_power 0 PULSE(0 1.2 0n 0.1n 0.1n 10n 20n)
M_power_n out_power in_power 0 0 NMOS_VTG L=0.045u W=10u
M_power_p out_power in_power vdd_power vdd_power PMOS_VTG L=0.045u W=20u
Cload_power out_power 0 1f

* Charge Conservation Test Circuit using capacitance approach
* Instead of direct charge extraction, we'll measure capacitances and integrate
Vdd_charge vdd_charge 0 DC 1.2
Vg_charge gate_charge 0 PULSE(0 1.2 0n 1n 1n 10n 20n)
* MOS for charge conservation test
M_charge drain_charge gate_charge source_charge bulk_charge NMOS_VTG L=0.045u W=10u
Vd_charge drain_charge 0 DC 1.2
Vs_charge source_charge 0 DC 0
Vb_charge bulk_charge 0 DC 0
* Capacitors to measure charges (small value to avoid affecting circuit)
Cg gate_charge 0 1e-18
Cd drain_charge 0 1e-18
Cs source_charge 0 1e-18
Cb bulk_charge 0 1e-18

* Quasi-Static Analysis Circuit with improved convergence
Vgs_qs gate_qs 0 PULSE(0 1.2 0n 20n 20n 100n 200n)
Vds_qs drain_qs 0 DC 1.2
Vs_qs source_qs 0 DC 0
Vb_qs bulk_qs 0 DC 0
M_qs drain_qs gate_qs source_qs bulk_qs NMOS_VTG L=0.045u W=10u
Cload_qs drain_qs 0 10f

* Noise Analysis Circuits
* Thermal Noise Analysis Circuit - Common source amplifier configuration
Vdd_noise vdd_noise 0 DC 1.2
Vin_noise in_noise 0 DC 0.6 AC 1
Rb_noise in_noise gate_noise 1k       ; Bias resistor (blocks DC)
Cb_noise in_noise gate_noise 1u       ; Coupling capacitor (passes AC)
Rs_noise source_noise 0 100           ; Source resistor for stability
Rd_noise vdd_noise drain_noise 10k    ; Drain resistor - load
Vgs_noise gate_noise source_noise DC 0 ; Gate-source voltage (will be altered)
Vds_noise drain_noise source_noise DC 0 ; Drain-source voltage (will be altered)
Vbulk_noise bulk_noise 0 DC 0         ; Bulk/substrate connection
M_noise drain_noise gate_noise source_noise bulk_noise NMOS_VTG L=0.045u W=10u

* Flicker Noise Source Circuit - Separate circuit for flicker noise characterization
* Voltage and current sources for AC analysis
Vin_f flicker_in 0 DC 0 AC 1
* Input stage for analysis
Rin_f flicker_in flicker_gate 1k
Vbias_f flicker_vdd 0 DC 1.2
Vgs_flicker flicker_gate_bias 0 DC 0.6
M_flicker flicker_drain flicker_gate flicker_source flicker_bulk NMOS_VTG L=0.045u W=10u
Vgs_inp_f flicker_gate flicker_gate_bias DC 0
Rout_f flicker_drain flicker_vdd 10k
Vbulk_f flicker_bulk 0 DC 0
Vsrc_f flicker_source 0 DC 0

* Shot Noise Test Circuit - Configured for shot noise observation
Vdd_shot shot_vdd 0 DC 1.2 AC 1
Vgs_shot shot_gate 0 DC 0.9
Rload_shot shot_vdd shot_drain 10k
M_shot shot_drain shot_gate shot_source shot_bulk NMOS_VTG L=0.045u W=10u
Vbulk_shot shot_bulk 0 DC 0
Vsrc_shot shot_source 0 DC 0

* Control block
.control
set filetype=ascii
set wr_vecnames
set wr_singlescale
set wr_singleprecision
set wr_formatted

* Run DC analysis with temperature sweep
echo "Starting temperature sweep"

* Temperature -40°C
option temp=-40
echo "Running simulation at temperature: -40 °C"
dc Vds_iv 0 1.2 0.01 Vgs_iv 0 1.2 0.2
let id = i(Vds_iv)
let is = i(Vs_iv)
let ig = i(Vgs_iv)
let ib = i(Vb_iv)
let kcl = abs(id + is + ig + ib)
* Write data in the order expected by data_reader: v(d) v(g) i(vds) i(vs) i(vb) i(vgs) kcl
wrdata ./iv_data_-40.txt v(drain_iv) v(gate_iv) id is ib ig kcl

* Temperature 0°C
option temp=0
echo "Running simulation at temperature: 0 °C"
dc Vds_iv 0 1.2 0.01 Vgs_iv 0 1.2 0.2
let id = i(Vds_iv)
let is = i(Vs_iv)
let ig = i(Vgs_iv)
let ib = i(Vb_iv)
let kcl = abs(id + is + ig + ib)
wrdata ./iv_data_0.txt v(drain_iv) v(gate_iv) id is ib ig kcl

* Temperature 25°C
option temp=25
echo "Running simulation at temperature: 25 °C"
dc Vds_iv 0 1.2 0.01 Vgs_iv 0 1.2 0.2
let id = i(Vds_iv)
let is = i(Vs_iv)
let ig = i(Vgs_iv)
let ib = i(Vb_iv)
let kcl = abs(id + is + ig + ib)
wrdata ./iv_data_25.txt v(drain_iv) v(gate_iv) id is ib ig kcl

* Temperature 50°C
option temp=50
echo "Running simulation at temperature: 50 °C"
dc Vds_iv 0 1.2 0.01 Vgs_iv 0 1.2 0.2
let id = i(Vds_iv)
let is = i(Vs_iv)
let ig = i(Vgs_iv)
let ib = i(Vb_iv)
let kcl = abs(id + is + ig + ib)
wrdata ./iv_data_50.txt v(drain_iv) v(gate_iv) id is ib ig kcl

* Temperature 100°C
option temp=100
echo "Running simulation at temperature: 100 °C"
dc Vds_iv 0 1.2 0.01 Vgs_iv 0 1.2 0.2
let id = i(Vds_iv)
let is = i(Vs_iv)
let ig = i(Vgs_iv)
let ib = i(Vb_iv)
let kcl = abs(id + is + ig + ib)
wrdata ./iv_data_100.txt v(drain_iv) v(gate_iv) id is ib ig kcl

* Temperature 150°C
option temp=150
echo "Running simulation at temperature: 150 °C"
dc Vds_iv 0 1.2 0.01 Vgs_iv 0 1.2 0.2
let id = i(Vds_iv)
let is = i(Vs_iv)
let ig = i(Vgs_iv)
let ib = i(Vb_iv)
let kcl = abs(id + is + ig + ib)
wrdata ./iv_data_150.txt v(drain_iv) v(gate_iv) id is ib ig kcl

* Bias Point Analysis Section
echo "Starting bias point analysis"

* Set up bias points for analysis
let vds_points = (0.0 0.6 1.2)
let vgs_points = (0.0 0.6 1.2)

* Run bias point analysis at room temperature
option temp=27
echo "Running bias point analysis at 27°C"

* Loop through bias points
let i = 0
while i < length(vds_points)
    let j = 0
    while j < length(vgs_points)
        * Set bias voltages
        alter Vds_bias = vds_points[i]
        alter Vgs_bias = vgs_points[j]

        * Run DC analysis at this bias point
        op
        let id_bias = i(Vds_bias)
        let is_bias = i(Vs_bias)
        let ig_bias = i(Vgs_bias)
        let ib_bias = i(Vb_bias)

        * Write data for this bias point
        wrdata ./bias_point_data.txt v(drain_bias) v(gate_bias) id_bias ig_bias is_bias ib_bias append

        let j = j + 1
    end
    let i = i + 1
end

* Enhanced CV simulation section - runs at multiple frequencies

* Set up gate voltage sweep parameters
let vg_start = -0.8   ; Start accumulation region
let vg_stop = 1.2     ; End strong inversion
let vg_step = 0.05    ; Small step size for smooth curve
let num_points = floor((vg_stop - vg_start)/vg_step) + 1

* Perform gate voltage sweep with measurements at each bias point
let vg_bias = vg_start
while vg_bias <= vg_stop
    * Set gate bias
    alter Vg_cv = vg_bias

    * Run AC analysis at multiple frequencies
    * 1kHz (low frequency response)
    ac lin 1 1k 1k
    let cgg_1k = -imag(i(Vg_cv))/(2*3.14159*1e3)

    * 10kHz
    ac lin 1 10k 10k
    let cgg_10k = -imag(i(Vg_cv))/(2*3.14159*1e4)

    * 100kHz
    ac lin 1 100k 100k
    let cgg_100k = -imag(i(Vg_cv))/(2*3.14159*1e5)

    * 1MHz (standard frequency for CV measurements)
    ac lin 1 1meg 1meg
    let cgg_1m = -imag(i(Vg_cv))/(2*3.14159*1e6)

    * Calculate individual capacitance components at 1MHz
    * These help identify the behavior in different regions
    let cgb_1m = abs(imag(v(gate_cv,bulk_cv)/i(Vg_cv)))/(2*3.14159*1e6)
    let cgs_1m = abs(imag(v(gate_cv,source_cv)/i(Vg_cv)))/(2*3.14159*1e6)
    let cgd_1m = abs(imag(v(gate_cv,drain_cv)/i(Vg_cv)))/(2*3.14159*1e6)

    * Increment gate voltage
    let vg_bias = vg_bias + vg_step
end

echo "CV simulation completed."

* Transient Analysis Commands

* Run Large-Signal Transient Analysis
echo "Starting large-signal transient analysis"
tran 0.01n 100n
* Save current through drain, gate, source, and voltages
wrdata ./tran_large_signal.txt time v(gate_tran) v(drain_tran) i(Vds_tran) i(Vgs_tran) i(Vs_tran) i(Vb_tran)

* Run Switching Analysis (inverter)
echo "Starting switching analysis"
tran 0.01n 100n
* Save input and output voltage, as well as current through power supply
wrdata ./tran_switching.txt time v(in_inv) v(out_inv) i(Vdd_inv)

* Calculate switching power
let power_switching = -v(vdd_inv)*i(Vdd_inv)
wrdata ./tran_switching_power.txt time power_switching

* Run Delay Effect Analysis
echo "Starting delay effect analysis"
tran 0.01n 100n
* Save input, intermediate, and output voltage waveforms
wrdata ./tran_delay.txt time v(in_delay) v(mid1_delay) v(mid2_delay) v(out_delay)

* Run Power Dissipation Analysis at different temperatures
echo "Starting power dissipation analysis"

* Temperature 27°C (room temperature)
option temp=27
tran 0.01n 100n
let power_diss = -v(vdd_power)*i(Vdd_power)
let energy = integ(power_diss)
* Save time, input, output, power, and energy
wrdata ./tran_power_27C.txt time v(in_power) v(out_power) power_diss energy

* Temperature 100°C
option temp=100
tran 0.01n 100n
let power_diss = -v(vdd_power)*i(Vdd_power)
let energy = integ(power_diss)
wrdata ./tran_power_100C.txt time v(in_power) v(out_power) power_diss energy

* Run Quasi-Static Analysis with improved timestep control
echo "Starting quasi-static analysis"
option temp=27
option minbreak=1e-15
* Use slower rise/fall times to observe quasi-static behavior
tran 0.1n 500n uic
* Save gate voltage, drain voltage and drain current
let id_qs = i(Vds_qs)
wrdata ./tran_quasi_static.txt time v(gate_qs) v(drain_qs) id_qs

* Run Charge Conservation Analysis using an alternative approach
echo "Starting charge conservation analysis"
option temp=27
* Modified approach that doesn't rely on direct charge extraction
tran 0.01n 100n
* Calculate terminal currents
let ig_charge = i(Vg_charge)
let id_charge = i(Vd_charge)
let is_charge = i(Vs_charge)
let ib_charge = i(Vb_charge)
* Calculate total current (should be close to zero for conservation)
let i_total = ig_charge + id_charge + is_charge + ib_charge
* Calculate charges by integrating currents
let qg_approx = integ(ig_charge)
let qd_approx = integ(id_charge)
let qs_approx = integ(is_charge)
let qb_approx = integ(ib_charge)
let q_total = qg_approx + qd_approx + qs_approx + qb_approx
* Save the results
wrdata ./tran_charge.txt time v(gate_charge) ig_charge id_charge is_charge ib_charge i_total qg_approx qd_approx qs_approx qb_approx q_total

* Noise Analysis Simulations
echo "Starting noise analysis simulations"

* First, make sure we can switch to the noise plots
set filetype=ascii
set wr_vecnames
set wr_singlescale

* Thermal Noise Analysis
echo "Thermal Noise Analysis"
* Setup bias conditions for thermal noise analysis

* First bias point (0.3, 0.3)
alter Vgs_noise = 0.3
alter Vds_noise = 0.3
noise v(drain_noise) Vin_noise dec 20 1 1G
eprvcd ./thermal_noise_vgs0.3_vds0.3.raw all

* Second bias point (0.3, 0.6)
alter Vgs_noise = 0.3
alter Vds_noise = 0.6
noise v(drain_noise) Vin_noise dec 20 1 1G
eprvcd ./thermal_noise_vgs0.3_vds0.6.raw all

* Third bias point (0.3, 0.9)
alter Vgs_noise = 0.3
alter Vds_noise = 0.9
noise v(drain_noise) Vin_noise dec 20 1 1G
eprvcd ./thermal_noise_vgs0.3_vds0.9.raw all

* Fourth bias point (0.3, 1.2)
alter Vgs_noise = 0.3
alter Vds_noise = 1.2
noise v(drain_noise) Vin_noise dec 20 1 1G
eprvcd ./thermal_noise_vgs0.3_vds1.2.raw all

* Fifth bias point (0.6, 0.3)
alter Vgs_noise = 0.6
alter Vds_noise = 0.3
noise v(drain_noise) Vin_noise dec 20 1 1G
eprvcd ./thermal_noise_vgs0.6_vds0.3.raw all

* Sixth bias point (0.6, 0.6)
alter Vgs_noise = 0.6
alter Vds_noise = 0.6
noise v(drain_noise) Vin_noise dec 20 1 1G
eprvcd ./thermal_noise_vgs0.6_vds0.6.raw all

* Flicker (1/f) Noise Analysis
echo "Flicker (1/f) Noise Analysis"
* Set bias for flicker noise analysis (typically more visible at lower frequencies)
alter Vgs_flicker = 0.6
alter Vbias_f = 1.2

* Run noise analysis with focus on lower frequencies where flicker noise dominates
noise v(flicker_drain) Vin_f dec 20 0.1 1MEG
eprvcd ./flicker_noise.raw all

* Shot Noise Analysis
echo "Shot Noise Analysis"
* Set bias for shot noise observation
alter Vgs_shot = 0.9
* Run noise analysis - Ensure AC is set correctly on Vdd_shot
noise v(shot_drain) Vdd_shot dec 20 1 1G
eprvcd ./shot_noise.raw all

* Temperature-Dependent Noise Analysis
echo "Temperature-Dependent Noise Analysis"
* Run noise analysis at different temperatures

* First temperature -40°C
option temp = -40
noise v(drain_noise) Vin_noise dec 20 1 1G
eprvcd ./noise_temp-40.raw all

* Second temperature 0°C
option temp = 0
noise v(drain_noise) Vin_noise dec 20 1 1G
eprvcd ./noise_temp0.raw all

* Third temperature 27°C
option temp = 27
noise v(drain_noise) Vin_noise dec 20 1 1G
eprvcd ./noise_temp27.raw all

* Fourth temperature 50°C
option temp = 50
noise v(drain_noise) Vin_noise dec 20 1 1G
eprvcd ./noise_temp50.raw all

* Fifth temperature 100°C
option temp = 100
noise v(drain_noise) Vin_noise dec 20 1 1G
eprvcd ./noise_temp100.raw all

* Sixth temperature 150°C
option temp = 150
noise v(drain_noise) Vin_noise dec 20 1 1G
eprvcd ./noise_temp150.raw all

echo "Noise analysis simulations completed"

quit
.endc

.end
