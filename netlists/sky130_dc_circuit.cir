* MOSFET DC Characteristics Simulation with Temperature Analysis
.option scale=1E-6
.option gmin=1e-12
.option reltol=1e-3
.option abstol=1e-9
.option chgtol=1e-12
.option method=trap
.option TEMP=27
.option TNOM=27
.option TEMPSCALE=1.0

* Include SkyWater sky130 device models
.include "../models/skywater-pdk-libs-sky130_fd_pr/cells/nfet_01v8/sky130_fd_pr__nfet_01v8__tt.corner.spice"

* MOSFET device under test (Sky130 NMOS 1.8V)
X1 drain_iv gate_iv source_iv bulk_iv sky130_fd_pr__nfet_01v8 l=1 w=1

* MOSFET device under test for bias point analysis
X2 drain_bias gate_bias source_bias bulk_bias sky130_fd_pr__nfet_01v8 l=1 w=1

* IV Characteristics Circuit
* Source and bulk connected to ground
Vs_iv source_iv 0 DC 0
Vb_iv bulk_iv 0 DC 0
* Gate voltage source
Vg_iv gate_iv source_iv DC 0
* Drain voltage source
Vd_iv drain_iv source_iv DC 0

* Control block
.control
set filetype=ascii
set wr_vecnames
set wr_singlescale
set wr_singleprecision
set wr_formatted

* Run DC analysis with temperature sweep
echo "Starting temperature sweep"

* Temperature -40°C
option temp=-40
echo "Running simulation at temperature: -40 °C"
dc Vg_iv 0 1.2 0.2 Vd_iv 0 1.2 0.01
let id = i(Vd_iv)
let is = i(Vs_iv)
let ig = i(Vg_iv)
let ib = i(Vb_iv)
let kcl = abs(id + is + ig + ib)
* Write data in the order expected by data_reader: v(d) v(g) i(vds) i(vs) i(vb) i(vgs) kcl
wrdata ./iv_data_-40.txt v(drain_iv) v(gate_iv) id is ib ig kcl

echo "DC analysis completed"
quit
.endc

.end
