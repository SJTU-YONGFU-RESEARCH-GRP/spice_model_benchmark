* MOSFET AC Analysis Circuit
* This simulation performs comprehensive AC analyses including:
* - Capacitance-voltage (C-V) measurements at different frequencies
* - Small-signal parameter extraction
* - Charge conservation tests
* - High-frequency behavior analysis
* - Non-quasi-static effects

.option temp=27 tnom=27
.option gmin=1e-15
.option reltol=1e-8
.option abstol=1e-12
.option chgtol=1e-15
.option method=gear

* Include the device model file
.inc ../models/FreePDK45/nom.inc

* MOSFET device under test
M1 drain_1 gate_1 source_1 bulk_1 NMOS_VTG L=1u W=10u

* Test circuit for capacitance and small-signal parameter measurements
* Gate voltage source with AC component for small-signal analysis
VG gate_1 0 DC 0 AC 1

* Drain bias at VDD (typical operation voltage)
VD drain_1 0 DC 1.0 AC 0

* Source and bulk connections tied to ground
VS source_1 0 DC 0 AC 0
VB bulk_1 0 DC 0 AC 0

* ------------------------------------------------------
* Small signal S-parameter test circuit on separate nodes
* for high-frequency characterization
* ------------------------------------------------------
* S-parameter test transistor
M2 drain_2 gate_2 0 0 NMOS_VTG L=1u W=10u

* 2-port definition: Port1=Gate, Port2=Drain (Z0=50 ohm)
* Use 50-ohm series resistors between the port voltage sources and the device terminals.
RG gate_2 gate_in2 50
RD drain_2 drain_in2 50

* Port sources for S-parameters (DC bias + small-signal AC excitation set in .control)
VGS gate_in2 0 DC 0.8 AC 0
VDS drain_in2 0 DC 1.0 AC 0

* ------------------------------------------------------
* Charge conservation test circuit
* ------------------------------------------------------
* MOSFET for charge conservation test
M3 drain_3 gate_3 source_3 bulk_3 NMOS_VTG L=1u W=10u

* Transient voltage source for gate
VGQ gate_3 0 DC 0 PWL(0 0 1n 0 2n 1.0 5n 1.0)

* Bias sources
VDQ drain_3 0 DC 1.0
VSQ source_3 0 DC 0
VBQ bulk_3 0 DC 0

.control
* Create output directories if they don't exist
shell mkdir -p .

* Output format configuration
set filetype=ascii
set wr_vecnames=yes
set wr_singlescale=yes
set numdgt=10

* ----------------------------------------------------------
* CV Analysis at Different Frequencies
* ----------------------------------------------------------
* Set up gate voltage sweep parameters
let vg_start = -0.8   ; Start accumulation region
let vg_stop = 1.2     ; End strong inversion
let vg_step = 0.05    ; Small step size for smooth curve
let num_points = floor((vg_stop - vg_start)/vg_step) + 1

* Create output file with header
echo "Vg Cgg_1kHz Cgg_10kHz Cgg_100kHz Cgg_1MHz Cgb_1MHz Cgs_1MHz Cgd_1MHz" > cv_data.txt

* Create output file for full 4x4 small-signal capacitance matrix (rows: current @ {g,d,s,b}; cols: excited voltage @ {g,d,s,b})
* C_ij is defined from: I_i = j*omega*sum_j(C_ij*V_j), so C_ij = -Im(Y_ij)/omega.
echo "Vg Cgg Cdg Csg Cbg Cgd Cdd Csd Cbd Cgs Cds Css Cbs Cgb Cdb Csb Cbb" > cmatrix_data.txt

* Initialize vectors for capacitance values
let cgg_1k_vec = vector(num_points)
let cgg_10k_vec = vector(num_points)
let cgg_100k_vec = vector(num_points)
let cgg_1m_vec = vector(num_points)
let cgb_1m_vec = vector(num_points)
let cgs_1m_vec = vector(num_points)
let cgd_1m_vec = vector(num_points)
let vg_vec = vector(num_points)
let idx = 0

* Initialize capacitance value variables
let cgg_val_1k = 0
let cgg_val_10k = 0
let cgg_val_100k = 0
let cgg_val_1m = 0
let cgb_val_1m = 0
let cgs_val_1m = 0
let cgd_val_1m = 0

* Perform gate voltage sweep with measurements at each bias point
let idx = 0
while idx < num_points
    let vg_bias = vg_start + idx * vg_step
    * Set gate bias
    alter VG = vg_bias

    * Store gate voltage value
    let vg_vec[idx] = vg_bias

    * Run AC analysis at 1kHz (low frequency response)
    ac lin 1 1k 1k
    let cgg_val_1k = -imag(i(VG))/(2*3.14159*1e3)
    let cgg_1k_vec[idx] = cgg_val_1k

    * Run AC analysis at 10kHz
    ac lin 1 10k 10k
    let cgg_val_10k = -imag(i(VG))/(2*3.14159*1e4)
    let cgg_10k_vec[idx] = cgg_val_10k

    * Run AC analysis at 100kHz
    ac lin 1 100k 100k
    let cgg_val_100k = -imag(i(VG))/(2*3.14159*1e5)
    let cgg_100k_vec[idx] = cgg_val_100k

    * Run AC analysis at 1MHz (standard frequency for CV measurements)
    ac lin 1 1meg 1meg
    let cgg_val_1m = -imag(i(VG))/(2*3.14159*1e6)
    let cgg_1m_vec[idx] = cgg_val_1m

    * Calculate individual capacitance components at 1MHz
    let cgb_val_1m = -imag(i(VB))/(2*3.14159*1e6)
    let cgb_1m_vec[idx] = cgb_val_1m

    let cgs_val_1m = -imag(i(VS))/(2*3.14159*1e6)
    let cgs_1m_vec[idx] = cgs_val_1m

    let cgd_val_1m = -imag(i(VD))/(2*3.14159*1e6)
    let cgd_1m_vec[idx] = cgd_val_1m

    * Print results to file
    echo "$&vg_bias $&cgg_val_1k $&cgg_val_10k $&cgg_val_100k $&cgg_val_1m $&cgb_val_1m $&cgs_val_1m $&cgd_val_1m" >> cv_data.txt

    * ----------------------------------------------------------
    * Full 4x4 small-signal capacitance matrix at 1MHz
    * Excite one terminal with AC=1V, hold others AC=0V.
    * Measure all terminal currents to form one column of Y, then convert to C.
    * ----------------------------------------------------------
    * Column: excite gate
    alter @VG[acmag] = 1
    alter @VD[acmag] = 0
    alter @VS[acmag] = 0
    alter @VB[acmag] = 0
    ac lin 1 1meg 1meg
    let cgg_m = -imag(i(VG))/(2*3.14159*1e6)
    let cdg_m = -imag(i(VD))/(2*3.14159*1e6)
    let csg_m = -imag(i(VS))/(2*3.14159*1e6)
    let cbg_m = -imag(i(VB))/(2*3.14159*1e6)
    set cgg_s = $&cgg_m
    set cdg_s = $&cdg_m
    set csg_s = $&csg_m
    set cbg_s = $&cbg_m

    * Column: excite drain
    alter @VG[acmag] = 0
    alter @VD[acmag] = 1
    alter @VS[acmag] = 0
    alter @VB[acmag] = 0
    ac lin 1 1meg 1meg
    let cgd_m = -imag(i(VG))/(2*3.14159*1e6)
    let cdd_m = -imag(i(VD))/(2*3.14159*1e6)
    let csd_m = -imag(i(VS))/(2*3.14159*1e6)
    let cbd_m = -imag(i(VB))/(2*3.14159*1e6)
    set cgd_s = $&cgd_m
    set cdd_s = $&cdd_m
    set csd_s = $&csd_m
    set cbd_s = $&cbd_m

    * Column: excite source
    alter @VG[acmag] = 0
    alter @VD[acmag] = 0
    alter @VS[acmag] = 1
    alter @VB[acmag] = 0
    ac lin 1 1meg 1meg
    let cgs_m = -imag(i(VG))/(2*3.14159*1e6)
    let cds_m = -imag(i(VD))/(2*3.14159*1e6)
    let css_m = -imag(i(VS))/(2*3.14159*1e6)
    let cbs_m = -imag(i(VB))/(2*3.14159*1e6)
    set cgs_s = $&cgs_m
    set cds_s = $&cds_m
    set css_s = $&css_m
    set cbs_s = $&cbs_m

    * Column: excite bulk
    alter @VG[acmag] = 0
    alter @VD[acmag] = 0
    alter @VS[acmag] = 0
    alter @VB[acmag] = 1
    ac lin 1 1meg 1meg
    let cgb_m = -imag(i(VG))/(2*3.14159*1e6)
    let cdb_m = -imag(i(VD))/(2*3.14159*1e6)
    let csb_m = -imag(i(VS))/(2*3.14159*1e6)
    let cbb_m = -imag(i(VB))/(2*3.14159*1e6)
    set cgb_s = $&cgb_m
    set cdb_s = $&cdb_m
    set csb_s = $&csb_m
    set cbb_s = $&cbb_m

    * Restore: excite gate for any subsequent CV calculations
    alter @VG[acmag] = 1
    alter @VD[acmag] = 0
    alter @VS[acmag] = 0
    alter @VB[acmag] = 0

    * Write one row for this Vg bias
    echo "$&vg_bias $cgg_s $cdg_s $csg_s $cbg_s $cgd_s $cdd_s $csd_s $cbd_s $cgs_s $cds_s $css_s $cbs_s $cgb_s $cdb_s $csb_s $cbb_s" >> cmatrix_data.txt

    * Increment index
    let idx = idx + 1
end

echo "CV simulation completed."

* ----------------------------------------------------------
* High-Frequency AC Analysis (S-parameters)
* ----------------------------------------------------------
* Set operating point for the S-parameter test circuit
alter VGS = 0.8
alter VDS = 1.0

* Store the S-parameter data at increasing frequencies
echo "# S-parameter analysis" > sparams_data.txt
echo "# freq s11_mag s11_phase s12_mag s12_phase s21_mag s21_phase s22_mag s22_phase" >> sparams_data.txt

* Compute true 2-port S-parameters by extracting Y-parameters via two AC excitations.
* Convert Y -> S using reference impedance Z0=50 ohm.

* Frequencies to evaluate (Hz)
foreach freq 1e6 1e7 1e8 1e9
    * Reset plots so the two AC runs are always ac1 (port1) and ac2 (port2)
    destroy all
    * Excite Port1 (Gate): V1=1V, V2=0V
    alter @VGS[acmag]=1
    alter @VDS[acmag]=0
    ac lin 1 $freq $freq
    * Port currents entering the DUT are -i(Vsource)
    let y11 = (-i(VGS)) / v(gate_in2)
    let y21 = (-i(VDS)) / v(gate_in2)

    * Excite Port2 (Drain): V1=0V, V2=1V
    alter @VGS[acmag]=0
    alter @VDS[acmag]=1
    ac lin 1 $freq $freq
    let y12 = (-i(VGS)) / v(drain_in2)
    let y22 = (-i(VDS)) / v(drain_in2)

    * Convert Y -> S: S = (I - Z0*Y) * inv(I + Z0*Y)
    * Note: y11/y21 are defined in plot ac1; y12/y22 are in the current plot (ac2)
    let a11 = 1 + 50*ac1.y11
    let a12 = 50*y12
    let a21 = 50*ac1.y21
    let a22 = 1 + 50*y22
    let b11 = 1 - 50*ac1.y11
    let b12 = -50*y12
    let b21 = -50*ac1.y21
    let b22 = 1 - 50*y22
    let detA = a11*a22 - a12*a21

    let s11 = (b11*a22 - b12*a21) / detA
    let s12 = (-b11*a12 + b12*a11) / detA
    let s21 = (b21*a22 - b22*a21) / detA
    let s22 = (-b21*a12 + b22*a11) / detA

    let s11_m = abs(s11)
    let s11_p = 180/3.141592653589793*ph(s11)
    let s12_m = abs(s12)
    let s12_p = 180/3.141592653589793*ph(s12)
    let s21_m = abs(s21)
    let s21_p = 180/3.141592653589793*ph(s21)
    let s22_m = abs(s22)
    let s22_p = 180/3.141592653589793*ph(s22)

    echo "$freq $&s11_m $&s11_p $&s12_m $&s12_p $&s21_m $&s21_p $&s22_m $&s22_p" >> sparams_data.txt
end

echo "S-parameter analysis completed."

* ----------------------------------------------------------
* Non-quasi-static Effects Analysis
* ----------------------------------------------------------
* For NQS effects, analyze transient gate/drain current response at very high frequencies
echo "# Non-quasi-static effects analysis - phase shifts" > nqs_effects.txt
echo "# freq vg_phase id_phase phase_diff" >> nqs_effects.txt

* Fixed frequency points instead of loop
* Set bias to saturation region
alter VG = 0.8
alter VD = 1.0

* Frequency 1: 10MHz
ac lin 1 1e7 1e7
let vg_phase_1 = 180/3.14159*ph(v(gate_1))
let id_phase_1 = 180/3.14159*ph(i(VD))
let phase_diff_1 = vg_phase_1 - id_phase_1
echo "1e7 $&vg_phase_1 $&id_phase_1 $&phase_diff_1" >> nqs_effects.txt

* Frequency 2: 100MHz
ac lin 1 1e8 1e8
let vg_phase_2 = 180/3.14159*ph(v(gate_1))
let id_phase_2 = 180/3.14159*ph(i(VD))
let phase_diff_2 = vg_phase_2 - id_phase_2
echo "1e8 $&vg_phase_2 $&id_phase_2 $&phase_diff_2" >> nqs_effects.txt

* Frequency 3: 1GHz
ac lin 1 1e9 1e9
let vg_phase_3 = 180/3.14159*ph(v(gate_1))
let id_phase_3 = 180/3.14159*ph(i(VD))
let phase_diff_3 = vg_phase_3 - id_phase_3
echo "1e9 $&vg_phase_3 $&id_phase_3 $&phase_diff_3" >> nqs_effects.txt

* Frequency 4: 10GHz
ac lin 1 1e10 1e10
let vg_phase_4 = 180/3.14159*ph(v(gate_1))
let id_phase_4 = 180/3.14159*ph(i(VD))
let phase_diff_4 = vg_phase_4 - id_phase_4
echo "1e10 $&vg_phase_4 $&id_phase_4 $&phase_diff_4" >> nqs_effects.txt

echo "Non-quasi-static effects analysis completed."

* ----------------------------------------------------------
* Charge Conservation Test (Transient Analysis)
* ----------------------------------------------------------
* Run transient analysis to check charge conservation
tran 0.01n 5n
* Save time points, gate voltage, and terminal currents
write charge_conservation.txt time v(gate_3) i(VGQ) i(VDQ) i(VSQ) i(VBQ)

echo "Charge conservation test completed."

quit
.endc

.end
