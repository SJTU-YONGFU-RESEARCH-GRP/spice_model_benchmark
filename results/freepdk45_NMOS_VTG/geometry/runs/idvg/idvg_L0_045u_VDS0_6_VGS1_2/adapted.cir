* Geometry OP check netlist (template)

.option gmin=1e-15
.include "../../../../../../models/FreePDK45/tran_models/models_nom/NMOS_VTG.inc"
.option reltol=1e-8
.option abstol=1e-12
.option chgtol=1e-15
.option method=gear
.option TEMP=27
.option TNOM=27
.option TEMPSCALE=1.0

* MOSFET device under test
M1 drain_geo gate_geo source_geo bulk_geo NMOS_VTG __LPARAM__=__L__ __WPARAM__=__W__

* Bias sources
Vds_geo drain_geo 0 DC __VDS__
Vgs_geo gate_geo 0 DC __VGS__
Vs_geo source_geo 0 DC 0
Vb_geo bulk_geo 0 DC 0

.control
set filetype=ascii
set wr_vecnames
set wr_singlescale
set wr_formatted

option temp=__TEMP__

echo "W L VDS VGS IDS" > ./geometry_op___TAG__.txt

op

let ids = abs(i(Vds_geo))

echo "__W__ __L__ __VDS__ __VGS__ $&ids" >> ./geometry_op___TAG__.txt

quit
.endc

.end
