* Geometry OP check netlist (template)

.option gmin=1e-15
.include "../../../../../../models/FreePDK45/tran_models/models_nom/NMOS_VTG.inc"
.option reltol=1e-8
.option abstol=1e-12
.option chgtol=1e-15
.option method=gear
.option TEMP=27
.option TNOM=27
.option TEMPSCALE=1.0

* MOSFET device under test
M1 drain_geo gate_geo source_geo bulk_geo NMOS_VTG L=0.18u W=10u

* Bias sources
Vds_geo drain_geo 0 DC 0.59
Vgs_geo gate_geo 0 DC 1.2
Vs_geo source_geo 0 DC 0
Vb_geo bulk_geo 0 DC 0

.control
set filetype=ascii
set wr_vecnames
set wr_singlescale
set wr_formatted

option temp=27

echo "W L VDS VGS IDS" > ./geometry_op_gds_W10u_L0_18u_VDS0_59_VGS1_2.txt

op

let ids = abs(i(Vds_geo))

echo "10u 0.18u 0.59 1.2 $&ids" >> ./geometry_op_gds_W10u_L0_18u_VDS0_59_VGS1_2.txt

quit
.endc

.end
