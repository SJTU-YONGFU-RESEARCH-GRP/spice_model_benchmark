* RC extraction prototype netlist (template)

.option gmin=1e-15
.include "../../../../../models/FreePDK45/tran_models/models_nom/NMOS_VTG.inc"
.option reltol=1e-8
.option abstol=1e-12
.option chgtol=1e-15
.option method=gear
.option TEMP=27
.option TNOM=27
.option TEMPSCALE=1.0

* Gate step driver
Vstep_rc step_rc 0 PULSE(0 1.2 0 1p 1p 10n 20n)
Rdrive_rc step_rc gate_rc 1k

* Bias sources
Vds_rc drain_rc 0 DC 0.6
Vs_rc source_rc 0 DC 0
Vb_rc bulk_rc 0 DC 0

* MOSFET device under test
M1 drain_rc gate_rc source_rc bulk_rc NMOS_VTG L=0.045u W=1u

.control
set filetype=ascii
set wr_vecnames
set wr_singlescale
set wr_formatted

option temp=27

tran 1p 20n

let id = abs(i(Vds_rc))
wrdata ./rc_step_W1u_L0_045u.txt time v(gate_rc) id

quit
.endc

.end
