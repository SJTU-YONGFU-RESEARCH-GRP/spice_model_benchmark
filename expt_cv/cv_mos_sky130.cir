* MOSFET CV Analysis using Sky130 PDK
* This simulation performs a comprehensive bias sweep with multiple AC analyses
* to generate complete CV characteristics for MOSFET devices

.option temp=27 tnom=27
.option gmin=1e-15
.option reltol=1e-8
.option abstol=1e-12
.option chgtol=1e-15
.option method=gear

* Include Sky130 models using custom.spice
.include "/home/yongfu/proj/spice_model_benchmark/models/skywater-pdk-libs-sky130_fd_pr/models/custom.spice"

* Enhanced test circuit for capacitance measurements
* Use small signal AC analysis to extract capacitance components
* Configure for operation in different regions (accumulation, depletion, inversion)

* Gate voltage source with AC component for small-signal analysis
VG gate 0 DC 0 AC 1
* Drain bias at typical operation voltage
VD drain 0 DC 1.0
* Source and bulk connections tied to ground
VS source 0 DC 0
VB bulk 0 DC 0

* MOSFET device under test - using Sky130 1.8V NMOS
M1 drain gate source bulk sky130_fd_pr__nfet_01v8 L=0.15u W=10u

.control
* Create output directories if they don't exist
shell mkdir -p results

* Output format configuration
set filetype=ascii
set wr_vecnames=yes
set wr_singlescale=yes
set numdgt=16

* Create log file
echo "** MOSFET CV Characteristic Simulation using Sky130 models **" > ./results/cv_sky130_sim.log

* Set up gate voltage sweep parameters
let vg_start = -0.8   ; Start accumulation region
let vg_stop = 1.8     ; End strong inversion
let vg_step = 0.05    ; Small step size for smooth curve
let num_points = floor((vg_stop - vg_start)/vg_step) + 1
echo "Gate voltage sweep from $&vg_start V to $&vg_stop V, $&num_points points" >> ./results/cv_sky130_sim.log

* Create output file with header
echo "Vg Cgg_1kHz Cgg_10kHz Cgg_100kHz Cgg_1MHz Cgb_1MHz Cgs_1MHz Cgd_1MHz" > ./results/cv_sky130_data.txt

* Store vectors for capacitance values
let cgg_1k_vec = vector(num_points)
let cgg_10k_vec = vector(num_points)
let cgg_100k_vec = vector(num_points)
let cgg_1m_vec = vector(num_points)
let cgb_1m_vec = vector(num_points)
let cgs_1m_vec = vector(num_points)
let cgd_1m_vec = vector(num_points)
let vg_vec = vector(num_points)
let idx = 0

* Perform gate voltage sweep with measurements at each bias point
let vg_bias = vg_start
while vg_bias <= vg_stop
    * Set gate bias
    alter VG = vg_bias

    * Store gate voltage value
    let vg_vec[idx] = vg_bias

    * Run AC analysis at 1kHz (low frequency response)
    ac lin 1 1k 1k
    let cgg_val_1k = -imag(i(VG))/(2*3.14159*1e3)
    let cgg_1k_vec[idx] = cgg_val_1k

    * Run AC analysis at 10kHz
    ac lin 1 10k 10k
    let cgg_val_10k = -imag(i(VG))/(2*3.14159*1e4)
    let cgg_10k_vec[idx] = cgg_val_10k

    * Run AC analysis at 100kHz
    ac lin 1 100k 100k
    let cgg_val_100k = -imag(i(VG))/(2*3.14159*1e5)
    let cgg_100k_vec[idx] = cgg_val_100k

    * Run AC analysis at 1MHz (standard frequency for CV measurements)
    ac lin 1 1meg 1meg
    let cgg_val_1m = -imag(i(VG))/(2*3.14159*1e6)
    let cgg_1m_vec[idx] = cgg_val_1m

    * Calculate individual capacitance components at 1MHz
    let cgb_val_1m = -imag(i(VB))/(2*3.14159*1e6)
    let cgb_1m_vec[idx] = cgb_val_1m

    let cgs_val_1m = -imag(i(VS))/(2*3.14159*1e6)
    let cgs_1m_vec[idx] = cgs_val_1m

    let cgd_val_1m = -imag(i(VD))/(2*3.14159*1e6)
    let cgd_1m_vec[idx] = cgd_val_1m

    * Print results to file
    echo "$&vg_bias $&cgg_val_1k $&cgg_val_10k $&cgg_val_100k $&cgg_val_1m $&cgb_val_1m $&cgs_val_1m $&cgd_val_1m" >> ./results/cv_sky130_data.txt

    * Log progress
    echo "VG = $&vg_bias V: Cgg(1kHz) = $&cgg_val_1k F, Cgg(1MHz) = $&cgg_val_1m F" >> ./results/cv_sky130_sim.log

    * Increment index and gate voltage
    let idx = idx + 1
    let vg_bias = vg_bias + vg_step
end

echo "CV simulation completed successfully" >> ./results/cv_sky130_sim.log
echo "CV simulation completed."
quit
.endc

.end
